* esd_ring_rport: Kron-reduced pad-ring resistance, scripts/esd/pex.py
.subckt esd_ring_rport cls_clamp cls_clamp_vdda clv_clamp clv_clamp_vdda iovdd_adcconv iovdd_clamp iovdd_clamp_vdda iovdd_clk iovdd_datain iovdd_doq iovdd_doqb iovdd_dsmclk iovdd_ibiastest iovdd_iovdd_w4 iovdd_iovdd_w5 iovdd_iovss_w3 iovdd_miso iovdd_mosi iovdd_rstn iovdd_sclk iovdd_ss iovdd_vcm iovdd_vdd_w2 iovdd_vdda_e4 iovdd_vi iovdd_vss_s3 iovdd_vss_w1 iovss_adcconv iovss_clamp iovss_clamp_vdda iovss_clk iovss_datain iovss_doq iovss_doqb iovss_dsmclk iovss_ibiastest iovss_iovdd_w4 iovss_iovdd_w5 iovss_iovss_w3 iovss_miso iovss_mosi iovss_rstn iovss_sclk iovss_ss iovss_vcm iovss_vdd_w2 iovss_vdda_e4 iovss_vi iovss_vss_s3 iovss_vss_w1 pad_adcconv pad_clk pad_datain pad_doq pad_doqb pad_dsmclk pad_ibiastest pad_iovdd_w4 pad_iovdd_w5 pad_iovss_w3 pad_miso pad_mosi pad_rstn pad_sclk pad_ss pad_vcm pad_vdd_w2 pad_vdda_e4 pad_vi pad_vss_s3 pad_vss_w1 padc_adcconv padc_clk padc_datain padc_doq padc_doqb padc_dsmclk padc_ibiastest padc_iovdd_w4 padc_iovdd_w5 padc_iovss_w3 padc_miso padc_mosi padc_rstn padc_sclk padc_ss padc_vcm padc_vdd_w2 padc_vdda_e4 padc_vi padc_vss_s3 padc_vss_w1 vdd_adcconv vdd_clamp vdd_clk vdd_datain vdd_iovdd_w4 vdd_iovdd_w5 vdd_iovss_w3 vdd_miso vdd_mosi vdd_rstn vdd_sclk vdd_ss vdd_vdd_w2 vdd_vss_s3 vdd_vss_w1 vdda_clamp_vdda vdda_doq vdda_doqb vdda_dsmclk vdda_ibiastest vdda_vcm vdda_vdda_e4 vdda_vi vddadcp vddadsm vddring_0 vddring_1 vddring_2 vddring_3 vddring_4 vddring_5 vddring_6 vddring_7 vss_adcconv vss_clamp vss_clamp_vdda vss_clk vss_datain vss_doq vss_doqb vss_dsmclk vss_ibiastest vss_iovdd_w4 vss_iovdd_w5 vss_iovss_w3 vss_miso vss_mosi vss_rstn vss_sclk vss_ss vss_vcm vss_vdd_w2 vss_vdda_e4 vss_vi vss_vss_s3 vss_vss_w1 vssdcp vssdsm vssring_0 vssring_1 vssring_2 vssring_3 vssring_4 vssring_5 vssring_6 vssring_7
R0 cls_clamp padc_vss_w1 18.6744
R1 cls_clamp vss_adcconv 188795
R2 cls_clamp vss_clamp 0.383559
R3 cls_clamp vss_datain 334.982
R4 cls_clamp vss_iovdd_w4 144465
R5 cls_clamp vss_iovss_w3 933.924
R6 cls_clamp vss_vdd_w2 1.27387
R7 cls_clamp vss_vss_w1 1.33107
R8 cls_clamp vssring_0 148.804
R9 cls_clamp vssring_1 853334
R10 cls_clamp vssring_4 440.19
R11 cls_clamp_vdda vss_clamp_vdda 0.340845
R12 cls_clamp_vdda vss_ibiastest 1397.29
R13 cls_clamp_vdda vss_miso 2.74987
R14 cls_clamp_vdda vss_mosi 539801
R15 cls_clamp_vdda vss_ss 2604.23
R16 cls_clamp_vdda vss_vcm 68496.1
R17 cls_clamp_vdda vss_vdda_e4 1.58312
R18 cls_clamp_vdda vssdcp 120.793
R19 cls_clamp_vdda vssdsm 621.061
R20 cls_clamp_vdda vssring_2 120006
R21 cls_clamp_vdda vssring_3 95.3256
R22 cls_clamp_vdda vssring_7 700.77
R23 clv_clamp padc_vdd_w2 7.90143
R24 clv_clamp vdd_clamp 0.33046
R25 clv_clamp vdd_datain 7878.55
R26 clv_clamp vdd_iovdd_w4 394757
R27 clv_clamp vdd_iovss_w3 131.178
R28 clv_clamp vdd_vdd_w2 2.60902
R29 clv_clamp vdd_vss_w1 2.54627
R30 clv_clamp vddring_0 32.222
R31 clv_clamp vddring_4 51.606
R32 clv_clamp_vdda padc_vdda_e4 9.28332
R33 clv_clamp_vdda vdda_clamp_vdda 0.308977
R34 clv_clamp_vdda vdda_ibiastest 156.122
R35 clv_clamp_vdda vdda_vcm 383183
R36 clv_clamp_vdda vdda_vdda_e4 3.16035
R37 clv_clamp_vdda vddadcp 3.75146
R38 clv_clamp_vdda vddadsm 2504.81
R39 iovdd_adcconv iovdd_clamp 736.721
R40 iovdd_adcconv iovdd_datain 0.0246785
R41 iovdd_adcconv iovdd_dsmclk 540.288
R42 iovdd_adcconv iovdd_vss_s3 0.0246544
R43 iovdd_adcconv iovdd_vss_w1 1040.46
R44 iovdd_clamp iovdd_datain 586.09
R45 iovdd_clamp iovdd_dsmclk 49815.5
R46 iovdd_clamp iovdd_vdd_w2 0.0580874
R47 iovdd_clamp iovdd_vss_s3 4809.98
R48 iovdd_clamp iovdd_vss_w1 0.0155662
R49 iovdd_clamp_vdda iovdd_clk 375662
R50 iovdd_clamp_vdda iovdd_doqb 135302
R51 iovdd_clamp_vdda iovdd_ibiastest 301.433
R52 iovdd_clamp_vdda iovdd_miso 0.0720124
R53 iovdd_clamp_vdda iovdd_mosi 7884.56
R54 iovdd_clamp_vdda iovdd_sclk 54530.2
R55 iovdd_clamp_vdda iovdd_ss 666.301
R56 iovdd_clamp_vdda iovdd_vcm 2418.12
R57 iovdd_clamp_vdda iovdd_vdda_e4 0.0668362
R58 iovdd_clamp_vdda iovdd_vi 17988.9
R59 iovdd_clk iovdd_iovdd_w4 3962.69
R60 iovdd_clk iovdd_iovdd_w5 418.065
R61 iovdd_clk iovdd_iovss_w3 26253.9
R62 iovdd_clk iovdd_miso 16734.7
R63 iovdd_clk iovdd_mosi 386.297
R64 iovdd_clk iovdd_rstn 0.0256653
R65 iovdd_clk iovdd_sclk 0.025665
R66 iovdd_clk iovdd_ss 2666.72
R67 iovdd_clk iovdd_vdd_w2 201168
R68 iovdd_clk padc_iovdd_w4 91376.2
R69 iovdd_clk padc_iovdd_w5 9453.85
R70 iovdd_datain iovdd_dsmclk 3842.85
R71 iovdd_datain iovdd_vss_s3 210.467
R72 iovdd_datain iovdd_vss_w1 0.0669786
R73 iovdd_doq iovdd_doqb 0.0246833
R74 iovdd_doq iovdd_dsmclk 0.0246839
R75 iovdd_doq iovdd_ibiastest 28860.8
R76 iovdd_doq iovdd_vcm 4045.09
R77 iovdd_doq iovdd_vdda_e4 264272
R78 iovdd_doq iovdd_vi 811.416
R79 iovdd_doq iovdd_vss_s3 27669.2
R80 iovdd_doqb iovdd_dsmclk 334.618
R81 iovdd_doqb iovdd_ibiastest 3092.26
R82 iovdd_doqb iovdd_vcm 276.831
R83 iovdd_doqb iovdd_vdda_e4 28362.3
R84 iovdd_doqb iovdd_vi 0.0695662
R85 iovdd_dsmclk iovdd_ibiastest 194021
R86 iovdd_dsmclk iovdd_vcm 27194.3
R87 iovdd_dsmclk iovdd_vi 5523.97
R88 iovdd_dsmclk iovdd_vss_s3 0.0321999
R89 iovdd_dsmclk iovdd_vss_w1 70353.7
R90 iovdd_ibiastest iovdd_vcm 0.0271779
R91 iovdd_ibiastest iovdd_vdda_e4 0.0810844
R92 iovdd_ibiastest iovdd_vi 164.837
R93 iovdd_iovdd_w4 iovdd_iovdd_w5 0.0307093
R94 iovdd_iovdd_w4 iovdd_iovss_w3 0.0273178
R95 iovdd_iovdd_w4 iovdd_mosi 189569
R96 iovdd_iovdd_w4 iovdd_rstn 502.151
R97 iovdd_iovdd_w4 iovdd_sclk 27408.5
R98 iovdd_iovdd_w4 iovdd_vdd_w2 432.79
R99 iovdd_iovdd_w4 padc_iovdd_w4 0.0263407
R100 iovdd_iovdd_w4 padc_iovdd_w5 0.32812
R101 iovdd_iovdd_w5 iovdd_iovss_w3 201.848
R102 iovdd_iovdd_w5 iovdd_miso 866402
R103 iovdd_iovdd_w5 iovdd_mosi 19999.6
R104 iovdd_iovdd_w5 iovdd_rstn 0.0752988
R105 iovdd_iovdd_w5 iovdd_sclk 2891.61
R106 iovdd_iovdd_w5 iovdd_ss 138063
R107 iovdd_iovdd_w5 iovdd_vdd_w2 2849.48
R108 iovdd_iovdd_w5 padc_iovdd_w4 0.328115
R109 iovdd_iovdd_w5 padc_iovdd_w5 0.0250187
R110 iovdd_iovss_w3 iovdd_rstn 5852.4
R111 iovdd_iovss_w3 iovdd_sclk 181589
R112 iovdd_iovss_w3 iovdd_vdd_w2 0.0722368
R113 iovdd_iovss_w3 padc_iovdd_w4 0.287813
R114 iovdd_iovss_w3 padc_iovdd_w5 3534.99
R115 iovdd_miso iovdd_mosi 351.236
R116 iovdd_miso iovdd_rstn 118753
R117 iovdd_miso iovdd_sclk 2429.17
R118 iovdd_miso iovdd_ss 0.0256781
R119 iovdd_mosi iovdd_rstn 2741.23
R120 iovdd_mosi iovdd_sclk 0.025665
R121 iovdd_mosi iovdd_ss 0.025665
R122 iovdd_mosi padc_iovdd_w5 452258
R123 iovdd_rstn iovdd_sclk 396.336
R124 iovdd_rstn iovdd_ss 18923.5
R125 iovdd_rstn iovdd_vdd_w2 44903.4
R126 iovdd_rstn padc_iovdd_w4 9524.52
R127 iovdd_rstn padc_iovdd_w5 0.792832
R128 iovdd_sclk iovdd_ss 387.094
R129 iovdd_sclk padc_iovdd_w4 632017
R130 iovdd_sclk padc_iovdd_w5 65388.9
R131 iovdd_vcm iovdd_vdda_e4 227.898
R132 iovdd_vcm iovdd_vi 0.0271776
R133 iovdd_vdd_w2 padc_iovdd_w4 8491.95
R134 iovdd_vdd_w2 padc_iovdd_w5 56475.7
R135 iovdd_vdda_e4 iovdd_vi 3756.8
R136 iovdd_vss_s3 iovdd_vss_w1 6793.06
R137 iovss_adcconv iovss_datain 0.0193404
R138 iovss_adcconv iovss_doq 7.95668
R139 iovss_adcconv iovss_doqb 19.2641
R140 iovss_adcconv iovss_dsmclk 2.98652
R141 iovss_adcconv iovss_ibiastest 197.846
R142 iovss_adcconv iovss_vcm 116.555
R143 iovss_adcconv iovss_vdda_e4 781.183
R144 iovss_adcconv iovss_vi 48.7307
R145 iovss_adcconv iovss_vss_s3 0.0194094
R146 iovss_adcconv iovss_vss_w1 3.28958
R147 iovss_clamp iovss_clk 524.869
R148 iovss_clamp iovss_iovdd_w4 12.7616
R149 iovss_clamp iovss_iovdd_w5 40.5134
R150 iovss_clamp iovss_iovss_w3 1.98642
R151 iovss_clamp iovss_miso 16135.5
R152 iovss_clamp iovss_mosi 3251.11
R153 iovss_clamp iovss_rstn 150.589
R154 iovss_clamp iovss_sclk 1342.03
R155 iovss_clamp iovss_ss 7087.1
R156 iovss_clamp iovss_vdd_w2 0.0399211
R157 iovss_clamp iovss_vss_w1 0.0118331
R158 iovss_clamp padc_iovss_w3 809.344
R159 iovss_clamp_vdda iovss_clk 94486.9
R160 iovss_clamp_vdda iovss_ibiastest 132.263
R161 iovss_clamp_vdda iovss_miso 0.0699253
R162 iovss_clamp_vdda iovss_mosi 18057.7
R163 iovss_clamp_vdda iovss_rstn 183024
R164 iovss_clamp_vdda iovss_sclk 40817.3
R165 iovss_clamp_vdda iovss_ss 1493.4
R166 iovss_clamp_vdda iovss_vcm 536165
R167 iovss_clamp_vdda iovss_vdda_e4 0.0406048
R168 iovss_clk iovss_iovdd_w4 16.7972
R169 iovss_clk iovss_iovdd_w5 6.81123
R170 iovss_clk iovss_iovss_w3 33.1741
R171 iovss_clk iovss_miso 18.3764
R172 iovss_clk iovss_mosi 2.88679
R173 iovss_clk iovss_rstn 0.02015
R174 iovss_clk iovss_sclk 0.020233
R175 iovss_clk iovss_ss 7.57874
R176 iovss_clk iovss_vdd_w2 278.986
R177 iovss_clk padc_iovss_w3 17791.5
R178 iovss_datain iovss_doq 15.666
R179 iovss_datain iovss_doqb 36.2421
R180 iovss_datain iovss_dsmclk 6.6854
R181 iovss_datain iovss_ibiastest 362.744
R182 iovss_datain iovss_vcm 214.001
R183 iovss_datain iovss_vdda_e4 1431.83
R184 iovss_datain iovss_vi 89.8783
R185 iovss_datain iovss_vss_s3 2.47108
R186 iovss_datain iovss_vss_w1 0.0671245
R187 iovss_doq iovss_doqb 0.0194302
R188 iovss_doq iovss_dsmclk 0.0193878
R189 iovss_doq iovss_ibiastest 19.0476
R190 iovss_doq iovss_vcm 10.5599
R191 iovss_doq iovss_vdda_e4 76.2423
R192 iovss_doq iovss_vi 3.70412
R193 iovss_doq iovss_vss_s3 3.38245
R194 iovss_doq iovss_vss_w1 45.5132
R195 iovss_doqb iovss_dsmclk 2.76502
R196 iovss_doqb iovss_ibiastest 10.3836
R197 iovss_doqb iovss_vcm 4.91055
R198 iovss_doqb iovss_vdda_e4 43.2134
R199 iovss_doqb iovss_vi 0.0694225
R200 iovss_doqb iovss_vss_s3 9.44218
R201 iovss_doqb iovss_vss_w1 103.591
R202 iovss_dsmclk iovss_ibiastest 38.9613
R203 iovss_dsmclk iovss_vcm 22.5008
R204 iovss_dsmclk iovss_vdda_e4 154.512
R205 iovss_dsmclk iovss_vi 8.84474
R206 iovss_dsmclk iovss_vss_s3 0.0227427
R207 iovss_dsmclk iovss_vss_w1 20.4528
R208 iovss_ibiastest iovss_vcm 0.0204901
R209 iovss_ibiastest iovss_vdda_e4 0.0469263
R210 iovss_ibiastest iovss_vi 2.0769
R211 iovss_ibiastest iovss_vss_s3 106.426
R212 iovss_ibiastest iovss_vss_w1 1027.74
R213 iovss_iovdd_w4 iovss_iovdd_w5 0.0724873
R214 iovss_iovdd_w4 iovss_iovss_w3 0.0460968
R215 iovss_iovdd_w4 iovss_miso 523.128
R216 iovss_iovdd_w4 iovss_mosi 105.256
R217 iovss_iovdd_w4 iovss_rstn 4.68244
R218 iovss_iovdd_w4 iovss_sclk 43.3142
R219 iovss_iovdd_w4 iovss_ss 229.696
R220 iovss_iovdd_w4 iovss_vdd_w2 5.8646
R221 iovss_iovdd_w4 padc_iovss_w3 2.47729
R222 iovss_iovdd_w5 iovss_iovss_w3 2.4757
R223 iovss_iovdd_w5 iovss_miso 240.814
R224 iovss_iovdd_w5 iovss_mosi 47.7469
R225 iovss_iovdd_w5 iovss_rstn 0.0953491
R226 iovss_iovdd_w5 iovss_sclk 19.0418
R227 iovss_iovdd_w5 iovss_ss 105.378
R228 iovss_iovdd_w5 iovss_vdd_w2 21.4409
R229 iovss_iovdd_w5 padc_iovss_w3 1130.12
R230 iovss_iovss_w3 iovss_miso 1025.91
R231 iovss_iovss_w3 iovss_mosi 206.576
R232 iovss_iovss_w3 iovss_rstn 9.42911
R233 iovss_iovss_w3 iovss_sclk 85.1521
R234 iovss_iovss_w3 iovss_ss 450.538
R235 iovss_iovss_w3 iovss_vdd_w2 0.0459228
R236 iovss_iovss_w3 padc_iovss_w3 0.0967006
R237 iovss_miso iovss_mosi 2.58352
R238 iovss_miso iovss_rstn 36.6293
R239 iovss_miso iovss_sclk 7.31674
R240 iovss_miso iovss_ss 0.0201944
R241 iovss_miso iovss_vdd_w2 8585.68
R242 iovss_miso padc_iovss_w3 550009
R243 iovss_mosi iovss_rstn 6.84314
R244 iovss_mosi iovss_sclk 0.0202338
R245 iovss_mosi iovss_ss 0.0202042
R246 iovss_mosi iovss_vdd_w2 1729.72
R247 iovss_mosi padc_iovss_w3 110753
R248 iovss_rstn iovss_sclk 2.43532
R249 iovss_rstn iovss_ss 15.8031
R250 iovss_rstn iovss_vdd_w2 79.9082
R251 iovss_rstn padc_iovss_w3 5058.67
R252 iovss_sclk iovss_ss 2.69688
R253 iovss_sclk iovss_vdd_w2 713.83
R254 iovss_sclk padc_iovss_w3 45657.2
R255 iovss_ss iovss_vdd_w2 3770.95
R256 iovss_ss padc_iovss_w3 241544
R257 iovss_vcm iovss_vdda_e4 4.01306
R258 iovss_vcm iovss_vi 0.0205172
R259 iovss_vcm iovss_vss_s3 62.3636
R260 iovss_vcm iovss_vss_w1 606.603
R261 iovss_vdd_w2 padc_iovss_w3 2.90526
R262 iovss_vdda_e4 iovss_vi 9.6881
R263 iovss_vdda_e4 iovss_vss_s3 420.708
R264 iovss_vdda_e4 iovss_vss_w1 4056.3
R265 iovss_vi iovss_vss_s3 25.635
R266 iovss_vi iovss_vss_w1 255.158
R267 iovss_vss_s3 iovss_vss_w1 8.82482
R268 pad_adcconv padc_adcconv 0.001
R269 pad_clk padc_clk 0.001
R270 pad_datain padc_datain 0.001
R271 pad_doq padc_doq 0.001
R272 pad_doqb padc_doqb 0.001
R273 pad_dsmclk padc_dsmclk 0.001
R274 pad_ibiastest padc_ibiastest 0.001
R275 pad_iovdd_w4 padc_iovdd_w4 0.001
R276 pad_iovdd_w5 padc_iovdd_w5 0.001
R277 pad_iovss_w3 padc_iovss_w3 0.001
R278 pad_miso padc_miso 0.001
R279 pad_mosi padc_mosi 0.001
R280 pad_rstn padc_rstn 0.001
R281 pad_sclk padc_sclk 0.001
R282 pad_ss padc_ss 0.001
R283 pad_vcm padc_vcm 0.001
R284 pad_vdd_w2 padc_vdd_w2 0.001
R285 pad_vdda_e4 padc_vdda_e4 0.001
R286 pad_vi padc_vi 0.001
R287 pad_vss_s3 padc_vss_s3 0.001
R288 pad_vss_w1 padc_vss_w1 0.001
R289 padc_iovdd_w4 padc_iovdd_w5 2.14216
R290 padc_vdd_w2 vdd_clamp 1.39837
R291 padc_vdd_w2 vdd_datain 416000
R292 padc_vdd_w2 vdd_iovdd_w4 7685.65
R293 padc_vdd_w2 vdd_iovss_w3 1.26854
R294 padc_vdd_w2 vdd_vdd_w2 0.0830671
R295 padc_vdd_w2 vdd_vss_w1 304.099
R296 padc_vdd_w2 vddring_0 12703.3
R297 padc_vdd_w2 vddring_4 20345.2
R298 padc_vdda_e4 vdda_clamp_vdda 1.85945
R299 padc_vdda_e4 vdda_ibiastest 1.26794
R300 padc_vdda_e4 vdda_vcm 4508.58
R301 padc_vdda_e4 vdda_vdda_e4 0.082451
R302 padc_vdda_e4 vddadcp 470.344
R303 padc_vdda_e4 vddadsm 24.2406
R304 padc_vss_s3 vss_adcconv 6.33663
R305 padc_vss_s3 vss_datain 5040.54
R306 padc_vss_s3 vss_doq 5149.25
R307 padc_vss_s3 vss_doqb 979868
R308 padc_vss_s3 vss_dsmclk 6.33856
R309 padc_vss_s3 vss_vss_s3 0.314437
R310 padc_vss_w1 vss_adcconv 8110.99
R311 padc_vss_w1 vss_clamp 7.99001
R312 padc_vss_w1 vss_datain 12.494
R313 padc_vss_w1 vss_vdd_w2 80395.2
R314 padc_vss_w1 vss_vss_w1 0.310094
R315 padc_vss_w1 vssring_0 111.831
R316 padc_vss_w1 vssring_4 283.309
R317 vdd_adcconv vdd_clamp 137455
R318 vdd_adcconv vdd_datain 0.254456
R319 vdd_adcconv vdd_vss_s3 0.254323
R320 vdd_adcconv vdd_vss_w1 474.243
R321 vdd_clamp vdd_datain 546.771
R322 vdd_clamp vdd_iovdd_w4 42139.2
R323 vdd_clamp vdd_iovss_w3 21.3384
R324 vdd_clamp vdd_vdd_w2 0.318201
R325 vdd_clamp vdd_vss_w1 0.306041
R326 vdd_clamp vddring_0 6.50128
R327 vdd_clamp vddring_4 10.4123
R328 vdd_clk vdd_iovdd_w4 139900
R329 vdd_clk vdd_iovdd_w5 526.894
R330 vdd_clk vdd_mosi 357.291
R331 vdd_clk vdd_rstn 0.26483
R332 vdd_clk vdd_sclk 0.264893
R333 vdd_clk vdd_ss 74746.2
R334 vdd_datain vdd_vdd_w2 67898.5
R335 vdd_datain vdd_vss_s3 327.687
R336 vdd_datain vdd_vss_w1 0.402197
R337 vdd_datain vddring_0 66118.1
R338 vdd_datain vddring_4 105893
R339 vdd_iovdd_w4 vdd_iovdd_w5 0.254452
R340 vdd_iovdd_w4 vdd_iovss_w3 0.254522
R341 vdd_iovdd_w4 vdd_rstn 504.319
R342 vdd_iovdd_w4 vdd_vdd_w2 341.641
R343 vdd_iovdd_w5 vdd_iovss_w3 336.4
R344 vdd_iovdd_w5 vdd_rstn 0.422576
R345 vdd_iovdd_w5 vdd_sclk 110228
R346 vdd_iovdd_w5 vdd_vdd_w2 65127.7
R347 vdd_iovss_w3 vdd_rstn 96323.5
R348 vdd_iovss_w3 vdd_vdd_w2 0.285662
R349 vdd_iovss_w3 vdd_vss_w1 4209.14
R350 vdd_iovss_w3 vddring_0 175867
R351 vdd_iovss_w3 vddring_4 281664
R352 vdd_miso vdd_mosi 355.589
R353 vdd_miso vdd_sclk 74390.4
R354 vdd_miso vdd_ss 0.264697
R355 vdd_mosi vdd_rstn 74631.5
R356 vdd_mosi vdd_sclk 0.264893
R357 vdd_mosi vdd_ss 0.264893
R358 vdd_rstn vdd_sclk 356.742
R359 vdd_sclk vdd_ss 357.291
R360 vdd_vdd_w2 vdd_vss_w1 49.6419
R361 vdd_vdd_w2 vddring_0 2075.03
R362 vdd_vdd_w2 vddring_4 3323.31
R363 vdd_vss_s3 vdd_vss_w1 88222.8
R364 vdd_vss_w1 vddring_0 3.89701
R365 vdd_vss_w1 vddring_4 6.24135
R366 vdda_clamp_vdda vdda_ibiastest 28.4785
R367 vdda_clamp_vdda vdda_vcm 48416
R368 vdda_clamp_vdda vdda_vdda_e4 0.361104
R369 vdda_clamp_vdda vddadcp 0.308983
R370 vdda_clamp_vdda vddadsm 384.42
R371 vdda_doq vdda_doqb 0.254446
R372 vdda_doq vdda_dsmclk 0.254314
R373 vdda_doq vdda_vcm 156871
R374 vdda_doq vdda_vi 510.993
R375 vdda_doqb vdda_dsmclk 327.519
R376 vdda_doqb vdda_ibiastest 144820
R377 vdda_doqb vdda_vcm 588.304
R378 vdda_doqb vdda_vi 0.435713
R379 vdda_dsmclk vdda_vi 95036.7
R380 vdda_ibiastest vdda_vcm 0.280476
R381 vdda_ibiastest vdda_vdda_e4 0.327597
R382 vdda_ibiastest vdda_vi 407.843
R383 vdda_ibiastest vddadcp 5959.79
R384 vdda_ibiastest vddadsm 7.76068
R385 vdda_vcm vdda_vdda_e4 439.411
R386 vdda_vcm vdda_vi 0.280401
R387 vdda_vcm vddadsm 6676.43
R388 vdda_vdda_e4 vdda_vi 107995
R389 vdda_vdda_e4 vddadcp 45.5843
R390 vdda_vdda_e4 vddadsm 2.22263
R391 vddadcp vddadsm 62884.2
R392 vddring_0 vddring_1 5.28
R393 vddring_0 vddring_4 8.23904
R394 vddring_1 vddring_6 3.43965
R395 vddring_2 vddring_3 5.28
R396 vddring_2 vddring_5 3.39888
R397 vddring_3 vddring_7 3.40452
R398 vddring_4 vddring_5 1.08
R399 vddring_6 vddring_7 1.08
R400 vss_adcconv vss_clamp 79967.9
R401 vss_adcconv vss_datain 0.265565
R402 vss_adcconv vss_doq 37407.5
R403 vss_adcconv vss_dsmclk 54.8547
R404 vss_adcconv vss_vss_s3 0.248771
R405 vss_adcconv vss_vss_w1 570.624
R406 vss_clamp vss_datain 139.243
R407 vss_clamp vss_iovdd_w4 474.546
R408 vss_clamp vss_iovdd_w5 993292
R409 vss_clamp vss_iovss_w3 11.9302
R410 vss_clamp vss_vdd_w2 0.440387
R411 vss_clamp vss_vss_w1 0.368745
R412 vss_clamp vssring_0 2.60023
R413 vss_clamp vssring_1 865.657
R414 vss_clamp vssring_4 43.3353
R415 vss_clamp_vdda vss_ibiastest 220.529
R416 vss_clamp_vdda vss_miso 1.15802
R417 vss_clamp_vdda vss_mosi 372751
R418 vss_clamp_vdda vss_ss 1798.31
R419 vss_clamp_vdda vss_vcm 1485.78
R420 vss_clamp_vdda vss_vdda_e4 0.433184
R421 vss_clamp_vdda vssdcp 0.821232
R422 vss_clamp_vdda vssdsm 10.5046
R423 vss_clamp_vdda vssring_2 2154.49
R424 vss_clamp_vdda vssring_3 0.403279
R425 vss_clamp_vdda vssring_7 6.66276
R426 vss_clk vss_iovdd_w4 73982.4
R427 vss_clk vss_iovdd_w5 594.142
R428 vss_clk vss_mosi 357.113
R429 vss_clk vss_rstn 0.275476
R430 vss_clk vss_sclk 0.264888
R431 vss_clk vss_ss 74425.1
R432 vss_clk vssring_6 93936.7
R433 vss_datain vss_dsmclk 35004.8
R434 vss_datain vss_vss_s3 324.99
R435 vss_datain vss_vss_w1 0.419532
R436 vss_datain vssring_0 1796.9
R437 vss_datain vssring_4 3949.64
R438 vss_doq vss_doqb 0.265689
R439 vss_doq vss_dsmclk 0.265832
R440 vss_doq vss_vcm 104524
R441 vss_doq vss_vi 571.297
R442 vss_doq vss_vss_s3 383.726
R443 vss_doq vssring_2 629755
R444 vss_doq vssring_5 27722.4
R445 vss_doqb vss_dsmclk 328.742
R446 vss_doqb vss_ibiastest 145114
R447 vss_doqb vss_vcm 70.4851
R448 vss_doqb vss_vi 0.449381
R449 vss_doqb vss_vss_s3 73020.5
R450 vss_doqb vssring_2 229.356
R451 vss_doqb vssring_5 8.87415
R452 vss_dsmclk vss_vi 108453
R453 vss_dsmclk vss_vss_s3 0.320666
R454 vss_ibiastest vss_miso 386684
R455 vss_ibiastest vss_vcm 0.298928
R456 vss_ibiastest vss_vdda_e4 0.295824
R457 vss_ibiastest vss_vi 421.414
R458 vss_ibiastest vssdcp 22985.6
R459 vss_ibiastest vssdsm 2.93027
R460 vss_ibiastest vssring_2 2.7816
R461 vss_ibiastest vssring_3 75.2542
R462 vss_ibiastest vssring_5 878613
R463 vss_ibiastest vssring_7 386726
R464 vss_iovdd_w4 vss_iovdd_w5 0.237633
R465 vss_iovdd_w4 vss_iovss_w3 0.264823
R466 vss_iovdd_w4 vss_rstn 60.4448
R467 vss_iovdd_w4 vss_vdd_w2 44.5613
R468 vss_iovdd_w4 vssring_0 561.316
R469 vss_iovdd_w4 vssring_1 0.422148
R470 vss_iovdd_w4 vssring_6 53.6564
R471 vss_iovdd_w5 vss_iovss_w3 345.013
R472 vss_iovdd_w5 vss_rstn 0.435237
R473 vss_iovdd_w5 vss_sclk 131264
R474 vss_iovdd_w5 vss_vdd_w2 42656.8
R475 vss_iovdd_w5 vssring_1 5.96564
R476 vss_iovdd_w5 vssring_6 1.53184
R477 vss_iovss_w3 vss_rstn 95076.2
R478 vss_iovss_w3 vss_vdd_w2 0.254972
R479 vss_iovss_w3 vssring_0 14.2729
R480 vss_iovss_w3 vssring_1 1.2262
R481 vss_iovss_w3 vssring_6 365106
R482 vss_miso vss_mosi 347.747
R483 vss_miso vss_sclk 72464.8
R484 vss_miso vss_ss 0.27626
R485 vss_miso vss_vdda_e4 971.416
R486 vss_miso vssdcp 2.02762
R487 vss_miso vssdsm 14556.2
R488 vss_miso vssring_3 370.776
R489 vss_miso vssring_7 11.4254
R490 vss_mosi vss_rstn 76649.6
R491 vss_mosi vss_sclk 0.264892
R492 vss_mosi vss_ss 0.264897
R493 vss_rstn vss_sclk 366.523
R494 vss_rstn vssring_1 749.779
R495 vss_rstn vssring_6 44.9161
R496 vss_sclk vss_ss 357.08
R497 vss_ss vssdcp 7326.15
R498 vss_ss vssring_7 41282.2
R499 vss_vcm vss_vdda_e4 21.7861
R500 vss_vcm vss_vi 0.279325
R501 vss_vcm vssdcp 120197
R502 vss_vcm vssdsm 14.379
R503 vss_vcm vssring_2 0.130944
R504 vss_vcm vssring_3 371.454
R505 vss_vcm vssring_5 88.4984
R506 vss_vdd_w2 vss_vss_w1 5730.38
R507 vss_vdd_w2 vssring_0 2.94127
R508 vss_vdd_w2 vssring_1 91.3304
R509 vss_vdda_e4 vss_vi 61926.1
R510 vss_vdda_e4 vssdcp 59.8271
R511 vss_vdda_e4 vssdsm 2.12307
R512 vss_vdda_e4 vssring_2 33.0196
R513 vss_vdda_e4 vssring_3 1.98912
R514 vss_vdda_e4 vssring_7 1006.48
R515 vss_vi vssdsm 94696.2
R516 vss_vi vssring_2 1.9635
R517 vss_vi vssring_5 1.37778
R518 vss_vss_s3 vss_vss_w1 107696
R519 vss_vss_w1 vssring_0 2.11858
R520 vss_vss_w1 vssring_4 1.78188
R521 vssdcp vssdsm 843.184
R522 vssdcp vssring_2 173230
R523 vssdcp vssring_3 21.4354
R524 vssdcp vssring_7 1.87501
R525 vssdsm vssring_2 20.6961
R526 vssdsm vssring_3 2.60181
R527 vssdsm vssring_7 14187.3
R528 vssring_0 vssring_1 1021.18
R529 vssring_0 vssring_4 99.7837
R530 vssring_1 vssring_6 614.918
R531 vssring_2 vssring_3 534.708
R532 vssring_2 vssring_5 262.633
R533 vssring_3 vssring_7 360.671
R534 vssring_4 vssring_5 1.08
R535 vssring_6 vssring_7 1.08
.ends
