* NGSPICE file created from dsa1_dig_top.ext - technology: ihp-sg13cmos5l

* Black-box entry subcircuit for FILLER2 abstract view
.subckt FILLER2 VSS VDD
.ends

* Black-box entry subcircuit for MUXI2X1 abstract view
.subckt MUXI2X1 A0 A1 S0 VDD VSS Y
.ends

* Black-box entry subcircuit for WELLTAP abstract view
.subckt WELLTAP VDD VSS
.ends

* Black-box entry subcircuit for DFFQX1 abstract view
.subckt DFFQX1 CK D Q VDD VSS
.ends

* Black-box entry subcircuit for FILLER4 abstract view
.subckt FILLER4 VDD VSS
.ends

* Black-box entry subcircuit for FILLER1 abstract view
.subckt FILLER1 VDD VSS
.ends

* Black-box entry subcircuit for DECAPHV16 abstract view
.subckt DECAPHV16 VDD VSS
.ends

* Black-box entry subcircuit for BUFX3 abstract view
.subckt BUFX3 A VDD VSS Y
.ends

* Black-box entry subcircuit for DFFRQX1 abstract view
.subckt DFFRQX1 CK D Q RB VDD VSS
.ends

* Black-box entry subcircuit for XOR2X1 abstract view
.subckt XOR2X1 A B VDD VSS Y
.ends

* Black-box entry subcircuit for DECAPHV8 abstract view
.subckt DECAPHV8 VDD VSS
.ends

* Black-box entry subcircuit for XNOR3X1 abstract view
.subckt XNOR3X1 A B C VDD VSS Y
.ends

* Black-box entry subcircuit for INVX1 abstract view
.subckt INVX1 A VDD VSS Y
.ends

* Black-box entry subcircuit for AND2X1 abstract view
.subckt AND2X1 A B VDD VSS Y
.ends

* Black-box entry subcircuit for MIN3X1 abstract view
.subckt MIN3X1 A B C VDD VSS Y
.ends

* Black-box entry subcircuit for NAND3X1 abstract view
.subckt NAND3X1 A B VDD VSS Y C
.ends

* Black-box entry subcircuit for XNOR2X1 abstract view
.subckt XNOR2X1 A B VDD VSS Y
.ends

* Black-box entry subcircuit for NOR3X1 abstract view
.subckt NOR3X1 A B C VDD VSS Y
.ends

* Black-box entry subcircuit for OAOI211X1 abstract view
.subckt OAOI211X1 A B C D VDD VSS Y
.ends

* Black-box entry subcircuit for OAI21X1 abstract view
.subckt OAI21X1 A B C VDD VSS Y
.ends

* Black-box entry subcircuit for NOR2BX1 abstract view
.subckt NOR2BX1 AB B VDD VSS Y
.ends

* Black-box entry subcircuit for AND3BX1 abstract view
.subckt AND3BX1 AB B C VDD VSS Y
.ends

* Black-box entry subcircuit for AOAI211X1 abstract view
.subckt AOAI211X1 A B C D VDD VSS Y
.ends

* Black-box entry subcircuit for OR2X2 abstract view
.subckt OR2X2 A B VDD VSS Y
.ends

* Black-box entry subcircuit for OA21X2 abstract view
.subckt OA21X2 A B C VDD VSS Y
.ends

* Black-box entry subcircuit for NOR2X1 abstract view
.subckt NOR2X1 A B VDD VSS Y
.ends

* Black-box entry subcircuit for NAND2X1 abstract view
.subckt NAND2X1 A B VDD VSS Y
.ends

* Black-box entry subcircuit for AOI211X1 abstract view
.subckt AOI211X1 A B C D VDD VSS Y
.ends

* Black-box entry subcircuit for AOI21X1 abstract view
.subckt AOI21X1 A B C VDD VSS Y
.ends

* Black-box entry subcircuit for OAI31X1 abstract view
.subckt OAI31X1 A B C D VDD VSS Y
.ends

* Black-box entry subcircuit for AOI31X1 abstract view
.subckt AOI31X1 A B C D VDD VSS Y
.ends

* Black-box entry subcircuit for AOI22X1 abstract view
.subckt AOI22X1 A B C D VDD VSS Y
.ends

* Black-box entry subcircuit for AO22X2 abstract view
.subckt AO22X2 A B C D VDD VSS Y
.ends

* Black-box entry subcircuit for DECAPHV32 abstract view
.subckt DECAPHV32 VDD VSS
.ends

* Black-box entry subcircuit for AO21X2 abstract view
.subckt AO21X2 A B C VDD VSS Y
.ends

* Black-box entry subcircuit for NAND2BX1 abstract view
.subckt NAND2BX1 AB B VDD VSS Y
.ends

* Black-box entry subcircuit for AND3X2 abstract view
.subckt AND3X2 A B VDD VSS Y C
.ends

* Black-box entry subcircuit for BUFX12 abstract view
.subckt BUFX12 A VDD VSS Y
.ends

* Black-box entry subcircuit for OR3BX1 abstract view
.subckt OR3BX1 AB B C VDD VSS Y
.ends

* Black-box entry subcircuit for BUFX6 abstract view
.subckt BUFX6 A VDD VSS Y
.ends

* Black-box entry subcircuit for BUFX4 abstract view
.subckt BUFX4 A VDD VSS Y
.ends

* Black-box entry subcircuit for NOR3BX1 abstract view
.subckt NOR3BX1 AB B C VDD VSS Y
.ends

* Black-box entry subcircuit for AOI221X1 abstract view
.subckt AOI221X1 A B C D E VDD VSS Y
.ends

* Black-box entry subcircuit for ANTENNA2 abstract view
.subckt ANTENNA2 A VDD VSS
.ends

* Black-box entry subcircuit for OA211X2 abstract view
.subckt OA211X2 A B C D VDD VSS Y
.ends

* Black-box entry subcircuit for OAOI211X2 abstract view
.subckt OAOI211X2 A B C D VDD VSS Y
.ends

* Black-box entry subcircuit for OR3X2 abstract view
.subckt OR3X2 A B C VDD VSS Y
.ends

* Black-box entry subcircuit for OAI211X1 abstract view
.subckt OAI211X1 A B C D VDD VSS Y
.ends

* Black-box entry subcircuit for INVX4 abstract view
.subckt INVX4 A VDD VSS Y
.ends

* Black-box entry subcircuit for AOI21BX1 abstract view
.subckt AOI21BX1 A B CB VDD VSS Y
.ends

* Black-box entry subcircuit for XOR3X1 abstract view
.subckt XOR3X1 A B C VDD VSS Y
.ends

* Black-box entry subcircuit for AOI2B2BX1 abstract view
.subckt AOI2B2BX1 AB B CB D VDD VSS Y
.ends

* Black-box entry subcircuit for NAND4X2 abstract view
.subckt NAND4X2 A B VDD VSS Y C D
.ends

* Black-box entry subcircuit for AOI2B1X1 abstract view
.subckt AOI2B1X1 AB B C VDD VSS Y
.ends

* Black-box entry subcircuit for MUX2X1 abstract view
.subckt MUX2X1 A0 A1 S0 VDD VSS Y
.ends

* Black-box entry subcircuit for INVX2 abstract view
.subckt INVX2 A VDD VSS Y
.ends

* Black-box entry subcircuit for BUFX8 abstract view
.subckt BUFX8 A VDD VSS Y
.ends

* Black-box entry subcircuit for NOR4X2 abstract view
.subckt NOR4X2 A B C D VDD VSS Y
.ends

* Black-box entry subcircuit for AO31X2 abstract view
.subckt AO31X2 A B C D VDD VSS Y
.ends

* Black-box entry subcircuit for AO211X2 abstract view
.subckt AO211X2 A B C D VDD VSS Y
.ends

* Black-box entry subcircuit for INVX14 abstract view
.subckt INVX14 A VDD VSS Y
.ends

* Black-box entry subcircuit for AND4X2 abstract view
.subckt AND4X2 A B C D VDD VSS Y
.ends

* Black-box entry subcircuit for NAND3BX1 abstract view
.subckt NAND3BX1 AB B C VDD VSS Y
.ends

* Black-box entry subcircuit for INVX16 abstract view
.subckt INVX16 A VDD VSS Y
.ends

* Black-box entry subcircuit for CGX3 abstract view
.subckt CGX3 CK E ECK VDD VSS
.ends

* Black-box entry subcircuit for OAI22X1 abstract view
.subckt OAI22X1 A B C D VDD VSS Y
.ends

* Black-box entry subcircuit for INVX6 abstract view
.subckt INVX6 A VDD VSS Y
.ends

* Black-box entry subcircuit for INVX8 abstract view
.subckt INVX8 A VDD VSS Y
.ends

* Black-box entry subcircuit for OAI221X1 abstract view
.subckt OAI221X1 A B C D E VDD VSS Y
.ends

* Black-box entry subcircuit for OAI2B2BX1 abstract view
.subckt OAI2B2BX1 AB B CB D VDD VSS Y
.ends

* Black-box entry subcircuit for OR3BX2 abstract view
.subckt OR3BX2 AB B C VDD VSS Y
.ends

* Black-box entry subcircuit for NOR2X2 abstract view
.subckt NOR2X2 A B VDD VSS Y
.ends

* Black-box entry subcircuit for AOI2B2X1 abstract view
.subckt AOI2B2X1 AB B C D VDD VSS Y
.ends

* Black-box entry subcircuit for AOI2BB2X1 abstract view
.subckt AOI2BB2X1 AB BB C D VDD VSS Y
.ends

* Black-box entry subcircuit for AOI221X2 abstract view
.subckt AOI221X2 A B C D E VDD VSS Y
.ends

* Black-box entry subcircuit for NAND3BX2 abstract view
.subckt NAND3BX2 AB B C VDD VSS Y
.ends

* Black-box entry subcircuit for OR4X1 abstract view
.subckt OR4X1 A B VDD VSS Y C D
.ends

* Black-box entry subcircuit for NOR2BX2 abstract view
.subckt NOR2BX2 AB B VDD VSS Y
.ends

* Black-box entry subcircuit for NAND2X1P5 abstract view
.subckt NAND2X1P5 A B VDD VSS Y
.ends

* Black-box entry subcircuit for NAND4BX1 abstract view
.subckt NAND4BX1 AB B C D VDD VSS Y
.ends

.subckt dsa1_dig_top VDD VSS adc_conv clk data_in miso mosi o_aux_ctrl[0] o_aux_ctrl[10]
+ o_aux_ctrl[11] o_aux_ctrl[12] o_aux_ctrl[13] o_aux_ctrl[14] o_aux_ctrl[15] o_aux_ctrl[1]
+ o_aux_ctrl[2] o_aux_ctrl[3] o_aux_ctrl[4] o_aux_ctrl[5] o_aux_ctrl[6] o_aux_ctrl[7]
+ o_aux_ctrl[8] o_aux_ctrl[9] o_bias_cfg[0] o_bias_cfg[10] o_bias_cfg[11] o_bias_cfg[12]
+ o_bias_cfg[13] o_bias_cfg[14] o_bias_cfg[15] o_bias_cfg[16] o_bias_cfg[17] o_bias_cfg[18]
+ o_bias_cfg[19] o_bias_cfg[1] o_bias_cfg[20] o_bias_cfg[21] o_bias_cfg[22] o_bias_cfg[23]
+ o_bias_cfg[24] o_bias_cfg[25] o_bias_cfg[26] o_bias_cfg[27] o_bias_cfg[28] o_bias_cfg[29]
+ o_bias_cfg[2] o_bias_cfg[30] o_bias_cfg[31] o_bias_cfg[32] o_bias_cfg[33] o_bias_cfg[34]
+ o_bias_cfg[3] o_bias_cfg[4] o_bias_cfg[5] o_bias_cfg[6] o_bias_cfg[7] o_bias_cfg[8]
+ o_bias_cfg[9] o_clk_cfg[0] o_clk_cfg[10] o_clk_cfg[11] o_clk_cfg[12] o_clk_cfg[13]
+ o_clk_cfg[14] o_clk_cfg[15] o_clk_cfg[16] o_clk_cfg[17] o_clk_cfg[18] o_clk_cfg[1]
+ o_clk_cfg[2] o_clk_cfg[3] o_clk_cfg[4] o_clk_cfg[5] o_clk_cfg[6] o_clk_cfg[7] o_clk_cfg[8]
+ o_clk_cfg[9] o_en_ctrl[0] o_en_ctrl[10] o_en_ctrl[1] o_en_ctrl[2] o_en_ctrl[3] o_en_ctrl[4]
+ o_en_ctrl[5] o_en_ctrl[6] o_en_ctrl[7] o_en_ctrl[8] o_en_ctrl[9] o_lf_cfg[0] o_lf_cfg[10]
+ o_lf_cfg[11] o_lf_cfg[12] o_lf_cfg[13] o_lf_cfg[14] o_lf_cfg[15] o_lf_cfg[1] o_lf_cfg[2]
+ o_lf_cfg[3] o_lf_cfg[4] o_lf_cfg[5] o_lf_cfg[6] o_lf_cfg[7] o_lf_cfg[8] o_lf_cfg[9]
+ o_rst_ctrl_b[0] o_rst_ctrl_b[1] o_tst_ctrl[0] o_tst_ctrl[10] o_tst_ctrl[11] o_tst_ctrl[12]
+ o_tst_ctrl[13] o_tst_ctrl[14] o_tst_ctrl[15] o_tst_ctrl[1] o_tst_ctrl[2] o_tst_ctrl[3]
+ o_tst_ctrl[4] o_tst_ctrl[5] o_tst_ctrl[6] o_tst_ctrl[7] o_tst_ctrl[8] o_tst_ctrl[9]
+ o_uwb_tx_cfg[0] o_uwb_tx_cfg[10] o_uwb_tx_cfg[11] o_uwb_tx_cfg[12] o_uwb_tx_cfg[13]
+ o_uwb_tx_cfg[14] o_uwb_tx_cfg[15] o_uwb_tx_cfg[16] o_uwb_tx_cfg[17] o_uwb_tx_cfg[18]
+ o_uwb_tx_cfg[19] o_uwb_tx_cfg[1] o_uwb_tx_cfg[20] o_uwb_tx_cfg[21] o_uwb_tx_cfg[22]
+ o_uwb_tx_cfg[23] o_uwb_tx_cfg[24] o_uwb_tx_cfg[25] o_uwb_tx_cfg[26] o_uwb_tx_cfg[27]
+ o_uwb_tx_cfg[28] o_uwb_tx_cfg[29] o_uwb_tx_cfg[2] o_uwb_tx_cfg[3] o_uwb_tx_cfg[4]
+ o_uwb_tx_cfg[5] o_uwb_tx_cfg[6] o_uwb_tx_cfg[7] o_uwb_tx_cfg[8] o_uwb_tx_cfg[9]
+ rst_b sclk ss
XFILLER_95_840 VSS VDD FILLER2
XFILLER_39_233 VSS VDD FILLER2
X_09671_ _20139_/A _20187_/A _09626_/B VDD VSS _09682_/B MUXI2X1
XTAP_TAPCELL_ROW_146_1323 VDD VSS WELLTAP
X_18869_ _18924_/CK _18869_/D _18869_/Q VDD VSS DFFQX1
XFILLER_39_255 VSS VDD FILLER2
XFILLER_55_715 VDD VSS FILLER4
XFILLER_39_277 VSS VDD FILLER2
XFILLER_36_19 VSS VDD FILLER2
XFILLER_27_417 VSS VDD FILLER2
XFILLER_94_372 VSS VDD FILLER2
XFILLER_55_737 VDD VSS FILLER4
XFILLER_39_288 VDD VSS FILLER1
XFILLER_27_439 VSS VDD FILLER2
XFILLER_54_269 VSS VDD FILLER2
XFILLER_35_461 VDD VSS FILLER4
XTAP_TAPCELL_ROW_80_735 VDD VSS WELLTAP
XFILLER_52_18 VSS VDD FILLER2
XFILLER_11_807 VSS VDD FILLER2
XFILLER_22_177 VSS VDD FILLER2
XFILLER_10_328 VSS VDD FILLER2
XTAP_TAPCELL_ROW_157_1430 VDD VSS WELLTAP
XFILLER_22_199 VSS VDD FILLER2
XFILLER_108_205 VSS VDD FILLER2
XFILLER_136_514 VDD VSS DECAPHV16
XFILLER_164_823 VSS VDD FILLER2
XFILLER_148_385 VSS VDD FILLER2
XFILLER_136_536 VSS VDD FILLER2
XFILLER_164_856 VDD VSS FILLER1
XFILLER_163_333 VSS VDD FILLER2
XFILLER_117_783 VSS VDD FILLER2
XTAP_TAPCELL_ROW_112_1024 VDD VSS WELLTAP
XFILLER_77_37 VDD VSS FILLER1
XTAP_TAPCELL_ROW_88_802 VDD VSS WELLTAP
XFILLER_89_166 VSS VDD FILLER2
XFILLER_132_797 VSS VDD FILLER2
X_20127_ _20127_/A VDD VSS _20127_/Y BUFX3
X_09938_ _09938_/A VDD VSS _10034_/A BUFX3
XFILLER_77_339 VSS VDD FILLER2
XFILLER_58_520 VDD VSS FILLER1
XFILLER_133_32 VSS VDD FILLER2
X_20058_ clkload6/A _20193_/A _20059_/D _20071_/RB VDD VSS DFFRQX1
X_09869_ _18575_/Q _09869_/B VDD VSS _09869_/Y XOR2X1
XFILLER_133_54 VSS VDD FILLER2
XFILLER_58_586 VDD VSS DECAPHV8
X_11900_ _11968_/A _11961_/B _11961_/C VDD VSS _11958_/C XNOR3X1
XFILLER_85_383 VDD VSS FILLER4
X_12880_ _18881_/Q _13181_/B _12885_/C VDD VSS _17880_/B XNOR3X1
XFILLER_45_225 VSS VDD FILLER2
XTAP_TAPCELL_ROW_164_1489 VDD VSS WELLTAP
XFILLER_73_556 VSS VDD FILLER2
XFILLER_93_69 VSS VDD FILLER2
X_11831_ _19230_/Q VDD VSS _11876_/A INVX1
XFILLER_45_258 VSS VDD FILLER2
XTAP_TAPCELL_ROW_123_1120 VDD VSS WELLTAP
XFILLER_14_601 VSS VDD FILLER2
XTAP_TAPCELL_ROW_43_404 VDD VSS WELLTAP
XFILLER_26_461 VSS VDD FILLER2
X_14550_ _19990_/Q _14558_/B VDD VSS _19254_/D AND2X1
X_11762_ _19172_/Q _11762_/B _11762_/C VDD VSS _11852_/B MIN3X1
XFILLER_159_606 VSS VDD FILLER2
X_13501_ _18914_/Q _14159_/B VDD VSS _13502_/C _14159_/C NAND3X1
X_10713_ _18642_/Q _18804_/Q VDD VSS _10715_/C XNOR2X1
X_14481_ _14490_/A _14481_/B _14481_/C VDD VSS _19194_/D NOR3X1
XFILLER_41_464 VDD VSS FILLER1
X_11693_ _19988_/Q _19252_/Q VDD VSS _11716_/C AND2X1
X_16220_ _19719_/Q _16883_/B VDD VSS _16222_/C XNOR2X1
XFILLER_41_486 VSS VDD FILLER2
X_13432_ _13432_/A _13432_/B _13432_/C _13432_/D VDD VSS _14388_/B OAOI211X1
XTAP_TAPCELL_ROW_51_470 VDD VSS WELLTAP
X_10644_ _10718_/A _10718_/B _11195_/A VDD VSS _10645_/D OAI21X1
XFILLER_158_51 VDD VSS FILLER1
X_16151_ _16845_/B _19684_/Q VDD VSS _16152_/C NOR2BX1
XFILLER_154_300 VDD VSS FILLER1
X_13363_ _13219_/A _14386_/B _14386_/C VDD VSS _13364_/C AND3BX1
X_10575_ _10576_/A _10576_/B _10576_/D _10576_/C VDD VSS _10642_/B AOAI211X1
XFILLER_139_396 VSS VDD FILLER2
XFILLER_5_310 VSS VDD FILLER2
X_15102_ _19536_/Q _15102_/B VDD VSS _15903_/B XOR2X1
X_12314_ _19183_/Q VDD VSS _12331_/A INVX1
XFILLER_6_855 VSS VDD FILLER2
XFILLER_127_569 VSS VDD FILLER2
X_16082_ _19617_/Q _16769_/B VDD VSS _16083_/C OR2X2
XFILLER_5_332 VDD VSS FILLER4
XFILLER_108_750 VDD VSS FILLER1
X_13294_ _13494_/B _13385_/B _13385_/C VDD VSS _13502_/A OA21X2
X_15033_ _15036_/B _15033_/B VDD VSS _18089_/B XNOR2X1
X_19910_ clkload8/A _19910_/D _19910_/Q VDD VSS DFFQX1
XFILLER_154_388 VSS VDD FILLER2
X_12245_ _19126_/Q _14405_/B VDD VSS _12258_/B XNOR2X1
XFILLER_107_282 VSS VDD FILLER2
XFILLER_123_742 VSS VDD FILLER2
XFILLER_122_230 VSS VDD FILLER2
X_19841_ _19841_/CK _19841_/D _19841_/Q VDD VSS DFFQX1
X_12176_ _14436_/B _14436_/C VDD VSS _12177_/B NOR2X1
XFILLER_122_241 VSS VDD FILLER2
XFILLER_69_818 VSS VDD FILLER2
XFILLER_96_615 VDD VSS FILLER4
XFILLER_68_317 VDD VSS DECAPHV8
XTAP_TAPCELL_ROW_130_1179 VDD VSS WELLTAP
XFILLER_95_103 VDD VSS DECAPHV16
XFILLER_150_583 VDD VSS FILLER4
X_11127_ _11127_/A VDD VSS _11364_/B BUFX3
XFILLER_68_328 VSS VDD FILLER2
XFILLER_150_594 VSS VDD FILLER2
X_16984_ _16984_/A _16984_/B VDD VSS _16996_/A NAND2X1
X_19772_ clkload4/A _19772_/D _19772_/Q VDD VSS DFFQX1
XFILLER_95_136 VDD VSS FILLER4
XFILLER_110_447 VSS VDD FILLER2
XFILLER_77_840 VSS VDD FILLER2
X_15935_ _19612_/Q _16764_/B _15935_/C VDD VSS _15969_/A OAI21X1
X_18723_ _19947_/CK _18723_/D _18723_/Q VDD VSS DFFQX1
X_11058_ _11090_/A _11090_/B _11127_/A VDD VSS _11083_/A OAI21X1
XFILLER_83_309 VSS VDD FILLER2
X_10009_ _10180_/A _11407_/C VDD VSS _18529_/D NOR2X1
X_18654_ _18845_/CK _18654_/D _18654_/Q VDD VSS DFFQX1
X_15866_ _15879_/A _15866_/B VDD VSS _19475_/D AND2X1
X_09968__239 _20081_/CK VDD VSS _18515_/CK INVX1
XFILLER_92_854 VSS VDD FILLER2
X_14817_ _19447_/Q _14865_/A _14817_/C VDD VSS _14818_/D XNOR3X1
X_17605_ _19882_/Q _19850_/Q VDD VSS _17610_/A XNOR2X1
X_18585_ _18595_/CK _18585_/D _18585_/Q VDD VSS DFFQX1
XFILLER_52_718 VDD VSS FILLER4
X_15797_ _15800_/A _15797_/B VDD VSS _19415_/D NOR2X1
XFILLER_91_375 VSS VDD FILLER2
XFILLER_51_217 VSS VDD FILLER2
X_17536_ _17536_/A _17536_/B _17537_/C VDD VSS _19867_/D NOR3X1
XFILLER_17_483 VDD VSS DECAPHV16
X_14748_ _19500_/Q _14748_/B VDD VSS _14785_/C NAND2X1
XFILLER_83_91 VSS VDD FILLER2
XFILLER_32_431 VDD VSS FILLER4
XTAP_TAPCELL_ROW_141_1286 VDD VSS WELLTAP
X_17467_ _17468_/A _17468_/B _17468_/D _17468_/C VDD VSS _17470_/C AOI211X1
X_14679_ _19526_/Q _14742_/C VDD VSS _15892_/B XNOR2X1
XFILLER_149_127 VDD VSS FILLER1
X_16418_ _16784_/B _19630_/Q VDD VSS _16429_/A NOR2BX1
X_19206_ _19250_/CK _19206_/D _19206_/Q VDD VSS DFFQX1
XFILLER_32_497 VSS VDD FILLER2
X_17398_ _19837_/Q _19805_/Q _17398_/C VDD VSS _17402_/B AOI21X1
XFILLER_20_659 VSS VDD FILLER2
XFILLER_118_514 VDD VSS FILLER4
X_19137_ _19166_/CK _19137_/D _19137_/Q VDD VSS DFFQX1
X_16349_ _16390_/B _16349_/B VDD VSS _16853_/B NOR2BX1
XFILLER_9_671 VSS VDD FILLER2
XFILLER_66_0 VDD VSS FILLER1
XFILLER_157_193 VSS VDD FILLER2
X_19068_ _19068_/CK _19068_/D _19068_/Q VDD VSS DFFQX1
X_18019_ _18020_/B _18045_/B _18019_/C _18056_/C VDD VSS _19967_/D OAI31X1
XFILLER_133_539 VDD VSS FILLER1
XFILLER_160_314 VSS VDD FILLER2
XFILLER_99_420 VSS VDD FILLER2
XTAP_TAPCELL_ROW_152_1382 VDD VSS WELLTAP
XFILLER_99_442 VSS VDD FILLER2
XFILLER_99_453 VSS VDD FILLER2
XFILLER_141_550 VSS VDD FILLER2
XFILLER_141_561 VSS VDD FILLER2
XFILLER_99_475 VSS VDD FILLER2
XFILLER_59_306 VSS VDD FILLER2
XFILLER_101_403 VSS VDD FILLER2
XFILLER_99_497 VSS VDD FILLER2
XFILLER_87_648 VSS VDD FILLER2
X_09723_ _20172_/A _09784_/C VDD VSS _09725_/C NAND2X1
XFILLER_28_704 VSS VDD FILLER2
XFILLER_95_670 VSS VDD FILLER2
XFILLER_67_361 VSS VDD FILLER2
XTAP_TAPCELL_ROW_57_529 VDD VSS WELLTAP
XFILLER_83_832 VDD VSS FILLER4
X_09654_ _18493_/Q VDD VSS _20106_/A INVX1
XFILLER_103_35 VSS VDD FILLER2
XFILLER_55_556 VSS VDD FILLER2
X_09585_ _18441_/Q VDD VSS _20153_/A INVX1
XFILLER_103_79 VDD VSS FILLER1
XTAP_TAPCELL_ROW_105_961 VDD VSS WELLTAP
XTAP_TAPCELL_ROW_65_595 VDD VSS WELLTAP
XFILLER_70_548 VSS VDD FILLER2
XFILLER_23_420 VDD VSS FILLER1
XFILLER_50_272 VSS VDD FILLER2
XFILLER_149_683 VDD VSS FILLER1
XFILLER_6_129 VDD VSS FILLER4
XFILLER_109_547 VSS VDD FILLER2
XFILLER_137_856 VDD VSS FILLER1
X_10360_ _19939_/Q _18821_/Q VDD VSS _10417_/A NAND2X1
XFILLER_128_43 VSS VDD FILLER2
XTAP_TAPCELL_ROW_20_197 VDD VSS WELLTAP
XFILLER_152_826 VSS VDD FILLER2
XFILLER_163_163 VDD VSS FILLER4
XFILLER_152_837 VSS VDD FILLER2
XFILLER_124_539 VDD VSS FILLER4
X_10291_ _19937_/Q _18819_/Q VDD VSS _10343_/A AND2X1
XFILLER_3_836 VDD VSS FILLER1
XFILLER_88_36 VDD VSS FILLER1
XFILLER_105_742 VSS VDD FILLER2
XFILLER_151_347 VSS VDD FILLER2
X_12030_ _14433_/C _19150_/Q _12116_/B VDD VSS _12031_/D AND3BX1
XFILLER_88_58 VDD VSS FILLER4
XFILLER_5_4 VSS VDD FILLER2
XFILLER_151_358 VSS VDD FILLER2
XFILLER_2_346 VDD VSS FILLER4
XFILLER_105_786 VDD VSS FILLER4
XFILLER_78_626 VSS VDD FILLER2
XFILLER_104_274 VSS VDD FILLER2
XFILLER_105_797 VSS VDD FILLER2
XFILLER_132_583 VSS VDD FILLER2
XFILLER_78_637 VDD VSS FILLER4
XTAP_TAPCELL_ROW_166_1507 VDD VSS WELLTAP
XFILLER_77_114 VDD VSS FILLER4
XTAP_TAPCELL_ROW_166_1518 VDD VSS WELLTAP
XFILLER_59_840 VSS VDD FILLER2
XFILLER_144_75 VSS VDD FILLER2
X_13981_ _13981_/A _13981_/B _13981_/C _13981_/D VDD VSS _13995_/B AOAI211X1
XFILLER_92_117 VSS VDD FILLER2
X_15720_ _15725_/A _15720_/B VDD VSS _19346_/D AND2X1
XFILLER_86_681 VDD VSS DECAPHV8
XFILLER_58_372 VSS VDD FILLER2
X_12932_ _12932_/A _12932_/B _12932_/C _12932_/D VDD VSS _14413_/B OAOI211X1
XFILLER_74_843 VSS VDD FILLER2
X_15651_ _19329_/Q _15701_/B VDD VSS _15652_/C NOR2BX1
XFILLER_37_84 VDD VSS FILLER4
X_12863_ _19105_/Q _12863_/B _12939_/C VDD VSS _13102_/B XNOR3X1
XFILLER_18_269 VDD VSS FILLER4
XFILLER_160_63 VSS VDD FILLER2
XFILLER_73_375 VDD VSS FILLER4
XTAP_TAPCELL_ROW_28_264 VDD VSS WELLTAP
XFILLER_160_85 VSS VDD FILLER2
X_14602_ _14624_/A _14624_/B VDD VSS _14607_/B NOR2X1
XFILLER_27_781 VSS VDD FILLER2
X_18370_ _18375_/CK _18519_/Q _20207_/A _20075_/RB VDD VSS DFFRQX1
X_11814_ _19091_/Q VDD VSS _11908_/A INVX1
XTAP_TAPCELL_ROW_8_88 VDD VSS WELLTAP
X_15582_ _15597_/A _15582_/B VDD VSS _15759_/B XNOR2X1
X_12794_ _12877_/A _12877_/B _14184_/B VDD VSS _12883_/C XNOR3X1
XFILLER_42_740 VDD VSS FILLER4
X_17321_ _19821_/Q _19789_/Q VDD VSS _17323_/B XOR2X1
XFILLER_14_453 VDD VSS FILLER4
X_14533_ _14766_/A _14533_/B VDD VSS _19239_/D AND2X1
X_11745_ _11745_/A _11745_/B _11745_/C _11745_/D VDD VSS _11835_/B OAOI211X1
XFILLER_159_436 VSS VDD FILLER2
XFILLER_14_486 VSS VDD FILLER2
X_17252_ _17250_/B _17252_/B VDD VSS _17253_/C NOR2BX1
X_14464_ _14467_/A _14464_/B VDD VSS _19178_/D AND2X1
X_11676_ _18813_/Q _14547_/B VDD VSS _18840_/D AND2X1
X_16203_ _19654_/Q _16203_/B _16811_/B VDD VSS _16228_/A MIN3X1
X_13415_ _13415_/A _13415_/B _13415_/C _13415_/D VDD VSS _13420_/B OAOI211X1
X_17183_ _17185_/C _17183_/B _17183_/C VDD VSS _19791_/D AOI21X1
X_10627_ _10627_/A _10630_/B VDD VSS _10665_/B XNOR2X1
X_14395_ _14457_/A VDD VSS _14426_/A BUFX3
XFILLER_127_322 VDD VSS FILLER4
XFILLER_139_182 VDD VSS FILLER4
XFILLER_128_856 VDD VSS FILLER1
X_16134_ _16134_/A _16134_/B _16736_/B VDD VSS _16157_/A MIN3X1
X_13346_ _14544_/A _14544_/B _19249_/Q VDD VSS _13347_/D OA21X2
XFILLER_115_506 VSS VDD FILLER2
X_10558_ _10686_/D _10558_/B _10633_/B _10558_/D VDD VSS _10578_/A AOI31X1
XFILLER_154_174 VDD VSS FILLER4
X_16065_ _19585_/Q _16734_/B VDD VSS _16066_/B XNOR2X1
X_13277_ _13308_/A _13300_/B _13300_/C VDD VSS _14221_/C XNOR3X1
X_10489_ _19943_/Q _18825_/Q VDD VSS _10530_/C XNOR2X1
XFILLER_5_184 VSS VDD FILLER2
X_15016_ _15016_/A VDD VSS _15017_/D INVX1
XTAP_TAPCELL_ROW_99_908 VDD VSS WELLTAP
X_12228_ _12236_/A _12236_/B _12236_/D _12236_/C VDD VSS _12396_/B AOI211X1
XFILLER_123_561 VSS VDD FILLER2
XFILLER_96_401 VDD VSS FILLER1
XFILLER_123_583 VSS VDD FILLER2
X_19824_ _19825_/CK _19824_/D _19824_/Q VDD VSS DFFQX1
XFILLER_150_380 VSS VDD FILLER2
X_12159_ _12401_/B _14499_/C _19208_/Q VDD VSS _12160_/D AND3BX1
XFILLER_111_756 VDD VSS FILLER4
XFILLER_84_607 VDD VSS FILLER4
X_19755_ _19791_/CK _19755_/D _19755_/Q VDD VSS DFFQX1
XFILLER_96_478 VSS VDD FILLER2
XFILLER_56_309 VSS VDD FILLER2
X_16967_ _19749_/Q _16978_/B VDD VSS _16971_/B XOR2X1
XFILLER_77_670 VSS VDD FILLER2
XFILLER_65_810 VDD VSS FILLER1
XFILLER_49_361 VSS VDD FILLER2
X_18706_ _18785_/CK _18706_/D _18706_/Q VDD VSS DFFQX1
X_15918_ _19578_/Q _16727_/B VDD VSS _15929_/A NAND2X1
XFILLER_83_139 VDD VSS FILLER4
X_16898_ _16976_/A _16898_/B VDD VSS _19733_/D NOR2X1
X_19686_ _19696_/CK _19686_/D _19686_/Q VDD VSS DFFQX1
XTAP_TAPCELL_ROW_143_1304 VDD VSS WELLTAP
XFILLER_76_191 VDD VSS FILLER4
XFILLER_37_556 VSS VDD FILLER2
XFILLER_37_567 VDD VSS DECAPHV16
X_15849_ _15849_/A _15849_/B VDD VSS _19461_/D AND2X1
X_18637_ _19946_/CK _18637_/D _18637_/Q VDD VSS DFFQX1
XFILLER_91_150 VSS VDD FILLER2
XFILLER_64_375 VSS VDD FILLER2
XFILLER_18_770 VSS VDD FILLER2
XFILLER_92_695 VSS VDD FILLER2
XFILLER_80_835 VDD VSS FILLER1
XFILLER_18_781 VSS VDD FILLER2
XFILLER_52_537 VDD VSS FILLER1
X_09370_ _18506_/Q _18505_/Q VDD VSS _09624_/B _09630_/C NAND3X1
X_18568_ _18589_/CK _18568_/D _18568_/Q VDD VSS DFFQX1
XFILLER_33_751 VSS VDD FILLER2
X_17519_ _17522_/A _17520_/B _17597_/C VDD VSS _17520_/C OAI21X1
XTAP_TAPCELL_ROW_102_931 VDD VSS WELLTAP
X_18499_ _18503_/CK _18499_/D _20112_/A _18503_/RB VDD VSS DFFRQX1
XFILLER_33_795 VSS VDD FILLER2
XFILLER_20_412 VDD VSS FILLER4
XTAP_TAPCELL_ROW_154_1400 VDD VSS WELLTAP
XFILLER_118_311 VSS VDD FILLER2
XFILLER_118_355 VDD VSS DECAPHV8
XFILLER_134_804 VSS VDD FILLER2
XFILLER_165_19 VSS VDD FILLER2
XFILLER_133_314 VSS VDD FILLER2
XFILLER_161_634 VDD VSS FILLER4
XFILLER_160_111 VDD VSS FILLER1
XFILLER_160_122 VSS VDD FILLER2
XFILLER_114_550 VSS VDD FILLER2
XFILLER_133_369 VSS VDD FILLER2
XFILLER_101_200 VSS VDD FILLER2
XFILLER_58_39 VDD VSS FILLER1
XFILLER_141_391 VSS VDD FILLER2
XFILLER_101_244 VDD VSS FILLER1
XFILLER_87_478 VDD VSS FILLER4
XFILLER_47_309 VSS VDD FILLER2
XFILLER_101_277 VSS VDD FILLER2
XFILLER_101_288 VDD VSS FILLER4
X_09706_ _18432_/Q _09811_/B _09811_/C _20205_/A VDD VSS _09707_/B AOI22X1
XFILLER_74_49 VSS VDD FILLER2
X_09637_ _18348_/Q VDD VSS _20216_/A INVX1
XFILLER_83_673 VDD VSS FILLER1
XFILLER_82_150 VSS VDD FILLER2
XFILLER_16_729 VSS VDD FILLER2
XFILLER_55_375 VSS VDD FILLER2
XTAP_TAPCELL_ROW_161_1459 VDD VSS WELLTAP
XFILLER_83_695 VDD VSS FILLER4
XFILLER_71_835 VSS VDD FILLER2
XFILLER_55_386 VSS VDD FILLER2
XFILLER_130_22 VDD VSS FILLER4
XFILLER_130_33 VSS VDD FILLER2
XFILLER_70_323 VSS VDD FILLER2
X_09568_ _20101_/A _09788_/B _09811_/C _20197_/A VDD VSS _09569_/C AOI22X1
XTAP_TAPCELL_ROW_25_234 VDD VSS WELLTAP
XFILLER_70_378 VSS VDD FILLER2
X_09499_ _18495_/D _09501_/B _09506_/C _20073_/Q VDD VSS _20073_/D AO22X2
XFILLER_70_389 VSS VDD FILLER2
X_11530_ _18682_/Q _11531_/B VDD VSS _18709_/D AND2X1
XFILLER_23_42 VDD VSS FILLER4
XFILLER_139_42 VSS VDD FILLER2
X_11461_ _16860_/A VDD VSS _11473_/B BUFX3
XFILLER_139_53 VDD VSS FILLER1
XFILLER_7_438 VDD VSS FILLER4
XFILLER_149_491 VDD VSS DECAPHV8
XFILLER_137_642 VSS VDD FILLER2
X_13200_ _18995_/Q _14257_/B VDD VSS _13203_/C _14257_/C NAND3X1
X_10412_ _18687_/Q _18741_/Q VDD VSS _10413_/D NAND2X1
XFILLER_137_664 VSS VDD FILLER2
X_14180_ _14186_/A _14180_/B VDD VSS _18932_/D NOR2X1
X_11392_ _11392_/A _11392_/B _11392_/C _11392_/D VDD VSS _11393_/B AOAI211X1
XFILLER_137_675 VSS VDD FILLER2
XFILLER_125_826 VSS VDD FILLER2
XTAP_TAPCELL_ROW_118_1074 VDD VSS WELLTAP
XFILLER_164_472 VSS VDD FILLER2
X_13131_ _13131_/A _13131_/B _13131_/C _13131_/D VDD VSS _14478_/B OAOI211X1
XFILLER_99_79 VDD VSS FILLER4
XFILLER_109_399 VSS VDD FILLER2
XFILLER_136_185 VDD VSS DECAPHV8
X_10343_ _10343_/A _10343_/B _10343_/C _10343_/D VDD VSS _10417_/B AOAI211X1
XFILLER_151_122 VSS VDD FILLER2
XFILLER_151_133 VSS VDD FILLER2
XFILLER_152_678 VDD VSS FILLER4
X_13062_ _13131_/A _13131_/B _13131_/C VDD VSS _13125_/C OAI21X1
X_10274_ _11436_/C _10274_/B _232_/E VDD VSS _11386_/C AOI21X1
XFILLER_155_52 VDD VSS DECAPHV8
XFILLER_152_689 VSS VDD FILLER2
XFILLER_105_561 VSS VDD FILLER2
XFILLER_155_85 VDD VSS DECAPHV8
XFILLER_105_583 VSS VDD FILLER2
X_12013_ _19039_/Q VDD VSS _12285_/A INVX1
XFILLER_155_96 VSS VDD FILLER2
XFILLER_105_594 VSS VDD FILLER2
X_17870_ _18851_/Q _17870_/B _17870_/C VDD VSS _17876_/C MIN3X1
XFILLER_132_380 VSS VDD FILLER2
XFILLER_2_187 VDD VSS FILLER1
XFILLER_66_607 VSS VDD FILLER2
XFILLER_120_564 VDD VSS DECAPHV32
X_16821_ _16843_/A _16821_/B VDD VSS _19663_/D AND2X1
XFILLER_38_309 VDD VSS FILLER1
XFILLER_78_489 VSS VDD FILLER2
XFILLER_93_437 VDD VSS DECAPHV8
XFILLER_59_681 VSS VDD FILLER2
X_16752_ _16759_/A _16752_/B VDD VSS _19601_/D NOR2X1
X_19540_ _19734_/CK _19540_/D _19540_/Q VDD VSS DFFQX1
X_13964_ _13965_/A _13965_/C _13965_/B VDD VSS _14301_/A AO21X2
XFILLER_93_448 VSS VDD FILLER2
XTAP_TAPCELL_ROW_129_1170 VDD VSS WELLTAP
XFILLER_19_556 VSS VDD FILLER2
X_15703_ _15710_/A _15703_/B VDD VSS _19331_/D NOR2X1
X_12915_ _12915_/A _12915_/B _12915_/C _12915_/D VDD VSS _14319_/B OAOI211X1
X_16683_ _16683_/A _16683_/B VDD VSS _16832_/B XNOR2X1
X_19471_ _19531_/CK _19471_/D _19471_/Q VDD VSS DFFQX1
XFILLER_80_109 VDD VSS FILLER1
XFILLER_19_578 VDD VSS FILLER4
X_13895_ _19004_/Q VDD VSS _13951_/A INVX1
XFILLER_46_375 VSS VDD FILLER2
XFILLER_61_312 VDD VSS FILLER1
X_15634_ _19328_/Q VDD VSS _15635_/A INVX1
X_18422_ _18422_/CK _18470_/D _20177_/A _18422_/RB VDD VSS DFFRQX1
X_12846_ _12955_/A _12955_/B _12966_/C VDD VSS _14538_/B AO21X2
XFILLER_64_82 VDD VSS FILLER4
XFILLER_64_93 VSS VDD FILLER2
X_18353_ _18359_/CK _18497_/D _20221_/A _18374_/RB VDD VSS DFFRQX1
XFILLER_159_200 VDD VSS DECAPHV8
X_15565_ _19353_/Q _15728_/B VDD VSS _15566_/C NOR2BX1
X_12777_ _12868_/D _12915_/A _12916_/B VDD VSS _12799_/D XNOR3X1
XFILLER_15_784 VSS VDD FILLER2
X_17304_ _19818_/Q _19786_/Q VDD VSS _17309_/A XNOR2X1
X_14516_ _14766_/A _14516_/B VDD VSS _19223_/D AND2X1
X_18284_ _18288_/CK _18284_/D _18284_/Q VDD VSS DFFQX1
X_11728_ _19199_/Q _11728_/B _11760_/C VDD VSS _11733_/C XNOR3X1
XFILLER_30_743 VSS VDD FILLER2
X_15496_ _19323_/Q _15695_/B VDD VSS _15499_/A XOR2X1
XFILLER_159_277 VSS VDD FILLER2
X_17235_ _19802_/Q _19770_/Q _17236_/C VDD VSS _17237_/B AOI21X1
X_14447_ _14421_/Y _14447_/B _14447_/C VDD VSS _19163_/D AND3BX1
X_11659_ _16273_/A VDD VSS _11669_/B BUFX3
XFILLER_128_631 VSS VDD FILLER2
XFILLER_116_804 VDD VSS FILLER1
X_17166_ _19788_/Q _19756_/Q VDD VSS _17168_/D XNOR2X1
X_14378_ _14410_/A _14378_/B _14378_/C VDD VSS _19101_/D NOR3X1
XFILLER_155_450 VDD VSS FILLER4
XFILLER_155_472 VSS VDD FILLER2
XFILLER_116_837 VDD VSS FILLER1
X_16117_ _19619_/Q _16772_/B VDD VSS _16118_/B XNOR2X1
X_13329_ _13329_/A _13329_/B _13329_/C _13329_/D VDD VSS _13466_/A AOAI211X1
XFILLER_127_185 VDD VSS FILLER1
X_17097_ _17094_/B _17097_/B VDD VSS _17098_/C NOR2BX1
X_16048_ _16055_/C _16055_/B VDD VSS _16049_/B NAND2BX1
XFILLER_130_328 VSS VDD FILLER2
XFILLER_142_188 VSS VDD FILLER2
XFILLER_123_391 VDD VSS FILLER4
XFILLER_69_445 VSS VDD FILLER2
X_19807_ _19841_/CK _19807_/D _19807_/Q VDD VSS DFFQX1
XFILLER_29_0 VSS VDD FILLER2
XFILLER_69_478 VDD VSS FILLER4
XFILLER_97_798 VSS VDD FILLER2
XFILLER_69_489 VSS VDD FILLER2
XFILLER_57_629 VDD VSS DECAPHV8
XFILLER_56_106 VDD VSS FILLER1
X_17999_ _18541_/Q _18542_/Q VDD VSS _18044_/B _18042_/B AND3X2
XTAP_TAPCELL_ROW_67_613 VDD VSS WELLTAP
X_19738_ clkload3/A _19738_/D _19738_/Q VDD VSS DFFQX1
XFILLER_84_448 VSS VDD FILLER2
XFILLER_84_459 VDD VSS FILLER1
X_19669_ _19702_/CK _19669_/D _19669_/Q VDD VSS DFFQX1
XFILLER_37_375 VDD VSS DECAPHV8
XFILLER_92_481 VSS VDD FILLER2
XFILLER_64_172 VSS VDD FILLER2
XFILLER_53_835 VSS VDD FILLER2
XFILLER_25_526 VDD VSS FILLER1
X_09422_ _09626_/B _09422_/B VDD VSS _09447_/B NAND2BX1
XFILLER_80_632 VDD VSS DECAPHV8
XTAP_TAPCELL_ROW_75_690 VDD VSS WELLTAP
XFILLER_52_334 VDD VSS FILLER1
XFILLER_12_209 VSS VDD FILLER2
X_09353_ _09380_/B _09414_/D VDD VSS _09353_/Y NOR2BX1
XFILLER_80_687 VSS VDD FILLER2
XFILLER_52_378 VDD VSS FILLER4
XFILLER_40_518 VSS VDD FILLER2
XTAP_TAPCELL_ROW_22_215 VDD VSS WELLTAP
X_09284_ _09284_/AB _09414_/D VDD VSS _09284_/Y NOR2BX1
XFILLER_21_743 VDD VSS FILLER1
XFILLER_20_220 VSS VDD FILLER2
XFILLER_60_18 VSS VDD FILLER2
XFILLER_20_231 VDD VSS FILLER1
XFILLER_166_759 VDD VSS FILLER4
XTAP_TAPCELL_ROW_30_281 VDD VSS WELLTAP
XFILLER_146_461 VSS VDD FILLER2
XFILLER_118_163 VDD VSS FILLER4
XFILLER_146_472 VDD VSS FILLER1
XFILLER_118_174 VSS VDD FILLER2
XFILLER_133_122 VSS VDD FILLER2
XFILLER_69_27 VSS VDD FILLER2
Xclkload90 _19406_/CK VDD VSS clkload90/Y BUFX12
XFILLER_161_453 VDD VSS FILLER1
XFILLER_161_464 VDD VSS FILLER1
XFILLER_133_177 VSS VDD FILLER2
XFILLER_88_710 VDD VSS FILLER4
XFILLER_161_486 VSS VDD FILLER2
XFILLER_88_721 VSS VDD FILLER2
XFILLER_114_391 VSS VDD FILLER2
XFILLER_125_55 VSS VDD FILLER2
XFILLER_88_765 VSS VDD FILLER2
XFILLER_85_15 VDD VSS FILLER1
XFILLER_48_607 VDD VSS FILLER4
XFILLER_48_629 VSS VDD FILLER2
XFILLER_85_48 VDD VSS FILLER1
XFILLER_47_117 VSS VDD FILLER2
XFILLER_47_139 VDD VSS FILLER4
XFILLER_141_32 VSS VDD FILLER2
XFILLER_62_109 VSS VDD FILLER2
XFILLER_141_43 VSS VDD FILLER2
X_10961_ _18648_/Q _18810_/Q VDD VSS _10962_/C NAND2X1
XFILLER_28_364 VSS VDD FILLER2
XFILLER_18_75 VDD VSS FILLER4
XFILLER_16_504 VSS VDD FILLER2
XFILLER_56_684 VSS VDD FILLER2
XFILLER_28_386 VSS VDD FILLER2
XFILLER_141_76 VSS VDD FILLER2
X_12700_ _18880_/Q VDD VSS _12884_/A INVX1
XFILLER_55_172 VDD VSS FILLER1
X_13680_ _14226_/A wire154/Y _14226_/C VDD VSS _13682_/B OAI21X1
X_10892_ _19954_/Q _18836_/Q VDD VSS _10931_/B NAND2X1
XFILLER_71_654 VDD VSS DECAPHV8
XFILLER_70_131 VDD VSS FILLER1
XFILLER_43_345 VSS VDD FILLER2
XFILLER_70_142 VSS VDD FILLER2
X_12631_ _12731_/B _14315_/C _19046_/Q VDD VSS _12632_/D AND3BX1
XFILLER_71_698 VSS VDD FILLER2
XFILLER_70_175 VDD VSS FILLER4
XFILLER_24_581 VDD VSS FILLER4
X_15350_ _19459_/Q _15845_/B VDD VSS _15351_/C NAND2X1
XFILLER_70_197 VSS VDD FILLER2
XFILLER_11_220 VSS VDD FILLER2
X_12562_ _12561_/A _14440_/B _14440_/C VDD VSS _12654_/C OR3BX1
XTAP_TAPCELL_ROW_5_56 VDD VSS WELLTAP
XFILLER_133_0 VSS VDD FILLER2
X_14301_ _14301_/A _14301_/B _17827_/B VDD VSS _19033_/D AOI21X1
X_11513_ _18666_/Q _11519_/B VDD VSS _18693_/D AND2X1
XFILLER_156_214 VSS VDD FILLER2
XFILLER_12_787 VSS VDD FILLER2
X_15281_ _15281_/A _15281_/B _15281_/C VDD VSS _15844_/C NOR3X1
X_12493_ _20003_/Q _19267_/Q VDD VSS _12499_/C NAND2X1
XFILLER_8_758 VDD VSS DECAPHV8
X_17020_ _18006_/C VDD VSS _17838_/A BUFX3
Xwire155 wire155/A VDD VSS wire155/Y BUFX6
X_14232_ _14136_/Y _14232_/B _14232_/C VDD VSS _18977_/D AND3BX1
Xwire166 wire166/A VDD VSS wire166/Y BUFX4
X_11444_ _19939_/Q _17990_/A VDD VSS _18632_/D AND2X1
XFILLER_125_601 VSS VDD FILLER2
X_14163_ _14163_/A _14163_/B _14163_/C VDD VSS _18917_/D NOR3X1
XFILLER_166_62 VDD VSS FILLER1
XFILLER_109_196 VSS VDD FILLER2
X_11375_ _18591_/Q _11375_/B _11375_/C VDD VSS _11381_/B MIN3X1
X_13114_ _13314_/A _13314_/B _13314_/D _13314_/C VDD VSS _14385_/C AOI211X1
XFILLER_98_507 VDD VSS FILLER4
XFILLER_124_155 VSS VDD FILLER2
X_10326_ _18686_/Q _18740_/Q VDD VSS _10329_/D XOR2X1
XFILLER_98_518 VDD VSS FILLER1
X_18971_ _18999_/CK _18971_/D _18971_/Q VDD VSS DFFQX1
X_14094_ _17975_/B _17975_/C VDD VSS _17969_/B OR2X2
XFILLER_79_710 VSS VDD FILLER2
XFILLER_3_463 VSS VDD FILLER2
XFILLER_112_328 VDD VSS FILLER4
XFILLER_124_199 VDD VSS FILLER4
X_17922_ _17927_/A _17927_/B VDD VSS _17923_/B XOR2X1
X_13045_ _19191_/Q VDD VSS _13137_/A INVX1
XFILLER_59_60 VSS VDD FILLER2
XFILLER_140_659 VSS VDD FILLER2
X_10257_ _18630_/Q _18792_/Q VDD VSS _10258_/C XOR2X1
XFILLER_121_840 VSS VDD FILLER2
XFILLER_78_253 VDD VSS FILLER4
X_17853_ _17853_/A _17853_/B _17853_/C VDD VSS _17868_/C MIN3X1
X_10188_ _10188_/A _10188_/B VDD VSS _10189_/C NAND2X1
XFILLER_94_713 VDD VSS FILLER1
XFILLER_120_361 VSS VDD FILLER2
XFILLER_79_798 VDD VSS FILLER1
XFILLER_78_275 VSS VDD FILLER2
XFILLER_66_415 VSS VDD FILLER2
X_16804_ _16811_/A _16804_/B VDD VSS _19647_/D NOR2X1
XFILLER_94_757 VSS VDD FILLER2
X_14996_ _19423_/Q _15806_/B _15806_/C VDD VSS _15045_/C NOR3BX1
X_17784_ _19920_/Q _19888_/Q VDD VSS _17785_/C NAND2X1
X_19523_ _19531_/CK _19523_/D _19523_/Q VDD VSS DFFQX1
X_16735_ _16735_/A _16735_/B VDD VSS _19586_/D NOR2X1
X_13947_ _13957_/A _14198_/B _13957_/C VDD VSS _14199_/C NOR3X1
XFILLER_46_150 VDD VSS FILLER4
XFILLER_19_375 VSS VDD FILLER2
XFILLER_75_92 VDD VSS FILLER1
XFILLER_35_835 VSS VDD FILLER2
XFILLER_34_312 VSS VDD FILLER2
XFILLER_34_323 VSS VDD FILLER2
X_16666_ _16668_/B _16667_/B _18168_/C VDD VSS _16667_/C OAI21X1
X_19454_ _19484_/CK _19454_/D _19454_/Q VDD VSS DFFQX1
X_13878_ _17924_/B _17924_/C _13929_/D _13929_/C VDD VSS _17940_/C AOI211X1
XFILLER_62_654 VDD VSS FILLER1
XFILLER_61_120 VDD VSS FILLER4
XFILLER_61_131 VSS VDD FILLER2
XFILLER_61_142 VDD VSS FILLER1
X_15617_ _15617_/A _15617_/B _15617_/C VDD VSS _15637_/A OAI21X1
X_18405_ _18406_/CK _18405_/D _18405_/Q _18405_/RB VDD VSS DFFRQX1
X_12829_ _12940_/A _12940_/B _12940_/C _12940_/D VDD VSS _13039_/A AOI31X1
XTAP_TAPCELL_ROW_72_660 VDD VSS WELLTAP
XFILLER_22_518 VDD VSS FILLER1
X_16597_ _19637_/Q _16597_/B _16791_/B VDD VSS _16622_/A MIN3X1
X_19385_ _19385_/CK _19385_/D _19385_/Q VDD VSS DFFQX1
XFILLER_61_175 VSS VDD FILLER2
XFILLER_148_704 VDD VSS FILLER1
X_15548_ _19465_/Q _15855_/B VDD VSS _15549_/B XNOR2X1
X_18336_ _18343_/CK _18336_/D _18336_/Q _18374_/RB VDD VSS DFFRQX1
XFILLER_148_726 VDD VSS FILLER4
XFILLER_147_214 VSS VDD FILLER2
X_18267_ _18268_/CK _18267_/D _18267_/Q _20081_/RB VDD VSS DFFRQX1
X_15479_ _15515_/A _15515_/B VDD VSS _15884_/B XOR2X1
XFILLER_30_584 VSS VDD FILLER2
XFILLER_147_247 VSS VDD FILLER2
XTAP_TAPCELL_ROW_138_1258 VDD VSS WELLTAP
X_17218_ _19799_/Q _19767_/Q VDD VSS _17219_/B XOR2X1
XFILLER_128_450 VSS VDD FILLER2
X_18198_ _20014_/Q output5/A _18201_/A _20015_/Q VDD VSS _18199_/B AOI211X1
XFILLER_162_206 VSS VDD FILLER2
XFILLER_116_623 VSS VDD FILLER2
X_17149_ _17149_/A _17151_/C _17149_/C VDD VSS _19784_/D AOI21X1
XFILLER_128_494 VDD VSS FILLER1
XFILLER_143_431 VDD VSS FILLER1
XFILLER_116_656 VDD VSS FILLER4
XFILLER_115_144 VSS VDD FILLER2
XFILLER_116_667 VSS VDD FILLER2
X_20160_ _20160_/A VDD VSS _20160_/Y BUFX3
XFILLER_115_155 VSS VDD FILLER2
XFILLER_130_125 VSS VDD FILLER2
X_20091_ _20091_/A VDD VSS _20091_/Y BUFX3
XFILLER_69_253 VSS VDD FILLER2
XFILLER_85_713 VSS VDD FILLER2
XFILLER_57_415 VSS VDD FILLER2
XTAP_TAPCELL_ROW_149_1354 VDD VSS WELLTAP
XFILLER_97_584 VSS VDD FILLER2
XFILLER_111_383 VSS VDD FILLER2
XFILLER_85_768 VDD VSS FILLER1
XFILLER_84_256 VDD VSS FILLER1
XFILLER_26_802 VSS VDD FILLER2
XFILLER_38_684 VSS VDD FILLER2
XFILLER_25_301 VSS VDD FILLER2
XFILLER_65_492 VDD VSS FILLER1
XFILLER_25_334 VDD VSS FILLER1
XFILLER_53_654 VDD VSS FILLER4
XFILLER_52_131 VSS VDD FILLER2
XFILLER_25_345 VSS VDD FILLER2
XFILLER_52_142 VDD VSS FILLER4
X_09405_ _13283_/A _09405_/B VDD VSS _231_/E NAND2X1
XFILLER_53_676 VSS VDD FILLER2
XFILLER_41_827 VSS VDD FILLER2
X_09336_ _18445_/D _09335_/Y _09302_/A VDD VSS _18514_/D MUXI2X1
X_09267_ _09301_/A _09277_/A VDD VSS _09354_/A NAND2BX1
XFILLER_138_247 VSS VDD FILLER2
XFILLER_5_706 VDD VSS FILLER4
X_09198_ _18513_/Q VDD VSS _18444_/D INVX1
XFILLER_5_728 VDD VSS FILLER1
XFILLER_153_228 VDD VSS FILLER4
XFILLER_20_21 VDD VSS FILLER1
XFILLER_105_4 VDD VSS FILLER1
XTAP_TAPCELL_ROW_115_1044 VDD VSS WELLTAP
XFILLER_134_453 VSS VDD FILLER2
X_11160_ _11364_/B _11221_/A VDD VSS _11184_/A NAND2X1
XFILLER_162_773 VDD VSS FILLER4
XFILLER_106_177 VSS VDD FILLER2
XFILLER_121_103 VDD VSS FILLER4
XFILLER_96_14 VDD VSS FILLER4
XFILLER_161_272 VDD VSS FILLER4
XFILLER_121_114 VSS VDD FILLER2
X_10111_ _10120_/A _10111_/B VDD VSS _11415_/C XOR2X1
X_11091_ _11263_/A _11128_/A VDD VSS _11122_/A NOR2X1
XFILLER_103_840 VSS VDD FILLER2
XFILLER_0_433 VSS VDD FILLER2
X_10042_ _18580_/Q _18581_/Q VDD VSS _10054_/B _10042_/C NAND3X1
XFILLER_76_702 VDD VSS FILLER1
XTAP_TAPCELL_ROW_78_719 VDD VSS WELLTAP
XFILLER_29_30 VSS VDD FILLER2
XFILLER_0_477 VSS VDD FILLER2
XFILLER_152_20 VSS VDD FILLER2
XFILLER_76_724 VDD VSS FILLER1
X_14850_ _14850_/A _14850_/B _15707_/B VDD VSS _14855_/C MIN3X1
XFILLER_29_96 VSS VDD FILLER2
X_13801_ _18919_/Q _13809_/B _13918_/D VDD VSS _14132_/C XNOR3X1
XFILLER_17_802 VDD VSS FILLER1
XFILLER_35_109 VSS VDD FILLER2
X_14781_ _14781_/A _14781_/B _14872_/B _14781_/D VDD VSS _15865_/C AO22X2
XFILLER_75_278 VDD VSS FILLER1
X_11993_ _19998_/Q _19262_/Q VDD VSS _12055_/D NOR2X1
XTAP_TAPCELL_ROW_86_785 VDD VSS WELLTAP
XTAP_TAPCELL_ROW_126_1151 VDD VSS WELLTAP
XFILLER_17_835 VSS VDD FILLER2
X_16520_ _19634_/Q _16788_/B VDD VSS _16521_/C NOR2X1
X_13732_ _13837_/A _13837_/B _13837_/D _13837_/C VDD VSS _13735_/B AOAI211X1
XFILLER_56_492 VSS VDD FILLER2
XFILLER_16_323 VSS VDD FILLER2
X_10944_ _10944_/A _10944_/B VDD VSS _10984_/B _10944_/C NAND3X1
X_16451_ _16451_/A _16476_/C VDD VSS _16751_/B XNOR2X1
XFILLER_32_827 VSS VDD FILLER2
X_13663_ _18889_/Q _13751_/A _13807_/B VDD VSS _13869_/D XNOR3X1
XFILLER_31_304 VSS VDD FILLER2
X_10875_ _10965_/A _18727_/Q _10875_/C _10875_/D _10875_/E VDD VSS _10876_/C AOI221X1
XFILLER_71_495 VSS VDD FILLER2
X_15402_ _15440_/B _15402_/B VDD VSS _15434_/B XNOR2X1
XFILLER_31_337 VDD VSS FILLER4
X_19170_ _19200_/CK _19170_/D _19170_/Q VDD VSS DFFQX1
X_12614_ _18934_/Q VDD VSS _12617_/A INVX1
X_16382_ _19725_/Q wire155/Y VDD VSS _16386_/B XNOR2X1
X_13594_ _13594_/A _13594_/B _13594_/C _13594_/D VDD VSS _13686_/B AOAI211X1
X_18121_ _18121_/A _18121_/B _18121_/C VDD VSS _18123_/C OA21X2
X_15333_ _15341_/B _15333_/B VDD VSS _15690_/B XNOR2X1
X_12545_ _19101_/Q VDD VSS _12557_/A INVX1
XFILLER_157_545 VDD VSS FILLER4
XFILLER_129_258 VDD VSS FILLER1
XFILLER_145_707 VDD VSS FILLER1
X_18052_ _18546_/Q _18052_/B VDD VSS _18053_/B NAND2X1
X_15264_ _19402_/Q VDD VSS _15304_/A INVX1
XFILLER_144_206 VDD VSS FILLER4
XFILLER_145_729 VDD VSS FILLER4
X_12476_ _19183_/Q _14469_/B VDD VSS _12483_/C _14469_/C NAND3X1
X_17003_ _19754_/Q _17049_/B _17006_/A _17006_/B VDD VSS _17004_/B AOAI211X1
X_14215_ _14231_/A _14215_/B VDD VSS _18964_/D AND2X1
XANTENNA_5 _20132_/Y VDD VSS ANTENNA2
X_11427_ _18548_/D _11428_/B VDD VSS _18620_/D NOR2BX1
X_15195_ _15243_/A _15243_/B VDD VSS _15842_/B XOR2X1
XFILLER_6_56 VSS VDD FILLER2
XFILLER_6_67 VDD VSS FILLER4
XFILLER_125_453 VDD VSS FILLER1
XFILLER_6_89 VDD VSS FILLER4
XFILLER_113_604 VSS VDD FILLER2
X_14146_ _14154_/A _14146_/B VDD VSS _18902_/D NOR2X1
X_11358_ _11379_/A _11358_/B _11358_/C VDD VSS _11364_/D OAI21X1
XFILLER_4_761 VSS VDD FILLER2
XFILLER_152_261 VSS VDD FILLER2
XFILLER_113_648 VSS VDD FILLER2
X_10309_ _10312_/B _10310_/B _11386_/C VDD VSS _10310_/C OAI21X1
XFILLER_98_348 VDD VSS FILLER1
X_18954_ _19025_/CK _18954_/D _18954_/Q VDD VSS DFFQX1
X_14077_ _14089_/A _14078_/B _14078_/C VDD VSS _14140_/B OR3BX1
XFILLER_3_282 VSS VDD FILLER2
X_11289_ _11289_/A VDD VSS _11370_/A BUFX3
X_17905_ _17905_/A _17905_/B _17905_/C VDD VSS _17911_/C MIN3X1
X_13028_ _13028_/A _14445_/B VDD VSS _13111_/A OR2X2
X_18885_ _18934_/CK _18885_/D _18885_/Q VDD VSS DFFQX1
XFILLER_20_4 VSS VDD FILLER2
XFILLER_67_735 VSS VDD FILLER2
XFILLER_66_212 VSS VDD FILLER2
X_17836_ _19934_/Q _17836_/B _18168_/C VDD VSS _17837_/B OAI21X1
XFILLER_86_80 VSS VDD FILLER2
XFILLER_39_448 VSS VDD FILLER2
XFILLER_120_191 VSS VDD FILLER2
XFILLER_13_3 VSS VDD FILLER2
XTAP_TAPCELL_ROW_49_454 VDD VSS WELLTAP
XFILLER_54_407 VDD VSS FILLER4
X_17767_ _17768_/C _18127_/B _17767_/C VDD VSS _19916_/D AND3BX1
X_14979_ _19395_/Q _15774_/B VDD VSS _15026_/B NOR2X1
X_19506_ _19508_/CK _19506_/D _19506_/Q VDD VSS DFFQX1
X_16718_ _16718_/A _16724_/B VDD VSS _19570_/D NOR2X1
XFILLER_35_654 VSS VDD FILLER2
X_17698_ _19901_/Q _19869_/Q _17698_/C VDD VSS _17702_/B AOI21X1
XFILLER_62_451 VDD VSS FILLER4
XFILLER_34_142 VDD VSS FILLER4
XFILLER_62_462 VSS VDD FILLER2
XFILLER_50_602 VSS VDD FILLER2
X_19437_ _19465_/CK _19437_/D _19437_/Q VDD VSS DFFQX1
X_16649_ _16649_/A _16649_/B _16793_/B VDD VSS _16674_/B MIN3X1
XFILLER_90_793 VSS VDD FILLER2
XFILLER_23_849 VSS VDD FILLER2
XFILLER_50_657 VSS VDD FILLER2
X_19368_ _19406_/CK _19368_/D _19368_/Q VDD VSS DFFQX1
XFILLER_148_534 VSS VDD FILLER2
X_18319_ _18325_/CK _18516_/Q _18319_/Q _18422_/RB VDD VSS DFFRQX1
X_19299_ _19331_/CK _19299_/D _19299_/Q VDD VSS DFFQX1
XFILLER_148_556 VDD VSS FILLER1
XFILLER_136_707 VDD VSS FILLER4
XFILLER_148_589 VDD VSS FILLER4
XFILLER_163_526 VSS VDD FILLER2
XFILLER_163_537 VDD VSS FILLER1
XFILLER_135_239 VDD VSS FILLER1
XFILLER_116_431 VDD VSS FILLER4
X_20212_ _20212_/A VDD VSS _20212_/Y BUFX3
XFILLER_1_219 VSS VDD FILLER2
XFILLER_104_648 VDD VSS FILLER1
X_20143_ _20143_/A VDD VSS _20143_/Y BUFX3
X_09954_ _18599_/Q _09980_/B VDD VSS _09981_/C XOR2X1
XFILLER_131_445 VDD VSS DECAPHV8
Xclkbuf_leaf_9_clk_regs clkbuf_leaf_9_clk_regs/A VDD VSS _19785_/CK BUFX12
XFILLER_103_158 VSS VDD FILLER2
XFILLER_106_57 VSS VDD FILLER2
X_20074_ _20081_/CK _20074_/D _20074_/Q _20075_/RB VDD VSS DFFRQX1
XFILLER_100_810 VSS VDD FILLER2
XFILLER_112_670 VSS VDD FILLER2
X_09885_ _09885_/A VDD VSS _10032_/A BUFX3
XFILLER_58_724 VSS VDD FILLER2
XFILLER_97_370 VSS VDD FILLER2
XFILLER_85_521 VSS VDD FILLER2
XFILLER_57_212 VDD VSS FILLER4
XFILLER_66_39 VSS VDD FILLER2
XFILLER_57_256 VDD VSS FILLER4
XFILLER_73_716 VSS VDD FILLER2
XFILLER_72_204 VDD VSS FILLER1
XFILLER_57_278 VDD VSS FILLER1
XFILLER_122_45 VDD VSS FILLER1
XFILLER_72_248 VSS VDD FILLER2
XFILLER_82_49 VDD VSS FILLER4
XFILLER_25_197 VSS VDD FILLER2
XFILLER_158_309 VSS VDD FILLER2
X_10660_ _10960_/A _10660_/B VDD VSS _10661_/C NAND2X1
X_09319_ _20080_/RB _09322_/B VDD VSS _09319_/Y NOR2BX1
X_10591_ _10594_/A _10592_/D _10592_/A _10592_/B VDD VSS _10593_/B OA211X2
XFILLER_139_556 VSS VDD FILLER2
X_12330_ _12474_/A _12474_/C VDD VSS _12473_/C AND2X1
XFILLER_31_20 VDD VSS FILLER1
XFILLER_166_375 VDD VSS FILLER1
XFILLER_166_397 VDD VSS DECAPHV8
XFILLER_154_537 VDD VSS FILLER1
XFILLER_126_239 VSS VDD FILLER2
XFILLER_147_31 VSS VDD FILLER2
X_12261_ _19070_/Q _12512_/B _14343_/B VDD VSS _14278_/B XNOR3X1
XTAP_TAPCELL_ROW_2_35 VDD VSS WELLTAP
XFILLER_31_86 VDD VSS FILLER4
X_14000_ _18977_/Q _14232_/B VDD VSS _14001_/D _14232_/C NAND3X1
XFILLER_107_453 VDD VSS DECAPHV8
X_11212_ _11080_/Y _11267_/B _11298_/A VDD VSS _11307_/B MUXI2X1
XFILLER_134_250 VSS VDD FILLER2
XFILLER_150_710 VSS VDD FILLER2
Xoutput20 _20089_/Y VDD VSS o_aux_ctrl[7] BUFX3
Xoutput7 output7/A VDD VSS o_aux_ctrl[0] BUFX3
X_12192_ _18985_/Q _12201_/B _12201_/C VDD VSS _14208_/B XNOR3X1
XFILLER_122_412 VDD VSS FILLER4
Xoutput31 _20115_/Y VDD VSS o_bias_cfg[17] BUFX3
Xoutput42 _20125_/Y VDD VSS o_bias_cfg[27] BUFX3
Xoutput53 _20103_/Y VDD VSS o_bias_cfg[5] BUFX3
X_11143_ _11143_/A _11173_/C VDD VSS _11144_/C XNOR2X1
Xoutput64 _20148_/Y VDD VSS o_clk_cfg[15] BUFX3
XFILLER_1_742 VSS VDD FILLER2
XFILLER_110_607 VDD VSS DECAPHV8
Xoutput75 _20141_/Y VDD VSS o_clk_cfg[8] BUFX3
Xoutput86 _20160_/Y VDD VSS o_en_ctrl[8] BUFX3
XFILLER_95_307 VDD VSS FILLER4
Xoutput97 _20166_/Y VDD VSS o_lf_cfg[3] BUFX3
X_15951_ _19610_/Q _16762_/B VDD VSS _16797_/B XNOR2X1
X_11074_ _18651_/Q _18813_/Q _11074_/C VDD VSS _11099_/C MIN3X1
XFILLER_88_370 VSS VDD FILLER2
X_14902_ _19365_/Q _14902_/B _15740_/B VDD VSS _14954_/B MIN3X1
X_10025_ _18602_/Q VDD VSS _10026_/A INVX1
XFILLER_163_96 VSS VDD FILLER2
X_15882_ _15895_/A _15882_/B VDD VSS _19489_/D NOR2X1
X_18670_ _19949_/CK _18670_/D _18670_/Q VDD VSS DFFQX1
XFILLER_64_716 VDD VSS DECAPHV8
X_17621_ _19885_/Q _19853_/Q VDD VSS _17623_/B XOR2X1
X_14833_ _19448_/Q _14833_/B _14865_/C VDD VSS _14867_/C XNOR3X1
XFILLER_29_481 VSS VDD FILLER2
XTAP_TAPCELL_ROW_46_424 VDD VSS WELLTAP
XFILLER_91_546 VDD VSS DECAPHV8
XFILLER_63_248 VDD VSS FILLER4
X_14764_ _19306_/Q _15674_/B VDD VSS _14765_/B XOR2X1
X_17552_ _19870_/Q _19838_/Q _17552_/C VDD VSS _17556_/B AOI21X1
X_11976_ _19177_/Q _14463_/B VDD VSS _12029_/C _14463_/C AND3X2
XFILLER_17_654 VSS VDD FILLER2
XFILLER_16_142 VSS VDD FILLER2
X_16503_ _16503_/A _16522_/B VDD VSS _16788_/B XOR2X1
X_13715_ _19113_/Q _14391_/B _14391_/C VDD VSS _13716_/D NOR3BX1
X_17483_ _19856_/Q _19824_/Q VDD VSS _17488_/A XNOR2X1
X_10927_ _10962_/A _10962_/B _10927_/C VDD VSS _10928_/C AOI21X1
XFILLER_72_782 VDD VSS DECAPHV8
X_14695_ _19389_/Q VDD VSS _14758_/A INVX1
XFILLER_72_793 VSS VDD FILLER2
XFILLER_32_624 VDD VSS DECAPHV8
XFILLER_44_495 VSS VDD FILLER2
X_19222_ _19250_/CK _19222_/D _19222_/Q VDD VSS DFFQX1
X_16434_ _16459_/B _16434_/B VDD VSS _16856_/B NOR2BX1
X_13646_ _19083_/Q _14359_/B VDD VSS _13727_/A NAND2X1
X_10858_ _18700_/Q _18754_/Q VDD VSS _10862_/A XNOR2X1
X_16365_ _16365_/A _16365_/B VDD VSS _16392_/B NAND2X1
X_19153_ _19191_/CK _19153_/D _19153_/Q VDD VSS DFFQX1
X_13577_ _18915_/Q _14161_/B VDD VSS _13591_/A NAND2X1
XFILLER_31_189 VSS VDD FILLER2
X_10789_ _10790_/A _10790_/B _10790_/D _10790_/C VDD VSS _10805_/A OAOI211X1
X_15316_ _19514_/Q _15909_/B VDD VSS _15359_/C NAND2BX1
X_18104_ _18105_/A _18105_/B _18187_/C VDD VSS _18105_/C OAI21X1
X_12528_ _12528_/A _12528_/B _14116_/B VDD VSS _12532_/C MIN3X1
X_16296_ _16296_/A _16296_/B VDD VSS _16297_/B _16296_/C NAND3X1
X_19084_ _19139_/CK _19084_/D _19084_/Q VDD VSS DFFQX1
XFILLER_157_375 VSS VDD FILLER2
XTAP_TAPCELL_ROW_135_1228 VDD VSS WELLTAP
XFILLER_68_4 VSS VDD FILLER2
X_15247_ _15247_/A _15247_/B VDD VSS _15813_/B XNOR2X1
X_18035_ _18056_/A _18035_/B _18056_/C VDD VSS _19975_/D OAI21X1
X_12459_ _14345_/B _14345_/C _12460_/A VDD VSS _12461_/C OAI21X1
XFILLER_126_762 VSS VDD FILLER2
X_15178_ _15178_/A _15178_/B _15178_/C VDD VSS _15223_/A AOI21X1
XFILLER_99_613 VDD VSS DECAPHV8
XFILLER_99_635 VDD VSS FILLER4
XFILLER_153_592 VDD VSS FILLER4
XFILLER_141_743 VDD VSS FILLER1
X_14129_ _18196_/A _14129_/B _14129_/C VDD VSS _18888_/D AND3BX1
X_19986_ _19986_/CK _19986_/D _19986_/Q VDD VSS DFFQX1
XFILLER_141_765 VSS VDD FILLER2
XFILLER_99_679 VDD VSS FILLER4
XFILLER_100_106 VDD VSS FILLER1
X_18937_ _18961_/CK _18937_/D _18937_/Q VDD VSS DFFQX1
XFILLER_140_297 VSS VDD FILLER2
XFILLER_79_381 VSS VDD FILLER2
XFILLER_39_223 VSS VDD FILLER2
X_09670_ _18446_/Q VDD VSS _20158_/A INVX1
X_18868_ _18924_/CK _18868_/D _18868_/Q VDD VSS DFFQX1
XTAP_TAPCELL_ROW_146_1324 VDD VSS WELLTAP
XFILLER_67_565 VSS VDD FILLER2
XFILLER_94_362 VDD VSS FILLER4
X_17819_ _19928_/Q _19896_/Q VDD VSS _17823_/B XNOR2X1
XFILLER_82_524 VSS VDD FILLER2
XFILLER_54_215 VDD VSS FILLER1
X_18799_ _18799_/CK _18799_/D _18799_/Q VDD VSS DFFQX1
XFILLER_54_237 VDD VSS FILLER1
XFILLER_82_568 VDD VSS FILLER4
XFILLER_70_708 VDD VSS DECAPHV8
XTAP_TAPCELL_ROW_80_736 VDD VSS WELLTAP
XFILLER_50_421 VSS VDD FILLER2
XTAP_TAPCELL_ROW_17_170 VDD VSS WELLTAP
XFILLER_22_156 VDD VSS FILLER1
XFILLER_50_476 VDD VSS FILLER1
XFILLER_108_239 VSS VDD FILLER2
XFILLER_163_356 VSS VDD FILLER2
XFILLER_117_773 VDD VSS FILLER4
XFILLER_104_412 VDD VSS FILLER4
XFILLER_117_56 VDD VSS FILLER4
XTAP_TAPCELL_ROW_112_1025 VDD VSS WELLTAP
XTAP_TAPCELL_ROW_88_803 VDD VSS WELLTAP
X_20126_ _20126_/A VDD VSS _20126_/Y BUFX3
X_09937_ _09981_/A _11399_/C VDD VSS _09955_/A NAND2X1
XFILLER_89_189 VDD VSS FILLER4
X_20057_ clkload6/A _20057_/D _20057_/Q _20071_/RB VDD VSS DFFRQX1
XFILLER_86_852 VSS VDD FILLER2
XFILLER_100_640 VDD VSS FILLER1
X_09868_ _18574_/Q _09871_/B VDD VSS _09869_/B NAND2X1
XFILLER_85_351 VSS VDD FILLER2
XFILLER_73_502 VSS VDD FILLER2
XTAP_TAPCELL_ROW_96_880 VDD VSS WELLTAP
XFILLER_100_695 VSS VDD FILLER2
X_09799_ _18438_/Q _09811_/B _09813_/C _20147_/A _09799_/E VDD VSS _09803_/B AOI221X1
X_11830_ _11830_/A _11830_/B _11830_/C _11830_/D VDD VSS _11918_/A OAOI211X2
XTAP_TAPCELL_ROW_108_981 VDD VSS WELLTAP
XTAP_TAPCELL_ROW_123_1121 VDD VSS WELLTAP
XFILLER_60_218 VDD VSS FILLER4
X_11761_ _11761_/A _11761_/B _14456_/B VDD VSS _11762_/B MIN3X1
XFILLER_54_793 VDD VSS DECAPHV8
XFILLER_26_86 VDD VSS FILLER1
XFILLER_13_112 VSS VDD FILLER2
XFILLER_26_495 VSS VDD FILLER2
X_13500_ _14159_/B _14159_/C _18914_/Q VDD VSS _13502_/B AOI21X1
X_10712_ _18641_/Q _18803_/Q VDD VSS _10715_/D NOR2X1
XFILLER_13_134 VSS VDD FILLER2
XFILLER_14_668 VSS VDD FILLER2
X_14480_ _14766_/A _14480_/B VDD VSS _19193_/D AND2X1
X_11692_ _19987_/Q _19251_/Q VDD VSS _11716_/A OR2X2
XFILLER_13_156 VSS VDD FILLER2
XFILLER_9_105 VSS VDD FILLER2
XFILLER_158_128 VSS VDD FILLER2
X_13431_ _19138_/Q _13617_/A _13617_/B VDD VSS _13432_/D XNOR3X1
XFILLER_139_320 VSS VDD FILLER2
X_10643_ _10718_/A _10718_/B VDD VSS _10675_/B NAND2X1
XFILLER_13_189 VSS VDD FILLER2
XTAP_TAPCELL_ROW_51_471 VDD VSS WELLTAP
XFILLER_155_802 VSS VDD FILLER2
X_16150_ _16150_/A _16150_/B _16880_/B VDD VSS _16174_/B MIN3X1
X_13362_ _19082_/Q _13418_/B _13437_/C VDD VSS _13601_/A XNOR3X1
XFILLER_6_801 VDD VSS FILLER4
XFILLER_139_375 VDD VSS FILLER4
X_10574_ _10574_/A VDD VSS _10576_/C INVX1
XFILLER_6_812 VSS VDD FILLER2
XFILLER_42_96 VSS VDD FILLER2
XFILLER_155_835 VSS VDD FILLER2
X_15101_ _19535_/Q _15146_/C VDD VSS _15102_/B NAND2X1
XFILLER_154_323 VSS VDD FILLER2
X_12313_ _12313_/A _14436_/B _12373_/C _12313_/D VDD VSS _12483_/A OAOI211X1
XFILLER_166_183 VDD VSS DECAPHV8
X_16081_ _19649_/Q _16081_/B _16806_/B VDD VSS _16106_/A MIN3X1
X_13293_ _13291_/B _13494_/A _13393_/B VDD VSS _13385_/C OR3BX1
X_15032_ _19312_/Q _15683_/B VDD VSS _15033_/B XNOR2X1
X_12244_ _12471_/A _12471_/B VDD VSS _14405_/B XNOR2X1
XFILLER_5_366 VDD VSS FILLER4
X_19840_ _19841_/CK _19840_/D _19840_/Q VDD VSS DFFQX1
X_12175_ _12214_/A wire161/Y _12214_/D _12214_/C VDD VSS _14436_/C AOI211X1
XFILLER_123_765 VDD VSS DECAPHV8
XFILLER_150_551 VSS VDD FILLER2
X_11126_ _11126_/A _11126_/B _11126_/C VDD VSS _11158_/B MIN3X1
XFILLER_1_561 VSS VDD FILLER2
XFILLER_110_415 VSS VDD FILLER2
XFILLER_122_275 VSS VDD FILLER2
X_19771_ clkload4/A _19771_/D _19771_/Q VDD VSS DFFQX1
X_16983_ _17151_/B _17011_/B VDD VSS _16994_/A XNOR2X1
XFILLER_96_649 VDD VSS DECAPHV16
XFILLER_3_79 VSS VDD FILLER2
X_18722_ _18831_/CK _18722_/D _18722_/Q VDD VSS DFFQX1
XFILLER_110_459 VSS VDD FILLER2
X_15934_ _15948_/A _15948_/B VDD VSS _15935_/C NAND2X1
X_11057_ _18572_/Q _11057_/B VDD VSS _11086_/A NAND2X1
XFILLER_67_71 VSS VDD FILLER2
XFILLER_92_811 VDD VSS FILLER1
X_10008_ _10011_/B _10008_/B VDD VSS _11407_/C XOR2X1
X_18653_ _18845_/CK _18653_/D _18653_/Q VDD VSS DFFQX1
X_15865_ _14522_/Y _15865_/B _15865_/C VDD VSS _19474_/D AND3BX1
X_17604_ _17606_/C _17604_/B _17604_/C VDD VSS _19881_/D AOI21X1
X_14816_ _19447_/Q _15832_/B VDD VSS _14908_/A NAND2X1
XFILLER_52_708 VSS VDD FILLER2
X_18584_ _18595_/CK _18584_/D _18584_/Q VDD VSS DFFQX1
X_15796_ _15800_/A _15796_/B VDD VSS _19414_/D NOR2X1
XFILLER_17_462 VSS VDD FILLER2
X_17535_ _19866_/Q _19834_/Q VDD VSS _17537_/C _17535_/C AND3X2
XFILLER_83_70 VSS VDD FILLER2
XFILLER_45_782 VDD VSS FILLER4
X_14747_ _15893_/B VDD VSS _14748_/B INVX1
X_11959_ _11959_/A _11959_/B _14336_/B VDD VSS _12014_/B MIN3X1
XFILLER_32_421 VSS VDD FILLER2
XFILLER_44_281 VSS VDD FILLER2
XFILLER_149_106 VSS VDD FILLER2
X_17466_ _19852_/Q _19820_/Q VDD VSS _17468_/D XNOR2X1
X_14678_ _19499_/Q VDD VSS _14681_/A INVX1
X_19205_ _20000_/CK _19205_/D _19205_/Q VDD VSS DFFQX1
XTAP_TAPCELL_ROW_14_140 VDD VSS WELLTAP
X_16417_ _19662_/Q _16820_/B VDD VSS _16433_/A NOR2X1
X_13629_ _13640_/A _13640_/B _13630_/C VDD VSS _14422_/B OR3X2
XFILLER_20_638 VDD VSS FILLER4
X_17397_ _17395_/B _17397_/B VDD VSS _17398_/C NOR2BX1
X_19136_ _19166_/CK _19136_/D _19136_/Q VDD VSS DFFQX1
X_16348_ _16348_/A _16348_/B _16348_/C _16348_/D VDD VSS _16349_/B AOI211X1
XFILLER_146_835 VSS VDD FILLER2
XFILLER_158_695 VSS VDD FILLER2
XFILLER_157_161 VSS VDD FILLER2
XFILLER_118_537 VDD VSS FILLER4
XFILLER_9_683 VDD VSS FILLER1
X_16279_ _19657_/Q _16815_/B VDD VSS _16296_/A NAND2BX1
X_19067_ _19068_/CK _19067_/D _19067_/Q VDD VSS DFFQX1
XFILLER_133_518 VSS VDD FILLER2
X_18018_ _18528_/Q _18527_/Q _18529_/Q _18530_/Q VDD VSS _18019_/C AOI31X1
XFILLER_59_0 VDD VSS DECAPHV8
XFILLER_160_304 VDD VSS FILLER4
XFILLER_114_721 VSS VDD FILLER2
XTAP_TAPCELL_ROW_152_1383 VDD VSS WELLTAP
XFILLER_99_432 VSS VDD FILLER2
XFILLER_114_765 VSS VDD FILLER2
XFILLER_114_787 VSS VDD FILLER2
X_19969_ _19985_/CK _19969_/D _19969_/Q VDD VSS DFFQX1
XFILLER_101_426 VSS VDD FILLER2
XFILLER_86_137 VSS VDD FILLER2
X_09722_ _18269_/Q _09818_/C _09722_/C _09788_/B VDD VSS _09731_/C AOI22X1
XFILLER_101_459 VDD VSS FILLER4
Xclkbuf_2_0__f__001_ clkbuf_0__001_/Y VDD VSS clkbuf_leaf_4__001_/A BUFX12
X_09653_ _18445_/Q VDD VSS _20157_/A INVX1
XFILLER_67_384 VDD VSS FILLER4
XFILLER_103_25 VSS VDD FILLER2
XFILLER_82_321 VDD VSS FILLER4
X_09584_ _18345_/Q VDD VSS _20213_/A INVX1
XTAP_TAPCELL_ROW_93_850 VDD VSS WELLTAP
XFILLER_43_719 VSS VDD FILLER2
XFILLER_82_365 VDD VSS FILLER4
XFILLER_63_18 VSS VDD FILLER2
XFILLER_36_793 VSS VDD FILLER2
XTAP_TAPCELL_ROW_65_596 VDD VSS WELLTAP
XTAP_TAPCELL_ROW_105_962 VDD VSS WELLTAP
XFILLER_11_627 VSS VDD FILLER2
XFILLER_23_487 VDD VSS DECAPHV16
XFILLER_10_115 VSS VDD FILLER2
XFILLER_11_649 VSS VDD FILLER2
XFILLER_10_137 VSS VDD FILLER2
XFILLER_149_673 VSS VDD FILLER2
XFILLER_155_109 VDD VSS FILLER1
XFILLER_6_108 VDD VSS FILLER1
XFILLER_109_526 VDD VSS FILLER4
XFILLER_137_835 VSS VDD FILLER2
XFILLER_12_44 VSS VDD FILLER2
XFILLER_136_323 VSS VDD FILLER2
XFILLER_164_632 VSS VDD FILLER2
XFILLER_151_304 VDD VSS FILLER1
X_10290_ _10405_/A _10405_/B VDD VSS _10294_/B XNOR2X1
XFILLER_163_175 VSS VDD FILLER2
XFILLER_105_721 VDD VSS FILLER1
XFILLER_117_592 VSS VDD FILLER2
XFILLER_151_337 VSS VDD FILLER2
XFILLER_3_848 VSS VDD FILLER2
XFILLER_120_724 VSS VDD FILLER2
XTAP_TAPCELL_ROW_166_1508 VDD VSS WELLTAP
XTAP_TAPCELL_ROW_166_1519 VDD VSS WELLTAP
XFILLER_59_830 VDD VSS FILLER1
X_20109_ _20109_/A VDD VSS _20109_/Y BUFX3
X_13980_ _18921_/Q _14168_/B VDD VSS _13995_/A NAND2X1
XFILLER_93_608 VDD VSS FILLER1
XFILLER_74_800 VDD VSS FILLER4
X_12931_ _13028_/A _13039_/A _13108_/B VDD VSS _12932_/D XNOR3X1
XFILLER_19_749 VDD VSS FILLER1
XFILLER_100_481 VSS VDD FILLER2
XFILLER_37_52 VSS VDD FILLER2
XFILLER_160_31 VSS VDD FILLER2
X_15650_ _15672_/A _18179_/B VDD VSS _19301_/D NOR2X1
X_12862_ _12938_/A _13107_/D _12925_/C VDD VSS _12939_/C XNOR3X1
XFILLER_46_568 VDD VSS FILLER1
XFILLER_34_708 VSS VDD FILLER2
XFILLER_160_53 VDD VSS FILLER1
XFILLER_37_96 VDD VSS FILLER4
XFILLER_73_365 VSS VDD FILLER2
XFILLER_61_516 VDD VSS FILLER4
X_14601_ _14601_/A _14601_/B _14615_/B _14601_/D VDD VSS _14624_/B AOI211X1
X_11813_ _19062_/Q _14334_/B VDD VSS _11944_/B NOR2X1
XTAP_TAPCELL_ROW_28_265 VDD VSS WELLTAP
XFILLER_163_0 VSS VDD FILLER2
X_15581_ _15597_/C _15597_/B VDD VSS _15582_/B NOR2BX1
XTAP_TAPCELL_ROW_8_89 VDD VSS WELLTAP
XFILLER_73_398 VSS VDD FILLER2
X_12793_ _18936_/Q VDD VSS _12877_/A INVX1
XFILLER_14_421 VSS VDD FILLER2
X_17320_ _19820_/Q _19788_/Q _17320_/C VDD VSS _17325_/C AO21X2
X_14532_ _14532_/A _14532_/B _17827_/B VDD VSS _19238_/D AOI21X1
XFILLER_26_292 VDD VSS FILLER1
XFILLER_14_443 VSS VDD FILLER2
X_11744_ _11751_/A _14520_/B VDD VSS _11835_/A NOR2X1
X_17251_ _17390_/A _17251_/B VDD VSS _19806_/D NOR2X1
X_14463_ _14421_/Y _14463_/B _14463_/C VDD VSS _19177_/D AND3BX1
X_11675_ _11675_/A _16704_/B VDD VSS _18839_/D NOR2X1
XTAP_TAPCELL_ROW_11_110 VDD VSS WELLTAP
X_16202_ _16202_/A VDD VSS _16811_/B INVX1
X_13414_ _19052_/Q _14323_/B VDD VSS _13415_/D _14322_/C AND3X2
X_17182_ _17185_/C _17183_/B _17229_/C VDD VSS _17183_/C OAI21X1
X_10626_ _10298_/Y _10624_/Y _11120_/A VDD VSS _10630_/B MUXI2X1
X_14394_ _14415_/A _14394_/B VDD VSS _19116_/D AND2X1
XFILLER_155_610 VDD VSS FILLER4
XFILLER_155_632 VSS VDD FILLER2
X_16133_ _16133_/A _16133_/B _16772_/B VDD VSS _16155_/B MIN3X1
XFILLER_10_682 VDD VSS FILLER4
X_13345_ _13345_/A _13345_/B _13345_/C _13345_/D VDD VSS _14544_/B OAOI211X1
XFILLER_154_120 VDD VSS FILLER4
X_10557_ _10965_/A _18719_/Q VDD VSS _10558_/D AND2X1
XFILLER_155_654 VDD VSS DECAPHV16
XFILLER_154_142 VSS VDD FILLER2
XFILLER_127_367 VDD VSS FILLER4
XFILLER_143_816 VSS VDD FILLER2
XFILLER_6_664 VDD VSS FILLER4
XFILLER_155_687 VDD VSS FILLER1
XFILLER_115_529 VSS VDD FILLER2
XFILLER_142_304 VSS VDD FILLER2
X_16064_ _16088_/C _16064_/B VDD VSS _16734_/B XNOR2X1
X_13276_ _19025_/Q _14292_/B VDD VSS _13300_/C XNOR2X1
XFILLER_143_849 VSS VDD FILLER2
X_10488_ _19942_/Q _18824_/Q VDD VSS _10530_/A NAND2X1
XFILLER_108_581 VSS VDD FILLER2
XFILLER_142_337 VDD VSS FILLER4
X_15015_ _15015_/A _15015_/B _15015_/C _15015_/D VDD VSS _15017_/B OAOI211X1
X_12227_ _20001_/Q _19265_/Q VDD VSS _12396_/A AND2X1
X_19823_ _19825_/CK _19823_/D _19823_/Q VDD VSS DFFQX1
XFILLER_96_413 VDD VSS FILLER4
X_12158_ _12158_/A _12158_/B _12158_/C _12158_/D VDD VSS _14499_/C OAI211X1
XFILLER_69_649 VSS VDD FILLER2
XFILLER_68_137 VSS VDD FILLER2
X_11109_ _18680_/Q _18788_/Q VDD VSS _11132_/B NAND2X1
XFILLER_111_768 VSS VDD FILLER2
X_19754_ _19791_/CK _19754_/D _19754_/Q VDD VSS DFFQX1
X_16966_ _16971_/A _16968_/C _16966_/C VDD VSS _19748_/D AOI21X1
X_12089_ _12155_/A _12116_/B _12091_/C VDD VSS _14434_/B AND3BX1
XFILLER_49_340 VSS VDD FILLER2
XFILLER_83_107 VSS VDD FILLER2
XFILLER_110_278 VDD VSS FILLER4
X_18705_ _18788_/CK _18705_/D _18705_/Q VDD VSS DFFQX1
XFILLER_110_289 VDD VSS FILLER4
X_15917_ _19898_/Q _19546_/Q VDD VSS _16727_/B XNOR2X1
XFILLER_83_129 VSS VDD FILLER2
X_19685_ _19696_/CK _19685_/D _19685_/Q VDD VSS DFFQX1
XFILLER_65_833 VDD VSS FILLER4
X_16897_ _16976_/A _16897_/B VDD VSS _19732_/D NOR2X1
XFILLER_64_321 VDD VSS FILLER4
X_18636_ _19943_/CK _18636_/D _18636_/Q VDD VSS DFFQX1
X_15848_ _15867_/A _15848_/B VDD VSS _19460_/D NOR2X1
XFILLER_64_354 VDD VSS FILLER1
XFILLER_92_674 VDD VSS FILLER4
XFILLER_80_814 VSS VDD FILLER2
XFILLER_52_516 VDD VSS FILLER1
X_18567_ _18589_/CK _18567_/D _18567_/Q VDD VSS DFFQX1
XTAP_TAPCELL_ROW_90_820 VDD VSS WELLTAP
XFILLER_91_184 VSS VDD FILLER2
XFILLER_18_793 VDD VSS FILLER4
XFILLER_17_270 VSS VDD FILLER2
X_15779_ _15779_/A VDD VSS _15780_/B INVX1
XFILLER_17_292 VSS VDD FILLER2
X_17518_ _19863_/Q _19831_/Q VDD VSS _17520_/B XNOR2X1
XFILLER_32_240 VSS VDD FILLER2
X_18498_ _18503_/CK _18519_/Q _20111_/A _18498_/RB VDD VSS DFFRQX1
XTAP_TAPCELL_ROW_102_932 VDD VSS WELLTAP
X_17449_ _19848_/Q VDD VSS _17600_/B INVX1
XTAP_TAPCELL_ROW_154_1401 VDD VSS WELLTAP
XFILLER_145_120 VDD VSS FILLER4
X_19119_ _19119_/CK _19119_/D _19119_/Q VDD VSS DFFQX1
XFILLER_145_131 VSS VDD FILLER2
XFILLER_106_507 VDD VSS FILLER4
XFILLER_106_529 VSS VDD FILLER2
XFILLER_145_175 VSS VDD FILLER2
XFILLER_133_337 VSS VDD FILLER2
XFILLER_133_348 VDD VSS FILLER1
XFILLER_161_668 VSS VDD FILLER2
XFILLER_99_240 VSS VDD FILLER2
XFILLER_160_156 VDD VSS FILLER1
XFILLER_102_757 VDD VSS DECAPHV8
XFILLER_87_468 VDD VSS FILLER4
XFILLER_114_35 VSS VDD FILLER2
X_09705_ _20074_/Q _09770_/B _09812_/B _18304_/Q VDD VSS _09707_/A AOI22X1
XFILLER_114_68 VDD VSS FILLER4
XFILLER_28_535 VSS VDD FILLER2
XFILLER_28_546 VSS VDD FILLER2
XFILLER_83_641 VSS VDD FILLER2
X_09636_ _09636_/A _09636_/B _09729_/D _09636_/D VDD VSS _18283_/D AOAI211X1
XFILLER_55_343 VDD VSS FILLER1
XFILLER_43_505 VDD VSS FILLER1
XFILLER_16_719 VSS VDD FILLER2
XFILLER_82_173 VSS VDD FILLER2
XFILLER_70_313 VSS VDD FILLER2
XFILLER_43_527 VDD VSS DECAPHV8
X_09567_ _09815_/B VDD VSS _09811_/C BUFX3
XFILLER_43_549 VSS VDD FILLER2
XFILLER_70_346 VDD VSS DECAPHV8
XTAP_TAPCELL_ROW_25_235 VDD VSS WELLTAP
X_09498_ _18494_/D _09501_/B _09506_/C _20072_/Q VDD VSS _20072_/D AO22X2
XFILLER_23_240 VDD VSS FILLER4
XFILLER_130_89 VDD VSS DECAPHV8
XFILLER_90_49 VSS VDD FILLER2
XFILLER_142_5 VSS VDD FILLER2
XFILLER_11_424 VDD VSS FILLER1
XFILLER_128_109 VSS VDD FILLER2
XFILLER_23_54 VSS VDD FILLER2
XFILLER_11_468 VDD VSS DECAPHV8
X_11460_ _19953_/Q _11460_/B VDD VSS _18646_/D AND2X1
XFILLER_23_65 VDD VSS FILLER1
XFILLER_156_429 VDD VSS DECAPHV8
X_10411_ _10411_/A VDD VSS _10460_/A INVX1
XFILLER_137_654 VDD VSS FILLER4
XFILLER_136_131 VSS VDD FILLER2
X_11391_ _11392_/A _11392_/B _11392_/D _11392_/C VDD VSS _11391_/Y AOI211X1
XFILLER_99_36 VDD VSS FILLER1
XFILLER_136_142 VSS VDD FILLER2
XFILLER_99_47 VDD VSS FILLER4
XFILLER_109_367 VDD VSS FILLER4
XFILLER_125_816 VDD VSS FILLER4
X_13130_ _19219_/Q _13444_/A _13139_/B VDD VSS _13131_/D XNOR3X1
XFILLER_137_698 VDD VSS DECAPHV8
X_10342_ _10343_/A _10343_/B _10343_/D _10343_/C VDD VSS _10342_/Y AOI211X1
XTAP_TAPCELL_ROW_118_1075 VDD VSS WELLTAP
XFILLER_3_601 VDD VSS FILLER1
XFILLER_151_101 VDD VSS FILLER4
XFILLER_151_112 VDD VSS FILLER4
XFILLER_124_337 VSS VDD FILLER2
XFILLER_124_348 VDD VSS FILLER1
X_13061_ _19218_/Q _13061_/B VDD VSS _13131_/C _13061_/C NAND3X1
X_10273_ _18551_/Q _10306_/A VDD VSS _10312_/B NAND2X1
XFILLER_151_156 VDD VSS FILLER1
XFILLER_2_144 VDD VSS FILLER1
XFILLER_151_178 VDD VSS FILLER1
X_12012_ _19010_/Q _12012_/B _14273_/B VDD VSS _14240_/A MIN3X1
X_18207__254 _20052_/CK VDD VSS _20048_/CK INVX1
XFILLER_151_189 VSS VDD FILLER2
X_16820_ _16826_/A _16820_/B VDD VSS _19662_/D NOR2X1
XFILLER_78_468 VSS VDD FILLER2
XFILLER_65_118 VDD VSS FILLER1
XFILLER_19_513 VSS VDD FILLER2
X_16751_ _16759_/A _16751_/B VDD VSS _19600_/D NOR2X1
X_13963_ _19034_/Q _14302_/B VDD VSS _14010_/D XOR2X1
XTAP_TAPCELL_ROW_129_1171 VDD VSS WELLTAP
XFILLER_74_641 VDD VSS FILLER1
X_15702_ _15710_/A _15702_/B VDD VSS _19330_/D NOR2X1
X_19470_ _19531_/CK _19470_/D _19470_/Q VDD VSS DFFQX1
X_12914_ _19077_/Q _13102_/A _13102_/B VDD VSS _12915_/D XNOR3X1
X_16682_ _19641_/Q _16796_/B VDD VSS _16683_/B XNOR2X1
X_13894_ _13957_/A _14198_/B VDD VSS _13936_/B NOR2X1
XFILLER_73_140 VSS VDD FILLER2
X_18421_ _18422_/CK _18501_/D _20176_/A _18450_/RB VDD VSS DFFRQX1
XFILLER_74_696 VDD VSS FILLER1
X_15633_ _15674_/A _18174_/B VDD VSS _19300_/D AND2X1
X_12845_ _12955_/A _12955_/B VDD VSS _14538_/A _12966_/C NAND3X1
XFILLER_73_184 VSS VDD FILLER2
XFILLER_27_590 VDD VSS FILLER1
XFILLER_61_357 VSS VDD FILLER2
X_18352_ _18357_/CK _18352_/D _18352_/Q _20078_/RB VDD VSS DFFRQX1
X_15564_ _15564_/A _15564_/B _15564_/C _15564_/D VDD VSS _15591_/A AOAI211X1
X_12776_ _19076_/Q _12776_/B _12821_/C VDD VSS _12916_/B XNOR3X1
XFILLER_15_763 VDD VSS FILLER4
XFILLER_30_700 VDD VSS FILLER4
X_17303_ _17305_/C _17303_/B _17303_/C VDD VSS _19817_/D AOI21X1
X_14515_ _14766_/A _14515_/B VDD VSS _19222_/D AND2X1
X_11727_ _14486_/A _11745_/D VDD VSS _11760_/C XNOR2X1
XFILLER_30_722 VSS VDD FILLER2
X_15495_ _15495_/A _15504_/B VDD VSS _15695_/B XOR2X1
X_18283_ _18288_/CK _18283_/D _18283_/Q VDD VSS DFFQX1
XFILLER_42_593 VSS VDD FILLER2
XFILLER_159_245 VDD VSS FILLER4
XFILLER_159_256 VSS VDD FILLER2
XFILLER_147_407 VSS VDD FILLER2
X_17234_ _19803_/Q _19771_/Q VDD VSS _17236_/C XOR2X1
X_14446_ _14421_/Y _14446_/B _14446_/C VDD VSS _19162_/D AND3BX1
X_11658_ _18798_/Q _11658_/B VDD VSS _18825_/D AND2X1
XFILLER_30_777 VDD VSS FILLER1
XFILLER_128_621 VSS VDD FILLER2
XFILLER_80_82 VDD VSS FILLER4
XFILLER_127_120 VSS VDD FILLER2
XFILLER_128_643 VSS VDD FILLER2
X_10609_ _18666_/Q _18774_/Q VDD VSS _10642_/D NOR2X1
X_17165_ _17168_/A _17165_/B _17165_/C VDD VSS _19787_/D AOI21X1
X_14377_ _14393_/A _14377_/B VDD VSS _19100_/D NOR2X1
X_11589_ _18735_/Q _11589_/B VDD VSS _18762_/D AND2X1
XFILLER_128_687 VSS VDD FILLER2
XFILLER_127_164 VSS VDD FILLER2
X_16116_ _16134_/B _16116_/B VDD VSS _16772_/B XNOR2X1
X_13328_ _19192_/Q _14479_/B VDD VSS _13331_/C _14479_/C NAND3X1
XFILLER_115_315 VDD VSS FILLER4
X_17096_ _17391_/A VDD VSS _17390_/A BUFX3
XFILLER_50_4 VSS VDD FILLER2
XFILLER_6_483 VSS VDD FILLER2
X_16047_ _19680_/Q _16840_/B VDD VSS _16055_/B NAND2X1
X_13259_ _20012_/Q _19276_/Q VDD VSS _13345_/C NAND2X1
XFILLER_89_91 VSS VDD FILLER2
XFILLER_130_318 VDD VSS FILLER4
XFILLER_111_510 VDD VSS DECAPHV8
XFILLER_123_370 VSS VDD FILLER2
X_19806_ _19895_/CK _19806_/D _19806_/Q VDD VSS DFFQX1
XFILLER_97_777 VSS VDD FILLER2
XFILLER_69_468 VDD VSS FILLER4
X_17998_ _18540_/Q _18038_/B VDD VSS _18042_/B AND2X1
XFILLER_38_800 VDD VSS FILLER4
XFILLER_84_416 VSS VDD FILLER2
XTAP_TAPCELL_ROW_67_614 VDD VSS WELLTAP
X_19737_ _19737_/CK _19737_/D _19737_/Q VDD VSS DFFQX1
X_16949_ _19745_/Q _17078_/B VDD VSS _16951_/B XOR2X1
XFILLER_96_298 VSS VDD FILLER2
XFILLER_37_310 VSS VDD FILLER2
XFILLER_37_321 VDD VSS FILLER4
XFILLER_65_641 VSS VDD FILLER2
X_19668_ _19702_/CK _19668_/D _19668_/Q VDD VSS DFFQX1
XFILLER_80_600 VDD VSS FILLER4
X_09421_ _09421_/A _09520_/D _09421_/C VDD VSS _18228_/E AOI21X1
XFILLER_92_471 VSS VDD FILLER2
XFILLER_64_162 VDD VSS FILLER1
XFILLER_52_302 VSS VDD FILLER2
X_18619_ _18622_/CK _18619_/D _18619_/Q VDD VSS DFFQX1
XFILLER_52_324 VDD VSS FILLER1
X_19599_ _19664_/CK _19599_/D _19599_/Q VDD VSS DFFQX1
XTAP_TAPCELL_ROW_75_691 VDD VSS WELLTAP
X_09352_ _09369_/B _09258_/B _09351_/Y VDD VSS _18509_/D MUXI2X1
XFILLER_40_508 VSS VDD FILLER2
XFILLER_100_15 VDD VSS DECAPHV8
XFILLER_21_722 VSS VDD FILLER2
X_09283_ _09362_/B _20046_/Q _09296_/A _09283_/D VDD VSS _18258_/D OAI31X1
XFILLER_20_210 VSS VDD FILLER2
XFILLER_21_755 VDD VSS FILLER1
XFILLER_166_738 VSS VDD FILLER2
XFILLER_119_654 VSS VDD FILLER2
XFILLER_146_440 VDD VSS FILLER4
XFILLER_118_142 VDD VSS FILLER4
XTAP_TAPCELL_ROW_30_282 VDD VSS WELLTAP
XFILLER_134_602 VSS VDD FILLER2
XFILLER_119_687 VSS VDD FILLER2
XFILLER_161_410 VDD VSS DECAPHV16
XFILLER_106_337 VDD VSS FILLER1
XFILLER_106_348 VSS VDD FILLER2
Xclkload80 _19478_/CK VDD VSS clkload80/Y BUFX12
XFILLER_161_443 VSS VDD FILLER2
XFILLER_134_668 VSS VDD FILLER2
Xclkload91 _19460_/CK VDD VSS clkload91/Y INVX4
XFILLER_88_700 VDD VSS FILLER4
XFILLER_121_307 VSS VDD FILLER2
XFILLER_133_189 VSS VDD FILLER2
XFILLER_88_733 VDD VSS FILLER1
XFILLER_87_232 VSS VDD FILLER2
XFILLER_102_554 VSS VDD FILLER2
XFILLER_88_788 VSS VDD FILLER2
XFILLER_85_38 VSS VDD FILLER2
X_10960_ _10960_/A VDD VSS _11364_/A BUFX3
XFILLER_44_803 VDD VSS FILLER1
XFILLER_44_825 VSS VDD FILLER2
XFILLER_56_696 VDD VSS FILLER1
XFILLER_43_313 VDD VSS FILLER4
XFILLER_18_98 VSS VDD FILLER2
X_09619_ _18347_/Q VDD VSS _20215_/A INVX1
XFILLER_55_184 VSS VDD FILLER2
X_10891_ _19954_/Q _18836_/Q VDD VSS _10931_/D NOR2X1
XFILLER_16_549 VSS VDD FILLER2
X_12630_ _12630_/A _12630_/B _12630_/C _12630_/D VDD VSS _14315_/C OAI211X1
XFILLER_71_666 VSS VDD FILLER2
XFILLER_71_677 VDD VSS FILLER1
XFILLER_12_700 VDD VSS FILLER4
X_12561_ _12561_/A _14439_/B _14440_/C VDD VSS _14441_/B AOI21BX1
XFILLER_34_75 VDD VSS FILLER4
XFILLER_11_210 VSS VDD FILLER2
XFILLER_34_86 VSS VDD FILLER2
XTAP_TAPCELL_ROW_5_57 VDD VSS WELLTAP
XFILLER_11_243 VDD VSS DECAPHV8
XFILLER_129_418 VDD VSS FILLER1
X_14300_ _14352_/A _14300_/B _14300_/C VDD VSS _19032_/D NOR3X1
X_11512_ _18665_/Q _11519_/B VDD VSS _18692_/D AND2X1
X_15280_ _15281_/A _15281_/B _15281_/C VDD VSS _15844_/B OA21X2
X_12492_ _19213_/Q VDD VSS _12659_/A INVX1
XFILLER_7_225 VSS VDD FILLER2
XFILLER_126_0 VDD VSS FILLER4
X_14231_ _14231_/A _14231_/B VDD VSS _18976_/D AND2X1
X_11443_ _19938_/Q _17990_/A VDD VSS _18631_/D AND2X1
XFILLER_137_440 VSS VDD FILLER2
Xwire156 wire156/A VDD VSS wire156/Y BUFX4
Xwire167 wire167/A VDD VSS wire167/Y BUFX6
X_14162_ _14163_/A _14162_/B _14162_/C VDD VSS _18916_/D NOR3X1
XFILLER_109_175 VDD VSS FILLER4
X_11374_ _11381_/C _11381_/A VDD VSS _11377_/B NOR2BX1
XFILLER_152_421 VDD VSS FILLER4
XFILLER_164_292 VSS VDD FILLER2
X_13113_ _13113_/A _13113_/B _13113_/C _13113_/D VDD VSS _14385_/B OAOI211X1
XFILLER_113_808 VSS VDD FILLER2
X_10325_ _10721_/D _10325_/B _10381_/C _10325_/D VDD VSS _10345_/A OAI31X1
X_18970_ _18999_/CK _18970_/D _18970_/Q VDD VSS DFFQX1
X_14093_ _14093_/A _14093_/B _14093_/C _14093_/D VDD VSS _17975_/C OAOI211X1
XFILLER_3_453 VDD VSS FILLER4
X_17921_ _18862_/Q _17921_/B _17921_/C VDD VSS _17927_/B XOR3X1
X_13044_ _13138_/A _13138_/B VDD VSS _13122_/B NOR2X1
XFILLER_105_370 VSS VDD FILLER2
X_10256_ _19937_/Q _18819_/Q VDD VSS _10258_/B XOR2X1
XFILLER_140_649 VDD VSS FILLER4
X_17852_ _18849_/Q _17868_/B VDD VSS _17855_/B XNOR2X1
X_10187_ _18616_/Q VDD VSS _10189_/A INVX1
XFILLER_66_405 VSS VDD FILLER2
XFILLER_39_619 VDD VSS FILLER1
X_16803_ _16843_/A _16803_/B VDD VSS _19646_/D AND2X1
XFILLER_94_736 VDD VSS FILLER4
XFILLER_38_118 VDD VSS FILLER1
X_17783_ _17785_/A _17785_/B _17783_/C VDD VSS _19920_/D AOI21X1
X_14995_ _14995_/A _14995_/B _14995_/C VDD VSS _15806_/C NOR3X1
X_19522_ _19536_/CK _19522_/D _19522_/Q VDD VSS DFFQX1
X_16734_ _16768_/A _16734_/B VDD VSS _19585_/D AND2X1
XFILLER_93_268 VSS VDD FILLER2
X_13946_ _14001_/A _14001_/B _13957_/C VDD VSS _14199_/B AOI21BX1
XFILLER_47_674 VDD VSS FILLER1
X_19453_ _19484_/CK _19453_/D _19453_/Q VDD VSS DFFQX1
X_16665_ _19736_/Q _16901_/B VDD VSS _16667_/B XNOR2X1
X_13877_ _14133_/B _13877_/B _18891_/Q VDD VSS _13929_/C AND3BX1
X_18404_ _18406_/CK _18404_/D _18404_/Q _18405_/RB VDD VSS DFFRQX1
X_15616_ _19355_/Q _15730_/B VDD VSS _15617_/C NAND2X1
XFILLER_50_817 VDD VSS DECAPHV8
X_19384_ _19412_/CK _19384_/D _19384_/Q VDD VSS DFFQX1
X_12828_ _14475_/C _19188_/Q _13036_/B VDD VSS _12940_/D AND3BX1
X_16596_ _16596_/A VDD VSS _16791_/B INVX1
XTAP_TAPCELL_ROW_72_661 VDD VSS WELLTAP
XFILLER_61_165 VDD VSS FILLER4
X_18335_ _18343_/CK _18495_/D _20089_/A _18374_/RB VDD VSS DFFRQX1
X_15547_ _19492_/Q _15547_/B _15885_/B VDD VSS _15855_/B MIN3X1
X_12759_ _12759_/A _14537_/B _14537_/C VDD VSS _12760_/D NOR3X1
XFILLER_91_92 VDD VSS FILLER1
XFILLER_147_204 VSS VDD FILLER2
X_18266_ _18268_/CK _18266_/D _18266_/Q _20081_/RB VDD VSS DFFRQX1
X_15478_ _15514_/B _15478_/B VDD VSS _15515_/B XNOR2X1
XFILLER_30_574 VSS VDD FILLER2
X_17217_ _19798_/Q _19766_/Q _17217_/C VDD VSS _17221_/B AOI21X1
XTAP_TAPCELL_ROW_138_1259 VDD VSS WELLTAP
X_14429_ _14456_/A _14429_/B VDD VSS _19146_/D NOR2X1
X_18197_ _20014_/Q _20061_/Q _09421_/C _18197_/D VDD VSS _20014_/D AOI2B2BX1
XFILLER_116_602 VSS VDD FILLER2
XFILLER_128_462 VSS VDD FILLER2
X_17148_ _17149_/A _17151_/C _17164_/C VDD VSS _17149_/C OAI21X1
XFILLER_156_793 VDD VSS FILLER4
XFILLER_155_270 VDD VSS DECAPHV8
XFILLER_155_292 VDD VSS DECAPHV8
XFILLER_143_454 VSS VDD FILLER2
X_17079_ _17079_/A _17079_/B VDD VSS _17080_/B XNOR2X1
XFILLER_115_189 VDD VSS FILLER4
XFILLER_143_498 VSS VDD FILLER2
XFILLER_131_649 VSS VDD FILLER2
X_20090_ _20090_/A VDD VSS _20090_/Y BUFX3
XFILLER_69_210 VSS VDD FILLER2
XFILLER_130_137 VSS VDD FILLER2
XFILLER_69_221 VDD VSS FILLER1
XFILLER_97_541 VDD VSS DECAPHV16
XFILLER_85_725 VDD VSS FILLER1
XFILLER_84_202 VSS VDD FILLER2
XTAP_TAPCELL_ROW_149_1355 VDD VSS WELLTAP
XFILLER_85_747 VSS VDD FILLER2
XFILLER_84_235 VSS VDD FILLER2
XFILLER_38_630 VSS VDD FILLER2
XFILLER_55_19 VSS VDD FILLER2
XFILLER_84_268 VSS VDD FILLER2
XFILLER_84_279 VDD VSS FILLER4
XFILLER_38_696 VDD VSS FILLER1
XFILLER_37_162 VSS VDD FILLER2
XFILLER_37_184 VSS VDD FILLER2
XFILLER_25_324 VSS VDD FILLER2
XFILLER_37_195 VSS VDD FILLER2
XFILLER_111_25 VDD VSS FILLER4
X_09404_ _13283_/A _11440_/B VDD VSS _18229_/E NAND2X1
XFILLER_111_47 VDD VSS FILLER4
XTAP_TAPCELL_ROW_35_330 VDD VSS WELLTAP
XFILLER_80_452 VDD VSS FILLER4
XFILLER_80_474 VSS VDD FILLER2
XFILLER_71_18 VSS VDD FILLER2
XFILLER_40_316 VSS VDD FILLER2
X_09335_ _18285_/Q _18513_/Q _09354_/B VDD VSS _09335_/Y MUXI2X1
XFILLER_40_338 VSS VDD FILLER2
X_09266_ _18277_/Q _18276_/Q _18278_/Q VDD VSS _09269_/C AOI21X1
X_09197_ _18514_/Q VDD VSS _18445_/D INVX1
XFILLER_20_11 VSS VDD FILLER2
XFILLER_134_421 VSS VDD FILLER2
XFILLER_20_33 VSS VDD FILLER2
XFILLER_20_44 VSS VDD FILLER2
XFILLER_162_752 VDD VSS FILLER4
XTAP_TAPCELL_ROW_115_1045 VDD VSS WELLTAP
XFILLER_106_156 VDD VSS DECAPHV8
XFILLER_136_44 VSS VDD FILLER2
XFILLER_20_88 VDD VSS FILLER1
X_10110_ _10120_/B _10122_/A VDD VSS _10111_/B NAND2X1
XFILLER_136_77 VDD VSS FILLER4
X_11090_ _11090_/A _11090_/B _11090_/C VDD VSS _11128_/A NOR3X1
XFILLER_161_295 VDD VSS FILLER1
XFILLER_121_137 VSS VDD FILLER2
XFILLER_136_99 VSS VDD FILLER2
XFILLER_88_541 VDD VSS FILLER4
X_10041_ _11208_/A VDD VSS _10131_/A BUFX3
XFILLER_96_59 VSS VDD FILLER2
XFILLER_48_416 VSS VDD FILLER2
XFILLER_0_489 VDD VSS FILLER4
XFILLER_130_682 VSS VDD FILLER2
XFILLER_48_427 VSS VDD FILLER2
XFILLER_75_213 VDD VSS FILLER4
XFILLER_130_693 VDD VSS FILLER4
XFILLER_76_747 VSS VDD FILLER2
XFILLER_48_438 VSS VDD FILLER2
XFILLER_29_86 VDD VSS FILLER4
X_13800_ _18947_/Q _13921_/A _13987_/B VDD VSS _13918_/D XNOR3X1
XFILLER_152_87 VDD VSS DECAPHV8
X_14780_ _14781_/A _14781_/B VDD VSS _15865_/B _14872_/B _14781_/D NAND4X2
X_11992_ _12055_/A _12055_/B _12055_/C VDD VSS _11996_/B OAI21X1
XFILLER_29_674 VSS VDD FILLER2
XTAP_TAPCELL_ROW_86_786 VDD VSS WELLTAP
XFILLER_90_216 VDD VSS FILLER4
XFILLER_84_780 VDD VSS FILLER1
XFILLER_16_313 VSS VDD FILLER2
X_13731_ _13731_/A _14327_/B _14327_/C VDD VSS _13837_/D NOR3X1
X_10943_ _11195_/A _10943_/B _10943_/C VDD VSS _10944_/C AOI21X1
XFILLER_16_335 VSS VDD FILLER2
X_16450_ _19567_/Q _16715_/A _16450_/C VDD VSS _16476_/C MIN3X1
XFILLER_71_463 VSS VDD FILLER2
XFILLER_16_368 VSS VDD FILLER2
X_13662_ _13662_/A _13662_/B _13662_/C _13662_/D VDD VSS _13751_/A OAOI211X1
X_10874_ _10874_/A _10896_/C _10874_/C _10874_/D VDD VSS _10875_/E AOAI211X1
XFILLER_45_96 VSS VDD FILLER2
XFILLER_71_485 VDD VSS FILLER4
X_15401_ _19516_/Q _15911_/B VDD VSS _15402_/B XNOR2X1
X_12613_ _18878_/Q _12613_/B _17861_/B VDD VSS _12790_/B MIN3X1
XFILLER_43_198 VSS VDD FILLER2
X_16381_ _16381_/A _16388_/C VDD VSS wire155/A XNOR2X1
X_13593_ _18999_/Q _14261_/B VDD VSS _13686_/A NAND2X1
XFILLER_101_80 VSS VDD FILLER2
XFILLER_157_502 VSS VDD FILLER2
X_18120_ _18121_/A _18121_/B _18121_/C VDD VSS _18122_/B NOR3X1
XFILLER_61_40 VSS VDD FILLER2
X_15332_ _15341_/A _15721_/B VDD VSS _15333_/B XNOR2X1
X_12544_ _12544_/A _12544_/B _12544_/C _12544_/D VDD VSS _12634_/B AOAI211X1
XFILLER_157_524 VDD VSS FILLER1
XFILLER_61_73 VSS VDD FILLER2
XFILLER_129_248 VSS VDD FILLER2
XFILLER_8_545 VSS VDD FILLER2
XFILLER_157_557 VDD VSS FILLER1
X_18051_ _18054_/A _18051_/B _18056_/A VDD VSS _19983_/D AOI21X1
X_15263_ _15305_/A _15305_/B VDD VSS _15289_/A NAND2X1
X_12475_ _19184_/Q _12662_/A _12662_/B VDD VSS _12483_/D XNOR3X1
XFILLER_157_579 VSS VDD FILLER2
X_17002_ _19754_/Q _17049_/B _17006_/A _17006_/B VDD VSS _17002_/Y AOI211X1
X_14214_ _14218_/A _14214_/B VDD VSS _18963_/D NOR2X1
X_11426_ _14163_/A _11429_/B _11426_/C VDD VSS _18619_/D NOR3X1
XANTENNA_6 input4/Y VDD VSS ANTENNA2
XFILLER_138_793 VDD VSS FILLER4
X_15194_ _19484_/Q _15876_/B VDD VSS _15243_/B XNOR2X1
XFILLER_165_590 VDD VSS FILLER4
X_14145_ _14154_/A _14145_/B VDD VSS _18901_/D NOR2X1
X_11357_ _11357_/A VDD VSS _11358_/C INVX1
XFILLER_153_774 VSS VDD FILLER2
XFILLER_125_487 VSS VDD FILLER2
XFILLER_113_638 VDD VSS FILLER1
X_10308_ _10312_/A _10312_/C VDD VSS _10310_/B XNOR2X1
XFILLER_4_784 VDD VSS FILLER4
XFILLER_112_115 VDD VSS FILLER1
X_18953_ _19171_/CK _18953_/D _18953_/Q VDD VSS DFFQX1
X_14076_ _14171_/B _18924_/Q VDD VSS _14089_/A NAND2BX1
XFILLER_4_795 VDD VSS FILLER1
XFILLER_140_435 VDD VSS FILLER4
X_11288_ _11298_/A _11288_/B _11298_/C VDD VSS _11363_/B OAI21X1
XFILLER_112_137 VSS VDD FILLER2
X_17904_ _18859_/Q _17911_/B VDD VSS _17906_/B XNOR2X1
X_13027_ _13041_/A _14413_/B _13041_/C VDD VSS _14414_/B OAI21X1
X_10239_ _18624_/Q _18623_/Q _10268_/B VDD VSS _10240_/D AOI2B1X1
X_18884_ _18939_/CK _18884_/D _18884_/Q VDD VSS DFFQX1
XFILLER_39_405 VDD VSS FILLER1
XFILLER_79_574 VDD VSS DECAPHV8
XFILLER_39_416 VSS VDD FILLER2
X_17835_ _19934_/Q _17836_/B VDD VSS _17842_/C AND2X1
XFILLER_67_747 VSS VDD FILLER2
XFILLER_39_438 VDD VSS FILLER4
XFILLER_66_235 VSS VDD FILLER2
XFILLER_94_566 VSS VDD FILLER2
XTAP_TAPCELL_ROW_49_455 VDD VSS WELLTAP
X_17766_ _17766_/A _17766_/B _17766_/C _17766_/D VDD VSS _17767_/C AOAI211X1
X_14978_ _19395_/Q _15774_/B VDD VSS _15026_/C NAND2X1
XFILLER_94_599 VDD VSS FILLER4
X_19505_ _19531_/CK _19505_/D _19505_/Q VDD VSS DFFQX1
XFILLER_35_622 VSS VDD FILLER2
X_16717_ _16717_/A _16724_/B VDD VSS _19569_/D NOR2X1
XFILLER_81_238 VSS VDD FILLER2
X_13929_ _17924_/B _17924_/C _13929_/C _13929_/D VDD VSS _13941_/B AOAI211X1
XFILLER_34_110 VSS VDD FILLER2
XFILLER_19_184 VSS VDD FILLER2
X_17697_ _17695_/B _17697_/B VDD VSS _17698_/C NOR2BX1
X_19436_ _19465_/CK _19436_/D _19436_/Q VDD VSS DFFQX1
X_16648_ _19639_/Q VDD VSS _16649_/A INVX1
XFILLER_90_772 VSS VDD FILLER2
XFILLER_50_614 VSS VDD FILLER2
XTAP_TAPCELL_ROW_32_300 VDD VSS WELLTAP
X_19367_ _19379_/CK _19367_/D _19367_/Q VDD VSS DFFQX1
X_16579_ _19637_/Q _16596_/A VDD VSS _16580_/B XOR2X1
X_18318_ _18325_/CK _18515_/Q _18318_/Q _20081_/RB VDD VSS DFFRQX1
X_19298_ _19331_/CK _19298_/D _19298_/Q VDD VSS DFFQX1
X_18249_ _18257_/CK _18249_/D _18268_/D _18469_/RB VDD VSS DFFRQX1
XFILLER_116_410 VDD VSS DECAPHV8
XFILLER_116_421 VSS VDD FILLER2
X_20211_ _20211_/A VDD VSS _20211_/Y BUFX3
XFILLER_89_316 VDD VSS FILLER4
XFILLER_103_104 VSS VDD FILLER2
X_20142_ _20142_/A VDD VSS _20142_/Y BUFX3
XFILLER_89_338 VSS VDD FILLER2
X_09953_ _10034_/A _09953_/B _09953_/C _09953_/D VDD VSS _09980_/B AOAI211X1
XFILLER_89_349 VDD VSS FILLER1
XFILLER_106_36 VDD VSS FILLER1
XFILLER_131_468 VSS VDD FILLER2
XFILLER_131_479 VDD VSS FILLER1
X_20073_ _20081_/CK _20073_/D _20073_/Q _20073_/RB VDD VSS DFFRQX1
X_09884_ _10966_/A _09884_/B _09884_/C VDD VSS _09884_/Y OAI21X1
XFILLER_112_693 VDD VSS FILLER4
XFILLER_97_393 VSS VDD FILLER2
XFILLER_111_181 VDD VSS FILLER4
XFILLER_72_227 VDD VSS FILLER4
XFILLER_82_17 VSS VDD FILLER2
XFILLER_26_644 VDD VSS FILLER1
XTAP_TAPCELL_ROW_83_756 VDD VSS WELLTAP
XFILLER_26_666 VSS VDD FILLER2
XFILLER_53_463 VSS VDD FILLER2
XFILLER_15_11 VSS VDD FILLER2
XFILLER_53_474 VDD VSS DECAPHV8
XFILLER_80_271 VSS VDD FILLER2
X_09318_ _18451_/D _09317_/Y _09302_/Y VDD VSS _18520_/D MUXI2X1
XFILLER_139_535 VSS VDD FILLER2
X_10590_ _10542_/B _18558_/Q VDD VSS _10592_/A NAND2BX1
XFILLER_21_371 VDD VSS FILLER1
XFILLER_127_708 VDD VSS FILLER1
X_09249_ _18496_/D VDD VSS _18336_/D INVX1
XFILLER_31_32 VSS VDD FILLER2
XFILLER_126_207 VDD VSS FILLER1
XFILLER_154_527 VDD VSS DECAPHV8
X_12260_ _12451_/B _12451_/C VDD VSS _14343_/B NAND2X1
XFILLER_119_292 VSS VDD FILLER2
X_11211_ _11150_/Y _11244_/B _10947_/Y VDD VSS _11267_/B MUX2X1
XFILLER_103_2 VDD VSS FILLER1
X_12191_ _14243_/A _14244_/A _14277_/B VDD VSS _12201_/C XNOR3X1
XFILLER_150_700 VDD VSS FILLER4
Xoutput10 _20094_/Y VDD VSS o_aux_ctrl[12] BUFX3
Xoutput8 output8/A VDD VSS o_aux_ctrl[10] BUFX3
XFILLER_107_476 VSS VDD FILLER2
XFILLER_122_402 VDD VSS FILLER1
XFILLER_135_785 VSS VDD FILLER2
Xoutput21 _20090_/Y VDD VSS o_aux_ctrl[8] BUFX3
Xdelaybuf_3_clk _231_/CK VDD VSS delaybuf_4_clk/A BUFX12
Xoutput32 _20116_/Y VDD VSS o_bias_cfg[18] BUFX3
XFILLER_1_710 VDD VSS FILLER1
Xoutput43 _20126_/Y VDD VSS o_bias_cfg[28] BUFX3
X_11142_ _11469_/A _11142_/B _11142_/C VDD VSS _11173_/C MIN3X1
XFILLER_162_593 VDD VSS FILLER4
XFILLER_134_295 VDD VSS FILLER4
Xoutput54 _20104_/Y VDD VSS o_bias_cfg[6] BUFX3
Xoutput65 _20149_/Y VDD VSS o_clk_cfg[16] BUFX3
Xoutput76 _20142_/Y VDD VSS o_clk_cfg[9] BUFX3
XFILLER_122_468 VDD VSS FILLER1
Xoutput87 _20161_/Y VDD VSS o_en_ctrl[9] BUFX3
XFILLER_110_619 VDD VSS FILLER1
XFILLER_150_788 VSS VDD FILLER2
X_15950_ _15950_/A _15950_/B VDD VSS _16800_/B XNOR2X1
X_11073_ _18652_/Q _18814_/Q VDD VSS _11075_/A XOR2X1
Xoutput98 _20167_/Y VDD VSS o_lf_cfg[4] BUFX3
XFILLER_76_500 VSS VDD FILLER2
XFILLER_1_776 VSS VDD FILLER2
XFILLER_49_725 VDD VSS FILLER1
XFILLER_48_202 VSS VDD FILLER2
X_14901_ _14901_/A _14901_/B _15710_/B VDD VSS _14952_/B MIN3X1
X_10024_ _10021_/Y _10026_/C _17172_/A VDD VSS _18530_/D AND3BX1
XFILLER_103_693 VDD VSS FILLER1
XFILLER_49_747 VDD VSS DECAPHV8
X_15881_ _16768_/A _15881_/B VDD VSS _19488_/D AND2X1
XFILLER_48_235 VSS VDD FILLER2
XFILLER_49_769 VDD VSS FILLER4
X_17620_ _19884_/Q _19852_/Q _17620_/C VDD VSS _17625_/C AO21X2
X_14832_ _19476_/Q _14918_/A _14918_/B VDD VSS _14865_/C XNOR3X1
XFILLER_76_577 VSS VDD FILLER2
XFILLER_48_279 VDD VSS FILLER1
XFILLER_29_460 VDD VSS FILLER4
XFILLER_17_622 VSS VDD FILLER2
X_17551_ _17549_/B _17551_/B VDD VSS _17552_/C NOR2BX1
XTAP_TAPCELL_ROW_46_425 VDD VSS WELLTAP
X_14763_ _14770_/B _14763_/B VDD VSS _15674_/B XNOR2X1
X_11975_ _11987_/A _14462_/B _11987_/C VDD VSS _14463_/C OR3X2
XFILLER_44_441 VDD VSS DECAPHV8
X_16502_ _19601_/Q _16502_/B _16752_/B VDD VSS _16522_/B MIN3X1
X_13714_ _13714_/A _13714_/B _13714_/C _13714_/D VDD VSS _14391_/C OAOI211X1
XFILLER_32_603 VDD VSS FILLER1
XFILLER_16_154 VDD VSS FILLER1
X_17482_ _17484_/C _17482_/B _17482_/C VDD VSS _19855_/D AOI21X1
X_10926_ _18647_/Q _18809_/Q _10926_/C VDD VSS _10962_/B AOI21X1
X_14694_ _14694_/A _14694_/B _15735_/B VDD VSS _14728_/B MIN3X1
XFILLER_16_165 VSS VDD FILLER2
XFILLER_71_271 VSS VDD FILLER2
XFILLER_16_176 VSS VDD FILLER2
X_19221_ _19250_/CK _19221_/D _19221_/Q VDD VSS DFFQX1
XFILLER_71_282 VSS VDD FILLER2
X_16433_ _16433_/A _16433_/B _16433_/C VDD VSS _16434_/B NOR3X1
X_13645_ _13728_/A _13728_/B _13728_/C VDD VSS _13649_/B OAI21X1
X_10857_ _10857_/A _10890_/C VDD VSS _10876_/B XNOR2X1
XFILLER_20_809 VDD VSS FILLER1
X_19152_ _19191_/CK _19152_/D _19152_/Q VDD VSS DFFQX1
X_16364_ _16345_/A _16364_/B VDD VSS _16365_/B NAND2BX1
X_13576_ _13662_/A _13662_/B _13662_/C VDD VSS _14129_/B OAI21X1
X_10788_ _19951_/Q _18833_/Q VDD VSS _10790_/C XOR2X1
XFILLER_8_320 VDD VSS FILLER4
X_18103_ _18109_/C _18109_/B VDD VSS _18105_/B NAND2BX1
XFILLER_118_708 VSS VDD FILLER2
X_15315_ _19514_/Q _15909_/B VDD VSS _15359_/D NOR2BX1
XFILLER_12_393 VSS VDD FILLER2
X_19083_ _19119_/CK _19083_/D _19083_/Q VDD VSS DFFQX1
X_12527_ _18904_/Q _12527_/B _12527_/C VDD VSS _14116_/B XNOR3X1
X_16295_ _16296_/A _16296_/B _16296_/C VDD VSS _16308_/C AO21X2
XFILLER_157_387 VSS VDD FILLER2
X_18034_ _18538_/Q _18036_/B VDD VSS _18035_/B XNOR2X1
XTAP_TAPCELL_ROW_135_1229 VDD VSS WELLTAP
X_15246_ _15284_/D _15284_/C VDD VSS _15247_/B NOR2BX1
X_12458_ _12544_/A _12544_/B _12544_/D _12544_/C VDD VSS _14345_/C AOI211X1
X_11409_ _11422_/A _17990_/B _11409_/C VDD VSS _18603_/D NOR3X1
X_15177_ _19399_/Q _15778_/B VDD VSS _15178_/C NOR2BX1
X_12389_ _12472_/A _12472_/B _12472_/C VDD VSS _12416_/B AOI21X1
XFILLER_113_402 VDD VSS FILLER4
XFILLER_140_210 VDD VSS DECAPHV8
X_14128_ _14142_/A _14128_/B VDD VSS _18887_/D NOR2X1
XFILLER_99_647 VDD VSS FILLER4
XFILLER_125_295 VSS VDD FILLER2
X_19985_ _19985_/CK _19985_/D _19985_/Q VDD VSS DFFQX1
XFILLER_113_446 VDD VSS FILLER4
XFILLER_113_457 VDD VSS DECAPHV8
XFILLER_113_468 VSS VDD FILLER2
XFILLER_101_619 VSS VDD FILLER2
XFILLER_97_80 VSS VDD FILLER2
X_18936_ _18961_/CK _18936_/D _18936_/Q VDD VSS DFFQX1
X_14059_ _14078_/B _14139_/C _18896_/Q VDD VSS _14060_/D AND3BX1
XFILLER_97_91 VSS VDD FILLER2
XFILLER_100_118 VSS VDD FILLER2
X_18867_ _18924_/CK _18867_/D _18867_/Q VDD VSS DFFQX1
XFILLER_67_544 VSS VDD FILLER2
XTAP_TAPCELL_ROW_146_1325 VDD VSS WELLTAP
XFILLER_67_555 VSS VDD FILLER2
X_17818_ _19927_/Q _19895_/Q _17818_/C VDD VSS _17823_/A AOI21X1
X_18798_ _18799_/CK _18798_/D _18798_/Q VDD VSS DFFQX1
XFILLER_82_514 VDD VSS FILLER4
XFILLER_48_780 VDD VSS DECAPHV8
XFILLER_82_547 VSS VDD FILLER2
X_17749_ _19913_/Q _19881_/Q VDD VSS _17752_/B XOR2X1
XFILLER_35_452 VSS VDD FILLER2
XFILLER_62_271 VDD VSS FILLER1
XTAP_TAPCELL_ROW_80_737 VDD VSS WELLTAP
X_19419_ _19466_/CK _19419_/D _19419_/Q VDD VSS DFFQX1
XFILLER_50_444 VDD VSS FILLER4
XFILLER_50_455 VDD VSS FILLER4
XFILLER_50_499 VSS VDD FILLER2
XFILLER_163_313 VSS VDD FILLER2
XFILLER_148_398 VDD VSS FILLER1
XFILLER_132_700 VSS VDD FILLER2
XFILLER_144_560 VSS VDD FILLER2
XFILLER_131_221 VSS VDD FILLER2
XFILLER_89_157 VDD VSS FILLER4
X_20125_ _20125_/A VDD VSS _20125_/Y BUFX3
XTAP_TAPCELL_ROW_88_804 VDD VSS WELLTAP
XFILLER_132_788 VSS VDD FILLER2
X_09936_ _11398_/B _11398_/C _11398_/A VDD VSS _11399_/C OAI21X1
X_20056_ clkload6/A _20056_/D _20057_/D _20071_/RB VDD VSS DFFRQX1
X_09867_ _18576_/Q _09947_/B VDD VSS _09867_/Y XOR2X1
XFILLER_100_652 VDD VSS FILLER4
XFILLER_85_363 VDD VSS DECAPHV8
XFILLER_93_27 VSS VDD FILLER2
X_09798_ _18470_/Q _09813_/B _09816_/D VDD VSS _09799_/E AO21X2
XTAP_TAPCELL_ROW_96_881 VDD VSS WELLTAP
XFILLER_93_49 VSS VDD FILLER2
XFILLER_73_547 VSS VDD FILLER2
XFILLER_45_249 VSS VDD FILLER2
XTAP_TAPCELL_ROW_108_982 VDD VSS WELLTAP
XFILLER_73_569 VSS VDD FILLER2
XTAP_TAPCELL_ROW_123_1122 VDD VSS WELLTAP
XFILLER_26_54 VDD VSS FILLER4
XFILLER_165_4 VDD VSS FILLER1
XFILLER_14_603 VDD VSS FILLER1
X_11760_ _19199_/Q _11760_/B _11760_/C VDD VSS _14456_/B XNOR3X1
XFILLER_26_76 VDD VSS FILLER4
XFILLER_53_271 VDD VSS FILLER1
X_10711_ _18641_/Q _18803_/Q VDD VSS _10715_/B NAND2X1
XFILLER_53_282 VSS VDD FILLER2
XFILLER_41_433 VSS VDD FILLER2
X_11691_ _19224_/Q _14517_/B VDD VSS _11737_/B NOR2X1
X_13430_ _13430_/A _13430_/B _13430_/C _13430_/D VDD VSS _13617_/A AOAI211X1
X_10642_ _10642_/A _10642_/B _10642_/C _10642_/D VDD VSS _10718_/B AOI31X1
XTAP_TAPCELL_ROW_51_472 VDD VSS WELLTAP
X_13361_ _13436_/A _13616_/D _13424_/C VDD VSS _13437_/C XNOR3X1
X_10573_ _18665_/Q _18773_/Q VDD VSS _10574_/A XNOR2X1
XFILLER_166_162 VDD VSS DECAPHV8
X_15100_ _15100_/A _15100_/B _15872_/B VDD VSS _15183_/A AOI21X1
X_12312_ _12312_/A _14468_/B _14468_/C VDD VSS _12313_/D NOR3X1
X_16080_ _16074_/A _16080_/B _16080_/C VDD VSS _16104_/B AOI2B1X1
X_13292_ _18913_/Q VDD VSS _13494_/A INVX1
XFILLER_154_346 VDD VSS FILLER1
XFILLER_108_763 VSS VDD FILLER2
X_15031_ _15037_/B _15031_/B VDD VSS _15683_/B XNOR2X1
X_12243_ _12307_/A _12373_/B _12373_/C VDD VSS _12471_/B XNOR3X1
XFILLER_123_711 VDD VSS FILLER1
X_12174_ _19180_/Q _14466_/B VDD VSS _12214_/C _14466_/C AND3X2
XFILLER_122_221 VSS VDD FILLER2
XFILLER_123_777 VDD VSS FILLER1
X_11125_ _11272_/A _11125_/B VDD VSS _18574_/D NOR2X1
X_19770_ clkload4/A _19770_/D _19770_/Q VDD VSS DFFQX1
X_16982_ _19752_/Q VDD VSS _17151_/B INVX1
XFILLER_49_500 VSS VDD FILLER2
XFILLER_110_427 VDD VSS DECAPHV16
XFILLER_95_127 VSS VDD FILLER2
XFILLER_3_58 VDD VSS FILLER4
X_18721_ _19947_/CK _18721_/D _18721_/Q VDD VSS DFFQX1
XFILLER_3_69 VDD VSS FILLER4
XFILLER_1_584 VDD VSS FILLER4
X_15933_ _19612_/Q _16764_/B VDD VSS _15948_/B XOR2X1
X_11056_ _11086_/B _11056_/B VDD VSS _18572_/D AND2X1
XFILLER_77_842 VDD VSS FILLER1
XFILLER_49_544 VDD VSS FILLER4
X_10007_ _18601_/Q _10010_/B VDD VSS _10008_/B XOR2X1
XFILLER_67_83 VDD VSS FILLER1
X_18652_ _19959_/CK _18652_/D _18652_/Q VDD VSS DFFQX1
X_15864_ _15867_/A _15864_/B VDD VSS _19473_/D NOR2X1
XFILLER_64_514 VSS VDD FILLER2
X_17603_ _17606_/C _17604_/B _17654_/C VDD VSS _17604_/C OAI21X1
X_14815_ _14865_/A _14817_/C VDD VSS _15832_/B XNOR2X1
XFILLER_92_856 VDD VSS FILLER1
X_18583_ _18583_/CK _18583_/D _18583_/Q VDD VSS DFFQX1
XFILLER_64_558 VSS VDD FILLER2
X_15795_ _15849_/A _15795_/B VDD VSS _19413_/D AND2X1
XFILLER_91_355 VSS VDD FILLER2
XFILLER_17_441 VDD VSS FILLER4
X_17534_ _19866_/Q _19834_/Q _17535_/C VDD VSS _17536_/B AOI21X1
XFILLER_45_772 VSS VDD FILLER2
X_14746_ _14746_/A _14746_/B _14746_/C _14746_/D VDD VSS _14872_/B AOAI211X1
X_11958_ _11962_/A _11962_/B _11958_/C VDD VSS _14336_/B XNOR3X1
XFILLER_91_399 VSS VDD FILLER2
XFILLER_45_794 VDD VSS FILLER4
X_17465_ _17468_/A _17465_/B _17465_/C VDD VSS _19851_/D AOI21X1
X_10909_ _10927_/C _10909_/B _10909_/C _10909_/D VDD VSS _10910_/D OAI211X1
X_14677_ _14710_/A _14710_/B VDD VSS _14683_/B NOR2X1
X_11889_ _11981_/C _11980_/B _11980_/C VDD VSS _12048_/B XNOR3X1
XFILLER_60_764 VDD VSS DECAPHV8
X_19204_ _19995_/CK _19204_/D _19204_/Q VDD VSS DFFQX1
X_16416_ _16409_/A _16416_/B VDD VSS _16437_/B NOR2BX1
XTAP_TAPCELL_ROW_14_141 VDD VSS WELLTAP
X_13628_ _13716_/A _13716_/B VDD VSS _13643_/B NOR2X1
X_17396_ _17675_/A _17396_/B VDD VSS _19837_/D NOR2X1
X_19135_ _19139_/CK _19135_/D _19135_/Q VDD VSS DFFQX1
XFILLER_118_505 VDD VSS FILLER4
X_16347_ _16348_/A _16348_/B _16348_/D _16348_/C VDD VSS _16390_/B AOAI211X1
X_13559_ _14482_/A _14482_/B _13559_/C VDD VSS _13637_/C AOI21X1
XFILLER_158_685 VDD VSS FILLER4
XFILLER_145_313 VDD VSS DECAPHV16
XFILLER_118_549 VSS VDD FILLER2
X_19066_ _19068_/CK _19066_/D _19066_/Q VDD VSS DFFQX1
XFILLER_157_184 VSS VDD FILLER2
X_16278_ _16278_/A _16278_/B _16850_/B VDD VSS _16299_/A MIN3X1
XFILLER_157_195 VDD VSS FILLER1
XFILLER_145_346 VSS VDD FILLER2
X_18017_ _18049_/B VDD VSS _18045_/B BUFX3
X_15229_ _19484_/Q _15876_/B VDD VSS _15243_/D NAND2X1
XFILLER_114_700 VDD VSS FILLER4
XFILLER_99_422 VDD VSS FILLER1
XTAP_TAPCELL_ROW_152_1384 VDD VSS WELLTAP
XFILLER_114_744 VDD VSS FILLER4
XFILLER_99_455 VDD VSS FILLER1
XFILLER_59_308 VDD VSS FILLER1
XFILLER_141_574 VDD VSS FILLER4
X_19968_ _19985_/CK _19968_/D _19968_/Q VDD VSS DFFQX1
XFILLER_86_116 VDD VSS FILLER4
XFILLER_86_127 VSS VDD FILLER2
X_09721_ _20110_/A _20126_/A _09773_/D VDD VSS _09722_/C MUX2X1
X_18919_ _18973_/CK _18919_/D _18919_/Q VDD VSS DFFQX1
X_19899_ clkload2/A _19899_/D _19899_/Q VDD VSS DFFQX1
Xclkbuf_2_0__f__000_ clkbuf_0__000_/Y VDD VSS clkbuf_leaf_6__000_/A BUFX12
XFILLER_67_352 VSS VDD FILLER2
XFILLER_83_812 VDD VSS FILLER4
XFILLER_55_503 VSS VDD FILLER2
X_09652_ _18413_/Q VDD VSS _20168_/A INVX1
XFILLER_95_683 VDD VSS DECAPHV8
XFILLER_82_300 VDD VSS FILLER4
X_09583_ _18457_/Q VDD VSS _20099_/A INVX1
XFILLER_103_59 VSS VDD FILLER2
XTAP_TAPCELL_ROW_93_851 VDD VSS WELLTAP
XFILLER_82_355 VSS VDD FILLER2
XTAP_TAPCELL_ROW_163_1480 VDD VSS WELLTAP
XFILLER_82_388 VSS VDD FILLER2
XFILLER_35_260 VSS VDD FILLER2
XTAP_TAPCELL_ROW_65_597 VDD VSS WELLTAP
XFILLER_51_731 VSS VDD FILLER2
XFILLER_35_282 VDD VSS FILLER4
XFILLER_51_742 VSS VDD FILLER2
XFILLER_35_293 VSS VDD FILLER2
XFILLER_50_230 VSS VDD FILLER2
XFILLER_23_455 VSS VDD FILLER2
XFILLER_50_252 VDD VSS FILLER4
XFILLER_149_630 VSS VDD FILLER2
XFILLER_51_797 VSS VDD FILLER2
XFILLER_137_8 VSS VDD FILLER2
XFILLER_148_151 VDD VSS FILLER1
XFILLER_148_162 VSS VDD FILLER2
XFILLER_149_696 VDD VSS DECAPHV8
XFILLER_109_538 VSS VDD FILLER2
XFILLER_148_184 VSS VDD FILLER2
XFILLER_136_346 VSS VDD FILLER2
XFILLER_164_666 VSS VDD FILLER2
XFILLER_128_45 VDD VSS FILLER1
XFILLER_105_700 VSS VDD FILLER2
XFILLER_128_67 VDD VSS FILLER4
XFILLER_152_839 VDD VSS FILLER1
XFILLER_117_571 VDD VSS FILLER4
XFILLER_104_210 VSS VDD FILLER2
XFILLER_105_733 VSS VDD FILLER2
XFILLER_88_49 VSS VDD FILLER2
XFILLER_163_198 VSS VDD FILLER2
XFILLER_132_530 VDD VSS FILLER1
XFILLER_151_349 VDD VSS FILLER1
XFILLER_2_337 VSS VDD FILLER2
XFILLER_144_390 VSS VDD FILLER2
XFILLER_105_777 VSS VDD FILLER2
XFILLER_104_265 VDD VSS FILLER4
XTAP_TAPCELL_ROW_166_1509 VDD VSS WELLTAP
XFILLER_77_127 VSS VDD FILLER2
XFILLER_120_747 VDD VSS FILLER4
XFILLER_144_66 VSS VDD FILLER2
X_20108_ _20108_/A VDD VSS _20108_/Y BUFX3
X_09919_ _09944_/A _09919_/B VDD VSS _09920_/C NAND2X1
XFILLER_58_341 VDD VSS DECAPHV16
XFILLER_92_108 VSS VDD FILLER2
X_20039_ _20045_/CK _20039_/D _20039_/Q _20045_/RB VDD VSS DFFRQX1
X_12930_ _19161_/Q VDD VSS _13028_/A INVX1
XFILLER_86_672 VSS VDD FILLER2
XFILLER_46_514 VSS VDD FILLER2
XFILLER_18_205 VSS VDD FILLER2
XFILLER_58_385 VSS VDD FILLER2
XFILLER_85_171 VDD VSS DECAPHV8
XFILLER_58_396 VSS VDD FILLER2
XTAP_TAPCELL_ROW_56_520 VDD VSS WELLTAP
XFILLER_85_193 VDD VSS FILLER1
X_12861_ _12932_/A _12932_/B _12932_/C VDD VSS _12925_/C OAI21X1
XFILLER_73_344 VDD VSS FILLER4
XFILLER_18_249 VSS VDD FILLER2
XFILLER_61_506 VSS VDD FILLER2
X_14600_ _19495_/Q _15888_/B VDD VSS _14624_/A AND2X1
X_11812_ _19090_/Q _11864_/B _11816_/C VDD VSS _14334_/B XNOR3X1
X_15580_ _19410_/Q _15791_/B VDD VSS _15597_/B NOR2X1
XTAP_TAPCELL_ROW_28_266 VDD VSS WELLTAP
XFILLER_33_219 VDD VSS FILLER4
X_12792_ _18909_/Q VDD VSS _12886_/A INVX1
XFILLER_42_731 VSS VDD FILLER2
X_14531_ _14522_/Y _14531_/B _14531_/C VDD VSS _19237_/D AND3BX1
XFILLER_156_0 VDD VSS FILLER4
X_11743_ _11769_/A _11769_/B VDD VSS _14520_/B XNOR2X1
XFILLER_42_764 VSS VDD FILLER2
XFILLER_41_252 VDD VSS FILLER4
XFILLER_14_477 VSS VDD FILLER2
X_17250_ _17252_/B _17250_/B VDD VSS _17251_/B XOR2X1
XFILLER_14_488 VDD VSS FILLER1
X_14462_ _14490_/A _14462_/B _14462_/C VDD VSS _19176_/D NOR3X1
X_11674_ _17812_/A VDD VSS _16704_/B BUFX3
XFILLER_53_96 VDD VSS DECAPHV8
X_16201_ _16201_/A _16201_/B _16847_/B VDD VSS _16219_/A MIN3X1
X_13413_ _14323_/B _14322_/C _19052_/Q VDD VSS _13415_/C AO21X2
XTAP_TAPCELL_ROW_11_111 VDD VSS WELLTAP
X_17181_ _19791_/Q _19759_/Q VDD VSS _17183_/B XOR2X1
X_10625_ _10625_/A VDD VSS _11120_/A BUFX3
XFILLER_128_825 VSS VDD FILLER2
X_14393_ _14393_/A _14393_/B VDD VSS _19115_/D NOR2X1
XFILLER_127_313 VDD VSS FILLER4
XFILLER_139_173 VSS VDD FILLER2
X_16132_ _19619_/Q VDD VSS _16133_/A INVX1
X_13344_ _13345_/A _13345_/B _13345_/D _13345_/C VDD VSS _14544_/A OA211X2
X_10556_ _10556_/A _10556_/B _10556_/C _10556_/D VDD VSS _10633_/B AOAI211X1
X_16063_ _19553_/Q _19905_/Q VDD VSS _16064_/B XNOR2X1
XFILLER_154_165 VSS VDD FILLER2
XFILLER_108_560 VSS VDD FILLER2
X_13275_ _13406_/A _13406_/B VDD VSS _14292_/B XNOR2X1
X_10487_ _10521_/A _10521_/B _10521_/C _10487_/D VDD VSS _10496_/B AOAI211X1
XFILLER_5_164 VDD VSS FILLER4
XFILLER_108_593 VSS VDD FILLER2
X_15014_ _19504_/Q _15898_/B VDD VSS _15017_/A NOR2BX1
X_09974__245 _20080_/CK VDD VSS _18521_/CK INVX1
X_12226_ _12329_/A _12329_/B _12329_/E VDD VSS _12303_/B OAI21X1
XFILLER_151_850 VDD VSS FILLER4
XFILLER_69_606 VSS VDD FILLER2
X_19822_ _19825_/CK _19822_/D _19822_/Q VDD VSS DFFQX1
X_12157_ _12158_/A _12158_/B _12158_/D _12158_/C VDD VSS _12401_/B OAOI211X1
XFILLER_68_116 VDD VSS FILLER4
XFILLER_111_736 VDD VSS DECAPHV8
XFILLER_111_747 VSS VDD FILLER2
X_11108_ _18680_/Q _18788_/Q VDD VSS _11132_/D NOR2X1
XFILLER_1_370 VSS VDD FILLER2
XFILLER_110_235 VSS VDD FILLER2
X_16965_ _16971_/A _16968_/C _17081_/C VDD VSS _16966_/C OAI21X1
X_19753_ _19785_/CK _19753_/D _19753_/Q VDD VSS DFFQX1
X_12088_ _12149_/A _12149_/B VDD VSS _12119_/B NOR2X1
XFILLER_49_330 VSS VDD FILLER2
XFILLER_1_392 VSS VDD FILLER2
XFILLER_96_469 VSS VDD FILLER2
X_15916_ _15923_/A _15923_/B VDD VSS _16728_/B XNOR2X1
X_18704_ _18785_/CK _18704_/D _18704_/Q VDD VSS DFFQX1
X_11039_ _11070_/C _11040_/B _11039_/C VDD VSS _11040_/C OAI21X1
X_19684_ _19696_/CK _19684_/D _19684_/Q VDD VSS DFFQX1
XFILLER_37_514 VSS VDD FILLER2
X_16896_ _16899_/A _16896_/B VDD VSS _19731_/D AND2X1
XFILLER_76_182 VSS VDD FILLER2
X_18635_ _19943_/CK _18635_/D _18635_/Q VDD VSS DFFQX1
X_15847_ _16776_/A VDD VSS _15867_/A BUFX3
XFILLER_94_81 VDD VSS FILLER4
XFILLER_94_92 VSS VDD FILLER2
XFILLER_91_152 VDD VSS FILLER1
XFILLER_64_366 VSS VDD FILLER2
X_18566_ _18578_/CK _18566_/D _18566_/Q VDD VSS DFFQX1
X_15778_ _15780_/A _15778_/B VDD VSS _19399_/D NOR2X1
XTAP_TAPCELL_ROW_90_821 VDD VSS WELLTAP
XFILLER_17_260 VDD VSS FILLER4
XFILLER_91_196 VSS VDD FILLER2
XFILLER_17_282 VDD VSS FILLER4
X_17517_ _17517_/A _17517_/B _17517_/C VDD VSS _17522_/A OA21X2
XFILLER_33_742 VSS VDD FILLER2
X_14729_ _19417_/Q VDD VSS _14730_/A INVX1
X_18497_ _18503_/CK _18497_/D _20110_/A _18498_/RB VDD VSS DFFRQX1
XFILLER_32_230 VSS VDD FILLER2
Xclkbuf_leaf_40__001_ clkbuf_leaf_4__001_/A VDD VSS _20007_/CK BUFX12
XTAP_TAPCELL_ROW_62_567 VDD VSS WELLTAP
XTAP_TAPCELL_ROW_102_933 VDD VSS WELLTAP
XFILLER_32_252 VSS VDD FILLER2
X_17448_ _17448_/A _17450_/C _17448_/C VDD VSS _19848_/D AOI21X1
XFILLER_32_274 VSS VDD FILLER2
XFILLER_32_296 VDD VSS FILLER4
XFILLER_20_447 VDD VSS FILLER1
XFILLER_165_419 VDD VSS FILLER4
X_17379_ _17379_/A _17379_/B VDD VSS _17380_/B XNOR2X1
XTAP_TAPCELL_ROW_154_1402 VDD VSS WELLTAP
XFILLER_119_836 VDD VSS FILLER1
XFILLER_71_0 VDD VSS FILLER4
XFILLER_158_482 VDD VSS DECAPHV8
XFILLER_118_324 VDD VSS FILLER1
X_19118_ _19196_/CK _19118_/D _19118_/Q VDD VSS DFFQX1
XFILLER_134_817 VSS VDD FILLER2
X_19049_ _19072_/CK _19049_/D _19049_/Q VDD VSS DFFQX1
XFILLER_134_839 VDD VSS FILLER1
XFILLER_145_165 VSS VDD FILLER2
XFILLER_99_230 VDD VSS FILLER4
XFILLER_0_808 VSS VDD FILLER2
XFILLER_0_819 VSS VDD FILLER2
XFILLER_99_252 VSS VDD FILLER2
XFILLER_114_585 VSS VDD FILLER2
XFILLER_141_371 VDD VSS FILLER1
XFILLER_56_801 VDD VSS FILLER1
X_09704_ _18384_/Q VDD VSS _20189_/A INVX1
XFILLER_74_119 VSS VDD FILLER2
XFILLER_28_514 VSS VDD FILLER2
XFILLER_56_834 VDD VSS FILLER4
XFILLER_56_856 VDD VSS FILLER1
X_09635_ _09635_/A _09635_/B _09635_/C VDD VSS _09636_/D OA21X2
X_09566_ _18505_/Q _09630_/C _18506_/Q VDD VSS _09815_/B AND3BX1
XFILLER_55_388 VDD VSS FILLER1
XFILLER_36_580 VDD VSS FILLER4
XFILLER_82_196 VSS VDD FILLER2
XFILLER_130_57 VDD VSS FILLER4
XTAP_TAPCELL_ROW_25_236 VDD VSS WELLTAP
X_09497_ _18445_/D _09501_/B _09497_/C VDD VSS _18236_/D AOI21X1
XFILLER_24_764 VDD VSS FILLER4
XFILLER_51_561 VSS VDD FILLER2
XFILLER_24_786 VDD VSS FILLER4
XFILLER_23_11 VSS VDD FILLER2
XFILLER_51_583 VSS VDD FILLER2
XFILLER_24_797 VDD VSS FILLER1
XFILLER_23_274 VDD VSS FILLER4
XFILLER_109_302 VSS VDD FILLER2
XFILLER_139_33 VSS VDD FILLER2
XFILLER_7_429 VDD VSS FILLER4
X_10410_ _18688_/Q _18742_/Q VDD VSS _10411_/A XNOR2X1
XFILLER_109_335 VSS VDD FILLER2
X_11390_ _18594_/Q _11390_/B VDD VSS _11392_/C NOR2BX1
X_09958__229 _20052_/CK VDD VSS _18505_/CK INVX1
X_10341_ _19938_/Q _18820_/Q VDD VSS _10343_/C AND2X1
XFILLER_124_316 VSS VDD FILLER2
XFILLER_136_176 VSS VDD FILLER2
XTAP_TAPCELL_ROW_118_1076 VDD VSS WELLTAP
X_13060_ _13061_/B _13061_/C _19218_/Q VDD VSS _13131_/B AOI21X1
XFILLER_151_135 VDD VSS FILLER1
X_10272_ _18551_/Q _10306_/A VDD VSS _10272_/Y NOR2X1
XFILLER_152_669 VDD VSS FILLER4
X_12011_ _19011_/Q VDD VSS _14239_/A INVX1
XFILLER_132_371 VSS VDD FILLER2
XFILLER_78_425 VSS VDD FILLER2
XFILLER_120_522 VDD VSS FILLER4
XFILLER_160_691 VDD VSS FILLER4
XFILLER_93_406 VDD VSS FILLER4
X_16750_ _16759_/A _16750_/B VDD VSS _19599_/D NOR2X1
XFILLER_59_672 VDD VSS FILLER4
X_13962_ _13965_/A _13965_/C _13965_/B _13962_/D VDD VSS _14302_/B AOAI211X1
XFILLER_93_428 VSS VDD FILLER2
XFILLER_48_85 VSS VDD FILLER2
XFILLER_74_620 VSS VDD FILLER2
XFILLER_19_536 VDD VSS FILLER4
X_15701_ _15710_/A _15701_/B VDD VSS _19329_/D NOR2X1
XFILLER_19_547 VSS VDD FILLER2
X_12913_ _12913_/A _14348_/B _12913_/C _12913_/D VDD VSS _13102_/A AOAI211X1
XTAP_TAPCELL_ROW_129_1172 VDD VSS WELLTAP
X_16681_ _16681_/A _16681_/B VDD VSS _16796_/B XNOR2X1
XFILLER_74_653 VDD VSS FILLER1
XFILLER_73_130 VSS VDD FILLER2
XFILLER_0_48 VSS VDD FILLER2
X_13893_ _13921_/A _13921_/B _13921_/D _13921_/C VDD VSS _14198_/B OAOI211X1
XFILLER_46_355 VDD VSS FILLER4
XFILLER_104_80 VDD VSS FILLER1
XFILLER_46_366 VDD VSS FILLER4
XFILLER_34_506 VDD VSS FILLER4
XFILLER_0_59 VSS VDD FILLER2
X_18420_ _18422_/CK _18521_/Q _20175_/A _18450_/RB VDD VSS DFFRQX1
XFILLER_62_826 VSS VDD FILLER2
X_15632_ _15635_/B _15632_/B VDD VSS _18174_/B XNOR2X1
XFILLER_73_163 VSS VDD FILLER2
XFILLER_46_377 VDD VSS FILLER1
X_12844_ _12953_/A _14475_/B VDD VSS _13032_/B NOR2X1
X_18351_ _18357_/CK _18351_/D _18351_/Q _18491_/RB VDD VSS DFFRQX1
XFILLER_61_347 VSS VDD FILLER2
XFILLER_15_742 VSS VDD FILLER2
XFILLER_14_230 VSS VDD FILLER2
X_15563_ _15563_/A _15697_/B VDD VSS _15564_/D OR2X2
X_12775_ _19104_/Q _12775_/B _12910_/D VDD VSS _12821_/C XNOR3X1
X_17302_ _17305_/C _17303_/B _17306_/C VDD VSS _17303_/C OAI21X1
XFILLER_15_775 VSS VDD FILLER2
XFILLER_159_213 VSS VDD FILLER2
X_14514_ _14491_/Y _14514_/B _14514_/C VDD VSS _19221_/D AND3BX1
X_18282_ _18288_/CK _18282_/D _18282_/Q VDD VSS DFFQX1
X_11726_ _11751_/A _11778_/A _11769_/B VDD VSS _11745_/D XNOR3X1
X_15494_ _19351_/Q _15725_/B VDD VSS _15504_/B XOR2X1
X_17233_ _19802_/Q _19770_/Q _17233_/C VDD VSS _19802_/D AOI21X1
X_14445_ _14456_/A _14445_/B VDD VSS _19161_/D NOR2X1
X_11657_ _18797_/Q _11658_/B VDD VSS _18824_/D AND2X1
XFILLER_128_611 VSS VDD FILLER2
XFILLER_30_789 VDD VSS FILLER1
X_17164_ _17168_/A _17165_/B _17164_/C VDD VSS _17165_/C OAI21X1
X_10608_ _18665_/Q _18773_/Q VDD VSS _10642_/A NAND2X1
X_14376_ _14316_/Y _14376_/B _14376_/C VDD VSS _19099_/D AND3BX1
X_11588_ _18734_/Q _11589_/B VDD VSS _18761_/D AND2X1
X_16115_ _16134_/A _16736_/B VDD VSS _16116_/B XNOR2X1
XFILLER_155_463 VSS VDD FILLER2
X_13327_ _14479_/B _14479_/C _19192_/Q VDD VSS _13331_/B AOI21X1
XFILLER_143_625 VSS VDD FILLER2
X_17095_ _17095_/A _17095_/B VDD VSS _19773_/D NOR2X1
X_10539_ _10843_/A _10844_/B _10844_/C _10960_/A VDD VSS _10548_/C AOI211X1
XFILLER_127_176 VSS VDD FILLER2
X_16046_ _19680_/Q _16840_/B VDD VSS _16055_/C NOR2X1
X_13258_ _13347_/A _14513_/B VDD VSS _13263_/B NOR2X1
X_12209_ _19097_/Q _14374_/B VDD VSS _12300_/A NOR2BX1
XFILLER_97_723 VSS VDD FILLER2
X_13189_ _18940_/Q _14190_/B VDD VSS _13290_/D _14190_/C NAND3X1
XFILLER_123_382 VSS VDD FILLER2
XFILLER_69_436 VDD VSS FILLER4
X_19805_ _19841_/CK _19805_/D _19805_/Q VDD VSS DFFQX1
XFILLER_96_244 VSS VDD FILLER2
X_17997_ _18538_/Q _18539_/Q VDD VSS _18038_/B _18036_/B AND3X2
XFILLER_29_2 VDD VSS FILLER1
XFILLER_84_406 VSS VDD FILLER2
X_16948_ _17114_/B _17062_/C _16948_/C VDD VSS _16953_/C MIN3X1
X_19736_ _19736_/CK _19736_/D _19736_/Q VDD VSS DFFQX1
XTAP_TAPCELL_ROW_67_615 VDD VSS WELLTAP
XFILLER_96_288 VDD VSS FILLER4
XFILLER_84_439 VSS VDD FILLER2
XFILLER_38_834 VSS VDD FILLER2
X_16879_ _16891_/A _16879_/B VDD VSS _19715_/D NOR2X1
X_19667_ _19667_/CK _19667_/D _19667_/Q VDD VSS DFFQX1
X_09420_ output5/A _18201_/A VDD VSS _09421_/C NOR2X1
XFILLER_53_826 VSS VDD FILLER2
XFILLER_25_517 VSS VDD FILLER2
X_18618_ _18622_/CK _18618_/D _18618_/Q VDD VSS DFFQX1
XFILLER_80_623 VSS VDD FILLER2
X_19598_ _19600_/CK _19598_/D _19598_/Q VDD VSS DFFQX1
XFILLER_92_483 VDD VSS FILLER1
XFILLER_92_494 VDD VSS FILLER4
XTAP_TAPCELL_ROW_75_692 VDD VSS WELLTAP
XTAP_TAPCELL_ROW_160_1450 VDD VSS WELLTAP
XFILLER_80_645 VSS VDD FILLER2
X_09351_ _09414_/D _09351_/B _09351_/C VDD VSS _09351_/Y NOR3X1
XFILLER_80_667 VSS VDD FILLER2
X_18549_ _18550_/CK _18549_/D _18549_/Q VDD VSS DFFQX1
XFILLER_52_369 VSS VDD FILLER2
XFILLER_80_689 VDD VSS FILLER1
XFILLER_33_561 VSS VDD FILLER2
X_09282_ _09362_/B _18258_/Q VDD VSS _09283_/D NAND2X1
XFILLER_100_38 VDD VSS FILLER1
XFILLER_33_583 VSS VDD FILLER2
XFILLER_100_49 VDD VSS DECAPHV16
XFILLER_166_717 VSS VDD FILLER2
XFILLER_20_299 VSS VDD FILLER2
XFILLER_146_452 VSS VDD FILLER2
XTAP_TAPCELL_ROW_30_283 VDD VSS WELLTAP
XFILLER_118_154 VSS VDD FILLER2
XFILLER_109_47 VSS VDD FILLER2
XFILLER_106_316 VSS VDD FILLER2
Xclkload70 clkload70/A VDD VSS clkload70/Y BUFX12
XFILLER_69_29 VDD VSS FILLER1
XFILLER_122_809 VSS VDD FILLER2
Xclkload81 _19528_/CK VDD VSS clkload81/Y INVX2
Xclkload92 _19724_/CK VDD VSS clkload92/Y INVX1
XFILLER_133_168 VDD VSS FILLER4
XFILLER_0_605 VSS VDD FILLER2
XFILLER_0_627 VSS VDD FILLER2
XFILLER_102_522 VDD VSS FILLER4
XFILLER_0_649 VSS VDD FILLER2
XFILLER_102_533 VDD VSS DECAPHV8
XFILLER_114_393 VDD VSS FILLER1
XFILLER_88_756 VDD VSS FILLER4
XFILLER_87_277 VSS VDD FILLER2
XFILLER_87_299 VSS VDD FILLER2
XFILLER_68_480 VSS VDD FILLER2
XFILLER_18_22 VSS VDD FILLER2
XFILLER_141_12 VSS VDD FILLER2
XFILLER_18_44 VSS VDD FILLER2
XFILLER_141_23 VSS VDD FILLER2
XFILLER_141_67 VSS VDD FILLER2
X_09618_ _09618_/A _09618_/B VDD VSS _18282_/D NAND2X1
X_10890_ _19953_/Q _18835_/Q _10890_/C VDD VSS _10931_/A MIN3X1
XFILLER_83_494 VSS VDD FILLER2
XFILLER_43_336 VDD VSS FILLER4
XFILLER_34_10 VSS VDD FILLER2
X_09549_ _20043_/Q _18201_/A VDD VSS _20044_/D NOR2BX1
XFILLER_43_369 VSS VDD FILLER2
XFILLER_34_32 VDD VSS DECAPHV8
XFILLER_70_166 VDD VSS FILLER4
XFILLER_12_712 VSS VDD FILLER2
X_12560_ _19184_/Q _14471_/B VDD VSS _12561_/A NAND2X1
XFILLER_12_734 VDD VSS DECAPHV8
XFILLER_11_222 VDD VSS FILLER1
XTAP_TAPCELL_ROW_5_58 VDD VSS WELLTAP
XFILLER_157_717 VSS VDD FILLER2
X_11511_ _18664_/Q _11519_/B VDD VSS _18691_/D AND2X1
XFILLER_133_2 VDD VSS FILLER1
X_12491_ _12566_/A _12566_/B _12566_/D VDD VSS _12503_/B OAI21X1
XFILLER_11_266 VDD VSS FILLER4
XFILLER_12_789 VDD VSS FILLER1
XFILLER_8_738 VDD VSS FILLER4
XFILLER_11_277 VSS VDD FILLER2
X_14230_ _14136_/Y _14230_/B _14230_/C VDD VSS _18975_/D AND3BX1
XFILLER_109_121 VSS VDD FILLER2
XFILLER_149_290 VSS VDD FILLER2
X_11442_ _19937_/Q _17990_/A VDD VSS _18630_/D AND2X1
Xwire168 wire168/A VDD VSS wire168/Y BUFX8
XFILLER_166_31 VDD VSS FILLER4
XFILLER_137_463 VSS VDD FILLER2
XFILLER_119_0 VSS VDD FILLER2
XFILLER_137_474 VSS VDD FILLER2
X_14161_ _14197_/A _14161_/B VDD VSS _18915_/D AND2X1
X_11373_ _11379_/A _11373_/B _11379_/C _18592_/Q VDD VSS _11381_/A AOI211X1
XFILLER_166_42 VSS VDD FILLER2
XFILLER_165_794 VDD VSS FILLER4
XFILLER_125_647 VDD VSS FILLER4
X_13112_ _19135_/Q _13315_/A _13315_/B VDD VSS _13113_/D XNOR3X1
X_10324_ _10965_/A _18713_/Q VDD VSS _10325_/D NAND2X1
XFILLER_125_658 VSS VDD FILLER2
XFILLER_124_146 VDD VSS FILLER1
X_14092_ _14093_/A _14093_/B _14093_/D _14093_/C VDD VSS _17975_/B OA211X2
XFILLER_106_850 VSS VDD FILLER2
XFILLER_3_443 VDD VSS FILLER4
XFILLER_112_308 VDD VSS FILLER4
XFILLER_140_617 VDD VSS FILLER4
XFILLER_1_0 VSS VDD FILLER2
XFILLER_140_628 VDD VSS FILLER4
X_17920_ _17920_/A _17920_/B VDD VSS _17921_/B NOR2X1
X_13043_ _19190_/Q _14477_/B VDD VSS _13138_/A NOR2BX1
X_10255_ _10315_/A _10315_/B _10315_/C _10315_/D VDD VSS _10655_/A NOR4X2
XFILLER_140_639 VDD VSS FILLER4
XFILLER_59_51 VDD VSS FILLER1
XFILLER_79_734 VSS VDD FILLER2
XFILLER_3_498 VSS VDD FILLER2
X_17851_ _17853_/C _17851_/B _17851_/C VDD VSS _19938_/D AOI21X1
X_10186_ _13177_/A _11422_/C VDD VSS _18544_/D NOR2X1
XFILLER_78_244 VDD VSS FILLER4
XFILLER_78_266 VSS VDD FILLER2
X_16802_ _16811_/A _16802_/B VDD VSS _19645_/D NOR2X1
XFILLER_78_277 VDD VSS FILLER1
XFILLER_66_417 VDD VSS FILLER1
XFILLER_93_203 VSS VDD FILLER2
X_17782_ _17785_/A _17785_/B _17828_/C VDD VSS _17783_/C OAI21X1
X_14994_ _15003_/A _15805_/B _14995_/C VDD VSS _15806_/B AOI21BX1
XFILLER_93_225 VSS VDD FILLER2
XFILLER_47_631 VSS VDD FILLER2
X_16733_ _16735_/A _16733_/B VDD VSS _19584_/D NOR2X1
X_19521_ _19536_/CK _19521_/D _19521_/Q VDD VSS DFFQX1
X_13945_ _18976_/Q _14231_/B VDD VSS _14001_/A NAND2X1
XFILLER_75_72 VDD VSS DECAPHV8
X_19452_ _19484_/CK _19452_/D _19452_/Q VDD VSS DFFQX1
X_16664_ _16670_/B _16664_/B VDD VSS _16901_/B XNOR2X1
XFILLER_47_697 VSS VDD FILLER2
XFILLER_34_314 VDD VSS FILLER1
X_13876_ _13876_/A _14131_/B _13876_/C VDD VSS _14133_/B AOI21X1
XFILLER_46_185 VSS VDD FILLER2
XFILLER_46_196 VSS VDD FILLER2
X_15615_ _19355_/Q _15730_/B VDD VSS _15617_/B NOR2X1
X_18403_ _18406_/CK _18403_/D _18403_/Q _18422_/RB VDD VSS DFFRQX1
XFILLER_34_347 VDD VSS FILLER4
X_19383_ _19412_/CK _19383_/D _19383_/Q VDD VSS DFFQX1
X_12827_ _12827_/A _12827_/B _12827_/C _12827_/D VDD VSS _13036_/B AOAI211X1
X_16595_ _16582_/A _16595_/B _16595_/C VDD VSS _16621_/B AOI2B1X1
XFILLER_22_509 VSS VDD FILLER2
XTAP_TAPCELL_ROW_72_662 VDD VSS WELLTAP
XFILLER_15_561 VSS VDD FILLER2
X_18334_ _18343_/CK _18494_/D _20088_/A _18374_/RB VDD VSS DFFRQX1
XFILLER_91_60 VDD VSS FILLER4
X_15546_ _19464_/Q _15853_/B _15546_/C VDD VSS _15574_/B AOI21X1
X_12758_ _14537_/B _14537_/C _12759_/A VDD VSS _12835_/D OAI21X1
XFILLER_148_717 VSS VDD FILLER2
X_18265_ _18268_/CK _18265_/D _18265_/Q _20078_/RB VDD VSS DFFRQX1
X_11709_ _19226_/Q _11709_/B _11724_/C VDD VSS _11768_/B XNOR3X1
XFILLER_30_553 VDD VSS FILLER4
X_15477_ _19518_/Q _15913_/B VDD VSS _15478_/B XNOR2X1
X_12689_ _19075_/Q _12689_/B _12804_/D VDD VSS _12731_/C XNOR3X1
X_17216_ _17536_/A _17216_/B _17217_/C VDD VSS _19798_/D NOR3X1
XFILLER_128_430 VSS VDD FILLER2
X_14428_ _14457_/A VDD VSS _14456_/A BUFX3
X_18196_ _18196_/A _18196_/B VDD VSS _20013_/D NOR2X1
XFILLER_162_208 VDD VSS FILLER1
X_17147_ _19783_/Q _19751_/Q _17147_/C VDD VSS _17151_/C MIN3X1
XFILLER_116_625 VDD VSS FILLER1
X_14359_ _14415_/A _14359_/B VDD VSS _19083_/D AND2X1
XFILLER_115_102 VDD VSS DECAPHV8
XFILLER_143_411 VSS VDD FILLER2
XFILLER_7_793 VDD VSS FILLER4
XFILLER_155_282 VSS VDD FILLER2
XFILLER_104_809 VSS VDD FILLER2
X_17078_ _19769_/Q _17078_/B VDD VSS _17079_/B XNOR2X1
XFILLER_115_168 VSS VDD FILLER2
XFILLER_131_628 VDD VSS FILLER4
X_16029_ _19679_/Q _16838_/B VDD VSS _16030_/C NOR2X1
XFILLER_130_116 VSS VDD FILLER2
XTAP_TAPCELL_ROW_149_1356 VDD VSS WELLTAP
XFILLER_69_277 VSS VDD FILLER2
XFILLER_57_417 VDD VSS FILLER1
XFILLER_111_385 VDD VSS FILLER1
X_19719_ _19724_/CK _19719_/D _19719_/Q VDD VSS DFFQX1
XFILLER_38_653 VDD VSS FILLER4
XFILLER_26_815 VDD VSS FILLER1
XFILLER_93_770 VDD VSS FILLER1
XFILLER_53_601 VSS VDD FILLER2
XFILLER_38_686 VDD VSS FILLER1
XFILLER_25_303 VDD VSS FILLER1
XFILLER_53_623 VSS VDD FILLER2
XFILLER_1_91 VSS VDD FILLER2
X_09403_ _09387_/B _18629_/Q _11429_/B VDD VSS _11440_/B AOI2B1X1
XTAP_TAPCELL_ROW_35_331 VDD VSS WELLTAP
XFILLER_25_369 VSS VDD FILLER2
XFILLER_41_829 VDD VSS FILLER1
XFILLER_53_689 VDD VSS DECAPHV8
X_09334_ _09380_/B _09362_/B VDD VSS _09334_/Y NOR2BX1
XFILLER_40_328 VDD VSS FILLER4
XFILLER_166_514 VSS VDD FILLER2
X_09265_ _09354_/B _09296_/A _09265_/C VDD VSS _09273_/A OAI21X1
XFILLER_119_430 VDD VSS FILLER4
X_09196_ _18515_/Q VDD VSS _18446_/D INVX1
XFILLER_147_772 VSS VDD FILLER2
XFILLER_107_614 VSS VDD FILLER2
XFILLER_153_219 VSS VDD FILLER2
XFILLER_119_485 VDD VSS DECAPHV8
XFILLER_134_411 VDD VSS FILLER4
XFILLER_106_113 VSS VDD FILLER2
XFILLER_107_658 VDD VSS FILLER1
XTAP_TAPCELL_ROW_115_1046 VDD VSS WELLTAP
XFILLER_20_56 VSS VDD FILLER2
XFILLER_136_56 VDD VSS FILLER4
XFILLER_136_67 VSS VDD FILLER2
XFILLER_115_680 VDD VSS FILLER1
XFILLER_103_842 VDD VSS FILLER1
X_10040_ _18604_/Q VDD VSS _10053_/A INVX1
XFILLER_96_49 VDD VSS FILLER4
XFILLER_88_575 VSS VDD FILLER2
XFILLER_102_363 VDD VSS FILLER4
XFILLER_152_44 VSS VDD FILLER2
XFILLER_75_247 VSS VDD FILLER2
XFILLER_91_718 VSS VDD FILLER2
X_11991_ _19997_/Q _19261_/Q VDD VSS _12055_/C NAND2X1
XFILLER_152_99 VSS VDD FILLER2
XFILLER_91_729 VDD VSS DECAPHV8
XFILLER_84_770 VDD VSS FILLER1
XTAP_TAPCELL_ROW_86_787 VDD VSS WELLTAP
X_13730_ _14327_/B _14327_/C _13731_/A VDD VSS _13837_/B OAI21X1
XFILLER_29_697 VSS VDD FILLER2
X_10942_ _10965_/A _18729_/Q _10942_/C _10942_/D VDD VSS _10943_/C AO22X2
XFILLER_71_420 VSS VDD FILLER2
XFILLER_44_634 VDD VSS FILLER1
XFILLER_45_53 VSS VDD FILLER2
XFILLER_83_291 VSS VDD FILLER2
XFILLER_16_358 VSS VDD FILLER2
X_13661_ _13661_/A _14162_/B _14162_/C VDD VSS _13662_/D NOR3X1
XFILLER_71_453 VSS VDD FILLER2
X_10873_ _10873_/A _10899_/C _10873_/C VDD VSS _10874_/D OAI21X1
XFILLER_43_155 VSS VDD FILLER2
XFILLER_44_689 VSS VDD FILLER2
X_15400_ _19543_/Q _15439_/B VDD VSS _15911_/B XOR2X1
X_12612_ _12612_/A _14117_/B _12612_/C VDD VSS _12613_/B MIN3X1
X_16380_ _19693_/Q _16854_/B VDD VSS _16388_/C XOR2X1
XFILLER_12_520 VDD VSS FILLER1
X_13592_ _18917_/Q VDD VSS _13672_/A INVX1
X_15331_ _15343_/A _15343_/B VDD VSS _15721_/B XNOR2X1
XFILLER_12_553 VDD VSS FILLER1
X_12543_ _12543_/A _14377_/B VDD VSS _12634_/A OR2X2
XFILLER_12_575 VDD VSS DECAPHV8
XTAP_TAPCELL_ROW_41_378 VDD VSS WELLTAP
X_18050_ _18546_/Q _18052_/B VDD VSS _18051_/B XNOR2X1
X_15262_ _15262_/A _15262_/B VDD VSS _15305_/B NAND2X1
X_12474_ _12474_/A _12474_/B _12474_/C _12474_/D VDD VSS _12662_/A AO31X2
XFILLER_61_96 VSS VDD FILLER2
XFILLER_157_569 VDD VSS FILLER4
X_17001_ _19755_/Q _17011_/B VDD VSS _17006_/B XOR2X1
X_14213_ _14231_/A _14213_/B VDD VSS _18962_/D AND2X1
XFILLER_138_783 VDD VSS FILLER4
X_11425_ _18546_/D _11428_/B VDD VSS _18618_/D NOR2BX1
X_15193_ _15875_/B _15193_/B _15193_/C VDD VSS _15876_/B XNOR3X1
XFILLER_6_36 VSS VDD FILLER2
XANTENNA_7 _20144_/A VDD VSS ANTENNA2
XFILLER_137_282 VSS VDD FILLER2
XFILLER_153_731 VDD VSS FILLER4
XFILLER_153_742 VSS VDD FILLER2
XFILLER_152_230 VSS VDD FILLER2
X_14144_ _14522_/A VDD VSS _14154_/A BUFX3
X_11356_ _11364_/A _11364_/C _11356_/C VDD VSS _11359_/A AOI21X1
XFILLER_153_764 VSS VDD FILLER2
XFILLER_152_241 VDD VSS FILLER1
XFILLER_3_251 VSS VDD FILLER2
X_10307_ _10298_/Y _10299_/Y _10306_/Y VDD VSS _10312_/C MUXI2X1
XFILLER_98_328 VSS VDD FILLER2
X_18952_ _19171_/CK _18952_/D _18952_/Q VDD VSS DFFQX1
X_14075_ _14158_/A _17968_/B VDD VSS _18869_/D AND2X1
XFILLER_112_127 VSS VDD FILLER2
X_11287_ _11379_/A _11308_/A VDD VSS _11292_/A NOR2X1
XFILLER_3_273 VDD VSS FILLER4
X_17903_ _17903_/A _17905_/C _17903_/C VDD VSS _19948_/D AOI21X1
X_13026_ _13212_/A _14352_/B VDD VSS _13067_/B NOR2X1
X_10238_ _10274_/B _10362_/D VDD VSS _10240_/C NOR2X1
X_18883_ _18934_/CK _18883_/D _18883_/Q VDD VSS DFFQX1
XFILLER_20_6 VDD VSS FILLER1
XFILLER_67_737 VDD VSS FILLER1
XFILLER_66_203 VSS VDD FILLER2
X_17834_ _18132_/A _17834_/B _17836_/B VDD VSS _19933_/D NOR3X1
X_10169_ _18614_/Q _10174_/B VDD VSS _10172_/D XNOR2X1
XTAP_TAPCELL_ROW_77_710 VDD VSS WELLTAP
XFILLER_94_523 VDD VSS DECAPHV8
XFILLER_79_597 VSS VDD FILLER2
XFILLER_86_71 VDD VSS FILLER1
X_14977_ _15045_/A _15045_/B VDD VSS _15774_/B XOR2X1
X_17765_ _17766_/A _17766_/B _17766_/D _17766_/C VDD VSS _17768_/C AOI211X1
XTAP_TAPCELL_ROW_49_456 VDD VSS WELLTAP
XFILLER_47_450 VSS VDD FILLER2
XFILLER_35_601 VSS VDD FILLER2
X_19504_ _19531_/CK _19504_/D _19504_/Q VDD VSS DFFQX1
X_16716_ _19920_/Q _16726_/B VDD VSS _19568_/D AND2X1
X_13928_ _18892_/Q _14134_/B VDD VSS _13941_/A NAND2X1
X_17696_ _17806_/A _17696_/B VDD VSS _19901_/D NOR2X1
XFILLER_74_280 VSS VDD FILLER2
X_16647_ _16636_/B _16647_/B _16647_/C VDD VSS _16672_/B AOI2B1X1
X_19435_ _19463_/CK _19435_/D _19435_/Q VDD VSS DFFQX1
XFILLER_23_807 VSS VDD FILLER2
X_13859_ _14363_/A _14363_/B _19087_/Q VDD VSS _13860_/D OAI21X1
XFILLER_34_166 VSS VDD FILLER2
XFILLER_34_177 VSS VDD FILLER2
XTAP_TAPCELL_ROW_32_301 VDD VSS WELLTAP
XFILLER_22_328 VSS VDD FILLER2
X_16578_ _16578_/A _16599_/B VDD VSS _16596_/A XNOR2X1
X_19366_ _19379_/CK _19366_/D _19366_/Q VDD VSS DFFQX1
XFILLER_31_840 VSS VDD FILLER2
XFILLER_148_514 VDD VSS FILLER4
X_15529_ _19352_/Q _15727_/B VDD VSS _15539_/B XNOR2X1
X_18317_ _18327_/CK _18514_/Q _18317_/Q _20067_/RB VDD VSS DFFRQX1
X_19297_ _19331_/CK _19297_/D _19297_/Q VDD VSS DFFQX1
X_18248_ _18256_/CK _18248_/D _18269_/D _18486_/RB VDD VSS DFFRQX1
XFILLER_129_761 VSS VDD FILLER2
XFILLER_163_517 VSS VDD FILLER2
X_18179_ _18179_/A _18179_/B _18179_/C VDD VSS _18185_/A MIN3X1
X_20210_ _20210_/A VDD VSS _20210_/Y BUFX3
XFILLER_116_444 VDD VSS FILLER4
XFILLER_144_753 VSS VDD FILLER2
XFILLER_143_241 VSS VDD FILLER2
XFILLER_144_764 VDD VSS FILLER1
XFILLER_104_628 VSS VDD FILLER2
X_20141_ _20141_/A VDD VSS _20141_/Y BUFX3
X_09952_ _11208_/A _09952_/B VDD VSS _09953_/D NAND2X1
X_20072_ _20081_/CK _20072_/D _20072_/Q _20075_/RB VDD VSS DFFRQX1
X_09883_ _10966_/A _09909_/B VDD VSS _09884_/C NAND2X1
XFILLER_100_834 VSS VDD FILLER2
XFILLER_58_759 VDD VSS FILLER4
XFILLER_100_856 VDD VSS FILLER1
XFILLER_111_193 VSS VDD FILLER2
XFILLER_85_556 VSS VDD FILLER2
XFILLER_122_14 VSS VDD FILLER2
XFILLER_57_269 VSS VDD FILLER2
XFILLER_66_770 VSS VDD FILLER2
XFILLER_122_58 VSS VDD FILLER2
XFILLER_25_111 VSS VDD FILLER2
XTAP_TAPCELL_ROW_83_757 VDD VSS WELLTAP
XFILLER_25_177 VSS VDD FILLER2
XFILLER_41_637 VDD VSS DECAPHV8
XFILLER_40_125 VDD VSS FILLER4
X_09317_ _18291_/Q _18519_/Q _09299_/Y VDD VSS _09317_/Y MUXI2X1
XFILLER_139_547 VDD VSS FILLER1
X_09248_ _18497_/D VDD VSS _18337_/D INVX1
XFILLER_31_11 VSS VDD FILLER2
XFILLER_154_506 VDD VSS FILLER4
XFILLER_5_505 VSS VDD FILLER2
XFILLER_5_516 VSS VDD FILLER2
XFILLER_110_4 VDD VSS DECAPHV8
XFILLER_119_282 VSS VDD FILLER2
XFILLER_31_77 VSS VDD FILLER2
XFILLER_135_742 VSS VDD FILLER2
XFILLER_5_549 VSS VDD FILLER2
X_11210_ _11179_/Y _11209_/Y _10984_/A VDD VSS _11244_/B MUXI2X1
XFILLER_107_444 VDD VSS FILLER4
X_12190_ _19041_/Q _12203_/B _12203_/C VDD VSS _14277_/B XNOR3X1
XFILLER_134_241 VSS VDD FILLER2
XFILLER_134_252 VDD VSS FILLER1
Xoutput11 _20095_/Y VDD VSS o_aux_ctrl[13] BUFX3
Xoutput9 output9/A VDD VSS o_aux_ctrl[11] BUFX3
Xoutput22 _20091_/Y VDD VSS o_aux_ctrl[9] BUFX3
XFILLER_150_723 VSS VDD FILLER2
Xoutput33 _20117_/Y VDD VSS o_bias_cfg[19] BUFX3
X_11141_ _18842_/Q VDD VSS _11142_/B INVX1
XFILLER_150_734 VDD VSS DECAPHV16
Xoutput44 _20127_/Y VDD VSS o_bias_cfg[29] BUFX3
XFILLER_1_722 VDD VSS FILLER1
Xoutput55 _20105_/Y VDD VSS o_bias_cfg[7] BUFX3
XFILLER_89_840 VSS VDD FILLER2
Xoutput66 _20150_/Y VDD VSS o_clk_cfg[17] BUFX3
XFILLER_0_232 VSS VDD FILLER2
Xoutput77 _20152_/Y VDD VSS o_en_ctrl[0] BUFX3
X_11072_ _11072_/A _11072_/B _11095_/C VDD VSS _11076_/B AOI21X1
Xoutput88 _20163_/Y VDD VSS o_lf_cfg[0] BUFX3
Xoutput99 _20168_/Y VDD VSS o_lf_cfg[5] BUFX3
XFILLER_163_54 VSS VDD FILLER2
XFILLER_103_672 VSS VDD FILLER2
X_14900_ _19337_/Q VDD VSS _14901_/A INVX1
X_10023_ _18006_/C VDD VSS _17172_/A BUFX3
XFILLER_88_372 VDD VSS FILLER1
X_15880_ _16795_/A VDD VSS _16768_/A BUFX3
XFILLER_102_182 VDD VSS FILLER4
X_14831_ _15015_/A _14881_/B VDD VSS _14918_/B XNOR2X1
XFILLER_91_526 VSS VDD FILLER2
X_17550_ _17675_/A _17550_/B VDD VSS _19870_/D NOR2X1
XFILLER_56_74 VSS VDD FILLER2
X_14762_ _19334_/Q _15706_/B VDD VSS _14763_/B XNOR2X1
XTAP_TAPCELL_ROW_46_426 VDD VSS WELLTAP
XFILLER_16_100 VDD VSS FILLER1
X_11974_ _11987_/A _14462_/B _11987_/C VDD VSS _14463_/B OAI21X1
XFILLER_17_645 VDD VSS FILLER4
X_16501_ _16501_/A VDD VSS _16752_/B INVX1
X_13713_ _19141_/Q _13719_/A _13719_/B VDD VSS _13714_/D XOR3X1
X_17481_ _17484_/C _17482_/B _17509_/C VDD VSS _17482_/C OAI21X1
X_10925_ _10925_/A _10925_/B VDD VSS _10926_/C NOR2X1
X_14693_ _19360_/Q VDD VSS _14694_/A INVX1
XFILLER_44_475 VDD VSS FILLER4
XFILLER_32_615 VDD VSS FILLER4
XFILLER_72_795 VDD VSS FILLER1
X_16432_ _16433_/A _16433_/B _16433_/C VDD VSS _16459_/B OAI21X1
X_19220_ _19250_/CK _19220_/D _19220_/Q VDD VSS DFFQX1
XFILLER_31_103 VDD VSS FILLER4
X_13644_ _19057_/Q _13709_/B _13781_/B VDD VSS _13837_/C XNOR3X1
X_10856_ _10856_/A _10856_/B _10856_/C _10856_/D VDD VSS _10890_/C AOI31X1
XFILLER_32_648 VDD VSS DECAPHV8
XFILLER_13_840 VSS VDD FILLER2
XFILLER_31_136 VDD VSS FILLER1
XFILLER_158_801 VSS VDD FILLER2
X_19151_ _19223_/CK _19151_/D _19151_/Q VDD VSS DFFQX1
X_16363_ _19628_/Q _16782_/B VDD VSS _16365_/A NAND2BX1
XFILLER_9_811 VSS VDD FILLER2
XFILLER_157_300 VSS VDD FILLER2
X_13575_ _18887_/Q _13575_/B _13575_/C VDD VSS _13660_/A MIN3X1
X_10787_ _19950_/Q _18832_/Q VDD VSS _10790_/D OR2X2
XFILLER_82_8 VSS VDD FILLER2
XFILLER_12_361 VDD VSS FILLER1
X_18102_ _19287_/Q _18102_/B VDD VSS _18109_/B NAND2BX1
XFILLER_158_856 VDD VSS FILLER1
X_15314_ _19541_/Q _15399_/C VDD VSS _15909_/B XNOR2X1
X_19082_ _19139_/CK _19082_/D _19082_/Q VDD VSS DFFQX1
X_12526_ _12533_/A _12609_/B _14149_/B VDD VSS _12532_/B XNOR3X1
XFILLER_40_692 VDD VSS FILLER4
XFILLER_157_344 VDD VSS FILLER4
X_16294_ _19658_/Q _16816_/B VDD VSS _16296_/C XNOR2X1
XFILLER_157_355 VSS VDD FILLER2
X_18033_ _18036_/B _18045_/B _18033_/C _18049_/D VDD VSS _19974_/D OAI31X1
X_15245_ _15281_/B _15843_/B _19457_/Q VDD VSS _15284_/C AOI2B1X1
X_12457_ _12457_/A _12457_/B _12457_/C _12457_/D VDD VSS _14345_/B OAOI211X1
XFILLER_138_591 VDD VSS FILLER1
X_11408_ _18530_/D _11428_/B VDD VSS _18602_/D NOR2BX1
X_15176_ _15176_/A _15176_/B _15748_/B VDD VSS _15220_/A MIN3X1
XFILLER_160_509 VSS VDD FILLER2
XFILLER_125_241 VDD VSS FILLER4
X_12388_ _12331_/A _14469_/B _14469_/C VDD VSS _12472_/C AND3BX1
XFILLER_153_561 VDD VSS FILLER4
XFILLER_99_626 VSS VDD FILLER2
XFILLER_141_723 VSS VDD FILLER2
X_14127_ _14142_/A _14127_/B VDD VSS _18886_/D NOR2X1
X_11339_ _11339_/A _11339_/B VDD VSS _11342_/B OR2X2
X_19984_ _19986_/CK _19984_/D _19984_/Q VDD VSS DFFQX1
XFILLER_140_244 VDD VSS FILLER4
X_18935_ _18961_/CK _18935_/D _18935_/Q VDD VSS DFFQX1
X_14058_ _14058_/A _14058_/B _14058_/C _14058_/D VDD VSS _14139_/C OAI211X1
XFILLER_141_789 VDD VSS FILLER4
X_13009_ _13097_/A _13097_/B VDD VSS _13070_/B NOR2X1
XFILLER_140_299 VDD VSS FILLER1
XFILLER_79_383 VDD VSS FILLER1
XFILLER_67_523 VSS VDD FILLER2
XFILLER_121_480 VDD VSS FILLER1
X_18866_ _18889_/CK _18866_/D _18866_/Q VDD VSS DFFQX1
XTAP_TAPCELL_ROW_146_1326 VDD VSS WELLTAP
X_17817_ _17815_/B _17817_/B VDD VSS _17818_/C NOR2BX1
X_18797_ _18799_/CK _18797_/D _18797_/Q VDD VSS DFFQX1
XFILLER_94_397 VSS VDD FILLER2
X_17748_ _17748_/A _17748_/B _17748_/C VDD VSS _17754_/C MIN3X1
XFILLER_63_751 VSS VDD FILLER2
X_17679_ _19897_/Q _19865_/Q VDD VSS _17680_/B XNOR2X1
XFILLER_63_784 VSS VDD FILLER2
XFILLER_62_261 VDD VSS FILLER1
X_19418_ _19466_/CK _19418_/D _19418_/Q VDD VSS DFFQX1
XFILLER_22_114 VSS VDD FILLER2
X_19349_ _19349_/CK _19349_/D _19349_/Q VDD VSS DFFQX1
XFILLER_50_489 VSS VDD FILLER2
XTAP_TAPCELL_ROW_157_1422 VDD VSS WELLTAP
XFILLER_148_333 VSS VDD FILLER2
XFILLER_149_856 VDD VSS FILLER1
XFILLER_148_355 VDD VSS FILLER1
XFILLER_30_180 VSS VDD FILLER2
XFILLER_163_325 VDD VSS FILLER1
XFILLER_117_742 VSS VDD FILLER2
XFILLER_163_358 VDD VSS FILLER1
XFILLER_7_90 VSS VDD FILLER2
XFILLER_144_550 VSS VDD FILLER2
XFILLER_2_508 VSS VDD FILLER2
XFILLER_104_403 VDD VSS FILLER4
XFILLER_104_425 VDD VSS FILLER1
XFILLER_131_211 VDD VSS FILLER1
XFILLER_116_296 VSS VDD FILLER2
XFILLER_132_745 VDD VSS FILLER4
XFILLER_104_458 VDD VSS FILLER1
X_20124_ _20124_/A VDD VSS _20124_/Y BUFX3
X_09935_ _18598_/Q _09935_/B VDD VSS _11398_/A XOR2X1
XTAP_TAPCELL_ROW_88_805 VDD VSS WELLTAP
X_20055_ clkload6/A _20192_/A _20056_/D _20071_/RB VDD VSS DFFRQX1
XFILLER_98_692 VDD VSS FILLER4
X_09866_ _18574_/Q _18575_/Q VDD VSS _09947_/B _09871_/B NAND3X1
XFILLER_86_843 VSS VDD FILLER2
XFILLER_85_342 VSS VDD FILLER2
XFILLER_58_567 VDD VSS FILLER4
X_09797_ _18310_/Q _09797_/B _09797_/C _20211_/A _09797_/E VDD VSS _09803_/A AOI221X1
XFILLER_100_686 VSS VDD FILLER2
XFILLER_85_375 VDD VSS DECAPHV8
XFILLER_73_526 VSS VDD FILLER2
XFILLER_39_781 VSS VDD FILLER2
Xdelaybuf_2_sclk sclk VDD VSS delaybuf_3_sclk/A BUFX12
XFILLER_26_11 VDD VSS FILLER4
XTAP_TAPCELL_ROW_108_983 VDD VSS WELLTAP
XFILLER_54_740 VDD VSS FILLER4
XFILLER_54_751 VSS VDD FILLER2
XTAP_TAPCELL_ROW_123_1123 VDD VSS WELLTAP
XFILLER_26_44 VSS VDD FILLER2
XFILLER_60_209 VDD VSS FILLER4
XFILLER_26_66 VSS VDD FILLER2
XFILLER_14_626 VSS VDD FILLER2
X_10710_ _11263_/A _10785_/A VDD VSS _10740_/A NOR2X1
XFILLER_158_4 VDD VSS FILLER4
X_11690_ _11706_/A _11716_/B VDD VSS _14517_/B XNOR2X1
XFILLER_139_300 VDD VSS FILLER4
X_10641_ _18667_/Q _18775_/Q VDD VSS _10718_/A XOR2X1
XFILLER_41_478 VSS VDD FILLER2
XFILLER_139_333 VSS VDD FILLER2
XTAP_TAPCELL_ROW_51_473 VDD VSS WELLTAP
X_13360_ _13432_/A _13432_/B _13432_/C VDD VSS _13424_/C OAI21X1
X_10572_ _18664_/Q _18772_/Q VDD VSS _10576_/D AND2X1
XFILLER_10_854 VSS VDD FILLER2
XFILLER_155_826 VSS VDD FILLER2
X_12311_ _12329_/A _12329_/B _12329_/E _12311_/D VDD VSS _14468_/C OAOI211X1
X_13291_ _13393_/B _13291_/B _18913_/Q VDD VSS _13385_/B AOI2B1X1
X_15030_ _19340_/Q _15714_/B VDD VSS _15031_/B XOR2X1
XFILLER_142_509 VSS VDD FILLER2
X_12242_ _12312_/A _12303_/B _12303_/C VDD VSS _12373_/C XNOR3X1
XFILLER_5_357 VSS VDD FILLER2
XFILLER_123_701 VDD VSS DECAPHV8
XFILLER_135_561 VDD VSS DECAPHV16
XFILLER_101_0 VDD VSS DECAPHV16
XFILLER_5_379 VDD VSS FILLER1
X_12173_ _19181_/Q _12329_/A _12218_/B VDD VSS _12214_/D XNOR3X1
XFILLER_123_756 VSS VDD FILLER2
XFILLER_162_391 VDD VSS DECAPHV16
X_11124_ _11126_/B _11124_/B VDD VSS _11125_/B XNOR2X1
XFILLER_96_607 VSS VDD FILLER2
XFILLER_1_541 VSS VDD FILLER2
X_16981_ _16979_/Y _16981_/B _17986_/C VDD VSS _19751_/D AND3BX1
XFILLER_110_417 VDD VSS FILLER1
XFILLER_107_91 VSS VDD FILLER2
X_18720_ _18801_/CK _18720_/D _18720_/Q VDD VSS DFFQX1
X_15932_ _19611_/Q _16763_/B _15950_/A VDD VSS _15948_/A MIN3X1
X_11055_ _11055_/A _11055_/B _11055_/C _11273_/A VDD VSS _11056_/B AOI31X1
XFILLER_103_491 VSS VDD FILLER2
XFILLER_67_62 VSS VDD FILLER2
XFILLER_49_556 VSS VDD FILLER2
X_10006_ _11208_/A _10107_/B _10006_/C VDD VSS _10010_/B AOI21X1
XTAP_TAPCELL_ROW_59_540 VDD VSS WELLTAP
X_15863_ _15879_/A _15863_/B VDD VSS _19472_/D AND2X1
X_18651_ _19959_/CK _18651_/D _18651_/Q VDD VSS DFFQX1
X_14814_ _19475_/Q _15866_/B VDD VSS _14817_/C XOR2X1
X_17602_ _17838_/A VDD VSS _17654_/C BUFX3
X_15794_ _16795_/A VDD VSS _15849_/A BUFX3
X_18582_ _18583_/CK _18582_/D _18582_/Q VDD VSS DFFQX1
XFILLER_17_420 VDD VSS FILLER1
X_14745_ _14785_/D VDD VSS _14746_/D INVX1
X_17533_ _19867_/Q _19835_/Q VDD VSS _17535_/C XOR2X1
X_11957_ _19092_/Q VDD VSS _11962_/A INVX1
XFILLER_83_61 VSS VDD FILLER2
XFILLER_17_464 VDD VSS FILLER1
X_17464_ _17468_/A _17465_/B _17509_/C VDD VSS _17465_/C OAI21X1
X_10908_ _10940_/A _10908_/B _10908_/C VDD VSS _10909_/D OAI21X1
X_14676_ _14676_/A _14676_/B _14676_/C _14676_/D VDD VSS _14710_/B OAOI211X1
XTAP_TAPCELL_ROW_141_1278 VDD VSS WELLTAP
X_11888_ _19996_/Q _19260_/Q VDD VSS _11980_/C XOR2X1
X_16415_ _19694_/Q _16855_/B VDD VSS _16437_/A NOR2X1
X_19203_ _19995_/CK _19203_/D _19203_/Q VDD VSS DFFQX1
XFILLER_20_607 VSS VDD FILLER2
X_13627_ _19112_/Q _14390_/B VDD VSS _13716_/A NOR2BX1
X_17395_ _17397_/B _17395_/B VDD VSS _17396_/B XOR2X1
X_10839_ _11116_/A _10839_/B VDD VSS _10840_/C NAND2X1
XTAP_TAPCELL_ROW_14_142 VDD VSS WELLTAP
X_16346_ _19660_/Q _16818_/B VDD VSS _16348_/C XNOR2X1
X_19134_ _19134_/CK _19134_/D _19134_/Q VDD VSS DFFQX1
XFILLER_157_130 VSS VDD FILLER2
X_13558_ _13559_/C _14482_/A VDD VSS _13637_/B _14482_/B NAND3X1
XFILLER_118_528 VSS VDD FILLER2
XFILLER_145_303 VSS VDD FILLER2
X_19065_ _19068_/CK _19065_/D _19065_/Q VDD VSS DFFQX1
X_12509_ _19045_/Q _12630_/A _12803_/B VDD VSS _12510_/D XNOR3X1
X_16277_ _19689_/Q VDD VSS _16278_/A INVX1
XFILLER_145_336 VSS VDD FILLER2
X_13489_ _18971_/Q _13594_/D _13489_/C VDD VSS _13516_/C XNOR3X1
X_15228_ _15284_/A _15284_/B VDD VSS _15247_/A NAND2X1
X_18016_ _18056_/A _18016_/B _18056_/C VDD VSS _19966_/D OAI21X1
XFILLER_126_583 VSS VDD FILLER2
XFILLER_160_328 VDD VSS FILLER4
X_15159_ _15200_/A _15200_/B VDD VSS _15811_/B XNOR2X1
XFILLER_113_211 VDD VSS FILLER4
XFILLER_141_520 VDD VSS FILLER1
XTAP_TAPCELL_ROW_152_1385 VDD VSS WELLTAP
XFILLER_99_434 VDD VSS FILLER1
XFILLER_113_233 VDD VSS FILLER4
XFILLER_113_255 VSS VDD FILLER2
XFILLER_114_789 VDD VSS FILLER1
X_19967_ _19985_/CK _19967_/D _19967_/Q VDD VSS DFFQX1
XFILLER_99_489 VDD VSS FILLER4
XFILLER_113_277 VSS VDD FILLER2
XFILLER_68_821 VSS VDD FILLER2
X_09720_ _20142_/A _20190_/A _09753_/A VDD VSS _09731_/B MUXI2X1
X_18918_ _18973_/CK _18918_/D _18918_/Q VDD VSS DFFQX1
X_19898_ _19924_/CK _19898_/D _19898_/Q VDD VSS DFFQX1
X_09651_ _18349_/Q VDD VSS _20217_/A INVX1
X_18849_ _18889_/CK _18849_/D _18849_/Q VDD VSS DFFQX1
XFILLER_94_150 VDD VSS FILLER1
XFILLER_67_375 VSS VDD FILLER2
XFILLER_27_206 VSS VDD FILLER2
XFILLER_82_312 VSS VDD FILLER2
X_09582_ _09753_/D _09582_/B _09582_/C VDD VSS _18280_/D OAI21X1
XTAP_TAPCELL_ROW_93_852 VDD VSS WELLTAP
XTAP_TAPCELL_ROW_163_1481 VDD VSS WELLTAP
XFILLER_70_518 VDD VSS FILLER1
XTAP_TAPCELL_ROW_65_598 VDD VSS WELLTAP
XFILLER_23_445 VSS VDD FILLER2
XFILLER_51_765 VDD VSS FILLER4
XFILLER_50_242 VDD VSS FILLER4
XFILLER_23_478 VSS VDD FILLER2
XFILLER_149_664 VSS VDD FILLER2
XFILLER_136_314 VSS VDD FILLER2
XFILLER_136_336 VSS VDD FILLER2
XFILLER_148_196 VSS VDD FILLER2
XFILLER_152_807 VDD VSS FILLER4
XTAP_TAPCELL_ROW_20_189 VDD VSS WELLTAP
XFILLER_124_509 VSS VDD FILLER2
XFILLER_164_689 VSS VDD FILLER2
XFILLER_117_561 VSS VDD FILLER2
XFILLER_151_317 VDD VSS FILLER4
XFILLER_151_328 VSS VDD FILLER2
XFILLER_117_594 VDD VSS FILLER1
XFILLER_105_756 VDD VSS FILLER4
XFILLER_160_851 VDD VSS FILLER4
XFILLER_78_607 VDD VSS FILLER4
XFILLER_120_715 VSS VDD FILLER2
XFILLER_144_34 VSS VDD FILLER2
XFILLER_144_45 VDD VSS FILLER1
XFILLER_132_597 VDD VSS FILLER4
X_20107_ _20107_/A VDD VSS _20107_/Y BUFX3
X_09918_ _09862_/B _09884_/Y _09928_/C VDD VSS _09919_/B MUXI2X1
XFILLER_104_299 VDD VSS FILLER4
X_20038_ _20045_/CK _20038_/D _20038_/Q _20045_/RB VDD VSS DFFRQX1
XFILLER_19_707 VDD VSS DECAPHV8
X_09849_ _18568_/Q _11039_/C _09849_/C _18569_/Q VDD VSS _09850_/B AOI211X1
XFILLER_74_813 VSS VDD FILLER2
XFILLER_37_32 VDD VSS DECAPHV8
XFILLER_85_161 VDD VSS FILLER4
XFILLER_100_472 VDD VSS FILLER4
XFILLER_86_695 VSS VDD FILLER2
XFILLER_37_43 VSS VDD FILLER2
XFILLER_18_228 VDD VSS FILLER4
X_12860_ _19160_/Q _12860_/B VDD VSS _12932_/C _12860_/C NAND3X1
XTAP_TAPCELL_ROW_56_521 VDD VSS WELLTAP
XFILLER_73_334 VSS VDD FILLER2
XFILLER_160_33 VDD VSS FILLER1
XFILLER_46_559 VSS VDD FILLER2
XFILLER_37_76 VSS VDD FILLER2
XFILLER_160_44 VSS VDD FILLER2
X_11811_ _11865_/A _11865_/B _14397_/B VDD VSS _11816_/C XNOR3X1
XFILLER_33_209 VDD VSS FILLER4
X_12791_ _18880_/Q _12791_/B _12791_/C VDD VSS _13181_/B MIN3X1
XTAP_TAPCELL_ROW_28_267 VDD VSS WELLTAP
XFILLER_163_2 VDD VSS FILLER1
XFILLER_73_389 VSS VDD FILLER2
XFILLER_26_261 VSS VDD FILLER2
XFILLER_160_99 VDD VSS DECAPHV8
X_14530_ _14539_/A _14530_/B VDD VSS _19236_/D NOR2X1
X_11742_ _11742_/A _11742_/B _11742_/C _11742_/D VDD VSS _11769_/A AOAI211X1
XFILLER_26_283 VSS VDD FILLER2
XFILLER_41_231 VDD VSS FILLER1
XFILLER_53_53 VSS VDD FILLER2
XFILLER_159_428 VSS VDD FILLER2
XFILLER_149_0 VSS VDD FILLER2
X_14461_ _14467_/A _14461_/B VDD VSS _19175_/D AND2X1
X_11673_ _18811_/Q _14547_/B VDD VSS _18838_/D AND2X1
X_16200_ _19686_/Q VDD VSS _16201_/A INVX1
X_13412_ _13416_/B _13416_/C _19053_/Q VDD VSS _13420_/A AOI21X1
X_17180_ _17329_/B _17180_/B _17180_/C VDD VSS _17185_/C MIN3X1
X_10624_ _11267_/A _10624_/B _10624_/C _10624_/D VDD VSS _10624_/Y AOI31X1
X_14392_ _14392_/A _14392_/B _15836_/C VDD VSS _19114_/D OA21X2
XTAP_TAPCELL_ROW_11_112 VDD VSS WELLTAP
XFILLER_128_837 VSS VDD FILLER2
X_16131_ _16120_/A _16131_/B _16131_/C VDD VSS _16144_/A AOI2B1X1
XFILLER_155_623 VSS VDD FILLER2
X_13343_ _13343_/A VDD VSS _13345_/B INVX1
X_10555_ _10556_/A _10556_/B _10556_/D _10556_/C VDD VSS _10558_/B AO211X2
XFILLER_10_695 VSS VDD FILLER2
XFILLER_6_644 VDD VSS FILLER4
XFILLER_5_110 VSS VDD FILLER2
XFILLER_154_133 VDD VSS FILLER4
XFILLER_143_807 VSS VDD FILLER2
XFILLER_143_818 VDD VSS FILLER1
X_16062_ _16062_/A _19904_/Q _16062_/C VDD VSS _16088_/C MIN3X1
XFILLER_5_132 VSS VDD FILLER2
X_13274_ _13274_/A _14290_/B _13274_/C _13274_/D VDD VSS _13406_/B AOAI211X1
X_10486_ _10521_/A _10521_/B _10521_/C _10721_/D VDD VSS _10487_/D AOI31X1
XFILLER_5_154 VSS VDD FILLER2
XFILLER_142_328 VSS VDD FILLER2
X_15013_ _15013_/A _15013_/B _15013_/C _15013_/D VDD VSS _15108_/B AOAI211X1
X_12225_ _19209_/Q _14500_/B VDD VSS _12329_/E _14500_/C NAND3X1
XFILLER_5_176 VSS VDD FILLER2
XFILLER_151_840 VDD VSS FILLER4
XFILLER_45_8 VSS VDD FILLER2
X_19821_ _19825_/CK _19821_/D _19821_/Q VDD VSS DFFQX1
XFILLER_2_850 VSS VDD FILLER2
X_12156_ _19180_/Q _14466_/B VDD VSS _12171_/C _14466_/C NAND3X1
XFILLER_150_372 VDD VSS DECAPHV8
X_11107_ _11068_/B _11107_/B _11107_/C VDD VSS _11132_/A AOI2B1X1
X_19752_ _19785_/CK _19752_/D _19752_/Q VDD VSS DFFQX1
X_16964_ _16973_/A _16973_/D VDD VSS _16968_/C NAND2X1
X_12087_ _12087_/A _12087_/B _12087_/C _12254_/B VDD VSS _12149_/B OAOI211X1
X_18703_ _18788_/CK _18703_/D _18703_/Q VDD VSS DFFQX1
XFILLER_77_662 VDD VSS DECAPHV8
XFILLER_49_353 VSS VDD FILLER2
X_15915_ _19547_/Q _19899_/Q VDD VSS _15923_/B XNOR2X1
X_11038_ _19958_/Q _18840_/Q VDD VSS _11040_/B XOR2X1
X_19683_ _19696_/CK _19683_/D _19683_/Q VDD VSS DFFQX1
X_16895_ _16976_/A _16895_/B VDD VSS _19730_/D NOR2X1
XFILLER_49_375 VDD VSS FILLER4
XFILLER_49_397 VSS VDD FILLER2
X_18634_ _18799_/CK _18634_/D _18634_/Q VDD VSS DFFQX1
XFILLER_37_548 VSS VDD FILLER2
X_15846_ _17906_/C VDD VSS _16776_/A BUFX3
XFILLER_18_751 VSS VDD FILLER2
XFILLER_52_507 VDD VSS FILLER4
X_18565_ _18578_/CK _18565_/D _18565_/Q VDD VSS DFFQX1
X_15777_ _15793_/A _15777_/B VDD VSS _19398_/D AND2X1
X_12989_ _18938_/Q _12992_/B _12989_/C VDD VSS _13076_/C XNOR3X1
XFILLER_91_175 VSS VDD FILLER2
XFILLER_45_570 VSS VDD FILLER2
XTAP_TAPCELL_ROW_90_822 VDD VSS WELLTAP
X_17516_ _19862_/Q _19830_/Q VDD VSS _17517_/C NAND2X1
X_14728_ _19361_/Q _14728_/B _15736_/B VDD VSS _14800_/B MIN3X1
X_18496_ _18503_/CK _18496_/D _20109_/A _18498_/RB VDD VSS DFFRQX1
XTAP_TAPCELL_ROW_62_568 VDD VSS WELLTAP
XTAP_TAPCELL_ROW_102_934 VDD VSS WELLTAP
XFILLER_60_551 VDD VSS FILLER1
XFILLER_32_242 VDD VSS FILLER1
X_17447_ _17448_/A _17450_/C _17452_/C VDD VSS _17448_/C OAI21X1
X_14659_ _14708_/A _14659_/B VDD VSS _15862_/B NOR2BX1
XFILLER_119_804 VDD VSS FILLER4
X_17378_ _19833_/Q _19801_/Q VDD VSS _17379_/B XNOR2X1
XFILLER_118_303 VDD VSS FILLER1
XTAP_TAPCELL_ROW_154_1403 VDD VSS WELLTAP
X_19117_ _19196_/CK _19117_/D _19117_/Q VDD VSS DFFQX1
XFILLER_145_111 VSS VDD FILLER2
XFILLER_146_634 VDD VSS DECAPHV8
X_16329_ _16332_/B _16329_/B VDD VSS _16330_/B XOR2X1
XFILLER_158_494 VSS VDD FILLER2
XFILLER_9_482 VSS VDD FILLER2
XFILLER_64_0 VDD VSS FILLER4
X_19048_ _19072_/CK _19048_/D _19048_/Q VDD VSS DFFQX1
XFILLER_133_328 VSS VDD FILLER2
XFILLER_161_648 VSS VDD FILLER2
XFILLER_114_564 VDD VSS FILLER4
XFILLER_102_715 VDD VSS FILLER1
XFILLER_99_264 VSS VDD FILLER2
XFILLER_59_106 VSS VDD FILLER2
XFILLER_141_383 VDD VSS FILLER4
XFILLER_87_437 VSS VDD FILLER2
XFILLER_4_91 VSS VDD FILLER2
X_09703_ _18448_/Q VDD VSS _20160_/A INVX1
XFILLER_101_269 VSS VDD FILLER2
XFILLER_68_662 VDD VSS FILLER4
XFILLER_68_684 VDD VSS FILLER4
XFILLER_68_695 VSS VDD FILLER2
X_09634_ _18238_/Q _09818_/B _09716_/B _18263_/Q _09634_/E VDD VSS _09635_/C AOI221X1
XFILLER_83_654 VSS VDD FILLER2
XFILLER_82_131 VDD VSS FILLER1
XFILLER_82_142 VSS VDD FILLER2
XFILLER_71_816 VDD VSS FILLER4
XFILLER_55_367 VDD VSS FILLER4
X_09565_ _09767_/B VDD VSS _09788_/B BUFX3
XFILLER_70_304 VSS VDD FILLER2
XFILLER_71_849 VDD VSS FILLER4
XFILLER_24_721 VSS VDD FILLER2
X_09496_ _19986_/Q _09496_/B _09496_/C VDD VSS _09497_/C AOI21X1
XTAP_TAPCELL_ROW_25_237 VDD VSS WELLTAP
XFILLER_130_69 VDD VSS FILLER4
XFILLER_23_23 VSS VDD FILLER2
XFILLER_23_297 VDD VSS FILLER4
XFILLER_11_448 VSS VDD FILLER2
XFILLER_149_450 VSS VDD FILLER2
XFILLER_149_472 VSS VDD FILLER2
XFILLER_136_111 VSS VDD FILLER2
X_10340_ _19939_/Q _18821_/Q VDD VSS _10343_/D XOR2X1
XFILLER_136_166 VSS VDD FILLER2
XTAP_TAPCELL_ROW_118_1077 VDD VSS WELLTAP
XFILLER_124_328 VSS VDD FILLER2
XFILLER_3_625 VSS VDD FILLER2
XFILLER_155_22 VDD VSS FILLER1
XFILLER_105_520 VDD VSS FILLER1
X_10271_ _10538_/A _10550_/A _10585_/C VDD VSS _10306_/A NOR3X1
XFILLER_133_840 VDD VSS DECAPHV16
XFILLER_3_658 VSS VDD FILLER2
X_12010_ _12010_/A _12010_/B _14238_/B VDD VSS _12072_/B MIN3X1
XFILLER_105_575 VDD VSS DECAPHV8
XFILLER_132_361 VSS VDD FILLER2
XFILLER_120_534 VSS VDD FILLER2
XFILLER_78_459 VSS VDD FILLER2
XFILLER_48_53 VDD VSS FILLER1
X_13961_ _19061_/Q _14333_/B VDD VSS _13962_/D NAND2X1
XFILLER_86_481 VSS VDD FILLER2
XFILLER_59_695 VDD VSS DECAPHV8
XFILLER_47_835 VSS VDD FILLER2
XFILLER_0_16 VSS VDD FILLER2
X_15700_ _15710_/A _15700_/B VDD VSS _19328_/D NOR2X1
X_12912_ _19104_/Q _14382_/B VDD VSS _12913_/D _14382_/C NAND3X1
XFILLER_46_323 VSS VDD FILLER2
X_16680_ _19609_/Q _16761_/B VDD VSS _16681_/B XNOR2X1
XTAP_TAPCELL_ROW_129_1173 VDD VSS WELLTAP
XFILLER_0_27 VDD VSS FILLER1
X_13892_ _18976_/Q _13998_/A _13998_/B VDD VSS _13921_/C XNOR3X1
XFILLER_100_291 VSS VDD FILLER2
X_15631_ _19328_/Q _15700_/B VDD VSS _15632_/B XNOR2X1
X_12843_ _12843_/A _12843_/B _12843_/C _12843_/D VDD VSS _14475_/B OAOI211X1
XFILLER_74_687 VSS VDD FILLER2
XFILLER_34_518 VSS VDD FILLER2
XFILLER_34_529 VDD VSS FILLER1
X_15562_ _15674_/A _18155_/B VDD VSS _19297_/D AND2X1
X_18350_ _18359_/CK _18350_/D _18350_/Q _18374_/RB VDD VSS DFFRQX1
X_12774_ _19132_/Q _12932_/A _12822_/B VDD VSS _12910_/D XNOR3X1
XFILLER_42_551 VDD VSS FILLER1
X_17301_ _19817_/Q _19785_/Q VDD VSS _17303_/B XOR2X1
X_14513_ _15806_/A _14513_/B _14513_/C VDD VSS _19220_/D NOR3X1
X_11725_ _19991_/Q _19255_/Q VDD VSS _11769_/B XOR2X1
XFILLER_9_25 VSS VDD FILLER2
X_15493_ _15541_/B _15493_/B VDD VSS _15725_/B NOR2BX1
X_18281_ _18288_/CK _18281_/D _18281_/Q VDD VSS DFFQX1
XFILLER_14_275 VSS VDD FILLER2
XFILLER_9_47 VSS VDD FILLER2
XFILLER_42_584 VSS VDD FILLER2
XFILLER_30_735 VDD VSS FILLER1
X_17232_ _19802_/Q _19770_/Q _17306_/C VDD VSS _17233_/C OAI21X1
X_14444_ _14449_/A _14444_/B _14444_/C VDD VSS _19160_/D NOR3X1
XFILLER_9_69 VDD VSS FILLER4
XFILLER_80_51 VDD VSS FILLER1
X_11656_ _18796_/Q _11658_/B VDD VSS _18823_/D AND2X1
XFILLER_80_62 VSS VDD FILLER2
X_17163_ _17168_/C _17168_/B VDD VSS _17165_/B NAND2BX1
X_10607_ _10633_/A _10633_/B _10607_/C _10607_/D VDD VSS _10619_/B AO31X2
XFILLER_80_95 VSS VDD FILLER2
XFILLER_127_111 VSS VDD FILLER2
Xclkbuf_1_0__f__002_ clkbuf_0__002_/Y VDD VSS clkload16/A BUFX12
X_14375_ _14410_/A _14375_/B _14375_/C VDD VSS _19098_/D NOR3X1
X_11587_ _18733_/Q _11589_/B VDD VSS _18760_/D AND2X1
X_16114_ _16137_/C _16114_/B VDD VSS _16736_/B XNOR2X1
X_13326_ _19165_/Q VDD VSS _13356_/A INVX1
XFILLER_116_829 VDD VSS DECAPHV8
X_17094_ _17097_/B _17094_/B VDD VSS _17095_/B XOR2X1
X_10538_ _10538_/A VDD VSS _10960_/A BUFX3
XFILLER_143_615 VSS VDD FILLER2
XFILLER_6_474 VSS VDD FILLER2
XFILLER_155_497 VDD VSS FILLER4
X_16045_ _16057_/A _16057_/B VDD VSS _16840_/B XNOR2X1
XFILLER_127_199 VSS VDD FILLER2
X_13257_ _13339_/A _14543_/B VDD VSS _13347_/A NOR2X1
XFILLER_108_391 VDD VSS FILLER1
X_10469_ _10503_/C _10469_/B VDD VSS _10474_/B XNOR2X1
X_12208_ wire159/Y _12208_/B VDD VSS _14374_/B XOR2X1
XFILLER_97_702 VSS VDD FILLER2
XFILLER_130_309 VSS VDD FILLER2
XFILLER_142_169 VDD VSS FILLER1
XFILLER_69_404 VSS VDD FILLER2
X_13188_ _13295_/A _13295_/C _13295_/B VDD VSS _14190_/C AO21X2
XFILLER_151_670 VSS VDD FILLER2
XFILLER_97_735 VSS VDD FILLER2
XFILLER_96_212 VSS VDD FILLER2
XFILLER_36_4 VSS VDD FILLER2
XFILLER_111_523 VSS VDD FILLER2
X_19804_ _19895_/CK _19804_/D _19804_/Q VDD VSS DFFQX1
X_12139_ _12210_/A _12447_/B VDD VSS _12140_/C XNOR2X1
XFILLER_97_768 VSS VDD FILLER2
XFILLER_111_556 VSS VDD FILLER2
X_17996_ _18537_/Q _18032_/B VDD VSS _18036_/B AND2X1
X_19735_ _19736_/CK _19735_/D _19735_/Q VDD VSS DFFQX1
X_16947_ wire164/Y VDD VSS _17062_/C INVX1
XTAP_TAPCELL_ROW_67_616 VDD VSS WELLTAP
XFILLER_37_312 VDD VSS FILLER1
X_19666_ _19667_/CK _19666_/D _19666_/Q VDD VSS DFFQX1
X_16878_ _16891_/A _16878_/B VDD VSS _19714_/D NOR2X1
XFILLER_92_440 VSS VDD FILLER2
XFILLER_65_654 VDD VSS FILLER4
XFILLER_64_142 VSS VDD FILLER2
X_18617_ _18622_/CK _18617_/D _18617_/Q VDD VSS DFFQX1
X_15829_ _15830_/A _15829_/B VDD VSS _19444_/D NOR2X1
XTAP_TAPCELL_ROW_9_90 VDD VSS WELLTAP
XFILLER_92_473 VDD VSS FILLER1
XFILLER_65_687 VSS VDD FILLER2
X_19597_ _19664_/CK _19597_/D _19597_/Q VDD VSS DFFQX1
XTAP_TAPCELL_ROW_160_1451 VDD VSS WELLTAP
X_09350_ _18509_/Q VDD VSS _09369_/B INVX1
X_18548_ _18550_/CK _18548_/D _18548_/Q VDD VSS DFFQX1
X_09281_ _20054_/RB _09362_/B VDD VSS _09281_/Y NOR2BX1
X_18479_ _18479_/CK _18495_/D _20124_/A _18498_/RB VDD VSS DFFRQX1
XTAP_TAPCELL_ROW_22_207 VDD VSS WELLTAP
XFILLER_166_707 VSS VDD FILLER2
XFILLER_159_770 VSS VDD FILLER2
XFILLER_119_612 VDD VSS FILLER4
XFILLER_165_217 VSS VDD FILLER2
XFILLER_119_623 VSS VDD FILLER2
XFILLER_165_239 VSS VDD FILLER2
XFILLER_107_807 VSS VDD FILLER2
XTAP_TAPCELL_ROW_30_284 VDD VSS WELLTAP
XFILLER_119_678 VSS VDD FILLER2
XFILLER_106_306 VSS VDD FILLER2
XFILLER_109_37 VSS VDD FILLER2
XFILLER_146_486 VDD VSS FILLER1
XFILLER_106_328 VSS VDD FILLER2
Xclkload60 _19115_/CK VDD VSS clkload60/Y BUFX12
XFILLER_118_199 VDD VSS FILLER4
Xclkload71 clkload71/A VDD VSS clkload71/Y INVX14
XFILLER_161_434 VDD VSS FILLER4
XFILLER_134_659 VSS VDD FILLER2
Xclkload82 _19573_/CK VDD VSS clkload82/Y INVX4
XFILLER_115_840 VSS VDD FILLER2
Xclkload93 _19722_/CK VDD VSS clkload93/Y INVX2
XFILLER_0_617 VSS VDD FILLER2
XFILLER_0_639 VSS VDD FILLER2
XFILLER_130_832 VDD VSS FILLER1
XFILLER_102_545 VSS VDD FILLER2
XFILLER_75_418 VDD VSS FILLER4
XFILLER_29_813 VSS VDD FILLER2
XFILLER_28_301 VSS VDD FILLER2
XFILLER_29_835 VSS VDD FILLER2
XFILLER_28_323 VSS VDD FILLER2
XFILLER_56_643 VDD VSS FILLER4
XFILLER_56_654 VDD VSS DECAPHV8
XFILLER_18_56 VSS VDD FILLER2
XFILLER_28_356 VSS VDD FILLER2
X_09617_ _18262_/Q _09818_/C _09617_/C _09788_/B _09617_/E VDD VSS _09618_/B AOI221X1
XFILLER_56_676 VSS VDD FILLER2
XTAP_TAPCELL_ROW_38_351 VDD VSS WELLTAP
XFILLER_71_613 VDD VSS DECAPHV16
XFILLER_43_304 VDD VSS FILLER4
XFILLER_16_518 VSS VDD FILLER2
XFILLER_71_646 VDD VSS FILLER4
X_09548_ _20042_/Q _18201_/A VDD VSS _20043_/D NOR2BX1
XFILLER_34_44 VSS VDD FILLER2
XFILLER_24_573 VSS VDD FILLER2
X_09479_ _18405_/D _09483_/B _09479_/C VDD VSS _18244_/D AOI21X1
XFILLER_11_201 VSS VDD FILLER2
X_11510_ _18663_/Q _11519_/B VDD VSS _18690_/D AND2X1
XTAP_TAPCELL_ROW_5_59 VDD VSS WELLTAP
X_12490_ _19212_/Q _14504_/B VDD VSS _12566_/D _14504_/C NAND3X1
XFILLER_156_206 VDD VSS FILLER1
XFILLER_7_205 VDD VSS FILLER1
XFILLER_50_10 VSS VDD FILLER2
X_11441_ _16273_/A VDD VSS _17990_/A BUFX3
X_14160_ _15383_/A VDD VSS _14197_/A BUFX3
X_11372_ _11379_/A _11373_/B _11379_/C _18592_/Q VDD VSS _11381_/C AOAI211X1
XFILLER_109_166 VSS VDD FILLER2
XFILLER_125_626 VDD VSS FILLER4
X_13111_ _13111_/A _13111_/B _13111_/C _13111_/D VDD VSS _13315_/A AOAI211X1
XFILLER_164_283 VSS VDD FILLER2
X_10323_ _10323_/A _10323_/B _10323_/C _10323_/D VDD VSS _10381_/C OAOI211X1
XFILLER_166_76 VSS VDD FILLER2
X_14091_ _18897_/Q _14140_/B VDD VSS _14093_/C _14140_/C NAND3X1
XFILLER_152_456 VSS VDD FILLER2
XFILLER_140_607 VSS VDD FILLER2
X_13042_ _13141_/A _13042_/B VDD VSS _14477_/B XNOR2X1
XFILLER_79_702 VSS VDD FILLER2
XFILLER_59_30 VDD VSS DECAPHV8
X_10254_ _11436_/C _11431_/B _10269_/D _10258_/D VDD VSS _10315_/D OA211X2
XFILLER_132_180 VDD VSS DECAPHV8
X_17850_ _17853_/C _17851_/B _17917_/C VDD VSS _17851_/C OAI21X1
X_10185_ _10188_/A _10188_/B VDD VSS _11422_/C XNOR2X1
XFILLER_59_85 VSS VDD FILLER2
XFILLER_59_96 VDD VSS FILLER4
X_16801_ _16811_/A _16801_/B VDD VSS _19644_/D NOR2X1
XFILLER_66_407 VDD VSS FILLER1
X_17781_ _19919_/Q _19887_/Q _17781_/C VDD VSS _17785_/B MIN3X1
XFILLER_66_429 VSS VDD FILLER2
X_14993_ _19450_/Q _15835_/B VDD VSS _15003_/A NAND2X1
XFILLER_115_80 VDD VSS FILLER4
XFILLER_115_91 VSS VDD FILLER2
X_19520_ _19536_/CK _19520_/D _19520_/Q VDD VSS DFFQX1
X_16732_ _16735_/A _16732_/B VDD VSS _19583_/D NOR2X1
X_13944_ _14020_/A _14135_/B VDD VSS _13974_/B NOR2X1
XFILLER_75_62 VDD VSS FILLER4
XFILLER_47_654 VDD VSS DECAPHV16
XFILLER_46_142 VSS VDD FILLER2
XFILLER_75_84 VDD VSS FILLER1
XFILLER_62_602 VSS VDD FILLER2
XFILLER_19_367 VDD VSS FILLER4
X_19451_ _19465_/CK _19451_/D _19451_/Q VDD VSS DFFQX1
XFILLER_62_613 VDD VSS DECAPHV8
X_16663_ _19704_/Q _16669_/A VDD VSS _16664_/B XOR2X1
X_13875_ _18892_/Q _13938_/A _13981_/B VDD VSS _13929_/D XNOR3X1
XFILLER_35_849 VDD VSS FILLER4
XFILLER_61_112 VSS VDD FILLER2
X_18402_ _18406_/CK _18519_/Q _20143_/A _18450_/RB VDD VSS DFFRQX1
X_15614_ _15611_/A _15614_/B _15614_/C VDD VSS _15635_/B AOI2B1X1
X_12826_ _12827_/A _12827_/B _12827_/D _12827_/C VDD VSS _14475_/C AOI211X1
X_19382_ _19412_/CK _19382_/D _19382_/Q VDD VSS DFFQX1
XFILLER_62_668 VSS VDD FILLER2
XFILLER_50_808 VSS VDD FILLER2
X_16594_ _19669_/Q _16828_/B VDD VSS _16595_/C NOR2X1
XTAP_TAPCELL_ROW_72_663 VDD VSS WELLTAP
X_18333_ _18343_/CK _18514_/Q _20087_/A _18374_/RB VDD VSS DFFRQX1
X_15545_ _15545_/A _15545_/B VDD VSS _15552_/B AND2X1
X_12757_ _12763_/A _12763_/B _12763_/D _12763_/C VDD VSS _14537_/C OAOI211X1
XFILLER_15_573 VSS VDD FILLER2
XFILLER_61_189 VSS VDD FILLER2
XFILLER_42_370 VSS VDD FILLER2
XFILLER_30_510 VDD VSS FILLER1
X_11708_ _19990_/Q _19254_/Q VDD VSS _11724_/C XOR2X1
XFILLER_30_532 VDD VSS FILLER4
X_15476_ _19545_/Q _15476_/B VDD VSS _15913_/B XOR2X1
X_18264_ _18268_/CK _18264_/D _18264_/Q _20073_/RB VDD VSS DFFRQX1
X_12688_ _19103_/Q _12819_/A _12910_/B VDD VSS _12804_/D XNOR3X1
XFILLER_30_576 VDD VSS FILLER1
X_17215_ _17214_/B _17215_/B VDD VSS _17217_/C NOR2BX1
X_14427_ _14467_/A _14427_/B VDD VSS _19145_/D AND2X1
X_11639_ _18780_/Q _11647_/B VDD VSS _18807_/D AND2X1
X_18195_ _19304_/Q _18195_/B _18195_/C VDD VSS _18196_/B MIN3X1
X_17146_ _19784_/Q _19752_/Q VDD VSS _17149_/A XNOR2X1
X_14358_ _14410_/A _14358_/B _14358_/C VDD VSS _19082_/D NOR3X1
XFILLER_155_250 VDD VSS FILLER4
XFILLER_155_261 VSS VDD FILLER2
XFILLER_128_486 VDD VSS DECAPHV8
X_13309_ _14221_/A _14221_/B _14221_/C _13309_/D VDD VSS _13511_/A OAOI211X1
X_17077_ _19768_/Q _17078_/B _17077_/C VDD VSS _17079_/A AOI21X1
X_14289_ _14311_/A _14289_/B VDD VSS _19022_/D NOR2X1
X_16028_ _16028_/A _16028_/B _16028_/C VDD VSS _16051_/A AOI21X1
XFILLER_130_106 VSS VDD FILLER2
XFILLER_112_832 VDD VSS FILLER4
XFILLER_112_854 VSS VDD FILLER2
XFILLER_27_0 VDD VSS FILLER1
XFILLER_111_375 VSS VDD FILLER2
XTAP_TAPCELL_ROW_149_1357 VDD VSS WELLTAP
X_17979_ _17987_/A _17980_/B _18187_/C VDD VSS _17980_/C OAI21X1
XFILLER_69_289 VSS VDD FILLER2
X_19718_ _19724_/CK _19718_/D _19718_/Q VDD VSS DFFQX1
XFILLER_37_120 VSS VDD FILLER2
XFILLER_37_131 VDD VSS FILLER4
XFILLER_38_665 VDD VSS FILLER4
XFILLER_37_142 VSS VDD FILLER2
X_19649_ _19722_/CK _19649_/D _19649_/Q VDD VSS DFFQX1
XFILLER_92_270 VSS VDD FILLER2
XFILLER_52_101 VSS VDD FILLER2
XFILLER_80_421 VSS VDD FILLER2
XFILLER_26_849 VDD VSS FILLER4
X_09402_ _18087_/D VDD VSS _13283_/A BUFX3
XFILLER_53_646 VDD VSS FILLER4
XTAP_TAPCELL_ROW_35_332 VDD VSS WELLTAP
X_09333_ _18446_/D _09332_/Y _09302_/A VDD VSS _18515_/D MUXI2X1
XFILLER_80_476 VDD VSS FILLER1
XFILLER_80_498 VDD VSS FILLER4
XFILLER_21_510 VSS VDD FILLER2
X_09264_ _18279_/Q _18278_/Q VDD VSS _09296_/A NOR2X1
XFILLER_138_217 VSS VDD FILLER2
XFILLER_166_526 VSS VDD FILLER2
XFILLER_119_420 VSS VDD FILLER2
XFILLER_138_239 VSS VDD FILLER2
XFILLER_21_587 VDD VSS FILLER4
X_09195_ _18516_/Q VDD VSS _18447_/D INVX1
XFILLER_21_598 VDD VSS DECAPHV8
XFILLER_147_751 VDD VSS FILLER1
XFILLER_153_209 VSS VDD FILLER2
XFILLER_162_710 VSS VDD FILLER2
XFILLER_119_497 VDD VSS FILLER1
XFILLER_146_294 VSS VDD FILLER2
XFILLER_162_743 VSS VDD FILLER2
XFILLER_106_136 VSS VDD FILLER2
XFILLER_134_445 VSS VDD FILLER2
XTAP_TAPCELL_ROW_115_1047 VDD VSS WELLTAP
XFILLER_106_147 VSS VDD FILLER2
XFILLER_162_765 VSS VDD FILLER2
XFILLER_122_607 VDD VSS DECAPHV8
Xclkbuf_leaf_1_sclk delaybuf_0_sclk/A VDD VSS _18226_/CK BUFX12
XFILLER_162_787 VSS VDD FILLER2
XFILLER_122_629 VSS VDD FILLER2
XFILLER_0_403 VSS VDD FILLER2
XFILLER_0_414 VSS VDD FILLER2
XFILLER_114_191 VSS VDD FILLER2
XFILLER_130_651 VSS VDD FILLER2
XFILLER_75_204 VSS VDD FILLER2
XFILLER_130_684 VDD VSS FILLER1
XFILLER_102_386 VSS VDD FILLER2
XFILLER_29_621 VSS VDD FILLER2
XFILLER_152_78 VDD VSS FILLER4
X_11990_ _12099_/A _12099_/B VDD VSS _12038_/B NOR2X1
XFILLER_29_654 VDD VSS FILLER4
XFILLER_28_142 VSS VDD FILLER2
XTAP_TAPCELL_ROW_86_788 VDD VSS WELLTAP
XFILLER_44_602 VSS VDD FILLER2
X_10941_ _11229_/D _10978_/C VDD VSS _10942_/D NOR2X1
XTAP_TAPCELL_ROW_126_1143 VDD VSS WELLTAP
XFILLER_90_229 VSS VDD FILLER2
XFILLER_84_793 VDD VSS DECAPHV8
XFILLER_43_123 VSS VDD FILLER2
XFILLER_16_337 VDD VSS FILLER1
X_13660_ _13660_/A _13660_/B _13660_/C _13660_/D VDD VSS _17920_/B OAOI211X1
X_10872_ _10873_/A _10899_/C _11226_/A VDD VSS _10873_/C AOI21X1
X_12611_ _18876_/Q _12611_/B _12611_/C VDD VSS _12612_/C MIN3X1
XFILLER_45_98 VDD VSS FILLER1
X_13591_ _13591_/A _13591_/B _13591_/C _13591_/D VDD VSS _13807_/A AOAI211X1
XFILLER_43_189 VSS VDD FILLER2
XFILLER_101_60 VSS VDD FILLER2
XFILLER_12_532 VSS VDD FILLER2
X_15330_ _19375_/Q _15752_/B VDD VSS _15343_/B XNOR2X1
XFILLER_40_841 VSS VDD FILLER2
X_12542_ _19073_/Q VDD VSS _12625_/A INVX1
XFILLER_129_217 VDD VSS FILLER4
XFILLER_8_514 VSS VDD FILLER2
XFILLER_131_0 VDD VSS FILLER4
XFILLER_61_64 VSS VDD FILLER2
XFILLER_157_537 VDD VSS DECAPHV8
XFILLER_129_239 VSS VDD FILLER2
XFILLER_12_587 VSS VDD FILLER2
X_15261_ _19401_/Q _15781_/B VDD VSS _15305_/A NAND2X1
XTAP_TAPCELL_ROW_41_379 VDD VSS WELLTAP
XFILLER_8_536 VSS VDD FILLER2
X_12473_ _19183_/Q _12474_/B _12473_/C VDD VSS _12483_/B XNOR3X1
XFILLER_138_740 VSS VDD FILLER2
X_17000_ _16998_/B _17000_/B VDD VSS _17006_/A NOR2BX1
X_14212_ _14218_/A _14212_/B VDD VSS _18961_/D NOR2X1
X_11424_ _14163_/A _11429_/B _11424_/C VDD VSS _18617_/D NOR3X1
X_15192_ _15275_/A _15275_/C VDD VSS _15193_/C NAND2X1
XTAP_TAPCELL_ROW_137_1250 VDD VSS WELLTAP
XFILLER_165_570 VDD VSS FILLER4
XANTENNA_8 _20099_/A VDD VSS ANTENNA2
XFILLER_125_434 VSS VDD FILLER2
X_14143_ _14158_/A _14143_/B VDD VSS _18900_/D AND2X1
X_11355_ _18589_/Q _11355_/B _11355_/C VDD VSS _11367_/B MIN3X1
XFILLER_153_754 VSS VDD FILLER2
XFILLER_99_819 VDD VSS FILLER1
XFILLER_152_253 VSS VDD FILLER2
XFILLER_140_404 VDD VSS FILLER1
X_10306_ _10306_/A _10595_/A VDD VSS _10306_/Y NAND2X1
X_18951_ _19171_/CK _18951_/D _18951_/Q VDD VSS DFFQX1
X_14074_ _14093_/A _17964_/C VDD VSS _17968_/B XNOR2X1
XFILLER_4_775 VSS VDD FILLER2
XFILLER_153_798 VDD VSS FILLER4
XFILLER_140_415 VSS VDD FILLER2
X_11286_ _11286_/A _11286_/B VDD VSS _11308_/A AND2X1
XFILLER_152_297 VSS VDD FILLER2
XFILLER_106_692 VDD VSS FILLER4
X_17902_ _17903_/A _17905_/C _17917_/C VDD VSS _17903_/C OAI21X1
X_13025_ _13101_/A _14384_/B VDD VSS _13212_/A NOR2X1
X_10237_ _10313_/B _10237_/B _18624_/Q _11436_/C VDD VSS _10538_/A OAOI211X1
XFILLER_140_459 VSS VDD FILLER2
X_18882_ _18934_/CK _18882_/D _18882_/Q VDD VSS DFFQX1
XFILLER_79_554 VDD VSS FILLER4
XFILLER_121_673 VSS VDD FILLER2
X_17833_ _19930_/Q _19931_/Q _19932_/Q _19933_/Q VDD VSS _17836_/B AND4X2
X_10168_ _10071_/Y _10167_/Y _10224_/A VDD VSS _10174_/B MUXI2X1
XFILLER_121_695 VDD VSS DECAPHV16
XFILLER_94_535 VDD VSS FILLER1
XFILLER_94_557 VSS VDD FILLER2
X_17764_ _19916_/Q _19884_/Q VDD VSS _17766_/D XNOR2X1
XFILLER_82_708 VSS VDD FILLER2
X_14976_ _19423_/Q _14976_/B _14995_/C VDD VSS _15045_/B XNOR3X1
X_10099_ _10099_/A _10101_/C VDD VSS _11414_/C XNOR2X1
XTAP_TAPCELL_ROW_49_457 VDD VSS WELLTAP
X_19503_ _19528_/CK _19503_/D _19503_/Q VDD VSS DFFQX1
X_16715_ _16715_/A _16724_/B VDD VSS _19567_/D NOR2X1
X_13927_ _13978_/A _17940_/B _13978_/C VDD VSS _17937_/A OAI21X1
XFILLER_35_624 VDD VSS FILLER1
X_17695_ _17697_/B _17695_/B VDD VSS _17696_/B XOR2X1
XFILLER_62_421 VDD VSS DECAPHV8
XFILLER_47_495 VDD VSS FILLER4
X_19434_ _19463_/CK _19434_/D _19434_/Q VDD VSS DFFQX1
X_16646_ _19671_/Q _16830_/B VDD VSS _16647_/C NOR2X1
XFILLER_35_668 VSS VDD FILLER2
X_13858_ _19087_/Q _14363_/A _14363_/B VDD VSS _13860_/C NOR3X1
X_19365_ _19412_/CK _19365_/D _19365_/Q VDD VSS DFFQX1
X_12809_ _12809_/A _14380_/B VDD VSS _12913_/A OR2X2
X_16577_ _19605_/Q _16756_/B VDD VSS _16599_/B XNOR2X1
XTAP_TAPCELL_ROW_32_302 VDD VSS WELLTAP
XFILLER_15_370 VSS VDD FILLER2
X_13789_ _19115_/Q _14393_/B VDD VSS _13857_/D XNOR2X1
X_18316_ _18325_/CK _18513_/Q _18316_/Q _18442_/RB VDD VSS DFFRQX1
X_15528_ _15528_/A _15541_/C VDD VSS _15727_/B XNOR2X1
X_19296_ _19331_/CK _19296_/D _19296_/Q VDD VSS DFFQX1
X_18247_ _18256_/CK _18247_/D _18270_/D _18405_/RB VDD VSS DFFRQX1
X_15459_ _15498_/B _15459_/B VDD VSS _18143_/B XNOR2X1
XFILLER_116_401 VSS VDD FILLER2
XFILLER_129_784 VSS VDD FILLER2
X_18178_ _18196_/A _18178_/B VDD VSS _20009_/D NOR2X1
XFILLER_156_570 VSS VDD FILLER2
XFILLER_156_592 VSS VDD FILLER2
XFILLER_128_294 VSS VDD FILLER2
X_17129_ _17132_/A _17132_/B _17164_/C VDD VSS _17130_/C OAI21X1
XFILLER_143_231 VSS VDD FILLER2
XFILLER_104_607 VSS VDD FILLER2
XFILLER_116_478 VDD VSS DECAPHV8
X_20140_ _20140_/A VDD VSS _20140_/Y BUFX3
X_09951_ _09946_/Y _09950_/Y _09938_/A VDD VSS _09952_/B MUXI2X1
XFILLER_131_437 VDD VSS FILLER1
XFILLER_98_830 VDD VSS FILLER4
XFILLER_98_852 VSS VDD FILLER2
X_20071_ clkload7/A _20071_/D _20071_/Q _20071_/RB VDD VSS DFFRQX1
X_09882_ _18567_/Q _09882_/B VDD VSS _09909_/B XOR2X1
XFILLER_106_49 VSS VDD FILLER2
XFILLER_100_802 VDD VSS FILLER4
XFILLER_97_362 VSS VDD FILLER2
XFILLER_57_204 VDD VSS FILLER1
XFILLER_85_579 VDD VSS FILLER4
XFILLER_38_473 VSS VDD FILLER2
XFILLER_66_793 VSS VDD FILLER2
XFILLER_25_101 VSS VDD FILLER2
XTAP_TAPCELL_ROW_83_758 VDD VSS WELLTAP
XFILLER_26_668 VDD VSS FILLER1
XFILLER_80_251 VDD VSS FILLER4
XFILLER_13_318 VSS VDD FILLER2
XFILLER_25_189 VDD VSS FILLER4
XFILLER_41_649 VSS VDD FILLER2
XFILLER_34_690 VDD VSS FILLER1
X_09316_ _18450_/RB _09322_/B VDD VSS _09316_/Y NOR2BX1
XFILLER_40_137 VSS VDD FILLER2
XFILLER_22_852 VSS VDD FILLER2
XFILLER_139_515 VSS VDD FILLER2
XFILLER_139_526 VDD VSS FILLER4
XFILLER_166_312 VSS VDD FILLER2
XFILLER_21_351 VDD VSS FILLER1
X_09247_ _18519_/Q VDD VSS _18338_/D INVX1
XFILLER_31_56 VSS VDD FILLER2
XTAP_TAPCELL_ROW_2_27 VDD VSS WELLTAP
XFILLER_147_581 VDD VSS FILLER4
XFILLER_147_45 VSS VDD FILLER2
XFILLER_5_539 VSS VDD FILLER2
XFILLER_134_220 VSS VDD FILLER2
XFILLER_147_67 VSS VDD FILLER2
XFILLER_134_231 VDD VSS FILLER1
XFILLER_135_765 VDD VSS FILLER4
XFILLER_147_78 VDD VSS FILLER1
XFILLER_162_551 VDD VSS DECAPHV8
XFILLER_135_776 VSS VDD FILLER2
Xoutput12 _20096_/Y VDD VSS o_aux_ctrl[14] BUFX3
Xoutput23 _20098_/Y VDD VSS o_bias_cfg[0] BUFX3
X_11140_ _19960_/Q VDD VSS _11469_/A INVX1
Xoutput34 _20099_/Y VDD VSS o_bias_cfg[1] BUFX3
XFILLER_0_200 VSS VDD FILLER2
Xoutput45 _20100_/Y VDD VSS o_bias_cfg[2] BUFX3
XFILLER_122_437 VDD VSS FILLER4
Xoutput56 _20106_/Y VDD VSS o_bias_cfg[8] BUFX3
XFILLER_122_448 VDD VSS DECAPHV8
Xoutput67 _20151_/Y VDD VSS o_clk_cfg[18] BUFX3
Xoutput78 _20162_/Y VDD VSS o_en_ctrl[10] BUFX3
X_11071_ _11072_/A _11072_/B VDD VSS _11093_/C NOR2X1
XFILLER_0_244 VSS VDD FILLER2
Xoutput89 _20173_/Y VDD VSS o_lf_cfg[10] BUFX3
X_10022_ _10022_/A _10022_/B _10022_/C VDD VSS _10026_/C OAI21X1
XFILLER_130_470 VDD VSS FILLER1
XFILLER_76_535 VSS VDD FILLER2
XFILLER_0_299 VSS VDD FILLER2
XFILLER_102_194 VSS VDD FILLER2
X_14830_ _15015_/B VDD VSS _14881_/B INVX1
XFILLER_29_440 VDD VSS FILLER1
XFILLER_29_451 VDD VSS FILLER4
XFILLER_57_771 VDD VSS FILLER4
X_14761_ _14800_/B _14761_/B VDD VSS _15706_/B XNOR2X1
X_11973_ _11973_/A _11973_/B _11973_/C _11973_/D VDD VSS _12031_/B OAOI211X1
XTAP_TAPCELL_ROW_46_427 VDD VSS WELLTAP
XFILLER_44_421 VSS VDD FILLER2
X_16500_ _19602_/Q _16753_/B VDD VSS _16503_/A XNOR2X1
X_13712_ _19140_/Q _14422_/B VDD VSS _13714_/C _14422_/C NAND3X1
X_10924_ _18647_/Q _18809_/Q VDD VSS _10925_/B NOR2X1
X_14692_ _19332_/Q _15704_/B VDD VSS _14727_/B NOR2X1
X_17480_ _19855_/Q _19823_/Q VDD VSS _17482_/B XOR2X1
XFILLER_72_774 VSS VDD FILLER2
X_16431_ _19663_/Q _16821_/B VDD VSS _16433_/C XNOR2X1
XFILLER_71_273 VDD VSS FILLER1
XFILLER_112_92 VSS VDD FILLER2
X_13643_ _19085_/Q _13643_/B _13716_/C VDD VSS _13781_/B XNOR3X1
X_10855_ _19953_/Q _18835_/Q VDD VSS _10857_/A XOR2X1
XFILLER_71_284 VDD VSS FILLER1
XFILLER_31_126 VSS VDD FILLER2
X_19150_ _19223_/CK _19150_/D _19150_/Q VDD VSS DFFQX1
X_16362_ _16390_/A _16390_/B VDD VSS _16379_/A NAND2X1
X_13574_ _14118_/A _17914_/B VDD VSS _18860_/D NOR2X1
XFILLER_158_824 VDD VSS FILLER4
X_10786_ _19950_/Q _18832_/Q VDD VSS _10790_/B AND2X1
X_18101_ _19287_/Q _18102_/B VDD VSS _18109_/C NOR2BX1
X_15313_ _19540_/Q _15313_/B VDD VSS _15399_/C NOR2BX1
X_12525_ _18933_/Q _12534_/B _14181_/B VDD VSS _14149_/B XNOR3X1
X_16293_ _16320_/B _16293_/B VDD VSS _16816_/B NAND2BX1
X_19081_ _19139_/CK _19081_/D _19081_/Q VDD VSS DFFQX1
XFILLER_9_856 VDD VSS FILLER1
XFILLER_12_395 VDD VSS FILLER1
X_18032_ _18537_/Q _18032_/B VDD VSS _18033_/C NOR2X1
XFILLER_8_366 VSS VDD FILLER2
X_15244_ _15281_/B _15843_/B _19457_/Q VDD VSS _15284_/D NAND3BX1
X_12456_ _12543_/A _12593_/A _12456_/C VDD VSS _12457_/D XNOR3X1
XFILLER_157_389 VDD VSS FILLER1
XFILLER_8_388 VDD VSS FILLER4
XFILLER_126_743 VSS VDD FILLER2
X_11407_ _11422_/A _17990_/B _11407_/C VDD VSS _18601_/D NOR3X1
X_15175_ _19371_/Q VDD VSS _15176_/A INVX1
X_12387_ _12474_/A _12474_/C _12474_/B VDD VSS _14469_/C AO21X2
X_14126_ _14142_/A _14126_/B VDD VSS _18885_/D NOR2X1
X_11338_ _11370_/A _11341_/B VDD VSS _11340_/A NOR2X1
X_19983_ _19986_/CK _19983_/D _19983_/Q VDD VSS DFFQX1
XFILLER_113_426 VSS VDD FILLER2
XFILLER_98_126 VSS VDD FILLER2
XFILLER_140_223 VSS VDD FILLER2
XFILLER_98_137 VSS VDD FILLER2
X_18934_ _18934_/CK _18934_/D _18934_/Q VDD VSS DFFQX1
X_14057_ _14058_/A _14058_/B _14058_/D _14058_/C VDD VSS _14078_/B OAOI211X1
X_11269_ _11269_/A _11276_/B VDD VSS _11274_/B XOR2X1
XFILLER_79_351 VSS VDD FILLER2
XFILLER_140_278 VSS VDD FILLER2
X_13008_ wire156/Y _13008_/B _13008_/C _13008_/D VDD VSS _13097_/B OAOI211X1
XFILLER_95_811 VDD VSS FILLER4
XFILLER_95_822 VDD VSS FILLER1
X_18865_ _18889_/CK _18865_/D _18865_/Q VDD VSS DFFQX1
XFILLER_39_215 VSS VDD FILLER2
X_17816_ _18173_/A _17816_/B VDD VSS _19927_/D NOR2X1
XTAP_TAPCELL_ROW_146_1327 VDD VSS WELLTAP
XFILLER_67_557 VDD VSS FILLER1
XFILLER_55_708 VSS VDD FILLER2
X_18796_ _18799_/CK _18796_/D _18796_/Q VDD VSS DFFQX1
XFILLER_94_354 VSS VDD FILLER2
X_17747_ _17747_/A _17748_/C _17747_/C VDD VSS _19912_/D AOI21X1
X_14959_ _14959_/A _14959_/B _14959_/C _14959_/D VDD VSS _14995_/B OAOI211X1
XFILLER_48_793 VDD VSS FILLER4
X_17678_ _17678_/A _17678_/B _17678_/C VDD VSS _17680_/A OA21X2
X_19417_ _19478_/CK _19417_/D _19417_/Q VDD VSS DFFQX1
XFILLER_23_627 VDD VSS FILLER4
X_16629_ _19607_/Q _16758_/B VDD VSS _16631_/C XOR2X1
XTAP_TAPCELL_ROW_17_162 VDD VSS WELLTAP
XFILLER_90_593 VSS VDD FILLER2
XFILLER_23_649 VSS VDD FILLER2
XFILLER_22_137 VSS VDD FILLER2
X_19348_ _19349_/CK _19348_/D _19348_/Q VDD VSS DFFQX1
XFILLER_149_835 VSS VDD FILLER2
XFILLER_148_323 VSS VDD FILLER2
XTAP_TAPCELL_ROW_157_1423 VDD VSS WELLTAP
X_19279_ _19306_/CK _19279_/D _19279_/Q VDD VSS DFFQX1
XFILLER_31_693 VSS VDD FILLER2
XFILLER_164_816 VSS VDD FILLER2
XFILLER_148_378 VSS VDD FILLER2
XFILLER_163_304 VSS VDD FILLER2
XFILLER_117_710 VSS VDD FILLER2
XFILLER_129_570 VDD VSS FILLER4
XFILLER_117_721 VDD VSS FILLER1
XFILLER_163_348 VDD VSS DECAPHV8
XFILLER_7_80 VDD VSS FILLER4
XFILLER_116_231 VDD VSS FILLER1
XFILLER_144_540 VSS VDD FILLER2
XFILLER_117_15 VDD VSS DECAPHV16
XFILLER_116_253 VSS VDD FILLER2
XTAP_TAPCELL_ROW_112_1017 VDD VSS WELLTAP
XFILLER_116_286 VDD VSS FILLER4
XFILLER_117_48 VDD VSS DECAPHV8
XFILLER_89_126 VSS VDD FILLER2
XFILLER_131_223 VDD VSS FILLER1
XFILLER_104_448 VSS VDD FILLER2
XFILLER_132_757 VDD VSS FILLER4
X_20123_ _20123_/A VDD VSS _20123_/Y BUFX3
XFILLER_77_19 VSS VDD FILLER2
X_09934_ _11396_/A _11396_/B VDD VSS _11398_/C AND2X1
XTAP_TAPCELL_ROW_88_806 VDD VSS WELLTAP
X_20054_ _20054_/CK _20054_/D _20054_/Q _20054_/RB VDD VSS DFFRQX1
X_09865_ _18573_/Q _09872_/B VDD VSS _09871_/B NOR2BX1
XFILLER_98_682 VSS VDD FILLER2
XFILLER_97_170 VSS VDD FILLER2
XFILLER_133_25 VSS VDD FILLER2
XFILLER_58_557 VDD VSS FILLER4
XFILLER_46_708 VDD VSS FILLER4
X_09796_ _18342_/Q _09810_/B VDD VSS _09797_/E NOR2X1
XFILLER_93_18 VSS VDD FILLER2
XFILLER_58_579 VSS VDD FILLER2
XFILLER_45_207 VSS VDD FILLER2
XFILLER_93_29 VDD VSS FILLER1
XFILLER_73_549 VDD VSS FILLER1
XFILLER_26_421 VSS VDD FILLER2
XTAP_TAPCELL_ROW_108_984 VDD VSS WELLTAP
XFILLER_26_443 VSS VDD FILLER2
XTAP_TAPCELL_ROW_123_1124 VDD VSS WELLTAP
X_10640_ _10640_/A _10687_/C _10803_/A VDD VSS _10645_/B OAI21X1
XFILLER_41_468 VDD VSS FILLER4
XFILLER_42_33 VDD VSS FILLER4
XFILLER_42_44 VSS VDD FILLER2
XFILLER_10_822 VDD VSS FILLER1
XTAP_TAPCELL_ROW_51_474 VDD VSS WELLTAP
X_10571_ _10638_/B _10571_/B _10927_/C VDD VSS _10578_/C OR3BX1
XFILLER_158_44 VSS VDD FILLER2
X_12310_ _12329_/A _12329_/B _12311_/D _12329_/E VDD VSS _14468_/B OA211X2
XFILLER_166_153 VDD VSS FILLER4
X_13290_ _13290_/A _13290_/B _13290_/C _13290_/D VDD VSS _13291_/B OAI211X1
XFILLER_6_826 VSS VDD FILLER2
XFILLER_155_849 VDD VSS DECAPHV8
XFILLER_108_721 VSS VDD FILLER2
XFILLER_166_197 VSS VDD FILLER2
X_12241_ _19210_/Q _14501_/B VDD VSS _12303_/C XNOR2X1
XTAP_TAPCELL_ROW_134_1220 VDD VSS WELLTAP
XFILLER_5_336 VDD VSS FILLER1
XFILLER_108_765 VDD VSS FILLER1
XFILLER_135_540 VSS VDD FILLER2
XFILLER_107_253 VDD VSS FILLER4
XFILLER_108_798 VSS VDD FILLER2
X_12172_ _19209_/Q _12172_/B _12224_/C VDD VSS _12218_/B XNOR3X1
XFILLER_123_735 VSS VDD FILLER2
XFILLER_150_521 VDD VSS FILLER4
X_11123_ _11126_/A _11126_/C VDD VSS _11124_/B XNOR2X1
X_16980_ _19750_/Q _17049_/B _16984_/A _16984_/B VDD VSS _16981_/B AOAI211X1
XFILLER_150_565 VDD VSS FILLER4
XFILLER_96_619 VSS VDD FILLER2
XFILLER_150_587 VSS VDD FILLER2
X_15931_ _19610_/Q _16762_/B VDD VSS _15950_/A AND2X1
X_11054_ _11055_/A _11055_/B _11055_/C VDD VSS _11086_/B AO21X2
XFILLER_77_822 VSS VDD FILLER2
XFILLER_103_481 VSS VDD FILLER2
XFILLER_49_535 VDD VSS FILLER4
X_10005_ _10034_/A _10005_/B _10005_/C _11208_/A VDD VSS _10006_/C AOI211X1
X_18650_ _19956_/CK _18650_/D _18650_/Q VDD VSS DFFQX1
X_15862_ _15879_/A _15862_/B VDD VSS _19471_/D AND2X1
XTAP_TAPCELL_ROW_59_541 VDD VSS WELLTAP
XFILLER_67_96 VSS VDD FILLER2
X_17601_ _19881_/Q _19849_/Q VDD VSS _17604_/B XOR2X1
X_14813_ _14813_/A _14813_/B _15802_/B VDD VSS _14911_/A MIN3X1
XFILLER_76_387 VSS VDD FILLER2
X_18581_ _18583_/CK _18581_/D _18581_/Q VDD VSS DFFQX1
XFILLER_64_538 VDD VSS DECAPHV16
X_15793_ _15793_/A _15793_/B VDD VSS _19412_/D AND2X1
XFILLER_123_91 VSS VDD FILLER2
X_17532_ _19866_/Q _19834_/Q _17532_/C VDD VSS _19866_/D AOI21X1
X_14744_ _19501_/Q _15894_/B VDD VSS _14785_/D XOR2X1
XFILLER_17_454 VDD VSS DECAPHV8
X_11956_ _12023_/B _12018_/B VDD VSS _11960_/B XNOR2X1
XFILLER_60_700 VDD VSS FILLER4
XFILLER_72_571 VDD VSS FILLER4
XFILLER_60_711 VSS VDD FILLER2
XFILLER_17_476 VSS VDD FILLER2
X_17463_ _17468_/C _17468_/B VDD VSS _17465_/B NAND2BX1
X_10907_ _10940_/A _10908_/B _11229_/D VDD VSS _10908_/C AOI21X1
XFILLER_60_733 VDD VSS FILLER1
X_14675_ _19498_/Q _15891_/B VDD VSS _14710_/A NOR2BX1
X_11887_ _11933_/A _14525_/B VDD VSS _11980_/B NAND2X1
XTAP_TAPCELL_ROW_141_1279 VDD VSS WELLTAP
XFILLER_44_295 VSS VDD FILLER2
XFILLER_32_435 VDD VSS FILLER1
X_19202_ _19995_/CK _19202_/D _19202_/Q VDD VSS DFFQX1
X_16414_ _16411_/A _16414_/B _16414_/C VDD VSS _16442_/B AOI2B1X1
X_13626_ _13721_/A _13721_/B VDD VSS _14390_/B XNOR2X1
X_10838_ _11039_/C _10838_/B _10838_/C _10838_/D VDD VSS _10840_/B AO211X2
X_17394_ _19837_/Q _19805_/Q VDD VSS _17395_/B XOR2X1
XFILLER_60_788 VSS VDD FILLER2
XFILLER_32_479 VSS VDD FILLER2
XTAP_TAPCELL_ROW_14_143 VDD VSS WELLTAP
XFILLER_158_621 VDD VSS FILLER1
XFILLER_9_620 VDD VSS DECAPHV8
X_19133_ _19134_/CK _19133_/D _19133_/Q VDD VSS DFFQX1
X_16345_ _16345_/A _16364_/B VDD VSS _16818_/B XNOR2X1
X_13557_ _13557_/A _13557_/B _13557_/C VDD VSS _14482_/B OR3X2
X_10769_ _10794_/A _10769_/B VDD VSS _10771_/B XNOR2X1
XFILLER_40_490 VDD VSS FILLER4
XFILLER_158_665 VSS VDD FILLER2
XFILLER_157_153 VSS VDD FILLER2
XFILLER_118_518 VSS VDD FILLER2
XFILLER_146_827 VSS VDD FILLER2
X_19064_ _19094_/CK _19064_/D _19064_/Q VDD VSS DFFQX1
X_12508_ _19073_/Q _12625_/B _12625_/C VDD VSS _12803_/B XNOR3X1
X_16276_ _19721_/Q _16885_/B VDD VSS _16302_/A NOR2X1
X_13488_ _14158_/A _17911_/B VDD VSS _18859_/D AND2X1
XFILLER_145_348 VDD VSS FILLER1
X_18015_ _18529_/Q _18015_/B VDD VSS _18016_/B XOR2X1
X_15227_ _15201_/B _15227_/B VDD VSS _15284_/B NAND2BX1
X_12439_ _18961_/Q VDD VSS _12535_/A INVX1
XFILLER_126_562 VSS VDD FILLER2
XFILLER_99_413 VSS VDD FILLER2
XFILLER_113_201 VSS VDD FILLER2
X_15158_ _19455_/Q _15158_/B _15198_/C VDD VSS _15200_/B XNOR3X1
X_14109_ _17983_/B _17983_/C _18127_/B VDD VSS _18871_/D OA21X2
X_15089_ _15089_/A _15809_/B _15809_/C VDD VSS _15090_/A NOR3X1
X_19966_ _19985_/CK _19966_/D _19966_/Q VDD VSS DFFQX1
XFILLER_99_468 VSS VDD FILLER2
XFILLER_87_619 VDD VSS FILLER4
X_18917_ _18973_/CK _18917_/D _18917_/Q VDD VSS DFFQX1
XFILLER_113_289 VSS VDD FILLER2
X_19897_ clkload2/A _19897_/D _19897_/Q VDD VSS DFFQX1
XFILLER_67_310 VSS VDD FILLER2
X_09650_ _09816_/D _09650_/B _09650_/C _09650_/D VDD VSS _18284_/D OAI211X1
XFILLER_67_343 VSS VDD FILLER2
X_18848_ _18915_/CK _18848_/D _18848_/Q VDD VSS DFFQX1
XFILLER_95_696 VDD VSS FILLER4
XFILLER_83_836 VDD VSS FILLER1
X_09581_ _09581_/A _09581_/B _09818_/C _18260_/Q _09581_/E VDD VSS _09582_/C AOI221X1
XFILLER_55_538 VDD VSS FILLER4
X_18779_ _19940_/CK _18779_/D _18779_/Q VDD VSS DFFQX1
XFILLER_94_195 VSS VDD FILLER2
XFILLER_82_346 VSS VDD FILLER2
XTAP_TAPCELL_ROW_93_853 VDD VSS WELLTAP
XTAP_TAPCELL_ROW_163_1482 VDD VSS WELLTAP
XFILLER_82_379 VSS VDD FILLER2
XTAP_TAPCELL_ROW_105_954 VDD VSS WELLTAP
XTAP_TAPCELL_ROW_65_599 VDD VSS WELLTAP
XFILLER_23_457 VDD VSS FILLER1
XFILLER_23_468 VSS VDD FILLER2
XFILLER_149_632 VDD VSS FILLER1
XFILLER_149_654 VSS VDD FILLER2
XFILLER_50_298 VSS VDD FILLER2
XFILLER_148_142 VSS VDD FILLER2
XFILLER_12_58 VSS VDD FILLER2
XFILLER_136_348 VDD VSS FILLER1
XFILLER_163_145 VSS VDD FILLER2
XFILLER_152_819 VSS VDD FILLER2
XFILLER_163_167 VSS VDD FILLER2
XFILLER_163_189 VSS VDD FILLER2
XFILLER_105_735 VDD VSS FILLER1
XFILLER_2_328 VSS VDD FILLER2
XFILLER_160_830 VSS VDD FILLER2
XFILLER_104_245 VDD VSS FILLER4
XFILLER_132_565 VSS VDD FILLER2
XFILLER_59_800 VDD VSS DECAPHV8
X_20106_ _20106_/A VDD VSS _20106_/Y BUFX3
XFILLER_77_118 VSS VDD FILLER2
X_09917_ _09874_/B _09861_/B _09928_/C VDD VSS _09990_/B MUXI2X1
XFILLER_86_641 VDD VSS FILLER1
XFILLER_58_332 VSS VDD FILLER2
X_20037_ _20045_/CK _20037_/D _20037_/Q _20045_/RB VDD VSS DFFRQX1
XFILLER_100_440 VDD VSS DECAPHV16
X_09848_ _09848_/A VDD VSS _09855_/B INVX1
XFILLER_86_674 VDD VSS FILLER1
XFILLER_74_825 VSS VDD FILLER2
XFILLER_160_12 VSS VDD FILLER2
XFILLER_85_184 VSS VDD FILLER2
X_09779_ _18341_/Q VDD VSS _20095_/A INVX1
XFILLER_37_66 VDD VSS FILLER4
X_11810_ _11854_/B _11820_/B VDD VSS _14397_/B XOR2X1
XFILLER_61_508 VDD VSS FILLER1
X_12790_ _12790_/A _12790_/B _14120_/B VDD VSS _12791_/B MIN3X1
XFILLER_73_379 VSS VDD FILLER2
XFILLER_42_700 VSS VDD FILLER2
XTAP_TAPCELL_ROW_28_268 VDD VSS WELLTAP
X_11741_ _19990_/Q _19254_/Q VDD VSS _11742_/D NAND2X1
Xclkbuf_leaf_2_clk_regs clkbuf_leaf_9_clk_regs/A VDD VSS _19924_/CK BUFX12
X_14460_ _14421_/Y _14460_/B _14460_/C VDD VSS _19174_/D AND3BX1
X_11672_ _18810_/Q _14547_/B VDD VSS _18837_/D AND2X1
XFILLER_42_788 VSS VDD FILLER2
X_13411_ _14323_/A _14323_/B VDD VSS _13416_/B _14323_/C NAND3X1
X_10623_ _10655_/A _10746_/B _10746_/C _11267_/A VDD VSS _10624_/D AOI211X1
X_14391_ _14410_/A _14391_/B _14391_/C VDD VSS _19113_/D NOR3X1
XTAP_TAPCELL_ROW_11_113 VDD VSS WELLTAP
XFILLER_139_153 VDD VSS FILLER4
XFILLER_127_304 VSS VDD FILLER2
X_16130_ _19651_/Q _16808_/B VDD VSS _16131_/C NOR2X1
X_13342_ _13466_/A _13466_/B _13466_/E VDD VSS _13449_/B AOI21X1
X_10554_ _19944_/Q _18826_/Q VDD VSS _10556_/C AND2X1
XFILLER_127_326 VDD VSS FILLER1
XFILLER_5_100 VSS VDD FILLER2
XFILLER_139_197 VDD VSS FILLER4
XFILLER_127_359 VDD VSS FILLER4
X_16061_ _19552_/Q VDD VSS _16062_/A INVX1
X_13273_ _19052_/Q _14323_/B VDD VSS _13274_/D _14322_/C NAND3X1
XFILLER_6_656 VDD VSS DECAPHV8
X_10485_ _18663_/Q _18771_/Q VDD VSS _10521_/C XNOR2X1
XFILLER_154_156 VSS VDD FILLER2
XFILLER_142_318 VDD VSS FILLER4
X_15012_ _15056_/D VDD VSS _15013_/D INVX1
X_12224_ _12401_/A _12401_/B _12224_/C VDD VSS _14500_/C OAI21X1
XFILLER_6_689 VDD VSS DECAPHV8
XFILLER_154_178 VDD VSS FILLER1
XFILLER_108_595 VDD VSS FILLER1
XFILLER_123_521 VSS VDD FILLER2
X_19820_ _19853_/CK _19820_/D _19820_/Q VDD VSS DFFQX1
X_12155_ _12155_/A _14433_/B _12155_/C _12155_/D VDD VSS _12171_/B OAOI211X1
Xclkbuf_2_1__f_sclk_regs clkbuf_0_sclk_regs/Y VDD VSS _20054_/CK BUFX12
X_11106_ _18679_/Q _18787_/Q VDD VSS _11107_/C AND2X1
XFILLER_110_215 VDD VSS DECAPHV8
X_19751_ _19785_/CK _19751_/D _19751_/Q VDD VSS DFFQX1
X_16963_ _19746_/Q _19747_/Q _16978_/B VDD VSS _16973_/D OAI21X1
X_12086_ _19123_/Q _14402_/B VDD VSS _12149_/A NOR2BX1
XFILLER_78_95 VSS VDD FILLER2
XFILLER_68_129 VDD VSS DECAPHV8
X_18702_ _18810_/CK _18702_/D _18702_/Q VDD VSS DFFQX1
XFILLER_110_259 VDD VSS FILLER4
X_15914_ _19898_/Q _19546_/Q VDD VSS _15923_/A NAND2BX1
X_11037_ _11037_/A _11037_/B _11037_/C VDD VSS _11070_/C OAI21X1
X_19682_ _19722_/CK _19682_/D _19682_/Q VDD VSS DFFQX1
X_16894_ _16976_/A _16894_/B VDD VSS _19729_/D NOR2X1
XFILLER_77_685 VSS VDD FILLER2
XFILLER_76_162 VDD VSS FILLER4
X_18633_ _18823_/CK _18633_/D _18633_/Q VDD VSS DFFQX1
X_15845_ _15849_/A _15845_/B VDD VSS _19459_/D AND2X1
XFILLER_37_538 VDD VSS FILLER4
XFILLER_64_335 VSS VDD FILLER2
XFILLER_76_195 VSS VDD FILLER2
X_18564_ _18578_/CK _18564_/D _18564_/Q VDD VSS DFFQX1
XFILLER_18_763 VSS VDD FILLER2
X_15776_ _15806_/A _15776_/B _15776_/C VDD VSS _19397_/D NOR3X1
X_12988_ _18883_/Q VDD VSS _13183_/A INVX1
XFILLER_33_711 VDD VSS FILLER1
X_17515_ _17517_/A _17517_/B _17515_/C VDD VSS _19862_/D AOI21X1
XTAP_TAPCELL_ROW_90_823 VDD VSS WELLTAP
XFILLER_45_582 VSS VDD FILLER2
X_14727_ _14727_/A _14727_/B _15705_/B VDD VSS _14770_/B MIN3X1
X_18495_ _18495_/CK _18495_/D _20108_/A _18498_/RB VDD VSS DFFRQX1
X_11939_ _19121_/Q _11969_/A _11973_/D VDD VSS _12022_/B XNOR3X1
XTAP_TAPCELL_ROW_102_935 VDD VSS WELLTAP
X_17446_ _19847_/Q _19815_/Q _17446_/C VDD VSS _17450_/C MIN3X1
XTAP_TAPCELL_ROW_62_569 VDD VSS WELLTAP
X_14658_ _14658_/A _14658_/B _14739_/B _14658_/D VDD VSS _14659_/B AOI22X1
XFILLER_20_416 VSS VDD FILLER2
X_13609_ _14226_/A wire154/Y _14226_/C _13609_/D VDD VSS _13768_/A OAOI211X1
X_17377_ _17377_/A _17377_/B _17377_/C VDD VSS _17379_/A OA21X2
XFILLER_13_490 VDD VSS FILLER4
X_14589_ _15887_/B _15887_/C _19494_/Q VDD VSS _14601_/D AOI21X1
XFILLER_146_602 VSS VDD FILLER2
XFILLER_146_613 VDD VSS FILLER4
X_19116_ _19196_/CK _19116_/D _19116_/Q VDD VSS DFFQX1
X_16328_ _19723_/Q _16887_/B VDD VSS _16329_/B XNOR2X1
XFILLER_118_337 VSS VDD FILLER2
X_19047_ _19072_/CK _19047_/D _19047_/Q VDD VSS DFFQX1
X_16259_ _19561_/Q _19913_/Q VDD VSS _16260_/B XNOR2X1
XFILLER_161_627 VSS VDD FILLER2
XFILLER_145_189 VDD VSS FILLER4
XFILLER_142_830 VSS VDD FILLER2
XFILLER_99_221 VSS VDD FILLER2
XFILLER_160_137 VSS VDD FILLER2
XFILLER_114_543 VSS VDD FILLER2
XFILLER_99_254 VDD VSS FILLER1
XFILLER_114_576 VDD VSS FILLER4
XFILLER_99_276 VSS VDD FILLER2
XFILLER_114_598 VDD VSS FILLER4
X_19949_ _19949_/CK _19949_/D _19949_/Q VDD VSS DFFQX1
XTAP_TAPCELL_ROW_165_1500 VDD VSS WELLTAP
X_09702_ _18352_/Q VDD VSS _20220_/A INVX1
XFILLER_56_814 VSS VDD FILLER2
XFILLER_114_49 VDD VSS FILLER4
XFILLER_67_151 VDD VSS FILLER1
XFILLER_56_825 VSS VDD FILLER2
XFILLER_110_782 VSS VDD FILLER2
XFILLER_55_313 VDD VSS DECAPHV8
XFILLER_110_793 VSS VDD FILLER2
X_09633_ _20184_/A _09753_/A _09633_/C VDD VSS _09634_/E AOI2B1X1
XFILLER_67_184 VSS VDD FILLER2
X_09564_ _09630_/C _18505_/Q _18506_/Q VDD VSS _09767_/B NOR3BX1
XFILLER_24_700 VDD VSS FILLER4
XFILLER_130_26 VSS VDD FILLER2
XFILLER_36_571 VSS VDD FILLER2
X_09495_ _18444_/D _09501_/B _09495_/C VDD VSS _18237_/D AOI21X1
XFILLER_36_593 VSS VDD FILLER2
XFILLER_51_530 VSS VDD FILLER2
XTAP_TAPCELL_ROW_25_238 VDD VSS WELLTAP
XFILLER_24_777 VSS VDD FILLER2
XFILLER_23_265 VSS VDD FILLER2
XFILLER_51_585 VDD VSS FILLER1
XFILLER_23_46 VDD VSS FILLER1
XFILLER_137_602 VDD VSS DECAPHV16
XFILLER_139_24 VSS VDD FILLER2
XFILLER_109_304 VDD VSS FILLER1
XFILLER_164_421 VDD VSS FILLER4
XFILLER_136_123 VDD VSS FILLER4
XFILLER_139_79 VSS VDD FILLER2
XFILLER_109_359 VSS VDD FILLER2
XFILLER_164_454 VSS VDD FILLER2
XFILLER_124_318 VDD VSS FILLER1
XTAP_TAPCELL_ROW_118_1078 VDD VSS WELLTAP
XFILLER_152_638 VDD VSS DECAPHV8
X_10270_ _10346_/A _10655_/A VDD VSS _10585_/C _10349_/B _10346_/B NAND4X2
XFILLER_151_148 VSS VDD FILLER2
XFILLER_132_351 VSS VDD FILLER2
XFILLER_78_416 VSS VDD FILLER2
XFILLER_78_427 VDD VSS FILLER1
XFILLER_78_449 VDD VSS FILLER4
XFILLER_120_557 VSS VDD FILLER2
X_13960_ _14004_/A _14004_/B VDD VSS _13970_/B NOR2X1
XFILLER_47_803 VSS VDD FILLER2
XFILLER_101_771 VSS VDD FILLER2
XFILLER_47_825 VSS VDD FILLER2
XFILLER_101_782 VDD VSS FILLER4
XFILLER_86_471 VDD VSS FILLER4
X_12911_ _14382_/B _14382_/C _19104_/Q VDD VSS _12913_/C AOI21X1
XFILLER_100_270 VDD VSS FILLER1
XFILLER_86_493 VSS VDD FILLER2
X_13891_ _13891_/A _13891_/B _13891_/C _13891_/D VDD VSS _13998_/A AOAI211X1
XTAP_TAPCELL_ROW_129_1174 VDD VSS WELLTAP
XFILLER_73_121 VSS VDD FILLER2
XFILLER_0_39 VDD VSS FILLER4
XFILLER_46_346 VSS VDD FILLER2
XFILLER_73_132 VDD VSS FILLER1
X_15630_ _15637_/A _15637_/B VDD VSS _15700_/B XNOR2X1
XFILLER_64_20 VSS VDD FILLER2
X_12842_ _12945_/A _12968_/A _12951_/B VDD VSS _12843_/D XNOR3X1
X_15561_ _15561_/A _15564_/C VDD VSS _18155_/B XNOR2X1
XFILLER_73_198 VSS VDD FILLER2
XFILLER_14_221 VDD VSS FILLER4
X_12773_ _12936_/A _12940_/B _12773_/C VDD VSS _12822_/B XNOR3X1
XFILLER_64_86 VSS VDD FILLER2
X_17300_ _17450_/B _17300_/B _17300_/C VDD VSS _17305_/C MIN3X1
X_14512_ _14539_/A _14512_/B VDD VSS _19219_/D NOR2X1
X_18280_ _18295_/CK _18280_/D _18280_/Q VDD VSS DFFQX1
X_11724_ _11724_/A _11724_/B _11724_/C _11724_/D VDD VSS _11778_/A OAOI211X1
XFILLER_14_265 VSS VDD FILLER2
X_15492_ _15492_/A _15492_/B _15492_/C VDD VSS _15493_/B NOR3X1
X_17231_ _17838_/A VDD VSS _17306_/C BUFX3
XFILLER_14_298 VSS VDD FILLER2
X_14443_ _14449_/A _14443_/B _14443_/C VDD VSS _19159_/D NOR3X1
X_11655_ _18795_/Q _11658_/B VDD VSS _18822_/D AND2X1
XFILLER_30_769 VSS VDD FILLER2
XFILLER_128_613 VDD VSS FILLER1
X_17162_ _19787_/Q _19755_/Q VDD VSS _17168_/B NAND2X1
X_10606_ _10633_/A _10633_/B _10607_/C _10686_/D VDD VSS _10607_/D AOAI211X1
X_14374_ _14393_/A _14374_/B VDD VSS _19097_/D NOR2X1
X_11586_ _18732_/Q _11589_/B VDD VSS _18759_/D AND2X1
X_16113_ _19555_/Q _19907_/Q VDD VSS _16114_/B XNOR2X1
XFILLER_127_145 VSS VDD FILLER2
X_13325_ _19110_/Q VDD VSS _13436_/A INVX1
X_10537_ _10843_/A _10701_/C VDD VSS _10844_/C NOR2X1
XFILLER_10_493 VSS VDD FILLER2
X_17093_ _19773_/Q _19741_/Q VDD VSS _17094_/B XOR2X1
XFILLER_127_189 VSS VDD FILLER2
XFILLER_143_638 VDD VSS FILLER4
X_16044_ _19648_/Q _16805_/B VDD VSS _16057_/B XOR2X1
XFILLER_143_649 VSS VDD FILLER2
X_13256_ _13260_/A _13343_/A VDD VSS _14543_/B XNOR2X1
X_10468_ _10503_/A _10503_/B _10595_/A VDD VSS _10469_/B OAI21X1
XFILLER_142_137 VSS VDD FILLER2
XFILLER_124_852 VDD VSS FILLER4
X_12207_ _12283_/A _12283_/B _14342_/B VDD VSS _12512_/B MIN3X1
XFILLER_43_6 VSS VDD FILLER2
X_13187_ _13295_/A _13295_/B VDD VSS _14190_/B _13295_/C NAND3X1
XFILLER_123_351 VSS VDD FILLER2
X_10399_ _10399_/A _10399_/B _10399_/C _10399_/D VDD VSS _10441_/B AOAI211X1
X_19803_ clkload4/A _19803_/D _19803_/Q VDD VSS DFFQX1
X_12138_ _12284_/A _12284_/B _14339_/B VDD VSS _12188_/A MIN3X1
XFILLER_123_384 VDD VSS FILLER1
XFILLER_97_747 VDD VSS FILLER4
XFILLER_123_395 VDD VSS FILLER1
X_17995_ _18535_/Q _18536_/Q VDD VSS _18032_/B _18030_/B AND3X2
XFILLER_96_235 VSS VDD FILLER2
XFILLER_1_180 VDD VSS FILLER4
XFILLER_111_579 VSS VDD FILLER2
X_16946_ _19744_/Q VDD VSS _17114_/B INVX1
X_19734_ _19734_/CK _19734_/D _19734_/Q VDD VSS DFFQX1
X_12069_ _18927_/Q _14175_/B VDD VSS _12129_/B NOR2X1
XFILLER_84_408 VDD VSS FILLER1
XTAP_TAPCELL_ROW_67_617 VDD VSS WELLTAP
XFILLER_38_825 VSS VDD FILLER2
X_19665_ _19667_/CK _19665_/D _19665_/Q VDD VSS DFFQX1
XFILLER_49_184 VSS VDD FILLER2
X_16877_ _17391_/A VDD VSS _16891_/A BUFX3
X_18616_ _18622_/CK _18616_/D _18616_/Q VDD VSS DFFQX1
X_15828_ _15830_/A _15828_/B VDD VSS _19443_/D NOR2X1
XFILLER_65_677 VDD VSS FILLER4
X_19596_ _19661_/CK _19596_/D _19596_/Q VDD VSS DFFQX1
XTAP_TAPCELL_ROW_9_91 VDD VSS WELLTAP
X_18547_ _18550_/CK _18547_/D _18547_/Q VDD VSS DFFQX1
XTAP_TAPCELL_ROW_160_1452 VDD VSS WELLTAP
XFILLER_18_593 VSS VDD FILLER2
X_15759_ _15770_/A _15759_/B VDD VSS _19382_/D AND2X1
XFILLER_52_349 VSS VDD FILLER2
XFILLER_61_850 VSS VDD FILLER2
X_09280_ _09284_/AB _09362_/B VDD VSS _09280_/Y NOR2BX1
X_18478_ _18479_/CK _18478_/D _18478_/Q _18498_/RB VDD VSS DFFRQX1
XFILLER_21_714 VSS VDD FILLER2
XTAP_TAPCELL_ROW_22_208 VDD VSS WELLTAP
X_17429_ _17431_/A _17431_/B _17429_/C VDD VSS _19844_/D AOI21X1
XFILLER_21_747 VDD VSS DECAPHV8
XFILLER_60_393 VDD VSS FILLER4
XFILLER_166_719 VDD VSS FILLER1
XFILLER_20_235 VDD VSS FILLER4
XFILLER_20_257 VDD VSS FILLER4
XFILLER_146_421 VSS VDD FILLER2
XFILLER_119_646 VDD VSS FILLER4
XTAP_TAPCELL_ROW_30_285 VDD VSS WELLTAP
XFILLER_9_291 VSS VDD FILLER2
XFILLER_134_616 VSS VDD FILLER2
XFILLER_161_402 VDD VSS FILLER1
Xclkload50 _19126_/CK VDD VSS clkload50/Y BUFX12
XFILLER_134_638 VDD VSS FILLER4
Xclkload61 _19059_/CK VDD VSS clkload61/Y INVX2
Xclkload72 clkload72/A VDD VSS clkload72/Y INVX16
Xclkload83 _19349_/CK VDD VSS clkload83/Y BUFX12
Xclkload94 _19667_/CK VDD VSS clkload94/Y INVX2
XFILLER_161_468 VSS VDD FILLER2
XFILLER_114_351 VDD VSS FILLER4
XFILLER_88_714 VSS VDD FILLER2
XFILLER_0_629 VDD VSS FILLER1
XFILLER_130_822 VSS VDD FILLER2
XFILLER_125_26 VDD VSS FILLER4
XFILLER_142_682 VDD VSS FILLER1
XFILLER_114_384 VSS VDD FILLER2
XFILLER_125_37 VSS VDD FILLER2
XFILLER_141_170 VSS VDD FILLER2
XFILLER_142_693 VDD VSS FILLER4
XFILLER_87_268 VSS VDD FILLER2
XFILLER_75_408 VSS VDD FILLER2
XFILLER_68_493 VSS VDD FILLER2
XFILLER_18_68 VSS VDD FILLER2
X_09616_ _18426_/Q _09696_/B _09616_/C _09729_/D VDD VSS _09617_/E OAOI211X1
XFILLER_44_817 VDD VSS FILLER4
XFILLER_18_79 VDD VSS FILLER1
XFILLER_141_58 VDD VSS FILLER4
XFILLER_83_463 VSS VDD FILLER2
XTAP_TAPCELL_ROW_38_352 VDD VSS WELLTAP
X_09547_ _20041_/Q _09547_/B VDD VSS _20042_/D NOR2BX1
X_09964__235 _20054_/CK VDD VSS _18511_/CK INVX1
XFILLER_36_390 VSS VDD FILLER2
XFILLER_24_530 VDD VSS FILLER1
XFILLER_52_850 VSS VDD FILLER2
XFILLER_34_23 VSS VDD FILLER2
X_09478_ _19978_/Q _09490_/B _09482_/C VDD VSS _09479_/C AOI21X1
XFILLER_70_179 VSS VDD FILLER2
XFILLER_51_360 VSS VDD FILLER2
XFILLER_51_371 VDD VSS FILLER1
XFILLER_51_382 VSS VDD FILLER2
XFILLER_8_707 VDD VSS FILLER4
XFILLER_8_718 VDD VSS FILLER4
Xclkload0 _231_/CK VDD VSS clkload0/Y INVX1
X_11440_ _13177_/A _11440_/B VDD VSS _18629_/D NOR2X1
XFILLER_137_421 VSS VDD FILLER2
XFILLER_109_123 VDD VSS FILLER1
XFILLER_50_33 VDD VSS FILLER4
XFILLER_50_44 VSS VDD FILLER2
Xwire159 wire159/A VDD VSS wire159/Y BUFX4
X_11371_ _11365_/B _11371_/B VDD VSS _11379_/C NOR2BX1
XFILLER_50_66 VSS VDD FILLER2
XFILLER_125_616 VSS VDD FILLER2
XFILLER_152_402 VDD VSS FILLER4
XFILLER_166_44 VDD VSS FILLER1
X_13110_ _19162_/Q _14446_/B VDD VSS _13111_/D _14446_/C NAND3X1
X_10322_ _18659_/Q _18767_/Q VDD VSS _10323_/D XNOR2X1
XFILLER_109_189 VSS VDD FILLER2
XFILLER_137_498 VSS VDD FILLER2
X_14090_ _18898_/Q _14096_/A _14104_/B VDD VSS _14093_/D XNOR3X1
XFILLER_124_137 VSS VDD FILLER2
XFILLER_106_841 VSS VDD FILLER2
X_13041_ _13041_/A _14413_/B _13041_/C _13041_/D VDD VSS _13316_/A OAOI211X1
X_10253_ _18623_/Q _18624_/Q _11436_/C VDD VSS _10269_/D OAI21X1
XFILLER_152_479 VSS VDD FILLER2
XFILLER_79_747 VSS VDD FILLER2
X_10184_ _10184_/A _10184_/B _10184_/C VDD VSS _10188_/B AOI21X1
XFILLER_120_321 VDD VSS FILLER4
XFILLER_78_235 VSS VDD FILLER2
X_16800_ _16811_/A _16800_/B VDD VSS _19643_/D NOR2X1
XFILLER_78_257 VSS VDD FILLER2
XFILLER_120_354 VSS VDD FILLER2
X_17780_ _19920_/Q _19888_/Q VDD VSS _17785_/A XNOR2X1
X_14992_ _19367_/Q _14992_/B _15743_/B VDD VSS _15039_/B MIN3X1
XFILLER_59_460 VDD VSS FILLER4
XFILLER_115_70 VSS VDD FILLER2
X_16731_ _16735_/A _16731_/B VDD VSS _19582_/D NOR2X1
X_13943_ _18921_/Q _14168_/B VDD VSS _14020_/A AND2X1
XFILLER_19_335 VSS VDD FILLER2
XFILLER_19_357 VSS VDD FILLER2
X_19450_ _19478_/CK _19450_/D _19450_/Q VDD VSS DFFQX1
X_16662_ _16672_/B _16662_/B VDD VSS _16669_/A XNOR2X1
X_13874_ _14132_/A _14132_/B _14132_/C _13874_/D VDD VSS _13938_/A OAOI211X1
XFILLER_75_96 VDD VSS FILLER4
XFILLER_74_474 VSS VDD FILLER2
XFILLER_35_828 VSS VDD FILLER2
XFILLER_62_625 VSS VDD FILLER2
X_18401_ _18406_/CK _18518_/Q _20142_/A _18450_/RB VDD VSS DFFRQX1
XFILLER_61_102 VSS VDD FILLER2
X_15613_ _19327_/Q _15699_/B VDD VSS _15614_/C AND2X1
X_19381_ _19412_/CK _19381_/D _19381_/Q VDD VSS DFFQX1
X_12825_ _19133_/Q VDD VSS _12938_/A INVX1
XFILLER_61_124 VSS VDD FILLER2
X_16593_ _16620_/A _16620_/B VDD VSS _16613_/A NAND2X1
XFILLER_131_91 VSS VDD FILLER2
X_18332_ _18343_/CK _18513_/Q _20086_/A _18374_/RB VDD VSS DFFRQX1
XFILLER_15_552 VDD VSS FILLER4
X_15544_ _19436_/Q _15821_/B VDD VSS _15552_/A NOR2BX1
XTAP_TAPCELL_ROW_72_664 VDD VSS WELLTAP
X_12756_ _12763_/A _12763_/B _12763_/C _12763_/D VDD VSS _14537_/B OA211X2
XFILLER_70_680 VSS VDD FILLER2
X_18263_ _18268_/CK _18263_/D _18263_/Q _18469_/RB VDD VSS DFFRQX1
X_11707_ _11724_/A _11724_/B VDD VSS _11709_/B NOR2X1
XFILLER_42_393 VSS VDD FILLER2
X_15475_ _19544_/Q _15475_/B VDD VSS _15476_/B NAND2X1
XFILLER_30_544 VSS VDD FILLER2
X_12687_ _19131_/Q _12813_/B _12813_/C VDD VSS _12910_/B XNOR3X1
X_17214_ _17215_/B _17214_/B VDD VSS _17216_/B NOR2BX1
X_14426_ _14426_/A _14426_/B VDD VSS _19144_/D NOR2X1
X_18194_ _18194_/A VDD VSS _18195_/B INVX1
X_11638_ _18779_/Q _11647_/B VDD VSS _18806_/D AND2X1
XFILLER_128_421 VSS VDD FILLER2
XFILLER_128_443 VSS VDD FILLER2
X_17145_ _17147_/C _17145_/B _17145_/C VDD VSS _19783_/D AOI21X1
X_14357_ _17566_/A VDD VSS _14410_/A BUFX3
XFILLER_10_290 VSS VDD FILLER2
XFILLER_116_616 VSS VDD FILLER2
X_11569_ _18716_/Q _11578_/B VDD VSS _18743_/D AND2X1
XFILLER_143_402 VSS VDD FILLER2
XFILLER_7_773 VDD VSS FILLER4
XFILLER_156_785 VDD VSS FILLER4
X_13308_ _13308_/A _14259_/B _14259_/C VDD VSS _13309_/D NOR3X1
XFILLER_155_284 VDD VSS FILLER1
XFILLER_115_126 VSS VDD FILLER2
XFILLER_116_649 VSS VDD FILLER2
X_17076_ _17077_/C _17469_/B _17076_/C VDD VSS _19768_/D AND3BX1
X_14288_ _14457_/A VDD VSS _14311_/A BUFX3
XFILLER_131_608 VDD VSS FILLER4
XFILLER_143_468 VDD VSS FILLER4
X_16027_ _16100_/A _16027_/B VDD VSS _19519_/D NOR2X1
X_13239_ _13339_/A _13345_/A _13343_/A VDD VSS _13240_/D XNOR3X1
XFILLER_112_800 VDD VSS DECAPHV8
XFILLER_124_660 VDD VSS DECAPHV8
XFILLER_124_682 VDD VSS DECAPHV8
XFILLER_111_354 VDD VSS DECAPHV16
XFILLER_97_577 VSS VDD FILLER2
XFILLER_69_268 VSS VDD FILLER2
X_17978_ _18871_/Q _17978_/B _17978_/C VDD VSS _17980_/B XNOR3X1
XTAP_TAPCELL_ROW_149_1358 VDD VSS WELLTAP
XFILLER_38_600 VDD VSS FILLER4
X_16929_ _19741_/Q _17078_/B VDD VSS _16931_/B XOR2X1
X_19717_ _19730_/CK _19717_/D _19717_/Q VDD VSS DFFQX1
XFILLER_65_463 VSS VDD FILLER2
X_19648_ _19722_/CK _19648_/D _19648_/Q VDD VSS DFFQX1
XFILLER_93_794 VSS VDD FILLER2
XFILLER_65_485 VSS VDD FILLER2
X_09401_ _18006_/C VDD VSS _18087_/D BUFX3
XFILLER_111_17 VSS VDD FILLER2
X_19579_ _19636_/CK _19579_/D _19579_/Q VDD VSS DFFQX1
XFILLER_53_658 VSS VDD FILLER2
XFILLER_52_146 VSS VDD FILLER2
XFILLER_80_466 VDD VSS DECAPHV8
X_09332_ _18286_/Q _18514_/Q _09354_/B VDD VSS _09332_/Y MUXI2X1
XFILLER_52_179 VSS VDD FILLER2
XFILLER_33_382 VSS VDD FILLER2
X_09263_ _09299_/A VDD VSS _09354_/B BUFX3
XFILLER_60_190 VDD VSS FILLER4
X_09194_ _18517_/Q VDD VSS _18448_/D INVX1
XFILLER_166_549 VDD VSS DECAPHV32
XFILLER_119_443 VSS VDD FILLER2
XFILLER_147_774 VDD VSS FILLER1
XFILLER_162_700 VSS VDD FILLER2
XFILLER_107_616 VDD VSS FILLER1
XFILLER_119_476 VDD VSS FILLER4
XFILLER_134_402 VSS VDD FILLER2
XFILLER_106_115 VDD VSS FILLER1
XFILLER_107_649 VSS VDD FILLER2
XFILLER_161_210 VSS VDD FILLER2
XTAP_TAPCELL_ROW_115_1048 VDD VSS WELLTAP
XFILLER_162_777 VSS VDD FILLER2
XFILLER_161_243 VDD VSS FILLER4
XFILLER_161_254 VSS VDD FILLER2
XFILLER_161_276 VSS VDD FILLER2
XFILLER_96_18 VDD VSS FILLER1
XFILLER_121_129 VDD VSS FILLER4
XFILLER_96_29 VSS VDD FILLER2
XFILLER_0_426 VSS VDD FILLER2
XFILLER_103_833 VDD VSS FILLER4
XFILLER_115_693 VDD VSS FILLER4
XFILLER_0_448 VSS VDD FILLER2
XFILLER_0_459 VSS VDD FILLER2
XFILLER_88_566 VSS VDD FILLER2
XFILLER_130_663 VDD VSS FILLER4
XFILLER_152_13 VSS VDD FILLER2
XFILLER_76_739 VDD VSS FILLER4
XFILLER_69_780 VSS VDD FILLER2
XFILLER_75_238 VSS VDD FILLER2
XFILLER_75_249 VDD VSS FILLER1
XFILLER_56_430 VSS VDD FILLER2
XFILLER_28_132 VSS VDD FILLER2
XFILLER_56_452 VSS VDD FILLER2
X_10940_ _10940_/A _10940_/B _10940_/C _10940_/D VDD VSS _10978_/C AOI211X1
XTAP_TAPCELL_ROW_86_789 VDD VSS WELLTAP
XFILLER_17_828 VSS VDD FILLER2
XTAP_TAPCELL_ROW_126_1144 VDD VSS WELLTAP
XFILLER_28_165 VDD VSS FILLER4
XFILLER_56_485 VSS VDD FILLER2
XFILLER_83_282 VSS VDD FILLER2
XFILLER_44_658 VSS VDD FILLER2
X_10871_ _10871_/A _10871_/B _10871_/C _10871_/D VDD VSS _10899_/C AOI31X1
XFILLER_71_455 VDD VSS FILLER1
XFILLER_45_88 VDD VSS FILLER4
X_12610_ _12610_/A _12610_/B _14115_/B VDD VSS _12611_/B MIN3X1
XFILLER_31_319 VSS VDD FILLER2
X_13590_ _18916_/Q _14162_/B _14162_/C VDD VSS _13591_/D OR3BX1
XFILLER_101_50 VSS VDD FILLER2
XFILLER_24_371 VSS VDD FILLER2
X_12541_ _12632_/A _12632_/B VDD VSS _12598_/B NOR2X1
XFILLER_24_393 VSS VDD FILLER2
XFILLER_40_853 VDD VSS FILLER4
X_15260_ _19373_/Q _15260_/B _15750_/B VDD VSS _15303_/B MIN3X1
X_12472_ _12472_/A _12472_/B _12472_/C _12472_/D VDD VSS _14439_/B AOAI211X1
XFILLER_157_549 VDD VSS FILLER1
XFILLER_138_752 VDD VSS DECAPHV16
X_14211_ _14231_/A _14211_/B VDD VSS _18960_/D AND2X1
X_11423_ _17812_/A VDD VSS _14163_/A BUFX3
X_15191_ _15191_/A _15191_/B _15191_/C _15191_/D VDD VSS _15275_/C OAI211X1
Xdelaybuf_6_clk delaybuf_6_clk/A VDD VSS delaybuf_7_clk/A BUFX12
XANTENNA_9 _17469_/B VDD VSS ANTENNA2
XFILLER_6_49 VSS VDD FILLER2
XFILLER_165_582 VSS VDD FILLER2
X_14142_ _14142_/A _14142_/B VDD VSS _18899_/D NOR2X1
X_11354_ _11383_/A _11354_/B VDD VSS _18589_/D NOR2X1
XFILLER_153_766 VDD VSS FILLER1
X_10305_ _10546_/A _10546_/B VDD VSS _10595_/A NAND2X1
XFILLER_125_468 VSS VDD FILLER2
XFILLER_125_479 VDD VSS DECAPHV8
X_18950_ _19115_/CK _18950_/D _18950_/Q VDD VSS DFFQX1
X_14073_ _18897_/Q _14073_/B _14078_/C VDD VSS _17964_/C XNOR3X1
X_11285_ _11285_/A _11285_/B _11285_/C VDD VSS _11296_/B OAI21X1
XFILLER_79_500 VSS VDD FILLER2
XFILLER_152_287 VSS VDD FILLER2
XFILLER_112_129 VDD VSS FILLER1
X_17901_ _18857_/Q _17901_/B _17901_/C VDD VSS _17905_/C MIN3X1
X_13024_ _13314_/A _13314_/B VDD VSS _14384_/B XNOR2X1
X_10236_ _18623_/Q _11435_/B VDD VSS _10237_/B NOR2BX1
XFILLER_140_449 VSS VDD FILLER2
X_18881_ _18934_/CK _18881_/D _18881_/Q VDD VSS DFFQX1
XFILLER_121_641 VSS VDD FILLER2
XFILLER_121_663 VSS VDD FILLER2
X_17832_ _19930_/Q _19931_/Q _19932_/Q _19933_/Q VDD VSS _17834_/B AOI31X1
XFILLER_67_717 VDD VSS FILLER4
X_10167_ _10167_/A _10167_/B _10167_/C VDD VSS _10167_/Y OAI21X1
XFILLER_94_514 VSS VDD FILLER2
X_17763_ _17766_/A _17763_/B _17763_/C VDD VSS _19915_/D AOI21X1
X_14975_ _19451_/Q _14975_/B _15000_/C VDD VSS _14995_/C XNOR3X1
X_10098_ _18607_/Q _10098_/B _10098_/C VDD VSS _10101_/C OAI21X1
XFILLER_66_249 VSS VDD FILLER2
XTAP_TAPCELL_ROW_49_458 VDD VSS WELLTAP
X_16714_ _17776_/A _16724_/B VDD VSS _19566_/D NOR2X1
X_19502_ _19528_/CK _19502_/D _19502_/Q VDD VSS DFFQX1
XFILLER_75_761 VSS VDD FILLER2
X_13926_ _18893_/Q _13931_/B _13981_/D VDD VSS _13978_/C XNOR3X1
XFILLER_47_463 VSS VDD FILLER2
X_17694_ _19901_/Q _19869_/Q VDD VSS _17695_/B XOR2X1
XFILLER_74_260 VDD VSS FILLER4
XFILLER_74_271 VSS VDD FILLER2
X_19433_ _19460_/CK _19433_/D _19433_/Q VDD VSS DFFQX1
XFILLER_74_282 VDD VSS FILLER1
X_16645_ _16638_/B _16645_/B _16645_/C VDD VSS _16670_/B AOI2B1X1
X_13857_ _13857_/A _13857_/B _13857_/C _13857_/D VDD VSS _14363_/B OAOI211X1
XFILLER_90_764 VSS VDD FILLER2
X_19364_ _19379_/CK _19364_/D _19364_/Q VDD VSS DFFQX1
X_12808_ _12821_/A _12821_/B _12821_/C VDD VSS _14349_/B OAI21X1
XFILLER_34_168 VDD VSS FILLER1
X_16576_ _16602_/C _16576_/B VDD VSS _16756_/B XNOR2X1
X_13788_ _13791_/A _13791_/C _13791_/B _13788_/D VDD VSS _14393_/B OAOI211X1
XTAP_TAPCELL_ROW_32_303 VDD VSS WELLTAP
XFILLER_31_820 VSS VDD FILLER2
X_18315_ _18327_/CK _18512_/Q _18315_/Q _18471_/RB VDD VSS DFFRQX1
XFILLER_96_4 VDD VSS FILLER4
X_15527_ _15540_/A _15757_/B VDD VSS _15541_/C XNOR2X1
XFILLER_148_505 VDD VSS FILLER4
X_19295_ _19331_/CK _19295_/D _19295_/Q VDD VSS DFFQX1
X_12739_ _12747_/A _12739_/B _12739_/C VDD VSS _12816_/C XNOR3X1
XTAP_TAPCELL_ROW_6_70 VDD VSS WELLTAP
X_18246_ _18256_/CK _18246_/D _18271_/D _18486_/RB VDD VSS DFFRQX1
X_15458_ _19322_/Q _15693_/B VDD VSS _15459_/B XNOR2X1
X_14409_ _14410_/A _14409_/B _14409_/C VDD VSS _19130_/D NOR3X1
XFILLER_144_700 VSS VDD FILLER2
X_18177_ _18179_/C _18177_/B VDD VSS _18178_/B XNOR2X1
X_15389_ _15389_/A _15389_/B _15389_/C VDD VSS _15427_/A OAI21X1
X_17128_ _19779_/Q _19747_/Q _17128_/C VDD VSS _17132_/B MIN3X1
XFILLER_116_435 VDD VSS FILLER1
XFILLER_7_592 VSS VDD FILLER2
XFILLER_144_788 VSS VDD FILLER2
X_17059_ _17208_/B _17062_/C _17059_/C VDD VSS _17060_/B MIN3X1
X_09950_ _09897_/Y _09949_/Y _10032_/A VDD VSS _09950_/Y MUXI2X1
XFILLER_144_799 VDD VSS FILLER4
X_20070_ clkload7/A _20070_/D _20070_/Q _20071_/RB VDD VSS DFFRQX1
XFILLER_106_28 VSS VDD FILLER2
X_09881_ _18566_/Q _09881_/B VDD VSS _09882_/B NAND2X1
XFILLER_112_663 VSS VDD FILLER2
XFILLER_58_717 VSS VDD FILLER2
XFILLER_111_140 VSS VDD FILLER2
XFILLER_57_216 VDD VSS FILLER1
XFILLER_111_173 VDD VSS FILLER4
XFILLER_57_227 VDD VSS FILLER4
XFILLER_57_238 VSS VDD FILLER2
XFILLER_26_603 VDD VSS FILLER1
Xclkbuf_2_3__f__001_ clkbuf_0__001_/Y VDD VSS clkload33/A BUFX12
XFILLER_72_219 VSS VDD FILLER2
XFILLER_122_49 VSS VDD FILLER2
XFILLER_81_731 VDD VSS DECAPHV8
XFILLER_65_282 VDD VSS FILLER4
XFILLER_38_496 VDD VSS FILLER4
XFILLER_81_742 VSS VDD FILLER2
XTAP_TAPCELL_ROW_83_759 VDD VSS WELLTAP
XFILLER_14_809 VSS VDD FILLER2
XFILLER_80_230 VSS VDD FILLER2
XFILLER_15_25 VSS VDD FILLER2
XFILLER_40_105 VDD VSS FILLER4
XFILLER_15_47 VSS VDD FILLER2
X_09315_ _18404_/D _09314_/Y _09302_/Y VDD VSS _18521_/D MUXI2X1
XFILLER_15_69 VSS VDD FILLER2
XFILLER_139_505 VDD VSS FILLER1
XFILLER_40_149 VSS VDD FILLER2
XFILLER_166_302 VDD VSS FILLER1
X_09246_ _18499_/D VDD VSS _18339_/D INVX1
XFILLER_21_385 VSS VDD FILLER2
XFILLER_119_240 VDD VSS FILLER1
XFILLER_147_571 VSS VDD FILLER2
XTAP_TAPCELL_ROW_2_28 VDD VSS WELLTAP
XFILLER_5_529 VDD VSS FILLER4
XFILLER_135_733 VSS VDD FILLER2
XFILLER_119_284 VDD VSS FILLER1
XFILLER_107_435 VSS VDD FILLER2
XFILLER_107_468 VSS VDD FILLER2
Xoutput13 _20097_/Y VDD VSS o_aux_ctrl[15] BUFX3
XFILLER_134_265 VDD VSS FILLER4
Xoutput24 _20108_/Y VDD VSS o_bias_cfg[10] BUFX3
XFILLER_162_574 VDD VSS FILLER4
XFILLER_122_416 VSS VDD FILLER2
Xoutput35 _20118_/Y VDD VSS o_bias_cfg[20] BUFX3
XFILLER_162_585 VSS VDD FILLER2
Xoutput46 _20128_/Y VDD VSS o_bias_cfg[30] BUFX3
Xoutput57 _20107_/Y VDD VSS o_bias_cfg[9] BUFX3
X_11070_ _19958_/Q _18840_/Q _11070_/C VDD VSS _11072_/B MIN3X1
XFILLER_1_735 VSS VDD FILLER2
XFILLER_0_223 VSS VDD FILLER2
XFILLER_150_758 VDD VSS FILLER4
Xoutput68 _20134_/Y VDD VSS o_clk_cfg[1] BUFX3
Xoutput79 _20153_/Y VDD VSS o_en_ctrl[1] BUFX3
XFILLER_1_768 VSS VDD FILLER2
X_10021_ _10022_/A _10022_/B _10022_/C VDD VSS _10021_/Y NOR3X1
XFILLER_88_352 VDD VSS FILLER4
XFILLER_0_256 VSS VDD FILLER2
XFILLER_76_514 VSS VDD FILLER2
X_20199_ _20199_/A VDD VSS _20199_/Y BUFX3
XFILLER_102_173 VSS VDD FILLER2
XFILLER_130_482 VSS VDD FILLER2
X_14760_ _19362_/Q _15737_/B VDD VSS _14761_/B XNOR2X1
XFILLER_63_219 VDD VSS FILLER4
XFILLER_56_65 VDD VSS FILLER4
X_11972_ _19149_/Q _14432_/B VDD VSS _12031_/A NOR2BX1
XFILLER_57_783 VSS VDD FILLER2
XFILLER_17_614 VDD VSS DECAPHV8
XFILLER_91_539 VSS VDD FILLER2
XFILLER_84_580 VSS VDD FILLER2
XFILLER_56_271 VDD VSS DECAPHV8
XTAP_TAPCELL_ROW_46_428 VDD VSS WELLTAP
XFILLER_72_731 VSS VDD FILLER2
X_13711_ _14422_/B _14422_/C _19140_/Q VDD VSS _13714_/B AOI21X1
X_10923_ _18648_/Q _18810_/Q VDD VSS _10962_/A XNOR2X1
X_14691_ _14694_/B _14691_/B VDD VSS _15704_/B XNOR2X1
XFILLER_44_466 VSS VDD FILLER2
XFILLER_112_71 VSS VDD FILLER2
X_16430_ _16447_/B _16430_/B VDD VSS _16821_/B NOR2BX1
XFILLER_112_82 VSS VDD FILLER2
X_13642_ _19113_/Q _13642_/B _13710_/C VDD VSS _13716_/C XNOR3X1
XFILLER_72_31 VDD VSS DECAPHV8
XFILLER_71_263 VDD VSS DECAPHV8
X_10854_ _11127_/A _10921_/A VDD VSS _10882_/A NAND2X1
XFILLER_72_53 VDD VSS FILLER1
XFILLER_31_116 VDD VSS FILLER4
XFILLER_25_680 VSS VDD FILLER2
X_16361_ _19660_/Q _16818_/B VDD VSS _16390_/A NAND2BX1
X_13573_ _13869_/A _13869_/B VDD VSS _17914_/B XNOR2X1
X_10785_ _10785_/A _10785_/B _10816_/B _11263_/A VDD VSS _10811_/A AOI31X1
XFILLER_157_302 VDD VSS FILLER1
X_18100_ _19286_/Q _18100_/B _18100_/C VDD VSS _18105_/A MIN3X1
XFILLER_158_836 VDD VSS FILLER4
X_15312_ _15359_/A _15359_/B VDD VSS _15318_/B NOR2X1
X_19080_ _19134_/CK _19080_/D _19080_/Q VDD VSS DFFQX1
X_12524_ _12535_/A _12535_/B _14212_/B VDD VSS _14181_/B XNOR3X1
XFILLER_9_835 VSS VDD FILLER2
X_16292_ _16292_/A _16292_/B VDD VSS _16293_/B _16292_/C NAND3X1
X_18031_ _18032_/B _18045_/B _18031_/C _18049_/D VDD VSS _19973_/D OAI31X1
XFILLER_75_9 VSS VDD FILLER2
XFILLER_145_519 VSS VDD FILLER2
X_15243_ _15243_/A _15243_/B _15243_/C _15243_/D VDD VSS _15843_/B OAI211X1
XFILLER_126_700 VSS VDD FILLER2
X_12455_ _19100_/Q VDD VSS _12543_/A INVX1
XFILLER_138_571 VSS VDD FILLER2
XFILLER_138_582 VSS VDD FILLER2
X_11406_ _17812_/A VDD VSS _11422_/A BUFX3
X_15174_ _19344_/Q VDD VSS _15218_/A INVX1
X_12386_ _12474_/A _12474_/B VDD VSS _14469_/B _12474_/C NAND3X1
X_14125_ _14142_/A _14125_/B VDD VSS _18884_/D NOR2X1
XFILLER_4_551 VDD VSS FILLER1
XFILLER_126_788 VSS VDD FILLER2
X_11337_ _11334_/B _11337_/B _11337_/C VDD VSS _11352_/A AOI2B1X1
X_19982_ _19986_/CK _19982_/D _19982_/Q VDD VSS DFFQX1
XFILLER_99_639 VSS VDD FILLER2
XFILLER_98_116 VSS VDD FILLER2
XFILLER_113_438 VDD VSS DECAPHV8
XFILLER_141_747 VSS VDD FILLER2
XFILLER_4_595 VSS VDD FILLER2
XFILLER_140_235 VSS VDD FILLER2
X_18933_ _18934_/CK _18933_/D _18933_/Q VDD VSS DFFQX1
X_14056_ _18924_/Q _14086_/A _14061_/B VDD VSS _14058_/C XOR3X1
X_11268_ _11081_/Y _11349_/B _11289_/A VDD VSS _11276_/B MUXI2X1
XFILLER_97_72 VSS VDD FILLER2
XFILLER_79_341 VSS VDD FILLER2
XFILLER_140_257 VDD VSS FILLER4
X_13007_ _13007_/A _14289_/B VDD VSS _13097_/A NOR2X1
X_10219_ _18620_/Q _10219_/B _10219_/C VDD VSS _10229_/A AOI21X1
X_18864_ _18889_/CK _18864_/D _18864_/Q VDD VSS DFFQX1
X_11199_ _11225_/C _11199_/B VDD VSS _11208_/B XNOR2X1
XFILLER_67_514 VSS VDD FILLER2
XFILLER_67_536 VSS VDD FILLER2
X_17815_ _17817_/B _17815_/B VDD VSS _17816_/B XOR2X1
X_18795_ _18795_/CK _18795_/D _18795_/Q VDD VSS DFFQX1
XTAP_TAPCELL_ROW_146_1328 VDD VSS WELLTAP
XFILLER_11_4 VSS VDD FILLER2
XFILLER_48_750 VDD VSS DECAPHV8
XFILLER_94_366 VDD VSS FILLER1
XFILLER_82_506 VDD VSS FILLER4
X_17746_ _17747_/A _17748_/C _17746_/C VDD VSS _17747_/C OAI21X1
X_14958_ _19450_/Q _15835_/B VDD VSS _14995_/A AND2X1
XFILLER_54_219 VSS VDD FILLER2
XFILLER_94_399 VDD VSS FILLER1
XFILLER_47_282 VSS VDD FILLER2
X_13909_ _19060_/Q VDD VSS _13912_/D INVX1
XFILLER_63_742 VSS VDD FILLER2
X_17677_ _19896_/Q _19864_/Q VDD VSS _17678_/C NAND2X1
XFILLER_62_230 VSS VDD FILLER2
X_14889_ _14904_/B _14889_/B VDD VSS _15740_/B XNOR2X1
XFILLER_90_550 VSS VDD FILLER2
XFILLER_23_606 VDD VSS FILLER4
XFILLER_90_561 VDD VSS FILLER1
XFILLER_63_775 VSS VDD FILLER2
X_16628_ _16652_/C _16628_/B VDD VSS _16758_/B XNOR2X1
X_19416_ _19478_/CK _19416_/D _19416_/Q VDD VSS DFFQX1
XTAP_TAPCELL_ROW_80_729 VDD VSS WELLTAP
XFILLER_35_477 VDD VSS DECAPHV16
XTAP_TAPCELL_ROW_17_163 VDD VSS WELLTAP
XFILLER_23_639 VDD VSS FILLER4
XFILLER_22_127 VSS VDD FILLER2
XFILLER_149_803 VSS VDD FILLER2
X_16559_ _19700_/Q _16862_/B VDD VSS _16561_/C XNOR2X1
X_19347_ _19349_/CK _19347_/D _19347_/Q VDD VSS DFFQX1
XFILLER_31_650 VDD VSS FILLER1
XTAP_TAPCELL_ROW_157_1424 VDD VSS WELLTAP
XFILLER_87_0 VSS VDD FILLER2
X_19278_ _19306_/CK _19278_/D _19278_/Q VDD VSS DFFQX1
X_18229_ _18229_/CK _18229_/E _18229_/ECK VDD VSS CGX3
XFILLER_117_700 VDD VSS FILLER4
XFILLER_117_755 VSS VDD FILLER2
XFILLER_7_92 VDD VSS FILLER1
XFILLER_117_777 VSS VDD FILLER2
XFILLER_104_416 VSS VDD FILLER2
XFILLER_132_725 VDD VSS FILLER4
XTAP_TAPCELL_ROW_112_1018 VDD VSS WELLTAP
XFILLER_89_116 VDD VSS FILLER4
X_20122_ _20122_/A VDD VSS _20122_/Y BUFX3
X_09933_ _18597_/Q _09933_/B VDD VSS _11396_/B XNOR2X1
XTAP_TAPCELL_ROW_88_807 VDD VSS WELLTAP
X_20053_ _20054_/CK _20053_/D _20054_/D _20054_/RB VDD VSS DFFRQX1
X_09864_ _18572_/Q _09864_/B VDD VSS _09872_/B NAND2X1
XFILLER_58_514 VDD VSS FILLER4
XFILLER_112_482 VDD VSS DECAPHV16
XFILLER_58_536 VDD VSS DECAPHV16
X_09795_ _20115_/A _20131_/A _09773_/D VDD VSS _09805_/B MUXI2X1
XFILLER_39_761 VDD VSS FILLER4
XTAP_TAPCELL_ROW_96_873 VDD VSS WELLTAP
XFILLER_66_580 VSS VDD FILLER2
XFILLER_54_720 VDD VSS FILLER4
XTAP_TAPCELL_ROW_108_985 VDD VSS WELLTAP
XFILLER_26_35 VSS VDD FILLER2
XFILLER_81_561 VSS VDD FILLER2
XFILLER_41_458 VDD VSS FILLER4
XFILLER_139_313 VSS VDD FILLER2
X_10570_ _10570_/A _10570_/B _10570_/C _10570_/D VDD VSS _10571_/B AOI211X1
XTAP_TAPCELL_ROW_51_475 VDD VSS WELLTAP
XFILLER_158_34 VSS VDD FILLER2
XFILLER_10_845 VSS VDD FILLER2
XFILLER_10_856 VDD VSS FILLER1
XFILLER_6_805 VSS VDD FILLER2
XFILLER_139_379 VDD VSS FILLER1
X_09229_ _18511_/Q VDD VSS _18362_/D INVX1
XFILLER_108_700 VDD VSS DECAPHV16
XFILLER_5_304 VSS VDD FILLER2
XFILLER_6_838 VDD VSS FILLER4
XFILLER_6_849 VSS VDD FILLER2
XFILLER_154_338 VDD VSS DECAPHV8
X_12240_ _12391_/A _12391_/B VDD VSS _14501_/B XNOR2X1
XFILLER_107_221 VDD VSS FILLER1
XFILLER_108_744 VDD VSS FILLER4
XTAP_TAPCELL_ROW_134_1221 VDD VSS WELLTAP
XFILLER_108_788 VSS VDD FILLER2
X_12171_ _12171_/A _12171_/B _12171_/C _12171_/D VDD VSS _14436_/B OAOI211X1
XFILLER_107_276 VSS VDD FILLER2
XFILLER_122_213 VSS VDD FILLER2
XFILLER_123_747 VDD VSS FILLER4
X_11122_ _11122_/A _11128_/B VDD VSS _11126_/C XOR2X1
XFILLER_122_235 VSS VDD FILLER2
XFILLER_122_257 VSS VDD FILLER2
XFILLER_110_408 VSS VDD FILLER2
XFILLER_150_577 VSS VDD FILLER2
X_15930_ _19578_/Q _16727_/B VDD VSS _16762_/B XOR2X1
X_11053_ _18572_/Q _11057_/B VDD VSS _11055_/C XNOR2X1
XFILLER_95_119 VDD VSS FILLER4
XFILLER_1_576 VDD VSS FILLER4
X_10004_ _10034_/A _10004_/B VDD VSS _10005_/C NOR2X1
XFILLER_77_856 VDD VSS FILLER1
X_15861_ _15867_/A _15861_/B VDD VSS _19470_/D NOR2X1
XFILLER_88_193 VSS VDD FILLER2
XFILLER_130_290 VDD VSS DECAPHV8
XTAP_TAPCELL_ROW_59_542 VDD VSS WELLTAP
XFILLER_76_355 VSS VDD FILLER2
X_17600_ _17748_/B _17600_/B _17600_/C VDD VSS _17606_/C MIN3X1
X_14812_ _19419_/Q VDD VSS _14813_/A INVX1
XFILLER_36_208 VSS VDD FILLER2
X_18580_ _18583_/CK _18580_/D _18580_/Q VDD VSS DFFQX1
XFILLER_92_837 VSS VDD FILLER2
X_15792_ _15800_/A _15792_/B VDD VSS _19411_/D NOR2X1
XFILLER_91_314 VDD VSS FILLER4
XFILLER_45_720 VSS VDD FILLER2
XFILLER_91_336 VDD VSS DECAPHV8
XFILLER_29_282 VSS VDD FILLER2
X_17531_ _19866_/Q _19834_/Q _17597_/C VDD VSS _17532_/C OAI21X1
XFILLER_45_742 VSS VDD FILLER2
X_14743_ _14877_/C _14821_/C VDD VSS _15894_/B OR2X2
X_11955_ _19037_/Q _11955_/B _11955_/C VDD VSS _12076_/B MIN3X1
XFILLER_44_230 VSS VDD FILLER2
X_17462_ _19851_/Q _19819_/Q VDD VSS _17468_/B NAND2X1
X_10906_ _10940_/D _10940_/B VDD VSS _10908_/B NAND2BX1
X_14674_ _19471_/Q _14700_/B _15862_/B VDD VSS _14737_/A MIN3X1
XFILLER_83_96 VDD VSS FILLER4
XFILLER_72_583 VDD VSS FILLER4
X_11886_ _19995_/Q _19259_/Q VDD VSS _11933_/A NAND2X1
XFILLER_72_594 VSS VDD FILLER2
X_16413_ _19726_/Q _16890_/B VDD VSS _16414_/C NOR2X1
X_19201_ _19995_/CK _19201_/D _19201_/Q VDD VSS DFFQX1
X_13625_ _13728_/A _13728_/B _13728_/C _13625_/D VDD VSS _13709_/B OAOI211X1
X_17393_ _19836_/Q _19804_/Q _17393_/C VDD VSS _17397_/B AOI21X1
X_10837_ _10965_/A _18726_/Q _10837_/C _10837_/D VDD VSS _10838_/D AO211X2
XFILLER_158_600 VDD VSS FILLER4
XFILLER_158_611 VDD VSS FILLER1
X_19132_ _19157_/CK _19132_/D _19132_/Q VDD VSS DFFQX1
X_16344_ _19628_/Q _16782_/B VDD VSS _16364_/B XNOR2X1
XFILLER_158_633 VDD VSS FILLER4
X_13556_ _13557_/A _13557_/C _13557_/B VDD VSS _14482_/A OAI21X1
X_10768_ _10794_/C _10794_/B VDD VSS _10769_/B NOR2BX1
XFILLER_9_643 VSS VDD FILLER2
XFILLER_157_132 VDD VSS FILLER1
XFILLER_9_654 VSS VDD FILLER2
X_19063_ _19094_/CK _19063_/D _19063_/Q VDD VSS DFFQX1
X_12507_ _19101_/Q _12546_/B _12546_/C VDD VSS _12625_/C XNOR3X1
XFILLER_8_142 VDD VSS FILLER4
XFILLER_145_305 VDD VSS FILLER1
X_16275_ _16302_/B _17469_/B _16275_/C VDD VSS _19529_/D AND3BX1
X_13487_ _13497_/A _13575_/B _13575_/C VDD VSS _17911_/B XNOR3X1
X_10699_ _10746_/B _10698_/Y _10947_/A VDD VSS _10699_/Y MUX2X1
X_18014_ _18528_/Q _18527_/Q VDD VSS _18015_/B NAND2X1
X_15226_ _19456_/Q _15842_/B VDD VSS _15284_/A NAND2X1
XFILLER_66_5 VSS VDD FILLER2
X_12438_ _12438_/A _12438_/B _14180_/B VDD VSS _12534_/B MIN3X1
XFILLER_160_308 VDD VSS FILLER1
XFILLER_99_403 VSS VDD FILLER2
X_15157_ _19483_/Q _15157_/B _15157_/C VDD VSS _15198_/C XOR3X1
XFILLER_126_585 VDD VSS FILLER1
X_12369_ _12380_/A _14375_/B _12380_/C VDD VSS _14376_/C OR3X2
XFILLER_153_371 VDD VSS FILLER1
XFILLER_153_382 VSS VDD FILLER2
X_14108_ _17172_/A VDD VSS _18127_/B BUFX3
X_15088_ _15088_/A _15088_/B VDD VSS _15809_/C AND2X1
X_19965_ _19985_/CK _19965_/D _19965_/Q VDD VSS DFFQX1
XFILLER_68_801 VSS VDD FILLER2
X_18916_ _18999_/CK _18916_/D _18916_/Q VDD VSS DFFQX1
X_14039_ _19007_/Q _14269_/B VDD VSS _14041_/A NOR2X1
XFILLER_67_300 VSS VDD FILLER2
X_19896_ clkload2/A _19896_/D _19896_/Q VDD VSS DFFQX1
XFILLER_95_631 VDD VSS DECAPHV8
XFILLER_68_856 VDD VSS FILLER1
XFILLER_79_193 VSS VDD FILLER2
X_18847_ _18905_/CK _18847_/D _18847_/Q VDD VSS DFFQX1
X_09580_ _09729_/D _18296_/Q _09812_/B VDD VSS _09581_/E OA21X2
X_18778_ _19947_/CK _18778_/D _18778_/Q VDD VSS DFFQX1
XFILLER_94_185 VSS VDD FILLER2
X_17729_ _19908_/Q _19876_/Q VDD VSS _17730_/C NAND2X1
XTAP_TAPCELL_ROW_93_854 VDD VSS WELLTAP
XTAP_TAPCELL_ROW_163_1483 VDD VSS WELLTAP
XFILLER_82_369 VSS VDD FILLER2
XFILLER_70_509 VSS VDD FILLER2
XFILLER_36_775 VDD VSS FILLER4
XFILLER_63_561 VSS VDD FILLER2
XTAP_TAPCELL_ROW_105_955 VDD VSS WELLTAP
XFILLER_63_572 VSS VDD FILLER2
XFILLER_51_723 VSS VDD FILLER2
XFILLER_50_200 VDD VSS FILLER4
XFILLER_11_609 VSS VDD FILLER2
XFILLER_137_806 VDD VSS FILLER4
XFILLER_109_508 VSS VDD FILLER2
XFILLER_12_15 VSS VDD FILLER2
XFILLER_137_817 VSS VDD FILLER2
XFILLER_164_603 VDD VSS FILLER1
XFILLER_164_614 VSS VDD FILLER2
XFILLER_12_37 VSS VDD FILLER2
XFILLER_3_819 VDD VSS FILLER4
XFILLER_132_500 VSS VDD FILLER2
XFILLER_144_382 VSS VDD FILLER2
XFILLER_105_747 VSS VDD FILLER2
XFILLER_104_235 VSS VDD FILLER2
X_20105_ _20105_/A VDD VSS _20105_/Y BUFX3
X_09916_ _18597_/Q _09933_/B VDD VSS _11398_/B NOR2BX1
X_20036_ _20045_/CK _20036_/D _20036_/Q _20045_/RB VDD VSS DFFRQX1
XFILLER_100_430 VSS VDD FILLER2
XFILLER_112_290 VDD VSS FILLER4
X_09847_ _18570_/Q _09848_/A VDD VSS _09902_/B XNOR2X1
XFILLER_86_664 VDD VSS DECAPHV8
XFILLER_74_804 VSS VDD FILLER2
X_09778_ _18405_/Q VDD VSS _20146_/A INVX1
XFILLER_73_325 VSS VDD FILLER2
XFILLER_46_539 VDD VSS FILLER4
XFILLER_27_720 VSS VDD FILLER2
XFILLER_73_336 VDD VSS FILLER1
XFILLER_27_742 VSS VDD FILLER2
XFILLER_26_230 VSS VDD FILLER2
XFILLER_27_775 VSS VDD FILLER2
XTAP_TAPCELL_ROW_28_269 VDD VSS WELLTAP
X_11740_ _19199_/Q _11760_/B _11760_/C VDD VSS _11797_/A MIN3X1
XFILLER_81_380 VDD VSS FILLER4
XFILLER_53_33 VDD VSS FILLER4
XFILLER_159_419 VSS VDD FILLER2
X_11671_ _18809_/Q _14547_/B VDD VSS _18836_/D AND2X1
XFILLER_149_2 VDD VSS FILLER1
XFILLER_53_77 VDD VSS FILLER4
XFILLER_53_88 VDD VSS FILLER4
X_13410_ _19054_/Q _14325_/B VDD VSS _13533_/A AND2X1
XFILLER_41_277 VSS VDD FILLER2
X_10622_ _10655_/A _10622_/B _10622_/C VDD VSS _10746_/C NOR3X1
X_14390_ _14393_/A _14390_/B VDD VSS _19112_/D NOR2X1
XTAP_TAPCELL_ROW_11_114 VDD VSS WELLTAP
X_13341_ _19221_/Q _14514_/B VDD VSS _13466_/E _14514_/C AND3X2
XFILLER_155_614 VSS VDD FILLER2
XFILLER_128_839 VDD VSS FILLER1
X_10553_ _10553_/A VDD VSS _10556_/D INVX1
XFILLER_6_602 VSS VDD FILLER2
XFILLER_155_625 VDD VSS FILLER1
XFILLER_10_675 VSS VDD FILLER2
XFILLER_6_624 VSS VDD FILLER2
XFILLER_10_686 VSS VDD FILLER2
XFILLER_154_124 VSS VDD FILLER2
X_16060_ _19584_/Q _16060_/B _16733_/B VDD VSS _16085_/B MIN3X1
X_13272_ _14323_/B _14322_/C _19052_/Q VDD VSS _13274_/C AOI21X1
XFILLER_136_850 VSS VDD FILLER2
X_10484_ _18662_/Q _18770_/Q VDD VSS _10521_/A NAND2X1
XFILLER_108_552 VSS VDD FILLER2
XFILLER_6_668 VDD VSS FILLER1
X_15011_ _19507_/Q _15901_/B VDD VSS _15056_/D XOR2X1
X_12223_ _12239_/A _12401_/B _12224_/C VDD VSS _14500_/B OR3BX1
XFILLER_135_371 VDD VSS FILLER1
XFILLER_5_189 VSS VDD FILLER2
XFILLER_135_393 VDD VSS FILLER4
XFILLER_118_92 VSS VDD FILLER2
X_12154_ _12154_/A _14465_/B _14465_/C VDD VSS _12155_/D NOR3X1
XFILLER_96_406 VSS VDD FILLER2
X_11105_ _11229_/A _11105_/B _11105_/C _11229_/D VDD VSS _11114_/B OAI22X1
XFILLER_96_417 VDD VSS FILLER1
X_19750_ _19785_/CK _19750_/D _19750_/Q VDD VSS DFFQX1
XFILLER_78_85 VDD VSS FILLER4
X_16962_ _16962_/A _16962_/B VDD VSS _16973_/A NAND2X1
X_12085_ wire160/Y _12181_/B VDD VSS _14402_/B XNOR2X1
XFILLER_96_439 VSS VDD FILLER2
XFILLER_77_631 VSS VDD FILLER2
X_18701_ _18810_/CK _18701_/D _18701_/Q VDD VSS DFFQX1
X_15913_ _16100_/A _15913_/B VDD VSS _19518_/D NOR2X1
X_11036_ _19957_/Q _18839_/Q VDD VSS _11037_/C NAND2X1
X_16893_ _17391_/A VDD VSS _16976_/A BUFX3
X_19681_ _19722_/CK _19681_/D _19681_/Q VDD VSS DFFQX1
XFILLER_76_130 VDD VSS FILLER1
XFILLER_92_601 VSS VDD FILLER2
XFILLER_64_303 VSS VDD FILLER2
X_15844_ _17010_/A _15844_/B _15844_/C VDD VSS _19458_/D NOR3X1
X_18632_ _19939_/CK _18632_/D _18632_/Q VDD VSS DFFQX1
XFILLER_94_73 VDD VSS FILLER4
XFILLER_92_656 VSS VDD FILLER2
X_15775_ _15780_/A _15775_/B VDD VSS _19396_/D NOR2X1
X_18563_ _18578_/CK _18563_/D _18563_/Q VDD VSS DFFQX1
X_12987_ _13177_/A _17885_/B VDD VSS _18854_/D NOR2X1
XFILLER_92_678 VSS VDD FILLER2
XFILLER_91_166 VDD VSS FILLER4
XFILLER_45_561 VSS VDD FILLER2
X_14726_ _19333_/Q VDD VSS _14727_/A INVX1
X_17514_ _17517_/A _17517_/B _17597_/C VDD VSS _17515_/C OAI21X1
XTAP_TAPCELL_ROW_90_824 VDD VSS WELLTAP
XFILLER_18_797 VSS VDD FILLER2
X_18494_ _18495_/CK _18494_/D _20107_/A _20075_/RB VDD VSS DFFRQX1
X_11938_ _19149_/Q _12029_/A _12029_/B VDD VSS _11973_/D XNOR3X1
XFILLER_60_520 VDD VSS FILLER1
XFILLER_33_734 VDD VSS FILLER4
X_17445_ _19848_/Q _19816_/Q VDD VSS _17448_/A XNOR2X1
X_14657_ _14658_/A _14658_/B VDD VSS _14708_/A _14739_/B _14658_/D NAND4X2
X_11869_ _11869_/A _11874_/D VDD VSS _14430_/B XNOR2X1
XFILLER_33_778 VSS VDD FILLER2
X_13608_ _13840_/B _14262_/C _19000_/Q VDD VSS _13609_/D AND3BX1
X_17376_ _19832_/Q _19800_/Q VDD VSS _17377_/C NAND2X1
XFILLER_60_597 VSS VDD FILLER2
X_14588_ _19494_/Q _15887_/B VDD VSS _14601_/A _15887_/C NAND3X1
XFILLER_119_828 VDD VSS DECAPHV8
X_16327_ _16352_/B _16327_/B VDD VSS _16887_/B NAND2BX1
X_19115_ _19115_/CK _19115_/D _19115_/Q VDD VSS DFFQX1
X_13539_ _13620_/A _14388_/B _13614_/C VDD VSS _14389_/C OR3BX1
XFILLER_9_462 VSS VDD FILLER2
X_19046_ _19072_/CK _19046_/D _19046_/Q VDD VSS DFFQX1
XFILLER_146_658 VDD VSS FILLER4
X_16258_ _19560_/Q _17748_/A _16258_/C VDD VSS _16285_/C MIN3X1
XFILLER_127_850 VSS VDD FILLER2
X_15209_ _19372_/Q _15749_/B VDD VSS _15220_/B XNOR2X1
X_16189_ _19622_/Q _16204_/A VDD VSS _16190_/B XNOR2X1
XFILLER_160_116 VSS VDD FILLER2
XFILLER_126_393 VSS VDD FILLER2
XFILLER_87_428 VDD VSS FILLER4
X_19948_ _19949_/CK _19948_/D _19948_/Q VDD VSS DFFQX1
XFILLER_4_71 VSS VDD FILLER2
XFILLER_4_93 VDD VSS FILLER1
XFILLER_101_238 VDD VSS FILLER4
X_09701_ _18336_/Q VDD VSS _20090_/A INVX1
XTAP_TAPCELL_ROW_165_1501 VDD VSS WELLTAP
XFILLER_68_642 VDD VSS FILLER4
XFILLER_67_130 VDD VSS FILLER1
X_19879_ _19880_/CK _19879_/D _19879_/Q VDD VSS DFFQX1
XFILLER_28_506 VDD VSS FILLER4
X_09632_ _09753_/A _20136_/A _09813_/C VDD VSS _09633_/C OAI21X1
X_09563_ _18241_/Q _09770_/B _09770_/C _20082_/A _09563_/E VDD VSS _09569_/B AOI221X1
XFILLER_83_689 VSS VDD FILLER2
XFILLER_36_550 VDD VSS FILLER1
XFILLER_70_328 VSS VDD FILLER2
X_09494_ _19985_/Q _09496_/B _09496_/C VDD VSS _09495_/C AOI21X1
XFILLER_130_49 VDD VSS DECAPHV8
XTAP_TAPCELL_ROW_25_239 VDD VSS WELLTAP
XFILLER_24_756 VDD VSS DECAPHV8
XFILLER_23_244 VDD VSS FILLER1
XFILLER_23_25 VDD VSS FILLER1
XFILLER_23_288 VSS VDD FILLER2
XFILLER_149_463 VSS VDD FILLER2
XFILLER_23_69 VSS VDD FILLER2
XFILLER_149_474 VDD VSS FILLER1
XFILLER_137_636 VSS VDD FILLER2
XFILLER_99_18 VDD VSS DECAPHV16
XFILLER_137_658 VDD VSS FILLER1
XFILLER_164_444 VSS VDD FILLER2
XFILLER_124_308 VDD VSS DECAPHV8
XFILLER_136_168 VDD VSS FILLER1
XTAP_TAPCELL_ROW_118_1079 VDD VSS WELLTAP
XFILLER_151_105 VSS VDD FILLER2
XFILLER_117_371 VDD VSS FILLER1
XFILLER_151_116 VSS VDD FILLER2
XFILLER_117_382 VSS VDD FILLER2
XFILLER_2_115 VSS VDD FILLER2
XFILLER_117_393 VDD VSS FILLER1
XFILLER_3_649 VSS VDD FILLER2
XFILLER_155_46 VSS VDD FILLER2
XFILLER_105_544 VDD VSS FILLER4
XFILLER_144_190 VSS VDD FILLER2
XFILLER_2_137 VSS VDD FILLER2
XFILLER_2_159 VDD VSS FILLER4
XFILLER_120_514 VDD VSS DECAPHV8
XFILLER_59_642 VSS VDD FILLER2
XFILLER_48_44 VSS VDD FILLER2
X_20019_ _20019_/CK _20019_/D _20019_/Q _20030_/RB VDD VSS DFFRQX1
X_12910_ _12910_/A _12910_/B _12910_/C _12910_/D VDD VSS _14382_/B AOAI211X1
XFILLER_46_303 VSS VDD FILLER2
XFILLER_19_528 VDD VSS DECAPHV8
XFILLER_101_794 VDD VSS DECAPHV16
X_13890_ _19003_/Q _14265_/B VDD VSS _13891_/D _14265_/C NAND3X1
XTAP_TAPCELL_ROW_129_1175 VDD VSS WELLTAP
XFILLER_100_293 VDD VSS FILLER1
X_12841_ _19215_/Q _12841_/B VDD VSS _12843_/C _12841_/C NAND3X1
XFILLER_73_155 VSS VDD FILLER2
XFILLER_61_306 VDD VSS FILLER4
XFILLER_27_561 VSS VDD FILLER2
X_15560_ _15563_/A _15697_/B VDD VSS _15564_/C XNOR2X1
X_12772_ _12940_/A _12940_/C VDD VSS _12773_/C AND2X1
XFILLER_61_339 VSS VDD FILLER2
X_14511_ _15806_/A _14511_/B _14511_/C VDD VSS _19218_/D NOR3X1
XFILLER_15_756 VSS VDD FILLER2
X_11723_ _19990_/Q _19254_/Q VDD VSS _11724_/D AND2X1
XFILLER_15_767 VSS VDD FILLER2
X_15491_ _15492_/A _15492_/B _15492_/C VDD VSS _15541_/B OAI21X1
XFILLER_120_71 VDD VSS FILLER1
X_17230_ _17230_/A _17230_/B _17230_/C VDD VSS _19801_/D AOI21X1
XFILLER_80_20 VDD VSS FILLER1
XFILLER_42_586 VDD VSS FILLER1
X_14442_ _14456_/A _14442_/B VDD VSS _19158_/D NOR2X1
XFILLER_159_249 VSS VDD FILLER2
X_11654_ _18794_/Q _11658_/B VDD VSS _18821_/D AND2X1
XFILLER_128_603 VDD VSS FILLER1
XFILLER_80_64 VDD VSS FILLER1
X_17161_ _19787_/Q _19755_/Q VDD VSS _17168_/C NOR2X1
X_10605_ _10633_/D _10633_/C VDD VSS _10607_/C NAND2BX1
X_14373_ _14316_/Y _14373_/B _14373_/C VDD VSS _19096_/D AND3BX1
XFILLER_80_86 VSS VDD FILLER2
X_11585_ _18731_/Q _11589_/B VDD VSS _18758_/D AND2X1
XFILLER_128_636 VSS VDD FILLER2
XFILLER_80_97 VDD VSS FILLER1
XFILLER_155_422 VDD VSS FILLER4
X_16112_ _16112_/A _19906_/Q _16112_/C VDD VSS _16137_/C MIN3X1
XFILLER_155_433 VSS VDD FILLER2
X_13324_ _13437_/A _13437_/B VDD VSS _13418_/B NOR2X1
XFILLER_6_421 VSS VDD FILLER2
X_17092_ _19772_/Q _19740_/Q _17092_/C VDD VSS _17097_/B AOI21X1
X_10536_ _11255_/A _10622_/B _10622_/C _10536_/D VDD VSS _10844_/B OAI31X1
XFILLER_13_91 VSS VDD FILLER2
XFILLER_143_606 VDD VSS FILLER4
XFILLER_129_91 VSS VDD FILLER2
X_16043_ _16059_/B _16043_/B VDD VSS _16805_/B XNOR2X1
X_13255_ _13255_/A _13255_/B _13255_/C _13255_/D VDD VSS _13260_/A AO31X2
XFILLER_142_116 VDD VSS FILLER4
X_10467_ _10538_/A _10467_/B VDD VSS _10503_/C NOR2X1
X_12206_ _12206_/A _12257_/D VDD VSS _14342_/B XNOR2X1
X_13186_ _18912_/Q _13286_/B _13286_/C VDD VSS _13494_/B MIN3X1
X_10398_ _18633_/Q _18795_/Q VDD VSS _10399_/D NAND2X1
XFILLER_151_672 VDD VSS FILLER1
X_19802_ _19841_/CK _19802_/D _19802_/Q VDD VSS DFFQX1
XFILLER_96_203 VDD VSS FILLER1
X_12137_ _12255_/A _12255_/B _12137_/C VDD VSS _14339_/B XNOR3X1
XFILLER_69_428 VDD VSS DECAPHV8
X_17994_ _18534_/Q _18026_/B VDD VSS _18030_/B AND2X1
XFILLER_111_547 VSS VDD FILLER2
X_19733_ _19734_/CK _19733_/D _19733_/Q VDD VSS DFFQX1
XFILLER_96_258 VDD VSS FILLER4
X_16945_ _16945_/A _16948_/C _16945_/C VDD VSS _19744_/D AOI21X1
X_12068_ _12070_/A _12070_/B _14206_/B VDD VSS _14175_/B XNOR3X1
XTAP_TAPCELL_ROW_67_618 VDD VSS WELLTAP
XFILLER_49_152 VSS VDD FILLER2
X_11019_ _11364_/A _11019_/B _11019_/C VDD VSS _11026_/C OAI21X1
XFILLER_65_623 VDD VSS FILLER4
X_19664_ _19664_/CK _19664_/D _19664_/Q VDD VSS DFFQX1
XFILLER_64_100 VSS VDD FILLER2
X_16876_ _16876_/A _16876_/B VDD VSS _19713_/D NOR2X1
XFILLER_64_111 VDD VSS FILLER1
XFILLER_37_325 VSS VDD FILLER2
XFILLER_92_431 VDD VSS FILLER4
X_18615_ _18622_/CK _18615_/D _18615_/Q VDD VSS DFFQX1
X_15827_ _15830_/A _15827_/B VDD VSS _19442_/D NOR2X1
XFILLER_53_818 VSS VDD FILLER2
X_19595_ _19664_/CK _19595_/D _19595_/Q VDD VSS DFFQX1
XFILLER_64_166 VSS VDD FILLER2
XTAP_TAPCELL_ROW_9_92 VDD VSS WELLTAP
XTAP_TAPCELL_ROW_75_684 VDD VSS WELLTAP
XFILLER_52_328 VDD VSS FILLER4
X_15758_ _15758_/A _15758_/B VDD VSS _19381_/D NOR2X1
X_18546_ _18550_/CK _18546_/D _18546_/Q VDD VSS DFFQX1
XTAP_TAPCELL_ROW_160_1453 VDD VSS WELLTAP
XFILLER_33_520 VSS VDD FILLER2
XFILLER_61_840 VSS VDD FILLER2
X_14709_ _14739_/D VDD VSS _14710_/D INVX1
X_15689_ _15693_/A _15689_/B VDD VSS _19318_/D NOR2X1
X_18477_ _18479_/CK _18514_/Q _20122_/A _18498_/RB VDD VSS DFFRQX1
XTAP_TAPCELL_ROW_22_209 VDD VSS WELLTAP
XFILLER_21_737 VDD VSS FILLER4
X_17428_ _17431_/A _17431_/B _17452_/C VDD VSS _17429_/C OAI21X1
XFILLER_60_383 VDD VSS FILLER4
XFILLER_166_709 VDD VSS FILLER1
XFILLER_159_761 VDD VSS FILLER4
XFILLER_20_247 VSS VDD FILLER2
X_17359_ _17362_/C _17360_/B _17363_/C VDD VSS _17360_/C OAI21X1
XFILLER_158_271 VDD VSS DECAPHV8
XFILLER_158_293 VDD VSS FILLER4
XFILLER_118_146 VDD VSS FILLER1
XTAP_TAPCELL_ROW_30_286 VDD VSS WELLTAP
XFILLER_106_308 VDD VSS FILLER1
XFILLER_109_39 VDD VSS FILLER1
Xclkload40 _19185_/CK VDD VSS clkload40/Y BUFX12
XFILLER_118_179 VDD VSS FILLER4
X_19029_ _19086_/CK _19029_/D _19029_/Q VDD VSS DFFQX1
Xclkload51 _19157_/CK VDD VSS clkload51/Y INVX4
XFILLER_133_116 VSS VDD FILLER2
Xclkload62 _19086_/CK VDD VSS clkload62/Y INVX4
Xclkload73 _19531_/CK VDD VSS clkload73/Y INVX1
XFILLER_115_831 VDD VSS FILLER4
Xclkload84 _19314_/CK VDD VSS clkload84/Y INVX6
Xclkload95 _19696_/CK VDD VSS clkload95/Y INVX2
XFILLER_126_190 VSS VDD FILLER2
XFILLER_88_704 VDD VSS FILLER1
XFILLER_102_503 VSS VDD FILLER2
XFILLER_102_514 VDD VSS DECAPHV8
XFILLER_114_374 VSS VDD FILLER2
XFILLER_87_214 VSS VDD FILLER2
XFILLER_130_856 VDD VSS FILLER1
XFILLER_110_591 VSS VDD FILLER2
XFILLER_141_37 VSS VDD FILLER2
X_09615_ _20199_/A _09811_/C _09770_/C _20084_/A _09615_/E VDD VSS _09616_/C AOI221X1
XFILLER_56_667 VDD VSS FILLER4
XFILLER_16_509 VSS VDD FILLER2
XTAP_TAPCELL_ROW_38_353 VDD VSS WELLTAP
XFILLER_83_486 VSS VDD FILLER2
XFILLER_55_177 VDD VSS FILLER4
X_09546_ _20040_/Q _09547_/B VDD VSS _20041_/D NOR2BX1
XFILLER_71_637 VSS VDD FILLER2
XFILLER_24_542 VSS VDD FILLER2
XFILLER_70_158 VDD VSS DECAPHV8
XFILLER_12_704 VSS VDD FILLER2
X_09477_ _18404_/D _09483_/B _09477_/C VDD VSS _18245_/D AOI21X1
XFILLER_34_79 VSS VDD FILLER2
Xclkload1 clkload1/A VDD VSS clkload1/Y INVX8
XFILLER_149_282 VDD VSS DECAPHV8
XFILLER_20_770 VDD VSS DECAPHV8
XFILLER_126_4 VSS VDD FILLER2
XFILLER_165_742 VSS VDD FILLER2
XFILLER_109_146 VDD VSS FILLER4
X_11370_ _11370_/A _11370_/B _11370_/C VDD VSS _11373_/B OAI21X1
XFILLER_164_230 VSS VDD FILLER2
XFILLER_109_157 VDD VSS FILLER4
XFILLER_109_168 VDD VSS FILLER1
XFILLER_164_263 VSS VDD FILLER2
X_10321_ _18658_/Q _18766_/Q VDD VSS _10323_/C NAND2X1
XFILLER_166_56 VDD VSS FILLER4
XFILLER_124_116 VDD VSS FILLER4
XFILLER_125_639 VSS VDD FILLER2
XFILLER_166_67 VDD VSS FILLER4
XFILLER_3_413 VDD VSS FILLER4
X_13040_ _13138_/B _14446_/C _19162_/Q VDD VSS _13041_/D AND3BX1
XFILLER_105_330 VSS VDD FILLER2
X_10252_ _18623_/Q _10721_/D _11432_/D VDD VSS _10315_/C NOR3X1
XFILLER_3_457 VSS VDD FILLER2
XFILLER_105_352 VDD VSS FILLER1
XFILLER_3_468 VSS VDD FILLER2
XFILLER_105_363 VSS VDD FILLER2
XFILLER_3_479 VSS VDD FILLER2
X_10183_ _18616_/Q _10189_/B VDD VSS _10188_/A XNOR2X1
XFILLER_59_65 VDD VSS DECAPHV16
XFILLER_160_480 VSS VDD FILLER2
XFILLER_105_396 VSS VDD FILLER2
X_14991_ _14991_/A _14991_/B _15713_/B VDD VSS _15037_/B MIN3X1
XFILLER_47_601 VDD VSS DECAPHV8
X_16730_ _16735_/A _16730_/B VDD VSS _19581_/D NOR2X1
X_13942_ _13993_/A _13949_/B VDD VSS _14168_/B XNOR2X1
XFILLER_46_111 VSS VDD FILLER2
XFILLER_75_53 VSS VDD FILLER2
XFILLER_47_645 VDD VSS FILLER4
X_16661_ _19672_/Q _16671_/A VDD VSS _16662_/B XNOR2X1
XFILLER_74_453 VDD VSS FILLER1
XFILLER_46_144 VDD VSS FILLER1
X_13873_ _13873_/A _14166_/B _14166_/C VDD VSS _13874_/D NOR3X1
XFILLER_35_818 VSS VDD FILLER2
X_15612_ _15674_/A _18169_/B VDD VSS _19299_/D AND2X1
X_18400_ _18406_/CK _18517_/Q _20141_/A _18450_/RB VDD VSS DFFRQX1
X_12824_ _12939_/A _12939_/B VDD VSS _12863_/B NOR2X1
XFILLER_34_328 VDD VSS FILLER4
X_16592_ _19701_/Q _16863_/B VDD VSS _16620_/A NAND2BX1
X_19380_ _19412_/CK _19380_/D _19380_/Q VDD VSS DFFQX1
XFILLER_62_648 VDD VSS FILLER4
XFILLER_43_840 VSS VDD FILLER2
X_15543_ _19408_/Q _15543_/B _15543_/C VDD VSS _15569_/A MIN3X1
X_18331_ _18343_/CK _18512_/Q _20085_/A _18374_/RB VDD VSS DFFRQX1
XFILLER_61_158 VSS VDD FILLER2
X_12755_ _12755_/A _12755_/B _12755_/C _12755_/D VDD VSS _14506_/B OAOI211X1
XTAP_TAPCELL_ROW_72_665 VDD VSS WELLTAP
XFILLER_61_169 VSS VDD FILLER2
XFILLER_42_361 VSS VDD FILLER2
X_18262_ _18275_/CK _18262_/D _18262_/Q _18486_/RB VDD VSS DFFRQX1
X_11706_ _11706_/A _11706_/B _11706_/C _11736_/B VDD VSS _11724_/B OAOI211X1
X_15474_ _15474_/A _15474_/B _15474_/C VDD VSS _15514_/B OA21X2
X_12686_ _19159_/Q _12739_/B _12739_/C VDD VSS _12813_/C XNOR3X1
XFILLER_91_96 VSS VDD FILLER2
X_17213_ _19798_/Q _19766_/Q VDD VSS _17214_/B XOR2X1
X_14425_ _14467_/A _14425_/B VDD VSS _19143_/D AND2X1
XFILLER_128_400 VSS VDD FILLER2
X_18193_ _18196_/A _18193_/B VDD VSS _20012_/D NOR2X1
X_11637_ _18778_/Q _11647_/B VDD VSS _18805_/D AND2X1
XFILLER_156_720 VSS VDD FILLER2
X_17144_ _17147_/C _17145_/B _17164_/C VDD VSS _17145_/C OAI21X1
X_14356_ _14368_/A _14356_/B VDD VSS _19081_/D NOR2X1
X_11568_ _11648_/A VDD VSS _11578_/B BUFX3
X_13307_ _13373_/A _13373_/B _13373_/E _13307_/D VDD VSS _14259_/C OAOI211X1
XFILLER_6_251 VSS VDD FILLER2
XFILLER_156_797 VSS VDD FILLER2
X_17075_ _17075_/A _17075_/B VDD VSS _17076_/C NAND2X1
X_10519_ _18664_/Q _18772_/Q VDD VSS _10576_/A XOR2X1
XFILLER_128_499 VDD VSS FILLER4
XFILLER_143_425 VDD VSS FILLER4
X_14287_ _14294_/A _14287_/B _14287_/C VDD VSS _19021_/D NOR3X1
X_11499_ _18653_/Q _11508_/B VDD VSS _18680_/D AND2X1
XFILLER_115_149 VSS VDD FILLER2
X_16026_ _16026_/A _16028_/B VDD VSS _16027_/B XOR2X1
X_13238_ _19248_/Q VDD VSS _13339_/A INVX1
XFILLER_41_4 VSS VDD FILLER2
XFILLER_130_108 VDD VSS FILLER1
XFILLER_97_501 VDD VSS FILLER1
XFILLER_97_512 VDD VSS FILLER4
XFILLER_69_203 VSS VDD FILLER2
XFILLER_111_311 VDD VSS FILLER1
X_13169_ _18967_/Q VDD VSS _13171_/D INVX1
XFILLER_97_534 VSS VDD FILLER2
XFILLER_112_856 VDD VSS FILLER1
XFILLER_69_247 VSS VDD FILLER2
XFILLER_2_490 VSS VDD FILLER2
X_17977_ _17977_/A _17977_/B VDD VSS _17978_/C NOR2X1
X_19716_ _19730_/CK _19716_/D _19716_/Q VDD VSS DFFQX1
XFILLER_84_228 VDD VSS FILLER4
XFILLER_38_623 VSS VDD FILLER2
X_16928_ _16928_/A _16928_/B _16928_/C VDD VSS _16933_/C OAI21X1
XFILLER_65_420 VSS VDD FILLER2
XFILLER_65_431 VSS VDD FILLER2
X_19647_ _19722_/CK _19647_/D _19647_/Q VDD VSS DFFQX1
X_16859_ _16859_/A _16859_/B VDD VSS _19698_/D AND2X1
XFILLER_37_155 VSS VDD FILLER2
X_09400_ _09400_/A VDD VSS _18006_/C BUFX3
XFILLER_52_103 VDD VSS FILLER1
XFILLER_80_423 VDD VSS FILLER1
XFILLER_111_29 VSS VDD FILLER2
X_19578_ _19705_/CK _19578_/D _19578_/Q VDD VSS DFFQX1
XFILLER_92_294 VDD VSS FILLER4
XFILLER_25_339 VSS VDD FILLER2
XFILLER_80_445 VSS VDD FILLER2
XFILLER_80_456 VSS VDD FILLER2
X_09331_ _20073_/RB _09346_/B VDD VSS _09331_/Y NOR2BX1
X_18529_ _18543_/CK _18529_/D _18529_/Q VDD VSS DFFQX1
XFILLER_33_350 VSS VDD FILLER2
XFILLER_61_670 VDD VSS DECAPHV16
XFILLER_21_512 VDD VSS FILLER1
X_09262_ _20030_/RB _09362_/B VDD VSS _09262_/Y NOR2BX1
XFILLER_21_556 VSS VDD FILLER2
XFILLER_119_400 VDD VSS DECAPHV8
X_09193_ _18518_/Q VDD VSS _18449_/D INVX1
XFILLER_21_578 VSS VDD FILLER2
XFILLER_159_591 VSS VDD FILLER2
XFILLER_147_742 VSS VDD FILLER2
XFILLER_146_252 VSS VDD FILLER2
XFILLER_106_105 VSS VDD FILLER2
XFILLER_146_285 VSS VDD FILLER2
XFILLER_146_296 VDD VSS FILLER1
XFILLER_105_9 VSS VDD FILLER2
XFILLER_106_138 VDD VSS FILLER1
XFILLER_134_447 VDD VSS FILLER1
XFILLER_136_26 VSS VDD FILLER2
XTAP_TAPCELL_ROW_115_1049 VDD VSS WELLTAP
XFILLER_162_756 VSS VDD FILLER2
XFILLER_134_469 VDD VSS DECAPHV8
XFILLER_115_650 VDD VSS FILLER1
XFILLER_162_789 VDD VSS FILLER1
XFILLER_115_672 VDD VSS DECAPHV8
XFILLER_114_160 VDD VSS FILLER4
XFILLER_88_523 VSS VDD FILLER2
XFILLER_88_545 VDD VSS FILLER1
XFILLER_88_556 VSS VDD FILLER2
XFILLER_29_13 VDD VSS FILLER4
XFILLER_29_24 VSS VDD FILLER2
XFILLER_48_409 VSS VDD FILLER2
XFILLER_130_675 VSS VDD FILLER2
XFILLER_75_217 VSS VDD FILLER2
XFILLER_29_68 VSS VDD FILLER2
XFILLER_75_228 VSS VDD FILLER2
XFILLER_152_58 VDD VSS FILLER4
Xdelaybuf_5_sclk delaybuf_5_sclk/A VDD VSS delaybuf_5_sclk/Y BUFX12
XFILLER_84_740 VSS VDD FILLER2
XFILLER_68_291 VSS VDD FILLER2
XFILLER_29_667 VSS VDD FILLER2
XFILLER_28_144 VDD VSS FILLER1
XTAP_TAPCELL_ROW_126_1145 VDD VSS WELLTAP
XFILLER_71_412 VSS VDD FILLER2
XFILLER_28_177 VSS VDD FILLER2
XFILLER_16_328 VSS VDD FILLER2
X_10870_ _18672_/Q _18780_/Q VDD VSS _10871_/D NOR2X1
XFILLER_71_445 VDD VSS FILLER4
XFILLER_25_840 VSS VDD FILLER2
XFILLER_43_147 VDD VSS FILLER4
X_09529_ _20024_/Q _18199_/A VDD VSS _20025_/D NOR2BX1
XFILLER_31_309 VSS VDD FILLER2
XFILLER_101_40 VDD VSS FILLER4
XFILLER_52_670 VDD VSS FILLER1
XFILLER_24_361 VSS VDD FILLER2
X_12540_ _12540_/A _12540_/B _12540_/C _12540_/D VDD VSS _12632_/B OAOI211X1
XFILLER_101_73 VSS VDD FILLER2
XFILLER_61_22 VSS VDD FILLER2
X_12471_ _12471_/A _12471_/B _12471_/C _12471_/D VDD VSS _14406_/B AOAI211X1
XFILLER_138_731 VSS VDD FILLER2
X_14210_ _14218_/A _14210_/B VDD VSS _18959_/D NOR2X1
X_11422_ _11422_/A _11429_/B _11422_/C VDD VSS _18616_/D NOR3X1
X_15190_ _15275_/D _15275_/B VDD VSS _15193_/B NAND2BX1
XFILLER_138_775 VDD VSS DECAPHV8
XFILLER_165_561 VDD VSS FILLER4
XFILLER_125_403 VSS VDD FILLER2
XFILLER_4_700 VSS VDD FILLER2
XFILLER_153_712 VDD VSS FILLER4
XFILLER_138_797 VDD VSS FILLER1
X_14141_ _14158_/A _14141_/B VDD VSS _18898_/D AND2X1
XFILLER_153_723 VSS VDD FILLER2
XFILLER_152_200 VDD VSS FILLER4
X_11353_ _11353_/A _11355_/C VDD VSS _11354_/B XOR2X1
XFILLER_165_594 VSS VDD FILLER2
XFILLER_125_436 VDD VSS FILLER1
XFILLER_152_222 VSS VDD FILLER2
X_10304_ _10304_/A _10304_/B _10304_/C _10304_/D VDD VSS _10546_/B AOI211X1
X_14072_ _18925_/Q _14086_/D _14072_/C VDD VSS _14078_/C XOR3X1
XFILLER_152_255 VDD VSS FILLER1
X_11284_ _18582_/Q _11284_/B VDD VSS _11285_/C NAND2X1
XFILLER_4_777 VDD VSS FILLER1
XFILLER_140_417 VDD VSS FILLER1
XFILLER_4_788 VSS VDD FILLER2
XFILLER_140_428 VSS VDD FILLER2
X_17900_ _17905_/A _17905_/B VDD VSS _17903_/A XNOR2X1
X_13023_ _13023_/A _14382_/B _13023_/C _13023_/D VDD VSS _13314_/A AOAI211X1
XFILLER_79_512 VDD VSS FILLER1
XFILLER_140_439 VDD VSS FILLER1
X_10235_ _13177_/A _11429_/C VDD VSS _18550_/D NOR2X1
XFILLER_10_81 VDD VSS FILLER4
XFILLER_133_480 VDD VSS FILLER1
X_18880_ _18934_/CK _18880_/D _18880_/Q VDD VSS DFFQX1
XFILLER_105_182 VDD VSS FILLER4
XFILLER_79_545 VSS VDD FILLER2
X_17831_ _19930_/Q _19931_/Q _19932_/Q _17831_/D VDD VSS _19932_/D AOI31X1
X_10166_ _10190_/B _10166_/B _10166_/C _10166_/D VDD VSS _10167_/C AO211X2
XTAP_TAPCELL_ROW_77_702 VDD VSS WELLTAP
XFILLER_79_589 VSS VDD FILLER2
XFILLER_120_185 VSS VDD FILLER2
X_17762_ _17766_/A _17763_/B _17828_/C VDD VSS _17763_/C OAI21X1
X_14974_ _19479_/Q _15052_/A _15052_/B VDD VSS _15000_/C XNOR3X1
X_10097_ _10097_/A _10097_/B VDD VSS _10098_/C NAND2X1
XFILLER_75_740 VDD VSS FILLER4
X_19501_ _19528_/CK _19501_/D _19501_/Q VDD VSS DFFQX1
XFILLER_75_751 VSS VDD FILLER2
X_16713_ _19918_/Q VDD VSS _17776_/A INVX1
X_13925_ _18921_/Q _13993_/A _13949_/B VDD VSS _13981_/D XNOR3X1
X_17693_ _19900_/Q _19868_/Q _17693_/C VDD VSS _17697_/B AOI21X1
XFILLER_19_177 VDD VSS FILLER4
X_19432_ _19460_/CK _19432_/D _19432_/Q VDD VSS DFFQX1
X_16644_ _19703_/Q _16865_/B VDD VSS _16645_/C NOR2X1
X_13856_ _13857_/A _13857_/B _13857_/D _13857_/C VDD VSS _14363_/A OA211X2
XFILLER_90_754 VDD VSS FILLER4
XFILLER_62_445 VSS VDD FILLER2
XFILLER_34_136 VSS VDD FILLER2
X_12807_ _12807_/A _14315_/B _12807_/C _12807_/D VDD VSS _12916_/A AOAI211X1
XFILLER_50_607 VSS VDD FILLER2
X_19363_ _19379_/CK _19363_/D _19363_/Q VDD VSS DFFQX1
X_16575_ _19573_/Q _19925_/Q VDD VSS _16576_/B XOR2X1
X_13787_ _19142_/Q _14424_/B VDD VSS _13788_/D NOR2BX1
X_10999_ _10999_/A _11030_/C VDD VSS _11014_/B XNOR2X1
XFILLER_62_489 VDD VSS FILLER4
XTAP_TAPCELL_ROW_32_304 VDD VSS WELLTAP
X_18314_ _18327_/CK _18511_/Q _18314_/Q _09380_/B VDD VSS DFFRQX1
X_15526_ _15526_/A _15543_/C VDD VSS _15757_/B XNOR2X1
X_12738_ _19159_/Q VDD VSS _12747_/A INVX1
XFILLER_43_692 VSS VDD FILLER2
X_19294_ _19331_/CK _19294_/D _19294_/Q VDD VSS DFFQX1
XTAP_TAPCELL_ROW_6_71 VDD VSS WELLTAP
XFILLER_148_528 VSS VDD FILLER2
XFILLER_89_4 VDD VSS DECAPHV8
X_15457_ _15457_/A _15462_/B VDD VSS _15693_/B XOR2X1
X_18245_ _18256_/CK _18245_/D _18272_/D _18405_/RB VDD VSS DFFRQX1
X_12669_ _12832_/A _12832_/B VDD VSS _14507_/B NAND2X1
XFILLER_129_742 VSS VDD FILLER2
X_14408_ _14426_/A _14408_/B VDD VSS _19129_/D NOR2X1
XTAP_TAPCELL_ROW_40_370 VDD VSS WELLTAP
XFILLER_128_241 VDD VSS FILLER1
X_15388_ _15425_/A _15425_/B VDD VSS _15413_/A NAND2X1
X_18176_ _18179_/A _18179_/B VDD VSS _18177_/B XNOR2X1
XFILLER_156_561 VSS VDD FILLER2
XFILLER_143_200 VSS VDD FILLER2
X_17127_ _19780_/Q _19748_/Q VDD VSS _17132_/A XNOR2X1
X_14339_ _14339_/A _14339_/B VDD VSS _19067_/D NOR2X1
XFILLER_7_582 VSS VDD FILLER2
XFILLER_143_233 VDD VSS FILLER1
X_17058_ _17062_/B _17073_/B VDD VSS _17064_/D XNOR2X1
XFILLER_116_469 VSS VDD FILLER2
XFILLER_131_417 VDD VSS DECAPHV16
XFILLER_143_277 VSS VDD FILLER2
X_16009_ _19678_/Q _16837_/B VDD VSS _16010_/A XNOR2X1
XFILLER_98_821 VSS VDD FILLER2
X_09880_ _09880_/A _09880_/B VDD VSS _09884_/B XOR2X1
XFILLER_124_491 VDD VSS FILLER4
XFILLER_32_0 VDD VSS FILLER1
XFILLER_111_130 VSS VDD FILLER2
XFILLER_112_675 VSS VDD FILLER2
XFILLER_97_364 VDD VSS FILLER1
XFILLER_97_375 VSS VDD FILLER2
XFILLER_111_185 VDD VSS FILLER1
XFILLER_66_751 VSS VDD FILLER2
Xclkbuf_2_3__f__000_ clkbuf_0__000_/Y VDD VSS clkload72/A BUFX12
XFILLER_122_39 VDD VSS FILLER4
XFILLER_26_626 VDD VSS DECAPHV16
XFILLER_93_592 VSS VDD FILLER2
XFILLER_53_434 VDD VSS DECAPHV8
XFILLER_81_787 VSS VDD FILLER2
XFILLER_80_264 VSS VDD FILLER2
XFILLER_41_629 VSS VDD FILLER2
X_09314_ _18292_/Q _18499_/D _09299_/Y VDD VSS _09314_/Y MUXI2X1
X_09245_ _18521_/Q VDD VSS _18340_/D INVX1
XFILLER_166_314 VDD VSS FILLER1
XFILLER_21_375 VSS VDD FILLER2
XFILLER_166_358 VSS VDD FILLER2
XFILLER_147_561 VSS VDD FILLER2
XTAP_TAPCELL_ROW_2_29 VDD VSS WELLTAP
XFILLER_147_594 VDD VSS FILLER4
XFILLER_135_756 VSS VDD FILLER2
XFILLER_162_531 VSS VDD FILLER2
XFILLER_150_704 VSS VDD FILLER2
Xoutput14 _20083_/Y VDD VSS o_aux_ctrl[1] BUFX3
Xoutput25 _20109_/Y VDD VSS o_bias_cfg[11] BUFX3
XFILLER_134_277 VSS VDD FILLER2
Xoutput36 _20119_/Y VDD VSS o_bias_cfg[21] BUFX3
Xoutput47 _20129_/Y VDD VSS o_bias_cfg[31] BUFX3
XFILLER_134_299 VDD VSS FILLER1
Xoutput58 _20133_/Y VDD VSS o_clk_cfg[0] BUFX3
Xoutput69 _20135_/Y VDD VSS o_clk_cfg[2] BUFX3
XFILLER_1_747 VDD VSS FILLER4
XFILLER_103_642 VSS VDD FILLER2
X_10020_ _18602_/Q _10026_/B VDD VSS _10022_/C XNOR2X1
X_20198_ _20198_/A VDD VSS _20198_/Y BUFX3
XFILLER_88_364 VSS VDD FILLER2
XFILLER_0_268 VSS VDD FILLER2
XFILLER_76_537 VDD VSS FILLER1
XFILLER_76_559 VSS VDD FILLER2
XFILLER_57_740 VDD VSS FILLER4
XFILLER_56_44 VSS VDD FILLER2
X_11971_ _12029_/A _12029_/B VDD VSS _14432_/B XNOR2X1
XFILLER_29_464 VDD VSS FILLER1
XFILLER_56_250 VSS VDD FILLER2
X_13710_ _13721_/A _13721_/B _13710_/C _13721_/E VDD VSS _14391_/B AOI211X1
XTAP_TAPCELL_ROW_46_429 VDD VSS WELLTAP
XFILLER_72_721 VSS VDD FILLER2
X_10922_ _11127_/A _10958_/A VDD VSS _10951_/A NAND2X1
XFILLER_56_283 VDD VSS FILLER1
XFILLER_17_637 VDD VSS DECAPHV8
X_14690_ _19360_/Q _15735_/B VDD VSS _14691_/B XNOR2X1
XFILLER_72_765 VDD VSS FILLER4
X_13641_ _19141_/Q _13719_/A _13719_/B VDD VSS _13710_/C XNOR3X1
XFILLER_32_607 VDD VSS DECAPHV8
X_10853_ _10853_/A _10853_/B VDD VSS _10921_/A NAND2X1
XFILLER_112_94 VDD VSS FILLER1
XFILLER_13_810 VSS VDD FILLER2
X_16360_ _16388_/A _16388_/B VDD VSS _16381_/A NAND2X1
XFILLER_72_65 VDD VSS FILLER4
X_13572_ _18888_/Q _13572_/B _13662_/C VDD VSS _13869_/B XNOR3X1
XTAP_TAPCELL_ROW_54_495 VDD VSS WELLTAP
X_10784_ _10784_/A _10784_/B VDD VSS _10814_/B NOR2X1
XFILLER_72_76 VDD VSS FILLER4
XFILLER_72_87 VDD VSS FILLER4
X_15311_ _15311_/A _15311_/B _15311_/C _15311_/D VDD VSS _15359_/B OAOI211X1
XFILLER_72_98 VSS VDD FILLER2
XFILLER_12_353 VSS VDD FILLER2
X_12523_ _18989_/Q _12537_/B _14249_/B VDD VSS _14212_/B XNOR3X1
X_16291_ _16292_/A _16292_/B _16292_/C VDD VSS _16320_/B AOI21X1
XFILLER_40_673 VDD VSS FILLER4
XFILLER_157_336 VSS VDD FILLER2
XFILLER_8_324 VDD VSS FILLER1
XFILLER_40_684 VSS VDD FILLER2
X_15242_ _15243_/A _15243_/B _15243_/D _15243_/C VDD VSS _15281_/B OAOI211X1
X_18030_ _18535_/Q _18030_/B _18536_/Q VDD VSS _18031_/C AOI21X1
X_12454_ _19099_/Q _14376_/B VDD VSS _12457_/C _14376_/C NAND3X1
X_11405_ _18528_/D _11428_/B VDD VSS _18600_/D NOR2BX1
X_15173_ _19343_/Q _15173_/B _15717_/B VDD VSS _15218_/B MIN3X1
X_12385_ _12553_/A _12553_/B VDD VSS _12462_/B NOR2X1
XFILLER_126_745 VDD VSS FILLER1
XFILLER_125_233 VDD VSS FILLER4
XFILLER_153_542 VSS VDD FILLER2
X_14124_ _14142_/A _14124_/B VDD VSS _18883_/D NOR2X1
X_11336_ _18587_/Q _11336_/B VDD VSS _11337_/C AND2X1
XFILLER_4_541 VSS VDD FILLER2
XFILLER_125_255 VDD VSS FILLER4
X_19981_ _19985_/CK _19981_/D _19981_/Q VDD VSS DFFQX1
XFILLER_21_91 VSS VDD FILLER2
XFILLER_113_406 VDD VSS FILLER1
XFILLER_141_715 VDD VSS FILLER4
XFILLER_125_277 VSS VDD FILLER2
XFILLER_113_428 VDD VSS FILLER1
XFILLER_141_737 VDD VSS FILLER4
XFILLER_137_91 VSS VDD FILLER2
X_18932_ _18934_/CK _18932_/D _18932_/Q VDD VSS DFFQX1
X_14055_ _18923_/Q _14170_/B _14170_/C VDD VSS _14058_/D OR3BX1
X_11267_ _11267_/A _11267_/B _11298_/C VDD VSS _11349_/B AOI21BX1
XFILLER_79_320 VDD VSS FILLER1
X_13006_ _13270_/A _13270_/B VDD VSS _14289_/B XNOR2X1
X_10218_ _10219_/C _16273_/A _10218_/C VDD VSS _18548_/D AND3BX1
XFILLER_95_802 VSS VDD FILLER2
X_18863_ _18889_/CK _18863_/D _18863_/Q VDD VSS DFFQX1
XFILLER_79_364 VDD VSS DECAPHV8
X_11198_ _19963_/Q _18845_/Q VDD VSS _11199_/B XOR2X1
XFILLER_79_375 VSS VDD FILLER2
XFILLER_121_472 VDD VSS FILLER1
XFILLER_95_835 VSS VDD FILLER2
XFILLER_39_217 VDD VSS FILLER1
X_17814_ _19927_/Q _19895_/Q VDD VSS _17815_/B XOR2X1
XFILLER_94_323 VSS VDD FILLER2
X_10149_ _10150_/A _10150_/B _10150_/D _10150_/C VDD VSS _10151_/B OAOI211X1
XFILLER_94_334 VDD VSS FILLER4
X_18794_ _18823_/CK _18794_/D _18794_/Q VDD VSS DFFQX1
XTAP_TAPCELL_ROW_146_1329 VDD VSS WELLTAP
XFILLER_94_345 VDD VSS FILLER4
X_17745_ _19911_/Q _19879_/Q _17745_/C VDD VSS _17748_/C MIN3X1
XFILLER_82_518 VDD VSS FILLER1
XFILLER_54_209 VDD VSS FILLER4
XFILLER_48_773 VSS VDD FILLER2
X_14957_ wire162/Y _14957_/B VDD VSS _15835_/B XNOR2X1
XFILLER_47_250 VSS VDD FILLER2
XFILLER_63_710 VSS VDD FILLER2
X_13908_ _19061_/Q _14333_/B VDD VSS _13965_/B XNOR2X1
X_17676_ _17812_/A VDD VSS _17806_/A BUFX3
X_14888_ _19393_/Q _15771_/B VDD VSS _14889_/B XNOR2X1
XFILLER_90_540 VDD VSS FILLER4
XFILLER_35_445 VSS VDD FILLER2
XFILLER_63_765 VDD VSS FILLER4
X_19415_ _19478_/CK _19415_/D _19415_/Q VDD VSS DFFQX1
X_16627_ _19575_/Q _19927_/Q VDD VSS _16628_/B XOR2X1
X_13839_ _13839_/A _14297_/B _14297_/C VDD VSS _13840_/D NOR3X1
XFILLER_63_798 VSS VDD FILLER2
XTAP_TAPCELL_ROW_17_164 VDD VSS WELLTAP
XFILLER_62_297 VSS VDD FILLER2
X_19346_ _19573_/CK _19346_/D _19346_/Q VDD VSS DFFQX1
XFILLER_50_448 VSS VDD FILLER2
XFILLER_16_692 VDD VSS FILLER4
X_16558_ _16558_/A _16569_/B VDD VSS _16862_/B XOR2X1
XFILLER_31_640 VSS VDD FILLER2
XFILLER_15_191 VDD VSS FILLER1
X_15509_ _15509_/A _15509_/B _15820_/B VDD VSS _15545_/A MIN3X1
X_19277_ _20013_/CK _19277_/D _19277_/Q VDD VSS DFFQX1
XTAP_TAPCELL_ROW_157_1425 VDD VSS WELLTAP
X_16489_ _16512_/A _16489_/B VDD VSS _19537_/D NOR2X1
XFILLER_31_695 VDD VSS FILLER1
XFILLER_136_509 VSS VDD FILLER2
XFILLER_148_369 VDD VSS FILLER4
X_18228_ _18228_/CK _18228_/E _18228_/ECK VDD VSS CGX3
XFILLER_129_561 VSS VDD FILLER2
X_18159_ _18159_/A _18159_/B VDD VSS _18162_/B NOR2X1
XFILLER_144_531 VDD VSS FILLER1
XFILLER_117_39 VSS VDD FILLER2
XFILLER_144_586 VDD VSS FILLER4
XTAP_TAPCELL_ROW_112_1019 VDD VSS WELLTAP
X_20121_ _20121_/A VDD VSS _20121_/Y BUFX3
X_09932_ _18596_/Q _09932_/B VDD VSS _11396_/A NOR2BX1
XFILLER_98_640 VDD VSS FILLER1
XTAP_TAPCELL_ROW_88_808 VDD VSS WELLTAP
X_20052_ _20052_/CK output5/A _20053_/D _20054_/RB VDD VSS DFFRQX1
XFILLER_86_802 VSS VDD FILLER2
X_09863_ _11435_/A _11196_/A VDD VSS _09885_/A NOR2X1
Xclkbuf_1_1__f__09186_ clkbuf_0__09186_/Y VDD VSS _18469_/CK BUFX12
XFILLER_100_623 VDD VSS FILLER4
XFILLER_85_323 VSS VDD FILLER2
XFILLER_100_634 VDD VSS FILLER4
XFILLER_133_27 VDD VSS FILLER1
X_09794_ _18342_/Q VDD VSS _20096_/A INVX1
XFILLER_100_656 VDD VSS FILLER1
XFILLER_39_740 VDD VSS FILLER4
XFILLER_85_356 VSS VDD FILLER2
XTAP_TAPCELL_ROW_96_874 VDD VSS WELLTAP
XFILLER_54_732 VSS VDD FILLER2
XTAP_TAPCELL_ROW_108_986 VDD VSS WELLTAP
XFILLER_38_294 VDD VSS FILLER4
XFILLER_54_765 VDD VSS FILLER4
XFILLER_14_607 VSS VDD FILLER2
XFILLER_26_58 VSS VDD FILLER2
XFILLER_54_787 VSS VDD FILLER2
XFILLER_26_478 VSS VDD FILLER2
XFILLER_41_415 VSS VDD FILLER2
XTAP_TAPCELL_ROW_51_476 VDD VSS WELLTAP
XFILLER_22_695 VSS VDD FILLER2
XFILLER_166_133 VSS VDD FILLER2
X_09228_ _18514_/Q VDD VSS _18365_/D INVX1
XFILLER_42_79 VSS VDD FILLER2
XFILLER_139_369 VSS VDD FILLER2
XFILLER_158_68 VDD VSS FILLER4
XFILLER_154_317 VSS VDD FILLER2
XFILLER_158_79 VDD VSS FILLER4
XFILLER_154_328 VSS VDD FILLER2
XFILLER_107_211 VDD VSS FILLER1
XTAP_TAPCELL_ROW_134_1222 VDD VSS WELLTAP
XFILLER_163_840 VSS VDD FILLER2
X_12170_ _19181_/Q _12329_/A _12329_/B VDD VSS _12171_/D XNOR3X1
XFILLER_162_350 VSS VDD FILLER2
XFILLER_1_500 VDD VSS FILLER4
X_11121_ _10845_/B _11119_/Y _11289_/A VDD VSS _11128_/B MUXI2X1
XFILLER_150_545 VDD VSS FILLER1
Xclkbuf_1_0__f_sclk clkbuf_0_sclk/Y VDD VSS delaybuf_1_sclk/A BUFX12
XFILLER_1_533 VSS VDD FILLER2
X_11052_ _11052_/A _11090_/B VDD VSS _11057_/B XNOR2X1
XFILLER_77_835 VSS VDD FILLER2
XFILLER_103_483 VDD VSS FILLER1
XFILLER_131_792 VSS VDD FILLER2
X_10003_ _09899_/Y _10058_/B _10034_/A VDD VSS _10107_/B MUXI2X1
XFILLER_76_323 VSS VDD FILLER2
X_15860_ _15867_/A _15860_/B VDD VSS _19469_/D NOR2X1
XFILLER_49_548 VSS VDD FILLER2
XTAP_TAPCELL_ROW_59_543 VDD VSS WELLTAP
X_14811_ _14811_/A _14811_/B _15769_/B VDD VSS _14858_/B MIN3X1
XFILLER_76_378 VDD VSS FILLER4
X_15791_ _15793_/A _15791_/B VDD VSS _19410_/D AND2X1
XFILLER_64_529 VDD VSS FILLER4
XFILLER_45_710 VDD VSS FILLER1
XFILLER_57_581 VDD VSS FILLER4
X_17530_ _17675_/A _17530_/B VDD VSS _19865_/D NOR2X1
XFILLER_123_82 VSS VDD FILLER2
X_14742_ _19526_/Q _19527_/Q _14742_/C _19528_/Q VDD VSS _14821_/C AOI31X1
X_11954_ _11954_/A _11954_/B _14304_/B VDD VSS _11955_/B MIN3X1
XFILLER_72_551 VDD VSS FILLER4
XFILLER_45_765 VSS VDD FILLER2
X_10905_ _18701_/Q _18755_/Q VDD VSS _10940_/B NAND2X1
X_17461_ _19851_/Q _19819_/Q VDD VSS _17468_/C NOR2X1
X_14673_ _19443_/Q _14673_/B _14673_/C VDD VSS _14733_/B MIN3X1
XFILLER_17_478 VDD VSS FILLER1
X_11885_ _19232_/Q VDD VSS _11981_/C INVX1
X_19200_ _19200_/CK _19200_/D _19200_/Q VDD VSS DFFQX1
X_16412_ _16512_/A _16412_/B VDD VSS _19534_/D NOR2X1
X_13624_ _13716_/B _14360_/C _19084_/Q VDD VSS _13625_/D AND3BX1
X_10836_ _10866_/A _10866_/B _10836_/C _10836_/D VDD VSS _10837_/D AOI31X1
X_17392_ _17389_/B _17392_/B VDD VSS _17393_/C NOR2BX1
XFILLER_13_662 VSS VDD FILLER2
X_19131_ _19157_/CK _19131_/D _19131_/Q VDD VSS DFFQX1
XFILLER_9_611 VSS VDD FILLER2
X_16343_ _16366_/B _16343_/B VDD VSS _16782_/B XNOR2X1
X_13555_ _13634_/A _14483_/B VDD VSS _13637_/D XNOR2X1
X_10767_ _18697_/Q _18751_/Q VDD VSS _10794_/B AND2X1
XFILLER_158_645 VDD VSS FILLER4
XFILLER_158_656 VSS VDD FILLER2
X_12506_ _19129_/Q _14408_/B VDD VSS _12546_/C XNOR2X1
XFILLER_157_144 VSS VDD FILLER2
XFILLER_118_509 VSS VDD FILLER2
X_16274_ _16274_/A _16274_/B VDD VSS _16275_/C NAND2X1
X_19062_ _19094_/CK _19062_/D _19062_/Q VDD VSS DFFQX1
XFILLER_158_678 VSS VDD FILLER2
XFILLER_157_155 VDD VSS FILLER1
XFILLER_146_829 VDD VSS FILLER1
X_13486_ _13486_/A _13486_/B _14127_/B VDD VSS _13575_/C MIN3X1
XFILLER_158_689 VDD VSS FILLER1
X_10698_ _11116_/A _10733_/B _10698_/C VDD VSS _10698_/Y OAI21X1
X_15225_ _15206_/A _15225_/B _15225_/C VDD VSS _15265_/B AOI2B1X1
X_18013_ _18056_/A _18013_/B _18056_/C VDD VSS _19965_/D OAI21X1
XFILLER_9_699 VSS VDD FILLER2
X_12437_ _18904_/Q _12527_/B _12527_/C VDD VSS _12609_/B MIN3X1
XFILLER_138_380 VSS VDD FILLER2
XFILLER_126_531 VSS VDD FILLER2
XFILLER_114_704 VDD VSS FILLER1
X_15156_ _15183_/C _15183_/D VDD VSS _15157_/C NAND2X1
XFILLER_153_350 VDD VSS FILLER1
X_12368_ _12380_/A _14375_/B _12380_/C VDD VSS _14376_/B OAI21X1
XFILLER_113_203 VDD VSS FILLER1
XFILLER_114_726 VSS VDD FILLER2
XFILLER_141_512 VSS VDD FILLER2
XTAP_TAPCELL_ROW_152_1377 VDD VSS WELLTAP
X_14107_ _17977_/A _17978_/B _17977_/B VDD VSS _17983_/C NOR3X1
XFILLER_4_360 VSS VDD FILLER2
XFILLER_114_748 VDD VSS FILLER1
X_11319_ _11319_/A _11319_/B VDD VSS _11322_/B AND2X1
XFILLER_141_534 VDD VSS DECAPHV16
X_15087_ _15088_/A _15088_/B VDD VSS _15809_/B NOR2X1
X_19964_ clkload3/A _19964_/D output5/A VDD VSS DFFQX1
X_12299_ _12299_/A _14375_/B _14375_/C VDD VSS _12300_/D NOR3X1
XFILLER_4_393 VSS VDD FILLER2
XFILLER_141_556 VSS VDD FILLER2
XFILLER_141_578 VSS VDD FILLER2
X_18915_ _18915_/CK _18915_/D _18915_/Q VDD VSS DFFQX1
X_14038_ _14038_/A _14169_/B _14054_/C _14038_/D VDD VSS _14086_/A OAOI211X1
X_19895_ _19895_/CK _19895_/D _19895_/Q VDD VSS DFFQX1
XFILLER_122_781 VDD VSS DECAPHV8
X_18846_ _18905_/CK _18846_/D _18846_/Q VDD VSS DFFQX1
XFILLER_95_643 VSS VDD FILLER2
XFILLER_67_334 VSS VDD FILLER2
XFILLER_95_654 VDD VSS DECAPHV16
XFILLER_94_142 VSS VDD FILLER2
XFILLER_82_304 VDD VSS FILLER1
X_18777_ _18831_/CK _18777_/D _18777_/Q VDD VSS DFFQX1
XFILLER_55_529 VDD VSS FILLER4
XFILLER_103_19 VSS VDD FILLER2
X_15989_ _15989_/A _15989_/B _15989_/C VDD VSS _16031_/B OA21X2
XFILLER_48_570 VSS VDD FILLER2
XFILLER_82_337 VSS VDD FILLER2
X_17728_ _17730_/A _17730_/B _17728_/C VDD VSS _19908_/D AOI21X1
XFILLER_63_540 VDD VSS DECAPHV8
XTAP_TAPCELL_ROW_163_1484 VDD VSS WELLTAP
X_17659_ _17838_/A VDD VSS _17746_/C BUFX3
XTAP_TAPCELL_ROW_105_956 VDD VSS WELLTAP
XFILLER_35_286 VSS VDD FILLER2
XFILLER_23_437 VSS VDD FILLER2
XFILLER_90_392 VSS VDD FILLER2
XFILLER_51_779 VSS VDD FILLER2
X_19329_ _19385_/CK _19329_/D _19329_/Q VDD VSS DFFQX1
XFILLER_148_155 VSS VDD FILLER2
XFILLER_149_689 VSS VDD FILLER2
XFILLER_12_49 VSS VDD FILLER2
XFILLER_136_328 VSS VDD FILLER2
XFILLER_164_648 VSS VDD FILLER2
XFILLER_163_114 VDD VSS FILLER4
XFILLER_117_520 VDD VSS FILLER4
XFILLER_128_27 VDD VSS FILLER4
XFILLER_145_840 VSS VDD FILLER2
XFILLER_163_136 VSS VDD FILLER2
XFILLER_128_49 VSS VDD FILLER2
XFILLER_163_169 VDD VSS FILLER1
XFILLER_105_715 VDD VSS FILLER4
XFILLER_117_575 VDD VSS FILLER1
XFILLER_144_372 VDD VSS FILLER4
XFILLER_132_523 VSS VDD FILLER2
XFILLER_144_15 VSS VDD FILLER2
X_20104_ _20104_/A VDD VSS _20104_/Y BUFX3
X_09915_ _11039_/C _09915_/B _09915_/C _09915_/D VDD VSS _09933_/B AOI22X1
XFILLER_144_59 VSS VDD FILLER2
XFILLER_98_470 VDD VSS FILLER4
XFILLER_113_781 VSS VDD FILLER2
XFILLER_59_835 VSS VDD FILLER2
XFILLER_58_323 VSS VDD FILLER2
X_20035_ _20045_/CK _20035_/D _20035_/Q _20045_/RB VDD VSS DFFRQX1
X_09846_ _18568_/Q _11039_/C _09849_/C _18569_/Q VDD VSS _09848_/A AOAI211X1
XFILLER_98_492 VSS VDD FILLER2
Xclkbuf_1_1__f__09169_ clkbuf_0__09169_/Y VDD VSS _18375_/CK BUFX12
XFILLER_85_142 VDD VSS FILLER4
XFILLER_46_507 VDD VSS FILLER4
X_09777_ _18357_/Q VDD VSS _20225_/A INVX1
XFILLER_73_315 VSS VDD FILLER2
XFILLER_160_25 VSS VDD FILLER2
XTAP_TAPCELL_ROW_56_513 VDD VSS WELLTAP
XFILLER_73_348 VDD VSS FILLER1
XFILLER_26_220 VSS VDD FILLER2
XFILLER_54_584 VSS VDD FILLER2
XFILLER_27_798 VSS VDD FILLER2
XFILLER_81_370 VSS VDD FILLER2
XFILLER_156_4 VDD VSS FILLER1
X_11670_ _16273_/A VDD VSS _14547_/B BUFX3
XTAP_TAPCELL_ROW_64_590 VDD VSS WELLTAP
XTAP_TAPCELL_ROW_140_1270 VDD VSS WELLTAP
XFILLER_41_256 VDD VSS FILLER1
XFILLER_139_100 VDD VSS FILLER1
X_10621_ _11116_/A _10621_/B _10621_/C VDD VSS _10746_/B OA21X2
XFILLER_128_807 VSS VDD FILLER2
XTAP_TAPCELL_ROW_11_115 VDD VSS WELLTAP
XFILLER_139_144 VSS VDD FILLER2
X_13340_ _13447_/A _14513_/B _13347_/C VDD VSS _14514_/C OR3BX1
XFILLER_10_643 VDD VSS DECAPHV8
X_10552_ _19945_/Q _18827_/Q VDD VSS _10553_/A XNOR2X1
XFILLER_155_604 VSS VDD FILLER2
XFILLER_127_317 VSS VDD FILLER2
XFILLER_154_114 VSS VDD FILLER2
X_13271_ _13271_/A _13271_/B _13271_/C _13271_/D VDD VSS _14322_/C AOAI211X1
X_10483_ _10803_/A _10483_/B _10483_/C _10483_/D VDD VSS _10496_/A AOI31X1
X_15010_ _19534_/Q _15058_/B VDD VSS _15901_/B XOR2X1
X_12222_ _12222_/A _14530_/B VDD VSS _12239_/A OR2X2
XFILLER_5_168 VSS VDD FILLER2
XFILLER_123_512 VSS VDD FILLER2
X_12153_ _14465_/B _14465_/C _12154_/A VDD VSS _12155_/C OAI21X1
XFILLER_151_854 VSS VDD FILLER2
XFILLER_2_842 VSS VDD FILLER2
XFILLER_123_556 VSS VDD FILLER2
X_11104_ _11146_/C _11104_/B VDD VSS _11105_/C XNOR2X1
XFILLER_111_729 VSS VDD FILLER2
X_16961_ _19748_/Q _16978_/B VDD VSS _16971_/A XOR2X1
X_12084_ _19095_/Q _12084_/B _12137_/C VDD VSS _12210_/A MIN3X1
XFILLER_78_75 VSS VDD FILLER2
XFILLER_89_470 VDD VSS FILLER1
X_18700_ _18810_/CK _18700_/D _18700_/Q VDD VSS DFFQX1
X_15912_ _16100_/A _15912_/B VDD VSS _19517_/D NOR2X1
X_11035_ _11067_/C _11041_/B _11226_/A VDD VSS _11041_/C AOI21X1
X_19680_ _19722_/CK _19680_/D _19680_/Q VDD VSS DFFQX1
X_16892_ _16899_/A _16892_/B VDD VSS _19728_/D AND2X1
XFILLER_77_654 VSS VDD FILLER2
XFILLER_134_70 VSS VDD FILLER2
XFILLER_76_142 VDD VSS FILLER4
XFILLER_65_816 VSS VDD FILLER2
X_18631_ _19939_/CK _18631_/D _18631_/Q VDD VSS DFFQX1
XFILLER_77_676 VSS VDD FILLER2
XFILLER_76_153 VSS VDD FILLER2
XFILLER_134_92 VSS VDD FILLER2
X_15843_ _15281_/B _15843_/B _17986_/C VDD VSS _19457_/D AND3BX1
XFILLER_94_41 VDD VSS FILLER4
XFILLER_77_687 VDD VSS FILLER1
XFILLER_76_197 VDD VSS FILLER1
X_18562_ _18578_/CK _18562_/D _18562_/Q VDD VSS DFFQX1
XFILLER_94_85 VSS VDD FILLER2
X_15774_ _15793_/A _15774_/B VDD VSS _19395_/D AND2X1
X_12986_ _13077_/A _13077_/B _13182_/C VDD VSS _17885_/B XNOR3X1
XFILLER_64_359 VDD VSS FILLER4
XFILLER_18_765 VDD VSS FILLER1
X_17513_ _17838_/A VDD VSS _17597_/C BUFX3
X_14725_ _19305_/Q _15673_/B VDD VSS _14768_/A NOR2X1
XFILLER_17_264 VSS VDD FILLER2
X_18493_ _18495_/CK _18493_/D _18493_/Q _18498_/RB VDD VSS DFFRQX1
X_11937_ _19177_/Q _11937_/B _11987_/C VDD VSS _12029_/B XNOR3X1
XTAP_TAPCELL_ROW_90_825 VDD VSS WELLTAP
XFILLER_91_189 VSS VDD FILLER2
XFILLER_17_286 VSS VDD FILLER2
XFILLER_32_223 VSS VDD FILLER2
X_17444_ _17446_/C _17444_/B _17444_/C VDD VSS _19847_/D AOI21X1
X_14656_ _14676_/A _14676_/B _14676_/D _14676_/C VDD VSS _14658_/D OAI211X1
X_11868_ _19120_/Q VDD VSS _11968_/A INVX1
XFILLER_33_768 VSS VDD FILLER2
X_13607_ _13607_/A _13607_/B _13607_/C _13607_/D VDD VSS _14262_/C OAI211X1
X_10819_ _10856_/A _10856_/B VDD VSS _10823_/A NAND2X1
X_17375_ _17390_/A _17375_/B VDD VSS _19832_/D NOR2X1
X_14587_ _19520_/Q _19519_/Q _19521_/Q VDD VSS _15887_/C AO21X2
X_11799_ _11804_/A _11804_/B _11804_/C VDD VSS _14523_/B OAI21X1
X_19114_ _19196_/CK _19114_/D _19114_/Q VDD VSS DFFQX1
XFILLER_119_818 VSS VDD FILLER2
X_16326_ _16326_/A _16326_/B VDD VSS _16327_/B _16326_/C NAND3X1
X_13538_ _19138_/Q _14419_/B VDD VSS _13620_/A NAND2X1
XFILLER_118_328 VDD VSS FILLER4
X_19045_ _19072_/CK _19045_/D _19045_/Q VDD VSS DFFQX1
X_16257_ _19912_/Q VDD VSS _17748_/A INVX1
X_13469_ _19167_/Q _13637_/A _13549_/B VDD VSS _13617_/D XOR3X1
XFILLER_127_840 VSS VDD FILLER2
XFILLER_145_158 VSS VDD FILLER2
X_15208_ _15223_/A _15223_/B VDD VSS _15749_/B XNOR2X1
X_16188_ _16206_/B _16188_/B VDD VSS _16204_/A XNOR2X1
XFILLER_126_372 VDD VSS FILLER4
XFILLER_142_832 VDD VSS FILLER1
XFILLER_5_680 VSS VDD FILLER2
XFILLER_114_534 VSS VDD FILLER2
X_15139_ _15139_/A _15139_/B _15139_/C _15139_/D VDD VSS _15200_/A AOAI211X1
XFILLER_99_234 VDD VSS FILLER1
XFILLER_102_707 VDD VSS DECAPHV8
X_19947_ _19947_/CK _19947_/D _19947_/Q VDD VSS DFFQX1
XFILLER_99_278 VDD VSS FILLER1
XFILLER_141_375 VDD VSS DECAPHV8
XFILLER_141_397 VDD VSS DECAPHV16
X_09700_ _09700_/A _09700_/B VDD VSS _18287_/D NAND2X1
XTAP_TAPCELL_ROW_165_1502 VDD VSS WELLTAP
X_19878_ clkload9/A _19878_/D _19878_/Q VDD VSS DFFQX1
XFILLER_95_440 VSS VDD FILLER2
X_09631_ _09814_/C VDD VSS _09813_/C BUFX3
XFILLER_56_816 VDD VSS FILLER1
XFILLER_110_773 VSS VDD FILLER2
X_18829_ _19946_/CK _18829_/D _18829_/Q VDD VSS DFFQX1
XFILLER_83_624 VSS VDD FILLER2
XFILLER_56_838 VSS VDD FILLER2
XFILLER_28_529 VDD VSS FILLER1
XFILLER_67_175 VSS VDD FILLER2
XFILLER_82_112 VSS VDD FILLER2
XFILLER_55_337 VDD VSS FILLER4
X_09562_ _18424_/Q _09673_/C VDD VSS _09563_/E NOR2X1
XFILLER_130_17 VSS VDD FILLER2
X_09493_ _18443_/D _09501_/B _09493_/C VDD VSS _18238_/D AOI21X1
XFILLER_63_370 VSS VDD FILLER2
XFILLER_36_584 VSS VDD FILLER2
XFILLER_36_595 VDD VSS FILLER1
XFILLER_24_768 VSS VDD FILLER2
XFILLER_23_278 VDD VSS FILLER1
Xclkbuf_leaf_10_clk_regs clkbuf_leaf_9_clk_regs/A VDD VSS _19791_/CK BUFX12
XTAP_TAPCELL_ROW_61_560 VDD VSS WELLTAP
XFILLER_135_9 VSS VDD FILLER2
XFILLER_109_317 VSS VDD FILLER2
XFILLER_136_158 VDD VSS DECAPHV8
XFILLER_152_607 VDD VSS DECAPHV8
Xclkbuf_leaf_4_sclk delaybuf_0_sclk/A VDD VSS _18220_/CK BUFX12
XFILLER_117_350 VSS VDD FILLER2
XFILLER_152_629 VDD VSS FILLER4
XFILLER_3_617 VSS VDD FILLER2
XFILLER_151_128 VSS VDD FILLER2
XFILLER_105_556 VSS VDD FILLER2
XFILLER_2_149 VSS VDD FILLER2
XFILLER_155_69 VDD VSS DECAPHV16
XFILLER_132_353 VDD VSS FILLER1
XFILLER_120_526 VSS VDD FILLER2
XFILLER_59_610 VSS VDD FILLER2
XFILLER_160_695 VSS VDD FILLER2
XFILLER_58_120 VSS VDD FILLER2
XFILLER_59_654 VDD VSS FILLER4
XFILLER_59_665 VSS VDD FILLER2
XFILLER_58_142 VSS VDD FILLER2
XFILLER_74_602 VSS VDD FILLER2
X_20018_ _20019_/CK _20018_/D _20018_/Q _20030_/RB VDD VSS DFFRQX1
XFILLER_47_827 VDD VSS FILLER1
X_09829_ _11435_/A _11196_/A VDD VSS _10313_/B OR2X2
XFILLER_74_613 VSS VDD FILLER2
XFILLER_74_635 VDD VSS FILLER4
XFILLER_73_112 VSS VDD FILLER2
XTAP_TAPCELL_ROW_129_1176 VDD VSS WELLTAP
X_12840_ _12840_/A _12840_/B _12840_/C _12840_/D VDD VSS _12843_/B OAOI211X1
XFILLER_104_62 VDD VSS FILLER1
XFILLER_64_44 VSS VDD FILLER2
X_12771_ _12771_/A _12771_/B _14474_/B _12771_/D _12771_/E VDD VSS _12940_/C OAI221X1
XFILLER_73_189 VSS VDD FILLER2
XFILLER_64_66 VDD VSS DECAPHV16
XFILLER_42_521 VSS VDD FILLER2
X_14510_ _14491_/Y _14510_/B _14510_/C VDD VSS _19217_/D AND3BX1
X_11722_ _19227_/Q VDD VSS _11751_/A INVX1
XFILLER_54_392 VSS VDD FILLER2
X_15490_ _19379_/Q _15756_/B VDD VSS _15492_/C XOR2X1
XFILLER_14_245 VDD VSS FILLER4
XFILLER_30_716 VSS VDD FILLER2
XFILLER_159_228 VDD VSS FILLER1
XFILLER_147_0 VSS VDD FILLER2
X_14441_ _14449_/A _14441_/B _14441_/C VDD VSS _19157_/D NOR3X1
X_11653_ _18793_/Q _11658_/B VDD VSS _18820_/D AND2X1
X_10604_ _19946_/Q _18828_/Q VDD VSS _10633_/C NAND2X1
X_17160_ _17160_/A _17160_/B _17160_/C VDD VSS _17168_/A OA21X2
X_14372_ _14393_/A _14372_/B VDD VSS _19095_/D NOR2X1
X_11584_ _18730_/Q _11589_/B VDD VSS _18757_/D AND2X1
XFILLER_10_451 VDD VSS FILLER4
X_16111_ _19554_/Q VDD VSS _16112_/A INVX1
X_13323_ _13365_/A _13365_/B _13365_/D _13365_/C VDD VSS _13437_/B OAOI211X1
X_10535_ _10579_/D _10535_/B _10535_/C _11255_/A VDD VSS _10536_/D AOAI211X1
XFILLER_109_840 VSS VDD FILLER2
X_17091_ _17089_/B _17091_/B VDD VSS _17092_/C NOR2BX1
XFILLER_10_484 VSS VDD FILLER2
XFILLER_127_147 VDD VSS FILLER1
XFILLER_6_444 VSS VDD FILLER2
X_16042_ _19616_/Q _16768_/B VDD VSS _16043_/B XNOR2X1
X_13254_ _13254_/A _14478_/B _13254_/C _13254_/D VDD VSS _13457_/A OAOI211X1
X_10466_ _10511_/A _10624_/B _10624_/C _10466_/D VDD VSS _10467_/B AOI31X1
XFILLER_136_681 VSS VDD FILLER2
X_12205_ _19097_/Q wire159/Y _12208_/B VDD VSS _12257_/D XNOR3X1
XFILLER_89_63 VSS VDD FILLER2
XFILLER_6_499 VDD VSS FILLER4
X_13185_ _13290_/A _13290_/B VDD VSS _13286_/C XOR2X1
XFILLER_89_85 VSS VDD FILLER2
XFILLER_123_331 VDD VSS FILLER4
XFILLER_135_191 VDD VSS FILLER1
XFILLER_151_640 VDD VSS FILLER4
X_10397_ _10476_/A VDD VSS _10441_/A INVX1
XFILLER_89_96 VDD VSS FILLER4
XFILLER_123_353 VDD VSS FILLER1
X_19801_ clkload5/A _19801_/D _19801_/Q VDD VSS DFFQX1
X_12136_ _19095_/Q VDD VSS _12255_/A INVX1
XFILLER_2_650 VDD VSS FILLER1
XFILLER_123_375 VSS VDD FILLER2
X_17993_ _18532_/Q _18533_/Q VDD VSS _18026_/B _18024_/B AND3X2
XFILLER_151_695 VDD VSS FILLER4
XFILLER_145_91 VSS VDD FILLER2
X_19732_ _19734_/CK _19732_/D _19732_/Q VDD VSS DFFQX1
X_16944_ _16945_/A _16948_/C _17081_/C VDD VSS _16945_/C OAI21X1
X_12067_ _18983_/Q _12072_/B _12072_/C VDD VSS _14206_/B XNOR3X1
XFILLER_77_440 VSS VDD FILLER2
X_11018_ _11364_/A _11018_/B VDD VSS _11019_/C NAND2X1
XTAP_TAPCELL_ROW_67_619 VDD VSS WELLTAP
XFILLER_77_462 VSS VDD FILLER2
X_19663_ _19664_/CK _19663_/D _19663_/Q VDD VSS DFFQX1
X_16875_ _16876_/A _16875_/B VDD VSS _19712_/D NOR2X1
XFILLER_92_421 VDD VSS FILLER4
XFILLER_77_495 VSS VDD FILLER2
X_18614_ _18622_/CK _18614_/D _18614_/Q VDD VSS DFFQX1
X_15826_ _15830_/A _15826_/B VDD VSS _19441_/D NOR2X1
XFILLER_37_348 VSS VDD FILLER2
X_19594_ _19664_/CK _19594_/D _19594_/Q VDD VSS DFFQX1
XTAP_TAPCELL_ROW_9_93 VDD VSS WELLTAP
X_18545_ _18550_/CK _18545_/D _18545_/Q VDD VSS DFFQX1
X_15757_ _15758_/A _15757_/B VDD VSS _19380_/D NOR2X1
XTAP_TAPCELL_ROW_75_685 VDD VSS WELLTAP
XFILLER_92_498 VSS VDD FILLER2
X_12969_ _13133_/A _13133_/B VDD VSS _12970_/C AND2X1
XTAP_TAPCELL_ROW_160_1454 VDD VSS WELLTAP
XFILLER_45_370 VSS VDD FILLER2
XFILLER_61_830 VDD VSS FILLER1
XFILLER_18_595 VDD VSS FILLER1
X_14708_ _14708_/A _14708_/B _14708_/C VDD VSS _14781_/A NOR3X1
XFILLER_33_543 VDD VSS FILLER4
X_18476_ _18479_/CK _18513_/Q _20121_/A _18491_/RB VDD VSS DFFRQX1
X_15688_ _15693_/A _15688_/B VDD VSS _19317_/D NOR2X1
XFILLER_33_576 VSS VDD FILLER2
X_17427_ _19843_/Q _19811_/Q _17427_/C VDD VSS _17431_/B MIN3X1
X_14639_ _14639_/A _14639_/B _15826_/B VDD VSS _14640_/B MIN3X1
XFILLER_165_209 VSS VDD FILLER2
X_17358_ _19829_/Q _19797_/Q VDD VSS _17360_/B XOR2X1
XFILLER_146_401 VDD VSS DECAPHV16
XFILLER_119_637 VSS VDD FILLER2
X_16309_ _19626_/Q _16780_/B VDD VSS _16320_/A NOR2X1
XFILLER_9_271 VSS VDD FILLER2
XFILLER_9_282 VSS VDD FILLER2
X_17289_ _17289_/A _17289_/B _17289_/C _17289_/D VDD VSS _17290_/C AOAI211X1
XTAP_TAPCELL_ROW_30_287 VDD VSS WELLTAP
XFILLER_134_607 VSS VDD FILLER2
Xclkload30 _19947_/CK VDD VSS clkload30/Y INVX1
XFILLER_146_478 VDD VSS DECAPHV8
X_19028_ _19086_/CK _19028_/D _19028_/Q VDD VSS DFFQX1
Xclkload41 _19217_/CK VDD VSS clkload41/Y BUFX12
Xclkload52 _19134_/CK VDD VSS clkload52/Y INVX2
Xclkload63 _18973_/CK VDD VSS clkload63/Y BUFX12
XFILLER_161_426 VDD VSS DECAPHV8
Xclkload74 _19508_/CK VDD VSS clkload74/Y INVX2
Xclkbuf_leaf_19__002_ clkload16/A VDD VSS _19959_/CK BUFX12
Xclkload85 _19333_/CK VDD VSS clkload85/Y BUFX12
Xclkload96 _19695_/CK VDD VSS clkload96/Y INVX2
XFILLER_87_204 VSS VDD FILLER2
XFILLER_88_738 VSS VDD FILLER2
XFILLER_102_526 VSS VDD FILLER2
XFILLER_56_602 VSS VDD FILLER2
XFILLER_96_782 VSS VDD FILLER2
XFILLER_68_473 VSS VDD FILLER2
XFILLER_96_793 VSS VDD FILLER2
XFILLER_29_849 VDD VSS FILLER4
X_09614_ _18298_/Q _09797_/B _09813_/B _20100_/A VDD VSS _09615_/E AO22X2
XFILLER_55_134 VDD VSS FILLER4
XFILLER_55_156 VDD VSS DECAPHV16
XTAP_TAPCELL_ROW_38_354 VDD VSS WELLTAP
X_09545_ _20039_/Q _09547_/B VDD VSS _20040_/D NOR2BX1
XFILLER_43_329 VSS VDD FILLER2
XFILLER_55_189 VSS VDD FILLER2
XFILLER_70_137 VSS VDD FILLER2
XFILLER_52_841 VSS VDD FILLER2
X_09476_ _19977_/Q _09490_/B _09476_/C VDD VSS _09477_/C AOI21X1
Xclkload2 clkload2/A VDD VSS clkload2/Y INVX1
XFILLER_7_219 VSS VDD FILLER2
XFILLER_137_423 VDD VSS FILLER1
XFILLER_50_24 VDD VSS FILLER4
XFILLER_166_13 VSS VDD FILLER2
XFILLER_20_793 VDD VSS FILLER4
XFILLER_50_57 VSS VDD FILLER2
XFILLER_165_765 VDD VSS FILLER4
XFILLER_166_35 VSS VDD FILLER2
XFILLER_125_618 VDD VSS FILLER1
X_10320_ _18658_/Q _18766_/Q VDD VSS _10323_/B NOR2X1
XFILLER_165_787 VSS VDD FILLER2
XFILLER_164_253 VSS VDD FILLER2
XFILLER_165_798 VSS VDD FILLER2
XFILLER_124_128 VSS VDD FILLER2
XFILLER_152_448 VSS VDD FILLER2
X_10251_ _18624_/Q _11436_/C VDD VSS _11432_/D OR2X2
XFILLER_3_447 VSS VDD FILLER2
XFILLER_105_342 VSS VDD FILLER2
XFILLER_79_716 VSS VDD FILLER2
XFILLER_132_150 VSS VDD FILLER2
XFILLER_105_375 VDD VSS FILLER4
X_10182_ _11226_/D _10182_/B _10145_/C _11435_/B VDD VSS _10189_/B OAI2B2BX1
XFILLER_121_835 VSS VDD FILLER2
XFILLER_78_226 VDD VSS FILLER4
XFILLER_78_248 VDD VSS FILLER1
XFILLER_120_345 VDD VSS FILLER4
XFILLER_120_356 VDD VSS FILLER1
X_14990_ _19339_/Q VDD VSS _14991_/A INVX1
XFILLER_94_719 VSS VDD FILLER2
XFILLER_115_72 VDD VSS FILLER1
X_13941_ _13941_/A _13941_/B _13941_/C _13941_/D VDD VSS _17945_/B AOAI211X1
XFILLER_86_270 VSS VDD FILLER2
XFILLER_47_624 VSS VDD FILLER2
XFILLER_74_421 VSS VDD FILLER2
X_16660_ _16674_/B _16660_/B VDD VSS _16671_/A XNOR2X1
X_13872_ _13872_/A _13872_/B _13872_/C _13872_/D VDD VSS _17924_/B AOAI211X1
X_15611_ _15611_/A _15614_/B VDD VSS _18169_/B XNOR2X1
X_12823_ _19132_/Q _14411_/B VDD VSS _12939_/A AND2X1
XFILLER_61_104 VDD VSS FILLER1
X_16591_ _19733_/Q _16898_/B VDD VSS _16616_/A NOR2X1
XFILLER_27_370 VSS VDD FILLER2
XFILLER_131_60 VSS VDD FILLER2
X_18330_ _18343_/CK _18511_/Q _20084_/A _18374_/RB VDD VSS DFFRQX1
X_15542_ _15789_/B VDD VSS _15543_/B INVX1
X_12754_ _19242_/Q _14536_/B VDD VSS _12835_/A AND2X1
XFILLER_91_42 VSS VDD FILLER2
X_18261_ _18275_/CK _18261_/D _18261_/Q _18486_/RB VDD VSS DFFRQX1
X_11705_ _19989_/Q _19253_/Q VDD VSS _11736_/B XNOR2X1
X_15473_ _15473_/A _15912_/B VDD VSS _15474_/C OR2X2
X_12685_ _19187_/Q _14474_/B VDD VSS _12739_/C XNOR2X1
XFILLER_91_86 VDD VSS FILLER4
XFILLER_147_209 VSS VDD FILLER2
X_17212_ _19797_/Q _19765_/Q _17212_/C VDD VSS _17215_/B MIN3X1
X_14424_ _14426_/A _14424_/B VDD VSS _19142_/D NOR2X1
X_11636_ _11648_/A VDD VSS _11647_/B BUFX3
XFILLER_30_557 VSS VDD FILLER2
X_18192_ _18192_/A _18195_/C VDD VSS _18193_/B XNOR2X1
X_17143_ _19783_/Q _19751_/Q VDD VSS _17145_/B XOR2X1
X_14355_ _14355_/A _14355_/B VDD VSS _14356_/B NAND2X1
X_11567_ _18715_/Q _11567_/B VDD VSS _18742_/D AND2X1
XFILLER_128_456 VSS VDD FILLER2
XFILLER_7_742 VSS VDD FILLER2
XFILLER_116_607 VSS VDD FILLER2
XFILLER_7_764 VSS VDD FILLER2
X_13306_ _13373_/A _13373_/B _13307_/D _13373_/E VDD VSS _14259_/B OA211X2
X_10518_ _10927_/C _10518_/B _10518_/C VDD VSS _10579_/A OA21X2
X_17074_ _17075_/A _17075_/B VDD VSS _17077_/C NOR2X1
X_14286_ _14294_/A _14286_/B _14286_/C VDD VSS _19020_/D NOR3X1
XFILLER_7_786 VSS VDD FILLER2
XFILLER_115_117 VSS VDD FILLER2
X_11498_ _16860_/A VDD VSS _11508_/B BUFX3
XFILLER_7_797 VSS VDD FILLER2
XFILLER_143_448 VSS VDD FILLER2
X_16025_ _19710_/Q _16873_/B _16025_/C VDD VSS _16028_/B MIN3X1
X_13237_ _19219_/Q _14512_/B VDD VSS _13254_/A NOR2BX1
X_10449_ _10530_/B _11095_/C _10449_/C VDD VSS _10462_/B OR3BX1
XFILLER_112_824 VDD VSS DECAPHV8
XFILLER_123_150 VSS VDD FILLER2
X_13168_ _18968_/Q _13168_/B _13192_/D VDD VSS _13295_/B XNOR3X1
XFILLER_124_695 VSS VDD FILLER2
XFILLER_34_4 VSS VDD FILLER2
XFILLER_151_492 VDD VSS FILLER4
XFILLER_111_334 VDD VSS FILLER4
X_12119_ _19096_/Q _12119_/B _12149_/C VDD VSS _12447_/B XNOR3X1
XFILLER_97_557 VDD VSS FILLER1
X_17976_ _17976_/A _17976_/B _17976_/C _17976_/D VDD VSS _17987_/A OAOI211X1
X_13099_ _19051_/Q _14321_/B VDD VSS _13415_/A NOR2BX1
XFILLER_85_719 VDD VSS FILLER4
X_19715_ _19730_/CK _19715_/D _19715_/Q VDD VSS DFFQX1
X_16927_ _19740_/Q wire164/Y VDD VSS _16928_/C NAND2X1
XFILLER_78_782 VDD VSS DECAPHV8
XFILLER_38_613 VDD VSS FILLER4
XFILLER_78_793 VDD VSS FILLER4
X_19646_ _19667_/CK _19646_/D _19646_/Q VDD VSS DFFQX1
XFILLER_38_657 VSS VDD FILLER2
X_16858_ _16865_/A _16858_/B VDD VSS _19697_/D NOR2X1
X_15809_ _17010_/A _15809_/B _15809_/C VDD VSS _19425_/D NOR3X1
X_19577_ _19737_/CK _19577_/D _19577_/Q VDD VSS DFFQX1
XFILLER_37_189 VSS VDD FILLER2
X_16789_ _16794_/A _16789_/B VDD VSS _19635_/D NOR2X1
X_09330_ _18447_/D _09329_/Y _09302_/Y VDD VSS _18516_/D MUXI2X1
XTAP_TAPCELL_ROW_35_324 VDD VSS WELLTAP
XFILLER_52_137 VSS VDD FILLER2
X_18528_ _18543_/CK _18528_/D _18528_/Q VDD VSS DFFQX1
X_09261_ _09351_/B _09265_/C _09261_/C VDD VSS _18279_/D AOI2B1X1
X_18459_ _18471_/CK _18512_/Q _18459_/Q _18463_/RB VDD VSS DFFRQX1
XFILLER_166_507 VSS VDD FILLER2
X_09192_ _18519_/Q VDD VSS _18450_/D INVX1
XFILLER_147_721 VDD VSS FILLER4
XFILLER_119_434 VSS VDD FILLER2
XFILLER_146_231 VDD VSS FILLER1
XFILLER_162_702 VDD VSS FILLER1
XFILLER_134_415 VSS VDD FILLER2
XFILLER_146_275 VDD VSS FILLER4
XFILLER_20_27 VSS VDD FILLER2
XFILLER_20_38 VSS VDD FILLER2
XFILLER_162_735 VSS VDD FILLER2
XFILLER_134_437 VSS VDD FILLER2
XFILLER_20_49 VSS VDD FILLER2
XFILLER_161_234 VSS VDD FILLER2
XFILLER_136_49 VSS VDD FILLER2
XFILLER_162_779 VDD VSS FILLER1
XFILLER_161_278 VDD VSS FILLER1
XFILLER_103_824 VSS VDD FILLER2
XFILLER_0_428 VDD VSS FILLER1
XFILLER_0_439 VDD VSS FILLER4
XFILLER_102_323 VSS VDD FILLER2
XFILLER_130_643 VSS VDD FILLER2
X_09970__241 _20081_/CK VDD VSS _18517_/CK INVX1
XFILLER_102_345 VSS VDD FILLER2
XFILLER_76_708 VDD VSS DECAPHV16
XFILLER_102_367 VSS VDD FILLER2
XFILLER_68_270 VSS VDD FILLER2
XFILLER_68_281 VSS VDD FILLER2
XFILLER_56_421 VSS VDD FILLER2
XFILLER_17_819 VSS VDD FILLER2
XTAP_TAPCELL_ROW_126_1146 VDD VSS WELLTAP
XFILLER_43_115 VSS VDD FILLER2
X_09528_ _20023_/Q _18201_/A VDD VSS _20024_/D NOR2X1
XFILLER_71_468 VSS VDD FILLER2
XFILLER_52_660 VDD VSS FILLER1
XFILLER_40_811 VSS VDD FILLER2
XFILLER_101_52 VDD VSS FILLER1
X_09459_ _19969_/Q _09467_/B _09476_/C VDD VSS _09460_/C AOI21X1
XFILLER_101_96 VSS VDD FILLER2
XFILLER_129_209 VSS VDD FILLER2
XFILLER_157_518 VDD VSS FILLER4
X_12470_ _12593_/A _12593_/B _12593_/E VDD VSS _12546_/B OA21X2
XFILLER_12_568 VSS VDD FILLER2
X_11421_ _11422_/A _11429_/B _11421_/C VDD VSS _18615_/D NOR3X1
XFILLER_137_231 VDD VSS DECAPHV8
XTAP_TAPCELL_ROW_137_1242 VDD VSS WELLTAP
XFILLER_137_253 VDD VSS DECAPHV8
XFILLER_138_787 VSS VDD FILLER2
X_14140_ _14136_/Y _14140_/B _14140_/C VDD VSS _18897_/D AND3BX1
X_11352_ _11352_/A _11352_/B _11352_/C VDD VSS _11355_/C AOI21X1
XFILLER_125_415 VSS VDD FILLER2
XFILLER_125_426 VDD VSS DECAPHV8
XFILLER_153_735 VSS VDD FILLER2
X_10303_ _11438_/A _11430_/B _11435_/A VDD VSS _10304_/D AND3BX1
X_14071_ _14086_/A _14086_/B _14086_/C VDD VSS _14072_/C OAI21X1
X_11283_ _11383_/A _11283_/B VDD VSS _18582_/D NOR2X1
XFILLER_4_756 VSS VDD FILLER2
X_13022_ _19133_/Q _14413_/B _14413_/C VDD VSS _13023_/D OR3BX1
XFILLER_79_502 VDD VSS FILLER1
XFILLER_10_60 VDD VSS FILLER1
X_10234_ _10234_/A _10234_/B VDD VSS _11429_/C XOR2X1
XFILLER_3_277 VSS VDD FILLER2
XFILLER_121_621 VDD VSS FILLER4
XFILLER_121_643 VDD VSS FILLER1
X_17830_ _19930_/Q _19931_/Q _19932_/Q _18087_/D VDD VSS _17831_/D AOAI211X1
XFILLER_121_654 VSS VDD FILLER2
X_10165_ _10190_/B _10165_/B VDD VSS _10166_/C NOR2X1
XFILLER_86_31 VDD VSS DECAPHV8
XFILLER_79_568 VSS VDD FILLER2
XFILLER_126_93 VSS VDD FILLER2
XFILLER_120_142 VSS VDD FILLER2
XTAP_TAPCELL_ROW_77_703 VDD VSS WELLTAP
XFILLER_121_687 VSS VDD FILLER2
X_17761_ _17766_/C _17766_/B VDD VSS _17763_/B NAND2BX1
X_14973_ _15013_/A _14973_/B VDD VSS _15052_/B XNOR2X1
X_10096_ _18607_/Q _10098_/B VDD VSS _10097_/B NAND2X1
XFILLER_94_549 VSS VDD FILLER2
XFILLER_47_421 VDD VSS FILLER4
X_19500_ _19528_/CK _19500_/D _19500_/Q VDD VSS DFFQX1
XFILLER_47_432 VSS VDD FILLER2
XFILLER_19_123 VDD VSS FILLER4
X_16712_ _19917_/Q _16726_/B VDD VSS _19565_/D AND2X1
X_13924_ _13924_/A _13924_/B _13924_/C _13924_/D VDD VSS _13949_/B AOAI211X1
X_17692_ _17690_/B _17692_/B VDD VSS _17693_/C NOR2BX1
XFILLER_90_700 VDD VSS FILLER4
XFILLER_19_91 VSS VDD FILLER2
X_19431_ _19460_/CK _19431_/D _19431_/Q VDD VSS DFFQX1
XFILLER_142_92 VSS VDD FILLER2
X_16643_ _16643_/A _16643_/B _16643_/C _16643_/D VDD VSS _16668_/B OAOI211X1
XFILLER_90_722 VDD VSS DECAPHV16
XFILLER_75_796 VDD VSS FILLER4
XFILLER_34_104 VSS VDD FILLER2
X_13855_ _19088_/Q _14364_/B VDD VSS _13910_/A XOR2X1
XTAP_TAPCELL_ROW_85_780 VDD VSS WELLTAP
XFILLER_19_189 VSS VDD FILLER2
XFILLER_74_295 VSS VDD FILLER2
XFILLER_35_649 VSS VDD FILLER2
X_19362_ _19379_/CK _19362_/D _19362_/Q VDD VSS DFFQX1
X_12806_ _19075_/Q _14348_/B VDD VSS _12807_/D _14348_/C NAND3X1
X_16574_ _19572_/Q _19924_/Q _16574_/C VDD VSS _16602_/C AOI2B1X1
XFILLER_62_468 VDD VSS FILLER4
X_13786_ _13860_/A _14329_/B VDD VSS _13831_/B AND2X1
X_10998_ _18649_/Q _18811_/Q _10998_/C VDD VSS _11030_/C MIN3X1
XFILLER_90_788 VSS VDD FILLER2
XFILLER_43_660 VDD VSS FILLER1
X_18313_ _18327_/CK _18510_/Q _18313_/Q _20067_/RB VDD VSS DFFRQX1
XTAP_TAPCELL_ROW_32_305 VDD VSS WELLTAP
X_15525_ _15525_/A _15525_/B _15525_/C VDD VSS _15543_/C OAI21X1
X_19293_ _19306_/CK _19293_/D _19293_/Q VDD VSS DFFQX1
X_12737_ _12737_/A _14442_/B VDD VSS _12816_/A OR2X2
XFILLER_148_518 VSS VDD FILLER2
XFILLER_30_332 VSS VDD FILLER2
X_18244_ _18256_/CK _18244_/D _18273_/D _18405_/RB VDD VSS DFFRQX1
XFILLER_30_343 VSS VDD FILLER2
X_15456_ _15456_/A _15456_/B _15456_/C VDD VSS _15462_/B OAI21X1
X_12668_ _12837_/A _12837_/B _12837_/D _12837_/C VDD VSS _12832_/B AOAI211X1
XFILLER_30_365 VSS VDD FILLER2
X_14407_ _14381_/Y _14407_/B _14407_/C VDD VSS _19128_/D AND3BX1
XFILLER_30_387 VDD VSS FILLER4
X_18175_ _19301_/Q VDD VSS _18179_/A INVX1
X_11619_ _18762_/Q _11624_/B VDD VSS _18789_/D AND2X1
XTAP_TAPCELL_ROW_40_371 VDD VSS WELLTAP
X_15387_ _19376_/Q _15753_/B VDD VSS _15425_/A NAND2X1
X_12599_ _12600_/B _12600_/C _19017_/Q VDD VSS _12894_/B AOI21X1
X_17126_ _17128_/C _17126_/B _17126_/C VDD VSS _19779_/D AOI21X1
XFILLER_129_798 VSS VDD FILLER2
XFILLER_144_724 VDD VSS FILLER4
X_14338_ _14339_/A _14338_/B VDD VSS _19066_/D NOR2X1
XFILLER_7_561 VDD VSS DECAPHV8
XFILLER_143_223 VDD VSS DECAPHV8
XFILLER_144_746 VSS VDD FILLER2
XFILLER_7_594 VDD VSS FILLER1
XFILLER_116_448 VSS VDD FILLER2
XFILLER_116_459 VSS VDD FILLER2
X_17057_ _19765_/Q VDD VSS _17062_/B INVX1
X_14269_ _14270_/A _14269_/B VDD VSS _19007_/D AND2X1
X_16008_ _16028_/C _16028_/A VDD VSS _16026_/A NAND2BX1
XFILLER_106_19 VSS VDD FILLER2
XFILLER_112_654 VSS VDD FILLER2
XFILLER_58_708 VSS VDD FILLER2
XFILLER_97_354 VDD VSS DECAPHV8
XFILLER_111_142 VDD VSS FILLER1
X_17959_ _17959_/A _17959_/B VDD VSS _17960_/B NOR2X1
XFILLER_85_538 VSS VDD FILLER2
XFILLER_38_421 VSS VDD FILLER2
XFILLER_66_741 VDD VSS FILLER4
XFILLER_38_454 VDD VSS FILLER4
XFILLER_65_262 VDD VSS FILLER4
XFILLER_65_273 VDD VSS FILLER4
X_19629_ _19661_/CK _19629_/D _19629_/Q VDD VSS DFFQX1
XFILLER_81_766 VDD VSS FILLER4
XFILLER_53_468 VSS VDD FILLER2
XFILLER_41_619 VDD VSS FILLER4
X_09313_ _18405_/RB _09322_/B VDD VSS _09313_/Y NOR2BX1
XFILLER_40_129 VDD VSS FILLER1
X_09244_ _18501_/D VDD VSS _18341_/D INVX1
XTAP_TAPCELL_ROW_121_1098 VDD VSS WELLTAP
XFILLER_166_326 VDD VSS FILLER4
XFILLER_166_337 VDD VSS DECAPHV16
XFILLER_31_26 VSS VDD FILLER2
XFILLER_119_264 VSS VDD FILLER2
XFILLER_107_426 VDD VSS FILLER4
XFILLER_107_448 VDD VSS FILLER1
Xoutput15 _20084_/Y VDD VSS o_aux_ctrl[2] BUFX3
XFILLER_162_565 VSS VDD FILLER2
Xoutput26 _20110_/Y VDD VSS o_bias_cfg[12] BUFX3
Xoutput37 _20120_/Y VDD VSS o_bias_cfg[22] BUFX3
XFILLER_115_470 VDD VSS FILLER1
Xoutput48 _20130_/Y VDD VSS o_bias_cfg[32] BUFX3
Xoutput59 _20143_/Y VDD VSS o_clk_cfg[10] BUFX3
XFILLER_88_310 VDD VSS DECAPHV8
XFILLER_1_759 VSS VDD FILLER2
XFILLER_88_343 VSS VDD FILLER2
XFILLER_163_47 VSS VDD FILLER2
XFILLER_103_654 VSS VDD FILLER2
XFILLER_102_142 VSS VDD FILLER2
X_20197_ _20197_/A VDD VSS _20197_/Y BUFX3
XFILLER_103_687 VDD VSS FILLER4
XFILLER_48_229 VSS VDD FILLER2
XFILLER_102_186 VSS VDD FILLER2
X_11970_ _19121_/Q _12022_/A _14400_/B VDD VSS _12087_/A MIN3X1
XFILLER_56_56 VSS VDD FILLER2
XFILLER_72_700 VSS VDD FILLER2
XFILLER_17_605 VSS VDD FILLER2
X_10921_ _10921_/A _10921_/B _10921_/C VDD VSS _10958_/A OR3X2
XFILLER_17_649 VSS VDD FILLER2
XFILLER_16_115 VSS VDD FILLER2
XFILLER_71_221 VDD VSS DECAPHV16
XFILLER_44_435 VSS VDD FILLER2
XFILLER_16_137 VSS VDD FILLER2
X_13640_ _13640_/A _13640_/B _13640_/C _13640_/D VDD VSS _13719_/B OAOI211X1
X_10852_ _11378_/A _10852_/B _10885_/B VDD VSS _18566_/D NOR3X1
XTAP_TAPCELL_ROW_82_750 VDD VSS WELLTAP
XFILLER_72_22 VDD VSS FILLER1
XFILLER_112_84 VDD VSS FILLER1
XFILLER_13_800 VSS VDD FILLER2
XFILLER_44_479 VDD VSS FILLER1
XFILLER_72_44 VSS VDD FILLER2
XFILLER_31_107 VSS VDD FILLER2
X_13571_ _18916_/Q _13580_/B _13580_/C VDD VSS _13662_/C XNOR3X1
X_10783_ _11272_/A _10783_/B VDD VSS _18564_/D NOR2X1
XTAP_TAPCELL_ROW_54_496 VDD VSS WELLTAP
X_15310_ _19513_/Q _15908_/B VDD VSS _15359_/A NOR2BX1
XFILLER_40_641 VDD VSS DECAPHV16
XFILLER_24_192 VSS VDD FILLER2
X_12522_ _19017_/Q _12894_/A _14283_/B VDD VSS _14249_/B XOR3X1
X_16290_ _19626_/Q _16780_/B VDD VSS _16292_/C XNOR2X1
XFILLER_157_348 VSS VDD FILLER2
X_15241_ _19485_/Q _15307_/A _15307_/B VDD VSS _15243_/C XNOR3X1
XFILLER_40_696 VDD VSS FILLER1
X_12453_ _14376_/B _14376_/C _19099_/Q VDD VSS _12457_/B AOI21X1
X_11404_ _11429_/B VDD VSS _11428_/B BUFX3
X_15172_ _15172_/A VDD VSS _15173_/B INVX1
X_12384_ _12467_/A _14438_/B VDD VSS _12553_/A NOR2X1
XFILLER_165_370 VSS VDD FILLER2
XFILLER_153_532 VDD VSS FILLER4
X_14123_ _14142_/A _14123_/B VDD VSS _18882_/D NOR2X1
X_11335_ _11383_/A _11335_/B VDD VSS _18587_/D NOR2X1
XFILLER_125_245 VSS VDD FILLER2
X_19980_ _19986_/CK _19980_/D _19980_/Q VDD VSS DFFQX1
XFILLER_141_705 VSS VDD FILLER2
XFILLER_153_565 VSS VDD FILLER2
XFILLER_153_576 VDD VSS DECAPHV16
XFILLER_4_564 VSS VDD FILLER2
XFILLER_140_204 VSS VDD FILLER2
X_18931_ _18934_/CK _18931_/D _18931_/Q VDD VSS DFFQX1
XFILLER_98_118 VDD VSS FILLER1
X_14054_ _14054_/A _14054_/B _14054_/C VDD VSS _14058_/B XNOR3X1
X_11266_ _11267_/A _11379_/B VDD VSS _11298_/C OR2X2
XFILLER_4_586 VSS VDD FILLER2
XFILLER_140_248 VSS VDD FILLER2
X_13005_ _13005_/A _13005_/B _13005_/C _13005_/D VDD VSS _13270_/A AO31X2
X_10217_ _10217_/A _10217_/B _10217_/C _10217_/D VDD VSS _10218_/C AOAI211X1
XFILLER_97_74 VDD VSS FILLER1
XFILLER_79_343 VDD VSS FILLER1
X_18862_ _18889_/CK _18862_/D _18862_/Q VDD VSS DFFQX1
X_11197_ _19962_/Q _18844_/Q _11197_/C VDD VSS _11225_/C AOI21X1
XFILLER_97_96 VSS VDD FILLER2
X_17813_ _19926_/Q _19894_/Q _17813_/C VDD VSS _17817_/B AOI21X1
X_10148_ _18612_/Q _10152_/B VDD VSS _10150_/C XOR2X1
XFILLER_0_781 VDD VSS FILLER4
X_18793_ _18823_/CK _18793_/D _18793_/Q VDD VSS DFFQX1
XFILLER_121_495 VSS VDD FILLER2
X_17744_ _19912_/Q _19880_/Q VDD VSS _17747_/A XNOR2X1
X_14956_ _14956_/A _14956_/B _14956_/C _14956_/D VDD VSS _15045_/A AOAI211X1
X_10079_ _18583_/Q _18584_/Q VDD VSS _10089_/B _10079_/C NAND3X1
X_13907_ _13907_/A _13910_/B _13907_/C VDD VSS _14333_/B OAI21X1
X_17675_ _17675_/A _17675_/B VDD VSS _19896_/D NOR2X1
X_14887_ _14887_/A _14911_/D VDD VSS _15771_/B XOR2X1
X_19414_ _19478_/CK _19414_/D _19414_/Q VDD VSS DFFQX1
X_16626_ _16626_/A _19926_/Q _16626_/C VDD VSS _16652_/C MIN3X1
X_13838_ _14297_/B _14297_/C _13839_/A VDD VSS _13840_/C OAI21X1
XFILLER_35_468 VSS VDD FILLER2
XFILLER_50_416 VSS VDD FILLER2
XFILLER_22_107 VSS VDD FILLER2
XFILLER_90_585 VSS VDD FILLER2
XFILLER_16_671 VSS VDD FILLER2
X_19345_ _19573_/CK _19345_/D _19345_/Q VDD VSS DFFQX1
XTAP_TAPCELL_ROW_17_165 VDD VSS WELLTAP
X_16557_ _19668_/Q _16826_/B VDD VSS _16569_/B XOR2X1
X_13769_ _13830_/A _13830_/B _13830_/D _13830_/C VDD VSS _14229_/C AOI211X1
XFILLER_149_816 VSS VDD FILLER2
X_15508_ _19435_/Q VDD VSS _15509_/A INVX1
XFILLER_148_315 VDD VSS FILLER4
X_19276_ _20013_/CK _19276_/D _19276_/Q VDD VSS DFFQX1
XFILLER_31_663 VSS VDD FILLER2
XFILLER_149_849 VSS VDD FILLER2
X_16488_ _16490_/B _16488_/B VDD VSS _16489_/B XOR2X1
XTAP_TAPCELL_ROW_157_1426 VDD VSS WELLTAP
X_18227_ _18228_/CK _18227_/E _18227_/ECK VDD VSS CGX3
X_15439_ _19543_/Q _15439_/B VDD VSS _15440_/C XNOR2X1
XFILLER_30_195 VSS VDD FILLER2
X_18158_ _18173_/A _18158_/B VDD VSS _20005_/D NOR2X1
XFILLER_156_370 VSS VDD FILLER2
X_17109_ _19776_/Q _19744_/Q VDD VSS _17112_/B XNOR2X1
X_18089_ _19284_/Q _18089_/B VDD VSS _18090_/D NAND2X1
X_20120_ _20120_/A VDD VSS _20120_/Y BUFX3
XFILLER_144_598 VDD VSS FILLER4
X_09931_ _11039_/C _10048_/B _09931_/C VDD VSS _09932_/B AOI21X1
XFILLER_132_749 VSS VDD FILLER2
XFILLER_125_790 VDD VSS FILLER1
X_20051_ clkload3/A _20051_/D _20051_/Q input3/Y VDD VSS DFFRQX1
XTAP_TAPCELL_ROW_88_809 VDD VSS WELLTAP
XFILLER_112_440 VDD VSS FILLER1
Xclkbuf_1_1__f__09185_ clkbuf_0__09185_/Y VDD VSS _18487_/CK BUFX12
X_09862_ _10190_/B _09862_/B _09862_/C VDD VSS _09876_/B AOI21X1
XFILLER_98_674 VSS VDD FILLER2
XFILLER_100_602 VSS VDD FILLER2
XFILLER_140_771 VDD VSS FILLER1
XFILLER_86_825 VSS VDD FILLER2
XFILLER_97_162 VDD VSS FILLER4
XFILLER_133_17 VSS VDD FILLER2
XFILLER_98_696 VDD VSS FILLER1
XFILLER_85_313 VDD VSS FILLER4
XFILLER_140_793 VDD VSS FILLER4
XFILLER_97_184 VSS VDD FILLER2
X_09793_ _18406_/Q VDD VSS _20147_/A INVX1
XFILLER_97_195 VSS VDD FILLER2
XFILLER_100_646 VSS VDD FILLER2
XTAP_TAPCELL_ROW_96_875 VDD VSS WELLTAP
XFILLER_73_519 VSS VDD FILLER2
XFILLER_54_700 VDD VSS FILLER4
XFILLER_54_744 VDD VSS FILLER1
XFILLER_26_26 VSS VDD FILLER2
XTAP_TAPCELL_ROW_123_1116 VDD VSS WELLTAP
XTAP_TAPCELL_ROW_108_987 VDD VSS WELLTAP
XFILLER_81_552 VDD VSS FILLER4
XFILLER_13_107 VSS VDD FILLER2
XFILLER_81_585 VDD VSS FILLER4
XFILLER_158_8 VSS VDD FILLER2
XFILLER_139_304 VSS VDD FILLER2
XFILLER_42_25 VDD VSS DECAPHV8
XFILLER_139_326 VSS VDD FILLER2
XFILLER_21_140 VSS VDD FILLER2
XFILLER_21_162 VSS VDD FILLER2
XFILLER_166_123 VDD VSS FILLER1
XFILLER_158_25 VSS VDD FILLER2
XFILLER_158_36 VDD VSS FILLER1
X_09227_ _18495_/D VDD VSS _18367_/D INVX1
XFILLER_21_184 VSS VDD FILLER2
XFILLER_166_145 VDD VSS DECAPHV8
XFILLER_166_178 VSS VDD FILLER2
XFILLER_107_201 VDD VSS FILLER1
XTAP_TAPCELL_ROW_134_1223 VDD VSS WELLTAP
XFILLER_108_757 VSS VDD FILLER2
XFILLER_108_779 VSS VDD FILLER2
XFILLER_107_278 VDD VSS FILLER1
X_11120_ _11120_/A VDD VSS _11289_/A BUFX3
XFILLER_135_598 VSS VDD FILLER2
XFILLER_162_373 VSS VDD FILLER2
XFILLER_122_215 VDD VSS FILLER1
XFILLER_150_557 VDD VSS DECAPHV8
X_11051_ _10776_/Y _11050_/Y _11120_/A VDD VSS _11090_/B MUXI2X1
XFILLER_89_663 VSS VDD FILLER2
XFILLER_1_556 VSS VDD FILLER2
XFILLER_107_73 VSS VDD FILLER2
X_10002_ _09949_/Y _10001_/Y _10032_/A VDD VSS _10058_/B MUXI2X1
XFILLER_67_33 VSS VDD FILLER2
XFILLER_88_173 VDD VSS FILLER4
XFILLER_49_527 VDD VSS DECAPHV8
XFILLER_76_346 VSS VDD FILLER2
X_14810_ _19363_/Q _15738_/B _14810_/C VDD VSS _14857_/B MIN3X1
XTAP_TAPCELL_ROW_59_544 VDD VSS WELLTAP
X_15790_ _15793_/A _15790_/B VDD VSS _19409_/D AND2X1
XFILLER_17_413 VSS VDD FILLER2
X_14741_ _19526_/Q _19527_/Q _19528_/Q _14742_/C VDD VSS _14877_/C AND4X2
X_11953_ _11959_/A _11959_/B _11953_/C VDD VSS _14304_/B XNOR3X1
XFILLER_45_755 VSS VDD FILLER2
XFILLER_83_54 VSS VDD FILLER2
X_17460_ _17460_/A _17460_/B _17460_/C VDD VSS _17468_/A OA21X2
X_10904_ _18701_/Q _18755_/Q VDD VSS _10940_/D NOR2X1
XFILLER_45_777 VSS VDD FILLER2
XFILLER_17_468 VDD VSS FILLER4
X_14672_ _14672_/A _14672_/B _15827_/B VDD VSS _14673_/B MIN3X1
X_11884_ _11884_/A _11884_/B _11884_/C _11884_/D VDD VSS _12048_/A AOAI211X1
XFILLER_83_87 VDD VSS FILLER4
XFILLER_60_725 VDD VSS DECAPHV8
XFILLER_32_416 VSS VDD FILLER2
X_16411_ _16411_/A _16414_/B VDD VSS _16412_/B XOR2X1
X_13623_ _13623_/A _13623_/B _13623_/C _13623_/D VDD VSS _14360_/C OAI211X1
XFILLER_60_747 VSS VDD FILLER2
X_17391_ _17391_/A VDD VSS _17675_/A BUFX3
X_10835_ _10866_/A _10866_/B _10836_/C _11014_/A VDD VSS _10836_/D AOAI211X1
X_19130_ _19157_/CK _19130_/D _19130_/Q VDD VSS DFFQX1
XTAP_TAPCELL_ROW_14_135 VDD VSS WELLTAP
X_16342_ _19596_/Q _16746_/B VDD VSS _16343_/B XOR2X1
X_13554_ _13557_/A _13557_/C _13557_/B _13554_/D VDD VSS _14483_/B OAOI211X1
X_10766_ _18697_/Q _18751_/Q VDD VSS _10794_/C OR2X2
XFILLER_157_112 VSS VDD FILLER2
XFILLER_8_111 VSS VDD FILLER2
XFILLER_12_173 VDD VSS FILLER4
X_19061_ _19115_/CK _19061_/D _19061_/Q VDD VSS DFFQX1
X_12505_ _12643_/A _12643_/B VDD VSS _14408_/B XNOR2X1
X_16273_ _16273_/A VDD VSS _17469_/B BUFX3
XFILLER_8_133 VDD VSS FILLER4
X_13485_ _13578_/A _13578_/B VDD VSS _14127_/B XNOR2X1
X_10697_ _11116_/A _10697_/B VDD VSS _10698_/C NAND2X1
X_18012_ _18049_/D VDD VSS _18056_/C BUFX3
X_15224_ _19429_/Q VDD VSS _15265_/A INVX1
X_12436_ _12438_/A _12438_/B _14180_/B VDD VSS _12527_/B XNOR3X1
XTAP_TAPCELL_ROW_3_40 VDD VSS WELLTAP
XFILLER_157_189 VDD VSS FILLER4
XFILLER_5_840 VSS VDD FILLER2
X_15155_ _15155_/A _15155_/B _15155_/C _15155_/D VDD VSS _15183_/D AOAI211X1
X_12367_ _19072_/Q VDD VSS _12460_/A INVX1
XFILLER_99_405 VDD VSS FILLER1
X_14106_ _17977_/A _17977_/B _17978_/B VDD VSS _17983_/B OA21X2
XTAP_TAPCELL_ROW_152_1378 VDD VSS WELLTAP
XFILLER_113_215 VSS VDD FILLER2
X_11318_ _11356_/C _11318_/B VDD VSS _11325_/B NOR2X1
X_15086_ _19453_/Q _15838_/B VDD VSS _15088_/B XNOR2X1
X_19963_ _19963_/CK _19963_/D _19963_/Q VDD VSS DFFQX1
X_12298_ wire159/Y _12298_/B _12298_/C _12298_/D VDD VSS _14375_/C OA211X2
XFILLER_99_449 VDD VSS FILLER4
XFILLER_113_237 VSS VDD FILLER2
XFILLER_141_568 VSS VDD FILLER2
X_18914_ _18939_/CK _18914_/D _18914_/Q VDD VSS DFFQX1
X_14037_ _18951_/Q _14202_/B _14202_/C VDD VSS _14038_/D NOR3BX1
X_11249_ _18578_/Q _11249_/B _11249_/C VDD VSS _11253_/B OAI21X1
X_19894_ clkload2/A _19894_/D _19894_/Q VDD VSS DFFQX1
XFILLER_95_600 VSS VDD FILLER2
XFILLER_67_302 VDD VSS FILLER1
XFILLER_122_793 VSS VDD FILLER2
XFILLER_79_173 VSS VDD FILLER2
X_18845_ _18845_/CK _18845_/D _18845_/Q VDD VSS DFFQX1
XFILLER_79_184 VSS VDD FILLER2
X_18776_ _18831_/CK _18776_/D _18776_/Q VDD VSS DFFQX1
XFILLER_95_677 VSS VDD FILLER2
X_15988_ _15988_/A _16803_/B VDD VSS _15989_/C NAND2X1
XFILLER_36_700 VDD VSS FILLER4
X_17727_ _17730_/A _17730_/B _17746_/C VDD VSS _17728_/C OAI21X1
X_14939_ _14956_/D _14956_/C VDD VSS _14940_/B NOR2BX1
XFILLER_91_850 VSS VDD FILLER2
XFILLER_35_243 VDD VSS DECAPHV8
X_17658_ _19893_/Q _19861_/Q VDD VSS _17661_/B XOR2X1
XTAP_TAPCELL_ROW_105_957 VDD VSS WELLTAP
XFILLER_51_714 VSS VDD FILLER2
XFILLER_36_788 VSS VDD FILLER2
XFILLER_23_416 VDD VSS FILLER4
XFILLER_90_371 VDD VSS FILLER4
X_16609_ _16622_/A _16622_/B VDD VSS _16829_/B XNOR2X1
XFILLER_63_596 VSS VDD FILLER2
XFILLER_51_747 VSS VDD FILLER2
X_17589_ _17589_/A _17589_/B _17589_/C _17589_/D VDD VSS _17590_/C AOAI211X1
XFILLER_50_235 VSS VDD FILLER2
XFILLER_51_769 VSS VDD FILLER2
XFILLER_92_0 VDD VSS FILLER1
XFILLER_50_246 VDD VSS FILLER1
X_19328_ _19385_/CK _19328_/D _19328_/Q VDD VSS DFFQX1
X_19259_ _19995_/CK _19259_/D _19259_/Q VDD VSS DFFQX1
XFILLER_149_679 VDD VSS FILLER4
XFILLER_148_178 VSS VDD FILLER2
XFILLER_148_189 VSS VDD FILLER2
XFILLER_145_830 VDD VSS FILLER4
XFILLER_128_39 VDD VSS FILLER4
XFILLER_117_554 VDD VSS FILLER4
XFILLER_132_502 VDD VSS FILLER1
XFILLER_160_811 VSS VDD FILLER2
XFILLER_160_855 VSS VDD FILLER2
X_20103_ _20103_/A VDD VSS _20103_/Y BUFX3
XFILLER_104_259 VSS VDD FILLER2
XFILLER_120_708 VSS VDD FILLER2
X_09914_ _09938_/A _10004_/B VDD VSS _09915_/D NAND2X1
XFILLER_144_49 VSS VDD FILLER2
XFILLER_86_611 VSS VDD FILLER2
X_20034_ _20045_/CK _20034_/D _20034_/Q _20045_/RB VDD VSS DFFRQX1
XFILLER_58_313 VDD VSS FILLER4
XFILLER_112_270 VDD VSS FILLER4
X_09845_ _09880_/A _09880_/B VDD VSS _09849_/C NOR2X1
XFILLER_100_421 VDD VSS FILLER4
XFILLER_140_590 VDD VSS FILLER4
Xclkbuf_1_1__f__09168_ clkbuf_0__09168_/Y VDD VSS _18389_/CK BUFX12
XFILLER_58_357 VDD VSS DECAPHV8
XFILLER_85_154 VSS VDD FILLER2
XFILLER_100_465 VSS VDD FILLER2
X_09776_ _09816_/D _09776_/B _09776_/C _09776_/D VDD VSS _18292_/D OAI211X1
XFILLER_85_165 VSS VDD FILLER2
XFILLER_100_476 VDD VSS FILLER1
XFILLER_100_487 VDD VSS DECAPHV8
XTAP_TAPCELL_ROW_56_514 VDD VSS WELLTAP
XFILLER_39_571 VSS VDD FILLER2
XFILLER_37_58 VDD VSS DECAPHV8
XFILLER_160_59 VDD VSS FILLER4
XFILLER_82_850 VSS VDD FILLER2
XFILLER_54_541 VDD VSS FILLER1
XFILLER_26_243 VSS VDD FILLER2
XFILLER_54_563 VDD VSS DECAPHV16
XFILLER_14_416 VSS VDD FILLER2
XFILLER_42_747 VSS VDD FILLER2
XTAP_TAPCELL_ROW_64_591 VDD VSS WELLTAP
XTAP_TAPCELL_ROW_140_1271 VDD VSS WELLTAP
X_10620_ _11116_/A _10656_/B VDD VSS _10621_/C NAND2X1
XFILLER_139_123 VDD VSS FILLER4
XFILLER_22_471 VSS VDD FILLER2
X_10551_ _10579_/D VDD VSS _10945_/A BUFX3
XTAP_TAPCELL_ROW_11_116 VDD VSS WELLTAP
XFILLER_22_493 VDD VSS FILLER4
XFILLER_139_189 VDD VSS DECAPHV8
XFILLER_108_510 VDD VSS FILLER1
X_13270_ _13270_/A _13270_/B _13270_/C _13270_/D VDD VSS _14290_/B AOAI211X1
X_10482_ _10965_/A _18717_/Q VDD VSS _10483_/D AND2X1
XFILLER_155_649 VSS VDD FILLER2
XFILLER_10_688 VDD VSS FILLER1
XFILLER_6_637 VSS VDD FILLER2
XFILLER_108_532 VSS VDD FILLER2
XFILLER_6_648 VSS VDD FILLER2
XFILLER_154_137 VSS VDD FILLER2
X_12221_ _19182_/Q VDD VSS _12312_/A INVX1
XFILLER_135_362 VSS VDD FILLER2
XFILLER_151_822 VSS VDD FILLER2
X_12152_ _14466_/B _14466_/C _19180_/Q VDD VSS _12171_/A AOI21X1
XFILLER_2_810 VSS VDD FILLER2
XFILLER_150_310 VSS VDD FILLER2
XFILLER_163_693 VDD VSS FILLER4
XFILLER_151_844 VDD VSS FILLER1
X_11103_ _18707_/Q _18761_/Q VDD VSS _11104_/B XOR2X1
XFILLER_150_354 VSS VDD FILLER2
X_16960_ _16958_/Y _16960_/B _17986_/C VDD VSS _19747_/D AND3BX1
X_12083_ _12083_/A _12083_/B _14371_/B VDD VSS _12084_/B MIN3X1
XFILLER_123_579 VDD VSS FILLER4
XFILLER_104_771 VSS VDD FILLER2
XFILLER_89_460 VDD VSS FILLER4
X_15911_ _16100_/A _15911_/B VDD VSS _19516_/D NOR2X1
X_11034_ _18678_/Q _18786_/Q VDD VSS _11041_/B XOR2X1
XFILLER_77_622 VDD VSS FILLER1
XFILLER_1_375 VSS VDD FILLER2
XFILLER_104_793 VDD VSS FILLER4
XFILLER_150_398 VDD VSS FILLER4
XFILLER_1_386 VSS VDD FILLER2
X_16891_ _16891_/A _16891_/B VDD VSS _19727_/D NOR2X1
XFILLER_1_397 VSS VDD FILLER2
XFILLER_76_121 VSS VDD FILLER2
X_18630_ _19939_/CK _18630_/D _18630_/Q VDD VSS DFFQX1
XFILLER_65_806 VDD VSS FILLER4
X_15842_ _15849_/A _15842_/B VDD VSS _19456_/D AND2X1
XFILLER_92_603 VDD VSS FILLER1
XFILLER_49_379 VSS VDD FILLER2
XFILLER_18_700 VSS VDD FILLER2
XFILLER_91_113 VDD VSS DECAPHV16
X_18561_ _18578_/CK _18561_/D _18561_/Q VDD VSS DFFQX1
X_15773_ _15793_/A _15773_/B VDD VSS _19394_/D AND2X1
X_12985_ _18910_/Q _13076_/B _14154_/B VDD VSS _13182_/C XNOR3X1
XFILLER_45_530 VSS VDD FILLER2
XFILLER_91_146 VDD VSS FILLER4
X_17512_ _19861_/Q _19829_/Q _17512_/C VDD VSS _17517_/B MIN3X1
X_14724_ _14727_/B _14724_/B VDD VSS _15673_/B XNOR2X1
XFILLER_18_777 VDD VSS FILLER4
X_18492_ _18495_/CK _18513_/Q _20105_/A _20075_/RB VDD VSS DFFRQX1
X_11936_ _19205_/Q _11936_/B _12048_/D VDD VSS _11987_/C XNOR3X1
XFILLER_27_80 VDD VSS FILLER4
XFILLER_18_788 VSS VDD FILLER2
XFILLER_17_254 VSS VDD FILLER2
XTAP_TAPCELL_ROW_90_826 VDD VSS WELLTAP
XFILLER_18_799 VDD VSS FILLER1
XFILLER_150_81 VSS VDD FILLER2
X_17443_ _17446_/C _17444_/B _17452_/C VDD VSS _17444_/C OAI21X1
XTAP_TAPCELL_ROW_27_260 VDD VSS WELLTAP
XFILLER_33_747 VDD VSS FILLER4
X_14655_ _19497_/Q _14655_/B VDD VSS _14676_/C NAND2X1
X_11867_ _19091_/Q _11867_/B _11867_/C VDD VSS _11962_/B MIN3X1
XTAP_TAPCELL_ROW_102_927 VDD VSS WELLTAP
XFILLER_32_235 VSS VDD FILLER2
X_13606_ _13607_/A _13607_/B _13607_/D _13607_/C VDD VSS _13840_/B OAOI211X1
X_17374_ _17377_/A _17377_/B VDD VSS _17375_/B XNOR2X1
X_10818_ _19951_/Q _18833_/Q VDD VSS _10856_/A NAND2X1
XFILLER_158_410 VDD VSS DECAPHV8
X_14586_ _19522_/Q _19495_/Q _15887_/B VDD VSS _14615_/B XOR3X1
XFILLER_60_588 VSS VDD FILLER2
XFILLER_158_421 VSS VDD FILLER2
X_11798_ _11830_/A _11830_/B VDD VSS _11808_/B NOR2X1
X_19113_ _19166_/CK _19113_/D _19113_/Q VDD VSS DFFQX1
XFILLER_41_780 VSS VDD FILLER2
XFILLER_119_808 VSS VDD FILLER2
X_16325_ _16326_/A _16326_/B _16326_/C VDD VSS _16352_/B AOI21X1
X_13537_ _13548_/A _14388_/B _13614_/C VDD VSS _14389_/B OAI21X1
X_10749_ _10749_/A _10749_/B VDD VSS _10790_/A NAND2X1
XFILLER_158_465 VDD VSS FILLER4
XFILLER_118_307 VDD VSS FILLER4
XFILLER_40_290 VSS VDD FILLER2
XFILLER_158_476 VSS VDD FILLER2
XFILLER_9_464 VDD VSS FILLER1
X_19044_ _19044_/CK _19044_/D _19044_/Q VDD VSS DFFQX1
XFILLER_9_475 VSS VDD FILLER2
X_16256_ _19592_/Q _16256_/B _16742_/B VDD VSS _16283_/B MIN3X1
X_13468_ _13559_/C _13557_/B _13468_/C VDD VSS _13549_/B XNOR3X1
XFILLER_64_4 VDD VSS FILLER1
X_15207_ _19400_/Q _15779_/A VDD VSS _15223_/B XNOR2X1
X_12419_ _12460_/A _12419_/B _12544_/D VDD VSS _12517_/C XNOR3X1
X_16187_ _19590_/Q _16740_/B VDD VSS _16188_/B XOR2X1
XFILLER_114_502 VSS VDD FILLER2
X_13399_ _13400_/B _13400_/C _18969_/Q VDD VSS _13402_/B AOI21X1
XFILLER_160_107 VDD VSS FILLER4
XFILLER_160_118 VDD VSS FILLER1
XFILLER_99_213 VSS VDD FILLER2
XFILLER_5_670 VSS VDD FILLER2
XFILLER_126_384 VSS VDD FILLER2
X_15138_ _15138_/A _15138_/B _15810_/B VDD VSS _15180_/B MIN3X1
XFILLER_154_693 VDD VSS FILLER4
XFILLER_5_692 VSS VDD FILLER2
XFILLER_99_246 VSS VDD FILLER2
XFILLER_114_557 VSS VDD FILLER2
XFILLER_114_568 VSS VDD FILLER2
XFILLER_87_408 VDD VSS DECAPHV8
X_15069_ _15069_/A _15069_/B VDD VSS _15776_/C _15069_/C AND3X2
X_19946_ _19946_/CK _19946_/D _19946_/Q VDD VSS DFFQX1
XFILLER_101_218 VDD VSS FILLER4
XFILLER_4_84 VSS VDD FILLER2
X_19877_ clkload9/A _19877_/D _19877_/Q VDD VSS DFFQX1
XFILLER_68_666 VSS VDD FILLER2
X_09630_ _18506_/Q _18505_/Q _09630_/C VDD VSS _09814_/C NOR3BX1
X_18828_ _19946_/CK _18828_/D _18828_/Q VDD VSS DFFQX1
XFILLER_95_463 VSS VDD FILLER2
XFILLER_95_496 VSS VDD FILLER2
X_09561_ _09815_/C VDD VSS _09770_/C BUFX3
X_18759_ _18788_/CK _18759_/D _18759_/Q VDD VSS DFFQX1
XFILLER_55_349 VSS VDD FILLER2
XFILLER_82_168 VSS VDD FILLER2
X_09492_ _19984_/Q _09496_/B _09507_/B VDD VSS _09493_/C AOI21X1
XFILLER_24_747 VSS VDD FILLER2
XTAP_TAPCELL_ROW_61_561 VDD VSS WELLTAP
XFILLER_149_432 VSS VDD FILLER2
XFILLER_137_627 VSS VDD FILLER2
XFILLER_139_49 VDD VSS FILLER4
XFILLER_137_649 VSS VDD FILLER2
XFILLER_136_137 VSS VDD FILLER2
XFILLER_164_446 VDD VSS FILLER1
XFILLER_118_852 VDD VSS FILLER4
XFILLER_132_310 VSS VDD FILLER2
XFILLER_144_181 VSS VDD FILLER2
XFILLER_3_8 VSS VDD FILLER2
XFILLER_105_568 VSS VDD FILLER2
XFILLER_120_505 VDD VSS FILLER4
XFILLER_160_674 VDD VSS FILLER4
XFILLER_160_685 VSS VDD FILLER2
XFILLER_132_398 VSS VDD FILLER2
XFILLER_101_741 VSS VDD FILLER2
XFILLER_98_290 VDD VSS FILLER4
XFILLER_58_132 VSS VDD FILLER2
X_20017_ _20019_/CK _20017_/D _20017_/Q _20030_/RB VDD VSS DFFRQX1
X_09828_ _09828_/A VDD VSS _09944_/A BUFX3
XFILLER_86_463 VDD VSS DECAPHV8
XFILLER_48_79 VSS VDD FILLER2
XFILLER_59_688 VSS VDD FILLER2
XFILLER_19_519 VDD VSS FILLER4
XFILLER_46_316 VSS VDD FILLER2
XTAP_TAPCELL_ROW_129_1177 VDD VSS WELLTAP
XFILLER_58_198 VSS VDD FILLER2
X_09759_ _09759_/A _09759_/B _09773_/D VDD VSS _09760_/E AOI21X1
XFILLER_104_74 VDD VSS FILLER4
XFILLER_74_669 VSS VDD FILLER2
XFILLER_62_809 VSS VDD FILLER2
XFILLER_73_146 VSS VDD FILLER2
XFILLER_55_850 VSS VDD FILLER2
XFILLER_104_85 VSS VDD FILLER2
XFILLER_73_157 VDD VSS FILLER1
XFILLER_64_34 VDD VSS FILLER4
X_12770_ _12771_/D _14474_/B VDD VSS _12940_/A NAND2X1
XFILLER_15_714 VSS VDD FILLER2
XFILLER_27_574 VSS VDD FILLER2
XFILLER_15_725 VSS VDD FILLER2
XFILLER_27_596 VSS VDD FILLER2
X_11721_ _11745_/A _11745_/B _11745_/C VDD VSS _14486_/A OAI21X1
XFILLER_15_747 VSS VDD FILLER2
XFILLER_14_235 VDD VSS FILLER4
XFILLER_15_769 VDD VSS FILLER1
XTAP_TAPCELL_ROW_24_230 VDD VSS WELLTAP
X_14440_ _14440_/A _14440_/B _14440_/C VDD VSS _14441_/C NOR3X1
X_11652_ _18792_/Q _11658_/B VDD VSS _18819_/D AND2X1
XFILLER_80_44 VSS VDD FILLER2
X_10603_ _19946_/Q _18828_/Q VDD VSS _10633_/D NOR2X1
X_14371_ _14393_/A _14371_/B VDD VSS _19094_/D NOR2X1
X_11583_ _18729_/Q _11589_/B VDD VSS _18756_/D AND2X1
X_16110_ _19587_/Q VDD VSS _16134_/A INVX1
X_13322_ _19109_/Q _13616_/A _13322_/C VDD VSS _13365_/C XNOR3X1
X_17090_ _17095_/A _17090_/B VDD VSS _19772_/D NOR2X1
X_10534_ _10579_/A _10579_/B _10579_/C _10581_/A VDD VSS _10622_/C AOI31X1
XFILLER_6_423 VDD VSS FILLER1
XFILLER_129_71 VDD VSS FILLER4
X_16041_ _16060_/B _16041_/B VDD VSS _16768_/B XNOR2X1
XFILLER_89_20 VSS VDD FILLER2
XFILLER_155_468 VDD VSS FILLER4
XFILLER_108_340 VSS VDD FILLER2
X_13253_ _13253_/A _14513_/B _14513_/C VDD VSS _13254_/D NOR3X1
X_10465_ _10511_/A _10465_/B VDD VSS _10466_/D NOR2X1
XFILLER_155_479 VDD VSS FILLER4
XFILLER_6_467 VSS VDD FILLER2
XFILLER_142_107 VSS VDD FILLER2
X_12204_ _19069_/Q VDD VSS _12283_/A INVX1
XFILLER_135_181 VDD VSS FILLER4
X_13184_ _18884_/Q _13184_/B _13184_/C VDD VSS _13495_/B MIN3X1
X_10396_ _18634_/Q _18796_/Q VDD VSS _10476_/A XNOR2X1
X_19800_ clkload5/A _19800_/D _19800_/Q VDD VSS DFFQX1
XFILLER_151_663 VSS VDD FILLER2
X_12135_ _19067_/Q VDD VSS _12284_/A INVX1
XFILLER_111_505 VDD VSS FILLER1
XFILLER_150_151 VDD VSS FILLER4
X_17992_ _18531_/Q _18020_/B VDD VSS _18024_/B AND2X1
XFILLER_69_419 VSS VDD FILLER2
XFILLER_150_173 VDD VSS DECAPHV8
X_16943_ _19743_/Q wire164/Y _16943_/C VDD VSS _16948_/C MIN3X1
X_19731_ _19734_/CK _19731_/D _19731_/Q VDD VSS DFFQX1
XFILLER_2_695 VSS VDD FILLER2
X_12066_ _14239_/A _14240_/A _14274_/B VDD VSS _12072_/C XNOR3X1
XFILLER_96_249 VSS VDD FILLER2
XFILLER_29_7 VSS VDD FILLER2
X_11017_ _10878_/Y _11016_/Y _11118_/A VDD VSS _11019_/B MUXI2X1
X_16874_ _16876_/A _16874_/B VDD VSS _19711_/D NOR2X1
X_19662_ _19695_/CK _19662_/D _19662_/Q VDD VSS DFFQX1
XFILLER_37_327 VDD VSS FILLER1
X_15825_ _15849_/A _15825_/B VDD VSS _19440_/D AND2X1
X_18613_ _18622_/CK _18613_/D _18613_/Q VDD VSS DFFQX1
XFILLER_49_198 VSS VDD FILLER2
X_19593_ _19661_/CK _19593_/D _19593_/Q VDD VSS DFFQX1
XFILLER_64_135 VDD VSS FILLER4
XFILLER_18_541 VDD VSS DECAPHV16
XFILLER_161_91 VSS VDD FILLER2
XFILLER_80_617 VSS VDD FILLER2
X_15756_ _15770_/A _15756_/B VDD VSS _19379_/D AND2X1
X_18544_ _18550_/CK _18544_/D _18544_/Q VDD VSS DFFQX1
XTAP_TAPCELL_ROW_9_94 VDD VSS WELLTAP
X_12968_ _12968_/A _12968_/B _14539_/B _12968_/D _12968_/E VDD VSS _13133_/B OAI221X1
XTAP_TAPCELL_ROW_75_686 VDD VSS WELLTAP
XFILLER_61_820 VDD VSS DECAPHV8
XFILLER_18_585 VSS VDD FILLER2
XTAP_TAPCELL_ROW_160_1455 VDD VSS WELLTAP
X_14707_ _14710_/A _14739_/B _14739_/C VDD VSS _14708_/C AND3BX1
XFILLER_73_691 VDD VSS FILLER4
X_18475_ _18479_/CK _18512_/Q _20120_/A _18491_/RB VDD VSS DFFRQX1
X_11919_ _19176_/Q VDD VSS _12034_/A INVX1
XFILLER_61_842 VDD VSS FILLER1
XFILLER_45_393 VDD VSS DECAPHV8
X_15687_ _15693_/A _15687_/B VDD VSS _19316_/D NOR2X1
XFILLER_60_330 VDD VSS FILLER1
X_12899_ _12899_/A _14286_/B _14286_/C VDD VSS _12900_/D NOR3X1
X_17426_ _19844_/Q _19812_/Q VDD VSS _17431_/A XNOR2X1
X_14638_ _19469_/Q _14638_/B _14638_/C VDD VSS _15826_/B XNOR3X1
XFILLER_60_374 VSS VDD FILLER2
XFILLER_159_730 VSS VDD FILLER2
X_17357_ _17507_/B _17357_/B _17357_/C VDD VSS _17362_/C MIN3X1
X_14569_ _20008_/Q _14569_/B VDD VSS _19272_/D AND2X1
X_16308_ _19658_/Q _16816_/B _16308_/C VDD VSS _16348_/A OAI21X1
XFILLER_9_261 VSS VDD FILLER2
XFILLER_158_284 VSS VDD FILLER2
XFILLER_118_126 VDD VSS FILLER4
X_17288_ _17289_/A _17289_/B _17289_/D _17289_/C VDD VSS _17291_/C AOI211X1
XFILLER_118_137 VSS VDD FILLER2
Xclkload20 _19954_/CK VDD VSS clkload20/Y INVX1
X_19027_ _19119_/CK _19027_/D _19027_/Q VDD VSS DFFQX1
XFILLER_146_468 VDD VSS FILLER4
X_16239_ _16256_/B _16239_/B VDD VSS _16778_/B XNOR2X1
Xclkload31 _19949_/CK VDD VSS clkload31/Y INVX1
Xclkload42 _19269_/CK VDD VSS clkload42/Y INVX1
Xclkload53 _19139_/CK VDD VSS clkload53/Y BUFX12
Xclkload64 _18889_/CK VDD VSS clkload64/Y INVX2
XFILLER_115_822 VSS VDD FILLER2
Xclkbuf_leaf_19__001_ clkload33/A VDD VSS _18939_/CK BUFX12
Xclkload75 _19734_/CK VDD VSS clkload75/Y INVX1
XTAP_TAPCELL_ROW_117_1070 VDD VSS WELLTAP
Xclkload86 _19331_/CK VDD VSS clkload86/Y BUFX12
XFILLER_161_449 VDD VSS FILLER4
Xclkload97 _19661_/CK VDD VSS clkload97/Y INVX2
XFILLER_114_343 VDD VSS DECAPHV8
XFILLER_130_803 VDD VSS FILLER1
XFILLER_114_365 VSS VDD FILLER2
XFILLER_125_18 VSS VDD FILLER2
XFILLER_141_151 VDD VSS FILLER4
XFILLER_114_376 VDD VSS FILLER1
XFILLER_141_162 VSS VDD FILLER2
XFILLER_141_184 VSS VDD FILLER2
X_19929_ clkload2/A _19929_/D _19929_/Q VDD VSS DFFQX1
XFILLER_68_430 VSS VDD FILLER2
XFILLER_96_750 VDD VSS FILLER4
XFILLER_68_452 VDD VSS FILLER4
XFILLER_56_614 VDD VSS FILLER4
XFILLER_56_636 VSS VDD FILLER2
XFILLER_110_593 VDD VSS FILLER1
XFILLER_141_17 VSS VDD FILLER2
X_09613_ _20103_/A _20119_/A _09729_/D VDD VSS _09617_/C MUX2X1
XFILLER_95_282 VSS VDD FILLER2
XFILLER_83_422 VDD VSS FILLER4
XFILLER_56_647 VDD VSS FILLER1
XFILLER_18_49 VSS VDD FILLER2
XFILLER_44_809 VDD VSS DECAPHV8
X_09544_ _20038_/Q _09547_/B VDD VSS _20039_/D NOR2BX1
XTAP_TAPCELL_ROW_38_355 VDD VSS WELLTAP
XFILLER_83_477 VSS VDD FILLER2
XFILLER_83_488 VDD VSS FILLER1
XFILLER_24_500 VSS VDD FILLER2
XFILLER_71_639 VDD VSS FILLER1
XFILLER_70_127 VDD VSS FILLER4
X_09475_ _18451_/D _09483_/B _09475_/C VDD VSS _18246_/D AOI21X1
XFILLER_51_341 VSS VDD FILLER2
XTAP_TAPCELL_ROW_21_200 VDD VSS WELLTAP
XFILLER_149_262 VSS VDD FILLER2
Xclkload3 clkload3/A VDD VSS clkload3/Y INVX4
XFILLER_109_104 VDD VSS FILLER4
XFILLER_126_6 VDD VSS FILLER1
XFILLER_164_221 VDD VSS FILLER4
XFILLER_166_25 VSS VDD FILLER2
XFILLER_125_608 VDD VSS DECAPHV8
XFILLER_137_468 VSS VDD FILLER2
XFILLER_124_107 VSS VDD FILLER2
XFILLER_152_416 VSS VDD FILLER2
XFILLER_164_276 VSS VDD FILLER2
X_10250_ _11435_/B _11438_/A _11435_/A VDD VSS _10721_/D OR3BX2
XFILLER_59_12 VSS VDD FILLER2
XFILLER_106_855 VSS VDD FILLER2
XFILLER_133_663 VDD VSS FILLER4
X_10181_ _14522_/A VDD VSS _13177_/A BUFX3
XFILLER_105_365 VDD VSS FILLER1
XFILLER_121_825 VSS VDD FILLER2
XFILLER_133_685 VDD VSS FILLER4
XFILLER_160_471 VSS VDD FILLER2
XFILLER_160_482 VDD VSS FILLER1
XFILLER_94_709 VDD VSS FILLER4
XFILLER_120_368 VDD VSS DECAPHV32
X_13940_ _18893_/Q _14135_/B _14135_/C VDD VSS _13941_/D OR3BX1
XFILLER_101_571 VSS VDD FILLER2
XFILLER_75_33 VDD VSS FILLER4
XFILLER_59_485 VDD VSS FILLER4
X_13871_ _18890_/Q _14131_/B VDD VSS _13872_/D _14131_/C NAND3X1
XFILLER_75_66 VSS VDD FILLER2
X_15610_ _19327_/Q _15699_/B VDD VSS _15614_/B XOR2X1
X_12822_ _12932_/A _12822_/B VDD VSS _14411_/B XNOR2X1
XFILLER_46_168 VSS VDD FILLER2
XFILLER_34_308 VDD VSS FILLER4
X_16590_ _16616_/B _16590_/B VDD VSS _19541_/D NOR2X1
XFILLER_55_680 VDD VSS FILLER1
X_15541_ _15541_/A _15541_/B _15541_/C _15541_/D VDD VSS _15568_/A AOAI211X1
XFILLER_91_21 VDD VSS FILLER4
X_12753_ _12827_/A _12827_/B _12827_/C VDD VSS _12768_/B AOI21X1
X_18260_ _18268_/CK _18260_/D _18260_/Q _20078_/RB VDD VSS DFFRQX1
X_11704_ _19988_/Q _19252_/Q VDD VSS _11706_/C NAND2X1
X_15472_ _15472_/A _15472_/B VDD VSS _15515_/A NOR2X1
XFILLER_70_672 VSS VDD FILLER2
X_12684_ _12827_/A _12827_/B VDD VSS _14474_/B XNOR2X1
XFILLER_30_514 VSS VDD FILLER2
X_17211_ _17212_/C _17211_/B _17211_/C VDD VSS _19797_/D AOI21X1
XFILLER_30_536 VDD VSS FILLER1
X_14423_ _14467_/A _14423_/B VDD VSS _19141_/D AND2X1
X_18191_ _19303_/Q _18191_/B _18191_/C VDD VSS _18195_/C MIN3X1
X_11635_ _18777_/Q _11635_/B VDD VSS _18804_/D AND2X1
XFILLER_24_81 VSS VDD FILLER2
XFILLER_156_700 VDD VSS FILLER4
X_17142_ _19782_/Q _19750_/Q _17142_/C VDD VSS _17147_/C AO21X2
X_14354_ _14415_/A _14354_/B VDD VSS _19080_/D AND2X1
X_11566_ _18714_/Q _11567_/B VDD VSS _18741_/D AND2X1
XFILLER_156_744 VSS VDD FILLER2
XFILLER_155_232 VDD VSS FILLER4
XFILLER_6_220 VSS VDD FILLER2
XFILLER_155_243 VSS VDD FILLER2
X_13305_ _19025_/Q _13406_/A _13406_/B VDD VSS _13307_/D XNOR3X1
XFILLER_6_231 VDD VSS FILLER1
X_17073_ _19767_/Q _17073_/B _17073_/C VDD VSS _17075_/B MIN3X1
X_10517_ _10965_/A _18718_/Q VDD VSS _10518_/C NAND2X1
XFILLER_155_254 VSS VDD FILLER2
X_14285_ _14285_/A _14285_/B VDD VSS _19019_/D NOR2X1
X_11497_ _11497_/A _11641_/B VDD VSS _18679_/D NOR2X1
X_16024_ _16024_/A _16024_/B _16024_/C VDD VSS _16025_/C MIN3X1
X_13236_ _13354_/A _14416_/B VDD VSS _13266_/B NOR2X1
XFILLER_108_181 VDD VSS FILLER4
X_10448_ _10448_/A _10448_/B _10448_/C _10448_/D VDD VSS _10449_/C AOI211X1
XFILLER_108_192 VSS VDD FILLER2
XFILLER_124_641 VSS VDD FILLER2
XFILLER_41_6 VDD VSS FILLER1
XFILLER_123_140 VSS VDD FILLER2
XFILLER_151_460 VDD VSS FILLER4
X_13167_ _18996_/Q _13373_/A _13195_/B VDD VSS _13192_/D XNOR3X1
XFILLER_111_302 VSS VDD FILLER2
X_10379_ _10406_/D _10406_/C VDD VSS _10381_/D NOR2BX1
XFILLER_112_836 VSS VDD FILLER2
XFILLER_2_470 VDD VSS FILLER4
XFILLER_123_184 VSS VDD FILLER2
X_12118_ _19124_/Q _12118_/B _12147_/D VDD VSS _12149_/C XOR3X1
XFILLER_69_238 VSS VDD FILLER2
XFILLER_69_249 VDD VSS FILLER1
X_17975_ _17975_/A _17975_/B _17975_/C VDD VSS _17976_/D NOR3X1
X_13098_ _13271_/A _13098_/B VDD VSS _14321_/B XOR2X1
XFILLER_97_569 VSS VDD FILLER2
XFILLER_2_492 VDD VSS FILLER1
X_19714_ _19730_/CK _19714_/D _19714_/Q VDD VSS DFFQX1
X_16926_ _16928_/A _16928_/B _16926_/C VDD VSS _19740_/D AOI21X1
X_12049_ _12055_/A _12055_/B _12050_/D _12055_/C VDD VSS _14528_/A OA211X2
XFILLER_77_271 VDD VSS FILLER1
XFILLER_77_282 VDD VSS FILLER4
X_19645_ _19667_/CK _19645_/D _19645_/Q VDD VSS DFFQX1
X_16857_ _16859_/A _16857_/B VDD VSS _19696_/D AND2X1
XFILLER_92_230 VSS VDD FILLER2
XFILLER_37_135 VSS VDD FILLER2
XFILLER_93_764 VDD VSS FILLER4
XFILLER_65_455 VSS VDD FILLER2
XFILLER_92_252 VSS VDD FILLER2
XFILLER_53_606 VSS VDD FILLER2
X_15808_ _17566_/A VDD VSS _17010_/A BUFX3
XFILLER_80_403 VDD VSS FILLER4
XFILLER_1_96 VSS VDD FILLER2
X_16788_ _16794_/A _16788_/B VDD VSS _19634_/D NOR2X1
X_19576_ _19737_/CK _19576_/D _19576_/Q VDD VSS DFFQX1
XFILLER_52_127 VDD VSS FILLER4
XTAP_TAPCELL_ROW_35_325 VDD VSS WELLTAP
X_15739_ _15739_/A _15739_/B VDD VSS _19364_/D NOR2X1
X_18527_ _18543_/CK _18527_/D _18527_/Q VDD VSS DFFQX1
XFILLER_80_458 VDD VSS FILLER1
XFILLER_34_853 VDD VSS FILLER4
XFILLER_33_341 VDD VSS FILLER4
X_09260_ _09265_/C _09408_/C _18279_/Q VDD VSS _09261_/C AOI21X1
XFILLER_21_503 VSS VDD FILLER2
X_18458_ _18471_/CK _18511_/Q _20100_/A _18464_/RB VDD VSS DFFRQX1
XFILLER_61_694 VSS VDD FILLER2
XFILLER_21_536 VDD VSS FILLER4
X_17409_ _19840_/Q _19808_/Q VDD VSS _17411_/B XNOR2X1
X_09191_ _18520_/Q VDD VSS _18451_/D INVX1
X_18389_ _18389_/CK _18501_/D _20194_/A _18442_/RB VDD VSS DFFRQX1
XFILLER_159_582 VDD VSS FILLER4
XFILLER_119_468 VSS VDD FILLER2
Xclkload120 _18389_/CK VDD VSS clkload120/Y INVX2
XFILLER_20_17 VDD VSS FILLER4
XFILLER_88_503 VDD VSS DECAPHV8
XFILLER_103_814 VSS VDD FILLER2
XFILLER_114_151 VSS VDD FILLER2
XFILLER_88_514 VSS VDD FILLER2
XFILLER_88_525 VDD VSS FILLER1
XFILLER_102_313 VDD VSS FILLER4
XFILLER_114_173 VSS VDD FILLER2
XFILLER_130_633 VSS VDD FILLER2
XFILLER_152_38 VSS VDD FILLER2
XFILLER_75_219 VDD VSS FILLER1
XFILLER_29_614 VSS VDD FILLER2
XFILLER_152_49 VSS VDD FILLER2
XFILLER_69_794 VDD VSS FILLER4
XFILLER_29_647 VDD VSS FILLER4
XFILLER_68_293 VDD VSS FILLER1
XFILLER_28_124 VDD VSS FILLER4
XFILLER_29_658 VSS VDD FILLER2
XTAP_TAPCELL_ROW_126_1147 VDD VSS WELLTAP
XFILLER_45_36 VSS VDD FILLER2
X_09527_ _18197_/D _09527_/B _09527_/C VDD VSS _20022_/D NOR3X1
XFILLER_52_650 VSS VDD FILLER2
XFILLER_24_341 VDD VSS FILLER1
XFILLER_12_514 VDD VSS FILLER4
X_09458_ _18443_/D _09468_/B _09458_/C VDD VSS _18254_/D AOI21X1
XFILLER_101_75 VDD VSS FILLER1
XFILLER_138_700 VSS VDD FILLER2
X_09389_ _19932_/Q _19934_/Q _09389_/C VDD VSS _09390_/B NOR3X1
XFILLER_61_57 VSS VDD FILLER2
XFILLER_131_4 VDD VSS FILLER1
X_11420_ _18542_/D _11428_/B VDD VSS _18614_/D NOR2BX1
XTAP_TAPCELL_ROW_137_1243 VDD VSS WELLTAP
XFILLER_165_552 VDD VSS FILLER4
XFILLER_153_703 VDD VSS FILLER4
XFILLER_125_405 VDD VSS FILLER1
X_11351_ _18589_/Q _11355_/B VDD VSS _11353_/A XNOR2X1
XFILLER_165_574 VSS VDD FILLER2
XFILLER_165_596 VDD VSS FILLER1
X_10302_ _10266_/D _11438_/A _11432_/D VDD VSS _10304_/C AND3BX1
XFILLER_4_735 VDD VSS FILLER4
XFILLER_153_747 VSS VDD FILLER2
XFILLER_125_449 VDD VSS FILLER4
XFILLER_152_235 VDD VSS FILLER4
X_14070_ _14203_/A _14203_/B _18952_/Q VDD VSS _14086_/C OAI21X1
XFILLER_118_490 VSS VDD FILLER2
X_11282_ _11285_/A _11285_/B VDD VSS _11283_/B XNOR2X1
XFILLER_4_768 VSS VDD FILLER2
X_13021_ _13021_/A _13021_/B _13091_/C _13021_/D VDD VSS _13215_/A OAOI211X1
XFILLER_152_279 VSS VDD FILLER2
X_10233_ _18622_/Q _10233_/B VDD VSS _10234_/B XNOR2X1
XFILLER_106_696 VDD VSS FILLER1
XFILLER_79_536 VSS VDD FILLER2
XFILLER_161_791 VSS VDD FILLER2
X_10164_ _18591_/Q _10203_/B VDD VSS _10165_/B XOR2X1
XFILLER_126_83 VSS VDD FILLER2
XTAP_TAPCELL_ROW_77_704 VDD VSS WELLTAP
X_14972_ _15056_/C _15013_/B VDD VSS _14973_/B NAND2X1
X_17760_ _19915_/Q _19883_/Q VDD VSS _17766_/B NAND2X1
X_10095_ _10101_/A _10101_/B VDD VSS _10099_/A XNOR2X1
XFILLER_86_98 VSS VDD FILLER2
XFILLER_59_282 VDD VSS FILLER4
XFILLER_19_113 VSS VDD FILLER2
X_16711_ _16711_/A _16724_/B VDD VSS _19564_/D NOR2X1
X_13923_ _18948_/Q _14001_/B VDD VSS _13924_/D _13923_/C NAND3X1
XFILLER_59_293 VSS VDD FILLER2
X_17691_ _17806_/A _17691_/B VDD VSS _19900_/D NOR2X1
XFILLER_75_753 VDD VSS FILLER1
XFILLER_74_230 VSS VDD FILLER2
X_16642_ _19735_/Q _16900_/B VDD VSS _16643_/D NOR2X1
X_19430_ _19460_/CK _19430_/D _19430_/Q VDD VSS DFFQX1
XFILLER_75_786 VSS VDD FILLER2
XFILLER_47_477 VSS VDD FILLER2
X_13854_ _13854_/A _14393_/B _13854_/C VDD VSS _14364_/B MIN3X1
XFILLER_62_414 VDD VSS FILLER4
XTAP_TAPCELL_ROW_85_781 VDD VSS WELLTAP
X_12805_ _14348_/B _14348_/C _19075_/Q VDD VSS _12807_/C AOI21X1
XFILLER_34_138 VDD VSS FILLER1
X_16573_ _16573_/A _16573_/B VDD VSS _16574_/C NOR2X1
X_19361_ _19379_/CK _19361_/D _19361_/Q VDD VSS DFFQX1
XFILLER_16_853 VDD VSS FILLER4
Xclkbuf_leaf_18__002_ clkload16/A VDD VSS _19956_/CK BUFX12
X_13785_ _19086_/Q _14362_/B VDD VSS _13860_/A NAND2X1
XFILLER_15_330 VSS VDD FILLER2
X_10997_ _18650_/Q _18812_/Q VDD VSS _10999_/A XOR2X1
X_15524_ _19408_/Q _15789_/B VDD VSS _15526_/A XNOR2X1
X_18312_ _18325_/CK _18525_/Q _18312_/Q _18422_/RB VDD VSS DFFRQX1
X_19292_ _19306_/CK _19292_/D _19292_/Q VDD VSS DFFQX1
X_12736_ _19131_/Q VDD VSS _12813_/A INVX1
XFILLER_35_91 VSS VDD FILLER2
XFILLER_70_480 VDD VSS FILLER4
XFILLER_43_694 VDD VSS FILLER1
XFILLER_15_385 VSS VDD FILLER2
XFILLER_70_491 VSS VDD FILLER2
X_18243_ _18256_/CK _18243_/D _18274_/D _20080_/RB VDD VSS DFFRQX1
X_15455_ _19350_/Q _15724_/B VDD VSS _15457_/A XOR2X1
XFILLER_129_700 VSS VDD FILLER2
X_12667_ _19242_/Q _14536_/B VDD VSS _12832_/A NAND2X1
X_14406_ _14381_/Y _14406_/B _14406_/C VDD VSS _19127_/D AND3BX1
X_18174_ _19300_/Q _18174_/B _18174_/C VDD VSS _18179_/C MIN3X1
X_11618_ _18761_/Q _11624_/B VDD VSS _18788_/D AND2X1
X_15386_ _19348_/Q _15386_/B _15722_/B VDD VSS _15456_/A MIN3X1
XFILLER_156_530 VSS VDD FILLER2
XFILLER_129_755 VSS VDD FILLER2
X_12598_ _19018_/Q _12598_/B _12632_/C VDD VSS _12717_/A XNOR3X1
XTAP_TAPCELL_ROW_40_372 VDD VSS WELLTAP
XFILLER_129_777 VSS VDD FILLER2
X_17125_ _17128_/C _17126_/B _17164_/C VDD VSS _17126_/C OAI21X1
X_14337_ _14339_/A _14337_/B VDD VSS _19065_/D NOR2X1
XFILLER_128_265 VDD VSS FILLER4
X_11549_ _18698_/Q _11555_/B VDD VSS _18725_/D AND2X1
XFILLER_7_573 VSS VDD FILLER2
XFILLER_156_585 VSS VDD FILLER2
XFILLER_128_287 VSS VDD FILLER2
X_17056_ _17095_/A _17056_/B VDD VSS _19764_/D NOR2X1
X_14268_ _14268_/A _14268_/B _15836_/C VDD VSS _19006_/D OA21X2
XFILLER_131_408 VSS VDD FILLER2
X_16007_ _19711_/Q _16874_/B VDD VSS _16028_/A NAND2X1
XTAP_TAPCELL_ROW_114_1040 VDD VSS WELLTAP
X_13219_ _13219_/A _13219_/B _13231_/C VDD VSS _13365_/B XNOR3X1
X_14199_ _14219_/A _14199_/B _14199_/C VDD VSS _18949_/D NOR3X1
XFILLER_98_834 VSS VDD FILLER2
XFILLER_97_333 VDD VSS FILLER1
XFILLER_85_517 VDD VSS FILLER4
XFILLER_100_828 VSS VDD FILLER2
X_17958_ _17958_/A _17958_/B _17958_/C _17958_/D VDD VSS _17966_/A OAOI211X1
XFILLER_18_0 VSS VDD FILLER2
X_16909_ _20068_/Q _16909_/B _16909_/C VDD VSS _16912_/B AOI21X1
XFILLER_66_753 VDD VSS FILLER1
X_17889_ _18856_/Q VDD VSS _17894_/A INVX1
XFILLER_93_561 VSS VDD FILLER2
XFILLER_38_466 VSS VDD FILLER2
X_19628_ _19661_/CK _19628_/D _19628_/Q VDD VSS DFFQX1
XFILLER_93_594 VDD VSS FILLER1
XFILLER_53_425 VSS VDD FILLER2
XFILLER_25_116 VSS VDD FILLER2
XFILLER_65_296 VSS VDD FILLER2
XFILLER_19_691 VDD VSS FILLER1
XFILLER_25_138 VSS VDD FILLER2
X_19559_ _19584_/CK _19559_/D _19559_/Q VDD VSS DFFQX1
XFILLER_80_244 VSS VDD FILLER2
XFILLER_53_458 VSS VDD FILLER2
XFILLER_80_255 VSS VDD FILLER2
XFILLER_80_266 VDD VSS FILLER1
X_09312_ _18405_/D _09311_/Y _09302_/Y VDD VSS _18522_/D MUXI2X1
XFILLER_22_834 VSS VDD FILLER2
X_09243_ _18470_/D VDD VSS _18342_/D INVX1
XTAP_TAPCELL_ROW_121_1099 VDD VSS WELLTAP
XFILLER_21_377 VDD VSS FILLER1
XFILLER_31_16 VDD VSS FILLER4
XFILLER_31_38 VSS VDD FILLER2
X_18210__256 _20052_/CK VDD VSS _18277_/CK INVX1
XFILLER_147_27 VDD VSS FILLER4
XFILLER_119_276 VSS VDD FILLER2
XFILLER_134_202 VSS VDD FILLER2
XFILLER_147_38 VSS VDD FILLER2
XFILLER_135_747 VSS VDD FILLER2
XFILLER_162_522 VDD VSS FILLER4
XFILLER_134_235 VSS VDD FILLER2
XFILLER_162_544 VSS VDD FILLER2
XFILLER_134_246 VDD VSS FILLER4
XFILLER_150_706 VDD VSS FILLER1
Xoutput16 _20085_/Y VDD VSS o_aux_ctrl[3] BUFX3
XFILLER_89_801 VSS VDD FILLER2
XFILLER_150_717 VSS VDD FILLER2
Xoutput27 _20111_/Y VDD VSS o_bias_cfg[13] BUFX3
XFILLER_150_728 VSS VDD FILLER2
Xoutput38 _20121_/Y VDD VSS o_bias_cfg[23] BUFX3
Xoutput49 _20131_/Y VDD VSS o_bias_cfg[33] BUFX3
XFILLER_1_727 VSS VDD FILLER2
XFILLER_0_215 VDD VSS FILLER4
XFILLER_102_110 VDD VSS FILLER1
XFILLER_103_633 VSS VDD FILLER2
XFILLER_115_493 VDD VSS DECAPHV8
X_20196_ _20196_/A VDD VSS _20196_/Y BUFX3
XFILLER_103_699 VSS VDD FILLER2
XFILLER_57_720 VSS VDD FILLER2
XFILLER_57_731 VSS VDD FILLER2
XFILLER_69_591 VSS VDD FILLER2
XFILLER_56_230 VSS VDD FILLER2
XFILLER_57_775 VSS VDD FILLER2
X_10920_ _11272_/A _10920_/B VDD VSS _18568_/D NOR2X1
XFILLER_72_723 VDD VSS FILLER1
XFILLER_29_488 VDD VSS DECAPHV16
X_10851_ _10851_/A _10851_/B _10885_/A _10851_/D VDD VSS _10885_/B AOI211X1
XFILLER_44_458 VDD VSS FILLER4
XTAP_TAPCELL_ROW_82_751 VDD VSS WELLTAP
XFILLER_71_277 VSS VDD FILLER2
XFILLER_25_672 VSS VDD FILLER2
X_13570_ _18944_/Q _14194_/B VDD VSS _13580_/C XNOR2X1
X_10782_ _10784_/A _10782_/B VDD VSS _10783_/B XOR2X1
XFILLER_71_299 VSS VDD FILLER2
XTAP_TAPCELL_ROW_54_497 VDD VSS WELLTAP
XFILLER_158_806 VSS VDD FILLER2
X_12521_ _12600_/B _12600_/C VDD VSS _14283_/B NAND2X1
XFILLER_9_805 VSS VDD FILLER2
Xclkbuf_leaf_5_clk_regs clkbuf_leaf_9_clk_regs/A VDD VSS _19841_/CK BUFX12
XFILLER_158_828 VDD VSS FILLER1
X_15240_ _15274_/A _15240_/B VDD VSS _15307_/B XNOR2X1
XFILLER_9_849 VSS VDD FILLER2
X_12452_ _12452_/A _12452_/B _12452_/C _12452_/D VDD VSS _12461_/B OAOI211X1
XFILLER_122_0 VDD VSS FILLER4
X_11403_ _17827_/B _17990_/B _11403_/C VDD VSS _18599_/D NOR3X1
X_15171_ _19315_/Q _15171_/B _15686_/B VDD VSS _15217_/B MIN3X1
XFILLER_126_725 VSS VDD FILLER2
X_12383_ _12472_/A _12472_/B VDD VSS _14438_/B XNOR2X1
XFILLER_125_213 VDD VSS FILLER1
X_09977__248 _20080_/CK VDD VSS _18524_/CK INVX1
X_14122_ _14142_/A _14122_/B VDD VSS _18881_/D NOR2X1
XFILLER_165_393 VDD VSS FILLER4
XFILLER_153_544 VDD VSS FILLER1
X_11334_ _11337_/B _11334_/B VDD VSS _11335_/B XOR2X1
XFILLER_4_532 VSS VDD FILLER2
XFILLER_137_71 VDD VSS FILLER4
X_18930_ _18934_/CK _18930_/D _18930_/Q VDD VSS DFFQX1
X_14053_ _18196_/A _17963_/B _17963_/C VDD VSS _18868_/D AND3BX1
XFILLER_137_82 VSS VDD FILLER2
X_11265_ _11379_/A _11276_/A VDD VSS _11269_/A NOR2X1
XFILLER_97_53 VSS VDD FILLER2
X_13004_ _13004_/A _13004_/B _13004_/C _13004_/D VDD VSS _13192_/A AOAI211X1
XFILLER_106_493 VSS VDD FILLER2
X_10216_ _10217_/A _10217_/B _10217_/D _10217_/C VDD VSS _10219_/C AOI211X1
XFILLER_133_290 VSS VDD FILLER2
X_18861_ _18889_/CK _18861_/D _18861_/Q VDD VSS DFFQX1
X_11196_ _11196_/A _18737_/Q VDD VSS _11229_/E NAND2X1
XFILLER_67_506 VSS VDD FILLER2
X_17812_ _17812_/A VDD VSS _18173_/A BUFX3
XFILLER_95_826 VSS VDD FILLER2
X_10147_ _10047_/B _10146_/Y _10224_/A VDD VSS _10152_/B MUXI2X1
XFILLER_67_528 VSS VDD FILLER2
X_18792_ _18823_/CK _18792_/D _18792_/Q VDD VSS DFFQX1
XFILLER_0_793 VDD VSS FILLER1
X_14955_ _19394_/Q _14955_/B _15773_/B VDD VSS _15026_/A MIN3X1
X_17743_ _17806_/A _17743_/B VDD VSS _19911_/D NOR2X1
X_10078_ _18606_/Q _10078_/B _10076_/B VDD VSS _10097_/A AOI21BX1
XFILLER_75_561 VSS VDD FILLER2
X_13906_ _19088_/Q _14364_/B VDD VSS _13907_/C NAND2X1
X_14886_ _19421_/Q _14959_/A _14909_/B VDD VSS _14911_/D XNOR3X1
X_17674_ _17678_/A _17678_/B VDD VSS _17675_/B XNOR2X1
XFILLER_63_734 VDD VSS FILLER4
XFILLER_90_531 VSS VDD FILLER2
X_19413_ _19508_/CK _19413_/D _19413_/Q VDD VSS DFFQX1
XTAP_TAPCELL_ROW_45_420 VDD VSS WELLTAP
XFILLER_63_756 VSS VDD FILLER2
X_16625_ _19574_/Q VDD VSS _16626_/A INVX1
X_13837_ _13837_/A _13837_/B _13837_/C _13837_/D VDD VSS _14297_/C AOI211X1
XFILLER_46_90 VDD VSS FILLER4
XFILLER_50_406 VDD VSS FILLER4
X_16556_ _16571_/B _16556_/B VDD VSS _16826_/B XNOR2X1
X_19344_ _19573_/CK _19344_/D _19344_/Q VDD VSS DFFQX1
XTAP_TAPCELL_ROW_17_166 VDD VSS WELLTAP
XFILLER_62_288 VSS VDD FILLER2
XFILLER_50_428 VDD VSS DECAPHV16
X_13768_ _13768_/A _13768_/B _13768_/C _13768_/D VDD VSS _14229_/B OAOI211X1
XFILLER_16_683 VSS VDD FILLER2
XFILLER_94_4 VSS VDD FILLER2
X_15507_ _19380_/Q VDD VSS _15540_/A INVX1
X_12719_ _12719_/A _14347_/B VDD VSS _12807_/A OR2X2
X_16487_ _19729_/Q _16894_/B VDD VSS _16488_/B XOR2X1
X_19275_ _20004_/CK _19275_/D _19275_/Q VDD VSS DFFQX1
Xclkbuf_0_clk clk VDD VSS clkbuf_0_clk/Y BUFX12
XFILLER_30_130 VSS VDD FILLER2
X_13699_ _13727_/A _14326_/B _13699_/C _13699_/D VDD VSS _13781_/A AOAI211X1
XTAP_TAPCELL_ROW_157_1427 VDD VSS WELLTAP
XFILLER_31_686 VSS VDD FILLER2
X_15438_ _15473_/A _15912_/B VDD VSS _15474_/A XNOR2X1
X_18226_ _18226_/CK _18226_/E _18226_/ECK VDD VSS CGX3
XFILLER_129_552 VDD VSS FILLER4
XFILLER_7_40 VSS VDD FILLER2
X_15369_ _15391_/B _15369_/B VDD VSS _15785_/B XNOR2X1
X_18157_ _18159_/A _18157_/B VDD VSS _18158_/B XOR2X1
XFILLER_116_202 VSS VDD FILLER2
XFILLER_117_736 VSS VDD FILLER2
XFILLER_144_522 VDD VSS FILLER1
XFILLER_117_747 VSS VDD FILLER2
X_17108_ _19775_/Q _19743_/Q _17108_/C VDD VSS _17114_/C AOI21X1
XFILLER_116_235 VSS VDD FILLER2
X_18088_ _18090_/A _18090_/B _18090_/C _18088_/D VDD VSS _19992_/D AOI31X1
XFILLER_144_566 VSS VDD FILLER2
XFILLER_116_268 VSS VDD FILLER2
X_17039_ _17566_/A VDD VSS _17536_/A BUFX3
X_09930_ _09944_/A _09930_/B _09930_/C VDD VSS _09931_/C OA21X2
X_20050_ clkload3/A _20050_/D _20051_/D input3/Y VDD VSS DFFRQX1
XFILLER_131_249 VDD VSS DECAPHV8
X_09861_ _09928_/C _09861_/B VDD VSS _09862_/C NOR2X1
Xclkbuf_1_1__f__09184_ clkbuf_0__09184_/Y VDD VSS _18503_/CK BUFX12
XFILLER_140_761 VDD VSS FILLER1
XFILLER_112_474 VSS VDD FILLER2
X_09792_ _18454_/Q VDD VSS _20179_/A INVX1
XFILLER_85_325 VDD VSS FILLER1
XFILLER_100_669 VSS VDD FILLER2
XFILLER_38_230 VSS VDD FILLER2
XTAP_TAPCELL_ROW_96_876 VDD VSS WELLTAP
XFILLER_66_561 VSS VDD FILLER2
XTAP_TAPCELL_ROW_108_988 VDD VSS WELLTAP
XTAP_TAPCELL_ROW_123_1117 VDD VSS WELLTAP
XFILLER_26_49 VSS VDD FILLER2
XFILLER_14_609 VDD VSS FILLER1
XFILLER_54_789 VDD VSS FILLER1
XFILLER_53_277 VSS VDD FILLER2
XFILLER_53_288 VDD VSS DECAPHV16
XFILLER_34_491 VSS VDD FILLER2
XFILLER_22_631 VSS VDD FILLER2
XFILLER_22_642 VSS VDD FILLER2
XFILLER_42_37 VSS VDD FILLER2
XFILLER_22_675 VDD VSS FILLER4
XFILLER_166_113 VSS VDD FILLER2
X_09226_ _18521_/Q VDD VSS _18372_/D INVX1
XFILLER_166_157 VDD VSS FILLER1
XFILLER_6_819 VSS VDD FILLER2
XFILLER_108_736 VDD VSS DECAPHV8
XFILLER_108_769 VDD VSS FILLER4
XFILLER_135_555 VSS VDD FILLER2
XFILLER_107_257 VSS VDD FILLER2
XFILLER_162_352 VDD VSS FILLER1
XFILLER_135_577 VDD VSS DECAPHV8
XFILLER_123_728 VSS VDD FILLER2
XFILLER_150_514 VSS VDD FILLER2
XFILLER_1_524 VDD VSS FILLER4
X_11050_ _10912_/Y _11049_/Y _11118_/A VDD VSS _11050_/Y MUXI2X1
XFILLER_150_569 VDD VSS FILLER1
XFILLER_1_568 VSS VDD FILLER2
XFILLER_103_463 VSS VDD FILLER2
X_10001_ _09986_/Y _10000_/Y _11178_/C VDD VSS _10001_/Y MUX2X1
XFILLER_89_686 VDD VSS DECAPHV8
XFILLER_107_96 VSS VDD FILLER2
X_20179_ _20179_/A VDD VSS _20179_/Y BUFX3
XFILLER_77_848 VDD VSS FILLER4
XFILLER_49_539 VDD VSS FILLER1
XTAP_TAPCELL_ROW_59_545 VDD VSS WELLTAP
XFILLER_92_807 VDD VSS FILLER4
XFILLER_76_369 VSS VDD FILLER2
XFILLER_64_509 VSS VDD FILLER2
XFILLER_123_40 VDD VSS FILLER1
XTAP_TAPCELL_ROW_145_1320 VDD VSS WELLTAP
XFILLER_57_561 VDD VSS FILLER4
X_14740_ _19500_/Q _15893_/B VDD VSS _14746_/C NOR2BX1
XFILLER_57_572 VSS VDD FILLER2
X_11952_ _19064_/Q VDD VSS _11959_/A INVX1
XFILLER_29_274 VDD VSS FILLER4
XFILLER_123_73 VSS VDD FILLER2
XFILLER_57_594 VSS VDD FILLER2
XFILLER_44_211 VDD VSS FILLER1
XFILLER_72_520 VDD VSS FILLER4
XFILLER_29_296 VSS VDD FILLER2
X_10903_ _18700_/Q _18754_/Q _10903_/C VDD VSS _10940_/A MIN3X1
X_14671_ _14671_/A _14671_/B _14671_/C VDD VSS _15827_/B XNOR3X1
X_11883_ _19231_/Q _14525_/B VDD VSS _11884_/D _14525_/C NAND3X1
XFILLER_60_704 VSS VDD FILLER2
XFILLER_44_255 VSS VDD FILLER2
X_16410_ _19726_/Q _16890_/B VDD VSS _16414_/B XOR2X1
XFILLER_72_575 VDD VSS FILLER1
X_13622_ _13623_/A _13623_/B _13623_/D _13623_/C VDD VSS _13716_/B OAOI211X1
XFILLER_44_277 VDD VSS FILLER4
X_17390_ _17390_/A _17390_/B VDD VSS _19836_/D NOR2X1
X_10834_ _18645_/Q _18807_/Q VDD VSS _10836_/C XNOR2X1
XFILLER_44_288 VSS VDD FILLER2
XFILLER_16_71 VSS VDD FILLER2
X_16341_ _16368_/A _16368_/B VDD VSS _16746_/B XNOR2X1
X_13553_ _19223_/Q _14516_/B VDD VSS _13554_/D AND2X1
XTAP_TAPCELL_ROW_14_136 VDD VSS WELLTAP
X_10765_ _10765_/A _10765_/B _10765_/C _10765_/D VDD VSS _10794_/A OAI31X1
X_19060_ _19115_/CK _19060_/D _19060_/Q VDD VSS DFFQX1
X_12504_ _19157_/Q _12504_/B _14440_/C VDD VSS _12643_/B XNOR3X1
XFILLER_40_472 VSS VDD FILLER2
XFILLER_157_124 VSS VDD FILLER2
X_16272_ _16274_/A _16274_/B VDD VSS _16302_/B NOR2X1
X_13484_ _13492_/A _13578_/D VDD VSS _13575_/B XNOR2X1
XFILLER_139_850 VDD VSS FILLER4
X_10696_ _11226_/A _10696_/B _10696_/C _10696_/D VDD VSS _10733_/B OAI211X1
X_15223_ _15223_/A _15223_/B _15223_/C VDD VSS _15262_/A OAI21X1
X_18011_ _18011_/A VDD VSS _18049_/D BUFX3
XFILLER_8_156 VSS VDD FILLER2
X_12435_ _18932_/Q VDD VSS _12438_/A INVX1
XFILLER_157_179 VSS VDD FILLER2
XTAP_TAPCELL_ROW_3_41 VDD VSS WELLTAP
XFILLER_32_81 VSS VDD FILLER2
XFILLER_8_178 VSS VDD FILLER2
XFILLER_154_820 VSS VDD FILLER2
XFILLER_154_842 VSS VDD FILLER2
XFILLER_148_81 VSS VDD FILLER2
X_15154_ _15154_/A VDD VSS _15155_/D INVX1
X_12366_ _12512_/B _12366_/B _12366_/C _12366_/D VDD VSS _12517_/B AOAI211X1
X_14105_ _18899_/Q _14142_/B VDD VSS _17978_/B XNOR2X1
X_11317_ _11370_/A _11317_/B VDD VSS _11318_/B NOR2X1
XTAP_TAPCELL_ROW_152_1379 VDD VSS WELLTAP
X_15085_ _15112_/A _15085_/B VDD VSS _15838_/B XNOR2X1
X_19962_ _19963_/CK _19962_/D _19962_/Q VDD VSS DFFQX1
XFILLER_99_428 VDD VSS FILLER4
XFILLER_4_362 VDD VSS FILLER1
X_12297_ wire159/Y _12298_/B _12298_/D _12298_/C VDD VSS _14375_/B OAOI211X1
XTAP_TAPCELL_ROW_111_1010 VDD VSS WELLTAP
X_18913_ _18939_/CK _18913_/D _18913_/Q VDD VSS DFFQX1
X_14036_ _14036_/A _14036_/B _14036_/C _14036_/D VDD VSS _14202_/C OAOI211X1
XFILLER_106_290 VSS VDD FILLER2
X_11248_ _18579_/Q _11252_/B VDD VSS _11253_/C XNOR2X1
X_19893_ _19895_/CK _19893_/D _19893_/Q VDD VSS DFFQX1
XFILLER_79_152 VDD VSS FILLER4
XFILLER_164_91 VDD VSS FILLER1
X_18844_ _19963_/CK _18844_/D _18844_/Q VDD VSS DFFQX1
XFILLER_95_623 VSS VDD FILLER2
X_11179_ _11179_/A _11179_/B VDD VSS _11179_/Y NAND2X1
XFILLER_121_282 VDD VSS FILLER4
X_18775_ _19947_/CK _18775_/D _18775_/Q VDD VSS DFFQX1
X_15987_ _19678_/Q _16837_/B _16010_/B VDD VSS _16030_/A MIN3X1
XFILLER_48_572 VDD VSS FILLER1
XFILLER_36_712 VSS VDD FILLER2
X_17726_ _19907_/Q _19875_/Q _17726_/C VDD VSS _17730_/B MIN3X1
XFILLER_82_328 VSS VDD FILLER2
X_14938_ _15805_/B _15805_/C _19422_/Q VDD VSS _14956_/C AOI21X1
XTAP_TAPCELL_ROW_93_846 VDD VSS WELLTAP
XFILLER_48_594 VSS VDD FILLER2
XFILLER_91_840 VSS VDD FILLER2
XFILLER_36_756 VSS VDD FILLER2
XFILLER_63_553 VDD VSS FILLER4
X_17657_ _17803_/B _17657_/B _17657_/C VDD VSS _17663_/C MIN3X1
X_14869_ _19476_/Q _15867_/B VDD VSS _14920_/A NOR2BX1
XTAP_TAPCELL_ROW_105_958 VDD VSS WELLTAP
XFILLER_35_266 VSS VDD FILLER2
XFILLER_35_277 VSS VDD FILLER2
X_16608_ _19638_/Q _16792_/B VDD VSS _16622_/B XOR2X1
XFILLER_23_439 VDD VSS FILLER1
X_17588_ _17589_/A _17589_/B _17589_/D _17589_/C VDD VSS _17591_/C AOI211X1
XFILLER_149_614 VDD VSS FILLER4
X_19327_ _19385_/CK _19327_/D _19327_/Q VDD VSS DFFQX1
X_16539_ _19731_/Q _16896_/B VDD VSS _16543_/B XNOR2X1
XFILLER_31_472 VDD VSS FILLER1
X_19258_ _19995_/CK _19258_/D _19258_/Q VDD VSS DFFQX1
XFILLER_164_639 VSS VDD FILLER2
XFILLER_163_105 VSS VDD FILLER2
XFILLER_128_18 VSS VDD FILLER2
XFILLER_129_371 VDD VSS FILLER1
X_19189_ _19191_/CK _19189_/D _19189_/Q VDD VSS DFFQX1
XFILLER_163_127 VSS VDD FILLER2
XFILLER_157_691 VSS VDD FILLER2
XFILLER_117_533 VDD VSS FILLER4
XFILLER_129_393 VDD VSS FILLER4
XFILLER_132_514 VSS VDD FILLER2
XFILLER_160_845 VSS VDD FILLER2
XFILLER_132_547 VSS VDD FILLER2
X_20102_ _20102_/A VDD VSS _20102_/Y BUFX3
X_09913_ _09928_/C _09939_/B _09913_/C VDD VSS _10004_/B OAI21X1
XFILLER_104_249 VSS VDD FILLER2
XFILLER_144_17 VDD VSS FILLER1
XFILLER_98_461 VSS VDD FILLER2
XFILLER_59_815 VDD VSS FILLER4
XFILLER_113_772 VDD VSS FILLER4
X_20033_ _20033_/CK _20033_/D _20033_/Q _20045_/RB VDD VSS DFFRQX1
XFILLER_59_826 VDD VSS FILLER4
X_09844_ _18568_/Q _10686_/D VDD VSS _09880_/B XNOR2X1
XFILLER_100_411 VDD VSS FILLER4
Xclkbuf_1_1__f__09167_ clkbuf_0__09167_/Y VDD VSS _18406_/CK BUFX12
X_09775_ _09816_/D _20193_/A _09775_/C _09813_/C VDD VSS _09776_/D AOAI211X1
XFILLER_37_26 VSS VDD FILLER2
XFILLER_86_689 VDD VSS FILLER1
XFILLER_73_306 VSS VDD FILLER2
XFILLER_39_561 VSS VDD FILLER2
XFILLER_73_317 VDD VSS FILLER1
XTAP_TAPCELL_ROW_56_515 VDD VSS WELLTAP
XFILLER_100_499 VSS VDD FILLER2
XFILLER_160_38 VSS VDD FILLER2
XFILLER_39_594 VDD VSS FILLER4
XFILLER_160_49 VDD VSS FILLER4
XFILLER_54_531 VSS VDD FILLER2
XFILLER_27_756 VDD VSS DECAPHV8
XTAP_TAPCELL_ROW_64_592 VDD VSS WELLTAP
XTAP_TAPCELL_ROW_140_1272 VDD VSS WELLTAP
XFILLER_10_601 VSS VDD FILLER2
XFILLER_139_135 VSS VDD FILLER2
X_10550_ _10550_/A VDD VSS _11267_/A BUFX3
X_09209_ _18510_/Q VDD VSS _18425_/D INVX1
XFILLER_10_667 VSS VDD FILLER2
XFILLER_154_105 VSS VDD FILLER2
X_10481_ _18635_/Q _18797_/Q _10481_/C _10481_/D VDD VSS _10483_/C AOAI211X1
X_12220_ _12382_/A _12382_/B VDD VSS _12373_/B NAND2X1
XFILLER_163_650 VDD VSS FILLER1
XFILLER_108_577 VDD VSS FILLER4
XFILLER_123_503 VSS VDD FILLER2
XFILLER_151_812 VSS VDD FILLER2
XFILLER_163_672 VDD VSS FILLER4
X_12151_ _12160_/A _14465_/B _12160_/C VDD VSS _14466_/C OR3X2
XFILLER_123_536 VDD VSS FILLER4
XFILLER_78_22 VSS VDD FILLER2
XFILLER_151_856 VDD VSS FILLER1
X_11102_ _18706_/Q _18760_/Q _11102_/C VDD VSS _11146_/C AO21X2
XFILLER_78_44 VSS VDD FILLER2
X_12082_ _19122_/Q _12087_/A _14401_/B VDD VSS _14371_/B XNOR3X1
XFILLER_1_343 VSS VDD FILLER2
XFILLER_1_365 VSS VDD FILLER2
X_15910_ _16100_/A _15910_/B VDD VSS _19515_/D NOR2X1
X_11033_ _18677_/Q _18785_/Q _11033_/C VDD VSS _11067_/C AO21X2
XFILLER_49_314 VDD VSS DECAPHV8
X_16890_ _16891_/A _16890_/B VDD VSS _19726_/D NOR2X1
XFILLER_103_282 VDD VSS FILLER4
XFILLER_49_347 VSS VDD FILLER2
XFILLER_134_72 VDD VSS FILLER1
X_15841_ _17010_/A _15841_/B _15841_/C VDD VSS _19455_/D NOR3X1
XFILLER_134_83 VSS VDD FILLER2
XFILLER_92_626 VDD VSS FILLER4
XFILLER_91_103 VDD VSS FILLER4
X_18560_ _18578_/CK _18560_/D _18560_/Q VDD VSS DFFQX1
XFILLER_94_65 VSS VDD FILLER2
XFILLER_92_637 VDD VSS FILLER4
XFILLER_64_328 VSS VDD FILLER2
XFILLER_18_723 VDD VSS FILLER4
X_15772_ _16795_/A VDD VSS _15793_/A BUFX3
X_12984_ _12992_/A _12992_/B _12989_/C VDD VSS _14154_/B XNOR3X1
XFILLER_18_734 VSS VDD FILLER2
XFILLER_94_87 VDD VSS FILLER1
XFILLER_73_840 VSS VDD FILLER2
XFILLER_18_756 VSS VDD FILLER2
X_17511_ _19862_/Q _19830_/Q VDD VSS _17517_/A XNOR2X1
X_14723_ _19333_/Q _15705_/B VDD VSS _14724_/B XNOR2X1
X_11935_ _19233_/Q _11988_/A _12055_/B VDD VSS _12048_/D XNOR3X1
XFILLER_91_158 VDD VSS DECAPHV8
X_18491_ _18495_/CK _18512_/Q _20104_/A _18491_/RB VDD VSS DFFRQX1
XFILLER_72_350 VSS VDD FILLER2
XTAP_TAPCELL_ROW_90_827 VDD VSS WELLTAP
XFILLER_32_203 VSS VDD FILLER2
XFILLER_17_277 VSS VDD FILLER2
X_17442_ _19847_/Q _19815_/Q VDD VSS _17444_/B XOR2X1
X_14654_ _19498_/Q _15891_/B VDD VSS _14676_/D XOR2X1
XFILLER_32_214 VSS VDD FILLER2
X_11866_ _11967_/B _11866_/B VDD VSS _11867_/C XNOR2X1
XFILLER_72_394 VSS VDD FILLER2
XTAP_TAPCELL_ROW_102_928 VDD VSS WELLTAP
XFILLER_60_545 VDD VSS FILLER4
X_13605_ _19028_/Q _13837_/A _13610_/B VDD VSS _13607_/C XNOR3X1
X_10817_ _11263_/A _10853_/A VDD VSS _10846_/A NOR2X1
X_17373_ _19831_/Q _19799_/Q _17373_/C VDD VSS _17377_/B MIN3X1
X_14585_ _19520_/Q _19519_/Q VDD VSS _15887_/B _19521_/Q NAND3X1
X_11797_ _11797_/A _11797_/B _11797_/C _11851_/B VDD VSS _11830_/B OAOI211X1
XFILLER_13_461 VDD VSS FILLER4
X_19112_ _19166_/CK _19112_/D _19112_/Q VDD VSS DFFQX1
XFILLER_13_483 VSS VDD FILLER2
X_16324_ _19691_/Q _16852_/B VDD VSS _16326_/C XNOR2X1
X_13536_ _13728_/A _13728_/B VDD VSS _13565_/B NOR2X1
X_10748_ _19949_/Q _18831_/Q VDD VSS _10749_/A NAND2X1
XFILLER_43_91 VSS VDD FILLER2
XFILLER_158_455 VDD VSS FILLER4
XFILLER_13_494 VSS VDD FILLER2
XFILLER_146_617 VDD VSS FILLER1
X_16255_ _16255_/A _16255_/B _16778_/B VDD VSS _16264_/A MIN3X1
X_19043_ _19044_/CK _19043_/D _19043_/Q VDD VSS DFFQX1
XFILLER_159_91 VSS VDD FILLER2
X_13467_ _13557_/A _13557_/C VDD VSS _13468_/C NOR2X1
X_10679_ _10679_/A _10679_/B VDD VSS _10696_/B XOR2X1
XFILLER_127_842 VDD VSS FILLER1
X_15206_ _15206_/A _15225_/B VDD VSS _15779_/A XNOR2X1
X_12418_ _19100_/Q _12593_/A _12456_/C VDD VSS _12544_/D XNOR3X1
XFILLER_138_190 VDD VSS FILLER1
X_16186_ _16208_/A _16208_/B VDD VSS _16740_/B XNOR2X1
X_13398_ _14221_/A _14221_/B _14221_/C VDD VSS _13400_/B OAI21X1
XFILLER_57_4 VDD VSS DECAPHV8
XFILLER_114_514 VDD VSS FILLER4
X_15137_ _15137_/A _15137_/B _15137_/C VDD VSS _15178_/A OAI21X1
X_12349_ _12349_/A _12349_/B _14114_/B VDD VSS _12352_/B MIN3X1
XFILLER_142_856 VDD VSS FILLER1
XFILLER_4_170 VSS VDD FILLER2
X_15068_ _15069_/A _15069_/B _15069_/C VDD VSS _15776_/B AOI21X1
X_19945_ _19946_/CK _19945_/D _19945_/Q VDD VSS DFFQX1
XFILLER_4_192 VSS VDD FILLER2
X_14019_ _14019_/A _14169_/B _14169_/C VDD VSS _14020_/D NOR3X1
X_19876_ clkload9/A _19876_/D _19876_/Q VDD VSS DFFQX1
XFILLER_110_731 VSS VDD FILLER2
XFILLER_67_111 VDD VSS FILLER1
X_18827_ _19946_/CK _18827_/D _18827_/Q VDD VSS DFFQX1
XFILLER_56_807 VSS VDD FILLER2
XFILLER_95_486 VSS VDD FILLER2
XFILLER_82_103 VSS VDD FILLER2
X_09560_ _09630_/C _09578_/B VDD VSS _09815_/C NOR2X2
X_18758_ _18785_/CK _18758_/D _18758_/Q VDD VSS DFFQX1
XFILLER_48_380 VSS VDD FILLER2
XFILLER_48_391 VDD VSS FILLER1
XFILLER_36_531 VDD VSS FILLER1
X_17709_ _19904_/Q _19872_/Q VDD VSS _17711_/B XNOR2X1
X_09491_ _18442_/D _09501_/B _09491_/C VDD VSS _18239_/D AOI21X1
XFILLER_24_704 VDD VSS FILLER1
X_18689_ _18799_/CK _18689_/D _18689_/Q VDD VSS DFFQX1
XFILLER_36_586 VDD VSS FILLER1
XFILLER_90_191 VSS VDD FILLER2
XFILLER_51_556 VSS VDD FILLER2
XFILLER_23_17 VSS VDD FILLER2
XTAP_TAPCELL_ROW_61_562 VDD VSS WELLTAP
XFILLER_32_781 VSS VDD FILLER2
XFILLER_149_499 VDD VSS FILLER1
XFILLER_164_425 VSS VDD FILLER2
XFILLER_136_127 VDD VSS FILLER1
XFILLER_117_341 VSS VDD FILLER2
XFILLER_133_856 VDD VSS FILLER1
XFILLER_99_781 VDD VSS FILLER1
XFILLER_120_528 VDD VSS FILLER1
XFILLER_58_111 VSS VDD FILLER2
X_20016_ clkload7/A _20016_/D _20016_/Q _20071_/RB VDD VSS DFFRQX1
X_09827_ _09907_/A _10247_/A VDD VSS _09828_/A OR2X2
XFILLER_101_764 VSS VDD FILLER2
XFILLER_104_20 VSS VDD FILLER2
XFILLER_86_475 VSS VDD FILLER2
XFILLER_101_786 VDD VSS FILLER1
XFILLER_46_328 VSS VDD FILLER2
X_09758_ _18435_/Q _09811_/B _09811_/C _20208_/A _09758_/E VDD VSS _09759_/B AOI221X1
XTAP_TAPCELL_ROW_129_1178 VDD VSS WELLTAP
XFILLER_55_840 VDD VSS FILLER4
X_09689_ _18415_/Q _09696_/B wire176/Y _18351_/Q VDD VSS _09690_/D OAI22X1
XFILLER_161_4 VSS VDD FILLER2
XFILLER_82_670 VDD VSS FILLER4
X_11720_ _19226_/Q _14519_/B VDD VSS _11745_/C _14519_/C NAND3X1
XFILLER_82_681 VSS VDD FILLER2
XFILLER_14_225 VSS VDD FILLER2
XFILLER_120_30 VSS VDD FILLER2
X_11651_ _18791_/Q _11658_/B VDD VSS _18818_/D AND2X1
XTAP_TAPCELL_ROW_24_231 VDD VSS WELLTAP
XFILLER_42_567 VSS VDD FILLER2
X_10602_ _19945_/Q _18827_/Q VDD VSS _10633_/A NAND2X1
X_14370_ _14393_/A _14370_/B VDD VSS _19093_/D NOR2X1
X_11582_ _18728_/Q _11589_/B VDD VSS _18755_/D AND2X1
XFILLER_80_56 VSS VDD FILLER2
X_13321_ _19109_/Q _14387_/B VDD VSS _13437_/A NOR2BX1
XFILLER_127_105 VSS VDD FILLER2
X_10533_ _10556_/A _10556_/B _10533_/C VDD VSS _10579_/C AO21X2
XFILLER_155_414 VDD VSS DECAPHV8
XFILLER_10_475 VSS VDD FILLER2
XFILLER_127_138 VSS VDD FILLER2
X_16040_ _19584_/Q _16733_/B VDD VSS _16041_/B XOR2X1
X_13252_ _13443_/A _13443_/B _13443_/C VDD VSS _13356_/B AOI21X1
XFILLER_155_458 VSS VDD FILLER2
X_10464_ _10579_/D _10535_/B _10535_/C _10655_/A VDD VSS _10624_/C AOAI211X1
XFILLER_129_83 VDD VSS FILLER1
XFILLER_124_812 VSS VDD FILLER2
XFILLER_136_672 VSS VDD FILLER2
X_12203_ _19041_/Q _12203_/B _12203_/C VDD VSS _12513_/B MIN3X1
XFILLER_89_54 VSS VDD FILLER2
XFILLER_108_385 VDD VSS FILLER4
X_13183_ _13183_/A _14124_/B _13183_/C VDD VSS _13184_/B MIN3X1
X_10395_ _10581_/A _10395_/B VDD VSS _10499_/A _10395_/C _10395_/D NAND4X2
XFILLER_163_480 VSS VDD FILLER2
XFILLER_124_856 VDD VSS FILLER1
X_12134_ _19012_/Q _12134_/B _12134_/C VDD VSS _14244_/A MIN3X1
X_17991_ _18528_/Q _18527_/Q _18529_/Q _18530_/Q VDD VSS _18020_/B AND4X2
XFILLER_145_60 VSS VDD FILLER2
X_19730_ _19730_/CK _19730_/D _19730_/Q VDD VSS DFFQX1
X_16942_ _19744_/Q _17049_/B VDD VSS _16945_/A XNOR2X1
X_12065_ _12285_/A _12285_/B _12077_/C VDD VSS _14274_/B XNOR3X1
XFILLER_1_184 VSS VDD FILLER2
X_11016_ _10946_/Y _11015_/Y _10947_/Y VDD VSS _11016_/Y MUXI2X1
XFILLER_38_807 VSS VDD FILLER2
X_19661_ _19661_/CK _19661_/D _19661_/Q VDD VSS DFFQX1
X_16873_ _16876_/A _16873_/B VDD VSS _19710_/D NOR2X1
XFILLER_77_464 VDD VSS FILLER1
XFILLER_37_306 VDD VSS FILLER4
X_18612_ _18612_/CK _18612_/D _18612_/Q VDD VSS DFFQX1
XFILLER_77_486 VSS VDD FILLER2
XFILLER_49_177 VSS VDD FILLER2
X_15824_ _15830_/A _15824_/B VDD VSS _19439_/D NOR2X1
XFILLER_65_637 VDD VSS FILLER4
XFILLER_38_80 VDD VSS FILLER4
X_19592_ _19664_/CK _19592_/D _19592_/Q VDD VSS DFFQX1
XFILLER_18_531 VSS VDD FILLER2
XFILLER_161_81 VSS VDD FILLER2
X_18543_ _18543_/CK _18543_/D _18543_/Q VDD VSS DFFQX1
XFILLER_92_467 VDD VSS FILLER4
XFILLER_80_607 VSS VDD FILLER2
X_15755_ _15758_/A _15755_/B VDD VSS _19378_/D NOR2X1
X_12967_ _14538_/A _14538_/B _12967_/C VDD VSS _12968_/E AO21X2
XTAP_TAPCELL_ROW_9_95 VDD VSS WELLTAP
XFILLER_92_489 VSS VDD FILLER2
XTAP_TAPCELL_ROW_75_687 VDD VSS WELLTAP
X_14706_ _14739_/A _14739_/B _14739_/C VDD VSS _14708_/B AOI21X1
X_11918_ _11918_/A _11918_/B _11918_/C _11918_/D VDD VSS _14462_/C OA211X2
XTAP_TAPCELL_ROW_160_1456 VDD VSS WELLTAP
X_18474_ _18479_/CK _18511_/Q _20119_/A _18491_/RB VDD VSS DFFRQX1
X_15686_ _15706_/A _15686_/B VDD VSS _19315_/D AND2X1
X_12898_ _14286_/B _14286_/C _12899_/A VDD VSS _12900_/C OAI21X1
XFILLER_33_556 VSS VDD FILLER2
X_17425_ _17427_/C _17425_/B _17425_/C VDD VSS _19843_/D AOI21X1
XFILLER_21_707 VSS VDD FILLER2
X_14637_ _19441_/Q VDD VSS _14639_/A INVX1
X_11849_ _19146_/Q VDD VSS _11854_/A INVX1
XFILLER_21_729 VDD VSS DECAPHV8
XFILLER_14_770 VDD VSS FILLER1
XFILLER_159_742 VSS VDD FILLER2
XFILLER_60_397 VSS VDD FILLER2
X_17356_ _19828_/Q VDD VSS _17507_/B INVX1
X_14568_ _20007_/Q _14569_/B VDD VSS _19271_/D AND2X1
XFILLER_20_239 VSS VDD FILLER2
XFILLER_13_291 VSS VDD FILLER2
XFILLER_119_628 VSS VDD FILLER2
X_16307_ _16299_/A _16307_/B VDD VSS _16326_/B NAND2BX1
XFILLER_9_251 VSS VDD FILLER2
XFILLER_118_116 VSS VDD FILLER2
X_13519_ _14226_/A wire154/Y VDD VSS _13568_/B NOR2X1
X_17287_ _19814_/Q _19782_/Q VDD VSS _17289_/D XNOR2X1
X_14499_ _14491_/Y _14499_/B _14499_/C VDD VSS _19208_/D AND3BX1
Xclkload10 _19841_/CK VDD VSS clkload10/Y INVX1
X_19026_ _19119_/CK _19026_/D _19026_/Q VDD VSS DFFQX1
Xclkload21 _19956_/CK VDD VSS clkload21/Y INVX6
X_16238_ _19592_/Q _16742_/B VDD VSS _16239_/B XOR2X1
Xclkload32 clkload32/A VDD VSS clkload32/Y BUFX12
Xclkload43 _20007_/CK VDD VSS clkload43/Y INVX8
Xclkload54 _19200_/CK VDD VSS clkload54/Y BUFX12
Xclkbuf_leaf_19__000_ clkload72/A VDD VSS _19584_/CK BUFX12
Xclkload65 _18915_/CK VDD VSS clkload65/Y INVX1
Xclkload76 _19484_/CK VDD VSS clkload76/Y BUFX12
XFILLER_142_620 VDD VSS FILLER4
X_16169_ _16175_/B _16169_/B VDD VSS _16881_/B XNOR2X1
Xclkload87 _19385_/CK VDD VSS clkload87/Y BUFX12
XFILLER_154_480 VDD VSS FILLER4
Xclkload98 _19664_/CK VDD VSS clkload98/Y INVX2
XFILLER_48_0 VSS VDD FILLER2
XFILLER_88_729 VDD VSS FILLER4
XFILLER_102_528 VDD VSS FILLER1
X_19928_ clkload2/A _19928_/D _19928_/Q VDD VSS DFFQX1
XFILLER_114_399 VDD VSS DECAPHV16
X_19859_ _19895_/CK _19859_/D _19859_/Q VDD VSS DFFQX1
XFILLER_29_818 VSS VDD FILLER2
XFILLER_110_561 VSS VDD FILLER2
XFILLER_110_572 VSS VDD FILLER2
X_09612_ _18239_/Q _09818_/B _09612_/C _09626_/B _09612_/E VDD VSS _09618_/A AOI221X1
XFILLER_96_795 VDD VSS FILLER1
XFILLER_68_486 VSS VDD FILLER2
XFILLER_56_626 VDD VSS FILLER4
XTAP_TAPCELL_ROW_66_610 VDD VSS WELLTAP
XFILLER_55_114 VDD VSS FILLER4
XFILLER_28_328 VSS VDD FILLER2
XFILLER_83_445 VSS VDD FILLER2
XFILLER_37_840 VSS VDD FILLER2
X_09543_ _20037_/Q _09547_/B VDD VSS _20038_/D NOR2BX1
XFILLER_71_607 VSS VDD FILLER2
XTAP_TAPCELL_ROW_38_356 VDD VSS WELLTAP
XFILLER_71_629 VDD VSS FILLER1
XFILLER_52_821 VDD VSS FILLER4
X_09474_ _19976_/Q _09490_/B _09476_/C VDD VSS _09475_/C AOI21X1
XFILLER_34_16 VSS VDD FILLER2
XFILLER_51_320 VDD VSS FILLER1
XFILLER_24_534 VDD VSS DECAPHV8
XFILLER_24_556 VSS VDD FILLER2
XFILLER_34_49 VDD VSS FILLER4
XFILLER_12_718 VDD VSS DECAPHV16
XFILLER_51_375 VSS VDD FILLER2
XTAP_TAPCELL_ROW_21_201 VDD VSS WELLTAP
XFILLER_149_230 VDD VSS DECAPHV8
XFILLER_133_8 VSS VDD FILLER2
XFILLER_149_252 VSS VDD FILLER2
Xclkload4 clkload4/A VDD VSS clkload4/Y INVX1
XFILLER_20_751 VSS VDD FILLER2
XFILLER_109_116 VSS VDD FILLER2
XFILLER_166_48 VDD VSS DECAPHV8
XFILLER_164_255 VDD VSS FILLER1
XFILLER_106_801 VSS VDD FILLER2
XFILLER_152_406 VSS VDD FILLER2
XFILLER_118_694 VSS VDD FILLER2
XFILLER_133_631 VSS VDD FILLER2
XFILLER_3_438 VSS VDD FILLER2
XFILLER_117_182 VDD VSS FILLER4
XFILLER_145_491 VDD VSS FILLER4
XFILLER_133_642 VSS VDD FILLER2
X_10180_ _10180_/A _11421_/C VDD VSS _18543_/D NOR2X1
XFILLER_78_206 VDD VSS FILLER4
XFILLER_120_303 VSS VDD FILLER2
XFILLER_105_388 VSS VDD FILLER2
XFILLER_115_30 VDD VSS FILLER4
XFILLER_59_453 VSS VDD FILLER2
XFILLER_59_464 VDD VSS FILLER1
XFILLER_101_561 VDD VSS FILLER4
XFILLER_115_96 VSS VDD FILLER2
XFILLER_59_497 VSS VDD FILLER2
X_13870_ _14131_/B _14131_/C _18890_/Q VDD VSS _13872_/C AOI21X1
XFILLER_74_445 VDD VSS DECAPHV8
X_12821_ _12821_/A _12821_/B _12821_/C _12821_/D VDD VSS _13017_/A OAOI211X1
XFILLER_74_467 VSS VDD FILLER2
XFILLER_62_607 VSS VDD FILLER2
XFILLER_55_670 VDD VSS DECAPHV8
X_15540_ _15540_/A _15757_/B VDD VSS _15541_/D OR2X2
X_12752_ _14508_/B _12841_/C _19215_/Q VDD VSS _12827_/C AND3BX1
XFILLER_55_692 VDD VSS DECAPHV8
XTAP_TAPCELL_ROW_72_657 VDD VSS WELLTAP
XFILLER_15_556 VSS VDD FILLER2
X_11703_ _19988_/Q _19252_/Q VDD VSS _11706_/B NOR2X1
X_15471_ _15471_/A _15471_/B _15883_/B VDD VSS _15512_/B MIN3X1
X_12683_ _12683_/A _14472_/B _12683_/C _12683_/D VDD VSS _12827_/B AOAI211X1
XFILLER_91_77 VSS VDD FILLER2
X_17210_ _17212_/C _17211_/B _17229_/C VDD VSS _17211_/C OAI21X1
X_14422_ _14421_/Y _14422_/B _14422_/C VDD VSS _19140_/D AND3BX1
XFILLER_70_695 VSS VDD FILLER2
XFILLER_42_386 VSS VDD FILLER2
X_11634_ _18776_/Q _11635_/B VDD VSS _18803_/D AND2X1
X_18190_ _18190_/A VDD VSS _18191_/B INVX1
XFILLER_156_712 VSS VDD FILLER2
X_17141_ _17142_/C _17469_/B _17141_/C VDD VSS _19782_/D AND3BX1
X_14353_ _14316_/Y _14353_/B _14353_/C VDD VSS _19079_/D AND3BX1
X_11565_ _18713_/Q _11567_/B VDD VSS _18740_/D AND2X1
XFILLER_11_784 VSS VDD FILLER2
XFILLER_128_436 VSS VDD FILLER2
X_13304_ _13391_/A _13391_/B _13391_/C VDD VSS _13377_/B AOI21X1
X_17072_ _19768_/Q _17073_/B VDD VSS _17075_/A XNOR2X1
X_10516_ _10570_/A _10516_/B VDD VSS _10518_/B XNOR2X1
XFILLER_156_767 VSS VDD FILLER2
XFILLER_109_650 VDD VSS FILLER1
X_14284_ _14255_/Y _14284_/B _14284_/C VDD VSS _19018_/D AND3BX1
X_11496_ _18651_/Q _11496_/B VDD VSS _18678_/D AND2X1
XFILLER_7_777 VSS VDD FILLER2
XFILLER_156_789 VDD VSS FILLER1
XFILLER_6_265 VSS VDD FILLER2
X_16023_ _19708_/Q _16871_/B _16023_/C VDD VSS _16024_/C MIN3X1
X_13235_ _13355_/A _14448_/B VDD VSS _13354_/A NOR2X1
XFILLER_40_70 VSS VDD FILLER2
X_10447_ _10448_/A _10448_/B _10448_/D _10448_/C VDD VSS _10530_/B AOAI211X1
XFILLER_6_287 VDD VSS FILLER4
XFILLER_6_298 VDD VSS FILLER4
XFILLER_123_130 VSS VDD FILLER2
X_13166_ _19024_/Q _13201_/B _13208_/C VDD VSS _13195_/B XNOR3X1
X_10378_ _18660_/Q _18768_/Q VDD VSS _10406_/C NOR2X1
XFILLER_124_675 VSS VDD FILLER2
XFILLER_69_217 VDD VSS FILLER4
X_12117_ _19152_/Q _12214_/A wire161/Y VDD VSS _12147_/D XNOR3X1
X_17974_ _17975_/B _17975_/C _17975_/A VDD VSS _17976_/C OAI21X1
X_13097_ _13097_/A _13097_/B _13097_/C _13097_/D VDD VSS _13373_/A OAOI211X2
X_19713_ _19730_/CK _19713_/D _19713_/Q VDD VSS DFFQX1
XFILLER_27_5 VSS VDD FILLER2
X_16925_ _16928_/A _16928_/B _17081_/C VDD VSS _16926_/C OAI21X1
X_12048_ _12048_/A _12048_/B _12048_/C _12048_/D VDD VSS _14494_/B AOAI211X1
XFILLER_78_762 VDD VSS FILLER4
XFILLER_65_412 VSS VDD FILLER2
XFILLER_38_637 VDD VSS DECAPHV16
X_19644_ _19702_/CK _19644_/D _19644_/Q VDD VSS DFFQX1
XFILLER_93_732 VSS VDD FILLER2
X_16856_ _16859_/A _16856_/B VDD VSS _19695_/D AND2X1
XFILLER_93_743 VDD VSS FILLER1
XFILLER_37_125 VSS VDD FILLER2
XFILLER_38_659 VDD VSS FILLER1
XFILLER_19_840 VSS VDD FILLER2
X_15807_ _15816_/A _15807_/B VDD VSS _19424_/D NOR2X1
X_19575_ _19737_/CK _19575_/D _19575_/Q VDD VSS DFFQX1
XFILLER_93_787 VSS VDD FILLER2
X_16787_ _16794_/A _16787_/B VDD VSS _19633_/D NOR2X1
XFILLER_53_629 VSS VDD FILLER2
X_13999_ _14232_/B _14232_/C _18977_/Q VDD VSS _14001_/C AOI21X1
X_18526_ _18526_/CK _18526_/D _18526_/Q _09295_/Y VDD VSS DFFRQX1
X_15738_ _15743_/A _15738_/B VDD VSS _19363_/D AND2X1
XTAP_TAPCELL_ROW_35_326 VDD VSS WELLTAP
XFILLER_18_394 VSS VDD FILLER2
X_18457_ _18469_/CK _18457_/D _18457_/Q _20075_/RB VDD VSS DFFRQX1
XFILLER_33_364 VDD VSS DECAPHV8
X_15669_ _15672_/A _18190_/A VDD VSS _19303_/D NOR2X1
XFILLER_33_375 VDD VSS FILLER4
X_17408_ _19839_/Q _19807_/Q _17408_/C VDD VSS _17413_/C AOI21X1
XFILLER_60_183 VSS VDD FILLER2
X_09190_ _18470_/D VDD VSS _18454_/D INVX1
X_18388_ _18389_/CK _18521_/Q _20193_/A _18442_/RB VDD VSS DFFRQX1
XFILLER_60_194 VDD VSS FILLER1
XFILLER_159_561 VSS VDD FILLER2
X_17339_ _19825_/Q _19793_/Q VDD VSS _17346_/C NOR2X1
XFILLER_119_436 VDD VSS FILLER1
XFILLER_146_244 VSS VDD FILLER2
Xclkload110 _18220_/CK VDD VSS clkload110/Y INVX1
Xclkload121 _18406_/CK VDD VSS clkload121/Y INVX2
XFILLER_134_417 VDD VSS FILLER1
XFILLER_134_428 VSS VDD FILLER2
X_19009_ _19037_/CK _19009_/D _19009_/Q VDD VSS DFFQX1
XFILLER_162_737 VDD VSS FILLER1
XFILLER_115_620 VSS VDD FILLER2
XFILLER_136_18 VSS VDD FILLER2
XFILLER_161_247 VSS VDD FILLER2
XFILLER_0_408 VSS VDD FILLER2
XFILLER_115_686 VSS VDD FILLER2
XFILLER_115_697 VSS VDD FILLER2
XFILLER_130_645 VDD VSS FILLER1
XFILLER_69_740 VDD VSS FILLER4
XFILLER_130_667 VDD VSS FILLER1
XFILLER_102_369 VDD VSS FILLER1
XFILLER_69_773 VSS VDD FILLER2
XFILLER_68_261 VSS VDD FILLER2
XFILLER_28_103 VDD VSS FILLER4
XFILLER_68_283 VDD VSS FILLER1
XFILLER_83_231 VDD VSS FILLER1
XFILLER_56_445 VSS VDD FILLER2
XFILLER_84_776 VDD VSS FILLER4
XFILLER_56_467 VSS VDD FILLER2
XFILLER_44_607 VDD VSS DECAPHV8
XTAP_TAPCELL_ROW_126_1148 VDD VSS WELLTAP
XFILLER_83_264 VDD VSS FILLER4
XFILLER_43_106 VSS VDD FILLER2
X_09526_ _20021_/Q _09526_/B _20022_/Q VDD VSS _09527_/C AOI21X1
X_09457_ _19968_/Q _09467_/B _09476_/C VDD VSS _09458_/C AOI21X1
XFILLER_12_526 VSS VDD FILLER2
XFILLER_52_695 VSS VDD FILLER2
XFILLER_40_835 VSS VDD FILLER2
XFILLER_12_537 VDD VSS DECAPHV16
XFILLER_157_509 VDD VSS FILLER4
X_09388_ _19930_/Q _19931_/Q _19933_/Q VDD VSS _09389_/C OR3X2
XFILLER_8_519 VSS VDD FILLER2
XFILLER_124_4 VSS VDD FILLER2
XTAP_TAPCELL_ROW_137_1244 VDD VSS WELLTAP
XFILLER_137_244 VSS VDD FILLER2
X_11350_ _11357_/A _11358_/B VDD VSS _11355_/B XNOR2X1
XFILLER_20_592 VSS VDD FILLER2
XFILLER_138_789 VDD VSS FILLER1
XFILLER_137_277 VSS VDD FILLER2
X_10301_ _10314_/C _11430_/B VDD VSS _10304_/B NOR2X1
XFILLER_153_737 VDD VSS FILLER1
XFILLER_3_202 VSS VDD FILLER2
XFILLER_118_480 VDD VSS FILLER4
X_11281_ _18582_/Q _11284_/B VDD VSS _11285_/B XNOR2X1
XFILLER_3_224 VSS VDD FILLER2
X_13020_ _13020_/A _14352_/B _14352_/C VDD VSS _13021_/D NOR3X1
XFILLER_105_130 VDD VSS FILLER4
X_10232_ _10167_/Y _10231_/Y _10224_/A VDD VSS _10233_/B MUXI2X1
XFILLER_140_409 VSS VDD FILLER2
XFILLER_106_675 VSS VDD FILLER2
XFILLER_10_73 VSS VDD FILLER2
XFILLER_79_526 VSS VDD FILLER2
Xclkbuf_regs_0_clk delaybuf_8_clk/Y VDD VSS clkbuf_regs_0_clk/Y BUFX12
XFILLER_10_95 VSS VDD FILLER2
X_10163_ _18589_/Q _18590_/Q VDD VSS _10203_/B _10163_/C NAND3X1
XFILLER_126_73 VSS VDD FILLER2
XFILLER_86_44 VSS VDD FILLER2
XTAP_TAPCELL_ROW_77_705 VDD VSS WELLTAP
XFILLER_86_55 VDD VSS DECAPHV16
XFILLER_121_689 VDD VSS FILLER1
X_14971_ _19506_/Q _15900_/B VDD VSS _15013_/B NAND2BX1
X_10094_ _09993_/B _10182_/B _10131_/A VDD VSS _10101_/B MUXI2X1
XFILLER_59_272 VSS VDD FILLER2
X_16710_ _16710_/A _16724_/B VDD VSS _19563_/D NOR2X1
X_13922_ _14001_/B _13923_/C _18948_/Q VDD VSS _13924_/C AOI21X1
X_17690_ _17692_/B _17690_/B VDD VSS _17691_/B XOR2X1
XFILLER_74_242 VSS VDD FILLER2
X_16641_ _16643_/A _16643_/B _16643_/C _16641_/D VDD VSS _19543_/D OAOI211X1
XFILLER_35_618 VDD VSS FILLER4
XFILLER_142_83 VSS VDD FILLER2
X_13853_ _19115_/Q VDD VSS _13854_/A INVX1
XTAP_TAPCELL_ROW_85_782 VDD VSS WELLTAP
XFILLER_34_128 VSS VDD FILLER2
X_19360_ _19412_/CK _19360_/D _19360_/Q VDD VSS DFFQX1
X_12804_ _12804_/A _12804_/B _12804_/C _12804_/D VDD VSS _14348_/B AOAI211X1
X_16572_ _19604_/Q _16572_/B _16755_/B VDD VSS _16578_/A MIN3X1
Xclkbuf_leaf_18__001_ clkload33/A VDD VSS _18934_/CK BUFX12
X_13784_ _13857_/A _13784_/B VDD VSS _14362_/B XNOR2X1
X_10996_ _10996_/A _10996_/B _11263_/A VDD VSS _11020_/A AOI21X1
XFILLER_90_779 VSS VDD FILLER2
X_18311_ _18311_/CK _18471_/D _18311_/Q _18471_/RB VDD VSS DFFRQX1
X_15523_ _15545_/A _15545_/B VDD VSS _15789_/B XNOR2X1
X_19291_ _19306_/CK _19291_/D _19291_/Q VDD VSS DFFQX1
X_12735_ _12821_/A _12821_/B VDD VSS _12776_/B NOR2X1
XFILLER_15_375 VSS VDD FILLER2
XFILLER_96_8 VDD VSS FILLER1
XFILLER_31_835 VSS VDD FILLER2
XTAP_TAPCELL_ROW_6_63 VDD VSS WELLTAP
XFILLER_148_509 VSS VDD FILLER2
X_18242_ _18256_/CK _18242_/D _18275_/D _20080_/RB VDD VSS DFFRQX1
XFILLER_30_323 VSS VDD FILLER2
X_15454_ _15464_/A _15464_/B VDD VSS _15724_/B XNOR2X1
X_12666_ _12666_/A _12678_/C VDD VSS _14536_/B XNOR2X1
X_14405_ _14426_/A _14405_/B VDD VSS _19126_/D NOR2X1
X_11617_ _18760_/Q _11624_/B VDD VSS _18787_/D AND2X1
XFILLER_128_211 VSS VDD FILLER2
X_18173_ _18173_/A _18173_/B VDD VSS _20008_/D NOR2X1
X_15385_ _19320_/Q _15385_/B _15385_/C VDD VSS _15419_/A MIN3X1
X_12597_ _19046_/Q _12597_/B _12803_/D VDD VSS _12632_/C XNOR3X1
XTAP_TAPCELL_ROW_40_373 VDD VSS WELLTAP
XFILLER_7_530 VDD VSS FILLER1
X_17124_ _19779_/Q _19747_/Q VDD VSS _17126_/B XOR2X1
XFILLER_156_553 VDD VSS FILLER4
X_14336_ _14339_/A _14336_/B VDD VSS _19064_/D NOR2X1
X_11548_ _18697_/Q _11555_/B VDD VSS _18724_/D AND2X1
XFILLER_51_91 VSS VDD FILLER2
XFILLER_144_748 VDD VSS FILLER1
X_17055_ _17064_/C _17059_/C VDD VSS _17056_/B XOR2X1
X_14267_ _14285_/A _14267_/B VDD VSS _19005_/D NOR2X1
X_11479_ _18635_/Q _11484_/B VDD VSS _18662_/D AND2X1
X_16006_ _19711_/Q _16874_/B VDD VSS _16028_/C NOR2X1
X_13218_ _19108_/Q VDD VSS _13219_/A INVX1
XFILLER_98_802 VSS VDD FILLER2
XTAP_TAPCELL_ROW_114_1041 VDD VSS WELLTAP
XFILLER_124_450 VSS VDD FILLER2
X_14198_ _14219_/A _14198_/B _14198_/C VDD VSS _18948_/D NOR3X1
XFILLER_112_601 VSS VDD FILLER2
XFILLER_124_461 VDD VSS DECAPHV8
XFILLER_152_781 VDD VSS DECAPHV8
XFILLER_124_483 VDD VSS DECAPHV8
X_13149_ _20010_/Q _19274_/Q VDD VSS _13150_/C NOR2X1
XFILLER_112_656 VDD VSS FILLER1
XFILLER_85_507 VSS VDD FILLER2
X_17957_ _17957_/A _17957_/B _17957_/C VDD VSS _17958_/D NOR3X1
XFILLER_111_166 VSS VDD FILLER2
XFILLER_78_581 VDD VSS FILLER1
X_16908_ _16907_/Y _20015_/Q _16908_/C VDD VSS _16909_/C AND3BX1
XFILLER_65_220 VSS VDD FILLER2
X_17888_ _17891_/C _17888_/B _17888_/C VDD VSS _19945_/D AOI21X1
XFILLER_26_607 VDD VSS FILLER4
X_19627_ _19661_/CK _19627_/D _19627_/Q VDD VSS DFFQX1
X_16839_ _17391_/A VDD VSS _16865_/A BUFX3
XFILLER_93_584 VDD VSS DECAPHV8
XFILLER_81_724 VSS VDD FILLER2
XFILLER_53_415 VSS VDD FILLER2
XFILLER_25_106 VSS VDD FILLER2
XFILLER_65_286 VSS VDD FILLER2
XFILLER_80_223 VSS VDD FILLER2
X_19558_ _19600_/CK _19558_/D _19558_/Q VDD VSS DFFQX1
XFILLER_81_757 VSS VDD FILLER2
X_09311_ _18293_/Q _18521_/Q _09299_/Y VDD VSS _09311_/Y MUXI2X1
XFILLER_15_18 VSS VDD FILLER2
X_18509_ _18509_/CK _18509_/D _18509_/Q _09349_/Y VDD VSS DFFRQX1
XFILLER_34_662 VSS VDD FILLER2
X_19489_ _19736_/CK _19489_/D _19489_/Q VDD VSS DFFQX1
XFILLER_80_289 VSS VDD FILLER2
XFILLER_22_824 VDD VSS FILLER4
XFILLER_61_470 VDD VSS FILLER1
XFILLER_34_684 VDD VSS FILLER4
XFILLER_34_695 VSS VDD FILLER2
X_09242_ _18471_/D VDD VSS _18343_/D INVX1
XFILLER_139_509 VSS VDD FILLER2
XFILLER_21_367 VDD VSS FILLER4
XFILLER_31_28 VDD VSS FILLER1
XFILLER_119_255 VSS VDD FILLER2
XFILLER_162_501 VSS VDD FILLER2
XFILLER_107_417 VSS VDD FILLER2
Xoutput17 _20086_/Y VDD VSS o_aux_ctrl[4] BUFX3
XFILLER_134_269 VSS VDD FILLER2
Xoutput28 _20112_/Y VDD VSS o_bias_cfg[14] BUFX3
XFILLER_162_578 VDD VSS FILLER1
XFILLER_1_706 VDD VSS FILLER4
Xoutput39 _20122_/Y VDD VSS o_bias_cfg[24] BUFX3
XFILLER_89_835 VSS VDD FILLER2
XFILLER_88_323 VSS VDD FILLER2
XFILLER_0_238 VSS VDD FILLER2
X_20195_ _20195_/A VDD VSS _20195_/Y BUFX3
XFILLER_103_656 VDD VSS FILLER1
XFILLER_88_356 VSS VDD FILLER2
XFILLER_130_464 VDD VSS FILLER4
XFILLER_102_166 VSS VDD FILLER2
XFILLER_130_475 VSS VDD FILLER2
XFILLER_88_389 VSS VDD FILLER2
XFILLER_69_570 VDD VSS FILLER4
XFILLER_102_188 VDD VSS FILLER1
XFILLER_56_36 VSS VDD FILLER2
XFILLER_29_445 VSS VDD FILLER2
XFILLER_84_562 VSS VDD FILLER2
XFILLER_16_106 VDD VSS FILLER4
XFILLER_84_595 VSS VDD FILLER2
XFILLER_71_212 VSS VDD FILLER2
XFILLER_44_426 VSS VDD FILLER2
XFILLER_112_42 VDD VSS FILLER4
X_10850_ _10885_/A _10851_/D _10851_/A _10851_/B VDD VSS _10852_/B OA211X2
XFILLER_72_757 VSS VDD FILLER2
XFILLER_112_53 VSS VDD FILLER2
XTAP_TAPCELL_ROW_82_752 VDD VSS WELLTAP
X_09509_ _20071_/Q _20070_/Q _20015_/Q VDD VSS _09510_/C OAI21X1
X_10781_ _10814_/A _10784_/B VDD VSS _10782_/B NOR2X1
XFILLER_13_835 VSS VDD FILLER2
X_12520_ _12540_/A _12540_/B _12540_/D _12540_/C VDD VSS _12600_/C OAI211X1
XTAP_TAPCELL_ROW_54_498 VDD VSS WELLTAP
XFILLER_12_323 VSS VDD FILLER2
XFILLER_24_183 VSS VDD FILLER2
XFILLER_9_817 VSS VDD FILLER2
XFILLER_157_328 VSS VDD FILLER2
X_12451_ _19070_/Q _12451_/B VDD VSS _12452_/C _12451_/C NAND3X1
XFILLER_8_338 VSS VDD FILLER2
X_11402_ _11429_/B VDD VSS _17990_/B BUFX3
X_15170_ _15672_/A _18102_/B VDD VSS _19287_/D NOR2X1
X_12382_ _12382_/A _12382_/B _12382_/C _12382_/D VDD VSS _12472_/A AOAI211X1
X_14121_ _14142_/A _14121_/B VDD VSS _18880_/D NOR2X1
XFILLER_115_0 VDD VSS FILLER4
X_11333_ _11333_/A _11333_/B _11333_/C VDD VSS _11334_/B OAI21X1
XFILLER_21_72 VSS VDD FILLER2
XFILLER_125_247 VDD VSS FILLER1
XFILLER_141_707 VDD VSS FILLER1
XFILLER_153_567 VDD VSS FILLER1
X_14052_ _14101_/A _17959_/B _17960_/C VDD VSS _17963_/C OR3BX1
XFILLER_4_555 VSS VDD FILLER2
X_11264_ _11264_/A _11264_/B _11264_/C VDD VSS _11276_/A NOR3X1
XFILLER_141_729 VSS VDD FILLER2
X_13003_ _18994_/Q _14256_/B VDD VSS _13004_/D _14256_/C NAND3X1
X_10215_ _18620_/Q _10219_/B VDD VSS _10217_/D XNOR2X1
X_18860_ _18915_/CK _18860_/D _18860_/Q VDD VSS DFFQX1
X_11195_ _11195_/A _11195_/B VDD VSS _11209_/A NAND2X1
XFILLER_97_87 VDD VSS FILLER4
X_17811_ _18132_/A _17811_/B _17813_/C VDD VSS _19926_/D NOR3X1
XFILLER_97_98 VDD VSS FILLER1
XFILLER_121_464 VDD VSS FILLER1
X_10146_ _10166_/D _10146_/B _10146_/C VDD VSS _10146_/Y AOI21X1
X_18791_ _18818_/CK _18791_/D _18791_/Q VDD VSS DFFQX1
XFILLER_79_389 VSS VDD FILLER2
XFILLER_48_732 VSS VDD FILLER2
X_17742_ _17745_/C _17742_/B VDD VSS _17743_/B XNOR2X1
XFILLER_153_82 VSS VDD FILLER2
X_14954_ _14954_/A _14954_/B _15742_/B VDD VSS _14992_/B MIN3X1
X_10077_ _18010_/A VDD VSS _17812_/A BUFX3
XFILLER_75_551 VDD VSS FILLER4
XFILLER_48_765 VSS VDD FILLER2
X_13905_ _19088_/Q _14364_/B VDD VSS _13907_/A NOR2X1
X_17673_ _19895_/Q _19863_/Q _17673_/C VDD VSS _17678_/B MIN3X1
X_14885_ _19449_/Q _14885_/B _14920_/C VDD VSS _14909_/B XNOR3X1
XFILLER_75_595 VDD VSS FILLER1
X_19412_ _19412_/CK _19412_/D _19412_/Q VDD VSS DFFQX1
X_16624_ _19606_/Q _16757_/B VDD VSS _16631_/A NOR2X1
X_13836_ _13921_/A _13921_/B _13921_/D VDD VSS _13865_/B OAI21X1
XTAP_TAPCELL_ROW_45_421 VDD VSS WELLTAP
XFILLER_16_640 VDD VSS FILLER1
X_19343_ _19573_/CK _19343_/D _19343_/Q VDD VSS DFFQX1
XFILLER_16_662 VSS VDD FILLER2
X_16555_ _19636_/Q _16790_/B VDD VSS _16556_/B XNOR2X1
XFILLER_90_587 VDD VSS FILLER1
XFILLER_22_109 VDD VSS FILLER1
X_13767_ _19002_/Q _13889_/A _13889_/B VDD VSS _13768_/D XNOR3X1
X_10979_ _18703_/Q _18757_/Q VDD VSS _10980_/B XOR2X1
XTAP_TAPCELL_ROW_17_167 VDD VSS WELLTAP
XFILLER_149_818 VDD VSS FILLER1
X_15506_ _15541_/A _15541_/B VDD VSS _15528_/A NAND2X1
X_19274_ _20004_/CK _19274_/D _19274_/Q VDD VSS DFFQX1
X_12718_ _12731_/A _12731_/B _12731_/C VDD VSS _14317_/B OAI21X1
X_16486_ _16492_/B _16486_/B VDD VSS _16894_/B XOR2X1
XFILLER_31_654 VSS VDD FILLER2
X_13698_ _19084_/Q _14360_/B VDD VSS _13699_/D _14360_/C NAND3X1
X_09960__231 _20054_/CK VDD VSS _18507_/CK INVX1
XFILLER_31_665 VDD VSS FILLER1
XFILLER_148_328 VSS VDD FILLER2
XFILLER_30_142 VDD VSS FILLER4
X_18225_ _18226_/CK _18225_/E _18225_/ECK VDD VSS CGX3
XTAP_TAPCELL_ROW_157_1428 VDD VSS WELLTAP
XFILLER_30_153 VSS VDD FILLER2
X_15437_ _19544_/Q _15475_/B VDD VSS _15912_/B XNOR2X1
X_12649_ _19186_/Q _12649_/B _12663_/C VDD VSS _12771_/B XNOR3X1
XFILLER_157_840 VSS VDD FILLER2
XFILLER_30_186 VSS VDD FILLER2
XFILLER_117_704 VSS VDD FILLER2
X_18156_ _18162_/A _18159_/B VDD VSS _18157_/B NOR2X1
X_15368_ _19432_/Q _15816_/B VDD VSS _15369_/B XNOR2X1
XFILLER_7_52 VSS VDD FILLER2
XFILLER_156_361 VSS VDD FILLER2
X_17107_ _17105_/B _17107_/B VDD VSS _17108_/C NOR2BX1
X_14319_ _14352_/A _14319_/B _14319_/C VDD VSS _19049_/D NOR3X1
XFILLER_156_394 VDD VSS FILLER4
X_18087_ _18090_/A _18090_/B _18090_/C _18087_/D VDD VSS _18088_/D AOAI211X1
XFILLER_7_96 VSS VDD FILLER2
X_15299_ _15294_/A _15299_/B VDD VSS _15300_/C NOR2BX1
XFILLER_7_393 VSS VDD FILLER2
XFILLER_132_718 VSS VDD FILLER2
XFILLER_144_578 VDD VSS DECAPHV8
X_17038_ _17095_/A _17038_/B VDD VSS _19761_/D NOR2X1
XFILLER_131_217 VDD VSS FILLER4
XFILLER_98_621 VSS VDD FILLER2
X_09860_ _09857_/Y _09901_/B _11229_/A VDD VSS _09861_/B MUXI2X1
Xclkbuf_1_1__f__09183_ clkbuf_0__09183_/Y VDD VSS _18550_/CK BUFX12
XFILLER_140_751 VSS VDD FILLER2
XFILLER_30_0 VSS VDD FILLER2
XFILLER_97_153 VSS VDD FILLER2
XFILLER_58_518 VSS VDD FILLER2
X_09791_ _09816_/D _09791_/B _09791_/C _09791_/D VDD VSS _18293_/D OAI211X1
X_18989_ _19025_/CK _18989_/D _18989_/Q VDD VSS DFFQX1
XTAP_TAPCELL_ROW_96_877 VDD VSS WELLTAP
XFILLER_54_724 VDD VSS FILLER1
XFILLER_39_798 VSS VDD FILLER2
XFILLER_53_212 VSS VDD FILLER2
XTAP_TAPCELL_ROW_108_989 VDD VSS WELLTAP
XTAP_TAPCELL_ROW_123_1118 VDD VSS WELLTAP
XFILLER_53_267 VDD VSS FILLER4
XFILLER_41_407 VSS VDD FILLER2
XFILLER_81_598 VSS VDD FILLER2
X_09225_ _18501_/D VDD VSS _18373_/D INVX1
XTAP_TAPCELL_ROW_51_468 VDD VSS WELLTAP
XFILLER_42_49 VDD VSS DECAPHV8
XFILLER_158_49 VSS VDD FILLER2
XFILLER_147_350 VSS VDD FILLER2
XFILLER_108_748 VSS VDD FILLER2
XFILLER_108_759 VDD VSS FILLER1
XFILLER_116_770 VSS VDD FILLER2
XFILLER_107_20 VSS VDD FILLER2
Xclkbuf_leaf_17__002_ clkload16/A VDD VSS _19954_/CK BUFX12
XFILLER_89_654 VSS VDD FILLER2
XFILLER_1_547 VSS VDD FILLER2
X_10000_ _18579_/Q _10013_/B VDD VSS _10000_/Y XOR2X1
XFILLER_88_142 VDD VSS FILLER4
XTAP_TAPCELL_ROW_87_800 VDD VSS WELLTAP
XFILLER_130_261 VSS VDD FILLER2
X_20178_ _20178_/A VDD VSS _20178_/Y BUFX3
X_09989_ _10034_/A _09989_/B VDD VSS _09990_/C NAND2X1
XFILLER_67_57 VSS VDD FILLER2
XFILLER_130_272 VSS VDD FILLER2
XFILLER_67_79 VDD VSS FILLER4
XTAP_TAPCELL_ROW_59_546 VDD VSS WELLTAP
XFILLER_92_819 VSS VDD FILLER2
XTAP_TAPCELL_ROW_145_1321 VDD VSS WELLTAP
XFILLER_91_318 VSS VDD FILLER2
XFILLER_123_63 VSS VDD FILLER2
X_11951_ _19036_/Q VDD VSS _11954_/A INVX1
XFILLER_72_510 VDD VSS FILLER1
XFILLER_123_96 VSS VDD FILLER2
X_10902_ _10936_/C _10902_/B _10902_/C VDD VSS _10909_/C OAI21X1
X_14670_ _19444_/Q VDD VSS _14733_/A INVX1
X_11882_ _14525_/B _14525_/C _19231_/Q VDD VSS _11884_/C AOI21X1
X_13621_ _19112_/Q _13721_/A _13721_/B VDD VSS _13623_/C XNOR3X1
X_10833_ _18644_/Q _18806_/Q VDD VSS _10866_/A NAND2X1
XFILLER_60_738 VSS VDD FILLER2
XFILLER_13_621 VSS VDD FILLER2
XFILLER_16_83 VDD VSS FILLER1
X_16340_ _19563_/Q _16710_/A _16340_/C VDD VSS _16368_/B MIN3X1
XFILLER_25_492 VSS VDD FILLER2
X_13552_ _19196_/Q VDD VSS _13634_/A INVX1
X_10764_ _18696_/Q _18750_/Q VDD VSS _10765_/D NAND2X1
XTAP_TAPCELL_ROW_14_137 VDD VSS WELLTAP
XFILLER_13_654 VSS VDD FILLER2
XFILLER_12_142 VSS VDD FILLER2
XFILLER_158_626 VSS VDD FILLER2
XFILLER_158_637 VDD VSS FILLER1
X_12503_ _19185_/Q _12503_/B _12566_/C VDD VSS _14440_/C XNOR3X1
XFILLER_13_687 VSS VDD FILLER2
X_16271_ _19721_/Q _16885_/B VDD VSS _16274_/B XNOR2X1
X_13483_ _18915_/Q _13656_/A _13498_/B VDD VSS _13578_/D XNOR3X1
XFILLER_139_840 VDD VSS FILLER4
X_10695_ _10965_/A _18722_/Q _10803_/A _10695_/D _10695_/E VDD VSS _10696_/D AOI221X1
X_18010_ _18010_/A _18054_/A VDD VSS _18011_/A OR2X2
XFILLER_12_197 VDD VSS FILLER4
X_15222_ _19400_/Q _15779_/A VDD VSS _15223_/C NAND2X1
X_12434_ _18905_/Q VDD VSS _12533_/A INVX1
XFILLER_8_146 VDD VSS FILLER1
XFILLER_138_361 VDD VSS FILLER1
XTAP_TAPCELL_ROW_3_42 VDD VSS WELLTAP
XFILLER_126_523 VSS VDD FILLER2
X_15153_ _19509_/Q _15903_/B VDD VSS _15155_/C NOR2BX1
X_12365_ _12421_/A _14344_/B VDD VSS _12517_/A OR2X2
XFILLER_154_854 VSS VDD FILLER2
XFILLER_59_8 VDD VSS FILLER4
X_14104_ _14104_/A _14104_/B _14104_/C VDD VSS _14142_/B OA21X2
X_11316_ _11316_/A _11316_/B _11316_/C VDD VSS _11333_/A OAI21X1
X_15084_ _19426_/Q VDD VSS _15138_/A INVX1
X_19961_ _19963_/CK _19961_/D _19961_/Q VDD VSS DFFQX1
XFILLER_153_375 VSS VDD FILLER2
X_12296_ _19126_/Q _12471_/A _12471_/B VDD VSS _12298_/C XNOR3X1
X_18912_ _18939_/CK _18912_/D _18912_/Q VDD VSS DFFQX1
X_14035_ _18979_/Q _14043_/A _14043_/B VDD VSS _14036_/D XNOR3X1
XTAP_TAPCELL_ROW_111_1011 VDD VSS WELLTAP
X_11247_ _11247_/A _11264_/B VDD VSS _11252_/B XNOR2X1
X_19892_ clkload2/A _19892_/D _19892_/Q VDD VSS DFFQX1
XFILLER_79_131 VDD VSS FILLER4
XFILLER_68_816 VSS VDD FILLER2
XFILLER_121_250 VSS VDD FILLER2
X_18843_ _18845_/CK _18843_/D _18843_/Q VDD VSS DFFQX1
XFILLER_95_613 VDD VSS FILLER4
X_11178_ _11196_/A _18736_/Q _11178_/C _11178_/D _11178_/E VDD VSS _11179_/B AOI221X1
XFILLER_68_838 VSS VDD FILLER2
XFILLER_94_101 VSS VDD FILLER2
X_10129_ _10190_/B _10129_/B _10175_/B _10166_/D VDD VSS _10130_/C AOI211X1
X_18774_ _18801_/CK _18774_/D _18774_/Q VDD VSS DFFQX1
X_15986_ _16012_/A _15986_/B _16013_/A VDD VSS _16010_/B MIN3X1
XFILLER_94_167 VSS VDD FILLER2
X_17725_ _19908_/Q _19876_/Q VDD VSS _17730_/A XNOR2X1
X_14937_ _19422_/Q _15805_/B VDD VSS _14956_/D _15805_/C NAND3X1
XFILLER_75_370 VSS VDD FILLER2
XFILLER_63_521 VDD VSS DECAPHV8
XTAP_TAPCELL_ROW_93_847 VDD VSS WELLTAP
XTAP_TAPCELL_ROW_163_1476 VDD VSS WELLTAP
X_17656_ _19892_/Q VDD VSS _17803_/B INVX1
X_14868_ _14918_/A _14918_/B VDD VSS _15867_/B XNOR2X1
XFILLER_36_779 VSS VDD FILLER2
X_16607_ _16631_/B _16607_/B VDD VSS _16792_/B OR2X2
XTAP_TAPCELL_ROW_105_959 VDD VSS WELLTAP
X_13819_ _13918_/A _13918_/B _13918_/D _13918_/C VDD VSS _14166_/C AOI211X1
XFILLER_63_587 VSS VDD FILLER2
X_17587_ _19878_/Q _19846_/Q VDD VSS _17589_/D XNOR2X1
XFILLER_51_738 VDD VSS FILLER4
X_14799_ _19362_/Q VDD VSS _14800_/A INVX1
XFILLER_50_226 VDD VSS FILLER4
X_19326_ _19333_/CK _19326_/D _19326_/Q VDD VSS DFFQX1
X_16538_ _16561_/B _16538_/B VDD VSS _16896_/B AND2X1
XFILLER_149_626 VDD VSS FILLER4
XFILLER_148_125 VDD VSS FILLER4
X_19257_ _19996_/CK _19257_/D _19257_/Q VDD VSS DFFQX1
X_16469_ _16469_/A _16469_/B _16469_/C _16469_/D VDD VSS _16492_/B AOAI211X1
XFILLER_164_607 VSS VDD FILLER2
X_18208_ input3/Y hold260/Y VDD VSS _18208_/Y NOR2BX1
XFILLER_78_0 VSS VDD FILLER2
X_19188_ _19217_/CK _19188_/D _19188_/Q VDD VSS DFFQX1
X_18139_ _18139_/A _18139_/B VDD VSS _18143_/C NAND2X1
XFILLER_156_180 VDD VSS FILLER4
XFILLER_105_729 VDD VSS FILLER4
XFILLER_160_824 VSS VDD FILLER2
XFILLER_104_217 VDD VSS FILLER4
XFILLER_160_835 VDD VSS FILLER4
XFILLER_104_228 VDD VSS FILLER4
XFILLER_144_397 VSS VDD FILLER2
X_20101_ _20101_/A VDD VSS _20101_/Y BUFX3
X_09912_ _11014_/A _09912_/B _09912_/C _09928_/C VDD VSS _09913_/C OAI211X1
XFILLER_113_751 VDD VSS FILLER1
X_20032_ _20045_/CK _20032_/D _20032_/Q _20045_/RB VDD VSS DFFRQX1
Xclkbuf_1_1__f__09166_ clkbuf_0__09166_/Y VDD VSS _18422_/CK BUFX12
X_09843_ _18566_/Q _18567_/Q VDD VSS _09880_/A _09881_/B NAND3X1
XFILLER_86_613 VDD VSS FILLER1
XFILLER_112_261 VSS VDD FILLER2
XFILLER_140_570 VDD VSS FILLER1
XFILLER_85_112 VSS VDD FILLER2
XFILLER_112_294 VDD VSS FILLER1
XFILLER_86_657 VSS VDD FILLER2
XFILLER_85_134 VDD VSS DECAPHV8
X_09774_ _09816_/D _18404_/Q VDD VSS _09775_/C NOR2X1
XFILLER_39_540 VSS VDD FILLER2
XFILLER_100_456 VDD VSS FILLER4
XFILLER_74_819 VSS VDD FILLER2
XFILLER_85_167 VDD VSS FILLER1
XFILLER_39_573 VDD VSS FILLER1
XTAP_TAPCELL_ROW_56_516 VDD VSS WELLTAP
XFILLER_85_189 VDD VSS FILLER4
XFILLER_66_370 VSS VDD FILLER2
XFILLER_54_510 VDD VSS FILLER1
XFILLER_27_735 VSS VDD FILLER2
XFILLER_27_768 VDD VSS FILLER4
XFILLER_42_727 VDD VSS FILLER4
XFILLER_53_37 VDD VSS FILLER1
XTAP_TAPCELL_ROW_64_593 VDD VSS WELLTAP
XFILLER_53_59 VSS VDD FILLER2
XTAP_TAPCELL_ROW_140_1273 VDD VSS WELLTAP
XFILLER_22_440 VSS VDD FILLER2
XFILLER_10_624 VDD VSS FILLER4
XFILLER_50_793 VSS VDD FILLER2
XFILLER_10_657 VSS VDD FILLER2
X_09208_ _18511_/Q VDD VSS _18426_/D INVX1
X_10480_ _10514_/A _10481_/C _10481_/D VDD VSS _10483_/B OR3BX1
XFILLER_148_670 VSS VDD FILLER2
XFILLER_136_843 VSS VDD FILLER2
XFILLER_135_331 VDD VSS FILLER4
XFILLER_108_567 VDD VSS FILLER4
XFILLER_135_353 VSS VDD FILLER2
X_12150_ _12160_/A _14465_/B _12160_/C VDD VSS _14466_/B OAI21X1
XFILLER_108_589 VDD VSS FILLER4
XFILLER_135_375 VDD VSS FILLER4
XFILLER_78_12 VDD VSS FILLER4
XFILLER_135_386 VSS VDD FILLER2
XFILLER_150_312 VDD VSS FILLER1
XFILLER_151_835 VSS VDD FILLER2
XFILLER_2_823 VSS VDD FILLER2
XFILLER_135_397 VDD VSS FILLER1
XFILLER_150_323 VSS VDD FILLER2
X_11101_ _11136_/C _11101_/B VDD VSS _11105_/B XNOR2X1
XFILLER_78_34 VDD VSS FILLER4
X_12081_ _19067_/Q _12081_/B _12284_/C VDD VSS _12448_/B MIN3X1
XFILLER_150_345 VDD VSS FILLER4
XFILLER_104_751 VSS VDD FILLER2
XFILLER_78_67 VSS VDD FILLER2
XFILLER_104_762 VSS VDD FILLER2
X_11032_ _11074_/C _11032_/B VDD VSS _11047_/B XNOR2X1
XFILLER_78_89 VDD VSS FILLER1
XFILLER_150_389 VSS VDD FILLER2
XFILLER_134_40 VDD VSS FILLER4
X_15840_ _15198_/B _15840_/B _17986_/C VDD VSS _19454_/D AND3BX1
X_15771_ _15780_/A _15771_/B VDD VSS _19393_/D NOR2X1
X_12983_ _18966_/Q _13171_/A _14217_/B VDD VSS _12989_/C XNOR3X1
X_17510_ _17512_/C _17510_/B _17510_/C VDD VSS _19861_/D AOI21X1
X_14722_ _14728_/B _14722_/B VDD VSS _15705_/B XNOR2X1
X_18490_ _18495_/CK _18490_/D _18490_/Q _18491_/RB VDD VSS DFFRQX1
X_11934_ _11934_/A VDD VSS _12055_/B BUFX3
XFILLER_17_245 VSS VDD FILLER2
X_17441_ _19846_/Q _19814_/Q _17441_/C VDD VSS _17446_/C AO21X2
X_14653_ _19497_/Q _14655_/B VDD VSS _14676_/B XNOR2X1
X_11865_ _11865_/A _11865_/B _14397_/B VDD VSS _11967_/B MIN3X1
XTAP_TAPCELL_ROW_102_929 VDD VSS WELLTAP
X_13604_ _13604_/A _13604_/B _13604_/C _13604_/D VDD VSS _13837_/A AOAI211X1
X_17372_ _17372_/A VDD VSS _17373_/C INVX1
X_10816_ _10745_/B _10816_/B _10816_/C VDD VSS _10853_/A AND3BX1
X_14584_ _14601_/B _14584_/B _14584_/C VDD VSS _14615_/A NOR3BX1
X_11796_ _19201_/Q _14489_/B VDD VSS _11830_/A NOR2BX1
XFILLER_60_568 VDD VSS FILLER4
XFILLER_158_401 VSS VDD FILLER2
XFILLER_41_760 VSS VDD FILLER2
X_19111_ _19139_/CK _19111_/D _19111_/Q VDD VSS DFFQX1
Xclkbuf_1_0__f__09186_ clkbuf_0__09186_/Y VDD VSS _18471_/CK BUFX12
X_16323_ _16348_/A _16348_/B VDD VSS _16852_/B XNOR2X1
XFILLER_13_473 VSS VDD FILLER2
X_13535_ _19083_/Q _14359_/B VDD VSS _13728_/A AND2X1
X_10747_ _10747_/A _10747_/B _10747_/C _10945_/A VDD VSS _10774_/A AOI31X1
XFILLER_146_607 VSS VDD FILLER2
X_19042_ _19068_/CK _19042_/D _19042_/Q VDD VSS DFFQX1
X_16254_ _19624_/Q VDD VSS _16255_/A INVX1
X_13466_ _13466_/A _13466_/B _14515_/B _19222_/Q _13466_/E VDD VSS _13557_/C AOI221X1
X_10678_ _10718_/D _10721_/A VDD VSS _10679_/B NAND2X1
XFILLER_9_499 VSS VDD FILLER2
XFILLER_139_692 VDD VSS FILLER4
X_15205_ _15225_/C _15205_/B VDD VSS _15225_/B NOR2X1
X_12417_ _19128_/Q _12462_/B _12553_/C VDD VSS _12456_/C XNOR3X1
X_16185_ _19557_/Q _16703_/A _16185_/C VDD VSS _16208_/B MIN3X1
X_13397_ _18970_/Q _14224_/B VDD VSS _13586_/A NOR2BX1
XFILLER_114_504 VDD VSS FILLER1
XFILLER_126_364 VDD VSS DECAPHV8
XFILLER_153_150 VSS VDD FILLER2
X_15136_ _19398_/Q _15777_/B VDD VSS _15137_/C NAND2X1
XFILLER_99_204 VSS VDD FILLER2
X_12348_ _18902_/Q _12348_/B _12348_/C VDD VSS _14114_/B XNOR3X1
XFILLER_99_215 VDD VSS FILLER1
X_15067_ _15089_/A _15088_/A _15092_/D VDD VSS _15069_/C XNOR3X1
X_19944_ _19946_/CK _19944_/D _19944_/Q VDD VSS DFFQX1
X_12279_ _19015_/Q VDD VSS _12357_/A INVX1
XFILLER_141_367 VDD VSS FILLER4
XFILLER_68_602 VSS VDD FILLER2
X_14018_ _14018_/A _14018_/B _14018_/C _14018_/D VDD VSS _17957_/B OAOI211X1
X_19875_ _19880_/CK _19875_/D _19875_/Q VDD VSS DFFQX1
XFILLER_122_581 VDD VSS FILLER1
XFILLER_68_635 VSS VDD FILLER2
XFILLER_68_646 VDD VSS FILLER1
X_18826_ _19946_/CK _18826_/D _18826_/Q VDD VSS DFFQX1
XFILLER_68_668 VDD VSS FILLER1
XFILLER_67_156 VDD VSS FILLER4
XFILLER_110_787 VSS VDD FILLER2
X_18757_ _18788_/CK _18757_/D _18757_/Q VDD VSS DFFQX1
X_15969_ _15969_/A VDD VSS _15970_/B INVX1
XFILLER_95_498 VDD VSS FILLER1
XFILLER_67_189 VSS VDD FILLER2
XFILLER_36_510 VDD VSS FILLER1
XFILLER_83_649 VSS VDD FILLER2
XFILLER_82_137 VSS VDD FILLER2
X_17708_ _19903_/Q _19871_/Q _17708_/C VDD VSS _17712_/C AOI21X1
X_09490_ _19983_/Q _09490_/B _09507_/B VDD VSS _09491_/C AOI21X1
XFILLER_64_852 VSS VDD FILLER2
X_18688_ _18795_/CK _18688_/D _18688_/Q VDD VSS DFFQX1
X_17639_ _19889_/Q _19857_/Q VDD VSS _17646_/C NOR2X1
XFILLER_63_384 VDD VSS FILLER4
XFILLER_51_579 VDD VSS FILLER4
XFILLER_149_423 VSS VDD FILLER2
X_19309_ _19314_/CK _19309_/D _19309_/Q VDD VSS DFFQX1
XTAP_TAPCELL_ROW_61_563 VDD VSS WELLTAP
XFILLER_139_18 VSS VDD FILLER2
XFILLER_32_793 VSS VDD FILLER2
XFILLER_137_618 VDD VSS FILLER4
XFILLER_136_117 VSS VDD FILLER2
XFILLER_117_375 VSS VDD FILLER2
XFILLER_155_28 VSS VDD FILLER2
XFILLER_132_301 VSS VDD FILLER2
XFILLER_133_835 VSS VDD FILLER2
XFILLER_144_172 VSS VDD FILLER2
XFILLER_145_695 VSS VDD FILLER2
XFILLER_105_537 VSS VDD FILLER2
XFILLER_132_323 VSS VDD FILLER2
XFILLER_105_548 VDD VSS FILLER1
XFILLER_160_643 VDD VSS FILLER4
XFILLER_132_367 VDD VSS FILLER4
XFILLER_132_389 VSS VDD FILLER2
XFILLER_48_26 VSS VDD FILLER2
XFILLER_101_721 VDD VSS FILLER1
XFILLER_98_270 VSS VDD FILLER2
XFILLER_86_421 VSS VDD FILLER2
XFILLER_101_743 VDD VSS FILLER1
X_20015_ clkload7/A _20015_/D _20015_/Q _20030_/RB VDD VSS DFFRQX1
X_09826_ _11435_/A _11435_/B _11196_/A VDD VSS _10247_/A AO21X2
XTAP_TAPCELL_ROW_69_630 VDD VSS WELLTAP
XFILLER_100_242 VSS VDD FILLER2
XFILLER_100_264 VDD VSS FILLER4
XFILLER_86_487 VSS VDD FILLER2
X_09757_ _18339_/Q _09810_/B VDD VSS _09758_/E NOR2X1
XFILLER_74_649 VDD VSS FILLER4
XFILLER_27_532 VSS VDD FILLER2
XFILLER_27_554 VDD VSS FILLER4
X_09688_ _18447_/Q _09816_/B VDD VSS _09690_/C NOR2X1
XFILLER_64_58 VDD VSS FILLER4
XFILLER_15_716 VDD VSS FILLER1
XFILLER_54_373 VDD VSS FILLER4
XFILLER_54_384 VDD VSS DECAPHV8
XFILLER_81_181 VDD VSS FILLER4
XFILLER_42_535 VDD VSS DECAPHV16
XFILLER_70_855 VSS VDD FILLER2
X_11650_ _18790_/Q _11658_/B VDD VSS _18817_/D AND2X1
XTAP_TAPCELL_ROW_24_232 VDD VSS WELLTAP
X_10601_ _10649_/A _10649_/B _10601_/C _10601_/D VDD VSS _10619_/A AOAI211X1
XFILLER_23_782 VSS VDD FILLER2
X_11581_ _18727_/Q _11589_/B VDD VSS _18754_/D AND2X1
XFILLER_10_421 VSS VDD FILLER2
XFILLER_128_607 VDD VSS FILLER4
X_13320_ _13616_/A _13322_/C VDD VSS _14387_/B XNOR2X1
X_10532_ _10556_/A _10556_/B _10686_/D VDD VSS _10533_/C OAI21X1
XFILLER_10_465 VDD VSS FILLER4
XFILLER_155_426 VSS VDD FILLER2
XFILLER_129_40 VSS VDD FILLER2
XFILLER_13_84 VSS VDD FILLER2
XFILLER_129_62 VSS VDD FILLER2
X_13251_ _19192_/Q _14479_/B VDD VSS _13443_/C _14479_/C AND3X2
X_10463_ _10581_/A _10463_/B _10463_/C _10463_/D VDD VSS _10535_/C AND4X2
XFILLER_136_640 VSS VDD FILLER2
XFILLER_124_802 VDD VSS FILLER4
XFILLER_136_662 VSS VDD FILLER2
X_12202_ _14243_/A _14244_/A _14277_/B VDD VSS _12280_/B MIN3X1
XFILLER_89_44 VSS VDD FILLER2
X_13182_ _18882_/Q _13182_/B _13182_/C VDD VSS _13183_/C MIN3X1
XFILLER_135_161 VDD VSS FILLER4
X_10394_ _10390_/B _18554_/Q VDD VSS _10431_/A NAND2BX1
XFILLER_123_312 VSS VDD FILLER2
XFILLER_124_835 VSS VDD FILLER2
XFILLER_136_695 VSS VDD FILLER2
XFILLER_151_621 VSS VDD FILLER2
XFILLER_108_397 VSS VDD FILLER2
XFILLER_123_323 VDD VSS FILLER1
XFILLER_151_632 VSS VDD FILLER2
X_12133_ _19013_/Q VDD VSS _14243_/A INVX1
XTAP_TAPCELL_ROW_0_10 VDD VSS WELLTAP
XFILLER_2_631 VSS VDD FILLER2
XFILLER_151_654 VSS VDD FILLER2
X_17990_ _17990_/A _17990_/B VDD VSS _19964_/D AND2X1
XFILLER_150_142 VSS VDD FILLER2
XFILLER_97_719 VDD VSS FILLER4
X_16941_ _17073_/B VDD VSS _17049_/B BUFX3
X_12064_ _19067_/Q _12284_/B _12284_/C VDD VSS _12077_/C XNOR3X1
XFILLER_2_675 VDD VSS FILLER4
XFILLER_104_570 VDD VSS FILLER4
XFILLER_145_83 VSS VDD FILLER2
XFILLER_150_197 VSS VDD FILLER2
X_11015_ _10983_/B _11014_/Y _10984_/A VDD VSS _11015_/Y MUX2X1
X_19660_ _19661_/CK _19660_/D _19660_/Q VDD VSS DFFQX1
XFILLER_49_134 VSS VDD FILLER2
X_16872_ _16876_/A _16872_/B VDD VSS _19709_/D NOR2X1
X_18611_ _18612_/CK _18611_/D _18611_/Q VDD VSS DFFQX1
X_15823_ _15830_/A _15823_/B VDD VSS _19438_/D NOR2X1
XFILLER_65_627 VSS VDD FILLER2
X_19591_ _19600_/CK _19591_/D _19591_/Q VDD VSS DFFQX1
XFILLER_49_189 VSS VDD FILLER2
XFILLER_65_649 VSS VDD FILLER2
XFILLER_38_92 VSS VDD FILLER2
XFILLER_161_71 VSS VDD FILLER2
X_18542_ _18543_/CK _18542_/D _18542_/Q VDD VSS DFFQX1
XFILLER_46_852 VDD VSS FILLER1
X_15754_ _15758_/A _15754_/B VDD VSS _19377_/D NOR2X1
X_12966_ _19244_/Q _12966_/B _12966_/C VDD VSS _12968_/B XNOR3X1
XTAP_TAPCELL_ROW_9_96 VDD VSS WELLTAP
XFILLER_73_671 VDD VSS FILLER4
X_14705_ _19498_/Q _14742_/C _14705_/C VDD VSS _14739_/A OR3BX1
XTAP_TAPCELL_ROW_75_688 VDD VSS WELLTAP
X_18473_ _18479_/CK _18510_/Q _20118_/A _18491_/RB VDD VSS DFFRQX1
X_11917_ _11918_/A _11918_/B _11918_/D _11918_/C VDD VSS _14462_/B OAOI211X2
XTAP_TAPCELL_ROW_160_1457 VDD VSS WELLTAP
X_15685_ _15693_/A _15685_/B VDD VSS _19314_/D NOR2X1
X_12897_ _19020_/Q VDD VSS _12899_/A INVX1
X_17424_ _17427_/C _17425_/B _17452_/C VDD VSS _17425_/C OAI21X1
X_14636_ _19443_/Q VDD VSS _14701_/A INVX1
X_11848_ _19147_/Q _11869_/A _11874_/D VDD VSS _11966_/A XNOR3X1
XFILLER_159_710 VSS VDD FILLER2
XFILLER_60_365 VSS VDD FILLER2
X_17355_ _17355_/A _17357_/C _17355_/C VDD VSS _19828_/D AOI21X1
XFILLER_60_387 VSS VDD FILLER2
XFILLER_14_793 VSS VDD FILLER2
X_14567_ _20006_/Q _14569_/B VDD VSS _19270_/D AND2X1
XFILLER_20_229 VSS VDD FILLER2
XFILLER_159_754 VSS VDD FILLER2
X_11779_ _11804_/A _11804_/B VDD VSS _11781_/B NOR2X1
XFILLER_119_607 VSS VDD FILLER2
Xclkbuf_1_0__f__09169_ clkbuf_0__09169_/Y VDD VSS _18374_/CK BUFX12
X_16306_ _19690_/Q _16851_/B VDD VSS _16326_/A NAND2BX1
X_13518_ _18999_/Q _14261_/B VDD VSS _14226_/A AND2X1
XFILLER_158_264 VSS VDD FILLER2
X_17286_ _17289_/A _17286_/B _17286_/C VDD VSS _19813_/D AOI21X1
XFILLER_159_798 VSS VDD FILLER2
X_14498_ _14539_/A _14498_/B VDD VSS _19207_/D NOR2X1
X_19025_ _19025_/CK _19025_/D _19025_/Q VDD VSS DFFQX1
XTAP_TAPCELL_ROW_30_279 VDD VSS WELLTAP
X_16237_ _16237_/A _16258_/C VDD VSS _16742_/B XNOR2X1
Xclkload11 _19880_/CK VDD VSS clkload11/Y INVX1
Xclkload22 _18845_/CK VDD VSS clkload22/Y INVX1
X_13449_ _19194_/Q _13449_/B _13457_/D VDD VSS _13459_/C XNOR3X1
Xclkload33 clkload33/A VDD VSS clkload33/Y INVX6
Xclkload44 _19119_/CK VDD VSS clkload44/Y INVX2
Xclkload55 _19995_/CK VDD VSS clkload55/Y INVX2
XFILLER_127_673 VDD VSS FILLER4
XFILLER_127_684 VSS VDD FILLER2
X_16168_ _19685_/Q _16846_/B VDD VSS _16169_/B XNOR2X1
Xclkload66 _18939_/CK VDD VSS clkload66/Y BUFX12
XFILLER_115_835 VSS VDD FILLER2
Xclkload77 _19463_/CK VDD VSS clkload77/Y INVX1
Xclkload88 _19412_/CK VDD VSS clkload88/Y INVX2
XFILLER_114_323 VSS VDD FILLER2
XFILLER_126_183 VSS VDD FILLER2
Xclkload99 _19636_/CK VDD VSS clkload99/Y INVX1
XFILLER_142_643 VDD VSS FILLER4
X_15119_ _15137_/A _15119_/B VDD VSS _15747_/B XOR2X1
X_16099_ _16099_/A _16103_/B VDD VSS _16100_/B XOR2X1
XFILLER_130_816 VSS VDD FILLER2
XFILLER_141_142 VDD VSS FILLER4
XFILLER_142_687 VSS VDD FILLER2
XFILLER_130_838 VSS VDD FILLER2
X_19927_ clkload2/A _19927_/D _19927_/Q VDD VSS DFFQX1
XFILLER_68_421 VDD VSS FILLER4
X_19858_ _19880_/CK _19858_/D _19858_/Q VDD VSS DFFQX1
X_09611_ _09626_/B _18394_/Q _09611_/C _09753_/D VDD VSS _09612_/E OAOI211X1
X_18809_ _18810_/CK _18809_/D _18809_/Q VDD VSS DFFQX1
XFILLER_95_273 VDD VSS FILLER4
XTAP_TAPCELL_ROW_66_611 VDD VSS WELLTAP
X_19789_ _19791_/CK _19789_/D _19789_/Q VDD VSS DFFQX1
X_09542_ _20036_/Q _09547_/B VDD VSS _20037_/D NOR2BX1
XFILLER_83_468 VSS VDD FILLER2
XTAP_TAPCELL_ROW_38_357 VDD VSS WELLTAP
X_09473_ _18450_/D _09483_/B _09473_/C VDD VSS _18247_/D AOI21X1
XFILLER_51_343 VDD VSS FILLER1
XTAP_TAPCELL_ROW_21_202 VDD VSS WELLTAP
Xclkload5 clkload5/A VDD VSS clkload5/Y INVX8
XFILLER_165_735 VSS VDD FILLER2
XFILLER_109_128 VSS VDD FILLER2
XFILLER_50_49 VDD VSS FILLER4
XFILLER_20_785 VDD VSS FILLER4
XFILLER_137_459 VDD VSS FILLER4
XFILLER_118_651 VSS VDD FILLER2
XFILLER_106_824 VSS VDD FILLER2
XFILLER_3_417 VDD VSS FILLER1
XFILLER_105_301 VSS VDD FILLER2
XFILLER_133_654 VSS VDD FILLER2
XFILLER_132_142 VDD VSS FILLER4
XFILLER_160_451 VDD VSS FILLER1
XFILLER_121_827 VDD VSS FILLER1
XFILLER_132_175 VDD VSS FILLER1
Xfanout220 _20081_/RB VDD VSS _18469_/RB BUFX3
XFILLER_120_337 VSS VDD FILLER2
XFILLER_115_42 VSS VDD FILLER2
XFILLER_59_443 VSS VDD FILLER2
XFILLER_47_616 VSS VDD FILLER2
X_09809_ _20116_/A _20132_/A _09773_/D VDD VSS _09819_/B MUXI2X1
XFILLER_101_584 VDD VSS FILLER4
XFILLER_47_649 VSS VDD FILLER2
XFILLER_86_295 VSS VDD FILLER2
XFILLER_46_137 VSS VDD FILLER2
X_12820_ _12939_/B _14382_/C _19104_/Q VDD VSS _12821_/D AND3BX1
XFILLER_46_159 VSS VDD FILLER2
XFILLER_131_52 VSS VDD FILLER2
XFILLER_15_513 VDD VSS FILLER4
X_12751_ _12832_/A _12832_/B VDD VSS _12841_/C _12832_/C NAND3X1
XFILLER_91_12 VSS VDD FILLER2
XFILLER_15_535 VSS VDD FILLER2
XFILLER_27_395 VSS VDD FILLER2
XFILLER_131_96 VDD VSS DECAPHV8
X_11702_ _11742_/A VDD VSS _11724_/A INVX1
XTAP_TAPCELL_ROW_72_658 VDD VSS WELLTAP
XFILLER_42_343 VSS VDD FILLER2
X_15470_ _19490_/Q VDD VSS _15471_/A INVX1
X_12682_ _19214_/Q _12832_/B VDD VSS _12683_/D _12682_/C NAND3X1
X_14421_ _14522_/A VDD VSS _14421_/Y BUFX3
X_11633_ _18775_/Q _11635_/B VDD VSS _18802_/D AND2X1
X_17140_ _17140_/A _17140_/B _17140_/C _17140_/D VDD VSS _17141_/C AOAI211X1
X_14352_ _14352_/A _14352_/B _14352_/C VDD VSS _19078_/D NOR3X1
X_11564_ _18712_/Q _11567_/B VDD VSS _18739_/D AND2X1
X_13303_ _14222_/B _13400_/C _18969_/Q VDD VSS _13391_/C AND3BX1
XFILLER_6_211 VSS VDD FILLER2
X_17071_ _17095_/A _17071_/B VDD VSS _19767_/D NOR2X1
X_10515_ _18637_/Q _18799_/Q VDD VSS _10516_/B XOR2X1
X_14283_ _14285_/A _14283_/B VDD VSS _19017_/D NOR2X1
X_11495_ _11495_/A _11641_/B VDD VSS _18677_/D NOR2X1
XFILLER_10_295 VSS VDD FILLER2
XFILLER_143_418 VSS VDD FILLER2
X_16022_ _16022_/A _16022_/B _16022_/C _16022_/D VDD VSS _16023_/C AOAI211X1
XFILLER_155_278 VDD VSS FILLER1
XFILLER_108_150 VSS VDD FILLER2
XFILLER_143_429 VSS VDD FILLER2
X_13234_ _13443_/A _13443_/B VDD VSS _14448_/B XNOR2X1
X_10446_ _10446_/A VDD VSS _10448_/C INVX1
XFILLER_136_481 VDD VSS FILLER4
XFILLER_136_492 VSS VDD FILLER2
XFILLER_156_60 VSS VDD FILLER2
XFILLER_156_71 VDD VSS FILLER1
XFILLER_124_643 VDD VSS FILLER1
X_13165_ _19052_/Q _13271_/D _13165_/C VDD VSS _13208_/C XOR3X1
X_10377_ _18660_/Q _18768_/Q VDD VSS _10406_/D NAND2X1
XFILLER_156_93 VSS VDD FILLER2
XFILLER_97_516 VSS VDD FILLER2
XFILLER_2_450 VSS VDD FILLER2
X_12116_ _12116_/A _12116_/B _12116_/C _12116_/D VDD VSS wire161/A AOAI211X1
XFILLER_123_175 VDD VSS FILLER4
X_17973_ _18870_/Q VDD VSS _17975_/A INVX1
X_13096_ _13415_/B _14290_/C _19023_/Q VDD VSS _13097_/D AND3BX1
X_16924_ _19740_/Q wire164/Y VDD VSS _16928_/B XNOR2X1
X_19712_ _19730_/CK _19712_/D _19712_/Q VDD VSS DFFQX1
X_12047_ _12113_/A _12113_/B _12113_/D VDD VSS _12059_/B OAI21X1
XFILLER_93_700 VSS VDD FILLER2
XFILLER_78_774 VSS VDD FILLER2
X_16855_ _16865_/A _16855_/B VDD VSS _19694_/D NOR2X1
X_19643_ _19724_/CK _19643_/D _19643_/Q VDD VSS DFFQX1
XFILLER_37_115 VSS VDD FILLER2
XFILLER_92_221 VSS VDD FILLER2
XFILLER_77_295 VSS VDD FILLER2
X_15806_ _15806_/A _15806_/B _15806_/C VDD VSS _19423_/D NOR3X1
XFILLER_65_457 VDD VSS FILLER1
X_19574_ _19737_/CK _19574_/D _19574_/Q VDD VSS DFFQX1
XFILLER_92_243 VSS VDD FILLER2
XFILLER_65_468 VSS VDD FILLER2
X_16786_ _16794_/A _16786_/B VDD VSS _19632_/D NOR2X1
X_13998_ _13998_/A _13998_/B _13998_/C _13998_/D VDD VSS _14232_/B AOAI211X1
XFILLER_93_799 VSS VDD FILLER2
XFILLER_80_416 VSS VDD FILLER2
XFILLER_46_671 VDD VSS FILLER1
X_18525_ _18525_/CK _18525_/D _18525_/Q _09298_/Y VDD VSS DFFRQX1
XFILLER_80_427 VSS VDD FILLER2
X_15737_ _15739_/A _15737_/B VDD VSS _19362_/D NOR2X1
XFILLER_65_90 VSS VDD FILLER2
X_12949_ _13108_/A _13108_/B _13108_/C VDD VSS _12972_/B AOI21X1
XTAP_TAPCELL_ROW_35_327 VDD VSS WELLTAP
XFILLER_61_630 VSS VDD FILLER2
XFILLER_34_844 VSS VDD FILLER2
X_18456_ _18469_/CK _18456_/D _18456_/Q _20078_/RB VDD VSS DFFRQX1
X_15668_ _15668_/A _15671_/C VDD VSS _18190_/A XNOR2X1
XFILLER_61_663 VSS VDD FILLER2
XFILLER_60_151 VSS VDD FILLER2
X_17407_ _17405_/B _17407_/B VDD VSS _17408_/C NOR2BX1
XFILLER_60_162 VDD VSS FILLER1
X_14619_ _14645_/A _14645_/B _14645_/C VDD VSS _15858_/A AOI21X1
X_18387_ _18389_/CK _18520_/Q _20192_/A _20067_/RB VDD VSS DFFRQX1
X_15599_ _15599_/A _15599_/B _15599_/C _15599_/D VDD VSS _15622_/B AOAI211X1
XFILLER_147_702 VSS VDD FILLER2
X_17338_ _17338_/A _17338_/B _17338_/C VDD VSS _17346_/A OA21X2
XFILLER_159_573 VDD VSS FILLER4
XFILLER_146_223 VSS VDD FILLER2
Xclkload100 _19600_/CK VDD VSS clkload100/Y INVX1
XFILLER_147_768 VDD VSS FILLER4
X_17269_ _17270_/B _17269_/B VDD VSS _17271_/B NOR2BX1
Xclkload111 _20054_/CK VDD VSS clkload111/Y INVX6
Xclkload122 _18423_/CK VDD VSS clkload122/Y INVX2
XFILLER_146_267 VSS VDD FILLER2
X_19008_ _19037_/CK _19008_/D _19008_/Q VDD VSS DFFQX1
XFILLER_162_727 VSS VDD FILLER2
XFILLER_115_610 VSS VDD FILLER2
XFILLER_127_481 VSS VDD FILLER2
XFILLER_155_790 VDD VSS FILLER1
XFILLER_115_654 VSS VDD FILLER2
XFILLER_114_142 VSS VDD FILLER2
XFILLER_130_602 VSS VDD FILLER2
XFILLER_102_304 VSS VDD FILLER2
XFILLER_114_164 VSS VDD FILLER2
XFILLER_142_484 VDD VSS FILLER4
XFILLER_102_337 VSS VDD FILLER2
XFILLER_114_197 VSS VDD FILLER2
XFILLER_130_657 VSS VDD FILLER2
XFILLER_29_39 VDD VSS FILLER4
XFILLER_84_700 VDD VSS FILLER4
XFILLER_84_733 VSS VDD FILLER2
XFILLER_28_137 VSS VDD FILLER2
XFILLER_84_766 VDD VSS FILLER4
XTAP_TAPCELL_ROW_126_1149 VDD VSS WELLTAP
XFILLER_84_788 VSS VDD FILLER2
XFILLER_45_27 VSS VDD FILLER2
XFILLER_71_427 VSS VDD FILLER2
X_09525_ _20021_/Q _09526_/B _18202_/B VDD VSS _20021_/D OA21X2
XFILLER_43_129 VSS VDD FILLER2
XFILLER_52_630 VDD VSS FILLER1
X_09456_ _09482_/C VDD VSS _09476_/C BUFX3
XFILLER_101_44 VSS VDD FILLER2
XFILLER_12_505 VDD VSS FILLER4
XFILLER_52_685 VSS VDD FILLER2
XFILLER_51_184 VSS VDD FILLER2
XFILLER_40_847 VSS VDD FILLER2
X_09387_ _18629_/Q _09387_/B _18163_/A VDD VSS _18232_/E AO21X2
XFILLER_8_509 VSS VDD FILLER2
XFILLER_138_713 VSS VDD FILLER2
XFILLER_165_521 VSS VDD FILLER2
XFILLER_138_768 VDD VSS FILLER1
XTAP_TAPCELL_ROW_137_1245 VDD VSS WELLTAP
XFILLER_153_716 VDD VSS FILLER1
X_10300_ _18623_/Q _10686_/D VDD VSS _10546_/A _10314_/C NAND3X1
XFILLER_165_576 VDD VSS FILLER1
XFILLER_117_4 VDD VSS FILLER4
XFILLER_152_204 VSS VDD FILLER2
XFILLER_137_289 VDD VSS DECAPHV8
X_11280_ _11280_/A _11286_/B VDD VSS _11284_/B XNOR2X1
X_10231_ _18595_/Q _10231_/B VDD VSS _10231_/Y XNOR2X1
XFILLER_105_153 VDD VSS FILLER4
XFILLER_133_462 VSS VDD FILLER2
XFILLER_105_164 VSS VDD FILLER2
X_10162_ _10180_/A _11419_/C VDD VSS _18541_/D NOR2X1
XFILLER_120_134 VDD VSS FILLER4
XFILLER_126_85 VDD VSS FILLER1
X_14970_ _19533_/Q _14970_/B VDD VSS _15900_/B XOR2X1
X_10093_ _10045_/Y _10146_/B _10167_/A VDD VSS _10182_/B MUX2X1
XFILLER_120_156 VDD VSS FILLER4
XTAP_TAPCELL_ROW_77_706 VDD VSS WELLTAP
XFILLER_120_167 VSS VDD FILLER2
XTAP_TAPCELL_ROW_148_1341 VDD VSS WELLTAP
X_13921_ _13921_/A _13921_/B _13921_/C _13921_/D VDD VSS _13923_/C OAI211X1
XFILLER_19_104 VDD VSS FILLER4
XFILLER_101_370 VSS VDD FILLER2
X_16640_ _16643_/A _16643_/B _16643_/C _18087_/D VDD VSS _16641_/D OAI31X1
XFILLER_47_457 VSS VDD FILLER2
X_13852_ _13912_/A _13912_/B _13912_/E VDD VSS _13862_/B OA21X2
XFILLER_47_468 VSS VDD FILLER2
XFILLER_47_479 VDD VSS FILLER1
XFILLER_16_811 VSS VDD FILLER2
X_12803_ _12803_/A _12803_/B _12803_/C _12803_/D VDD VSS _14315_/B AOAI211X1
X_16571_ _16571_/A _16571_/B _16790_/B VDD VSS _16597_/B MIN3X1
Xclkbuf_leaf_18__000_ clkload72/A VDD VSS _19600_/CK BUFX12
XFILLER_16_833 VDD VSS FILLER4
X_13783_ _13783_/A _14297_/B _13783_/C _13783_/D VDD VSS _13912_/A OAOI211X2
XFILLER_90_758 VDD VSS FILLER1
X_10995_ _11026_/B VDD VSS _10996_/B INVX1
XFILLER_55_490 VDD VSS FILLER4
XFILLER_43_630 VDD VSS FILLER4
X_18310_ _18311_/CK _18470_/D _18310_/Q _18464_/RB VDD VSS DFFRQX1
XFILLER_43_641 VSS VDD FILLER2
X_15522_ _19436_/Q _15821_/B VDD VSS _15545_/B XNOR2X1
X_19290_ _19306_/CK _19290_/D _19290_/Q VDD VSS DFFQX1
X_12734_ _12809_/A _14380_/B VDD VSS _12821_/A NOR2X1
XFILLER_31_814 VSS VDD FILLER2
XFILLER_15_365 VSS VDD FILLER2
XFILLER_43_685 VSS VDD FILLER2
X_18241_ _18241_/CK _18241_/D _18241_/Q _20078_/RB VDD VSS DFFRQX1
X_15453_ _19378_/Q _15755_/B VDD VSS _15464_/B XNOR2X1
XTAP_TAPCELL_ROW_6_64 VDD VSS WELLTAP
X_12665_ _12771_/A _12771_/B _12771_/E VDD VSS _12739_/B OA21X2
XFILLER_70_493 VDD VSS FILLER1
XFILLER_129_702 VDD VSS FILLER1
X_14404_ _14381_/Y _14404_/B _14404_/C VDD VSS _19125_/D AND3BX1
X_18172_ _18174_/C _18172_/B VDD VSS _18173_/B XNOR2X1
X_11616_ _11616_/A _11641_/B VDD VSS _18786_/D NOR2X1
X_15384_ _15691_/B VDD VSS _15385_/C INVX1
XFILLER_156_510 VDD VSS FILLER1
X_12596_ _19074_/Q _12729_/A _12804_/B VDD VSS _12803_/D XNOR3X1
X_17123_ _19778_/Q _19746_/Q _17123_/C VDD VSS _17128_/C AO21X2
XTAP_TAPCELL_ROW_40_374 VDD VSS WELLTAP
XFILLER_11_582 VSS VDD FILLER2
XFILLER_129_768 VSS VDD FILLER2
X_14335_ _14339_/A _14335_/B VDD VSS _19063_/D NOR2X1
XFILLER_11_593 VDD VSS FILLER1
X_11547_ _18696_/Q _11555_/B VDD VSS _18723_/D AND2X1
XFILLER_156_576 VSS VDD FILLER2
XFILLER_156_587 VDD VSS FILLER1
X_17054_ _17064_/A _17064_/B _17062_/D VDD VSS _17059_/C AOI21BX1
X_14266_ _14294_/A _14266_/B _14266_/C VDD VSS _19004_/D NOR3X1
XFILLER_109_481 VDD VSS FILLER4
X_11478_ _18634_/Q _11484_/B VDD VSS _18661_/D AND2X1
X_16005_ _16030_/A _16030_/B VDD VSS _16874_/B XNOR2X1
XFILLER_143_259 VSS VDD FILLER2
X_13217_ _14323_/A _14323_/B VDD VSS _13269_/B NAND2X1
X_10429_ _18555_/Q _10503_/A _10433_/B VDD VSS _10431_/C XOR3X1
X_14197_ _14197_/A _14197_/B VDD VSS _18947_/D AND2X1
XTAP_TAPCELL_ROW_114_1042 VDD VSS WELLTAP
XFILLER_97_302 VSS VDD FILLER2
XFILLER_124_473 VDD VSS FILLER1
XFILLER_3_770 VDD VSS FILLER1
XFILLER_151_270 VSS VDD FILLER2
XFILLER_152_793 VDD VSS FILLER4
X_13148_ _13150_/D _13255_/C _13255_/A VDD VSS _13152_/B NAND3BX1
XFILLER_124_495 VSS VDD FILLER2
XFILLER_112_646 VDD VSS DECAPHV8
XFILLER_151_292 VDD VSS FILLER1
XFILLER_2_280 VDD VSS FILLER1
X_17956_ _17957_/B _17957_/C _17957_/A VDD VSS _17958_/C OAI21X1
X_13079_ _13283_/A _17891_/B VDD VSS _18855_/D AND2X1
XFILLER_66_700 VSS VDD FILLER2
XFILLER_38_402 VSS VDD FILLER2
XFILLER_38_413 VDD VSS FILLER4
XFILLER_111_189 VDD VSS FILLER4
X_16907_ _20016_/Q _16906_/Y _20065_/Q VDD VSS _16907_/Y MUXI2X1
X_17887_ _17891_/C _17888_/B _17917_/C VDD VSS _17888_/C OAI21X1
X_19626_ _19661_/CK _19626_/D _19626_/Q VDD VSS DFFQX1
XTAP_TAPCELL_ROW_48_441 VDD VSS WELLTAP
X_16838_ _16838_/A _16838_/B VDD VSS _19679_/D NOR2X1
XFILLER_66_788 VSS VDD FILLER2
XFILLER_38_479 VSS VDD FILLER2
XFILLER_19_660 VDD VSS FILLER4
XFILLER_80_202 VSS VDD FILLER2
XFILLER_81_747 VSS VDD FILLER2
XFILLER_19_682 VSS VDD FILLER2
X_16769_ _16775_/A _16769_/B VDD VSS _19617_/D NOR2X1
X_19557_ _19600_/CK _19557_/D _19557_/Q VDD VSS DFFQX1
XFILLER_80_235 VSS VDD FILLER2
XFILLER_53_449 VSS VDD FILLER2
X_09310_ _18405_/RB _09322_/B VDD VSS _09310_/Y NOR2BX1
X_18508_ _18508_/CK _18508_/D _18508_/Q _09353_/Y VDD VSS DFFRQX1
X_19488_ _19736_/CK _19488_/D _19488_/Q VDD VSS DFFQX1
X_09241_ _18525_/Q VDD VSS _18344_/D INVX1
X_18439_ _18439_/CK _18471_/D _18439_/Q _18464_/RB VDD VSS DFFRQX1
XFILLER_33_184 VSS VDD FILLER2
XFILLER_21_335 VSS VDD FILLER2
XFILLER_166_318 VDD VSS DECAPHV8
XFILLER_119_201 VSS VDD FILLER2
XFILLER_119_234 VDD VSS FILLER4
XFILLER_147_18 VSS VDD FILLER2
XFILLER_107_407 VSS VDD FILLER2
XFILLER_119_278 VDD VSS FILLER1
XFILLER_147_598 VDD VSS FILLER1
Xoutput18 _20087_/Y VDD VSS o_aux_ctrl[5] BUFX3
Xoutput29 _20113_/Y VDD VSS o_bias_cfg[15] BUFX3
XFILLER_1_718 VDD VSS FILLER4
XFILLER_0_206 VSS VDD FILLER2
XFILLER_1_729 VDD VSS FILLER1
XFILLER_143_793 VDD VSS FILLER4
XFILLER_0_228 VDD VSS FILLER4
X_20194_ _20194_/A VDD VSS _20194_/Y BUFX3
XFILLER_163_28 VDD VSS FILLER4
XFILLER_130_421 VSS VDD FILLER2
XTAP_TAPCELL_ROW_132_1197 VDD VSS WELLTAP
XFILLER_88_335 VDD VSS FILLER4
XFILLER_163_39 VSS VDD FILLER2
XFILLER_102_123 VDD VSS FILLER1
XFILLER_103_679 VDD VSS DECAPHV8
XFILLER_56_26 VDD VSS FILLER4
XFILLER_29_468 VDD VSS DECAPHV8
XFILLER_44_416 VSS VDD FILLER2
XFILLER_44_449 VDD VSS FILLER4
XTAP_TAPCELL_ROW_82_753 VDD VSS WELLTAP
X_09508_ _20015_/Q _20070_/Q VDD VSS _20070_/D NOR2BX1
XFILLER_71_257 VSS VDD FILLER2
X_10780_ _18564_/Q _10780_/B VDD VSS _10784_/B NOR2X1
XFILLER_13_825 VSS VDD FILLER2
XFILLER_72_58 VSS VDD FILLER2
XFILLER_52_482 VSS VDD FILLER2
X_09439_ _18505_/Q _09630_/C _18506_/Q VDD VSS wire176/A NAND3BX1
XTAP_TAPCELL_ROW_54_499 VDD VSS WELLTAP
X_12450_ _12451_/B _12451_/C _19070_/Q VDD VSS _12452_/B AOI21X1
XFILLER_8_328 VSS VDD FILLER2
X_11401_ _17566_/A VDD VSS _17827_/B BUFX3
X_12381_ _19182_/Q _14468_/B _14468_/C VDD VSS _12382_/D OR3BX1
XFILLER_20_390 VSS VDD FILLER2
XFILLER_153_513 VDD VSS FILLER4
X_14120_ _14142_/A _14120_/B VDD VSS _18879_/D NOR2X1
XFILLER_4_501 VSS VDD FILLER2
X_11332_ _18587_/Q _11336_/B VDD VSS _11337_/B XOR2X1
XFILLER_153_557 VDD VSS FILLER1
XFILLER_108_0 VSS VDD FILLER2
XFILLER_125_259 VSS VDD FILLER2
XFILLER_137_62 VSS VDD FILLER2
X_14051_ _18895_/Q _14138_/B VDD VSS _14101_/A NAND2X1
XFILLER_141_719 VDD VSS FILLER1
X_11263_ _11263_/A VDD VSS _11379_/A BUFX3
XFILLER_140_218 VDD VSS FILLER1
X_13002_ _14256_/B _14256_/C _18994_/Q VDD VSS _13004_/C AOI21X1
X_10214_ _10146_/Y _10213_/Y _10224_/A VDD VSS _10219_/B MUXI2X1
XFILLER_97_55 VDD VSS FILLER1
XFILLER_134_793 VDD VSS FILLER4
X_11194_ _11224_/C _11194_/B VDD VSS _11195_/B XNOR2X1
XFILLER_161_590 VSS VDD FILLER2
X_17810_ _17809_/B _17810_/B VDD VSS _17813_/C NOR2BX1
X_10145_ _10190_/B _10145_/B _10145_/C _10166_/D VDD VSS _10146_/C AOI211X1
X_18790_ _18818_/CK _18790_/D _18790_/Q VDD VSS DFFQX1
XFILLER_67_508 VDD VSS FILLER1
XFILLER_94_305 VSS VDD FILLER2
XFILLER_48_700 VSS VDD FILLER2
X_17741_ _19911_/Q _19879_/Q VDD VSS _17742_/B XOR2X1
X_14953_ _19366_/Q VDD VSS _14954_/A INVX1
X_10076_ _10074_/Y _10076_/B _17172_/A VDD VSS _18534_/D AND3BX1
XFILLER_87_390 VSS VDD FILLER2
X_13904_ _19033_/Q VDD VSS _13967_/C INVX1
X_17672_ _17672_/A VDD VSS _17673_/C INVX1
X_14884_ _19477_/Q _14884_/B _14884_/C VDD VSS _14920_/C XNOR3X1
XFILLER_48_788 VSS VDD FILLER2
XFILLER_35_405 VSS VDD FILLER2
XFILLER_35_416 VSS VDD FILLER2
X_16623_ _19638_/Q _16792_/B _16623_/C VDD VSS _16649_/B OAI21X1
X_19411_ _19412_/CK _19411_/D _19411_/Q VDD VSS DFFQX1
XFILLER_90_522 VSS VDD FILLER2
XFILLER_35_427 VSS VDD FILLER2
X_13835_ _18975_/Q _14230_/B VDD VSS _13921_/D _14230_/C NAND3X1
XFILLER_63_747 VDD VSS FILLER4
XTAP_TAPCELL_ROW_45_422 VDD VSS WELLTAP
XFILLER_90_544 VDD VSS FILLER1
XFILLER_63_769 VDD VSS FILLER1
XFILLER_62_235 VDD VSS FILLER4
XFILLER_28_490 VSS VDD FILLER2
XFILLER_62_257 VDD VSS FILLER4
X_16554_ _16572_/B _16554_/B VDD VSS _16790_/B XNOR2X1
X_19342_ _19573_/CK _19342_/D _19342_/Q VDD VSS DFFQX1
X_13766_ _19030_/Q _13766_/B _13783_/C VDD VSS _13889_/A XNOR3X1
X_10978_ _18702_/Q _18756_/Q _10978_/C VDD VSS _11001_/C AO21X2
XTAP_TAPCELL_ROW_17_168 VDD VSS WELLTAP
XFILLER_15_151 VDD VSS FILLER4
X_15505_ _19379_/Q _15756_/B VDD VSS _15541_/A NAND2X1
XFILLER_16_696 VDD VSS FILLER1
X_19273_ _20013_/CK _19273_/D _19273_/Q VDD VSS DFFQX1
X_12717_ _12717_/A _12717_/B _12717_/C _12717_/D VDD VSS _12801_/B AOAI211X1
XFILLER_31_633 VSS VDD FILLER2
X_16485_ _19697_/Q _16858_/B VDD VSS _16486_/B XNOR2X1
XFILLER_94_6 VDD VSS FILLER1
XFILLER_15_184 VSS VDD FILLER2
X_13697_ _14360_/B _14360_/C _19084_/Q VDD VSS _13699_/C AOI21X1
XFILLER_15_195 VSS VDD FILLER2
XFILLER_148_307 VSS VDD FILLER2
XFILLER_30_132 VDD VSS FILLER1
X_18224_ _18226_/CK _18224_/E _18224_/ECK VDD VSS CGX3
X_15436_ _19543_/Q _15439_/B VDD VSS _15475_/B NOR2BX1
XTAP_TAPCELL_ROW_157_1429 VDD VSS WELLTAP
X_12648_ _12839_/A _12648_/B _12837_/C VDD VSS _12663_/C XNOR3X1
XTAP_TAPCELL_ROW_120_1090 VDD VSS WELLTAP
XFILLER_129_543 VSS VDD FILLER2
X_18155_ _19297_/Q _18155_/B VDD VSS _18159_/B NOR2X1
X_15367_ _15393_/A _15393_/B VDD VSS _15816_/B XNOR2X1
X_12579_ _12583_/A _12677_/B _12583_/B VDD VSS _14535_/C NOR3X1
XFILLER_117_727 VSS VDD FILLER2
X_17106_ _17390_/A _17106_/B VDD VSS _19775_/D NOR2X1
X_14318_ _14339_/A _14318_/B VDD VSS _19048_/D NOR2X1
XFILLER_117_749 VDD VSS FILLER1
X_18086_ _19284_/Q _18089_/B VDD VSS _18090_/C XNOR2X1
X_15298_ _19319_/Q VDD VSS _15340_/A INVX1
XFILLER_116_259 VSS VDD FILLER2
XFILLER_144_568 VDD VSS FILLER1
X_17037_ _17040_/B _17037_/B VDD VSS _17038_/B XOR2X1
X_14249_ _14270_/A _14249_/B VDD VSS _18989_/D AND2X1
XFILLER_131_207 VDD VSS FILLER4
XFILLER_112_421 VDD VSS FILLER4
XFILLER_152_590 VDD VSS FILLER1
XFILLER_112_465 VDD VSS FILLER4
X_09790_ _20079_/Q _09818_/B VDD VSS _09791_/D NAND2X1
X_18988_ _19037_/CK _18988_/D _18988_/Q VDD VSS DFFQX1
XFILLER_23_0 VDD VSS FILLER1
XFILLER_100_638 VSS VDD FILLER2
XFILLER_112_498 VDD VSS FILLER4
X_17939_ _17940_/B _17940_/C _17940_/A VDD VSS _17941_/C OAI21X1
XTAP_TAPCELL_ROW_96_878 VDD VSS WELLTAP
XFILLER_66_563 VDD VSS FILLER1
XFILLER_66_574 VSS VDD FILLER2
XFILLER_38_265 VSS VDD FILLER2
XFILLER_93_371 VDD VSS FILLER1
XFILLER_26_416 VSS VDD FILLER2
X_19609_ _19737_/CK _19609_/D _19609_/Q VDD VSS DFFQX1
XTAP_TAPCELL_ROW_123_1119 VDD VSS WELLTAP
XFILLER_81_533 VSS VDD FILLER2
XFILLER_54_758 VSS VDD FILLER2
Xclkbuf_0__002_ _232_/ECK VDD VSS clkbuf_0__002_/Y BUFX12
XFILLER_54_769 VSS VDD FILLER2
XFILLER_53_246 VSS VDD FILLER2
XFILLER_53_257 VSS VDD FILLER2
XFILLER_22_600 VDD VSS FILLER4
XFILLER_34_493 VDD VSS FILLER1
X_09224_ _18517_/Q VDD VSS _18384_/D INVX1
XTAP_TAPCELL_ROW_51_469 VDD VSS WELLTAP
XFILLER_158_17 VSS VDD FILLER2
XFILLER_10_828 VSS VDD FILLER2
Xclkbuf_leaf_13_clk_regs clkload1/A VDD VSS clkload4/A BUFX12
XFILLER_147_340 VDD VSS FILLER4
XFILLER_135_524 VDD VSS DECAPHV16
XTAP_TAPCELL_ROW_134_1215 VDD VSS WELLTAP
XFILLER_147_395 VSS VDD FILLER2
XFILLER_135_557 VDD VSS FILLER1
XFILLER_107_259 VDD VSS FILLER1
XFILLER_123_719 VSS VDD FILLER2
XFILLER_150_505 VDD VSS FILLER4
XFILLER_162_365 VDD VSS FILLER1
Xclkbuf_leaf_17__001_ clkload33/A VDD VSS _18905_/CK BUFX12
XFILLER_1_504 VDD VSS FILLER1
XFILLER_107_32 VDD VSS FILLER1
XFILLER_116_793 VSS VDD FILLER2
XFILLER_88_132 VSS VDD FILLER2
XFILLER_103_443 VDD VSS FILLER4
XFILLER_77_817 VSS VDD FILLER2
X_20177_ _20177_/A VDD VSS _20177_/Y BUFX3
XFILLER_88_154 VSS VDD FILLER2
XFILLER_77_828 VSS VDD FILLER2
X_09988_ _10017_/B _09987_/Y _10032_/A VDD VSS _09989_/B MUXI2X1
XFILLER_131_785 VSS VDD FILLER2
XFILLER_76_316 VSS VDD FILLER2
XFILLER_103_498 VSS VDD FILLER2
XTAP_TAPCELL_ROW_59_547 VDD VSS WELLTAP
XFILLER_85_850 VSS VDD FILLER2
XTAP_TAPCELL_ROW_145_1322 VDD VSS WELLTAP
X_11950_ _11950_/A _11950_/B _14271_/B VDD VSS _12012_/B MIN3X1
XFILLER_57_585 VSS VDD FILLER2
XFILLER_83_24 VDD VSS FILLER4
X_10901_ _10936_/C _10902_/B _11226_/A VDD VSS _10902_/C AOI21X1
XFILLER_29_287 VSS VDD FILLER2
XFILLER_83_46 VDD VSS FILLER4
XFILLER_45_747 VDD VSS FILLER4
X_11881_ wire166/Y _11881_/B _11881_/C _11881_/D VDD VSS _14525_/C AOAI211X1
XFILLER_72_544 VSS VDD FILLER2
XFILLER_44_235 VDD VSS FILLER4
XFILLER_17_449 VSS VDD FILLER2
XFILLER_72_555 VDD VSS FILLER1
XFILLER_60_706 VDD VSS FILLER1
X_13620_ _13620_/A _13620_/B _13620_/C _13620_/D VDD VSS _13721_/A AOAI211X1
XFILLER_83_79 VDD VSS FILLER4
X_10832_ _10871_/A _10871_/B _10832_/C _10832_/D VDD VSS _10837_/C AOI31X1
XFILLER_16_73 VDD VSS FILLER1
X_13551_ _13640_/A _13640_/B VDD VSS _13562_/B NOR2X1
X_10763_ _10763_/A VDD VSS _11229_/D BUFX3
XTAP_TAPCELL_ROW_14_138 VDD VSS WELLTAP
X_12502_ _12659_/A _12755_/A _12837_/B VDD VSS _12566_/C XNOR3X1
XFILLER_12_154 VDD VSS FILLER4
X_16270_ _16278_/B _16270_/B VDD VSS _16885_/B XNOR2X1
X_13482_ _18943_/Q _13490_/B _13586_/C VDD VSS _13498_/B XNOR3X1
XFILLER_157_126 VDD VSS FILLER1
X_10694_ _10692_/Y _10694_/B _10875_/C VDD VSS _10695_/E AND3BX1
XFILLER_157_137 VSS VDD FILLER2
X_15221_ _15221_/A _15749_/B _15221_/C VDD VSS _15260_/B OAI21X1
X_12433_ _18877_/Q VDD VSS _12612_/A INVX1
XFILLER_32_61 VDD VSS FILLER4
XFILLER_32_72 VSS VDD FILLER2
XTAP_TAPCELL_ROW_3_43 VDD VSS WELLTAP
XFILLER_166_671 VDD VSS FILLER4
XFILLER_154_822 VDD VSS FILLER1
X_15152_ _15191_/A _15191_/B _15154_/A _15191_/D VDD VSS _15183_/C OAI211X1
X_12364_ _12544_/A _12544_/B VDD VSS _14344_/B XNOR2X1
X_14103_ _17964_/B _17964_/C _14141_/B _18898_/Q _14103_/E VDD VSS _17977_/B AOI221X1
X_11315_ _18585_/Q _11315_/B VDD VSS _11316_/C NAND2X1
XFILLER_141_505 VSS VDD FILLER2
X_15083_ _15072_/A _15083_/B _15083_/C VDD VSS _15137_/A AOI2B1X1
X_19960_ _19963_/CK _19960_/D _19960_/Q VDD VSS DFFQX1
X_12295_ _12512_/B _12366_/B _12366_/C VDD VSS _12360_/A AOI21X1
XFILLER_107_771 VDD VSS FILLER4
XFILLER_141_527 VSS VDD FILLER2
X_18911_ _18939_/CK _18911_/D _18911_/Q VDD VSS DFFQX1
X_14034_ _18978_/Q _14233_/B VDD VSS _14036_/C _14233_/C NAND3X1
XFILLER_106_270 VSS VDD FILLER2
X_11246_ _11019_/B _11330_/B _11289_/A VDD VSS _11264_/B MUXI2X1
XTAP_TAPCELL_ROW_111_1012 VDD VSS WELLTAP
X_19891_ clkload2/A _19891_/D _19891_/Q VDD VSS DFFQX1
XFILLER_68_806 VSS VDD FILLER2
XFILLER_79_143 VSS VDD FILLER2
X_18842_ _18845_/CK _18842_/D _18842_/Q VDD VSS DFFQX1
XFILLER_122_774 VSS VDD FILLER2
X_11177_ _11226_/D _11177_/B _11197_/C VDD VSS _11178_/E NOR3X1
XFILLER_95_625 VDD VSS FILLER1
X_10128_ _11435_/A _11196_/A _10154_/B VDD VSS _10175_/B NOR3X1
X_15985_ _19676_/Q _16835_/B _15985_/C VDD VSS _16013_/A OAI21X1
X_18773_ _18773_/CK _18773_/D _18773_/Q VDD VSS DFFQX1
XFILLER_48_552 VDD VSS FILLER1
X_14936_ _14959_/A _14959_/B _14959_/D _14959_/C VDD VSS _15805_/C OAI211X1
X_17724_ _17726_/C _17724_/B _17724_/C VDD VSS _19907_/D AOI21X1
X_10059_ _10167_/A _10059_/B _10059_/C VDD VSS _10159_/B AOI21X1
XFILLER_57_91 VSS VDD FILLER2
XTAP_TAPCELL_ROW_93_848 VDD VSS WELLTAP
XFILLER_91_842 VDD VSS FILLER1
XFILLER_63_533 VSS VDD FILLER2
XFILLER_36_747 VSS VDD FILLER2
X_14867_ _14867_/A _14867_/B _14867_/C _14867_/D VDD VSS _14959_/A OAOI211X1
X_17655_ _17655_/A _17657_/C _17655_/C VDD VSS _19892_/D AOI21X1
XTAP_TAPCELL_ROW_163_1477 VDD VSS WELLTAP
XFILLER_36_758 VDD VSS FILLER1
X_16606_ _16606_/A _16606_/B _16606_/C VDD VSS _16607_/B NOR3X1
X_13818_ _13818_/A _13818_/B _13818_/C _13818_/D VDD VSS _14166_/B OAOI211X1
X_17586_ _17589_/A _17586_/B _17586_/C VDD VSS _19877_/D AOI21X1
XFILLER_90_363 VDD VSS DECAPHV8
X_14798_ _19363_/Q _15738_/B VDD VSS _14801_/A XOR2X1
XFILLER_16_482 VDD VSS FILLER4
X_16537_ _16537_/A _16537_/B VDD VSS _16538_/B _16537_/C NAND3X1
X_19325_ _19333_/CK _19325_/D _19325_/Q VDD VSS DFFQX1
X_13749_ _18918_/Q _13918_/A _13918_/B VDD VSS _13751_/C XNOR3X1
XFILLER_149_638 VDD VSS FILLER4
XFILLER_149_649 VSS VDD FILLER2
X_16468_ _19696_/Q _16857_/B VDD VSS _16469_/D NAND2BX1
X_19256_ _19996_/CK _19256_/D _19256_/Q VDD VSS DFFQX1
XFILLER_31_463 VSS VDD FILLER2
XFILLER_148_137 VSS VDD FILLER2
X_15419_ _15419_/A _15422_/B VDD VSS _18138_/B XNOR2X1
X_19187_ _19191_/CK _19187_/D _19187_/Q VDD VSS DFFQX1
X_16399_ _16420_/B _16399_/B VDD VSS _16784_/B XNOR2X1
XFILLER_117_513 VSS VDD FILLER2
XFILLER_163_118 VSS VDD FILLER2
XFILLER_117_524 VSS VDD FILLER2
X_18138_ _19293_/Q _18138_/B VDD VSS _18139_/A NAND2X1
XFILLER_8_670 VSS VDD FILLER2
XFILLER_105_708 VSS VDD FILLER2
XFILLER_160_803 VSS VDD FILLER2
XFILLER_105_719 VSS VDD FILLER2
XFILLER_144_354 VDD VSS FILLER4
X_18069_ _18069_/A _18069_/B _18069_/C VDD VSS _18074_/A AO21X2
XFILLER_144_365 VSS VDD FILLER2
XFILLER_144_376 VDD VSS FILLER1
X_20100_ _20100_/A VDD VSS _20100_/Y BUFX3
X_09911_ _11014_/A _09911_/B VDD VSS _09912_/C NAND2X1
X_20031_ _20033_/CK _20031_/D _20031_/Q _20045_/RB VDD VSS DFFRQX1
X_09842_ _18565_/Q _09878_/B VDD VSS _09881_/B NOR2BX1
XFILLER_86_603 VDD VSS FILLER1
Xclkbuf_1_1__f__09165_ clkbuf_0__09165_/Y VDD VSS _18437_/CK BUFX12
XFILLER_98_474 VSS VDD FILLER2
X_09773_ _20129_/A _09788_/B _09773_/C _09773_/D VDD VSS _09776_/C AOAI211X1
XFILLER_85_146 VDD VSS FILLER1
XFILLER_27_703 VSS VDD FILLER2
XFILLER_39_563 VDD VSS FILLER1
XTAP_TAPCELL_ROW_56_517 VDD VSS WELLTAP
XFILLER_54_500 VDD VSS DECAPHV8
XFILLER_82_831 VDD VSS FILLER4
X_09967__238 _20054_/CK VDD VSS _18514_/CK INVX1
XFILLER_27_747 VSS VDD FILLER2
XFILLER_54_533 VDD VSS FILLER1
XFILLER_81_330 VSS VDD FILLER2
XFILLER_26_235 VSS VDD FILLER2
XFILLER_54_555 VSS VDD FILLER2
XFILLER_81_352 VSS VDD FILLER2
XFILLER_53_16 VSS VDD FILLER2
XFILLER_35_791 VSS VDD FILLER2
XTAP_TAPCELL_ROW_140_1274 VDD VSS WELLTAP
XFILLER_22_430 VSS VDD FILLER2
XFILLER_149_7 VSS VDD FILLER2
XFILLER_50_750 VSS VDD FILLER2
XFILLER_10_603 VDD VSS FILLER1
XTAP_TAPCELL_ROW_11_108 VDD VSS WELLTAP
XFILLER_22_485 VDD VSS DECAPHV8
X_09207_ _18512_/Q VDD VSS _18427_/D INVX1
XFILLER_6_607 VSS VDD FILLER2
XFILLER_136_811 VSS VDD FILLER2
XFILLER_6_629 VSS VDD FILLER2
XFILLER_108_546 VSS VDD FILLER2
XFILLER_118_20 VDD VSS FILLER4
XFILLER_123_527 VSS VDD FILLER2
XFILLER_162_162 VDD VSS DECAPHV8
X_11100_ _18653_/Q _18815_/Q VDD VSS _11101_/B XOR2X1
X_12080_ _12080_/A _12080_/B _14338_/B VDD VSS _12081_/B MIN3X1
XTAP_TAPCELL_ROW_151_1370 VDD VSS WELLTAP
XFILLER_162_195 VSS VDD FILLER2
X_11031_ _18651_/Q _18813_/Q VDD VSS _11032_/B XOR2X1
XFILLER_103_262 VSS VDD FILLER2
XFILLER_89_485 VSS VDD FILLER2
XFILLER_49_349 VDD VSS FILLER1
XFILLER_94_23 VDD VSS FILLER4
XFILLER_76_146 VDD VSS FILLER1
XFILLER_58_850 VSS VDD FILLER2
XFILLER_94_34 VSS VDD FILLER2
XFILLER_94_45 VDD VSS FILLER1
X_15770_ _15770_/A _15770_/B VDD VSS _19392_/D AND2X1
X_12982_ _12994_/B _12994_/C VDD VSS _14217_/B AND2X1
XFILLER_94_67 VDD VSS FILLER1
XFILLER_17_202 VSS VDD FILLER2
XFILLER_57_371 VDD VSS FILLER1
X_14721_ _19361_/Q _15736_/B VDD VSS _14722_/B XOR2X1
XFILLER_85_691 VDD VSS FILLER4
X_11933_ _11933_/A _14525_/B _11933_/C _11933_/D VDD VSS _11934_/A AO31X2
XFILLER_57_393 VSS VDD FILLER2
XFILLER_72_341 VSS VDD FILLER2
XFILLER_150_62 VDD VSS FILLER4
X_17440_ _17441_/C _17469_/B _17440_/C VDD VSS _19846_/D AND3BX1
X_14652_ _14652_/A _14652_/B _14652_/C _14652_/D VDD VSS _14739_/B AOAI211X1
XFILLER_45_577 VSS VDD FILLER2
XFILLER_150_73 VSS VDD FILLER2
X_11864_ _11864_/A _11864_/B _14366_/B VDD VSS _11867_/B MIN3X1
XTAP_TAPCELL_ROW_27_252 VDD VSS WELLTAP
XFILLER_60_514 VDD VSS FILLER4
XFILLER_33_728 VSS VDD FILLER2
XFILLER_45_599 VSS VDD FILLER2
X_13603_ _19055_/Q _14326_/B VDD VSS _13604_/D _14326_/C NAND3X1
XFILLER_60_536 VSS VDD FILLER2
X_17371_ _19832_/Q _19800_/Q VDD VSS _17377_/A XNOR2X1
X_10815_ _10813_/Y _10851_/B _11431_/A VDD VSS _18565_/D AND3BX1
X_14583_ _19493_/Q _15886_/B VDD VSS _14601_/B NAND2X1
X_11795_ _11828_/A _11828_/B VDD VSS _14489_/B XNOR2X1
Xclkbuf_1_0__f__09185_ clkbuf_0__09185_/Y VDD VSS _18479_/CK BUFX12
X_16322_ _19659_/Q _16817_/B VDD VSS _16348_/B XOR2X1
X_19110_ _19139_/CK _19110_/D _19110_/Q VDD VSS DFFQX1
X_13534_ _13623_/A _13696_/B VDD VSS _14359_/B XNOR2X1
XFILLER_43_60 VSS VDD FILLER2
XFILLER_41_772 VDD VSS FILLER1
X_10746_ _10947_/A _10746_/B _10746_/C VDD VSS _10746_/Y AOI21X1
XFILLER_158_446 VSS VDD FILLER2
XFILLER_40_271 VSS VDD FILLER2
XFILLER_13_496 VDD VSS FILLER1
X_19041_ _19068_/CK _19041_/D _19041_/Q VDD VSS DFFQX1
X_16253_ _16243_/A _16253_/B VDD VSS _16267_/B NOR2BX1
X_13465_ _19222_/Q _14515_/B VDD VSS _13557_/A NOR2X1
XFILLER_159_82 VSS VDD FILLER2
X_10677_ _18668_/Q _18776_/Q VDD VSS _10721_/A NAND2X1
XFILLER_139_682 VSS VDD FILLER2
X_15204_ _15812_/B _15812_/C _15204_/C VDD VSS _15205_/B OA21X2
X_12416_ _19156_/Q _12416_/B _12472_/D VDD VSS _12553_/C XNOR3X1
X_16184_ _19909_/Q VDD VSS _16703_/A INVX1
X_13396_ _13594_/A _13401_/C VDD VSS _14224_/B XNOR2X1
XFILLER_166_490 VDD VSS FILLER4
XFILLER_154_641 VSS VDD FILLER2
X_15135_ _19398_/Q _15777_/B VDD VSS _15137_/B NOR2X1
X_12347_ _18874_/Q VDD VSS _12349_/A INVX1
XFILLER_126_376 VSS VDD FILLER2
XFILLER_154_685 VDD VSS DECAPHV8
XFILLER_141_313 VDD VSS FILLER4
XFILLER_153_184 VSS VDD FILLER2
X_15066_ _19453_/Q _15112_/A _15085_/B VDD VSS _15092_/D XNOR3X1
X_19943_ _19943_/CK _19943_/D _19943_/Q VDD VSS DFFQX1
XFILLER_4_21 VSS VDD FILLER2
XFILLER_141_335 VDD VSS FILLER4
X_12278_ _12278_/A _12278_/B _14246_/B VDD VSS _12356_/B MIN3X1
XFILLER_141_357 VSS VDD FILLER2
X_14017_ _18895_/Q _14085_/A _14085_/B VDD VSS _14018_/D XNOR3X1
X_11229_ _11229_/A _11229_/B _11229_/C _11229_/D _11229_/E VDD VSS _11230_/B OAI221X1
XFILLER_110_700 VSS VDD FILLER2
X_19874_ clkload9/A _19874_/D _19874_/Q VDD VSS DFFQX1
XFILLER_68_614 VDD VSS FILLER4
XFILLER_4_76 VSS VDD FILLER2
XFILLER_67_102 VSS VDD FILLER2
XFILLER_122_593 VSS VDD FILLER2
X_18825_ _19943_/CK _18825_/D _18825_/Q VDD VSS DFFQX1
XFILLER_110_755 VSS VDD FILLER2
XFILLER_95_455 VDD VSS FILLER4
XFILLER_95_477 VSS VDD FILLER2
XFILLER_83_617 VSS VDD FILLER2
XFILLER_55_308 VSS VDD FILLER2
X_18756_ _19939_/CK _18756_/D _18756_/Q VDD VSS DFFQX1
XFILLER_95_488 VDD VSS FILLER1
X_15968_ _19614_/Q _16766_/B VDD VSS _15971_/A XNOR2X1
X_17707_ _17705_/B _17707_/B VDD VSS _17708_/C NOR2BX1
X_14919_ _19477_/Q _15868_/B _15868_/C VDD VSS _14920_/D NOR3BX1
XFILLER_36_544 VDD VSS FILLER4
X_15899_ _15906_/A _15899_/B VDD VSS _19505_/D NOR2X1
X_18687_ _18795_/CK _18687_/D _18687_/Q VDD VSS DFFQX1
XFILLER_91_650 VDD VSS FILLER1
XFILLER_91_661 VSS VDD FILLER2
XFILLER_63_352 VSS VDD FILLER2
XFILLER_51_503 VDD VSS DECAPHV16
X_17638_ _17638_/A _17638_/B _17638_/C VDD VSS _17646_/A OA21X2
XFILLER_90_160 VSS VDD FILLER2
XFILLER_51_525 VSS VDD FILLER2
XFILLER_90_182 VSS VDD FILLER2
XFILLER_51_547 VSS VDD FILLER2
Xclkbuf_leaf_16__002_ clkload16/A VDD VSS _18788_/CK BUFX12
X_17569_ _17570_/B _17569_/B VDD VSS _17571_/B NOR2BX1
XFILLER_90_0 VDD VSS FILLER1
X_19308_ _19314_/CK _19308_/D _19308_/Q VDD VSS DFFQX1
XTAP_TAPCELL_ROW_61_564 VDD VSS WELLTAP
XFILLER_149_468 VDD VSS FILLER4
XFILLER_31_282 VSS VDD FILLER2
X_19239_ _19269_/CK _19239_/D _19239_/Q VDD VSS DFFQX1
XFILLER_136_107 VDD VSS FILLER4
XFILLER_164_416 VSS VDD FILLER2
XFILLER_164_427 VDD VSS FILLER1
XFILLER_118_833 VSS VDD FILLER2
XFILLER_145_663 VDD VSS FILLER4
XFILLER_133_814 VDD VSS FILLER4
XFILLER_155_18 VDD VSS FILLER4
XFILLER_133_825 VSS VDD FILLER2
XFILLER_145_685 VSS VDD FILLER2
XFILLER_160_666 VDD VSS DECAPHV8
XFILLER_59_603 VSS VDD FILLER2
XFILLER_98_260 VDD VSS FILLER4
XFILLER_58_102 VDD VSS FILLER4
X_20014_ clkload7/A _20014_/D _20014_/Q _20071_/RB VDD VSS DFFRQX1
XFILLER_58_113 VDD VSS FILLER1
X_09825_ _11039_/C VDD VSS _11208_/A BUFX3
XFILLER_48_49 VDD VSS FILLER4
XTAP_TAPCELL_ROW_69_631 VDD VSS WELLTAP
XFILLER_101_777 VSS VDD FILLER2
Xclkbuf_0__09179_ _18228_/ECK VDD VSS clkbuf_0__09179_/Y BUFX12
X_09756_ _18307_/Q _09812_/B _09784_/B _18467_/Q VDD VSS _09759_/A AOI22X1
XFILLER_58_179 VDD VSS FILLER4
XFILLER_74_639 VSS VDD FILLER2
XFILLER_73_105 VSS VDD FILLER2
XFILLER_39_360 VDD VSS DECAPHV8
XFILLER_104_44 VSS VDD FILLER2
XFILLER_100_287 VDD VSS FILLER4
XFILLER_55_831 VDD VSS FILLER1
XFILLER_64_26 VDD VSS DECAPHV8
X_09687_ _18399_/Q VDD VSS _20140_/A INVX1
XFILLER_27_566 VSS VDD FILLER2
XFILLER_54_352 VSS VDD FILLER2
XFILLER_42_503 VDD VSS DECAPHV8
XFILLER_161_6 VDD VSS FILLER1
XFILLER_42_514 VDD VSS FILLER4
XFILLER_27_588 VSS VDD FILLER2
XFILLER_81_171 VSS VDD FILLER2
XFILLER_154_5 VSS VDD FILLER2
XTAP_TAPCELL_ROW_24_233 VDD VSS WELLTAP
XFILLER_30_709 VSS VDD FILLER2
X_10600_ _10649_/A _10649_/B _10601_/C _10763_/A VDD VSS _10601_/D AOI31X1
XFILLER_23_772 VSS VDD FILLER2
X_11580_ _18726_/Q _11589_/B VDD VSS _18753_/D AND2X1
XFILLER_80_69 VDD VSS DECAPHV8
XFILLER_10_433 VSS VDD FILLER2
X_10531_ _19944_/Q _18826_/Q VDD VSS _10556_/B XOR2X1
XFILLER_10_455 VSS VDD FILLER2
XFILLER_6_404 VDD VSS FILLER4
X_13250_ _13329_/A _13329_/B VDD VSS _14479_/C _13329_/C NAND3X1
XFILLER_148_490 VDD VSS FILLER1
X_10462_ _10462_/A _10462_/B _10462_/C _10462_/D VDD VSS _10535_/B AND4X2
XFILLER_10_499 VDD VSS FILLER4
XFILLER_13_96 VDD VSS FILLER4
XFILLER_89_12 VDD VSS FILLER1
X_12201_ _18985_/Q _12201_/B _12201_/C VDD VSS _12278_/B MIN3X1
XFILLER_89_34 VDD VSS FILLER4
XFILLER_129_96 VDD VSS FILLER4
X_13181_ _13181_/A _13181_/B _14122_/B VDD VSS _13182_/B MIN3X1
X_10393_ _11378_/A _10393_/B _10431_/B VDD VSS _18554_/D AND3BX1
XFILLER_89_78 VSS VDD FILLER2
XFILLER_163_482 VDD VSS FILLER1
X_12132_ _12132_/A _12132_/B _14242_/B VDD VSS _12201_/B MIN3X1
XFILLER_151_644 VSS VDD FILLER2
XTAP_TAPCELL_ROW_0_11 VDD VSS WELLTAP
XFILLER_145_62 VDD VSS FILLER1
XFILLER_151_688 VSS VDD FILLER2
X_16940_ _16976_/A _16940_/B VDD VSS _19743_/D NOR2X1
X_12063_ _19095_/Q _12255_/B _12137_/C VDD VSS _12284_/C XNOR3X1
XFILLER_151_699 VSS VDD FILLER2
XFILLER_77_400 VSS VDD FILLER2
XFILLER_77_422 VSS VDD FILLER2
XFILLER_49_113 VDD VSS FILLER4
X_11014_ _11014_/A _11014_/B _11014_/C VDD VSS _11014_/Y AOI21X1
XFILLER_89_282 VDD VSS DECAPHV16
X_16871_ _16876_/A _16871_/B VDD VSS _19708_/D NOR2X1
XFILLER_65_606 VSS VDD FILLER2
X_18610_ _18612_/CK _18610_/D _18610_/Q VDD VSS DFFQX1
X_15822_ _15849_/A _15822_/B VDD VSS _19437_/D AND2X1
XFILLER_49_168 VSS VDD FILLER2
X_19590_ _19664_/CK _19590_/D _19590_/Q VDD VSS DFFQX1
XFILLER_49_179 VDD VSS FILLER1
XFILLER_46_820 VDD VSS DECAPHV8
XFILLER_161_50 VDD VSS FILLER1
XFILLER_58_691 VDD VSS FILLER4
X_15753_ _15770_/A _15753_/B VDD VSS _19376_/D AND2X1
X_18541_ _18543_/CK _18541_/D _18541_/Q VDD VSS DFFQX1
X_12965_ _12968_/D _14539_/B VDD VSS _13133_/A NAND2X1
XFILLER_92_458 VSS VDD FILLER2
XFILLER_161_83 VDD VSS FILLER1
XFILLER_73_650 VDD VSS FILLER1
XTAP_TAPCELL_ROW_9_97 VDD VSS WELLTAP
XFILLER_45_352 VDD VSS DECAPHV8
X_14704_ _14737_/A _14737_/B _14737_/C VDD VSS _14775_/A OA21X2
X_11916_ _11916_/A _11916_/B _11916_/C _11916_/D VDD VSS _11922_/B AOAI211X1
XTAP_TAPCELL_ROW_75_689 VDD VSS WELLTAP
XFILLER_33_503 VSS VDD FILLER2
XFILLER_18_577 VSS VDD FILLER2
X_15684_ _15706_/A _15684_/B VDD VSS _19313_/D AND2X1
X_18472_ _18479_/CK _18525_/Q _20117_/A _18498_/RB VDD VSS DFFRQX1
XFILLER_73_683 VSS VDD FILLER2
X_12896_ _12896_/A _12896_/B _12896_/C _12896_/D VDD VSS _12900_/B OAOI211X1
XFILLER_72_160 VSS VDD FILLER2
XFILLER_33_536 VSS VDD FILLER2
X_17423_ _19843_/Q _19811_/Q VDD VSS _17425_/B XOR2X1
X_14635_ _19414_/Q _14635_/B _14635_/C VDD VSS _14669_/B MIN3X1
XFILLER_61_856 VDD VSS FILLER1
XFILLER_33_547 VDD VSS FILLER1
X_11847_ _19175_/Q _11918_/A _11918_/B VDD VSS _11874_/D XNOR3X1
XFILLER_159_700 VDD VSS FILLER4
XFILLER_33_569 VSS VDD FILLER2
XFILLER_54_92 VSS VDD FILLER2
X_17354_ _17355_/A _17357_/C _17363_/C VDD VSS _17355_/C OAI21X1
X_14566_ _20005_/Q _14569_/B VDD VSS _19269_/D AND2X1
X_11778_ _11778_/A _11778_/B _11778_/C _11778_/D VDD VSS _11804_/B OAOI211X1
Xclkbuf_1_0__f__09168_ clkbuf_0__09168_/Y VDD VSS _18391_/CK BUFX12
XFILLER_13_282 VSS VDD FILLER2
XFILLER_158_243 VDD VSS FILLER4
X_16305_ _16305_/A _16305_/B VDD VSS _16332_/B NAND2X1
X_13517_ _13607_/A _13683_/B VDD VSS _14261_/B XNOR2X1
XFILLER_159_777 VSS VDD FILLER2
X_17285_ _17289_/A _17286_/B _17306_/C VDD VSS _17286_/C OAI21X1
X_10729_ _18695_/Q _18749_/Q _10729_/C _10729_/D _10729_/E VDD VSS _10765_/C AOI221X1
X_14497_ _15817_/A VDD VSS _14539_/A BUFX3
X_16236_ _16236_/A _19911_/Q _16236_/C VDD VSS _16258_/C MIN3X1
X_19024_ _19094_/CK _19024_/D _19024_/Q VDD VSS DFFQX1
Xclkload12 _19825_/CK VDD VSS clkload12/Y INVX1
X_13448_ _19222_/Q _13462_/B _13464_/B VDD VSS _13457_/D XNOR3X1
Xclkload23 _19963_/CK VDD VSS clkload23/Y INVX8
XFILLER_127_641 VSS VDD FILLER2
Xclkload34 _20013_/CK VDD VSS clkload34/Y INVX2
XFILLER_127_663 VDD VSS FILLER4
Xclkload45 _19094_/CK VDD VSS clkload45/Y BUFX12
X_16167_ _16177_/A _16177_/B VDD VSS _16846_/B XNOR2X1
Xclkload56 _19996_/CK VDD VSS clkload56/Y INVX1
Xclkload67 _18961_/CK VDD VSS clkload67/Y INVX1
X_13379_ _13502_/A _13578_/B VDD VSS _13496_/C XNOR2X1
XTAP_TAPCELL_ROW_117_1062 VDD VSS WELLTAP
XFILLER_126_162 VSS VDD FILLER2
Xclkload78 _19465_/CK VDD VSS clkload78/Y INVX1
XFILLER_154_471 VSS VDD FILLER2
XFILLER_114_313 VSS VDD FILLER2
X_15118_ _19398_/Q _15777_/B VDD VSS _15119_/B XNOR2X1
Xclkload89 _19379_/CK VDD VSS clkload89/Y BUFX12
XFILLER_154_493 VSS VDD FILLER2
X_16098_ _19714_/Q _16878_/B VDD VSS _16103_/B XOR2X1
XFILLER_142_666 VDD VSS DECAPHV16
XFILLER_130_828 VDD VSS FILLER4
X_15049_ _19452_/Q _15837_/B _15837_/C VDD VSS _15092_/C NOR3BX1
X_19926_ clkload2/A _19926_/D _19926_/Q VDD VSS DFFQX1
XFILLER_68_400 VSS VDD FILLER2
XFILLER_141_176 VDD VSS FILLER4
XFILLER_68_411 VDD VSS FILLER1
X_19857_ _19880_/CK _19857_/D _19857_/Q VDD VSS DFFQX1
X_09610_ _09626_/B _20183_/A VDD VSS _09611_/C NAND2X1
X_18808_ _18810_/CK _18808_/D _18808_/Q VDD VSS DFFQX1
XFILLER_110_574 VDD VSS FILLER1
XFILLER_68_488 VDD VSS FILLER1
X_19788_ _19791_/CK _19788_/D _19788_/Q VDD VSS DFFQX1
XFILLER_49_691 VSS VDD FILLER2
X_09541_ _20035_/Q _09547_/B VDD VSS _20036_/D NOR2BX1
XFILLER_55_138 VSS VDD FILLER2
X_18739_ _18767_/CK _18739_/D _18739_/Q VDD VSS DFFQX1
XTAP_TAPCELL_ROW_38_358 VDD VSS WELLTAP
X_09472_ _19975_/Q _09490_/B _09476_/C VDD VSS _09473_/C AOI21X1
XFILLER_24_514 VDD VSS DECAPHV8
XFILLER_52_856 VDD VSS FILLER1
XFILLER_63_193 VDD VSS FILLER1
XTAP_TAPCELL_ROW_21_203 VDD VSS WELLTAP
XFILLER_149_254 VDD VSS FILLER1
XFILLER_32_591 VSS VDD FILLER2
Xclkload6 clkload6/A VDD VSS clkload6/Y INVX2
XFILLER_20_753 VDD VSS FILLER1
XFILLER_149_276 VSS VDD FILLER2
XFILLER_50_28 VDD VSS FILLER1
XFILLER_165_747 VSS VDD FILLER2
XFILLER_137_449 VSS VDD FILLER2
XFILLER_20_797 VDD VSS FILLER1
XFILLER_164_235 VSS VDD FILLER2
XFILLER_118_641 VDD VSS FILLER4
XFILLER_165_769 VSS VDD FILLER2
XFILLER_152_408 VDD VSS FILLER1
XFILLER_117_151 VDD VSS FILLER1
XFILLER_118_696 VDD VSS FILLER1
XFILLER_160_441 VSS VDD FILLER2
XFILLER_105_357 VSS VDD FILLER2
XFILLER_160_463 VSS VDD FILLER2
XFILLER_105_379 VSS VDD FILLER2
Xfanout210 _09284_/AB VDD VSS _20054_/RB BUFX3
Xfanout221 _20081_/RB VDD VSS _20080_/RB BUFX3
XFILLER_59_411 VSS VDD FILLER2
XFILLER_59_422 VDD VSS FILLER1
XFILLER_87_742 VSS VDD FILLER2
XFILLER_87_753 VDD VSS DECAPHV16
XFILLER_86_230 VSS VDD FILLER2
XFILLER_86_252 VSS VDD FILLER2
X_09808_ _18343_/Q VDD VSS _20097_/A INVX1
XFILLER_59_477 VSS VDD FILLER2
XFILLER_19_308 VSS VDD FILLER2
XFILLER_47_639 VSS VDD FILLER2
X_09739_ _20111_/A _20127_/A _09773_/D VDD VSS _09740_/C MUXI2X1
XFILLER_74_458 VDD VSS FILLER4
XFILLER_43_801 VSS VDD FILLER2
X_12750_ _12832_/A _12832_/B _12832_/C VDD VSS _14508_/B AOI21X1
XFILLER_43_823 VDD VSS FILLER4
XFILLER_42_311 VSS VDD FILLER2
X_11701_ _19989_/Q _19253_/Q VDD VSS _11742_/A NAND2X1
XTAP_TAPCELL_ROW_72_659 VDD VSS WELLTAP
X_12681_ _12832_/B _12682_/C _19214_/Q VDD VSS _12683_/C AOI21X1
XFILLER_15_569 VDD VSS FILLER4
X_14420_ _14381_/Y _14420_/B _14420_/C VDD VSS _19139_/D AND3BX1
X_11632_ _18774_/Q _11635_/B VDD VSS _18801_/D AND2X1
XFILLER_23_580 VDD VSS FILLER4
XFILLER_11_742 VSS VDD FILLER2
X_14351_ _14415_/A _14351_/B VDD VSS _19077_/D AND2X1
X_11563_ _18711_/Q _11567_/B VDD VSS _18738_/D AND2X1
XFILLER_11_764 VDD VSS FILLER4
XFILLER_128_416 VSS VDD FILLER2
X_13302_ _13395_/A _13395_/B VDD VSS _13400_/C _13395_/C NAND3X1
XFILLER_10_263 VSS VDD FILLER2
X_17070_ _17073_/C _17070_/B VDD VSS _17071_/B XNOR2X1
X_10514_ _10514_/A _10514_/B _10514_/C _10514_/D VDD VSS _10570_/A AOAI211X1
X_14282_ _14334_/A _14282_/B VDD VSS _19016_/D AND2X1
X_11494_ _18649_/Q _11496_/B VDD VSS _18676_/D AND2X1
X_16021_ _19707_/Q _16870_/B VDD VSS _16022_/D NAND2X1
XFILLER_6_245 VSS VDD FILLER2
X_13233_ _13233_/A _14446_/B _13233_/C _13233_/D VDD VSS _13443_/A AOAI211X1
X_10445_ _19942_/Q _18824_/Q VDD VSS _10446_/A XNOR2X1
X_13164_ _13271_/A _13271_/B _13271_/C VDD VSS _13165_/C AO21X2
X_10376_ _18659_/Q _18767_/Q VDD VSS _10406_/A NAND2X1
XFILLER_123_132 VDD VSS FILLER1
XFILLER_151_452 VDD VSS DECAPHV8
XFILLER_97_506 VSS VDD FILLER2
X_12115_ _19179_/Q _14465_/B _14465_/C VDD VSS _12116_/D OR3BX1
XFILLER_151_474 VSS VDD FILLER2
X_17972_ _17970_/Y _17972_/B _17986_/C VDD VSS _19960_/D AND3BX1
X_13095_ _13095_/A _13095_/B _13095_/C _13095_/D VDD VSS _14290_/C OAI211X1
XFILLER_2_462 VDD VSS FILLER4
XFILLER_111_327 VSS VDD FILLER2
XFILLER_151_496 VSS VDD FILLER2
X_19711_ _19724_/CK _19711_/D _19711_/Q VDD VSS DFFQX1
X_16923_ _19738_/Q _19739_/Q wire164/Y VDD VSS _16928_/A MIN3X1
X_12046_ _19206_/Q _14495_/B VDD VSS _12113_/D _14495_/C NAND3X1
XFILLER_77_230 VSS VDD FILLER2
XFILLER_49_92 VDD VSS FILLER1
XFILLER_38_617 VSS VDD FILLER2
X_19642_ _19702_/CK _19642_/D _19642_/Q VDD VSS DFFQX1
X_16854_ _16859_/A _16854_/B VDD VSS _19693_/D AND2X1
XFILLER_78_797 VDD VSS FILLER1
XFILLER_1_22 VSS VDD FILLER2
XFILLER_1_44 VDD VSS FILLER4
X_15805_ _14522_/Y _15805_/B _15805_/C VDD VSS _19422_/D AND3BX1
X_19573_ _19573_/CK _19573_/D _19573_/Q VDD VSS DFFQX1
XFILLER_37_149 VSS VDD FILLER2
X_16785_ _16793_/A _16785_/B VDD VSS _19631_/D AND2X1
X_13997_ _14038_/A _14169_/B VDD VSS _14054_/B NOR2X1
XFILLER_34_801 VDD VSS FILLER1
X_18524_ _18524_/CK _18524_/D _18524_/Q _09304_/Y VDD VSS DFFRQX1
X_15736_ _15743_/A _15736_/B VDD VSS _19361_/D AND2X1
X_12948_ _13032_/A _14476_/B _14476_/C VDD VSS _13108_/C NOR3X1
XFILLER_92_288 VSS VDD FILLER2
XFILLER_45_160 VSS VDD FILLER2
XTAP_TAPCELL_ROW_35_328 VDD VSS WELLTAP
X_18455_ _18455_/CK _18455_/D _18455_/Q _20054_/RB VDD VSS DFFRQX1
X_15667_ _15660_/A _15667_/B _15667_/C VDD VSS _15671_/C AOI2B1X1
X_12879_ _12886_/A _13180_/B _14153_/B VDD VSS _12885_/C XNOR3X1
XFILLER_60_130 VDD VSS DECAPHV8
XFILLER_33_355 VDD VSS FILLER4
X_17406_ _17675_/A _17406_/B VDD VSS _19839_/D NOR2X1
XFILLER_61_686 VDD VSS FILLER1
X_14618_ _19495_/Q _15888_/B VDD VSS _14645_/A NAND2X1
XFILLER_60_174 VSS VDD FILLER2
X_15598_ _15823_/B _19438_/Q VDD VSS _15599_/D NAND2BX1
X_18386_ _18389_/CK _18386_/D _18386_/Q _18442_/RB VDD VSS DFFRQX1
X_17337_ _19824_/Q _19792_/Q VDD VSS _17338_/C NAND2X1
X_14549_ _19989_/Q _14558_/B VDD VSS _19253_/D AND2X1
XFILLER_147_725 VDD VSS FILLER1
XFILLER_147_747 VDD VSS FILLER4
XFILLER_119_449 VDD VSS DECAPHV16
XFILLER_146_235 VSS VDD FILLER2
X_17268_ _19810_/Q _19778_/Q VDD VSS _17269_/B XOR2X1
Xclkload101 _19584_/CK VDD VSS clkload101/Y BUFX12
XFILLER_146_246 VDD VSS FILLER1
Xclkload112 _20080_/CK VDD VSS clkload112/Y INVX6
Xclkload123 _18437_/CK VDD VSS clkload123/Y INVX2
X_19007_ _19171_/CK _19007_/D _19007_/Q VDD VSS DFFQX1
XFILLER_146_279 VDD VSS FILLER1
X_16219_ _16219_/A _16227_/B VDD VSS _16883_/B XNOR2X1
XFILLER_115_600 VSS VDD FILLER2
X_17199_ _19794_/Q _19762_/Q _17199_/C VDD VSS _17204_/C AO21X2
XFILLER_155_780 VSS VDD FILLER2
XFILLER_53_0 VSS VDD FILLER2
XFILLER_161_227 VDD VSS FILLER1
XFILLER_127_493 VSS VDD FILLER2
XFILLER_115_644 VDD VSS FILLER4
XFILLER_115_699 VDD VSS FILLER1
XFILLER_142_496 VSS VDD FILLER2
X_19909_ clkload8/A _19909_/D _19909_/Q VDD VSS DFFQX1
XFILLER_68_230 VSS VDD FILLER2
XFILLER_96_550 VDD VSS DECAPHV8
XFILLER_84_712 VSS VDD FILLER2
XFILLER_56_414 VDD VSS FILLER4
XFILLER_56_447 VDD VSS FILLER1
XFILLER_56_458 VSS VDD FILLER2
XFILLER_45_17 VSS VDD FILLER2
XFILLER_37_650 VDD VSS FILLER1
XFILLER_71_406 VSS VDD FILLER2
X_09524_ _20021_/Q _09526_/B _18197_/D VDD VSS _18202_/B AOI21X1
XFILLER_83_277 VSS VDD FILLER2
XFILLER_37_683 VDD VSS FILLER4
XFILLER_24_300 VSS VDD FILLER2
X_09455_ _18442_/D _09468_/B _09455_/C VDD VSS _18255_/D AOI21X1
XFILLER_51_152 VSS VDD FILLER2
XFILLER_61_16 VSS VDD FILLER2
X_09386_ _17906_/C VDD VSS _18163_/A BUFX3
XFILLER_101_89 VDD VSS FILLER4
XFILLER_137_224 VSS VDD FILLER2
XFILLER_138_747 VSS VDD FILLER2
XFILLER_124_6 VDD VSS FILLER1
XTAP_TAPCELL_ROW_137_1246 VDD VSS WELLTAP
X_10230_ _18594_/Q _10230_/B VDD VSS _10231_/B NOR2BX1
XFILLER_105_121 VSS VDD FILLER2
XFILLER_152_249 VDD VSS FILLER4
XFILLER_106_666 VSS VDD FILLER2
XFILLER_79_517 VSS VDD FILLER2
XFILLER_121_614 VSS VDD FILLER2
X_10161_ _10172_/A _10161_/B VDD VSS _11419_/C XNOR2X1
XFILLER_126_64 VSS VDD FILLER2
XFILLER_86_13 VSS VDD FILLER2
XFILLER_160_271 VDD VSS FILLER4
X_10092_ _10069_/Y _10091_/Y _10155_/A VDD VSS _10146_/B MUXI2X1
XFILLER_94_509 VSS VDD FILLER2
XFILLER_59_230 VSS VDD FILLER2
XTAP_TAPCELL_ROW_77_707 VDD VSS WELLTAP
XFILLER_87_561 VDD VSS DECAPHV16
XFILLER_75_701 VDD VSS FILLER1
X_13920_ _13987_/A _13987_/B _13987_/D _13987_/C VDD VSS _14001_/B AOAI211X1
XTAP_TAPCELL_ROW_148_1342 VDD VSS WELLTAP
XFILLER_74_200 VSS VDD FILLER2
XFILLER_75_734 VSS VDD FILLER2
XFILLER_19_127 VSS VDD FILLER2
X_13851_ _13849_/Y _19059_/Q _14331_/C VDD VSS _13912_/E NAND3BX1
XFILLER_19_149 VSS VDD FILLER2
XFILLER_90_704 VSS VDD FILLER2
XFILLER_75_778 VSS VDD FILLER2
XFILLER_62_406 VSS VDD FILLER2
X_12802_ _19021_/Q VDD VSS _12906_/A INVX1
XFILLER_28_672 VSS VDD FILLER2
X_16570_ _19636_/Q VDD VSS _16571_/A INVX1
X_13782_ _19058_/Q _14329_/B VDD VSS _13783_/D _14329_/C AND3X2
XFILLER_74_288 VDD VSS FILLER4
X_10994_ _10990_/B _18570_/Q VDD VSS _11023_/D NOR2BX1
XFILLER_28_694 VSS VDD FILLER2
X_15521_ _15546_/C _15521_/B VDD VSS _15821_/B OR2X2
X_12733_ _12910_/A _12910_/B VDD VSS _14380_/B XNOR2X1
XFILLER_35_50 VSS VDD FILLER2
Xclkbuf_2_3__f__09182_ clkbuf_0__09182_/Y VDD VSS _18578_/CK BUFX12
XFILLER_31_826 VSS VDD FILLER2
XFILLER_15_377 VDD VSS FILLER1
X_15452_ _15465_/A _15465_/B VDD VSS _15755_/B XNOR2X1
X_18240_ _18240_/CK _18240_/D _18240_/Q _18486_/RB VDD VSS DFFRQX1
XFILLER_70_472 VSS VDD FILLER2
X_12664_ _19186_/Q _14473_/B _14473_/C VDD VSS _12771_/E OR3BX1
XTAP_TAPCELL_ROW_6_65 VDD VSS WELLTAP
XFILLER_30_314 VDD VSS FILLER4
X_14403_ _14410_/A _14403_/B _14403_/C VDD VSS _19124_/D NOR3X1
XFILLER_42_196 VSS VDD FILLER2
X_11615_ _18758_/Q _11624_/B VDD VSS _18785_/D AND2X1
X_15383_ _15383_/A VDD VSS _15674_/A BUFX3
X_18171_ _19300_/Q _18174_/B VDD VSS _18172_/B XOR2X1
X_12595_ _12640_/A _12732_/B _12724_/C VDD VSS _12804_/B XNOR3X1
XFILLER_11_561 VDD VSS FILLER4
XFILLER_129_747 VSS VDD FILLER2
XFILLER_156_522 VDD VSS FILLER4
XFILLER_128_224 VDD VSS DECAPHV8
X_17122_ _17536_/A _17122_/B _17123_/C VDD VSS _19778_/D NOR3X1
X_14334_ _14334_/A _14334_/B VDD VSS _19062_/D AND2X1
XFILLER_128_235 VDD VSS FILLER4
X_11546_ _18695_/Q _11555_/B VDD VSS _18722_/D AND2X1
XTAP_TAPCELL_ROW_40_375 VDD VSS WELLTAP
XFILLER_7_543 VDD VSS FILLER1
X_17053_ _19762_/Q _19763_/Q _17073_/B VDD VSS _17062_/D OAI21X1
XFILLER_144_728 VSS VDD FILLER2
X_14265_ _14255_/Y _14265_/B _14265_/C VDD VSS _19003_/D AND3BX1
XFILLER_143_216 VSS VDD FILLER2
X_11477_ _18633_/Q _11484_/B VDD VSS _18660_/D AND2X1
X_16004_ _19679_/Q _16838_/B VDD VSS _16030_/B XOR2X1
X_13216_ _13422_/B VDD VSS _14323_/B BUFX3
X_10428_ _10595_/A _10503_/B VDD VSS _10433_/B NAND2X1
X_14196_ _14136_/Y _14196_/B _14196_/C VDD VSS _18946_/D AND3BX1
XTAP_TAPCELL_ROW_114_1043 VDD VSS WELLTAP
XFILLER_98_804 VDD VSS FILLER1
XFILLER_112_603 VDD VSS FILLER1
XFILLER_152_772 VDD VSS FILLER4
X_13147_ _19248_/Q _13345_/A _13343_/A VDD VSS _13444_/D XNOR3X1
XFILLER_3_760 VSS VDD FILLER2
XFILLER_112_625 VDD VSS FILLER4
X_10359_ _10579_/D _10359_/B VDD VSS _10435_/A NOR2X1
XFILLER_151_282 VSS VDD FILLER2
XFILLER_3_793 VSS VDD FILLER2
XFILLER_32_5 VSS VDD FILLER2
XFILLER_111_124 VSS VDD FILLER2
X_17955_ _17955_/A _17955_/B _17955_/C VDD VSS _19957_/D AOI21X1
X_13078_ _13183_/A _13081_/B _13081_/C VDD VSS _17891_/B XNOR3X1
XFILLER_85_509 VDD VSS FILLER1
XFILLER_25_4 VSS VDD FILLER2
X_16906_ _20067_/Q _20023_/Q _16906_/C VDD VSS _16906_/Y AOI21X1
X_12029_ _12029_/A _12029_/B _12029_/C _12029_/D VDD VSS _12116_/B AOAI211X1
X_17886_ _18855_/Q _17891_/B VDD VSS _17888_/B XOR2X1
XFILLER_66_734 VSS VDD FILLER2
XFILLER_66_745 VDD VSS FILLER1
XFILLER_38_447 VSS VDD FILLER2
X_19625_ _19661_/CK _19625_/D _19625_/Q VDD VSS DFFQX1
X_16837_ _16838_/A _16837_/B VDD VSS _19678_/D NOR2X1
XFILLER_65_244 VSS VDD FILLER2
XFILLER_38_458 VSS VDD FILLER2
XTAP_TAPCELL_ROW_48_442 VDD VSS WELLTAP
XFILLER_66_778 VDD VSS FILLER4
XFILLER_19_650 VDD VSS FILLER1
XFILLER_53_417 VDD VSS FILLER1
XFILLER_65_277 VSS VDD FILLER2
XFILLER_19_672 VDD VSS FILLER4
X_19556_ _19584_/CK _19556_/D _19556_/Q VDD VSS DFFQX1
XFILLER_65_288 VDD VSS FILLER1
X_16768_ _16768_/A _16768_/B VDD VSS _19616_/D AND2X1
XFILLER_46_491 VDD VSS FILLER1
XFILLER_34_631 VDD VSS DECAPHV8
XFILLER_18_182 VDD VSS FILLER4
X_18507_ _18507_/CK _18507_/D _18507_/Q _09356_/Y VDD VSS DFFRQX1
X_15719_ _15725_/A _15719_/B VDD VSS _19345_/D AND2X1
X_19487_ _19736_/CK _19487_/D _19487_/Q VDD VSS DFFQX1
X_16699_ _16699_/A _16704_/B VDD VSS _19553_/D NOR2X1
XFILLER_22_815 VSS VDD FILLER2
X_09240_ _18510_/Q VDD VSS _18345_/D INVX1
X_18438_ _18439_/CK _18470_/D _18438_/Q _18471_/RB VDD VSS DFFRQX1
XFILLER_33_174 VSS VDD FILLER2
XFILLER_21_347 VDD VSS FILLER4
XFILLER_166_308 VDD VSS FILLER4
X_18369_ _18374_/CK _18497_/D _20206_/A _18464_/RB VDD VSS DFFRQX1
XFILLER_147_511 VSS VDD FILLER2
XFILLER_119_246 VSS VDD FILLER2
XFILLER_147_555 VSS VDD FILLER2
XFILLER_162_514 VSS VDD FILLER2
Xoutput19 _20088_/Y VDD VSS o_aux_ctrl[6] BUFX3
XFILLER_115_452 VDD VSS FILLER4
XFILLER_115_463 VSS VDD FILLER2
XFILLER_143_772 VSS VDD FILLER2
XFILLER_130_400 VSS VDD FILLER2
X_20193_ _20193_/A VDD VSS _20193_/Y BUFX3
XFILLER_142_271 VSS VDD FILLER2
XTAP_TAPCELL_ROW_132_1198 VDD VSS WELLTAP
XFILLER_130_455 VSS VDD FILLER2
XFILLER_76_509 VSS VDD FILLER2
XFILLER_102_157 VSS VDD FILLER2
XFILLER_130_477 VDD VSS FILLER1
XFILLER_69_561 VSS VDD FILLER2
XFILLER_69_583 VDD VSS FILLER4
XFILLER_56_200 VDD VSS FILLER4
XFILLER_84_520 VDD VSS DECAPHV16
XFILLER_84_542 VDD VSS FILLER4
XFILLER_56_49 VSS VDD FILLER2
XFILLER_56_244 VSS VDD FILLER2
XFILLER_56_266 VSS VDD FILLER2
XFILLER_112_33 VSS VDD FILLER2
XFILLER_72_748 VSS VDD FILLER2
XFILLER_25_620 VDD VSS FILLER4
XFILLER_25_631 VSS VDD FILLER2
X_09507_ _18524_/Q _09507_/B _09507_/C _20081_/Q VDD VSS _20081_/D AO22X2
XTAP_TAPCELL_ROW_82_754 VDD VSS WELLTAP
XFILLER_24_130 VSS VDD FILLER2
X_09438_ _09446_/A _09753_/D VDD VSS _18217_/E NOR2X1
XFILLER_25_697 VDD VSS FILLER4
XFILLER_40_623 VSS VDD FILLER2
XFILLER_12_347 VSS VDD FILLER2
XFILLER_157_319 VSS VDD FILLER2
X_09369_ _18526_/Q _09369_/B _18507_/Q VDD VSS _09422_/B NOR3X1
XFILLER_12_369 VDD VSS FILLER4
XFILLER_166_831 VSS VDD FILLER2
X_11400_ _18010_/A VDD VSS _17566_/A BUFX3
XFILLER_138_544 VSS VDD FILLER2
X_12380_ _12380_/A _14375_/B _12380_/C _12380_/D VDD VSS _12593_/A OAOI211X2
XFILLER_138_555 VDD VSS DECAPHV8
X_11331_ _11331_/A _11339_/B VDD VSS _11336_/B XOR2X1
XFILLER_125_205 VDD VSS DECAPHV8
XFILLER_21_41 VSS VDD FILLER2
XFILLER_125_227 VSS VDD FILLER2
XFILLER_153_536 VDD VSS FILLER1
X_14050_ _17959_/A _17959_/B _17960_/C VDD VSS _17963_/B OAI21X1
XFILLER_137_52 VSS VDD FILLER2
X_11262_ _18580_/Q _11262_/B _11262_/C VDD VSS _11271_/A MIN3X1
XFILLER_21_96 VDD VSS FILLER4
XFILLER_97_23 VDD VSS FILLER4
X_13001_ wire156/Y _13008_/B _13008_/D _13008_/C VDD VSS _14256_/C OAI211X1
X_10213_ _11384_/A _10213_/B VDD VSS _10213_/Y XNOR2X1
XFILLER_134_783 VDD VSS FILLER4
XFILLER_137_96 VSS VDD FILLER2
X_11193_ _18683_/Q _18791_/Q VDD VSS _11194_/B XOR2X1
XFILLER_133_282 VSS VDD FILLER2
XFILLER_121_433 VSS VDD FILLER2
XFILLER_121_444 VDD VSS FILLER4
X_10144_ _10190_/B _10166_/B VDD VSS _10145_/C NOR2X1
XFILLER_79_358 VSS VDD FILLER2
XFILLER_95_818 VDD VSS FILLER4
XFILLER_0_763 VSS VDD FILLER2
XFILLER_121_488 VSS VDD FILLER2
X_17740_ _19910_/Q _19878_/Q _17740_/C VDD VSS _17745_/C AO21X2
XFILLER_94_328 VSS VDD FILLER2
X_14952_ _19338_/Q _14952_/B _15711_/B VDD VSS _14991_/B MIN3X1
X_10075_ _10075_/A _10075_/B _10075_/C _10075_/D VDD VSS _10076_/B OAI211X1
XFILLER_102_680 VDD VSS DECAPHV8
XFILLER_48_734 VDD VSS FILLER1
XFILLER_47_211 VDD VSS FILLER1
XFILLER_75_531 VDD VSS FILLER4
XFILLER_75_542 VSS VDD FILLER2
X_13903_ _13903_/A _13903_/B _13951_/C _13903_/D VDD VSS wire153/A OAOI211X1
X_17671_ _19896_/Q _19864_/Q VDD VSS _17678_/A XNOR2X1
X_14883_ _14966_/B _14918_/D VDD VSS _14884_/C AND2X1
X_19410_ _19412_/CK _19410_/D _19410_/Q VDD VSS DFFQX1
XFILLER_47_277 VSS VDD FILLER2
X_16622_ _16622_/A _16622_/B VDD VSS _16623_/C NAND2X1
X_13834_ _13891_/A _13891_/B VDD VSS _14230_/C _13891_/C NAND3X1
XFILLER_46_82 VDD VSS DECAPHV8
X_19341_ _19573_/CK _19341_/D _19341_/Q VDD VSS DFFQX1
X_16553_ _19604_/Q _16755_/B VDD VSS _16554_/B XOR2X1
X_13765_ _19001_/Q _14263_/B VDD VSS _13768_/C _14263_/C NAND3X1
X_10977_ _11004_/A _10977_/B VDD VSS _10981_/B XNOR2X1
XFILLER_62_269 VSS VDD FILLER2
XFILLER_15_141 VSS VDD FILLER2
XTAP_TAPCELL_ROW_17_169 VDD VSS WELLTAP
X_15504_ _15495_/A _15504_/B _15504_/C VDD VSS _15539_/A AOI2B1X1
XFILLER_31_612 VSS VDD FILLER2
XFILLER_15_163 VDD VSS FILLER4
XFILLER_149_809 VSS VDD FILLER2
X_19272_ _20004_/CK _19272_/D _19272_/Q VDD VSS DFFQX1
X_12716_ _12892_/A _14285_/B VDD VSS _12801_/A OR2X2
XFILLER_15_174 VSS VDD FILLER2
X_16484_ _16494_/A _16494_/B VDD VSS _16858_/B XNOR2X1
X_13696_ _13696_/A _13696_/B _13696_/C _13696_/D VDD VSS _14360_/B AOAI211X1
XFILLER_70_291 VSS VDD FILLER2
X_18223_ _18223_/CK _18223_/E _18223_/ECK VDD VSS CGX3
X_15435_ _19517_/Q VDD VSS _15473_/A INVX1
X_12647_ _19214_/Q VDD VSS _12839_/A INVX1
XFILLER_129_511 VSS VDD FILLER2
XTAP_TAPCELL_ROW_120_1091 VDD VSS WELLTAP
X_15366_ _19460_/Q _15848_/B VDD VSS _15393_/B XNOR2X1
X_18154_ _19297_/Q _18155_/B VDD VSS _18162_/A AND2X1
X_12578_ _12673_/A _12673_/B _12673_/C VDD VSS _14535_/B NOR3X1
XFILLER_8_852 VDD VSS FILLER4
X_17105_ _17107_/B _17105_/B VDD VSS _17106_/B XOR2X1
XFILLER_144_514 VDD VSS DECAPHV8
X_14317_ _14316_/Y _14317_/B _14317_/C VDD VSS _19047_/D AND3BX1
X_11529_ _18681_/Q _11531_/B VDD VSS _18708_/D AND2X1
X_15297_ _15297_/A _18123_/B VDD VSS _19290_/D AND2X1
X_18085_ _18085_/A VDD VSS _18090_/A INVX1
XFILLER_7_362 VSS VDD FILLER2
XFILLER_116_227 VDD VSS FILLER4
X_17036_ _19760_/Q _17078_/B _17036_/C VDD VSS _17037_/B MIN3X1
X_14248_ _14251_/A _14248_/B VDD VSS _18988_/D NOR2X1
XFILLER_132_709 VSS VDD FILLER2
Xclkbuf_1_1__f__09181_ clkbuf_0__09181_/Y VDD VSS _18622_/CK BUFX12
X_14179_ _14197_/A _14179_/B VDD VSS _18931_/D AND2X1
XFILLER_152_580 VSS VDD FILLER2
XFILLER_124_282 VSS VDD FILLER2
XFILLER_124_293 VSS VDD FILLER2
XFILLER_3_590 VSS VDD FILLER2
XFILLER_30_2 VDD VSS FILLER1
XFILLER_58_509 VSS VDD FILLER2
X_18987_ _19037_/CK _18987_/D _18987_/Q VDD VSS DFFQX1
XFILLER_39_701 VDD VSS FILLER4
XFILLER_140_786 VDD VSS FILLER4
XFILLER_85_317 VDD VSS FILLER1
XFILLER_140_797 VDD VSS FILLER1
X_17938_ _17948_/A _17946_/B VDD VSS _17942_/B NOR2BX1
XFILLER_39_723 VSS VDD FILLER2
XFILLER_78_391 VDD VSS DECAPHV8
XFILLER_39_756 VSS VDD FILLER2
XFILLER_16_0 VDD VSS FILLER1
XTAP_TAPCELL_ROW_96_879 VDD VSS WELLTAP
XFILLER_66_553 VDD VSS DECAPHV8
X_17869_ _17869_/A _17869_/B _17869_/C VDD VSS _17870_/C MIN3X1
XFILLER_54_704 VDD VSS FILLER1
X_19608_ _19737_/CK _19608_/D _19608_/Q VDD VSS DFFQX1
XFILLER_81_512 VDD VSS FILLER1
XFILLER_26_19 VSS VDD FILLER2
XFILLER_93_383 VDD VSS FILLER1
XFILLER_38_288 VSS VDD FILLER2
Xclkbuf_0__001_ _231_/ECK VDD VSS clkbuf_0__001_/Y BUFX12
XFILLER_81_556 VSS VDD FILLER2
X_19539_ _19734_/CK _19539_/D _19539_/Q VDD VSS DFFQX1
XFILLER_81_567 VSS VDD FILLER2
XFILLER_41_409 VDD VSS FILLER1
XFILLER_81_589 VSS VDD FILLER2
XFILLER_62_770 VSS VDD FILLER2
XFILLER_42_18 VSS VDD FILLER2
X_09223_ _18519_/Q VDD VSS _18386_/D INVX1
XFILLER_10_818 VDD VSS FILLER4
XFILLER_166_127 VSS VDD FILLER2
XFILLER_166_138 VDD VSS FILLER4
XFILLER_163_801 VDD VSS FILLER1
XTAP_TAPCELL_ROW_134_1216 VDD VSS WELLTAP
XFILLER_135_547 VDD VSS DECAPHV8
XFILLER_163_856 VDD VSS FILLER1
XFILLER_162_344 VSS VDD FILLER2
XFILLER_123_709 VSS VDD FILLER2
XFILLER_116_750 VDD VSS DECAPHV8
XFILLER_107_11 VSS VDD FILLER2
XFILLER_116_772 VDD VSS FILLER1
Xclkbuf_leaf_17__000_ clkload71/A VDD VSS _19664_/CK BUFX12
XFILLER_89_601 VDD VSS FILLER4
XFILLER_89_612 VDD VSS DECAPHV16
XFILLER_88_100 VDD VSS FILLER1
XFILLER_115_282 VSS VDD FILLER2
XFILLER_131_731 VDD VSS FILLER1
XFILLER_89_645 VDD VSS FILLER4
XFILLER_107_55 VDD VSS FILLER4
XFILLER_107_66 VSS VDD FILLER2
XFILLER_130_230 VSS VDD FILLER2
X_20176_ _20176_/A VDD VSS _20176_/Y BUFX3
X_09987_ _09948_/Y _09986_/Y _11178_/C VDD VSS _09987_/Y MUX2X1
XFILLER_67_26 VSS VDD FILLER2
XFILLER_49_509 VSS VDD FILLER2
XFILLER_130_252 VDD VSS FILLER4
XFILLER_103_477 VDD VSS FILLER4
XFILLER_76_328 VSS VDD FILLER2
XTAP_TAPCELL_ROW_59_548 VDD VSS WELLTAP
XFILLER_85_840 VSS VDD FILLER2
XFILLER_69_391 VDD VSS FILLER1
XFILLER_45_704 VDD VSS FILLER4
XFILLER_123_65 VDD VSS FILLER1
XFILLER_84_361 VDD VSS FILLER1
XFILLER_29_266 VSS VDD FILLER2
X_10900_ _18674_/Q _18782_/Q VDD VSS _10902_/B XNOR2X1
X_11880_ wire166/Y _11881_/B _11881_/D _11881_/C VDD VSS _14525_/B AO211X2
XFILLER_123_98 VDD VSS FILLER1
XFILLER_44_225 VSS VDD FILLER2
X_10831_ _10871_/A _10871_/B _10832_/C _11195_/A VDD VSS _10832_/D AOAI211X1
XTAP_TAPCELL_ROW_107_980 VDD VSS WELLTAP
XFILLER_60_718 VSS VDD FILLER2
XFILLER_16_41 VDD VSS FILLER4
X_13550_ _19167_/Q _14452_/B VDD VSS _13640_/A NOR2BX1
X_10762_ _10927_/C _10762_/B _10762_/C _11226_/A VDD VSS _10772_/C OAI22X1
XFILLER_16_96 VDD VSS FILLER4
XFILLER_12_122 VSS VDD FILLER2
XFILLER_52_291 VDD VSS FILLER4
X_12501_ _19241_/Q _12677_/B _12677_/C VDD VSS _12837_/B XNOR3X1
XTAP_TAPCELL_ROW_14_139 VDD VSS WELLTAP
XFILLER_157_105 VSS VDD FILLER2
X_13481_ _13585_/A _13594_/D _13489_/C VDD VSS _13586_/C XNOR3X1
X_10693_ _10729_/C _10729_/D _10729_/E _10693_/D VDD VSS _10694_/B AOAI211X1
X_15220_ _15220_/A _15220_/B VDD VSS _15221_/C NAND2X1
XFILLER_9_649 VSS VDD FILLER2
X_12432_ _13177_/A _17853_/B VDD VSS _18848_/D NOR2X1
XFILLER_8_137 VSS VDD FILLER2
XFILLER_154_801 VDD VSS DECAPHV8
XFILLER_120_0 VSS VDD FILLER2
X_15151_ _15191_/C _15275_/A VDD VSS _15154_/A NAND2X1
XTAP_TAPCELL_ROW_3_44 VDD VSS WELLTAP
XFILLER_5_800 VSS VDD FILLER2
XFILLER_126_514 VSS VDD FILLER2
XFILLER_138_374 VDD VSS FILLER1
X_12363_ _12363_/A _12363_/B _12363_/C _12363_/D VDD VSS _12544_/A AOAI211X1
XFILLER_126_525 VDD VSS FILLER1
XFILLER_148_73 VSS VDD FILLER2
XFILLER_165_171 VSS VDD FILLER2
XFILLER_154_834 VSS VDD FILLER2
X_14102_ _18897_/Q _14140_/B VDD VSS _14103_/E _14140_/C AND3X2
XFILLER_154_856 VDD VSS FILLER1
X_11314_ _11383_/A _11314_/B VDD VSS _18585_/D NOR2X1
XFILLER_165_193 VDD VSS FILLER1
X_15082_ _15082_/A _15776_/B _15776_/C VDD VSS _15083_/C NOR3X1
XFILLER_126_569 VDD VSS DECAPHV8
X_12294_ _12512_/A _12294_/B _12294_/C VDD VSS _12366_/C NOR3X1
X_18910_ _18939_/CK _18910_/D _18910_/Q VDD VSS DFFQX1
X_14033_ _14233_/B _14233_/C _18978_/Q VDD VSS _14036_/B AOI21X1
X_11245_ _11151_/Y _11288_/B _11298_/A VDD VSS _11330_/B MUXI2X1
X_19890_ _19924_/CK _19890_/D _19890_/Q VDD VSS DFFQX1
XTAP_TAPCELL_ROW_111_1013 VDD VSS WELLTAP
X_18841_ _19959_/CK _18841_/D _18841_/Q VDD VSS DFFQX1
X_11176_ _11175_/B _11176_/B VDD VSS _11197_/C NOR2BX1
XFILLER_79_166 VSS VDD FILLER2
XFILLER_94_103 VDD VSS FILLER1
X_10127_ _10127_/A _10127_/B VDD VSS _10154_/B NOR2X1
XFILLER_67_328 VSS VDD FILLER2
X_18772_ _18773_/CK _18772_/D _18772_/Q VDD VSS DFFQX1
X_15984_ _16015_/A _16015_/B VDD VSS _15985_/C NAND2X1
XFILLER_121_296 VDD VSS FILLER4
XFILLER_94_136 VSS VDD FILLER2
XFILLER_76_840 VSS VDD FILLER2
XFILLER_48_531 VDD VSS FILLER4
X_17723_ _17726_/C _17724_/B _17746_/C VDD VSS _17724_/C OAI21X1
XFILLER_94_158 VDD VSS FILLER4
X_14935_ _19449_/Q _15834_/B VDD VSS _14959_/C _15834_/C NAND3X1
X_10058_ _10167_/A _10058_/B VDD VSS _10059_/C NOR2X1
XFILLER_57_81 VDD VSS FILLER4
XFILLER_36_704 VSS VDD FILLER2
XFILLER_91_810 VSS VDD FILLER2
XFILLER_75_361 VSS VDD FILLER2
XFILLER_48_586 VSS VDD FILLER2
X_17654_ _17655_/A _17657_/C _17654_/C VDD VSS _17655_/C OAI21X1
XTAP_TAPCELL_ROW_93_849 VDD VSS WELLTAP
X_14866_ _14906_/C _14907_/B _15833_/C VDD VSS _14867_/D NOR3X1
XFILLER_35_225 VSS VDD FILLER2
XTAP_TAPCELL_ROW_163_1478 VDD VSS WELLTAP
X_16605_ _16606_/A _16606_/B _16606_/C VDD VSS _16631_/B OA21X2
X_13817_ _18947_/Q _13987_/A _13987_/B VDD VSS _13818_/D XNOR3X1
X_17585_ _17589_/A _17586_/B _17597_/C VDD VSS _17586_/C OAI21X1
X_14797_ _14811_/A _14811_/B _15769_/B VDD VSS _15738_/B XNOR3X1
XFILLER_90_375 VDD VSS FILLER1
XFILLER_50_217 VSS VDD FILLER2
XFILLER_44_770 VDD VSS FILLER4
X_19324_ _19333_/CK _19324_/D _19324_/Q VDD VSS DFFQX1
X_16536_ _16537_/A _16537_/B _16537_/C VDD VSS _16561_/B AO21X2
XFILLER_73_80 VSS VDD FILLER2
X_13748_ _13748_/A _13748_/B _13748_/C _13748_/D VDD VSS _13918_/A AO31X2
XFILLER_73_91 VSS VDD FILLER2
XFILLER_16_494 VDD VSS FILLER4
X_19255_ _19996_/CK _19255_/D _19255_/Q VDD VSS DFFQX1
XFILLER_31_453 VSS VDD FILLER2
X_16467_ _16467_/A _16467_/B _16892_/B VDD VSS _16490_/B MIN3X1
X_13679_ _18973_/Q _14228_/B VDD VSS _13771_/A AND2X1
XFILLER_31_486 VSS VDD FILLER2
XFILLER_148_149 VSS VDD FILLER2
X_15418_ _19321_/Q _15692_/B VDD VSS _15422_/B XOR2X1
X_19186_ _19217_/CK _19186_/D _19186_/Q VDD VSS DFFQX1
X_16398_ _16398_/A _16398_/B _16398_/C VDD VSS _16399_/B OAI21X1
XFILLER_117_503 VSS VDD FILLER2
XFILLER_129_363 VSS VDD FILLER2
XFILLER_145_812 VDD VSS FILLER1
XFILLER_145_823 VSS VDD FILLER2
X_18137_ _18135_/Y _18139_/B _18168_/C VDD VSS _20001_/D AND3BX1
XFILLER_156_160 VDD VSS FILLER4
XFILLER_145_834 VSS VDD FILLER2
X_15349_ _19459_/Q _15845_/B VDD VSS _15351_/B NOR2X1
XFILLER_145_856 VDD VSS FILLER1
XFILLER_156_193 VSS VDD FILLER2
X_18068_ _19280_/Q _18068_/B VDD VSS _18069_/C AND2X1
XFILLER_132_528 VSS VDD FILLER2
X_17019_ _17019_/A _17019_/B _17019_/C _17019_/D VDD VSS _17024_/B AOI31X1
X_09910_ _09910_/A _09910_/B VDD VSS _09912_/B XNOR2X1
X_20030_ _20033_/CK _20030_/D _20030_/Q _20030_/RB VDD VSS DFFRQX1
X_09841_ _18564_/Q _11195_/A _09841_/C VDD VSS _09878_/B AOI21X1
XFILLER_112_230 VSS VDD FILLER2
Xclkbuf_1_1__f__09164_ clkbuf_0__09164_/Y VDD VSS _18455_/CK BUFX12
XFILLER_58_306 VSS VDD FILLER2
XFILLER_86_637 VDD VSS FILLER4
XFILLER_58_328 VDD VSS FILLER4
X_09772_ _18356_/Q _09772_/B _09772_/C _09772_/D VDD VSS _09773_/C OAI211X1
XFILLER_85_125 VSS VDD FILLER2
XFILLER_67_840 VSS VDD FILLER2
XFILLER_39_531 VSS VDD FILLER2
XFILLER_37_18 VSS VDD FILLER2
XFILLER_39_542 VDD VSS FILLER1
XFILLER_160_19 VSS VDD FILLER2
XTAP_TAPCELL_ROW_56_518 VDD VSS WELLTAP
XFILLER_66_361 VDD VSS FILLER4
XFILLER_54_523 VDD VSS DECAPHV8
XFILLER_27_737 VDD VSS FILLER1
XFILLER_82_843 VSS VDD FILLER2
XFILLER_81_320 VDD VSS FILLER4
XFILLER_54_545 VSS VDD FILLER2
XFILLER_93_191 VDD VSS FILLER1
XFILLER_42_718 VSS VDD FILLER2
XFILLER_81_375 VSS VDD FILLER2
XTAP_TAPCELL_ROW_104_950 VDD VSS WELLTAP
XTAP_TAPCELL_ROW_140_1275 VDD VSS WELLTAP
XFILLER_139_116 VSS VDD FILLER2
XFILLER_139_127 VDD VSS FILLER1
XFILLER_22_464 VSS VDD FILLER2
XFILLER_10_615 VSS VDD FILLER2
XTAP_TAPCELL_ROW_11_109 VDD VSS WELLTAP
X_09206_ _18513_/Q VDD VSS _18428_/D INVX1
XFILLER_22_497 VSS VDD FILLER2
XFILLER_108_514 VSS VDD FILLER2
XFILLER_147_193 VSS VDD FILLER2
XFILLER_135_344 VSS VDD FILLER2
XFILLER_150_303 VSS VDD FILLER2
XFILLER_163_686 VSS VDD FILLER2
XFILLER_2_825 VDD VSS FILLER1
XFILLER_163_697 VDD VSS FILLER1
XFILLER_118_87 VSS VDD FILLER2
XTAP_TAPCELL_ROW_151_1371 VDD VSS WELLTAP
XFILLER_162_185 VDD VSS FILLER4
XFILLER_118_98 VSS VDD FILLER2
X_11030_ _11495_/A _11675_/A _11030_/C VDD VSS _11074_/C MIN3X1
XFILLER_89_453 VSS VDD FILLER2
XFILLER_78_69 VDD VSS FILLER1
XFILLER_89_464 VDD VSS FILLER1
XFILLER_131_561 VDD VSS FILLER4
XFILLER_134_20 VSS VDD FILLER2
XFILLER_104_797 VDD VSS FILLER1
XFILLER_131_583 VSS VDD FILLER2
XFILLER_134_53 VDD VSS FILLER1
X_20159_ _20159_/A VDD VSS _20159_/Y BUFX3
XFILLER_76_136 VSS VDD FILLER2
XFILLER_92_607 VSS VDD FILLER2
X_12981_ _13004_/A _13198_/B _13198_/C VDD VSS _12994_/C OR3BX1
XFILLER_57_350 VDD VSS FILLER1
X_14720_ _14758_/A _14758_/B _15767_/B VDD VSS _15736_/B XNOR3X1
XFILLER_45_523 VSS VDD FILLER2
X_11932_ _19996_/Q _19260_/Q VDD VSS _11933_/D NOR2X1
XFILLER_150_30 VSS VDD FILLER2
XFILLER_45_556 VSS VDD FILLER2
XFILLER_27_73 VSS VDD FILLER2
XFILLER_17_247 VDD VSS FILLER1
X_14651_ _19498_/Q _15891_/B VDD VSS _14652_/D XNOR2X1
X_11863_ _19118_/Q _11865_/B _14397_/B VDD VSS _14366_/B XNOR3X1
XTAP_TAPCELL_ROW_90_819 VDD VSS WELLTAP
XTAP_TAPCELL_ROW_27_253 VDD VSS WELLTAP
XFILLER_72_375 VSS VDD FILLER2
X_13602_ _14326_/B _14326_/C _19055_/Q VDD VSS _13604_/C AOI21X1
X_10814_ _10814_/A _10814_/B _10814_/C VDD VSS _10851_/B OAI21X1
X_17370_ _17372_/A _17370_/B _17370_/C VDD VSS _19831_/D AOI21X1
X_14582_ _14594_/A _15856_/B VDD VSS _14616_/B AND2X1
X_11794_ _19173_/Q _11794_/B _11794_/C VDD VSS _11874_/A MIN3X1
XFILLER_13_431 VSS VDD FILLER2
Xclkbuf_1_0__f__09184_ clkbuf_0__09184_/Y VDD VSS _18495_/CK BUFX12
X_16321_ _16335_/C _16321_/B VDD VSS _16817_/B OR2X2
X_13533_ _13533_/A _14293_/B _13599_/C _13533_/D VDD VSS _13733_/A OAOI211X1
X_10745_ _11127_/A _10745_/B VDD VSS _10778_/A NAND2X1
XFILLER_9_402 VDD VSS FILLER4
XFILLER_41_762 VDD VSS FILLER1
X_19040_ _19068_/CK _19040_/D _19040_/Q VDD VSS DFFQX1
X_16252_ _19656_/Q _16814_/B VDD VSS _16267_/A NOR2X1
X_13464_ _13464_/A _13464_/B VDD VSS _14515_/B XNOR2X1
XFILLER_40_283 VSS VDD FILLER2
XFILLER_139_650 VDD VSS FILLER1
X_10676_ _18668_/Q _18776_/Q VDD VSS _10718_/D OR2X2
XFILLER_127_801 VSS VDD FILLER2
XFILLER_9_468 VSS VDD FILLER2
XFILLER_139_672 VDD VSS FILLER4
XFILLER_71_9 VSS VDD FILLER2
X_15203_ _15204_/C _15812_/B _15812_/C VDD VSS _15225_/C NOR3X1
X_12415_ _19184_/Q _12566_/A _12662_/B VDD VSS _12472_/D XNOR3X1
X_16183_ _19558_/Q _19910_/Q VDD VSS _16208_/A XNOR2X1
X_13395_ _13395_/A _13395_/B _13395_/C _13395_/D VDD VSS _13594_/A AOAI211X1
XFILLER_166_480 VSS VDD FILLER2
XFILLER_127_856 VDD VSS FILLER1
X_15134_ _15134_/A _15134_/B _15134_/C VDD VSS _15176_/B OA21X2
X_12346_ _18876_/Q VDD VSS _12528_/A INVX1
XFILLER_154_675 VDD VSS FILLER4
XFILLER_142_826 VDD VSS FILLER4
XFILLER_153_174 VDD VSS FILLER4
X_15065_ _19481_/Q _15873_/B VDD VSS _15085_/B XOR2X1
X_19942_ _19943_/CK _19942_/D _19942_/Q VDD VSS DFFQX1
XFILLER_5_685 VSS VDD FILLER2
XFILLER_126_399 VDD VSS FILLER4
X_12277_ _18958_/Q _12277_/B _14209_/B VDD VSS _12354_/B MIN3X1
X_14016_ _18923_/Q _14054_/B _14054_/C VDD VSS _14085_/B XNOR3X1
XFILLER_4_44 VSS VDD FILLER2
X_11228_ _18710_/Q _18764_/Q _11228_/C VDD VSS _11229_/C MIN3X1
X_19873_ clkload9/A _19873_/D _19873_/Q VDD VSS DFFQX1
XFILLER_68_626 VSS VDD FILLER2
X_18824_ _19943_/CK _18824_/D _18824_/Q VDD VSS DFFQX1
X_11159_ _11159_/A _11159_/B VDD VSS _11221_/A OR2X2
XFILLER_95_434 VSS VDD FILLER2
XFILLER_49_840 VSS VDD FILLER2
XFILLER_67_147 VDD VSS FILLER4
X_18755_ _19939_/CK _18755_/D _18755_/Q VDD VSS DFFQX1
XFILLER_110_789 VDD VSS FILLER1
X_15967_ _15993_/A _15993_/B VDD VSS _16766_/B XNOR2X1
XFILLER_36_501 VSS VDD FILLER2
X_17706_ _17806_/A _17706_/B VDD VSS _19903_/D NOR2X1
X_14918_ _14918_/A _14918_/B _14966_/B _14918_/D VDD VSS _15868_/C AOI22X1
X_18686_ _18767_/CK _18686_/D _18686_/Q VDD VSS DFFQX1
X_15898_ _15906_/A _15898_/B VDD VSS _19504_/D NOR2X1
XFILLER_63_331 VDD VSS FILLER1
XFILLER_36_567 VDD VSS FILLER4
X_17637_ _19888_/Q _19856_/Q VDD VSS _17638_/C NAND2X1
X_14849_ _19335_/Q VDD VSS _14850_/A INVX1
XFILLER_63_375 VSS VDD FILLER2
XFILLER_24_729 VSS VDD FILLER2
X_17568_ _19874_/Q _19842_/Q VDD VSS _17569_/B XOR2X1
Xclkbuf_leaf_16__001_ clkload33/A VDD VSS _18915_/CK BUFX12
X_19307_ _19314_/CK _19307_/D _19307_/Q VDD VSS DFFQX1
XTAP_TAPCELL_ROW_101_920 VDD VSS WELLTAP
X_16519_ _19667_/Q VDD VSS _16545_/A INVX1
XTAP_TAPCELL_ROW_61_565 VDD VSS WELLTAP
X_17499_ _19859_/Q _19827_/Q VDD VSS _17501_/B XOR2X1
XFILLER_83_0 VSS VDD FILLER2
X_19238_ _19269_/CK _19238_/D _19238_/Q VDD VSS DFFQX1
XFILLER_117_300 VDD VSS FILLER1
XFILLER_145_620 VSS VDD FILLER2
X_19169_ _19196_/CK _19169_/D _19169_/Q VDD VSS DFFQX1
XFILLER_157_480 VSS VDD FILLER2
XFILLER_118_856 VDD VSS FILLER1
XFILLER_117_333 VSS VDD FILLER2
XFILLER_117_377 VDD VSS FILLER1
XFILLER_144_174 VDD VSS FILLER1
XFILLER_132_347 VDD VSS FILLER4
XFILLER_120_509 VSS VDD FILLER2
XFILLER_160_678 VSS VDD FILLER2
XFILLER_113_561 VSS VDD FILLER2
X_20013_ _20013_/CK _20013_/D _20013_/Q VDD VSS DFFQX1
X_09824_ _10686_/D VDD VSS _11039_/C BUFX3
XFILLER_98_294 VDD VSS FILLER1
XTAP_TAPCELL_ROW_69_632 VDD VSS WELLTAP
XFILLER_74_607 VSS VDD FILLER2
Xclkbuf_0__09178_ _18227_/ECK VDD VSS clkbuf_0__09178_/Y BUFX12
X_09755_ _20112_/A _20128_/A _09773_/D VDD VSS _09760_/C MUX2X1
XFILLER_46_309 VSS VDD FILLER2
XFILLER_86_489 VDD VSS FILLER1
XFILLER_74_629 VSS VDD FILLER2
XFILLER_67_681 VSS VDD FILLER2
XFILLER_100_299 VSS VDD FILLER2
XFILLER_39_383 VSS VDD FILLER2
XFILLER_104_67 VSS VDD FILLER2
X_09686_ _18367_/Q VDD VSS _20204_/A INVX1
XFILLER_104_78 VSS VDD FILLER2
XFILLER_64_38 VSS VDD FILLER2
XFILLER_64_49 VSS VDD FILLER2
XFILLER_54_364 VSS VDD FILLER2
XFILLER_82_695 VSS VDD FILLER2
XFILLER_14_239 VDD VSS FILLER1
XFILLER_120_44 VSS VDD FILLER2
XFILLER_120_88 VDD VSS FILLER4
XFILLER_80_37 VSS VDD FILLER2
XFILLER_120_99 VSS VDD FILLER2
XFILLER_50_581 VDD VSS FILLER4
X_10530_ _10530_/A _10530_/B _10530_/C _10530_/D VDD VSS _10556_/A AOAI211X1
XFILLER_13_42 VSS VDD FILLER2
XFILLER_13_64 VSS VDD FILLER2
XFILLER_6_416 VSS VDD FILLER2
X_10461_ _10525_/B _10461_/B _10763_/A VDD VSS _10462_/D OR3BX1
XFILLER_129_53 VSS VDD FILLER2
X_12200_ _18986_/Q VDD VSS _12278_/A INVX1
XFILLER_6_449 VSS VDD FILLER2
XFILLER_135_130 VDD VSS FILLER1
X_13180_ _18909_/Q _13180_/B _14153_/B VDD VSS _14122_/B XNOR3X1
XFILLER_136_664 VDD VSS FILLER1
X_10392_ _10392_/A _10392_/B VDD VSS _10431_/B OR2X2
XFILLER_89_46 VDD VSS FILLER1
XFILLER_108_377 VSS VDD FILLER2
XFILLER_163_472 VDD VSS FILLER1
X_12131_ _18956_/Q _12131_/B _14207_/B VDD VSS _12199_/B MIN3X1
XFILLER_135_185 VDD VSS FILLER1
XFILLER_151_634 VDD VSS FILLER1
XTAP_TAPCELL_ROW_0_12 VDD VSS WELLTAP
XFILLER_2_622 VSS VDD FILLER2
XFILLER_123_347 VDD VSS FILLER4
XFILLER_151_656 VDD VSS FILLER1
X_12062_ _12254_/A _12254_/B VDD VSS _12137_/C XOR2X1
XFILLER_150_155 VSS VDD FILLER2
XFILLER_89_250 VDD VSS DECAPHV16
X_11013_ _11229_/D _11013_/B _11013_/C _11013_/D VDD VSS _11014_/C OAI211X1
XFILLER_145_96 VDD VSS DECAPHV8
XFILLER_104_594 VSS VDD FILLER2
X_16870_ _16876_/A _16870_/B VDD VSS _19707_/D NOR2X1
XFILLER_49_125 VSS VDD FILLER2
X_15821_ _15830_/A _15821_/B VDD VSS _19436_/D NOR2X1
XFILLER_49_158 VSS VDD FILLER2
XFILLER_65_629 VDD VSS FILLER1
XFILLER_38_72 VDD VSS DECAPHV8
XFILLER_64_117 VSS VDD FILLER2
X_18540_ _18550_/CK _18540_/D _18540_/Q VDD VSS DFFQX1
XFILLER_38_94 VDD VSS FILLER1
X_15752_ _15758_/A _15752_/B VDD VSS _19375_/D NOR2X1
X_12964_ _13054_/A _13054_/B VDD VSS _14539_/B XNOR2X1
X_14703_ _19472_/Q _15863_/B VDD VSS _14737_/C NAND2X1
XTAP_TAPCELL_ROW_9_98 VDD VSS WELLTAP
XFILLER_61_802 VDD VSS FILLER4
X_18471_ _18471_/CK _18471_/D _18471_/Q _18471_/RB VDD VSS DFFRQX1
X_11915_ _19175_/Q _11918_/A _11915_/C VDD VSS _11916_/D XNOR3X1
XFILLER_61_813 VSS VDD FILLER2
X_15683_ _15693_/A _15683_/B VDD VSS _19312_/D NOR2X1
XFILLER_45_364 VSS VDD FILLER2
X_12895_ _19018_/Q _14284_/B VDD VSS _12896_/C _14284_/C NAND3X1
XFILLER_45_375 VDD VSS FILLER4
XFILLER_73_695 VDD VSS FILLER1
XFILLER_61_835 VSS VDD FILLER2
X_17422_ _19842_/Q _19810_/Q _17422_/C VDD VSS _17427_/C AO21X2
XFILLER_60_323 VSS VDD FILLER2
X_14634_ _19442_/Q _14672_/B _14640_/C VDD VSS _14635_/C XNOR3X1
X_11846_ _19203_/Q _11871_/B _11979_/C VDD VSS _11918_/B XOR3X1
XFILLER_72_194 VSS VDD FILLER2
X_17353_ _19827_/Q _19795_/Q _17353_/C VDD VSS _17357_/C MIN3X1
X_14565_ _20004_/Q _14569_/B VDD VSS _19268_/D AND2X1
X_11777_ _19992_/Q _19256_/Q VDD VSS _11804_/A AND2X1
Xclkbuf_1_0__f__09167_ clkbuf_0__09167_/Y VDD VSS _18407_/CK BUFX12
X_16304_ _19722_/Q _16886_/B VDD VSS _16305_/A NAND2BX1
X_13516_ _13516_/A _13516_/B _13516_/C _13516_/D VDD VSS _13675_/A AOAI211X1
X_10728_ _18696_/Q _18750_/Q VDD VSS _10765_/B XNOR2X1
X_17284_ _17289_/C _17289_/B VDD VSS _17286_/B NAND2BX1
X_14496_ _17906_/C VDD VSS _15817_/A BUFX3
XFILLER_159_789 VSS VDD FILLER2
XFILLER_146_417 VDD VSS FILLER1
XFILLER_146_428 VDD VSS DECAPHV8
X_19023_ _19094_/CK _19023_/D _19023_/Q VDD VSS DFFQX1
X_16235_ _19559_/Q VDD VSS _16236_/A INVX1
X_13447_ _13447_/A _13447_/B _13447_/C _13447_/D VDD VSS _13462_/B AOAI211X1
X_10659_ _11267_/A _10659_/B _10659_/C _10659_/D VDD VSS _10661_/B AOI31X1
Xclkload13 _19785_/CK VDD VSS clkload13/Y INVX1
Xclkload24 _19986_/CK VDD VSS clkload24/Y INVX4
Xclkload35 _20000_/CK VDD VSS clkload35/Y INVX2
Xclkload46 _19025_/CK VDD VSS clkload46/Y INVX2
XFILLER_115_804 VSS VDD FILLER2
X_16166_ _19653_/Q _16810_/B VDD VSS _16177_/B XNOR2X1
X_13378_ _18914_/Q _13378_/B _13393_/C VDD VSS _13578_/B XNOR3X1
XFILLER_142_601 VSS VDD FILLER2
Xclkload57 _19988_/CK VDD VSS clkload57/Y INVX4
XFILLER_154_461 VSS VDD FILLER2
Xclkload68 _18997_/CK VDD VSS clkload68/Y INVX2
XTAP_TAPCELL_ROW_117_1063 VDD VSS WELLTAP
XFILLER_55_4 VSS VDD FILLER2
Xclkload79 _19466_/CK VDD VSS clkload79/Y BUFX12
XFILLER_5_460 VDD VSS FILLER4
XFILLER_126_174 VSS VDD FILLER2
X_15117_ _15138_/A _15138_/B _15810_/B VDD VSS _15777_/B XNOR3X1
XFILLER_126_185 VDD VSS FILLER1
X_12329_ _12329_/A _12329_/B _14501_/B _12329_/D _12329_/E VDD VSS _12474_/C OAI221X1
XFILLER_114_336 VSS VDD FILLER2
X_16097_ _16104_/B _16097_/B VDD VSS _16878_/B XNOR2X1
XFILLER_102_509 VSS VDD FILLER2
XFILLER_141_155 VSS VDD FILLER2
X_15048_ _15054_/A _15054_/B _15054_/C VDD VSS _15837_/C NOR3X1
X_19925_ clkload2/A _19925_/D _19925_/Q VDD VSS DFFQX1
X_18206__253 _20052_/CK VDD VSS _18258_/CK INVX1
XFILLER_96_721 VSS VDD FILLER2
X_19856_ _19880_/CK _19856_/D _19856_/Q VDD VSS DFFQX1
XFILLER_96_743 VSS VDD FILLER2
XFILLER_95_242 VDD VSS FILLER4
XFILLER_68_456 VDD VSS FILLER1
XFILLER_56_607 VSS VDD FILLER2
X_18807_ _19940_/CK _18807_/D _18807_/Q VDD VSS DFFQX1
XFILLER_56_618 VDD VSS FILLER1
X_19787_ _19791_/CK _19787_/D _19787_/Q VDD VSS DFFQX1
X_16999_ _17095_/A _16999_/B VDD VSS _19754_/D NOR2X1
XFILLER_83_415 VSS VDD FILLER2
XFILLER_83_426 VSS VDD FILLER2
X_09540_ _20034_/Q _09547_/B VDD VSS _20035_/D NOR2BX1
X_18738_ _18767_/CK _18738_/D _18738_/Q VDD VSS DFFQX1
XTAP_TAPCELL_ROW_38_359 VDD VSS WELLTAP
X_09471_ _18449_/D _09483_/B _09471_/C VDD VSS _18248_/D AOI21X1
XFILLER_64_662 VSS VDD FILLER2
X_18669_ _18831_/CK _18669_/D _18669_/Q VDD VSS DFFQX1
XFILLER_70_109 VSS VDD FILLER2
XFILLER_64_695 VSS VDD FILLER2
XFILLER_24_526 VDD VSS FILLER4
XFILLER_24_548 VSS VDD FILLER2
XTAP_TAPCELL_ROW_21_204 VDD VSS WELLTAP
XFILLER_32_581 VDD VSS FILLER4
XFILLER_137_406 VDD VSS DECAPHV8
Xclkload7 clkload7/A VDD VSS clkload7/Y INVX8
XFILLER_165_715 VDD VSS FILLER4
XFILLER_109_108 VDD VSS FILLER1
XFILLER_50_18 VSS VDD FILLER2
XFILLER_164_203 VSS VDD FILLER2
XFILLER_149_299 VDD VSS DECAPHV16
XFILLER_164_269 VSS VDD FILLER2
XFILLER_117_141 VDD VSS DECAPHV8
XFILLER_132_100 VSS VDD FILLER2
XFILLER_105_336 VSS VDD FILLER2
XFILLER_117_196 VDD VSS DECAPHV8
XFILLER_59_38 VDD VSS FILLER4
XFILLER_121_807 VSS VDD FILLER2
XFILLER_133_667 VSS VDD FILLER2
XFILLER_59_49 VSS VDD FILLER2
XFILLER_133_689 VSS VDD FILLER2
Xfanout200 input4/Y VDD VSS _09322_/B BUFX3
Xfanout211 _18405_/RB VDD VSS _09284_/AB BUFX3
XFILLER_120_328 VSS VDD FILLER2
XFILLER_132_188 VDD VSS FILLER4
Xfanout222 _18405_/RB VDD VSS _20081_/RB BUFX3
XFILLER_115_22 VDD VSS DECAPHV8
XFILLER_132_199 VSS VDD FILLER2
XFILLER_115_66 VDD VSS FILLER4
X_09807_ _18455_/Q VDD VSS _20180_/A INVX1
XFILLER_87_798 VDD VSS FILLER4
XFILLER_74_415 VSS VDD FILLER2
XFILLER_59_489 VSS VDD FILLER2
XFILLER_28_821 VSS VDD FILLER2
X_09738_ _20143_/A _20191_/A _09753_/A VDD VSS _09740_/B MUXI2X1
XFILLER_131_21 VSS VDD FILLER2
XFILLER_55_662 VSS VDD FILLER2
X_09669_ _18414_/Q VDD VSS _20169_/A INVX1
XFILLER_27_375 VDD VSS FILLER4
XFILLER_54_161 VDD VSS FILLER1
XFILLER_82_481 VDD VSS FILLER1
XFILLER_43_835 VSS VDD FILLER2
X_11700_ _19225_/Q _11700_/B _11700_/C VDD VSS _11745_/A MIN3X1
XFILLER_91_25 VDD VSS FILLER1
XFILLER_42_323 VSS VDD FILLER2
XFILLER_131_87 VDD VSS FILLER4
X_12680_ _12755_/A _12755_/B _12755_/D _12755_/C VDD VSS _12682_/C OAI211X1
Xclkbuf_2_2__f_sclk_regs clkbuf_0_sclk_regs/Y VDD VSS _20080_/CK BUFX12
X_11631_ _18773_/Q _11635_/B VDD VSS _18800_/D AND2X1
XFILLER_91_69 VSS VDD FILLER2
XFILLER_70_687 VDD VSS DECAPHV8
X_232_ _232_/CK _232_/E _232_/ECK VDD VSS CGX3
XFILLER_24_74 VSS VDD FILLER2
XFILLER_23_592 VSS VDD FILLER2
X_14350_ _15383_/A VDD VSS _14415_/A BUFX3
X_11562_ _18710_/Q _11567_/B VDD VSS _18737_/D AND2X1
XFILLER_156_704 VDD VSS FILLER1
XFILLER_10_231 VDD VSS FILLER1
Xclkbuf_leaf_8_clk_regs clkbuf_leaf_9_clk_regs/A VDD VSS _19825_/CK BUFX12
XFILLER_156_726 VSS VDD FILLER2
XFILLER_10_253 VSS VDD FILLER2
X_13301_ _13395_/A _13395_/B _13395_/C VDD VSS _14222_/B AOI21X1
X_10513_ _10579_/D _10582_/B VDD VSS _10622_/B NOR2X1
XFILLER_7_725 VSS VDD FILLER2
X_14281_ _14285_/A _14281_/B VDD VSS _19015_/D NOR2X1
XFILLER_6_202 VSS VDD FILLER2
XFILLER_155_225 VSS VDD FILLER2
X_11493_ _18648_/Q _11496_/B VDD VSS _18675_/D AND2X1
XFILLER_7_747 VSS VDD FILLER2
XFILLER_109_642 VDD VSS DECAPHV8
XFILLER_6_235 VDD VSS FILLER4
X_16020_ _16020_/A _16022_/B VDD VSS _16870_/B XNOR2X1
X_13232_ _19191_/Q _14478_/B _14478_/C VDD VSS _13233_/D OR3BX1
XFILLER_109_664 VDD VSS FILLER4
X_10444_ _19941_/Q _18823_/Q VDD VSS _10448_/D AND2X1
XFILLER_109_675 VDD VSS DECAPHV16
XFILLER_40_62 VSS VDD FILLER2
XFILLER_108_163 VSS VDD FILLER2
XFILLER_109_697 VDD VSS FILLER4
X_13163_ _14353_/B _14353_/C _19079_/Q VDD VSS _13271_/C AOI21X1
XFILLER_123_111 VSS VDD FILLER2
X_10375_ _10366_/Y _10375_/B _10375_/C _10375_/D VDD VSS _10395_/C AOI2B2X1
XFILLER_163_291 VDD VSS FILLER4
X_12114_ _14465_/B _14465_/C _12154_/A VDD VSS _12116_/C OA21X2
XFILLER_156_95 VDD VSS FILLER1
XFILLER_151_464 VDD VSS FILLER1
X_17971_ _17976_/A _17976_/B _17971_/C VDD VSS _17972_/B OAI21X1
X_13094_ _13095_/A _13095_/B _13095_/D _13095_/C VDD VSS _13415_/B OAOI211X1
Xclkbuf_leaf_15__002_ clkbuf_leaf_9__002_/A VDD VSS _18810_/CK BUFX12
XFILLER_78_710 VDD VSS FILLER4
X_19710_ _19724_/CK _19710_/D _19710_/Q VDD VSS DFFQX1
X_16922_ _19738_/Q _16922_/B _16922_/C VDD VSS _19739_/D AOI21X1
X_12045_ _12053_/A _12099_/B _12099_/C VDD VSS _14495_/C OR3BX1
XFILLER_49_71 VSS VDD FILLER2
X_19641_ _19705_/CK _19641_/D _19641_/Q VDD VSS DFFQX1
XFILLER_38_607 VSS VDD FILLER2
X_16853_ _16859_/A _16853_/B VDD VSS _19692_/D AND2X1
XFILLER_93_724 VSS VDD FILLER2
XFILLER_92_212 VSS VDD FILLER2
XFILLER_77_286 VSS VDD FILLER2
X_15804_ _15816_/A _15804_/B VDD VSS _19421_/D NOR2X1
XFILLER_65_437 VSS VDD FILLER2
X_19572_ _19602_/CK _19572_/D _19572_/Q VDD VSS DFFQX1
X_16784_ _16793_/A _16784_/B VDD VSS _19630_/D AND2X1
XFILLER_93_768 VSS VDD FILLER2
X_13996_ _18950_/Q _14201_/B VDD VSS _14038_/A AND2X1
X_18523_ _18523_/CK _18523_/D _18523_/Q _09307_/Y VDD VSS DFFRQX1
XFILLER_80_407 VSS VDD FILLER2
X_15735_ _15739_/A _15735_/B VDD VSS _19360_/D NOR2X1
XFILLER_52_109 VSS VDD FILLER2
X_12947_ _12953_/A _14475_/B _13032_/C VDD VSS _14476_/C NOR3X1
XFILLER_65_92 VDD VSS FILLER1
XFILLER_46_695 VSS VDD FILLER2
XTAP_TAPCELL_ROW_35_329 VDD VSS WELLTAP
X_18454_ _18454_/CK _18454_/D _18454_/Q _18471_/RB VDD VSS DFFRQX1
XFILLER_73_492 VDD VSS FILLER4
X_15666_ _15666_/A _15702_/B VDD VSS _15667_/C NOR2X1
XFILLER_61_643 VSS VDD FILLER2
X_12878_ _18937_/Q _14185_/B _12888_/C VDD VSS _14153_/B XNOR3X1
XFILLER_61_654 VSS VDD FILLER2
XFILLER_33_345 VDD VSS FILLER1
XFILLER_61_665 VDD VSS FILLER1
XFILLER_60_142 VSS VDD FILLER2
X_17405_ _17407_/B _17405_/B VDD VSS _17406_/B XOR2X1
X_14617_ _19469_/Q _14638_/B _14638_/C VDD VSS _14671_/B MIN3X1
XFILLER_21_518 VSS VDD FILLER2
X_18385_ _18391_/CK _18518_/Q _20190_/A _20067_/RB VDD VSS DFFRQX1
X_11829_ _14490_/C _19202_/Q _11884_/B VDD VSS _11830_/D AND3BX1
X_15597_ _15597_/A _15597_/B _15597_/C VDD VSS _15625_/B OAI21X1
XFILLER_147_704 VDD VSS FILLER1
X_17336_ _17338_/A _17338_/B _17336_/C VDD VSS _19824_/D AOI21X1
X_14548_ _16273_/A VDD VSS _14558_/B BUFX3
XFILLER_81_91 VSS VDD FILLER2
XFILLER_159_586 VDD VSS FILLER1
XFILLER_159_597 VSS VDD FILLER2
X_17267_ _19809_/Q _19777_/Q _17267_/C VDD VSS _17270_/B MIN3X1
Xclkload102 _19602_/CK VDD VSS clkload102/Y BUFX12
X_14479_ _14421_/Y _14479_/B _14479_/C VDD VSS _19192_/D AND3BX1
Xclkload113 _20081_/CK VDD VSS clkload113/Y BUFX3
X_19006_ _19115_/CK _19006_/D _19006_/Q VDD VSS DFFQX1
X_16218_ _19687_/Q _16848_/B VDD VSS _16227_/B XNOR2X1
Xclkload124 _18454_/CK VDD VSS clkload124/Y INVX2
XFILLER_146_269 VDD VSS FILLER1
X_17198_ _17199_/C _17469_/B _17198_/C VDD VSS _19794_/D AND3BX1
XFILLER_162_729 VDD VSS FILLER1
XFILLER_127_472 VSS VDD FILLER2
XFILLER_6_780 VSS VDD FILLER2
XFILLER_114_111 VSS VDD FILLER2
XFILLER_115_634 VSS VDD FILLER2
X_16149_ _16512_/A _16149_/B VDD VSS _19524_/D NOR2X1
XFILLER_142_453 VDD VSS FILLER4
XFILLER_46_0 VSS VDD FILLER2
XFILLER_130_615 VSS VDD FILLER2
XFILLER_142_475 VSS VDD FILLER2
XFILLER_102_317 VSS VDD FILLER2
XFILLER_102_328 VSS VDD FILLER2
XFILLER_69_732 VDD VSS DECAPHV8
XFILLER_102_339 VDD VSS FILLER1
X_19908_ clkload8/A _19908_/D _19908_/Q VDD VSS DFFQX1
XFILLER_111_840 VSS VDD FILLER2
XFILLER_69_765 VDD VSS FILLER4
XFILLER_68_242 VSS VDD FILLER2
XFILLER_69_787 VSS VDD FILLER2
X_19839_ _19880_/CK _19839_/D _19839_/Q VDD VSS DFFQX1
XFILLER_29_629 VSS VDD FILLER2
XFILLER_96_584 VSS VDD FILLER2
XFILLER_69_798 VDD VSS FILLER1
XFILLER_28_117 VSS VDD FILLER2
XFILLER_56_437 VDD VSS FILLER4
XFILLER_28_128 VDD VSS FILLER1
XFILLER_110_394 VSS VDD FILLER2
XFILLER_83_245 VSS VDD FILLER2
X_09523_ _18197_/D _09526_/B _09523_/C VDD VSS _20020_/D NOR3X1
XFILLER_25_824 VDD VSS FILLER4
XFILLER_25_835 VSS VDD FILLER2
X_09454_ _19967_/Q _09467_/B _09483_/B VDD VSS _09455_/C AOI21X1
XFILLER_64_492 VSS VDD FILLER2
XFILLER_24_323 VSS VDD FILLER2
XFILLER_12_518 VSS VDD FILLER2
X_09385_ _18010_/A VDD VSS _17906_/C BUFX3
XFILLER_52_687 VDD VSS FILLER1
XFILLER_165_534 VDD VSS FILLER4
XTAP_TAPCELL_ROW_137_1247 VDD VSS WELLTAP
XFILLER_165_556 VSS VDD FILLER2
XFILLER_106_623 VDD VSS FILLER1
XFILLER_4_739 VSS VDD FILLER2
XFILLER_10_21 VSS VDD FILLER2
XFILLER_152_239 VSS VDD FILLER2
XFILLER_106_645 VDD VSS DECAPHV16
XFILLER_105_144 VSS VDD FILLER2
XFILLER_133_464 VDD VSS FILLER1
X_10160_ _10172_/C _10172_/B VDD VSS _10161_/B NAND2BX1
XFILLER_161_784 VSS VDD FILLER2
XFILLER_133_497 VDD VSS FILLER4
XFILLER_120_125 VSS VDD FILLER2
X_10091_ _10080_/Y _10090_/Y _10127_/A VDD VSS _10091_/Y MUX2X1
XFILLER_120_147 VSS VDD FILLER2
XTAP_TAPCELL_ROW_77_708 VDD VSS WELLTAP
XTAP_TAPCELL_ROW_148_1343 VDD VSS WELLTAP
XFILLER_87_584 VSS VDD FILLER2
XFILLER_47_415 VSS VDD FILLER2
XFILLER_74_212 VSS VDD FILLER2
XFILLER_19_63 VSS VDD FILLER2
XFILLER_101_394 VSS VDD FILLER2
X_13850_ _13860_/A _14329_/B VDD VSS _14331_/C _13850_/C NAND3X1
XFILLER_19_85 VSS VDD FILLER2
XFILLER_142_64 VSS VDD FILLER2
XFILLER_47_459 VDD VSS FILLER1
XFILLER_19_96 VSS VDD FILLER2
X_12801_ _12801_/A _12801_/B _12801_/C _12801_/D VDD VSS _12996_/A AOAI211X1
XFILLER_16_802 VSS VDD FILLER2
XTAP_TAPCELL_ROW_85_774 VDD VSS WELLTAP
X_13781_ _13781_/A _13781_/B _13781_/C _13781_/D VDD VSS _14329_/C AO211X2
X_10993_ _10990_/B _18570_/Q VDD VSS _11023_/B NAND2BX1
XFILLER_90_738 VDD VSS FILLER1
XFILLER_27_150 VSS VDD FILLER2
XFILLER_55_470 VDD VSS FILLER1
XFILLER_55_481 VSS VDD FILLER2
XFILLER_27_172 VSS VDD FILLER2
X_15520_ _15520_/A _15520_/B _15520_/C VDD VSS _15521_/B NOR3X1
XFILLER_27_183 VSS VDD FILLER2
X_12732_ _12732_/A _12732_/B _12732_/C _12732_/D VDD VSS _12910_/A AO31X2
XFILLER_43_654 VDD VSS FILLER4
XFILLER_42_120 VDD VSS FILLER1
XFILLER_42_131 VSS VDD FILLER2
XFILLER_42_142 VSS VDD FILLER2
X_15451_ _19406_/Q _15787_/B VDD VSS _15465_/B XNOR2X1
X_12663_ _12683_/A _14472_/B _12663_/C VDD VSS _14473_/C AOI21X1
XTAP_TAPCELL_ROW_6_66 VDD VSS WELLTAP
X_14402_ _14426_/A _14402_/B VDD VSS _19123_/D NOR2X1
X_18170_ _18170_/A _18170_/B VDD VSS _18174_/C NAND2X1
X_11614_ _18757_/Q _11624_/B VDD VSS _18784_/D AND2X1
X_15382_ _15672_/A _18133_/B VDD VSS _19292_/D NOR2X1
XFILLER_11_540 VDD VSS FILLER4
X_12594_ _12732_/A _12732_/C VDD VSS _12724_/C AND2X1
XFILLER_7_500 VDD VSS FILLER1
X_17121_ _17120_/B _17121_/B VDD VSS _17123_/C NOR2BX1
X_14333_ _14334_/A _14333_/B VDD VSS _19061_/D AND2X1
X_11545_ _18694_/Q _11555_/B VDD VSS _18721_/D AND2X1
XTAP_TAPCELL_ROW_40_376 VDD VSS WELLTAP
XFILLER_128_247 VSS VDD FILLER2
XFILLER_128_269 VSS VDD FILLER2
XFILLER_144_718 VSS VDD FILLER2
X_17052_ _17208_/B _17073_/B VDD VSS _17064_/C XNOR2X1
X_14264_ _14270_/A _14264_/B VDD VSS _19002_/D AND2X1
X_11476_ _18632_/Q _11484_/B VDD VSS _18659_/D AND2X1
X_16003_ _16031_/B _16003_/B VDD VSS _16838_/B XNOR2X1
XFILLER_7_599 VSS VDD FILLER2
X_13215_ _13215_/A _13271_/B _13271_/D _13271_/C VDD VSS _13422_/B AO211X2
X_10427_ _10388_/C _10427_/B _10427_/C VDD VSS _10503_/B NAND3BX1
XFILLER_109_494 VSS VDD FILLER2
X_14195_ _14219_/A _14195_/B _14195_/C VDD VSS _18945_/D NOR3X1
XFILLER_152_762 VDD VSS FILLER4
X_13146_ _20012_/Q _19276_/Q VDD VSS _13343_/A XOR2X1
X_10358_ _18625_/Q _10358_/B _10358_/C VDD VSS _10511_/A OA21X2
XFILLER_151_261 VDD VSS FILLER4
XFILLER_124_497 VDD VSS FILLER1
X_17954_ _17955_/A _17955_/B _18187_/C VDD VSS _17955_/C OAI21X1
X_13077_ _13077_/A _13077_/B _14123_/B VDD VSS _13081_/C MIN3X1
XFILLER_111_136 VDD VSS FILLER4
X_10289_ _18658_/Q _18766_/Q VDD VSS _10405_/B XOR2X1
XFILLER_78_540 VDD VSS FILLER4
X_16905_ _20067_/Q _20070_/Q _20071_/Q VDD VSS _16906_/C AND3BX1
X_12028_ _12029_/A _12029_/B _12029_/D _12029_/C VDD VSS _14433_/C AOI211X1
XFILLER_38_404 VDD VSS FILLER1
X_17885_ _17885_/A _17885_/B _17885_/C VDD VSS _17891_/C MIN3X1
XFILLER_65_212 VDD VSS FILLER4
XFILLER_120_692 VDD VSS FILLER4
X_16836_ _16838_/A _16836_/B VDD VSS _19677_/D NOR2X1
X_19624_ _19661_/CK _19624_/D _19624_/Q VDD VSS DFFQX1
XFILLER_93_554 VDD VSS FILLER4
XTAP_TAPCELL_ROW_48_443 VDD VSS WELLTAP
X_19555_ _19600_/CK _19555_/D _19555_/Q VDD VSS DFFQX1
X_16767_ _16768_/A _16767_/B VDD VSS _19615_/D AND2X1
X_13979_ _14020_/A _14135_/B _14020_/C VDD VSS _14137_/B OAI21X1
XTAP_TAPCELL_ROW_125_1140 VDD VSS WELLTAP
X_18506_ _18506_/CK _18506_/D _18506_/Q _09358_/Y VDD VSS DFFRQX1
X_15718_ _15739_/A _15718_/B VDD VSS _19344_/D NOR2X1
X_19486_ _19736_/CK _19486_/D _19486_/Q VDD VSS DFFQX1
X_16698_ _17712_/A _16704_/B VDD VSS _19552_/D NOR2X1
XFILLER_61_440 VSS VDD FILLER2
X_18437_ _18437_/CK _18501_/D _18437_/Q _18469_/RB VDD VSS DFFRQX1
XFILLER_61_462 VSS VDD FILLER2
X_15649_ _15652_/A _15652_/B VDD VSS _18179_/B XNOR2X1
XFILLER_21_326 VSS VDD FILLER2
XFILLER_21_337 VDD VSS FILLER1
X_18368_ _18375_/CK _18496_/D _20205_/A _18464_/RB VDD VSS DFFRQX1
XFILLER_21_359 VSS VDD FILLER2
X_17319_ _17320_/C _17469_/B _17319_/C VDD VSS _19820_/D AND3BX1
XFILLER_159_383 VSS VDD FILLER2
XFILLER_119_225 VDD VSS FILLER4
XFILLER_147_545 VDD VSS FILLER4
X_18299_ _18311_/CK _18512_/Q _18299_/Q _18471_/RB VDD VSS DFFRQX1
XFILLER_119_269 VSS VDD FILLER2
XFILLER_128_781 VSS VDD FILLER2
XFILLER_115_431 VDD VSS FILLER1
XFILLER_162_559 VDD VSS FILLER1
XFILLER_127_291 VDD VSS FILLER4
XFILLER_115_475 VSS VDD FILLER2
X_20192_ _20192_/A VDD VSS _20192_/Y BUFX3
XFILLER_115_486 VSS VDD FILLER2
XFILLER_163_19 VSS VDD FILLER2
XFILLER_142_294 VDD VSS FILLER4
XTAP_TAPCELL_ROW_132_1199 VDD VSS WELLTAP
XFILLER_130_445 VSS VDD FILLER2
XFILLER_102_147 VSS VDD FILLER2
XFILLER_57_713 VSS VDD FILLER2
XFILLER_111_670 VDD VSS DECAPHV8
XFILLER_56_212 VSS VDD FILLER2
XFILLER_111_692 VSS VDD FILLER2
XFILLER_96_381 VSS VDD FILLER2
XFILLER_84_587 VDD VSS DECAPHV8
XFILLER_71_237 VDD VSS FILLER4
X_09506_ _18523_/Q _09507_/B _09506_/C _20080_/Q VDD VSS _20080_/D AO22X2
XFILLER_37_492 VDD VSS FILLER4
XFILLER_112_78 VDD VSS FILLER4
XTAP_TAPCELL_ROW_82_755 VDD VSS WELLTAP
XFILLER_52_440 VSS VDD FILLER2
XFILLER_25_654 VSS VDD FILLER2
XFILLER_13_816 VSS VDD FILLER2
XFILLER_24_142 VSS VDD FILLER2
XFILLER_72_49 VDD VSS FILLER4
XFILLER_40_602 VSS VDD FILLER2
XFILLER_24_153 VSS VDD FILLER2
X_09437_ _09447_/B _09753_/D VDD VSS _18216_/E NOR2X1
XFILLER_80_793 VDD VSS FILLER4
XFILLER_24_175 VDD VSS FILLER4
XFILLER_40_657 VDD VSS FILLER1
XFILLER_12_359 VSS VDD FILLER2
XFILLER_138_501 VDD VSS FILLER4
X_09368_ _09576_/B VDD VSS _09770_/B BUFX3
XFILLER_166_821 VDD VSS FILLER4
XFILLER_138_534 VSS VDD FILLER2
X_09299_ _09299_/A VDD VSS _09299_/Y BUFX3
X_11330_ _11370_/A _11330_/B _11370_/C VDD VSS _11339_/B OAI21X1
XFILLER_126_718 VSS VDD FILLER2
XFILLER_153_504 VSS VDD FILLER2
XFILLER_138_589 VSS VDD FILLER2
XFILLER_165_375 VSS VDD FILLER2
XFILLER_153_526 VSS VDD FILLER2
XFILLER_4_514 VSS VDD FILLER2
XFILLER_21_53 VSS VDD FILLER2
X_11261_ _11262_/B _11261_/B _11261_/C _11378_/A VDD VSS _18580_/D AOI211X1
XFILLER_137_75 VSS VDD FILLER2
X_13000_ _19021_/Q _14287_/B _14287_/C VDD VSS _13008_/C OR3BX1
X_10212_ _18592_/Q _10220_/C VDD VSS _10213_/B NAND2X1
XFILLER_4_569 VSS VDD FILLER2
XFILLER_97_35 VSS VDD FILLER2
X_11192_ _18682_/Q _18790_/Q _11169_/B VDD VSS _11224_/C AOI21BX1
XFILLER_133_272 VSS VDD FILLER2
XFILLER_79_337 VDD VSS FILLER4
X_10143_ _10153_/B _10190_/C _10127_/A VDD VSS _10166_/B MUXI2X1
XFILLER_0_731 VDD VSS FILLER1
XFILLER_121_456 VDD VSS DECAPHV8
XFILLER_121_478 VSS VDD FILLER2
XFILLER_0_775 VSS VDD FILLER2
X_14951_ _14951_/A _14951_/B _15681_/B VDD VSS _14989_/B MIN3X1
X_10074_ _10075_/A _10075_/B _10075_/D _10075_/C VDD VSS _10074_/Y OAOI211X1
XFILLER_87_370 VSS VDD FILLER2
X_13902_ _19032_/Q _14300_/B _14300_/C VDD VSS _13903_/D NOR3BX1
XFILLER_153_96 VSS VDD FILLER2
X_17670_ _17672_/A _17670_/B _17670_/C VDD VSS _19895_/D AOI21X1
X_14882_ _15015_/A _15015_/B _15015_/D _15015_/C VDD VSS _14918_/D OAI211X1
X_16621_ _19670_/Q _16621_/B _16829_/B VDD VSS _16647_/B MIN3X1
XFILLER_90_502 VSS VDD FILLER2
X_13833_ _19003_/Q _13833_/B _13843_/C VDD VSS _13891_/C XNOR3X1
X_19340_ _19573_/CK _19340_/D _19340_/Q VDD VSS DFFQX1
X_16552_ _16573_/A _16573_/B VDD VSS _16755_/B XNOR2X1
XFILLER_46_94 VDD VSS FILLER1
X_13764_ _14263_/B _14263_/C _19001_/Q VDD VSS _13768_/B AOI21X1
XFILLER_90_568 VSS VDD FILLER2
X_10976_ _11004_/C _11004_/B VDD VSS _10977_/B NAND2BX1
XFILLER_43_440 VSS VDD FILLER2
XFILLER_43_451 VDD VSS FILLER1
X_15503_ _19351_/Q _15725_/B VDD VSS _15504_/C AND2X1
X_19271_ _20007_/CK _19271_/D _19271_/Q VDD VSS DFFQX1
X_12715_ _12868_/A _12868_/B VDD VSS _14285_/B XNOR2X1
X_16483_ _19665_/Q _16823_/B VDD VSS _16494_/B XOR2X1
X_13695_ _19030_/Q VDD VSS _13777_/A INVX1
X_18222_ _18235_/CK _18222_/E _18222_/ECK VDD VSS CGX3
X_15434_ _15434_/A _15434_/B VDD VSS _15472_/A OR2X2
XTAP_TAPCELL_ROW_53_490 VDD VSS WELLTAP
X_12646_ _19158_/Q VDD VSS _12737_/A INVX1
XFILLER_157_821 VDD VSS FILLER4
XTAP_TAPCELL_ROW_120_1092 VDD VSS WELLTAP
XFILLER_157_832 VDD VSS FILLER4
XFILLER_129_534 VSS VDD FILLER2
X_18153_ _19296_/Q _18153_/B _18153_/C VDD VSS _18159_/A MIN3X1
XFILLER_7_11 VSS VDD FILLER2
X_15365_ _15395_/C _15365_/B VDD VSS _15848_/B NAND2BX1
XFILLER_157_854 VSS VDD FILLER2
XFILLER_11_370 VSS VDD FILLER2
X_12577_ _12577_/A _12577_/B _12583_/A _12577_/D VDD VSS _12673_/C AOI211X1
XFILLER_129_556 VSS VDD FILLER2
X_17104_ _19775_/Q _19743_/Q VDD VSS _17105_/B XOR2X1
XFILLER_156_353 VSS VDD FILLER2
X_14316_ _18163_/A VDD VSS _14316_/Y BUFX3
X_18084_ _19283_/Q _18084_/B VDD VSS _18085_/A AND2X1
X_11528_ _18680_/Q _11531_/B VDD VSS _18707_/D AND2X1
XFILLER_7_352 VSS VDD FILLER2
X_15296_ _15335_/A _15296_/B VDD VSS _18123_/B XNOR2X1
X_17035_ _19761_/Q _17047_/B VDD VSS _17040_/B XOR2X1
XFILLER_7_385 VDD VSS FILLER4
X_14247_ _14270_/A _14247_/B VDD VSS _18987_/D AND2X1
X_11459_ _19952_/Q _11460_/B VDD VSS _18645_/D AND2X1
XFILLER_98_602 VSS VDD FILLER2
XFILLER_124_250 VSS VDD FILLER2
Xclkbuf_1_1__f__09180_ clkbuf_0__09180_/Y VDD VSS _18625_/CK BUFX12
XFILLER_125_784 VDD VSS FILLER4
X_14178_ _14186_/A _14178_/B VDD VSS _18930_/D NOR2X1
XFILLER_124_272 VSS VDD FILLER2
XFILLER_140_743 VSS VDD FILLER2
X_13129_ _13133_/A _13133_/C _13133_/B _13129_/D VDD VSS _13444_/A AO31X2
XFILLER_98_657 VSS VDD FILLER2
XFILLER_86_808 VDD VSS FILLER4
X_18986_ _19037_/CK _18986_/D _18986_/Q VDD VSS DFFQX1
XFILLER_86_819 VSS VDD FILLER2
XFILLER_100_607 VDD VSS DECAPHV16
X_17937_ _17937_/A _17937_/B _18865_/Q VDD VSS _17946_/B AOI21X1
XFILLER_97_189 VSS VDD FILLER2
XFILLER_38_201 VSS VDD FILLER2
XFILLER_38_212 VSS VDD FILLER2
XFILLER_66_532 VDD VSS FILLER4
X_17868_ _18849_/Q _17868_/B _17868_/C VDD VSS _17869_/C MIN3X1
XFILLER_38_267 VDD VSS FILLER1
X_19607_ _19737_/CK _19607_/D _19607_/Q VDD VSS DFFQX1
X_16819_ _16826_/A _16819_/B VDD VSS _19661_/D NOR2X1
XFILLER_66_598 VDD VSS FILLER4
X_17799_ _19924_/Q _19892_/Q VDD VSS _17802_/A XNOR2X1
Xclkbuf_0__000_ _230_/ECK VDD VSS clkbuf_0__000_/Y BUFX12
XFILLER_81_535 VDD VSS FILLER1
XFILLER_19_481 VDD VSS FILLER1
XFILLER_53_237 VSS VDD FILLER2
XFILLER_53_248 VDD VSS FILLER1
X_19538_ _19734_/CK _19538_/D _19538_/Q VDD VSS DFFQX1
XFILLER_34_451 VSS VDD FILLER2
X_19469_ _19531_/CK _19469_/D _19469_/Q VDD VSS DFFQX1
XFILLER_34_473 VSS VDD FILLER2
XFILLER_62_793 VDD VSS DECAPHV16
XFILLER_61_270 VSS VDD FILLER2
XFILLER_22_624 VSS VDD FILLER2
X_09222_ _18525_/Q VDD VSS _18392_/D INVX1
XFILLER_61_292 VDD VSS DECAPHV8
XFILLER_22_668 VSS VDD FILLER2
XFILLER_158_19 VDD VSS FILLER1
XFILLER_147_331 VSS VDD FILLER2
XFILLER_21_189 VSS VDD FILLER2
XFILLER_108_729 VSS VDD FILLER2
XFILLER_147_375 VDD VSS FILLER4
XTAP_TAPCELL_ROW_134_1217 VDD VSS WELLTAP
XFILLER_163_835 VSS VDD FILLER2
XFILLER_116_762 VDD VSS FILLER1
XFILLER_115_250 VSS VDD FILLER2
XFILLER_150_529 VDD VSS DECAPHV16
XFILLER_1_517 VSS VDD FILLER2
XFILLER_115_272 VDD VSS FILLER4
XFILLER_88_123 VSS VDD FILLER2
XFILLER_103_434 VSS VDD FILLER2
XFILLER_131_743 VDD VSS FILLER1
X_20175_ _20175_/A VDD VSS _20175_/Y BUFX3
XFILLER_131_765 VDD VSS FILLER4
X_09986_ _18578_/Q _09986_/B VDD VSS _09986_/Y XOR2X1
XFILLER_88_156 VDD VSS FILLER1
XFILLER_131_776 VSS VDD FILLER2
XFILLER_76_307 VSS VDD FILLER2
XFILLER_69_370 VSS VDD FILLER2
XFILLER_57_510 VSS VDD FILLER2
XFILLER_84_340 VSS VDD FILLER2
XFILLER_57_565 VSS VDD FILLER2
XFILLER_45_716 VDD VSS FILLER4
XFILLER_17_418 VSS VDD FILLER2
XFILLER_57_587 VDD VSS FILLER1
XFILLER_29_278 VDD VSS FILLER1
XFILLER_45_738 VDD VSS FILLER4
XFILLER_44_215 VSS VDD FILLER2
X_10830_ _18672_/Q _18780_/Q VDD VSS _10832_/C XNOR2X1
XFILLER_16_31 VSS VDD FILLER2
XFILLER_25_462 VSS VDD FILLER2
X_10761_ _10801_/A _10761_/B VDD VSS _10762_/C XNOR2X1
XFILLER_53_793 VSS VDD FILLER2
XFILLER_12_112 VSS VDD FILLER2
XFILLER_40_421 VSS VDD FILLER2
XFILLER_158_607 VDD VSS FILLER4
X_12500_ _12583_/A _12583_/B VDD VSS _12677_/C NOR2X1
XFILLER_12_134 VDD VSS FILLER4
XFILLER_139_810 VSS VDD FILLER2
X_13480_ _13511_/A _13511_/B _13511_/C VDD VSS _13489_/C OAI21X1
X_10692_ _10729_/C _10729_/D _10693_/D _10729_/E VDD VSS _10692_/Y AOI211X1
XFILLER_139_821 VDD VSS FILLER1
XFILLER_40_465 VSS VDD FILLER2
X_12431_ _12528_/A _12528_/B _12611_/C VDD VSS _17853_/B XNOR3X1
XTAP_TAPCELL_ROW_50_460 VDD VSS WELLTAP
XFILLER_139_854 VSS VDD FILLER2
XTAP_TAPCELL_ROW_156_1420 VDD VSS WELLTAP
XFILLER_32_41 VDD VSS FILLER4
XFILLER_166_640 VDD VSS FILLER4
XFILLER_148_30 VSS VDD FILLER2
XFILLER_21_690 VSS VDD FILLER2
XFILLER_166_651 VSS VDD FILLER2
XFILLER_138_353 VDD VSS DECAPHV8
X_15150_ _19510_/Q _15904_/B VDD VSS _15275_/A NAND2BX1
XFILLER_154_813 VSS VDD FILLER2
X_12362_ _19098_/Q _14375_/B _14375_/C VDD VSS _12363_/D OR3BX1
X_14101_ _14101_/A _14101_/B _14101_/C _14101_/D VDD VSS _17964_/B AOAI211X1
X_11313_ _11316_/A _11316_/B VDD VSS _11314_/B XNOR2X1
X_15081_ _19369_/Q _15081_/B _15746_/B VDD VSS _15134_/A MIN3X1
X_12293_ _12294_/B _12294_/C _12512_/A VDD VSS _12366_/B OAI21X1
XFILLER_153_367 VDD VSS FILLER4
XFILLER_141_518 VSS VDD FILLER2
X_14032_ _14045_/A _14045_/B _14032_/C _14045_/E VDD VSS _14202_/B AOI211X1
X_11244_ _11255_/A _11244_/B _11255_/C VDD VSS _11288_/B AOI21X1
XFILLER_122_710 VSS VDD FILLER2
XTAP_TAPCELL_ROW_111_1014 VDD VSS WELLTAP
XFILLER_122_743 VDD VSS DECAPHV8
XFILLER_79_123 VSS VDD FILLER2
X_18840_ _19959_/CK _18840_/D _18840_/Q VDD VSS DFFQX1
X_11175_ _11176_/B _11175_/B VDD VSS _11177_/B NOR2BX1
XFILLER_79_156 VSS VDD FILLER2
X_10126_ _10126_/A _10126_/B _10126_/C VDD VSS _10150_/A OAI21X1
X_18771_ _18799_/CK _18771_/D _18771_/Q VDD VSS DFFQX1
XFILLER_79_178 VSS VDD FILLER2
XFILLER_121_275 VDD VSS FILLER4
X_15983_ _19676_/Q _16835_/B VDD VSS _16015_/B XOR2X1
XFILLER_79_189 VDD VSS FILLER4
XFILLER_0_583 VSS VDD FILLER2
XFILLER_121_286 VSS VDD FILLER2
XFILLER_95_649 VSS VDD FILLER2
XFILLER_88_690 VDD VSS FILLER4
XFILLER_0_594 VSS VDD FILLER2
X_17722_ _19907_/Q _19875_/Q VDD VSS _17724_/B XOR2X1
X_14934_ _19450_/Q wire162/Y _15000_/B VDD VSS _14959_/D XNOR3X1
X_10057_ _10031_/Y _10056_/Y _10155_/A VDD VSS _10059_/B MUX2X1
XFILLER_94_148 VSS VDD FILLER2
XFILLER_91_800 VSS VDD FILLER2
X_17653_ _19891_/Q _19859_/Q _17653_/C VDD VSS _17657_/C MIN3X1
X_14865_ _14865_/A _14865_/B _14865_/C _14865_/D VDD VSS _15833_/C OA211X2
XFILLER_75_384 VDD VSS DECAPHV8
XTAP_TAPCELL_ROW_163_1479 VDD VSS WELLTAP
X_16604_ _19606_/Q _16757_/B VDD VSS _16606_/C XOR2X1
X_13816_ _13816_/A _13816_/B _13816_/C _13816_/D VDD VSS _13987_/A AOAI211X1
XFILLER_63_557 VDD VSS FILLER1
X_17584_ _17589_/C _17589_/B VDD VSS _17586_/B NAND2BX1
XFILLER_63_568 VDD VSS FILLER4
X_14796_ _19419_/Q _14813_/B _15802_/B VDD VSS _15769_/B XNOR3X1
XTAP_TAPCELL_ROW_122_1110 VDD VSS WELLTAP
XFILLER_63_579 VDD VSS FILLER4
X_19323_ _19333_/CK _19323_/D _19323_/Q VDD VSS DFFQX1
X_16535_ _19699_/Q _16861_/B VDD VSS _16537_/C XOR2X1
X_13747_ _18917_/Q _14163_/B _14163_/C VDD VSS _13751_/D OR3BX1
X_10959_ _11263_/A _10996_/A VDD VSS _10989_/A NOR2X1
XFILLER_44_793 VDD VSS DECAPHV8
XFILLER_71_590 VSS VDD FILLER2
XFILLER_92_5 VSS VDD FILLER2
XFILLER_149_618 VDD VSS FILLER1
X_19254_ _19996_/CK _19254_/D _19254_/Q VDD VSS DFFQX1
X_16466_ _19728_/Q VDD VSS _16467_/A INVX1
X_13678_ _13768_/A _13830_/B VDD VSS _14228_/B XNOR2X1
XFILLER_148_117 VSS VDD FILLER2
XFILLER_85_4 VSS VDD FILLER2
X_15417_ _15456_/A _15417_/B VDD VSS _15692_/B XNOR2X1
X_19185_ _19185_/CK _19185_/D _19185_/Q VDD VSS DFFQX1
X_12629_ _12630_/A _12630_/B _12630_/D _12630_/C VDD VSS _12731_/B OAOI211X1
X_16397_ _19598_/Q _16748_/B VDD VSS _16420_/B XOR2X1
XFILLER_157_640 VSS VDD FILLER2
X_18136_ _18136_/A _18136_/B _18136_/C VDD VSS _18139_/B OAI21X1
XFILLER_157_673 VSS VDD FILLER2
X_15348_ _15348_/A _15815_/B _15348_/C VDD VSS _15391_/B OA21X2
XFILLER_8_661 VSS VDD FILLER2
XFILLER_129_375 VSS VDD FILLER2
XFILLER_8_672 VDD VSS FILLER1
XFILLER_117_537 VDD VSS FILLER1
XFILLER_129_397 VSS VDD FILLER2
XFILLER_144_323 VSS VDD FILLER2
XFILLER_8_694 VSS VDD FILLER2
X_18067_ _18069_/A _18069_/B _18067_/C VDD VSS _19988_/D AOI21X1
X_15279_ _19486_/Q _15308_/A _15308_/B VDD VSS _15281_/C XOR3X1
XFILLER_160_805 VDD VSS FILLER1
X_17018_ _17009_/B _17018_/B VDD VSS _17019_/D NAND2BX1
XFILLER_125_570 VSS VDD FILLER2
XFILLER_98_410 VDD VSS DECAPHV8
XFILLER_98_421 VSS VDD FILLER2
XFILLER_113_743 VDD VSS FILLER1
X_09840_ _09910_/A _09910_/B VDD VSS _09841_/C NOR2X1
XFILLER_98_443 VSS VDD FILLER2
XFILLER_100_415 VSS VDD FILLER2
X_09771_ _20150_/A _09785_/B _09784_/C _20175_/A VDD VSS _09772_/D AOI22X1
X_18969_ _18997_/CK _18969_/D _18969_/Q VDD VSS DFFQX1
XTAP_TAPCELL_ROW_56_519 VDD VSS WELLTAP
XFILLER_82_822 VSS VDD FILLER2
XFILLER_27_727 VDD VSS DECAPHV8
XFILLER_39_598 VSS VDD FILLER2
XFILLER_94_693 VDD VSS FILLER4
XFILLER_26_215 VSS VDD FILLER2
XFILLER_26_237 VDD VSS FILLER1
XFILLER_41_207 VSS VDD FILLER2
XTAP_TAPCELL_ROW_64_585 VDD VSS WELLTAP
XTAP_TAPCELL_ROW_104_951 VDD VSS WELLTAP
XFILLER_41_229 VSS VDD FILLER2
XFILLER_35_782 VSS VDD FILLER2
XFILLER_34_281 VDD VSS FILLER4
XFILLER_22_421 VDD VSS FILLER4
XTAP_TAPCELL_ROW_140_1276 VDD VSS WELLTAP
XFILLER_34_292 VSS VDD FILLER2
XFILLER_50_785 VDD VSS FILLER4
X_09205_ _18514_/Q VDD VSS _18429_/D INVX1
XFILLER_108_504 VDD VSS FILLER4
XFILLER_135_312 VSS VDD FILLER2
XFILLER_148_695 VSS VDD FILLER2
XFILLER_147_172 VSS VDD FILLER2
XFILLER_147_183 VSS VDD FILLER2
XFILLER_163_654 VSS VDD FILLER2
XFILLER_118_44 VSS VDD FILLER2
XFILLER_163_676 VSS VDD FILLER2
XFILLER_162_142 VSS VDD FILLER2
XTAP_TAPCELL_ROW_151_1372 VDD VSS WELLTAP
XFILLER_89_421 VSS VDD FILLER2
XFILLER_116_592 VSS VDD FILLER2
XFILLER_134_32 VSS VDD FILLER2
XFILLER_89_487 VDD VSS FILLER1
X_20158_ _20158_/A VDD VSS _20158_/Y BUFX3
XFILLER_76_115 VSS VDD FILLER2
XFILLER_103_286 VSS VDD FILLER2
XFILLER_77_649 VSS VDD FILLER2
XFILLER_58_852 VDD VSS FILLER1
X_20089_ _20089_/A VDD VSS _20089_/Y BUFX3
X_12980_ _18993_/Q _14254_/B VDD VSS _13004_/A NAND2X1
XFILLER_73_811 VSS VDD FILLER2
X_11931_ _19996_/Q _19260_/Q VDD VSS _11933_/C NAND2X1
XFILLER_17_204 VDD VSS FILLER1
XFILLER_91_129 VDD VSS FILLER1
XFILLER_57_384 VSS VDD FILLER2
XFILLER_150_20 VDD VSS FILLER4
XFILLER_72_321 VDD VSS FILLER4
XFILLER_72_332 VSS VDD FILLER2
X_14650_ _14742_/C _14705_/C VDD VSS _15891_/B OR2X2
X_11862_ _19090_/Q VDD VSS _11864_/A INVX1
XFILLER_60_505 VDD VSS FILLER4
XFILLER_27_96 VSS VDD FILLER2
XFILLER_150_75 VDD VSS FILLER1
XTAP_TAPCELL_ROW_27_254 VDD VSS WELLTAP
X_13601_ _13601_/A _13601_/B _13601_/C _13601_/D VDD VSS _14326_/B AOAI211X1
X_10813_ _10814_/A _10814_/B _10814_/C VDD VSS _10813_/Y NOR3X1
X_14581_ _14584_/B _14584_/C VDD VSS _15856_/B XNOR2X1
XFILLER_26_793 VSS VDD FILLER2
X_11793_ _11793_/A _11793_/B _14458_/B VDD VSS _11794_/B MIN3X1
XFILLER_60_549 VSS VDD FILLER2
Xclkbuf_1_0__f__09183_ clkbuf_0__09183_/Y VDD VSS _18543_/CK BUFX12
XFILLER_41_730 VDD VSS FILLER1
X_16320_ _16320_/A _16320_/B _16320_/C VDD VSS _16321_/B NOR3X1
X_13532_ _13728_/B _14326_/C _19055_/Q VDD VSS _13533_/D AND3BX1
XFILLER_13_454 VSS VDD FILLER2
X_10744_ _10785_/A _10785_/B VDD VSS _10745_/B NAND2X1
X_16251_ _19688_/Q _16251_/B _16849_/B VDD VSS _16278_/B MIN3X1
XFILLER_40_273 VDD VSS FILLER1
XFILLER_159_51 VSS VDD FILLER2
X_13463_ _19223_/Q _14516_/B VDD VSS _13557_/B XOR2X1
X_10675_ _10718_/C _10675_/B VDD VSS _10679_/A NAND2BX1
XFILLER_9_458 VDD VSS FILLER4
X_15202_ _15201_/B _15227_/B VDD VSS _15812_/C NOR2BX1
X_12414_ _19212_/Q _12486_/B _12497_/C VDD VSS _12662_/B XNOR3X1
XFILLER_139_684 VDD VSS FILLER1
X_16182_ _16163_/A _16182_/B _16182_/C VDD VSS _16206_/B AOI2B1X1
XFILLER_127_835 VSS VDD FILLER2
XFILLER_138_161 VDD VSS FILLER4
X_13394_ _18997_/Q _14259_/B _14259_/C VDD VSS _13395_/D OR3BX1
XFILLER_126_323 VSS VDD FILLER2
XFILLER_154_632 VSS VDD FILLER2
X_15133_ _19342_/Q _15716_/B _15133_/C VDD VSS _15172_/A MIN3X1
X_12345_ _13283_/A _17847_/B VDD VSS _18847_/D AND2X1
XFILLER_5_631 VDD VSS FILLER4
XFILLER_126_356 VSS VDD FILLER2
XFILLER_5_664 VSS VDD FILLER2
XFILLER_126_378 VDD VSS FILLER1
XFILLER_141_304 VSS VDD FILLER2
XFILLER_142_838 VSS VDD FILLER2
X_15064_ _15872_/B _15064_/B _15099_/C VDD VSS _15873_/B XNOR3X1
X_19941_ _19943_/CK _19941_/D _19941_/Q VDD VSS DFFQX1
X_12276_ _18959_/Q VDD VSS _12354_/A INVX1
XFILLER_141_348 VSS VDD FILLER2
X_14015_ _18951_/Q _14015_/B _14032_/C VDD VSS _14054_/C XNOR3X1
XFILLER_141_359 VDD VSS FILLER1
X_11227_ _18656_/Q _18818_/Q _11227_/C VDD VSS _11229_/B MIN3X1
XFILLER_122_540 VSS VDD FILLER2
X_19872_ _19924_/CK _19872_/D _19872_/Q VDD VSS DFFQX1
XFILLER_122_551 VDD VSS FILLER1
XFILLER_110_713 VSS VDD FILLER2
X_18823_ _18823_/CK _18823_/D _18823_/Q VDD VSS DFFQX1
X_11158_ _18575_/Q _11158_/B _11158_/C VDD VSS _11217_/A MIN3X1
XFILLER_68_81 VSS VDD FILLER2
X_10109_ _10131_/A _10191_/B _10109_/C _18609_/Q VDD VSS _10122_/A AOAI211X1
X_15966_ _19582_/Q _16731_/B VDD VSS _15993_/B XOR2X1
X_18754_ _19940_/CK _18754_/D _18754_/Q VDD VSS DFFQX1
X_11089_ _18574_/Q VDD VSS _11126_/A INVX1
XFILLER_95_468 VDD VSS FILLER4
XFILLER_83_608 VSS VDD FILLER2
XFILLER_48_340 VSS VDD FILLER2
XFILLER_64_800 VDD VSS DECAPHV8
X_14917_ _14918_/A _14918_/B _14966_/B _14918_/D VDD VSS _15868_/B AND4X2
X_17705_ _17707_/B _17705_/B VDD VSS _17706_/B XOR2X1
XFILLER_48_373 VSS VDD FILLER2
XFILLER_82_129 VSS VDD FILLER2
X_15897_ _15906_/A _15897_/B VDD VSS _19503_/D NOR2X1
X_18685_ _18767_/CK _18685_/D _18685_/Q VDD VSS DFFQX1
XFILLER_75_170 VSS VDD FILLER2
XFILLER_36_535 VSS VDD FILLER2
X_14848_ _19336_/Q _15709_/B VDD VSS _14851_/A XOR2X1
X_17636_ _17638_/A _17638_/B _17636_/C VDD VSS _19888_/D AOI21X1
XFILLER_90_151 VDD VSS FILLER4
XFILLER_91_685 VSS VDD FILLER2
XFILLER_23_218 VSS VDD FILLER2
X_17567_ _19873_/Q _19841_/Q _17567_/C VDD VSS _17570_/B MIN3X1
Xclkbuf_leaf_16__000_ clkload71/A VDD VSS _19661_/CK BUFX12
XFILLER_51_538 VSS VDD FILLER2
X_14779_ _14818_/A _14818_/B _14818_/C VDD VSS _14795_/A AOI21X1
X_16518_ _19666_/Q _16518_/B _16824_/B VDD VSS _16545_/B MIN3X1
X_19306_ _19306_/CK _19306_/D _19306_/Q VDD VSS DFFQX1
XTAP_TAPCELL_ROW_101_921 VDD VSS WELLTAP
X_17498_ _19858_/Q _19826_/Q _17498_/C VDD VSS _17503_/C AO21X2
XTAP_TAPCELL_ROW_61_566 VDD VSS WELLTAP
XFILLER_32_763 VSS VDD FILLER2
XFILLER_149_459 VDD VSS FILLER4
X_16449_ _19919_/Q VDD VSS _16715_/A INVX1
X_19237_ _20004_/CK _19237_/D _19237_/Q VDD VSS DFFQX1
XFILLER_31_273 VDD VSS FILLER4
XFILLER_118_802 VDD VSS FILLER4
XFILLER_76_0 VSS VDD FILLER2
XFILLER_118_824 VSS VDD FILLER2
X_19168_ _19196_/CK _19168_/D _19168_/Q VDD VSS DFFQX1
XFILLER_118_835 VDD VSS FILLER1
XFILLER_129_183 VSS VDD FILLER2
XFILLER_157_492 VSS VDD FILLER2
X_18119_ _19290_/Q _18123_/B VDD VSS _18121_/C XOR2X1
XFILLER_8_491 VSS VDD FILLER2
XFILLER_145_654 VSS VDD FILLER2
X_19099_ _19126_/CK _19099_/D _19099_/Q VDD VSS DFFQX1
XFILLER_144_142 VDD VSS DECAPHV8
XFILLER_117_367 VDD VSS FILLER4
XFILLER_160_602 VSS VDD FILLER2
XFILLER_105_518 VSS VDD FILLER2
XFILLER_145_687 VDD VSS FILLER1
XFILLER_117_389 VDD VSS FILLER4
XFILLER_144_197 VSS VDD FILLER2
X_09973__244 _20054_/CK VDD VSS _18520_/CK INVX1
XFILLER_99_763 VDD VSS FILLER4
XFILLER_98_251 VSS VDD FILLER2
X_20012_ _20013_/CK _20012_/D _20012_/Q VDD VSS DFFQX1
XFILLER_48_18 VDD VSS FILLER4
XFILLER_101_713 VSS VDD FILLER2
X_09823_ _10266_/C VDD VSS _10686_/D BUFX3
XFILLER_113_584 VDD VSS FILLER4
XFILLER_100_212 VDD VSS FILLER1
XFILLER_59_649 VSS VDD FILLER2
XTAP_TAPCELL_ROW_69_633 VDD VSS WELLTAP
XFILLER_58_137 VSS VDD FILLER2
Xclkbuf_0__09177_ _18226_/ECK VDD VSS clkbuf_0__09177_/Y BUFX12
X_09754_ _20077_/Q _09818_/B _09754_/C _09816_/D _09754_/E VDD VSS _09761_/A AOI221X1
XFILLER_58_159 VDD VSS FILLER4
XFILLER_73_107 VDD VSS FILLER1
XFILLER_67_671 VSS VDD FILLER2
X_09685_ _18447_/Q VDD VSS _20159_/A INVX1
XFILLER_55_844 VSS VDD FILLER2
XFILLER_82_641 VDD VSS FILLER4
XFILLER_66_192 VDD VSS FILLER4
XFILLER_82_663 VSS VDD FILLER2
XFILLER_54_354 VDD VSS FILLER1
XFILLER_82_674 VDD VSS FILLER1
XFILLER_27_579 VSS VDD FILLER2
XFILLER_81_162 VSS VDD FILLER2
XFILLER_70_836 VDD VSS FILLER4
XFILLER_120_23 VSS VDD FILLER2
XFILLER_23_730 VDD VSS FILLER4
XFILLER_23_741 VSS VDD FILLER2
XFILLER_120_67 VDD VSS FILLER4
XFILLER_23_763 VDD VSS FILLER4
XFILLER_23_774 VDD VSS FILLER1
XFILLER_13_10 VDD VSS FILLER4
XFILLER_80_49 VSS VDD FILLER2
X_10460_ _10460_/A _10460_/B _10460_/C _10460_/D VDD VSS _10461_/B AOI211X1
XFILLER_109_835 VSS VDD FILLER2
XFILLER_13_76 VDD VSS FILLER4
XFILLER_108_323 VSS VDD FILLER2
X_10391_ _10392_/A _10392_/B VDD VSS _10393_/B NAND2X1
XFILLER_163_462 VSS VDD FILLER2
XFILLER_151_613 VSS VDD FILLER2
X_12130_ _18957_/Q VDD VSS _12199_/A INVX1
XFILLER_89_69 VSS VDD FILLER2
XFILLER_108_389 VSS VDD FILLER2
XTAP_TAPCELL_ROW_0_13 VDD VSS WELLTAP
XFILLER_135_197 VDD VSS DECAPHV8
X_12061_ _19123_/Q wire160/Y _12181_/B VDD VSS _12254_/B XNOR3X1
XFILLER_151_679 VSS VDD FILLER2
XFILLER_2_667 VSS VDD FILLER2
X_11012_ _11196_/A _18731_/Q VDD VSS _11013_/D NAND2X1
XFILLER_131_370 VSS VDD FILLER2
XFILLER_131_381 VDD VSS FILLER1
X_15820_ _15830_/A _15820_/B VDD VSS _19435_/D NOR2X1
XFILLER_77_468 VSS VDD FILLER2
XFILLER_92_405 VDD VSS FILLER4
XFILLER_38_62 VSS VDD FILLER2
XFILLER_92_416 VSS VDD FILLER2
X_15751_ _15758_/A _15751_/B VDD VSS _19374_/D NOR2X1
XFILLER_38_84 VDD VSS FILLER1
X_12963_ _20009_/Q _19273_/Q VDD VSS _13054_/A XNOR2X1
XFILLER_45_310 VSS VDD FILLER2
XFILLER_161_63 VDD VSS FILLER4
XFILLER_85_490 VSS VDD FILLER2
X_14702_ _19444_/Q _14702_/B _14702_/C VDD VSS _14776_/B MIN3X1
XFILLER_45_332 VDD VSS FILLER4
XFILLER_18_557 VDD VSS FILLER4
XFILLER_161_96 VSS VDD FILLER2
X_18470_ _18471_/CK _18470_/D _18470_/Q _18471_/RB VDD VSS DFFRQX1
X_11914_ _19174_/Q _14460_/B VDD VSS _11916_/C _14460_/C AND3X2
XFILLER_45_343 VSS VDD FILLER2
X_15682_ _15706_/A _15682_/B VDD VSS _19311_/D AND2X1
X_12894_ _12894_/A _12894_/B _12894_/C VDD VSS _12896_/B OA21X2
XFILLER_18_579 VDD VSS FILLER1
XTAP_TAPCELL_ROW_160_1449 VDD VSS WELLTAP
XFILLER_33_516 VDD VSS FILLER4
X_17421_ _17536_/A _17421_/B _17422_/C VDD VSS _19842_/D NOR3X1
XFILLER_33_527 VDD VSS FILLER4
X_14633_ _19386_/Q _15764_/B VDD VSS _14667_/B NOR2X1
X_11845_ _19231_/Q _11881_/D _11845_/C VDD VSS _11979_/C XNOR3X1
XFILLER_54_72 VDD VSS DECAPHV16
X_17352_ _19828_/Q _19796_/Q VDD VSS _17355_/A XNOR2X1
X_14564_ _20003_/Q _14569_/B VDD VSS _19267_/D AND2X1
XFILLER_159_724 VDD VSS FILLER1
XFILLER_13_240 VSS VDD FILLER2
X_11776_ _11776_/A _11776_/B _11776_/C _11776_/D VDD VSS _11828_/A AOAI211X1
Xclkbuf_1_0__f__09166_ clkbuf_0__09166_/Y VDD VSS _18423_/CK BUFX12
XFILLER_14_785 VDD VSS FILLER4
X_16303_ _16301_/Y _16305_/B _17986_/C VDD VSS _19530_/D AND3BX1
X_13515_ _18971_/Q wire154/Y _14225_/C VDD VSS _13516_/D OR3BX1
XFILLER_13_284 VDD VSS FILLER1
X_17283_ _19813_/Q _19781_/Q VDD VSS _17289_/B NAND2X1
X_10727_ _18695_/Q _18749_/Q VDD VSS _10765_/A NOR2X1
XFILLER_41_593 VSS VDD FILLER2
X_14495_ _14491_/Y _14495_/B _14495_/C VDD VSS _19206_/D AND3BX1
X_19022_ _19094_/CK _19022_/D _19022_/Q VDD VSS DFFQX1
X_16234_ _19560_/Q _19912_/Q VDD VSS _16237_/A XOR2X1
XFILLER_9_266 VSS VDD FILLER2
X_13446_ _14544_/A _14544_/B _19249_/Q VDD VSS _13447_/D OAI21X1
XFILLER_9_277 VSS VDD FILLER2
X_10658_ _11267_/A _10658_/B VDD VSS _10659_/D NOR2X1
XFILLER_70_82 VDD VSS FILLER1
Xclkload14 _19791_/CK VDD VSS clkload14/Y BUFX12
XFILLER_127_643 VDD VSS FILLER1
Xclkload25 _18823_/CK VDD VSS clkload25/Y INVX1
XFILLER_62_6 VSS VDD FILLER2
XFILLER_127_654 VSS VDD FILLER2
X_16165_ _16179_/B _16165_/B VDD VSS _16810_/B XNOR2X1
Xclkload36 _19250_/CK VDD VSS clkload36/Y INVX2
Xclkload47 _19068_/CK VDD VSS clkload47/Y BUFX12
X_13377_ _18942_/Q _13377_/B _13391_/D VDD VSS _13393_/C XNOR3X1
XFILLER_126_142 VDD VSS FILLER4
Xclkload58 _18924_/CK VDD VSS clkload58/Y INVX2
X_10589_ _18559_/Q _10589_/B VDD VSS _10592_/D NOR2X1
X_09957__228 _20052_/CK VDD VSS _18504_/CK INVX1
XFILLER_126_153 VSS VDD FILLER2
Xclkload69 _18999_/CK VDD VSS clkload69/Y INVX1
XFILLER_5_450 VSS VDD FILLER2
X_15116_ _15116_/A _15116_/B VDD VSS _15810_/B XNOR2X1
XTAP_TAPCELL_ROW_117_1064 VDD VSS WELLTAP
XFILLER_114_315 VDD VSS FILLER1
XFILLER_142_624 VSS VDD FILLER2
X_12328_ _12329_/D _14501_/B VDD VSS _12474_/A NAND2X1
X_16096_ _19682_/Q _16842_/B VDD VSS _16097_/B XNOR2X1
XFILLER_154_484 VSS VDD FILLER2
XFILLER_126_197 VDD VSS DECAPHV8
XFILLER_5_494 VSS VDD FILLER2
XFILLER_114_359 VSS VDD FILLER2
X_15047_ _15054_/A _15054_/B _15054_/C VDD VSS _15837_/B OA21X2
X_19924_ _19924_/CK _19924_/D _19924_/Q VDD VSS DFFQX1
X_12259_ _12363_/A _12363_/B VDD VSS _12451_/C _12363_/C NAND3X1
XFILLER_96_700 VSS VDD FILLER2
XFILLER_79_91 VSS VDD FILLER2
XFILLER_141_189 VSS VDD FILLER2
X_19855_ _19880_/CK _19855_/D _19855_/Q VDD VSS DFFQX1
XFILLER_95_210 VDD VSS FILLER4
X_18806_ _19949_/CK _18806_/D _18806_/Q VDD VSS DFFQX1
X_19786_ _19791_/CK _19786_/D _19786_/Q VDD VSS DFFQX1
XFILLER_96_788 VSS VDD FILLER2
XFILLER_95_265 VSS VDD FILLER2
XFILLER_83_405 VDD VSS FILLER4
X_16998_ _17000_/B _16998_/B VDD VSS _16999_/B XOR2X1
XTAP_TAPCELL_ROW_66_603 VDD VSS WELLTAP
XFILLER_37_811 VSS VDD FILLER2
XFILLER_55_118 VDD VSS FILLER1
X_18737_ _18818_/CK _18737_/D _18737_/Q VDD VSS DFFQX1
XFILLER_95_90 VSS VDD FILLER2
XFILLER_49_693 VDD VSS FILLER1
XFILLER_37_833 VDD VSS FILLER4
X_15949_ _19611_/Q _16763_/B VDD VSS _15950_/B XNOR2X1
XFILLER_76_490 VDD VSS FILLER4
XFILLER_48_181 VDD VSS FILLER4
XFILLER_37_855 VSS VDD FILLER2
XFILLER_36_332 VDD VSS FILLER1
X_09470_ _19974_/Q _09490_/B _09476_/C VDD VSS _09471_/C AOI21X1
X_18668_ _18831_/CK _18668_/D _18668_/Q VDD VSS DFFQX1
XFILLER_64_685 VDD VSS FILLER4
XFILLER_91_482 VSS VDD FILLER2
X_17619_ _17620_/C _18127_/B _17619_/C VDD VSS _19884_/D AND3BX1
XTAP_TAPCELL_ROW_74_680 VDD VSS WELLTAP
XFILLER_63_184 VSS VDD FILLER2
X_18599_ _18612_/CK _18599_/D _18599_/Q VDD VSS DFFQX1
XFILLER_20_700 VSS VDD FILLER2
XTAP_TAPCELL_ROW_21_205 VDD VSS WELLTAP
XFILLER_149_245 VSS VDD FILLER2
Xclkload8 clkload8/A VDD VSS clkload8/Y INVX2
XFILLER_149_278 VDD VSS FILLER1
XFILLER_137_429 VDD VSS FILLER4
XFILLER_166_19 VSS VDD FILLER2
XFILLER_118_687 VSS VDD FILLER2
XFILLER_105_326 VDD VSS FILLER4
XFILLER_145_495 VSS VDD FILLER2
XFILLER_160_421 VDD VSS DECAPHV8
XFILLER_105_348 VDD VSS FILLER4
XFILLER_160_465 VDD VSS FILLER1
Xfanout201 _09284_/AB VDD VSS _20030_/RB BUFX3
Xfanout212 _20073_/RB VDD VSS _18471_/RB BUFX3
XFILLER_59_402 VSS VDD FILLER2
Xfanout223 _18503_/RB VDD VSS _20078_/RB BUFX3
XFILLER_101_510 VSS VDD FILLER2
XFILLER_87_733 VSS VDD FILLER2
XFILLER_115_34 VDD VSS FILLER1
X_09806_ _18423_/Q VDD VSS _20178_/A INVX1
XFILLER_87_777 VDD VSS DECAPHV8
XFILLER_59_468 VSS VDD FILLER2
XFILLER_59_479 VDD VSS FILLER1
XFILLER_101_576 VSS VDD FILLER2
XFILLER_75_27 VSS VDD FILLER2
XFILLER_46_107 VDD VSS FILLER1
XFILLER_74_427 VSS VDD FILLER2
X_09737_ _18338_/Q _09810_/B _09737_/C _09737_/D VDD VSS _09745_/B OA211X2
XFILLER_46_129 VDD VSS FILLER4
XFILLER_55_641 VDD VSS DECAPHV8
XFILLER_28_855 VSS VDD FILLER2
X_09668_ _18350_/Q VDD VSS _20218_/A INVX1
XFILLER_70_611 VSS VDD FILLER2
XFILLER_42_313 VDD VSS FILLER1
X_09599_ _09626_/B _18393_/Q _09599_/C _09753_/D VDD VSS _09600_/E OAOI211X1
XFILLER_152_4 VSS VDD FILLER2
XFILLER_70_655 VSS VDD FILLER2
X_11630_ _18772_/Q _11635_/B VDD VSS _18799_/D AND2X1
XFILLER_30_508 VSS VDD FILLER2
XFILLER_42_379 VSS VDD FILLER2
X_231_ _231_/CK _231_/E _231_/ECK VDD VSS CGX3
X_11561_ _18709_/Q _11567_/B VDD VSS _18736_/D AND2X1
XFILLER_128_407 VSS VDD FILLER2
XFILLER_50_390 VSS VDD FILLER2
X_13300_ _18997_/Q _13300_/B _13300_/C VDD VSS _13395_/C XNOR3X1
XFILLER_10_243 VSS VDD FILLER2
X_10512_ _10512_/A VDD VSS _11255_/A BUFX3
X_14280_ _14285_/A _14280_/B VDD VSS _19014_/D NOR2X1
XFILLER_149_790 VSS VDD FILLER2
X_11492_ _18647_/Q _11496_/B VDD VSS _18674_/D AND2X1
XFILLER_156_749 VSS VDD FILLER2
XFILLER_108_120 VDD VSS FILLER1
X_13231_ _13231_/A _14385_/B _13231_/C _13231_/D VDD VSS _13432_/A OAOI211X1
XFILLER_109_654 VDD VSS FILLER4
XFILLER_136_440 VDD VSS FILLER1
X_10443_ _10803_/A _10443_/B _10514_/B _10443_/D VDD VSS _10462_/A AOI31X1
XFILLER_108_142 VSS VDD FILLER2
XFILLER_136_451 VSS VDD FILLER2
XFILLER_6_258 VSS VDD FILLER2
XFILLER_124_602 VSS VDD FILLER2
XFILLER_136_473 VSS VDD FILLER2
XFILLER_151_410 VDD VSS FILLER1
X_13162_ _19079_/Q _14353_/B VDD VSS _13271_/B _14353_/C NAND3X1
XFILLER_164_793 VSS VDD FILLER2
X_10374_ _10399_/A _10399_/B _10399_/C _10927_/C VDD VSS _10375_/D AOI31X1
X_12113_ _12113_/A _12113_/B _12113_/C _12113_/D VDD VSS _14465_/C OA211X2
XFILLER_112_808 VDD VSS FILLER4
XFILLER_6_0 VDD VSS FILLER1
XFILLER_112_819 VSS VDD FILLER2
X_17970_ _17976_/A _17976_/B _17971_/C VDD VSS _17970_/Y NOR3X1
X_13093_ _19051_/Q _13271_/A _13098_/B VDD VSS _13095_/C XOR3X1
XFILLER_78_700 VSS VDD FILLER2
XFILLER_151_476 VDD VSS FILLER1
Xclkbuf_leaf_15__001_ clkload33/A VDD VSS _18889_/CK BUFX12
XFILLER_78_722 VSS VDD FILLER2
XFILLER_111_329 VDD VSS FILLER1
XFILLER_123_189 VDD VSS FILLER4
X_16921_ _19738_/Q _16922_/B _17081_/C VDD VSS _16922_/C OAI21X1
X_12044_ _19233_/Q _14527_/B VDD VSS _12053_/A NAND2X1
XFILLER_132_690 VSS VDD FILLER2
XFILLER_77_221 VSS VDD FILLER2
XFILLER_78_766 VSS VDD FILLER2
X_19640_ _19705_/CK _19640_/D _19640_/Q VDD VSS DFFQX1
X_16852_ _16865_/A _16852_/B VDD VSS _19691_/D NOR2X1
XFILLER_93_714 VSS VDD FILLER2
XFILLER_77_265 VDD VSS FILLER4
XFILLER_65_405 VSS VDD FILLER2
XFILLER_1_24 VDD VSS FILLER1
XFILLER_65_427 VDD VSS FILLER4
X_15803_ _15816_/A _15803_/B VDD VSS _19420_/D NOR2X1
X_16783_ _16794_/A _16783_/B VDD VSS _19629_/D NOR2X1
X_19571_ _19602_/CK _19571_/D _19571_/Q VDD VSS DFFQX1
XFILLER_93_747 VSS VDD FILLER2
XFILLER_18_310 VSS VDD FILLER2
X_13995_ _13995_/A _13995_/B _13995_/C _13995_/D VDD VSS _14085_/A AOAI211X1
XFILLER_92_235 VSS VDD FILLER2
XFILLER_18_321 VDD VSS FILLER4
XFILLER_58_490 VDD VSS FILLER4
X_15734_ _15743_/A _15734_/B VDD VSS _19359_/D AND2X1
X_18522_ _18522_/CK _18522_/D _18522_/Q _09310_/Y VDD VSS DFFRQX1
XFILLER_46_652 VSS VDD FILLER2
X_12946_ _13036_/A _13036_/B _13032_/C VDD VSS _14476_/B AOI21BX1
X_15665_ _15666_/A _15702_/B VDD VSS _15667_/B NAND2X1
X_18453_ _18455_/CK _18522_/Q _20151_/A _20054_/RB VDD VSS DFFRQX1
XFILLER_45_184 VSS VDD FILLER2
X_12877_ _12877_/A _12877_/B _14184_/B VDD VSS _12888_/C MIN3X1
X_17404_ _19839_/Q _19807_/Q VDD VSS _17405_/B XOR2X1
X_14616_ _14616_/A _14616_/B _15857_/B VDD VSS _14638_/B MIN3X1
X_18384_ _18391_/CK _18384_/D _18384_/Q _20065_/RB VDD VSS DFFRQX1
X_11828_ _11828_/A _11828_/B _11828_/C _11828_/D VDD VSS _11884_/B AOAI211X1
XTAP_TAPCELL_ROW_71_650 VDD VSS WELLTAP
X_15596_ _15620_/A _15620_/B VDD VSS _15607_/A NAND2X1
XFILLER_159_532 VSS VDD FILLER2
XFILLER_14_582 VSS VDD FILLER2
X_17335_ _17338_/A _17338_/B _17363_/C VDD VSS _17336_/C OAI21X1
X_14547_ _19988_/Q _14547_/B VDD VSS _19252_/D AND2X1
X_11759_ _19171_/Q VDD VSS _11761_/A INVX1
XTAP_TAPCELL_ROW_43_396 VDD VSS WELLTAP
X_17266_ _17267_/C _17266_/B _17266_/C VDD VSS _19809_/D AOI21X1
X_14478_ _14490_/A _14478_/B _14478_/C VDD VSS _19191_/D NOR3X1
Xclkload103 _18550_/CK VDD VSS clkload103/Y INVX4
X_16217_ _16228_/A _16217_/B VDD VSS _16848_/B XNOR2X1
X_19005_ _19059_/CK _19005_/D _19005_/Q VDD VSS DFFQX1
Xclkload114 _18257_/CK VDD VSS clkload114/Y INVX2
XFILLER_146_259 VDD VSS DECAPHV8
X_13429_ _19165_/Q _14449_/B _14449_/C VDD VSS _13430_/D OR3BX1
XFILLER_127_440 VSS VDD FILLER2
X_17197_ _17197_/A _17197_/B _17197_/C _17197_/D VDD VSS _17198_/C AOAI211X1
XFILLER_162_719 VSS VDD FILLER2
X_16148_ _16150_/B _16148_/B VDD VSS _16149_/B XOR2X1
XFILLER_142_421 VDD VSS DECAPHV8
XFILLER_154_292 VDD VSS DECAPHV8
X_16079_ _16076_/A _16079_/B _16079_/C VDD VSS _16099_/A AOI2B1X1
X_19907_ _19924_/CK _19907_/D _19907_/Q VDD VSS DFFQX1
XFILLER_39_0 VSS VDD FILLER2
X_19838_ _19895_/CK _19838_/D _19838_/Q VDD VSS DFFQX1
XFILLER_110_351 VDD VSS DECAPHV8
XFILLER_56_405 VSS VDD FILLER2
XFILLER_28_107 VSS VDD FILLER2
XFILLER_83_213 VSS VDD FILLER2
Xinput1 data_in VDD VSS input1/Y BUFX3
X_19769_ clkload4/A _19769_/D _19769_/Q VDD VSS DFFQX1
XFILLER_84_758 VSS VDD FILLER2
X_09522_ _20018_/Q _20017_/Q _20019_/Q _20020_/Q VDD VSS _09523_/C AOI31X1
XFILLER_45_19 VDD VSS FILLER1
XTAP_TAPCELL_ROW_10_99 VDD VSS WELLTAP
XFILLER_83_268 VSS VDD FILLER2
X_09453_ _18457_/D _09468_/B _09453_/C VDD VSS _18256_/D AOI21X1
XFILLER_52_666 VDD VSS FILLER4
XFILLER_40_817 VSS VDD FILLER2
X_09384_ input3/Y _20051_/Q VDD VSS _18010_/A NAND2X1
XFILLER_40_828 VSS VDD FILLER2
XFILLER_101_69 VDD VSS FILLER4
XFILLER_61_18 VDD VSS FILLER1
XFILLER_51_198 VSS VDD FILLER2
XFILLER_137_215 VSS VDD FILLER2
XFILLER_20_574 VSS VDD FILLER2
XFILLER_165_546 VSS VDD FILLER2
XTAP_TAPCELL_ROW_137_1248 VDD VSS WELLTAP
X_09979__250 _20052_/CK VDD VSS _18526_/CK INVX1
XFILLER_106_602 VSS VDD FILLER2
XFILLER_4_718 VSS VDD FILLER2
XFILLER_118_484 VSS VDD FILLER2
XFILLER_146_793 VSS VDD FILLER2
XFILLER_105_112 VSS VDD FILLER2
XFILLER_10_44 VSS VDD FILLER2
XFILLER_126_11 VSS VDD FILLER2
XFILLER_105_134 VSS VDD FILLER2
XFILLER_79_508 VDD VSS FILLER4
XFILLER_10_66 VSS VDD FILLER2
XFILLER_126_44 VSS VDD FILLER2
XFILLER_133_476 VDD VSS FILLER4
XFILLER_126_55 VSS VDD FILLER2
XFILLER_105_189 VSS VDD FILLER2
X_10090_ _18586_/Q _10113_/C VDD VSS _10090_/Y XNOR2X1
XFILLER_121_649 VSS VDD FILLER2
XTAP_TAPCELL_ROW_77_709 VDD VSS WELLTAP
XFILLER_87_552 VDD VSS FILLER4
XTAP_TAPCELL_ROW_148_1344 VDD VSS WELLTAP
XFILLER_75_747 VDD VSS FILLER4
XFILLER_142_43 VSS VDD FILLER2
XFILLER_74_235 VSS VDD FILLER2
X_12800_ _19020_/Q _14286_/B _14286_/C VDD VSS _12801_/D OR3BX1
XFILLER_90_706 VDD VSS FILLER1
X_13780_ _13781_/A _13781_/B _13781_/D _13781_/C VDD VSS _14329_/B AOAI211X1
XTAP_TAPCELL_ROW_85_775 VDD VSS WELLTAP
XFILLER_142_98 VSS VDD FILLER2
X_10992_ _11272_/A _10992_/B VDD VSS _18570_/D NOR2X1
XFILLER_43_611 VDD VSS FILLER4
XFILLER_28_696 VDD VSS FILLER1
X_12731_ _12731_/A _12731_/B _12731_/C _12731_/D VDD VSS _12915_/A OAOI211X1
XFILLER_70_430 VDD VSS FILLER1
X_15450_ _15448_/Y _15450_/B VDD VSS _15787_/B NOR2BX1
XFILLER_35_74 VSS VDD FILLER2
X_12662_ _12662_/A _12662_/B _12662_/C _12662_/D VDD VSS _14472_/B AOAI211X1
XFILLER_35_96 VDD VSS FILLER4
XTAP_TAPCELL_ROW_6_67 VDD VSS WELLTAP
XFILLER_143_0 VSS VDD FILLER2
X_14401_ _14426_/A _14401_/B VDD VSS _19122_/D NOR2X1
X_11613_ _11648_/A VDD VSS _11624_/B BUFX3
X_15381_ _15385_/B _15381_/B VDD VSS _18133_/B XNOR2X1
XTAP_TAPCELL_ROW_159_1440 VDD VSS WELLTAP
X_12593_ _12593_/A _12593_/B _14408_/B _12593_/D _12593_/E VDD VSS _12732_/C OAI221X1
XFILLER_156_502 VDD VSS DECAPHV8
X_17120_ _17121_/B _17120_/B VDD VSS _17122_/B NOR2BX1
XFILLER_129_738 VDD VSS FILLER4
X_14332_ _14339_/A _14332_/B VDD VSS _19060_/D NOR2X1
X_11544_ _11648_/A VDD VSS _11555_/B BUFX3
XFILLER_129_749 VDD VSS FILLER1
XTAP_TAPCELL_ROW_40_377 VDD VSS WELLTAP
XFILLER_156_546 VSS VDD FILLER2
X_17051_ _19764_/Q VDD VSS _17208_/B INVX1
X_14263_ _14255_/Y _14263_/B _14263_/C VDD VSS _19001_/D AND3BX1
XFILLER_7_556 VSS VDD FILLER2
X_11475_ _18631_/Q _11484_/B VDD VSS _18658_/D AND2X1
XFILLER_143_207 VDD VSS FILLER4
XFILLER_7_578 VDD VSS FILLER4
X_16002_ _19647_/Q _16804_/B VDD VSS _16003_/B XNOR2X1
X_13214_ _19080_/Q _14354_/B VDD VSS _14323_/A NAND2X1
X_10426_ _10550_/A _10738_/B _10738_/C _10538_/A VDD VSS _10503_/A OAOI211X1
XFILLER_124_421 VSS VDD FILLER2
X_14194_ _14218_/A _14194_/B VDD VSS _18944_/D NOR2X1
X_13145_ _13255_/A _13255_/B _13255_/C _13255_/D VDD VSS _13345_/A AOI31X1
X_10357_ _18553_/Q _10357_/B _10357_/C VDD VSS _10392_/A MIN3X1
XFILLER_3_751 VSS VDD FILLER2
X_17953_ _17957_/A _17953_/B VDD VSS _17955_/B XNOR2X1
X_13076_ _18910_/Q _13076_/B _13076_/C VDD VSS _14123_/B XNOR3X1
X_10288_ _18657_/Q _18765_/Q VDD VSS _10405_/A AND2X1
XFILLER_78_530 VSS VDD FILLER2
XFILLER_111_148 VSS VDD FILLER2
X_16904_ _20016_/Q _16908_/C _20015_/Q _20065_/Q VDD VSS _16909_/B OAI211X1
X_12027_ _12087_/A _12087_/B _12087_/C VDD VSS _12254_/A OA21X2
XFILLER_25_6 VDD VSS FILLER1
X_17884_ _17885_/C _17884_/B _17884_/C VDD VSS _19944_/D AOI21X1
XFILLER_78_574 VSS VDD FILLER2
XFILLER_66_736 VDD VSS FILLER1
XFILLER_38_427 VDD VSS FILLER4
X_19623_ _19661_/CK _19623_/D _19623_/Q VDD VSS DFFQX1
X_16835_ _16838_/A _16835_/B VDD VSS _19676_/D NOR2X1
XFILLER_76_81 VSS VDD FILLER2
XFILLER_65_235 VSS VDD FILLER2
XTAP_TAPCELL_ROW_48_444 VDD VSS WELLTAP
X_19554_ _19584_/CK _19554_/D _19554_/Q VDD VSS DFFQX1
X_16766_ _16775_/A _16766_/B VDD VSS _19614_/D NOR2X1
X_13978_ _13978_/A _17940_/B _13978_/C _13978_/D VDD VSS _14018_/A OAOI211X1
XTAP_TAPCELL_ROW_125_1141 VDD VSS WELLTAP
X_18505_ _18505_/CK _18505_/D _18505_/Q _09360_/Y VDD VSS DFFRQX1
XFILLER_34_622 VSS VDD FILLER2
X_15717_ _15725_/A _15717_/B VDD VSS _19343_/D AND2X1
X_12929_ _13017_/A _13017_/B _13017_/C VDD VSS _12975_/B OAI21X1
X_16697_ _19904_/Q VDD VSS _17712_/A INVX1
X_19485_ _19736_/CK _19485_/D _19485_/Q VDD VSS DFFQX1
XFILLER_18_195 VSS VDD FILLER2
XFILLER_34_655 VSS VDD FILLER2
X_18436_ _18437_/CK _18521_/Q _18436_/Q _20078_/RB VDD VSS DFFRQX1
X_15648_ _19329_/Q _15701_/B VDD VSS _15652_/B XNOR2X1
XFILLER_34_688 VSS VDD FILLER2
XFILLER_22_828 VSS VDD FILLER2
XFILLER_21_316 VSS VDD FILLER2
X_15579_ _19410_/Q _15791_/B VDD VSS _15597_/C NAND2X1
X_18367_ _18374_/CK _18367_/D _18367_/Q _18463_/RB VDD VSS DFFRQX1
XFILLER_159_351 VDD VSS FILLER4
XFILLER_119_215 VSS VDD FILLER2
X_17318_ _17318_/A _17318_/B _17318_/C _17318_/D VDD VSS _17319_/C AOAI211X1
XFILLER_147_535 VSS VDD FILLER2
X_18298_ _18311_/CK _18511_/Q _18298_/Q _18464_/RB VDD VSS DFFRQX1
XFILLER_147_557 VDD VSS FILLER1
X_17249_ _19806_/Q _19774_/Q VDD VSS _17250_/B XOR2X1
XFILLER_128_771 VSS VDD FILLER2
XFILLER_162_516 VDD VSS FILLER1
XFILLER_128_793 VDD VSS FILLER4
XFILLER_134_229 VSS VDD FILLER2
XFILLER_162_538 VSS VDD FILLER2
X_20191_ _20191_/A VDD VSS _20191_/Y BUFX3
XFILLER_103_616 VSS VDD FILLER2
XFILLER_142_262 VDD VSS FILLER4
XFILLER_102_104 VDD VSS FILLER4
XFILLER_102_115 VDD VSS DECAPHV8
XFILLER_103_649 VSS VDD FILLER2
XFILLER_102_137 VSS VDD FILLER2
XFILLER_130_468 VSS VDD FILLER2
XFILLER_69_552 VDD VSS FILLER4
XFILLER_57_703 VSS VDD FILLER2
XFILLER_69_574 VSS VDD FILLER2
XFILLER_29_416 VSS VDD FILLER2
XFILLER_56_18 VDD VSS DECAPHV8
XFILLER_57_747 VDD VSS DECAPHV8
XFILLER_29_438 VSS VDD FILLER2
XFILLER_56_235 VSS VDD FILLER2
XFILLER_56_257 VSS VDD FILLER2
XFILLER_72_717 VDD VSS FILLER4
XFILLER_56_279 VDD VSS FILLER4
X_09505_ _18501_/D _09507_/B _09506_/C _20079_/Q VDD VSS _20079_/D AO22X2
XFILLER_72_39 VDD VSS FILLER1
X_09436_ _09783_/B VDD VSS _09753_/D BUFX3
XTAP_TAPCELL_ROW_143_1296 VDD VSS WELLTAP
XFILLER_80_783 VDD VSS FILLER4
XFILLER_12_316 VSS VDD FILLER2
XFILLER_12_338 VSS VDD FILLER2
Xclkbuf_leaf_14__002_ clkbuf_leaf_9__002_/A VDD VSS _19940_/CK BUFX12
X_09367_ _18506_/Q _18505_/Q _09630_/C VDD VSS _09576_/B NOR3X1
XFILLER_138_524 VDD VSS FILLER4
XFILLER_166_833 VDD VSS FILLER1
X_09298_ _18422_/RB _09414_/D VDD VSS _09298_/Y NOR2BX1
XFILLER_20_360 VDD VSS FILLER4
XFILLER_138_546 VDD VSS FILLER1
XFILLER_165_343 VDD VSS FILLER4
XFILLER_119_760 VDD VSS FILLER1
XFILLER_115_4 VSS VDD FILLER2
XFILLER_125_218 VSS VDD FILLER2
XFILLER_153_549 VDD VSS DECAPHV8
X_11260_ _11262_/B _11261_/B VDD VSS _11261_/C NOR2X1
XFILLER_21_65 VSS VDD FILLER2
XFILLER_106_421 VDD VSS DECAPHV16
XFILLER_134_730 VSS VDD FILLER2
XFILLER_137_54 VDD VSS FILLER1
X_10211_ _18593_/Q VDD VSS _11384_/A INVX1
XFILLER_134_774 VSS VDD FILLER2
X_11191_ _11221_/A _11221_/B _11364_/B VDD VSS _11215_/A OAI21X1
Xdelaybuf_2_clk delaybuf_2_clk/A VDD VSS _18232_/CK BUFX12
XFILLER_79_316 VDD VSS FILLER4
XFILLER_0_710 VDD VSS FILLER1
X_10142_ _11367_/A _10142_/B VDD VSS _10190_/C XNOR2X1
XFILLER_121_435 VDD VSS FILLER1
XFILLER_0_754 VDD VSS FILLER4
XFILLER_121_468 VDD VSS FILLER4
XFILLER_153_42 VDD VSS FILLER1
X_14950_ _19310_/Q VDD VSS _14951_/A INVX1
X_10073_ _18606_/Q _10078_/B VDD VSS _10075_/C XOR2X1
XFILLER_75_511 VSS VDD FILLER2
XFILLER_0_798 VSS VDD FILLER2
X_13901_ _13912_/A _13912_/B _13912_/E _13901_/D VDD VSS _14300_/C OAOI211X1
X_14881_ _14881_/A _14881_/B _14881_/C _14881_/D VDD VSS _14966_/B AOAI211X1
XFILLER_48_758 VSS VDD FILLER2
XFILLER_75_555 VSS VDD FILLER2
XFILLER_47_246 VDD VSS FILLER4
XFILLER_63_706 VDD VSS FILLER4
X_16620_ _16620_/A _16620_/B _16620_/C _16620_/D VDD VSS _16645_/B AOAI211X1
X_13832_ _19031_/Q _13912_/A _13912_/B VDD VSS _13843_/C XNOR3X1
XFILLER_63_717 VSS VDD FILLER2
XFILLER_46_40 VDD VSS FILLER1
XFILLER_90_514 VDD VSS FILLER4
XFILLER_56_780 VDD VSS FILLER1
XTAP_TAPCELL_ROW_45_414 VDD VSS WELLTAP
X_16551_ _16551_/A _19923_/Q _16551_/C VDD VSS _16573_/B MIN3X1
XFILLER_28_482 VSS VDD FILLER2
X_13763_ _13918_/A _13918_/B _13918_/C VDD VSS _13809_/B AOI21X1
X_10975_ _19956_/Q _18838_/Q VDD VSS _11004_/B NAND2X1
XFILLER_55_290 VSS VDD FILLER2
X_15502_ _19323_/Q _15502_/B _15502_/C VDD VSS _15532_/A MIN3X1
X_12714_ _19047_/Q _12714_/B _12731_/C VDD VSS _12868_/B XOR3X1
XFILLER_15_143 VDD VSS FILLER1
X_16482_ _16495_/B _16482_/B VDD VSS _16823_/B XOR2X1
X_19270_ _20004_/CK _19270_/D _19270_/Q VDD VSS DFFQX1
XFILLER_43_463 VSS VDD FILLER2
X_13694_ _13830_/A _13830_/B _13830_/C VDD VSS _13760_/B AOI21X1
XFILLER_70_260 VSS VDD FILLER2
XFILLER_71_794 VDD VSS FILLER4
XFILLER_102_90 VDD VSS FILLER4
XFILLER_43_496 VSS VDD FILLER2
X_15433_ _15405_/A _15433_/B _15433_/C VDD VSS _15471_/B AOI2B1X1
X_18221_ _18221_/CK _18221_/E _18221_/ECK VDD VSS CGX3
XFILLER_30_113 VSS VDD FILLER2
X_12645_ _12732_/A _12732_/B _12732_/C _12732_/D VDD VSS _12819_/A AOI31X1
XTAP_TAPCELL_ROW_53_491 VDD VSS WELLTAP
XFILLER_31_669 VSS VDD FILLER2
XFILLER_129_513 VDD VSS FILLER1
X_15364_ _15364_/A _15364_/B _15364_/C _15364_/D VDD VSS _15365_/B OAI211X1
X_18152_ _18152_/A _18153_/C _18152_/C VDD VSS _20004_/D AOI21X1
XTAP_TAPCELL_ROW_120_1093 VDD VSS WELLTAP
X_12576_ _20005_/Q _19269_/Q VDD VSS _12673_/B XNOR2X1
XFILLER_156_332 VDD VSS FILLER1
XFILLER_8_843 VSS VDD FILLER2
X_17103_ _19774_/Q _19742_/Q _17103_/C VDD VSS _17107_/B AOI21X1
X_14315_ _14255_/Y _14315_/B _14315_/C VDD VSS _19046_/D AND3BX1
X_18083_ _18083_/A _18083_/B _18083_/C _18083_/D VDD VSS _19991_/D AOI31X1
X_11527_ _18679_/Q _11531_/B VDD VSS _18706_/D AND2X1
XFILLER_117_719 VSS VDD FILLER2
XFILLER_129_579 VDD VSS DECAPHV8
XFILLER_144_505 VDD VSS FILLER4
X_15295_ _19318_/Q _15689_/B VDD VSS _15296_/B XNOR2X1
XFILLER_116_218 VSS VDD FILLER2
XFILLER_144_527 VDD VSS FILLER4
X_17034_ _17040_/A _17036_/C _17034_/C VDD VSS _19760_/D AOI21X1
XFILLER_7_375 VSS VDD FILLER2
X_14246_ _14251_/A _14246_/B VDD VSS _18986_/D NOR2X1
X_11458_ _19951_/Q _11460_/B VDD VSS _18644_/D AND2X1
XFILLER_109_292 VSS VDD FILLER2
X_10409_ _10454_/A _10454_/B _10409_/C VDD VSS _10463_/C OAI21X1
XFILLER_140_700 VSS VDD FILLER2
X_14177_ _14197_/A _14177_/B VDD VSS _18929_/D AND2X1
X_11389_ _18595_/Q _11390_/B VDD VSS _11392_/D XNOR2X1
XFILLER_125_796 VDD VSS FILLER4
XFILLER_97_113 VDD VSS FILLER4
X_13128_ _13316_/A _13316_/B _13316_/D VDD VSS _13157_/B OAI21X1
XFILLER_124_295 VDD VSS FILLER1
X_18985_ _19044_/CK _18985_/D _18985_/Q VDD VSS DFFQX1
XFILLER_97_135 VSS VDD FILLER2
X_17936_ _18865_/Q _17937_/A VDD VSS _17948_/A _17937_/B NAND3X1
X_13059_ _13133_/A _13133_/B _13133_/C VDD VSS _13061_/C AO21X2
XFILLER_97_179 VSS VDD FILLER2
XFILLER_94_831 VDD VSS FILLER4
XFILLER_78_382 VSS VDD FILLER2
XFILLER_39_747 VSS VDD FILLER2
X_17867_ _18850_/Q VDD VSS _17869_/A INVX1
XFILLER_94_853 VDD VSS FILLER4
XFILLER_66_544 VSS VDD FILLER2
XFILLER_38_235 VDD VSS FILLER4
X_19606_ _19737_/CK _19606_/D _19606_/Q VDD VSS DFFQX1
X_16818_ _16843_/A _16818_/B VDD VSS _19660_/D AND2X1
XFILLER_93_363 VDD VSS DECAPHV8
XFILLER_53_205 VSS VDD FILLER2
X_17798_ _17806_/A _17798_/B VDD VSS _19923_/D NOR2X1
X_19537_ _19730_/CK _19537_/D _19537_/Q VDD VSS DFFQX1
X_16749_ _16776_/A VDD VSS _16759_/A BUFX3
X_19468_ _19508_/CK _19468_/D _19468_/Q VDD VSS DFFQX1
X_09221_ _18510_/Q VDD VSS _18393_/D INVX1
XTAP_TAPCELL_ROW_16_160 VDD VSS WELLTAP
XFILLER_61_282 VSS VDD FILLER2
X_18419_ _18422_/CK _18520_/Q _20174_/A _18422_/RB VDD VSS DFFRQX1
XFILLER_148_800 VDD VSS FILLER4
XFILLER_10_809 VSS VDD FILLER2
X_19399_ _19460_/CK _19399_/D _19399_/Q VDD VSS DFFQX1
XTAP_TAPCELL_ROW_134_1218 VDD VSS WELLTAP
XFILLER_107_229 VDD VSS DECAPHV8
XFILLER_162_324 VDD VSS FILLER1
XFILLER_162_335 VSS VDD FILLER2
XFILLER_116_730 VDD VSS FILLER4
XFILLER_128_590 VSS VDD FILLER2
XFILLER_116_741 VSS VDD FILLER2
XFILLER_162_357 VDD VSS DECAPHV8
XFILLER_131_722 VSS VDD FILLER2
XFILLER_89_636 VSS VDD FILLER2
XFILLER_103_424 VSS VDD FILLER2
X_20174_ _20174_/A VDD VSS _20174_/Y BUFX3
XFILLER_115_295 VDD VSS FILLER4
X_09985_ _18577_/Q _09999_/C VDD VSS _09986_/B NAND2X1
XFILLER_89_669 VSS VDD FILLER2
XFILLER_88_146 VDD VSS FILLER1
XFILLER_77_809 VDD VSS DECAPHV8
XFILLER_67_28 VDD VSS FILLER1
XFILLER_103_468 VSS VDD FILLER2
XFILLER_67_39 VSS VDD FILLER2
XFILLER_131_799 VDD VSS FILLER4
XFILLER_130_298 VDD VSS FILLER4
XFILLER_85_842 VDD VSS FILLER1
XFILLER_57_544 VDD VSS FILLER4
XFILLER_123_34 VDD VSS FILLER4
XTAP_TAPCELL_ROW_145_1314 VDD VSS WELLTAP
XFILLER_96_190 VSS VDD FILLER2
XTAP_TAPCELL_ROW_95_870 VDD VSS WELLTAP
XFILLER_72_514 VSS VDD FILLER2
XFILLER_72_536 VSS VDD FILLER2
XFILLER_44_249 VSS VDD FILLER2
XFILLER_16_21 VDD VSS FILLER4
X_10760_ _10801_/D _10801_/B VDD VSS _10761_/B NOR2BX1
XFILLER_80_591 VSS VDD FILLER2
XFILLER_13_647 VDD VSS FILLER4
X_09419_ _20014_/Q _09516_/B VDD VSS _09520_/D NOR2X1
XFILLER_158_619 VSS VDD FILLER2
X_10691_ _18694_/Q _18748_/Q VDD VSS _10729_/E AND2X1
XFILLER_13_669 VSS VDD FILLER2
XFILLER_40_455 VSS VDD FILLER2
XFILLER_157_118 VSS VDD FILLER2
XFILLER_12_168 VSS VDD FILLER2
X_12430_ _18904_/Q _14148_/B _12527_/C VDD VSS _12611_/C XNOR3X1
XFILLER_139_844 VDD VSS FILLER1
XTAP_TAPCELL_ROW_50_461 VDD VSS WELLTAP
XTAP_TAPCELL_ROW_156_1421 VDD VSS WELLTAP
XFILLER_32_53 VSS VDD FILLER2
X_12361_ _12361_/A _12361_/B _14311_/B VDD VSS _12510_/A MIN3X1
XFILLER_5_802 VDD VSS FILLER1
XFILLER_165_151 VDD VSS FILLER4
XFILLER_166_685 VDD VSS FILLER4
XFILLER_138_387 VDD VSS FILLER4
X_14100_ _18896_/Q _14139_/B VDD VSS _14101_/D _14139_/C NAND3X1
XFILLER_126_538 VDD VSS DECAPHV8
XFILLER_138_398 VSS VDD FILLER2
XFILLER_148_75 VDD VSS FILLER1
X_11312_ _11304_/A _11312_/B _11312_/C VDD VSS _11316_/B AOI2B1X1
XFILLER_165_173 VDD VSS FILLER1
XFILLER_153_324 VDD VSS FILLER4
X_15080_ _19313_/Q _15080_/B _15684_/B VDD VSS _15132_/B MIN3X1
XFILLER_5_835 VSS VDD FILLER2
XFILLER_165_184 VSS VDD FILLER2
X_12292_ _19070_/Q VDD VSS _12512_/A INVX1
XFILLER_4_323 VSS VDD FILLER2
XFILLER_153_346 VDD VSS FILLER4
XFILLER_106_0 VSS VDD FILLER2
X_14031_ _14085_/A _14085_/B _14085_/C VDD VSS _14049_/B AOI21X1
XFILLER_107_763 VDD VSS DECAPHV8
X_11243_ _11255_/A _11379_/B VDD VSS _11255_/C NOR2X1
XFILLER_106_251 VDD VSS DECAPHV8
XFILLER_122_700 VSS VDD FILLER2
XFILLER_4_367 VSS VDD FILLER2
XFILLER_4_389 VDD VSS FILLER4
XTAP_TAPCELL_ROW_111_1015 VDD VSS WELLTAP
XFILLER_121_221 VDD VSS FILLER4
X_11174_ _19962_/Q _18844_/Q VDD VSS _11175_/B XOR2X1
XFILLER_79_135 VDD VSS FILLER1
XFILLER_161_390 VDD VSS DECAPHV8
XFILLER_121_232 VSS VDD FILLER2
XFILLER_164_85 VDD VSS FILLER4
X_10125_ _18610_/Q VDD VSS _10126_/A INVX1
XFILLER_95_617 VSS VDD FILLER2
XFILLER_121_265 VSS VDD FILLER2
X_18770_ _18799_/CK _18770_/D _18770_/Q VDD VSS DFFQX1
XFILLER_67_319 VSS VDD FILLER2
X_15982_ _19675_/Q _16834_/B _16020_/A VDD VSS _16015_/A MIN3X1
XFILLER_95_639 VDD VSS FILLER4
XFILLER_0_573 VSS VDD FILLER2
X_17721_ _19906_/Q _19874_/Q _17721_/C VDD VSS _17726_/C AO21X2
XFILLER_94_138 VDD VSS FILLER1
X_14933_ _19478_/Q _15869_/B VDD VSS _15000_/B XNOR2X1
X_10056_ _10043_/Y _10055_/Y _10127_/A VDD VSS _10056_/Y MUX2X1
XFILLER_48_544 VDD VSS DECAPHV8
XFILLER_48_566 VDD VSS FILLER4
XFILLER_36_706 VDD VSS FILLER1
X_17652_ _19892_/Q _19860_/Q VDD VSS _17655_/A XNOR2X1
XFILLER_48_588 VDD VSS FILLER1
X_14864_ _14865_/A _14865_/B _14865_/D _14865_/C VDD VSS _14907_/B OAOI211X1
XFILLER_91_834 VSS VDD FILLER2
X_16603_ _16603_/A _16626_/C VDD VSS _16757_/B XNOR2X1
XFILLER_91_856 VDD VSS FILLER1
X_13815_ _18974_/Q _14229_/B _14229_/C VDD VSS _13816_/D OR3BX1
X_14795_ _14795_/A _14840_/D VDD VSS _15802_/B XNOR2X1
X_17583_ _19877_/Q _19845_/Q VDD VSS _17589_/B NAND2X1
XTAP_TAPCELL_ROW_122_1111 VDD VSS WELLTAP
XFILLER_51_709 VSS VDD FILLER2
X_19322_ _19333_/CK _19322_/D _19322_/Q VDD VSS DFFQX1
XFILLER_50_208 VSS VDD FILLER2
X_16534_ _16545_/B _16534_/B VDD VSS _16861_/B XNOR2X1
X_13746_ _18917_/Q _13748_/B _13746_/C VDD VSS _13751_/B XNOR3X1
X_10958_ _10958_/A _10958_/B VDD VSS _10996_/A NOR2X1
XFILLER_149_608 VSS VDD FILLER2
XFILLER_43_282 VSS VDD FILLER2
X_19253_ _19988_/CK _19253_/D _19253_/Q VDD VSS DFFQX1
X_16465_ _16467_/B _16465_/B _16465_/C VDD VSS _19536_/D AOI21X1
X_13677_ _13748_/A _13748_/B _13748_/C _13748_/D VDD VSS _13818_/A AOI31X1
XFILLER_31_444 VSS VDD FILLER2
X_10889_ _10921_/A _10921_/B _11127_/A VDD VSS _10915_/A OAI21X1
XFILLER_148_129 VDD VSS FILLER1
XTAP_TAPCELL_ROW_13_130 VDD VSS WELLTAP
X_15416_ _15456_/C _15456_/B VDD VSS _15417_/B NOR2BX1
X_12628_ _12719_/A _12729_/A _12804_/B VDD VSS _12630_/C XNOR3X1
XFILLER_31_477 VSS VDD FILLER2
X_16396_ _16421_/A _16421_/B VDD VSS _16748_/B XNOR2X1
X_19184_ _19185_/CK _19184_/D _19184_/Q VDD VSS DFFQX1
X_15347_ _15347_/A _15347_/B _15347_/C _15347_/D VDD VSS _15348_/C AOAI211X1
X_18135_ _18136_/A _18136_/B _18136_/C VDD VSS _18135_/Y NOR3X1
XFILLER_157_663 VSS VDD FILLER2
X_12559_ _19102_/Q VDD VSS _12640_/A INVX1
XFILLER_145_836 VDD VSS FILLER1
XFILLER_156_184 VSS VDD FILLER2
X_15278_ _15307_/C _15307_/D VDD VSS _15308_/B AND2X1
X_18066_ _18069_/A _18069_/B _18187_/C VDD VSS _18067_/C OAI21X1
XFILLER_144_346 VDD VSS DECAPHV8
X_17017_ _19756_/Q _19757_/Q _17047_/B VDD VSS _17018_/B OAI21X1
X_14229_ _14294_/A _14229_/B _14229_/C VDD VSS _18974_/D NOR3X1
XFILLER_98_400 VDD VSS FILLER4
XFILLER_160_839 VDD VSS FILLER1
XFILLER_112_221 VSS VDD FILLER2
XFILLER_140_541 VDD VSS DECAPHV8
XFILLER_113_766 VSS VDD FILLER2
X_09770_ _18272_/Q _09770_/B _09770_/C _18324_/Q VDD VSS _09772_/C AOI22X1
XFILLER_113_799 VSS VDD FILLER2
X_18968_ _18997_/CK _18968_/D _18968_/Q VDD VSS DFFQX1
XFILLER_85_105 VSS VDD FILLER2
XFILLER_39_500 VSS VDD FILLER2
XFILLER_98_499 VDD VSS FILLER4
XFILLER_21_0 VDD VSS FILLER1
XFILLER_39_522 VSS VDD FILLER2
X_17919_ _18861_/Q _17919_/B _17919_/C VDD VSS _17927_/A MIN3X1
X_18899_ _19988_/CK _18899_/D _18899_/Q VDD VSS DFFQX1
XFILLER_78_190 VSS VDD FILLER2
XFILLER_54_514 VSS VDD FILLER2
XFILLER_39_588 VSS VDD FILLER2
XFILLER_82_856 VDD VSS FILLER1
XTAP_TAPCELL_ROW_92_840 VDD VSS WELLTAP
XTAP_TAPCELL_ROW_64_586 VDD VSS WELLTAP
XTAP_TAPCELL_ROW_104_952 VDD VSS WELLTAP
XFILLER_50_731 VSS VDD FILLER2
XTAP_TAPCELL_ROW_140_1277 VDD VSS WELLTAP
X_09204_ _18494_/D VDD VSS _18430_/D INVX1
XFILLER_22_477 VDD VSS FILLER4
XFILLER_22_499 VDD VSS FILLER1
XFILLER_148_663 VSS VDD FILLER2
XFILLER_135_335 VSS VDD FILLER2
XFILLER_163_644 VDD VSS FILLER4
XFILLER_135_379 VDD VSS FILLER1
XFILLER_151_828 VSS VDD FILLER2
XFILLER_104_700 VSS VDD FILLER2
XFILLER_78_16 VSS VDD FILLER2
XFILLER_104_711 VSS VDD FILLER2
XFILLER_118_78 VSS VDD FILLER2
XFILLER_78_38 VSS VDD FILLER2
XFILLER_150_338 VSS VDD FILLER2
XTAP_TAPCELL_ROW_151_1373 VDD VSS WELLTAP
XFILLER_78_49 VSS VDD FILLER2
X_20226_ _20226_/A VDD VSS _20226_/Y BUFX3
XFILLER_131_530 VSS VDD FILLER2
XFILLER_89_444 VSS VDD FILLER2
XFILLER_1_337 VSS VDD FILLER2
XFILLER_104_788 VSS VDD FILLER2
X_20157_ _20157_/A VDD VSS _20157_/Y BUFX3
XFILLER_134_44 VSS VDD FILLER2
XFILLER_76_138 VDD VSS FILLER1
XFILLER_134_77 VSS VDD FILLER2
X_20088_ _20088_/A VDD VSS _20088_/Y BUFX3
X_09899_ _09897_/Y _09898_/Y _09928_/C VDD VSS _09899_/Y MUXI2X1
XFILLER_92_609 VDD VSS FILLER1
XFILLER_18_706 VSS VDD FILLER2
XFILLER_85_661 VSS VDD FILLER2
XFILLER_73_801 VSS VDD FILLER2
X_11930_ _19997_/Q _19261_/Q VDD VSS _11988_/A XOR2X1
XFILLER_73_834 VSS VDD FILLER2
XFILLER_27_64 VSS VDD FILLER2
X_11861_ _19063_/Q _11861_/B _11861_/C VDD VSS _11959_/B MIN3X1
XFILLER_84_193 VDD VSS FILLER4
XFILLER_27_75 VDD VSS FILLER1
XFILLER_33_709 VSS VDD FILLER2
X_13600_ _19027_/Q _14294_/B _14294_/C VDD VSS _13607_/D OR3BX1
XFILLER_72_366 VSS VDD FILLER2
X_10812_ _18565_/Q _10849_/B VDD VSS _10814_/C XOR2X1
XTAP_TAPCELL_ROW_27_255 VDD VSS WELLTAP
XFILLER_72_377 VDD VSS FILLER1
X_14580_ _19493_/Q _15886_/B VDD VSS _14584_/C NOR2X1
X_11792_ _19200_/Q _11797_/A _14488_/B VDD VSS _14458_/B XNOR3X1
XFILLER_13_422 VDD VSS FILLER4
XFILLER_53_591 VSS VDD FILLER2
XFILLER_25_282 VDD VSS FILLER4
X_13531_ _13531_/A _13531_/B _13531_/C _13531_/D VDD VSS _14326_/C OAI211X1
X_10743_ _18563_/Q _10743_/B _10743_/C VDD VSS _10784_/A MIN3X1
XFILLER_40_230 VSS VDD FILLER2
X_16250_ _16247_/B _16250_/B _16250_/C VDD VSS _16274_/A AOI2B1X1
X_13462_ _13462_/A _13462_/B _14545_/B VDD VSS _14516_/B MIN3X1
X_10674_ _18667_/Q _18775_/Q VDD VSS _10718_/C AND2X1
XFILLER_43_96 VSS VDD FILLER2
XFILLER_41_797 VSS VDD FILLER2
X_15201_ _15227_/B _15201_/B VDD VSS _15812_/B NOR2BX1
XTAP_TAPCELL_ROW_10_100 VDD VSS WELLTAP
X_12413_ _19240_/Q _12413_/B _12495_/D VDD VSS _12497_/C XNOR3X1
X_16181_ _16181_/A _16739_/B VDD VSS _16182_/C AND2X1
XTAP_TAPCELL_ROW_110_999 VDD VSS WELLTAP
XFILLER_159_96 VSS VDD FILLER2
X_13393_ _13393_/A _13393_/B _13393_/C _13393_/D VDD VSS _13656_/A OAOI211X2
XFILLER_154_600 VDD VSS FILLER4
XFILLER_126_313 VDD VSS FILLER4
XFILLER_139_696 VDD VSS FILLER1
X_15132_ _15132_/A _15132_/B _15685_/B VDD VSS _15171_/B MIN3X1
XFILLER_138_184 VDD VSS FILLER4
X_12344_ _12610_/A _12610_/B _14115_/B VDD VSS _17847_/B XNOR3X1
XFILLER_153_132 VSS VDD FILLER2
XFILLER_5_643 VSS VDD FILLER2
XFILLER_5_654 VSS VDD FILLER2
X_15063_ _15108_/D _15145_/C VDD VSS _15099_/C NAND2X1
X_19940_ _19940_/CK _19940_/D _19940_/Q VDD VSS DFFQX1
XFILLER_4_142 VSS VDD FILLER2
X_12275_ _18902_/Q _12348_/B _12348_/C VDD VSS _12429_/B MIN3X1
XFILLER_4_164 VSS VDD FILLER2
X_14014_ _18979_/Q _14043_/A _14043_/B VDD VSS _14032_/C XOR3X1
XFILLER_107_593 VSS VDD FILLER2
X_11226_ _11226_/A _11226_/B _11226_/C _11226_/D VDD VSS _11230_/A OAI22X1
X_19871_ _19924_/CK _19871_/D _19871_/Q VDD VSS DFFQX1
X_18822_ _18823_/CK _18822_/D _18822_/Q VDD VSS DFFQX1
X_11157_ _11272_/A _11157_/B VDD VSS _18575_/D NOR2X1
XFILLER_95_425 VDD VSS FILLER4
X_10108_ _10131_/A _10191_/B _10109_/C _18609_/Q VDD VSS _10120_/B AO211X2
XFILLER_95_447 VSS VDD FILLER2
XFILLER_67_138 VSS VDD FILLER2
X_18753_ _19940_/CK _18753_/D _18753_/Q VDD VSS DFFQX1
XFILLER_0_392 VDD VSS FILLER1
X_15965_ _15965_/A _15995_/B VDD VSS _16731_/B XOR2X1
X_11088_ _11084_/B _18573_/Q _11088_/C VDD VSS _11126_/B AOI2B1X1
X_17704_ _19903_/Q _19871_/Q VDD VSS _17705_/B XOR2X1
XFILLER_82_108 VDD VSS FILLER4
XFILLER_36_503 VDD VSS FILLER1
X_14916_ _19449_/Q _15834_/B VDD VSS _14931_/C _15834_/C AND3X2
X_10039_ _10180_/A _11409_/C VDD VSS _18531_/D NOR2X1
XFILLER_48_363 VSS VDD FILLER2
X_18684_ _18767_/CK _18684_/D _18684_/Q VDD VSS DFFQX1
XFILLER_36_514 VDD VSS DECAPHV8
X_15896_ _16776_/A VDD VSS _15906_/A BUFX3
XFILLER_64_834 VSS VDD FILLER2
X_17635_ _17638_/A _17638_/B _17654_/C VDD VSS _17636_/C OAI21X1
X_14847_ _14857_/B _14847_/B VDD VSS _15709_/B XNOR2X1
XFILLER_84_81 VSS VDD FILLER2
XFILLER_91_675 VSS VDD FILLER2
XFILLER_17_761 VSS VDD FILLER2
XFILLER_23_208 VSS VDD FILLER2
X_17566_ _17566_/A VDD VSS _18132_/A BUFX3
X_14778_ _14778_/A _15831_/B _15831_/C VDD VSS _14818_/C NOR3X1
X_19305_ _19306_/CK _19305_/D _19305_/Q VDD VSS DFFQX1
XFILLER_16_282 VSS VDD FILLER2
X_16517_ _16509_/A _16517_/B VDD VSS _16537_/B NAND2BX1
X_13729_ _19056_/Q VDD VSS _13731_/A INVX1
XTAP_TAPCELL_ROW_101_922 VDD VSS WELLTAP
XFILLER_149_416 VSS VDD FILLER2
X_17497_ _17498_/C _18127_/B _17497_/C VDD VSS _19858_/D AND3BX1
XFILLER_31_252 VDD VSS FILLER4
X_19236_ _20004_/CK _19236_/D _19236_/Q VDD VSS DFFQX1
X_16448_ _19568_/Q _19920_/Q VDD VSS _16451_/A XNOR2X1
X_19167_ _19223_/CK _19167_/D _19167_/Q VDD VSS DFFQX1
XFILLER_145_611 VDD VSS FILLER4
X_16379_ _16379_/A _16390_/C VDD VSS _16854_/B XNOR2X1
XFILLER_117_324 VSS VDD FILLER2
X_18118_ _19289_/Q _18118_/B VDD VSS _18121_/A NOR2BX1
XFILLER_69_0 VSS VDD FILLER2
X_19098_ _19126_/CK _19098_/D _19098_/Q VDD VSS DFFQX1
XFILLER_144_132 VSS VDD FILLER2
XFILLER_145_677 VSS VDD FILLER2
X_18049_ _18052_/B _18049_/B _18049_/C _18049_/D VDD VSS _19982_/D OAI31X1
XFILLER_160_625 VSS VDD FILLER2
XFILLER_160_647 VSS VDD FILLER2
XFILLER_99_742 VSS VDD FILLER2
X_20011_ _20013_/CK _20011_/D _20011_/Q VDD VSS DFFQX1
X_09822_ _11435_/A _11435_/B _11196_/A VDD VSS _10266_/C NOR3X1
XFILLER_101_747 VSS VDD FILLER2
XFILLER_140_393 VSS VDD FILLER2
XTAP_TAPCELL_ROW_69_634 VDD VSS WELLTAP
XFILLER_86_447 VDD VSS DECAPHV16
XFILLER_100_235 VSS VDD FILLER2
Xclkbuf_0__09176_ _18225_/ECK VDD VSS clkbuf_0__09176_/Y BUFX12
X_09753_ _09753_/A _18403_/Q _09753_/C _09753_/D VDD VSS _09754_/E OAOI211X1
XFILLER_67_650 VDD VSS FILLER1
XFILLER_100_268 VSS VDD FILLER2
X_09684_ _18351_/Q VDD VSS _20219_/A INVX1
XFILLER_27_514 VDD VSS FILLER4
XFILLER_104_58 VDD VSS FILLER4
XFILLER_104_69 VDD VSS FILLER1
XFILLER_94_491 VSS VDD FILLER2
XFILLER_55_856 VDD VSS FILLER1
XFILLER_54_344 VDD VSS FILLER4
XFILLER_70_815 VDD VSS FILLER4
XFILLER_81_152 VSS VDD FILLER2
XFILLER_42_528 VSS VDD FILLER2
XFILLER_54_399 VDD VSS DECAPHV8
XFILLER_81_185 VDD VSS FILLER1
XTAP_TAPCELL_ROW_24_225 VDD VSS WELLTAP
XFILLER_22_230 VSS VDD FILLER2
XFILLER_120_79 VSS VDD FILLER2
XFILLER_22_274 VSS VDD FILLER2
XFILLER_22_296 VSS VDD FILLER2
XFILLER_155_408 VSS VDD FILLER2
XFILLER_129_33 VSS VDD FILLER2
XFILLER_148_460 VSS VDD FILLER2
XFILLER_136_633 VSS VDD FILLER2
X_10390_ _18554_/Q _10390_/B VDD VSS _10392_/B XOR2X1
XFILLER_89_26 VSS VDD FILLER2
XFILLER_136_655 VSS VDD FILLER2
XFILLER_124_806 VDD VSS FILLER1
XFILLER_135_143 VSS VDD FILLER2
XFILLER_108_368 VSS VDD FILLER2
XFILLER_124_817 VSS VDD FILLER2
XFILLER_136_688 VSS VDD FILLER2
XFILLER_2_602 VSS VDD FILLER2
XTAP_TAPCELL_ROW_0_14 VDD VSS WELLTAP
X_12060_ _19151_/Q _12060_/B _12091_/C VDD VSS _12181_/B XNOR3X1
XFILLER_104_530 VSS VDD FILLER2
XFILLER_150_135 VDD VSS FILLER4
XFILLER_104_541 VDD VSS FILLER1
XFILLER_104_563 VSS VDD FILLER2
X_11011_ _11037_/A _11037_/B _11011_/C _11011_/D VDD VSS _11013_/C OAOI211X1
X_20209_ _20209_/A VDD VSS _20209_/Y BUFX3
XFILLER_104_585 VSS VDD FILLER2
XFILLER_104_596 VDD VSS FILLER1
XFILLER_1_189 VSS VDD FILLER2
XFILLER_77_458 VDD VSS FILLER4
XFILLER_161_31 VSS VDD FILLER2
XFILLER_18_503 VDD VSS DECAPHV8
X_15750_ _15770_/A _15750_/B VDD VSS _19373_/D AND2X1
X_12962_ _19245_/Q VDD VSS _12968_/D INVX1
XFILLER_18_514 VSS VDD FILLER2
X_14701_ _14701_/A _14701_/B _15828_/B VDD VSS _14702_/B MIN3X1
X_11913_ _11973_/A _11973_/B _11973_/C VDD VSS _11969_/A OAI21X1
X_15681_ _15693_/A _15681_/B VDD VSS _19310_/D NOR2X1
X_12893_ _14284_/B _14284_/C _19018_/Q VDD VSS _12896_/A AOI21X1
XFILLER_73_675 VDD VSS FILLER1
X_17420_ _17419_/B _17420_/B VDD VSS _17422_/C NOR2BX1
X_14632_ _19414_/Q _14635_/B _15796_/B VDD VSS _15764_/B XNOR3X1
X_11844_ wire166/Y _11881_/B _11881_/C VDD VSS _11845_/C AOI21X1
XFILLER_45_388 VSS VDD FILLER2
XFILLER_72_185 VSS VDD FILLER2
XFILLER_60_347 VSS VDD FILLER2
X_17351_ _17353_/C _17351_/B _17351_/C VDD VSS _19827_/D AOI21X1
X_14563_ _20002_/Q _14569_/B VDD VSS _19266_/D AND2X1
X_11775_ _19228_/Q _14521_/B VDD VSS _11776_/D _14521_/C NAND3X1
Xclkbuf_1_0__f__09165_ clkbuf_0__09165_/Y VDD VSS _18439_/CK BUFX12
XFILLER_41_561 VDD VSS FILLER4
XFILLER_159_736 VSS VDD FILLER2
X_16302_ _16302_/A _16302_/B _16302_/C VDD VSS _16305_/B OAI21X1
XFILLER_159_747 VSS VDD FILLER2
XFILLER_158_224 VDD VSS DECAPHV8
X_13514_ _13594_/A _13594_/B _13594_/D _13594_/C VDD VSS _14225_/C AOI211X1
X_10726_ _10757_/C _10726_/B _10749_/B _10726_/D VDD VSS _10747_/B AOI2B2X1
X_17282_ _19813_/Q _19781_/Q VDD VSS _17289_/C NOR2X1
X_14494_ _14491_/Y _14494_/B _14494_/C VDD VSS _19205_/D AND3BX1
XFILLER_9_223 VSS VDD FILLER2
XFILLER_158_235 VDD VSS FILLER4
XFILLER_9_245 VSS VDD FILLER2
X_19021_ _19037_/CK _19021_/D _19021_/Q VDD VSS DFFQX1
X_16233_ _16233_/A _16233_/B _16233_/C VDD VSS _16256_/B AOI21X1
X_13445_ _19249_/Q _14544_/A _14544_/B VDD VSS _13447_/C NOR3X1
XFILLER_9_256 VSS VDD FILLER2
X_10657_ _11255_/A _10734_/B _10657_/C VDD VSS _10658_/B OAI21X1
XFILLER_70_61 VDD VSS FILLER1
XFILLER_127_611 VDD VSS FILLER1
Xclkload15 _19934_/CK VDD VSS clkload15/Y INVX2
Xclkload26 _18795_/CK VDD VSS clkload26/Y INVX1
X_16164_ _19621_/Q _16774_/B VDD VSS _16165_/B XNOR2X1
Xclkload37 _19223_/CK VDD VSS clkload37/Y INVX2
X_13376_ _18970_/Q _13511_/A _13401_/C VDD VSS _13391_/D XNOR3X1
X_10588_ _18559_/Q _10589_/B VDD VSS _10594_/A AND2X1
Xclkload48 _19044_/CK VDD VSS clkload48/Y BUFX12
XFILLER_154_452 VSS VDD FILLER2
XFILLER_127_677 VSS VDD FILLER2
XFILLER_142_603 VDD VSS FILLER1
Xclkload59 _19171_/CK VDD VSS clkload59/Y INVX4
X_15115_ _15139_/D _15139_/C VDD VSS _15116_/B NOR2BX1
X_12327_ _19210_/Q VDD VSS _12329_/D INVX1
XTAP_TAPCELL_ROW_117_1065 VDD VSS WELLTAP
XFILLER_142_614 VSS VDD FILLER2
X_16095_ _16106_/A _16106_/B VDD VSS _16842_/B XNOR2X1
XFILLER_141_102 VDD VSS DECAPHV16
XFILLER_142_647 VSS VDD FILLER2
X_15046_ _19425_/Q VDD VSS _15089_/A INVX1
X_19923_ _19924_/CK _19923_/D _19923_/Q VDD VSS DFFQX1
X_12258_ _19098_/Q _12258_/B _12258_/C VDD VSS _12363_/C XNOR3X1
XFILLER_130_809 VSS VDD FILLER2
XFILLER_141_146 VSS VDD FILLER2
X_11209_ _11209_/A _11229_/E VDD VSS _11209_/Y _11209_/C NAND3X1
X_19854_ _19880_/CK _19854_/D _19854_/Q VDD VSS DFFQX1
X_12189_ _12189_/A _12189_/B _14308_/B VDD VSS _12203_/C MIN3X1
XFILLER_95_200 VDD VSS FILLER4
XFILLER_68_425 VDD VSS FILLER1
XFILLER_68_436 VDD VSS DECAPHV16
X_18805_ _19949_/CK _18805_/D _18805_/Q VDD VSS DFFQX1
XFILLER_1_690 VSS VDD FILLER2
X_19785_ _19785_/CK _19785_/D _19785_/Q VDD VSS DFFQX1
XFILLER_96_778 VDD VSS FILLER4
X_16997_ _19754_/Q _17011_/B VDD VSS _16998_/B XOR2X1
XFILLER_95_255 VDD VSS FILLER4
XTAP_TAPCELL_ROW_66_604 VDD VSS WELLTAP
XFILLER_95_277 VSS VDD FILLER2
X_18736_ _18818_/CK _18736_/D _18736_/Q VDD VSS DFFQX1
XFILLER_83_428 VDD VSS FILLER1
X_15948_ _15948_/A _15948_/B VDD VSS _16801_/B XNOR2X1
XTAP_TAPCELL_ROW_128_1161 VDD VSS WELLTAP
X_18667_ _19946_/CK _18667_/D _18667_/Q VDD VSS DFFQX1
X_15879_ _15879_/A _15879_/B VDD VSS _19487_/D AND2X1
XFILLER_52_804 VSS VDD FILLER2
XFILLER_36_366 VDD VSS FILLER4
XFILLER_91_461 VDD VSS FILLER4
X_17618_ _17618_/A _17618_/B _17618_/C _17618_/D VDD VSS _17619_/C AOAI211X1
XFILLER_91_472 VDD VSS FILLER1
X_18598_ _18612_/CK _18598_/D _18598_/Q VDD VSS DFFQX1
XTAP_TAPCELL_ROW_74_681 VDD VSS WELLTAP
X_17549_ _17551_/B _17549_/B VDD VSS _17550_/B XOR2X1
XFILLER_51_369 VSS VDD FILLER2
XFILLER_149_224 VSS VDD FILLER2
XTAP_TAPCELL_ROW_21_206 VDD VSS WELLTAP
XFILLER_20_734 VSS VDD FILLER2
XFILLER_149_268 VSS VDD FILLER2
Xclkload9 clkload9/A VDD VSS clkload9/Y INVX1
X_19219_ _19250_/CK _19219_/D _19219_/Q VDD VSS DFFQX1
XFILLER_20_789 VDD VSS FILLER1
XFILLER_117_132 VDD VSS FILLER4
XFILLER_145_441 VDD VSS FILLER1
XFILLER_145_463 VSS VDD FILLER2
XFILLER_133_625 VSS VDD FILLER2
XFILLER_145_485 VSS VDD FILLER2
XFILLER_160_433 VDD VSS FILLER4
XFILLER_132_146 VDD VSS FILLER1
XFILLER_114_850 VSS VDD FILLER2
XFILLER_99_550 VSS VDD FILLER2
XFILLER_87_701 VDD VSS FILLER1
Xfanout202 _09284_/AB VDD VSS _20071_/RB BUFX3
XFILLER_99_561 VSS VDD FILLER2
Xfanout213 _20073_/RB VDD VSS _18463_/RB BUFX3
Xfanout224 _18503_/RB VDD VSS _18498_/RB BUFX3
XFILLER_160_499 VSS VDD FILLER2
XFILLER_113_371 VDD VSS FILLER1
XFILLER_113_393 VSS VDD FILLER2
XFILLER_101_544 VDD VSS FILLER4
X_09805_ _09819_/A _09805_/B _09805_/C VDD VSS _18294_/D OAI21X1
XFILLER_87_789 VSS VDD FILLER2
XFILLER_74_406 VSS VDD FILLER2
XFILLER_74_417 VDD VSS FILLER1
XFILLER_101_588 VDD VSS FILLER1
XFILLER_86_277 VSS VDD FILLER2
XFILLER_28_812 VSS VDD FILLER2
X_09736_ _18466_/Q _09784_/B _09784_/C _18434_/Q VDD VSS _09737_/D AOI22X1
XFILLER_39_160 VDD VSS FILLER4
XFILLER_55_620 VDD VSS FILLER1
XFILLER_28_845 VDD VSS FILLER4
XFILLER_39_193 VSS VDD FILLER2
X_09667_ _18478_/Q VDD VSS _20123_/A INVX1
XTAP_TAPCELL_ROW_37_350 VDD VSS WELLTAP
XFILLER_55_686 VSS VDD FILLER2
XFILLER_15_517 VSS VDD FILLER2
X_09598_ _09626_/B _20182_/A VDD VSS _09599_/C NAND2X1
XFILLER_42_336 VSS VDD FILLER2
XFILLER_145_4 VSS VDD FILLER2
X_230_ _231_/CK _230_/E _230_/ECK VDD VSS CGX3
XFILLER_23_561 VDD VSS FILLER4
XFILLER_11_712 VSS VDD FILLER2
X_11560_ _18708_/Q _11567_/B VDD VSS _18735_/D AND2X1
XFILLER_11_734 VDD VSS FILLER4
XFILLER_50_380 VDD VSS FILLER4
XFILLER_11_756 VSS VDD FILLER2
X_10511_ _10511_/A VDD VSS _10843_/A BUFX3
XFILLER_109_600 VSS VDD FILLER2
X_11491_ _18646_/Q _11496_/B VDD VSS _18673_/D AND2X1
XFILLER_149_780 VSS VDD FILLER2
X_13230_ _13230_/A _14416_/B _14416_/C VDD VSS _13231_/D NOR3X1
X_10442_ _10965_/A _18716_/Q VDD VSS _10443_/D AND2X1
XFILLER_164_761 VDD VSS FILLER4
XFILLER_124_614 VDD VSS FILLER4
X_13161_ _13161_/A _13161_/B VDD VSS _14353_/C _13161_/C NAND3X1
X_10373_ _18633_/Q _18795_/Q VDD VSS _10399_/C XNOR2X1
XFILLER_163_260 VSS VDD FILLER2
XFILLER_124_625 VDD VSS FILLER4
XFILLER_123_113 VDD VSS FILLER1
XFILLER_163_282 VSS VDD FILLER2
XFILLER_108_198 VSS VDD FILLER2
X_12112_ _19180_/Q _12112_/B _12160_/C VDD VSS _12214_/A XNOR3X1
XFILLER_2_421 VSS VDD FILLER2
XFILLER_156_86 VSS VDD FILLER2
X_13092_ _19050_/Q _14320_/B _14320_/C VDD VSS _13095_/D OR3BX1
XFILLER_2_443 VSS VDD FILLER2
Xclkbuf_leaf_15__000_ clkload71/A VDD VSS _19695_/CK BUFX12
XFILLER_123_168 VSS VDD FILLER2
XFILLER_111_319 VSS VDD FILLER2
X_16920_ _17172_/A VDD VSS _17081_/C BUFX3
X_12043_ _12099_/A _12099_/B _12099_/C VDD VSS _14495_/B OAI21X1
XFILLER_49_40 VSS VDD FILLER2
XFILLER_49_62 VSS VDD FILLER2
X_16851_ _16859_/A _16851_/B VDD VSS _19690_/D AND2X1
X_15802_ _15816_/A _15802_/B VDD VSS _19419_/D NOR2X1
XFILLER_77_277 VSS VDD FILLER2
X_19570_ _19602_/CK _19570_/D _19570_/Q VDD VSS DFFQX1
XFILLER_1_36 VSS VDD FILLER2
X_16782_ _16793_/A _16782_/B VDD VSS _19628_/D AND2X1
XFILLER_18_300 VSS VDD FILLER2
X_13994_ _18922_/Q _14169_/B _14169_/C VDD VSS _13995_/D OR3BX1
XFILLER_1_69 VSS VDD FILLER2
X_18521_ _18521_/CK _18521_/D _18521_/Q _09313_/Y VDD VSS DFFRQX1
XFILLER_18_333 VSS VDD FILLER2
X_15733_ _15743_/A _15733_/B VDD VSS _19358_/D AND2X1
XFILLER_18_344 VSS VDD FILLER2
X_12945_ _12945_/A _14509_/B VDD VSS _13036_/A OR2X2
XFILLER_18_366 VSS VDD FILLER2
X_18452_ _18455_/CK _18521_/Q _20150_/A _20054_/RB VDD VSS DFFRQX1
XFILLER_18_388 VSS VDD FILLER2
X_15664_ _19330_/Q VDD VSS _15666_/A INVX1
X_12876_ _18965_/Q _12891_/A _14216_/B VDD VSS _14185_/B XOR3X1
XFILLER_60_122 VSS VDD FILLER2
X_17403_ _19838_/Q _19806_/Q _17403_/C VDD VSS _17407_/B AOI21X1
X_14615_ _14615_/A _14615_/B _14615_/C VDD VSS _15857_/B XOR3X1
X_18383_ _18391_/CK _18516_/Q _20188_/A _20065_/RB VDD VSS DFFRQX1
X_11827_ _11828_/A _11828_/B _11828_/D _11828_/C VDD VSS _14490_/C AOI211X1
X_15595_ _15584_/A _15595_/B VDD VSS _15620_/B NAND2BX1
XTAP_TAPCELL_ROW_71_651 VDD VSS WELLTAP
XFILLER_159_522 VSS VDD FILLER2
X_17334_ _19823_/Q _19791_/Q _17334_/C VDD VSS _17338_/B MIN3X1
X_14546_ _19987_/Q _14547_/B VDD VSS _19251_/D AND2X1
X_11758_ _11758_/A _11758_/B _14426_/B VDD VSS _11818_/B MIN3X1
XFILLER_81_82 VSS VDD FILLER2
XFILLER_60_199 VSS VDD FILLER2
XTAP_TAPCELL_ROW_43_397 VDD VSS WELLTAP
XFILLER_119_408 VDD VSS FILLER4
X_10709_ _10709_/A _10709_/B _10709_/C VDD VSS _10785_/A NOR3X1
X_17265_ _17267_/C _17266_/B _17306_/C VDD VSS _17266_/C OAI21X1
X_14477_ _14493_/A _14477_/B VDD VSS _19190_/D NOR2X1
X_11689_ _19988_/Q _19252_/Q VDD VSS _11716_/B XOR2X1
X_19004_ _19059_/CK _19004_/D _19004_/Q VDD VSS DFFQX1
Xclkload104 _18589_/CK VDD VSS clkload104/Y INVX2
X_16216_ _19655_/Q _16813_/B VDD VSS _16217_/B XNOR2X1
Xclkload115 _18268_/CK VDD VSS clkload115/Y INVX2
X_13428_ _13601_/A _13601_/B _13601_/C VDD VSS _13473_/B AOI21X1
X_17196_ _17197_/A _17197_/B _17197_/D _17197_/C VDD VSS _17199_/C AOI211X1
XFILLER_60_4 VDD VSS DECAPHV8
XFILLER_127_463 VSS VDD FILLER2
XFILLER_161_219 VDD VSS DECAPHV8
XFILLER_142_400 VSS VDD FILLER2
X_16147_ _16150_/A _16880_/B VDD VSS _16148_/B XNOR2X1
X_13359_ _19137_/Q _14417_/B VDD VSS _13432_/C _14417_/C NAND3X1
XFILLER_154_260 VDD VSS DECAPHV16
XFILLER_115_636 VDD VSS FILLER1
XFILLER_6_793 VSS VDD FILLER2
XFILLER_5_270 VSS VDD FILLER2
X_16078_ _19713_/Q _16876_/B VDD VSS _16079_/C NOR2X1
XFILLER_142_488 VDD VSS FILLER1
X_15029_ _15039_/B _15029_/B VDD VSS _15714_/B XNOR2X1
X_19906_ clkload9/A _19906_/D _19906_/Q VDD VSS DFFQX1
XFILLER_130_639 VDD VSS FILLER4
X_19837_ _19895_/CK _19837_/D _19837_/Q VDD VSS DFFQX1
XFILLER_68_244 VDD VSS FILLER1
XFILLER_84_704 VDD VSS FILLER1
XFILLER_96_575 VSS VDD FILLER2
XFILLER_68_277 VDD VSS FILLER4
Xinput2 mosi VDD VSS input2/Y BUFX3
X_19768_ clkload4/A _19768_/D _19768_/Q VDD VSS DFFQX1
XFILLER_68_299 VSS VDD FILLER2
XFILLER_37_620 VSS VDD FILLER2
X_09521_ _20018_/Q _20017_/Q _20019_/Q _09521_/D VDD VSS _20019_/D AOI31X1
XFILLER_83_247 VDD VSS FILLER1
X_18719_ _18801_/CK _18719_/D _18719_/Q VDD VSS DFFQX1
X_19699_ _19702_/CK _19699_/D _19699_/Q VDD VSS DFFQX1
XFILLER_52_601 VSS VDD FILLER2
XFILLER_25_815 VSS VDD FILLER2
XFILLER_92_770 VDD VSS FILLER4
X_09452_ _19966_/Q _09467_/B _09483_/B VDD VSS _09453_/C AOI21X1
XFILLER_36_174 VDD VSS FILLER4
XFILLER_24_314 VSS VDD FILLER2
XFILLER_36_196 VDD VSS FILLER4
XFILLER_91_291 VDD VSS FILLER4
XFILLER_24_347 VSS VDD FILLER2
XTAP_TAPCELL_ROW_34_320 VDD VSS WELLTAP
X_09383_ _11196_/A _11436_/C _10274_/B _09907_/A VDD VSS _09387_/B AND4X2
XFILLER_12_509 VSS VDD FILLER2
XFILLER_52_678 VSS VDD FILLER2
XFILLER_20_542 VSS VDD FILLER2
XFILLER_165_503 VSS VDD FILLER2
XTAP_TAPCELL_ROW_137_1249 VDD VSS WELLTAP
Xclkbuf_leaf_16_clk_regs clkload1/A VDD VSS clkload7/A BUFX12
XFILLER_117_8 VSS VDD FILLER2
XFILLER_146_772 VSS VDD FILLER2
XFILLER_106_636 VSS VDD FILLER2
XFILLER_133_411 VSS VDD FILLER2
XFILLER_145_282 VDD VSS FILLER4
XFILLER_3_229 VSS VDD FILLER2
XFILLER_10_56 VDD VSS FILLER4
XFILLER_126_34 VSS VDD FILLER2
XFILLER_105_157 VSS VDD FILLER2
XFILLER_160_252 VDD VSS FILLER4
XFILLER_10_89 VSS VDD FILLER2
XFILLER_133_488 VSS VDD FILLER2
XFILLER_120_116 VSS VDD FILLER2
XFILLER_160_285 VDD VSS FILLER4
XFILLER_120_138 VDD VSS FILLER1
XFILLER_102_853 VDD VSS FILLER4
XFILLER_86_49 VSS VDD FILLER2
XFILLER_101_352 VSS VDD FILLER2
XFILLER_59_266 VSS VDD FILLER2
XFILLER_101_363 VSS VDD FILLER2
XTAP_TAPCELL_ROW_148_1345 VDD VSS WELLTAP
XFILLER_142_22 VDD VSS FILLER4
XFILLER_59_277 VSS VDD FILLER2
XFILLER_142_33 VDD VSS FILLER4
XFILLER_28_631 VSS VDD FILLER2
XFILLER_142_66 VDD VSS FILLER1
X_09719_ _18449_/Q VDD VSS _20161_/A INVX1
X_10991_ _11023_/A _10991_/B VDD VSS _10992_/B XOR2X1
XTAP_TAPCELL_ROW_85_776 VDD VSS WELLTAP
X_12730_ _12821_/B _14348_/C _19075_/Q VDD VSS _12731_/D AND3BX1
XFILLER_55_494 VSS VDD FILLER2
XFILLER_27_185 VDD VSS FILLER1
XFILLER_15_347 VDD VSS FILLER4
X_12661_ _19213_/Q _12755_/A _12837_/B VDD VSS _12662_/D XNOR3X1
XFILLER_70_453 VDD VSS FILLER4
XFILLER_15_358 VDD VSS FILLER4
XFILLER_43_678 VSS VDD FILLER2
XFILLER_70_464 VSS VDD FILLER2
XFILLER_42_166 VDD VSS FILLER4
XFILLER_30_306 VSS VDD FILLER2
X_14400_ _14415_/A _14400_/B VDD VSS _19121_/D AND2X1
X_11612_ _18756_/Q _11612_/B VDD VSS _18783_/D AND2X1
XTAP_TAPCELL_ROW_6_68 VDD VSS WELLTAP
XFILLER_42_177 VDD VSS FILLER4
XFILLER_30_328 VDD VSS FILLER4
X_15380_ _19320_/Q _15691_/B VDD VSS _15381_/B XNOR2X1
X_12592_ _12593_/D _14408_/B VDD VSS _12732_/A NAND2X1
XFILLER_30_339 VDD VSS FILLER4
XTAP_TAPCELL_ROW_159_1441 VDD VSS WELLTAP
XFILLER_136_0 VSS VDD FILLER2
X_14331_ _13849_/Y _16726_/B _14331_/C VDD VSS _19059_/D AND3BX1
X_11543_ _18006_/C VDD VSS _11648_/A BUFX3
XFILLER_156_514 VDD VSS DECAPHV8
XFILLER_7_524 VDD VSS FILLER4
XFILLER_7_535 VDD VSS DECAPHV8
XFILLER_51_74 VSS VDD FILLER2
X_17050_ _17048_/Y _17050_/B _17986_/C VDD VSS _19763_/D AND3BX1
X_14262_ _14255_/Y _14262_/B _14262_/C VDD VSS _19000_/D AND3BX1
X_11474_ _16860_/A VDD VSS _11484_/B BUFX3
XFILLER_51_96 VSS VDD FILLER2
XFILLER_109_463 VSS VDD FILLER2
X_16001_ _16033_/A _16033_/B VDD VSS _16804_/B XNOR2X1
X_13213_ _13365_/A _13364_/B VDD VSS _14354_/B XNOR2X1
X_10425_ _10585_/C _10550_/A VDD VSS _10738_/C NAND2BX1
X_14193_ _14219_/A _14193_/B _14193_/C VDD VSS _18943_/D NOR3X1
XFILLER_109_485 VSS VDD FILLER2
XFILLER_136_282 VSS VDD FILLER2
XFILLER_164_591 VSS VDD FILLER2
X_13144_ _20011_/Q _19275_/Q VDD VSS _13255_/D AND2X1
XTAP_TAPCELL_ROW_114_1035 VDD VSS WELLTAP
XFILLER_152_753 VSS VDD FILLER2
X_10356_ _11272_/A _10356_/B VDD VSS _18553_/D NOR2X1
XFILLER_152_797 VSS VDD FILLER2
X_17952_ _17957_/B _17957_/C VDD VSS _17953_/B NOR2X1
X_13075_ _18911_/Q _13178_/B _13178_/C VDD VSS _13081_/B XNOR3X1
X_10287_ _10338_/A _10338_/B _10287_/C VDD VSS _10295_/B AOI21X1
X_16903_ _19738_/Q _17827_/B VDD VSS _19738_/D NOR2X1
X_12026_ _19122_/Q _12026_/B VDD VSS _12087_/C _12026_/C NAND3X1
X_17883_ _17885_/C _17884_/B _17917_/C VDD VSS _17884_/C OAI21X1
XFILLER_78_564 VDD VSS FILLER4
XFILLER_120_661 VDD VSS FILLER4
X_19622_ _19696_/CK _19622_/D _19622_/Q VDD VSS DFFQX1
XFILLER_66_726 VDD VSS DECAPHV8
XFILLER_65_203 VSS VDD FILLER2
XFILLER_38_417 VDD VSS FILLER1
XFILLER_120_683 VSS VDD FILLER2
X_16834_ _16838_/A _16834_/B VDD VSS _19675_/D NOR2X1
XFILLER_93_523 VDD VSS FILLER4
XFILLER_76_71 VDD VSS FILLER4
X_19553_ _19584_/CK _19553_/D _19553_/Q VDD VSS DFFQX1
XTAP_TAPCELL_ROW_48_445 VDD VSS WELLTAP
XFILLER_81_707 VSS VDD FILLER2
X_16765_ _16775_/A _16765_/B VDD VSS _19613_/D NOR2X1
XFILLER_93_578 VSS VDD FILLER2
X_13977_ _13977_/A _14135_/B _14135_/C VDD VSS _13978_/D NOR3X1
XFILLER_19_664 VSS VDD FILLER2
XFILLER_34_601 VSS VDD FILLER2
XFILLER_18_152 VDD VSS FILLER4
X_18504_ _18504_/CK _18504_/D _18504_/Q _09362_/Y VDD VSS DFFRQX1
XTAP_TAPCELL_ROW_125_1142 VDD VSS WELLTAP
X_15716_ _15725_/A _15716_/B VDD VSS _19342_/D AND2X1
X_19484_ _19484_/CK _19484_/D _19484_/Q VDD VSS DFFQX1
X_12928_ _19105_/Q _14383_/B VDD VSS _13017_/C _14383_/C NAND3X1
XFILLER_33_100 VSS VDD FILLER2
X_16696_ _16696_/A _16704_/B VDD VSS _19551_/D NOR2X1
XFILLER_73_291 VSS VDD FILLER2
XFILLER_33_122 VSS VDD FILLER2
X_18435_ _18439_/CK _18499_/D _18435_/Q _18464_/RB VDD VSS DFFRQX1
X_15647_ _15657_/B _15647_/B VDD VSS _15701_/B XNOR2X1
XFILLER_33_144 VSS VDD FILLER2
X_12859_ _12860_/B _12860_/C _19160_/Q VDD VSS _12932_/B AOI21X1
XFILLER_61_464 VDD VSS FILLER1
XFILLER_33_166 VSS VDD FILLER2
XFILLER_61_486 VDD VSS FILLER4
XFILLER_21_328 VDD VSS FILLER1
X_18366_ _18374_/CK _18494_/D _20203_/A _18463_/RB VDD VSS DFFRQX1
X_15578_ _15578_/A _15599_/C VDD VSS _15791_/B XNOR2X1
XFILLER_33_199 VSS VDD FILLER2
X_17317_ _17318_/A _17318_/B _17318_/D _17318_/C VDD VSS _17320_/C AOI211X1
X_14529_ _14522_/Y _14529_/B _14529_/C VDD VSS _19235_/D AND3BX1
X_18297_ _18311_/CK _18510_/Q _18297_/Q _18464_/RB VDD VSS DFFRQX1
XFILLER_119_238 VSS VDD FILLER2
XFILLER_135_709 VDD VSS DECAPHV8
X_17248_ _19805_/Q _19773_/Q _17248_/C VDD VSS _17252_/B AOI21X1
XFILLER_115_400 VDD VSS FILLER4
XFILLER_127_271 VSS VDD FILLER2
X_17179_ _19790_/Q VDD VSS _17329_/B INVX1
XFILLER_127_282 VSS VDD FILLER2
XFILLER_51_0 VDD VSS FILLER1
XFILLER_143_742 VSS VDD FILLER2
X_20190_ _20190_/A VDD VSS _20190_/Y BUFX3
XFILLER_89_818 VSS VDD FILLER2
XFILLER_115_477 VDD VSS FILLER1
XFILLER_143_786 VSS VDD FILLER2
XFILLER_143_797 VSS VDD FILLER2
XFILLER_88_328 VSS VDD FILLER2
XFILLER_142_285 VSS VDD FILLER2
XFILLER_130_436 VSS VDD FILLER2
XFILLER_130_447 VDD VSS FILLER1
XFILLER_97_840 VSS VDD FILLER2
XFILLER_102_149 VDD VSS FILLER1
XFILLER_111_683 VSS VDD FILLER2
XFILLER_110_160 VSS VDD FILLER2
XFILLER_112_25 VDD VSS FILLER4
X_09504_ _18521_/Q _09507_/B _09506_/C _20078_/Q VDD VSS _20078_/D AO22X2
XFILLER_64_280 VDD VSS FILLER4
XFILLER_72_18 VDD VSS FILLER4
X_09435_ _18506_/Q _18505_/Q _09630_/C VDD VSS _09783_/B OR3BX1
XTAP_TAPCELL_ROW_19_180 VDD VSS WELLTAP
XTAP_TAPCELL_ROW_143_1297 VDD VSS WELLTAP
XFILLER_80_762 VDD VSS FILLER4
XFILLER_24_144 VDD VSS FILLER1
XFILLER_52_475 VSS VDD FILLER2
XFILLER_25_689 VSS VDD FILLER2
XFILLER_12_328 VSS VDD FILLER2
Xclkbuf_leaf_14__001_ clkload33/A VDD VSS _18973_/CK BUFX12
X_09366_ _18494_/D VDD VSS _18478_/D INVX1
XFILLER_21_840 VDD VSS FILLER4
XFILLER_138_514 VSS VDD FILLER2
XFILLER_165_300 VDD VSS FILLER4
X_09297_ _18526_/Q _09277_/A _09296_/Y VDD VSS _18526_/D MUX2X1
XFILLER_165_311 VSS VDD FILLER2
XFILLER_166_856 VDD VSS FILLER1
XFILLER_21_11 VSS VDD FILLER2
XFILLER_126_709 VDD VSS FILLER4
XFILLER_165_366 VDD VSS FILLER4
XFILLER_153_517 VSS VDD FILLER2
Xclkbuf_leaf_29__001_ clkbuf_2_1__f__001_/Y VDD VSS _19044_/CK BUFX12
XFILLER_119_783 VDD VSS FILLER4
XFILLER_4_516 VDD VSS FILLER1
X_10210_ _13177_/A _11426_/C VDD VSS _18547_/D NOR2X1
XFILLER_4_549 VSS VDD FILLER2
XFILLER_97_15 VDD VSS DECAPHV8
X_11190_ _18577_/Q VDD VSS _11220_/A INVX1
XFILLER_161_561 VDD VSS DECAPHV8
XFILLER_106_477 VDD VSS DECAPHV16
XFILLER_133_263 VSS VDD FILLER2
X_10141_ _18589_/Q _10163_/C VDD VSS _10142_/B NAND2X1
XFILLER_133_296 VSS VDD FILLER2
XFILLER_153_32 VSS VDD FILLER2
X_10072_ _09895_/B _10071_/Y _10131_/A VDD VSS _10078_/B MUXI2X1
XFILLER_87_361 VSS VDD FILLER2
XFILLER_48_726 VSS VDD FILLER2
X_13900_ _13912_/A _13912_/B _13901_/D _13912_/E VDD VSS _14300_/B OA211X2
XFILLER_153_76 VSS VDD FILLER2
XFILLER_75_523 VSS VDD FILLER2
X_14880_ _15015_/D VDD VSS _14881_/D INVX1
X_13831_ _19059_/Q _13831_/B _13850_/C VDD VSS _13912_/B XNOR3X1
XFILLER_62_206 VDD VSS DECAPHV8
XFILLER_16_601 VSS VDD FILLER2
X_16550_ _19571_/Q VDD VSS _16551_/A INVX1
XTAP_TAPCELL_ROW_45_415 VDD VSS WELLTAP
XFILLER_16_623 VDD VSS FILLER4
X_13762_ _18946_/Q _14196_/B VDD VSS _13918_/C _14196_/C AND3X2
X_10974_ _19956_/Q _18838_/Q VDD VSS _11004_/C NOR2X1
XFILLER_62_239 VSS VDD FILLER2
XFILLER_16_634 VDD VSS FILLER4
XFILLER_90_559 VSS VDD FILLER2
XFILLER_16_645 VSS VDD FILLER2
X_15501_ _15695_/B VDD VSS _15502_/B INVX1
X_12713_ _18991_/Q _12713_/B _12713_/C VDD VSS _12903_/A MIN3X1
X_16481_ _19633_/Q _16787_/B VDD VSS _16482_/B XOR2X1
X_13693_ _19001_/Q _14263_/B VDD VSS _13830_/C _14263_/C AND3X2
X_18220_ _18220_/CK _18220_/E _18220_/ECK VDD VSS CGX3
X_15432_ _19489_/Q _15882_/B VDD VSS _15433_/C NOR2BX1
XFILLER_70_283 VDD VSS FILLER1
X_12644_ _14409_/C _19130_/Q _12816_/B VDD VSS _12732_/D AND3BX1
XFILLER_31_648 VSS VDD FILLER2
XFILLER_12_840 VSS VDD FILLER2
XTAP_TAPCELL_ROW_53_492 VDD VSS WELLTAP
XFILLER_62_73 VSS VDD FILLER2
XFILLER_129_503 VDD VSS DECAPHV8
X_18151_ _18152_/A _18153_/C _18187_/C VDD VSS _18152_/C OAI21X1
XFILLER_30_158 VSS VDD FILLER2
X_15363_ _15364_/A _15364_/B _15364_/D _15364_/C VDD VSS _15395_/C OAOI211X1
X_12575_ _19241_/Q VDD VSS _12677_/A INVX1
XTAP_TAPCELL_ROW_120_1094 VDD VSS WELLTAP
X_17102_ _17100_/B _17102_/B VDD VSS _17103_/C NOR2BX1
XFILLER_157_856 VDD VSS FILLER1
X_14314_ _14334_/A _14314_/B VDD VSS _19045_/D AND2X1
X_18082_ _18168_/C _18090_/B VDD VSS _18083_/D NAND2X1
X_11526_ _18678_/Q _11531_/B VDD VSS _18705_/D AND2X1
X_15294_ _15294_/A _15299_/B VDD VSS _15689_/B XOR2X1
XFILLER_156_355 VDD VSS FILLER1
XFILLER_7_354 VDD VSS FILLER1
X_17033_ _17040_/A _17036_/C _17081_/C VDD VSS _17034_/C OAI21X1
X_14245_ _14251_/A _14245_/B VDD VSS _18985_/D NOR2X1
X_11457_ _19950_/Q _11460_/B VDD VSS _18643_/D AND2X1
XFILLER_109_282 VSS VDD FILLER2
XFILLER_125_742 VSS VDD FILLER2
XFILLER_125_753 VDD VSS FILLER4
X_10408_ _10454_/A _10454_/B _10721_/D VDD VSS _10409_/C AOI21X1
X_14176_ _14186_/A _14176_/B VDD VSS _18928_/D NOR2X1
XFILLER_124_241 VSS VDD FILLER2
X_11388_ _18594_/Q _11390_/B VDD VSS _11392_/B NAND2BX1
XFILLER_152_561 VDD VSS FILLER1
XFILLER_98_615 VDD VSS FILLER1
XFILLER_124_274 VDD VSS FILLER1
X_13127_ _19163_/Q _14447_/B VDD VSS _13316_/D _14447_/C NAND3X1
X_10339_ _10927_/C _10339_/B _10402_/B VDD VSS _10345_/C NOR3X1
XFILLER_112_425 VSS VDD FILLER2
X_18984_ _19037_/CK _18984_/D _18984_/Q VDD VSS DFFQX1
XFILLER_3_582 VDD VSS FILLER1
XFILLER_112_436 VDD VSS FILLER4
XFILLER_140_745 VDD VSS FILLER1
XFILLER_79_840 VSS VDD FILLER2
X_17935_ _17935_/A _17935_/B _17935_/C VDD VSS _19954_/D AOI21X1
X_13058_ _13133_/A _13133_/C VDD VSS _13061_/B _13133_/B NAND3X1
XTAP_TAPCELL_ROW_131_1190 VDD VSS WELLTAP
XFILLER_112_469 VDD VSS FILLER1
X_12009_ _18954_/Q _14205_/B VDD VSS _12070_/B NOR2X1
XFILLER_38_203 VDD VSS FILLER1
X_17866_ _17866_/A _17866_/B _17866_/C VDD VSS _19941_/D AOI21X1
XFILLER_38_247 VSS VDD FILLER2
X_16817_ _16826_/A _16817_/B VDD VSS _19659_/D NOR2X1
X_19605_ _19705_/CK _19605_/D _19605_/Q VDD VSS DFFQX1
XFILLER_26_409 VDD VSS FILLER4
X_17797_ _17800_/C _17797_/B VDD VSS _17798_/B XNOR2X1
XFILLER_93_375 VDD VSS DECAPHV8
X_19536_ _19536_/CK _19536_/D _19536_/Q VDD VSS DFFQX1
X_16748_ _16748_/A _16748_/B VDD VSS _19598_/D NOR2X1
X_19467_ _19508_/CK _19467_/D _19467_/Q VDD VSS DFFQX1
X_16679_ _16679_/A _16679_/B VDD VSS _16761_/B XNOR2X1
XFILLER_22_615 VSS VDD FILLER2
X_09220_ _18511_/Q VDD VSS _18394_/D INVX1
X_18418_ _18422_/CK _18519_/Q _20173_/A _18422_/RB VDD VSS DFFRQX1
XTAP_TAPCELL_ROW_16_161 VDD VSS WELLTAP
XFILLER_99_0 VDD VSS FILLER4
XFILLER_21_114 VDD VSS FILLER4
X_19398_ _19406_/CK _19398_/D _19398_/Q VDD VSS DFFQX1
XFILLER_22_659 VSS VDD FILLER2
XFILLER_148_823 VDD VSS DECAPHV8
XFILLER_166_119 VDD VSS FILLER4
XFILLER_147_300 VSS VDD FILLER2
X_18349_ _18359_/CK _18349_/D _18349_/Q _18374_/RB VDD VSS DFFRQX1
XFILLER_30_670 VDD VSS FILLER1
XFILLER_148_856 VDD VSS FILLER1
XFILLER_147_344 VDD VSS FILLER1
XTAP_TAPCELL_ROW_0_0 VDD VSS WELLTAP
XFILLER_135_517 VSS VDD FILLER2
XFILLER_107_219 VSS VDD FILLER2
XTAP_TAPCELL_ROW_134_1219 VDD VSS WELLTAP
XFILLER_115_241 VSS VDD FILLER2
XFILLER_150_509 VSS VDD FILLER2
Xclkbuf_2_2__f__09182_ clkbuf_0__09182_/Y VDD VSS _18583_/CK BUFX12
XFILLER_143_561 VDD VSS FILLER4
XFILLER_103_403 VDD VSS DECAPHV8
XFILLER_131_712 VSS VDD FILLER2
XFILLER_143_583 VDD VSS FILLER4
XFILLER_88_114 VSS VDD FILLER2
XFILLER_130_211 VSS VDD FILLER2
X_20173_ _20173_/A VDD VSS _20173_/Y BUFX3
X_09984_ _11095_/C VDD VSS _11226_/D BUFX3
XFILLER_130_222 VSS VDD FILLER2
XFILLER_67_18 VDD VSS DECAPHV8
XFILLER_130_244 VDD VSS DECAPHV8
XTAP_TAPCELL_ROW_145_1315 VDD VSS WELLTAP
XFILLER_57_556 VSS VDD FILLER2
XFILLER_84_342 VDD VSS FILLER1
XFILLER_57_567 VDD VSS FILLER1
XFILLER_29_258 VSS VDD FILLER2
XFILLER_123_57 VSS VDD FILLER2
XTAP_TAPCELL_ROW_95_871 VDD VSS WELLTAP
XFILLER_83_28 VSS VDD FILLER2
XFILLER_44_239 VSS VDD FILLER2
XTAP_TAPCELL_ROW_107_972 VDD VSS WELLTAP
XFILLER_25_453 VSS VDD FILLER2
XFILLER_25_464 VDD VSS FILLER1
XFILLER_13_615 VSS VDD FILLER2
XFILLER_80_581 VDD VSS FILLER4
XFILLER_16_88 VSS VDD FILLER2
X_09418_ _09421_/A _18201_/B _20057_/Q _20061_/D VDD VSS _18227_/E OAI211X1
X_10690_ _18695_/Q _18749_/Q VDD VSS _10693_/D XOR2X1
XFILLER_12_158 VSS VDD FILLER2
XFILLER_139_834 VSS VDD FILLER2
X_09349_ _09380_/B _09414_/D VDD VSS _09349_/Y NOR2BX1
XTAP_TAPCELL_ROW_50_462 VDD VSS WELLTAP
XFILLER_139_856 VDD VSS FILLER1
XFILLER_21_681 VDD VSS FILLER4
X_12360_ _12360_/A _12452_/D VDD VSS _14311_/B XNOR2X1
XFILLER_32_65 VSS VDD FILLER2
XFILLER_166_653 VDD VSS FILLER1
XFILLER_138_366 VDD VSS DECAPHV8
XTAP_TAPCELL_ROW_3_36 VDD VSS WELLTAP
XFILLER_154_815 VDD VSS FILLER1
X_11311_ _18585_/Q _11315_/B VDD VSS _11316_/A XNOR2X1
XFILLER_5_825 VDD VSS FILLER4
X_12291_ _12300_/A _12300_/B _12300_/C VDD VSS _12294_/C NOR3X1
XFILLER_154_848 VSS VDD FILLER2
XFILLER_119_580 VSS VDD FILLER2
XFILLER_107_742 VSS VDD FILLER2
X_14030_ _14054_/A _14170_/B _14170_/C VDD VSS _14085_/C NOR3X1
X_11242_ _11364_/B _11264_/A VDD VSS _11247_/A NAND2X1
XFILLER_164_20 VDD VSS FILLER1
XFILLER_106_263 VSS VDD FILLER2
XFILLER_107_797 VDD VSS FILLER4
XFILLER_121_200 VDD VSS FILLER4
X_11173_ _19961_/Q _18843_/Q _11173_/C VDD VSS _11176_/B MIN3X1
XTAP_TAPCELL_ROW_111_1016 VDD VSS WELLTAP
XFILLER_122_767 VSS VDD FILLER2
X_10124_ _17812_/A _10124_/B _10126_/C VDD VSS _18538_/D AND3BX1
XFILLER_95_607 VSS VDD FILLER2
XFILLER_79_158 VDD VSS FILLER1
XFILLER_122_789 VDD VSS FILLER1
X_15981_ _19674_/Q _16833_/B VDD VSS _16020_/A NOR2BX1
XFILLER_48_501 VSS VDD FILLER2
XFILLER_94_117 VSS VDD FILLER2
XFILLER_121_288 VDD VSS FILLER1
X_17720_ _18132_/A _17720_/B _17721_/C VDD VSS _19906_/D NOR3X1
XFILLER_88_681 VSS VDD FILLER2
X_14932_ _15834_/B _15834_/C _19449_/Q VDD VSS _14959_/B AOI21X1
X_10055_ _18583_/Q _10079_/C VDD VSS _10055_/Y XNOR2X1
XFILLER_57_40 VSS VDD FILLER2
XFILLER_57_51 VDD VSS FILLER1
X_17651_ _17653_/C _17651_/B _17651_/C VDD VSS _19891_/D AOI21X1
X_14863_ _19448_/Q VDD VSS _14906_/C INVX1
XFILLER_48_578 VSS VDD FILLER2
XFILLER_75_375 VSS VDD FILLER2
XFILLER_63_515 VSS VDD FILLER2
XFILLER_36_729 VSS VDD FILLER2
X_16602_ _19573_/Q _16722_/A _16602_/C VDD VSS _16626_/C MIN3X1
X_13814_ _18946_/Q _14196_/B VDD VSS _13818_/C _14196_/C NAND3X1
XFILLER_90_323 VSS VDD FILLER2
X_17582_ _19877_/Q _19845_/Q VDD VSS _17589_/C NOR2X1
Xdelaybuf_1_sclk delaybuf_1_sclk/A VDD VSS _18221_/CK BUFX12
X_14794_ _19447_/Q _14865_/A _14865_/B VDD VSS _14840_/D XNOR3X1
XFILLER_28_291 VSS VDD FILLER2
X_19321_ _19333_/CK _19321_/D _19321_/Q VDD VSS DFFQX1
XTAP_TAPCELL_ROW_122_1112 VDD VSS WELLTAP
X_16533_ _16545_/A _16825_/B VDD VSS _16534_/B XNOR2X1
X_13745_ _18196_/A _17925_/B _17925_/C VDD VSS _18862_/D AND3BX1
X_10957_ _10957_/A _10957_/B _10957_/C VDD VSS _11023_/A OA21X2
XFILLER_73_72 VSS VDD FILLER2
XFILLER_16_475 VSS VDD FILLER2
XFILLER_16_486 VDD VSS FILLER1
X_19252_ _19988_/CK _19252_/D _19252_/Q VDD VSS DFFQX1
X_16464_ _16467_/B _16465_/B _18168_/C VDD VSS _16465_/C OAI21X1
X_13676_ _14195_/C _18945_/Q _13816_/B VDD VSS _13748_/D AND3BX1
X_10888_ _10888_/A _10888_/B VDD VSS _10954_/A NAND2X1
XFILLER_148_108 VSS VDD FILLER2
X_18203_ _18200_/Y _20016_/Q _18202_/Y VDD VSS _20016_/D MUX2X1
X_15415_ _19349_/Q _15723_/B VDD VSS _15456_/B NOR2X1
XTAP_TAPCELL_ROW_13_131 VDD VSS WELLTAP
X_19183_ _19185_/CK _19183_/D _19183_/Q VDD VSS DFFQX1
X_12627_ _19074_/Q VDD VSS _12719_/A INVX1
XFILLER_129_311 VSS VDD FILLER2
X_16395_ _16395_/A _19917_/Q _16395_/C VDD VSS _16421_/B MIN3X1
X_18134_ _19293_/Q _18138_/B VDD VSS _18136_/C XOR2X1
X_15346_ _19431_/Q VDD VSS _15348_/A INVX1
X_12558_ _12558_/A _14345_/B _12625_/C _12558_/D VDD VSS _12729_/A OAOI211X1
XFILLER_129_399 VDD VSS FILLER1
X_18065_ _19280_/Q _18068_/B VDD VSS _18069_/B XOR2X1
X_11509_ _16860_/A VDD VSS _11519_/B BUFX3
XFILLER_7_162 VSS VDD FILLER2
X_15277_ _15311_/A _15311_/B _15311_/D _15311_/C VDD VSS _15307_/D OAI211X1
XFILLER_8_696 VDD VSS FILLER1
X_12489_ _12571_/A _14503_/B _12497_/C VDD VSS _14504_/C OR3BX1
XFILLER_7_184 VSS VDD FILLER2
X_17016_ _17180_/B _17047_/B VDD VSS _17022_/B XNOR2X1
XFILLER_7_195 VSS VDD FILLER2
XFILLER_132_509 VSS VDD FILLER2
X_14228_ _14231_/A _14228_/B VDD VSS _18973_/D AND2X1
XFILLER_160_818 VSS VDD FILLER2
XFILLER_125_561 VDD VSS FILLER4
XFILLER_113_712 VSS VDD FILLER2
XFILLER_98_80 VDD VSS FILLER1
XFILLER_125_594 VSS VDD FILLER2
X_14159_ _14136_/Y _14159_/B _14159_/C VDD VSS _18914_/D AND3BX1
XFILLER_98_434 VSS VDD FILLER2
XFILLER_140_553 VSS VDD FILLER2
XFILLER_86_607 VDD VSS FILLER4
XFILLER_112_255 VSS VDD FILLER2
XFILLER_140_564 VDD VSS FILLER4
X_18967_ _18997_/CK _18967_/D _18967_/Q VDD VSS DFFQX1
XFILLER_86_629 VSS VDD FILLER2
XFILLER_100_417 VDD VSS FILLER1
Xclkbuf_leaf_13__002_ clkbuf_leaf_9__002_/A VDD VSS _19949_/CK BUFX12
X_17918_ _17919_/C _17918_/B _17918_/C VDD VSS _19951_/D AOI21X1
X_18898_ _19171_/CK _18898_/D _18898_/Q VDD VSS DFFQX1
XFILLER_14_0 VSS VDD FILLER2
XFILLER_39_556 VSS VDD FILLER2
X_17849_ _17853_/A _17853_/B VDD VSS _17851_/B XNOR2X1
XFILLER_66_386 VSS VDD FILLER2
XTAP_TAPCELL_ROW_92_841 VDD VSS WELLTAP
X_19519_ _19536_/CK _19519_/D _19519_/Q VDD VSS DFFQX1
XTAP_TAPCELL_ROW_104_953 VDD VSS WELLTAP
XTAP_TAPCELL_ROW_64_587 VDD VSS WELLTAP
XFILLER_62_581 VSS VDD FILLER2
XFILLER_34_272 VSS VDD FILLER2
XFILLER_62_592 VSS VDD FILLER2
XFILLER_50_743 VSS VDD FILLER2
XFILLER_22_445 VDD VSS FILLER4
XFILLER_139_108 VSS VDD FILLER2
XFILLER_22_456 VSS VDD FILLER2
XFILLER_10_607 VSS VDD FILLER2
X_09203_ _18495_/D VDD VSS _18431_/D INVX1
XFILLER_50_776 VSS VDD FILLER2
XFILLER_148_642 VDD VSS FILLER4
XFILLER_147_141 VDD VSS FILLER4
XFILLER_108_539 VSS VDD FILLER2
XFILLER_135_314 VDD VSS FILLER1
XFILLER_147_185 VDD VSS FILLER1
XFILLER_118_24 VDD VSS FILLER1
XFILLER_162_122 VSS VDD FILLER2
XFILLER_135_369 VSS VDD FILLER2
XFILLER_163_678 VDD VSS FILLER1
XFILLER_150_317 VSS VDD FILLER2
XFILLER_89_401 VSS VDD FILLER2
XFILLER_162_177 VSS VDD FILLER2
XFILLER_150_328 VSS VDD FILLER2
XFILLER_89_412 VDD VSS FILLER1
XFILLER_78_28 VSS VDD FILLER2
XFILLER_103_200 VDD VSS FILLER1
X_20225_ _20225_/A VDD VSS _20225_/Y BUFX3
XTAP_TAPCELL_ROW_151_1374 VDD VSS WELLTAP
XFILLER_89_423 VDD VSS FILLER1
XFILLER_104_734 VSS VDD FILLER2
XFILLER_103_233 VDD VSS FILLER4
XFILLER_103_244 VSS VDD FILLER2
X_20156_ _20156_/A VDD VSS _20156_/Y BUFX3
XFILLER_89_478 VSS VDD FILLER2
XFILLER_77_618 VDD VSS FILLER4
XFILLER_103_277 VSS VDD FILLER2
XFILLER_103_288 VDD VSS FILLER1
XFILLER_76_128 VSS VDD FILLER2
X_20087_ _20087_/A VDD VSS _20087_/Y BUFX3
XFILLER_58_843 VSS VDD FILLER2
X_09898_ _09872_/Y _09857_/Y _10966_/A VDD VSS _09898_/Y MUX2X1
XFILLER_85_640 VSS VDD FILLER2
XFILLER_94_49 VDD VSS DECAPHV16
XFILLER_84_161 VSS VDD FILLER2
XFILLER_73_824 VSS VDD FILLER2
XFILLER_57_375 VSS VDD FILLER2
XFILLER_85_695 VSS VDD FILLER2
XFILLER_27_43 VSS VDD FILLER2
XFILLER_17_228 VSS VDD FILLER2
XTAP_TAPCELL_ROW_55_510 VDD VSS WELLTAP
XFILLER_150_44 VSS VDD FILLER2
X_11860_ _19062_/Q _14334_/B VDD VSS _11861_/B OR2X2
XFILLER_45_548 VSS VDD FILLER2
XTAP_TAPCELL_ROW_162_1470 VDD VSS WELLTAP
XFILLER_72_356 VSS VDD FILLER2
XFILLER_27_98 VDD VSS FILLER1
X_10811_ _10811_/A _10816_/C VDD VSS _10849_/B XNOR2X1
X_11791_ _19145_/Q _11818_/B _14427_/B VDD VSS _11854_/B MIN3X1
XTAP_TAPCELL_ROW_27_256 VDD VSS WELLTAP
XFILLER_60_518 VSS VDD FILLER2
XFILLER_150_99 VDD VSS FILLER4
Xclkbuf_1_0__f__09181_ clkbuf_0__09181_/Y VDD VSS _18612_/CK BUFX12
XFILLER_13_412 VSS VDD FILLER2
X_13530_ _13531_/A _13531_/B _13531_/D _13531_/C VDD VSS _13728_/B OAOI211X1
X_10742_ _11272_/A _10742_/B VDD VSS _18563_/D NOR2X1
XFILLER_41_743 VDD VSS FILLER1
XFILLER_25_294 VSS VDD FILLER2
X_13461_ _19250_/Q VDD VSS _13462_/A INVX1
X_10673_ _10721_/D VDD VSS _11226_/A BUFX3
XFILLER_9_427 VSS VDD FILLER2
XFILLER_158_439 VSS VDD FILLER2
XFILLER_9_449 VSS VDD FILLER2
XFILLER_139_642 VDD VSS DECAPHV8
X_15200_ _15200_/A _15200_/B _15200_/C VDD VSS _15201_/B AOI21X1
X_12412_ _12673_/A _12583_/A VDD VSS _12495_/D NOR2X1
XTAP_TAPCELL_ROW_10_101 VDD VSS WELLTAP
X_16180_ _19589_/Q VDD VSS _16181_/A INVX1
X_13392_ _14192_/C _18942_/Q _13516_/B VDD VSS _13393_/D AND3BX1
XFILLER_127_826 VSS VDD FILLER2
XFILLER_5_600 VDD VSS FILLER1
XFILLER_166_472 VSS VDD FILLER2
X_15131_ _19314_/Q VDD VSS _15132_/A INVX1
XFILLER_154_623 VDD VSS FILLER4
X_12343_ _18903_/Q _12429_/B _14147_/B VDD VSS _14115_/B XNOR3X1
XFILLER_166_494 VDD VSS FILLER1
XFILLER_154_656 VSS VDD FILLER2
XFILLER_142_807 VSS VDD FILLER2
XFILLER_114_509 VSS VDD FILLER2
XFILLER_142_818 VDD VSS FILLER4
XFILLER_153_155 VSS VDD FILLER2
X_15062_ _19508_/Q _15902_/B VDD VSS _15145_/C NAND2BX1
X_12274_ _12341_/A _12341_/B _14178_/B VDD VSS _12348_/C XNOR3X1
XFILLER_107_561 VSS VDD FILLER2
XFILLER_141_317 VSS VDD FILLER2
X_14013_ _14013_/A _14232_/B _14013_/C _14013_/D VDD VSS _14043_/B AOAI211X1
X_11225_ _19963_/Q _18845_/Q _11225_/C VDD VSS _11226_/C MIN3X1
XFILLER_4_176 VSS VDD FILLER2
XFILLER_141_339 VSS VDD FILLER2
XFILLER_134_380 VSS VDD FILLER2
X_19870_ clkload2/A _19870_/D _19870_/Q VDD VSS DFFQX1
XFILLER_4_187 VSS VDD FILLER2
XFILLER_122_531 VSS VDD FILLER2
XFILLER_68_607 VSS VDD FILLER2
X_18821_ _18823_/CK _18821_/D _18821_/Q VDD VSS DFFQX1
X_11156_ _11158_/B _11156_/B VDD VSS _11157_/B XOR2X1
XFILLER_68_618 VDD VSS FILLER1
XFILLER_95_404 VDD VSS FILLER4
XFILLER_68_61 VDD VSS FILLER4
XFILLER_68_72 VDD VSS FILLER4
XFILLER_49_810 VSS VDD FILLER2
XFILLER_110_737 VSS VDD FILLER2
X_10107_ _10131_/A _10107_/B VDD VSS _10109_/C NOR2X1
X_18752_ _19943_/CK _18752_/D _18752_/Q VDD VSS DFFQX1
XFILLER_67_128 VSS VDD FILLER2
X_15964_ _19550_/Q _19902_/Q VDD VSS _15995_/B XNOR2X1
X_11087_ _11085_/Y _11088_/C VDD VSS _18573_/D NOR2BX1
X_17703_ _19902_/Q _19870_/Q _17703_/C VDD VSS _17707_/B AOI21X1
X_14915_ _15834_/B _15834_/C _19449_/Q VDD VSS _14931_/B AO21X2
X_10038_ _10050_/B _10038_/B VDD VSS _11409_/C XOR2X1
X_18683_ _18818_/CK _18683_/D _18683_/Q VDD VSS DFFQX1
X_15895_ _15895_/A _15895_/B VDD VSS _19502_/D NOR2X1
XFILLER_48_375 VDD VSS FILLER1
XFILLER_76_695 VSS VDD FILLER2
X_17634_ _19887_/Q _19855_/Q _17634_/C VDD VSS _17638_/B MIN3X1
X_14846_ _19364_/Q _15739_/B VDD VSS _14847_/B XNOR2X1
XFILLER_84_71 VSS VDD FILLER2
XFILLER_36_548 VSS VDD FILLER2
XFILLER_91_654 VSS VDD FILLER2
XFILLER_90_142 VSS VDD FILLER2
X_17565_ _17567_/C _17565_/B _17565_/C VDD VSS _19873_/D AOI21X1
X_14777_ _15831_/B _15831_/C _14778_/A VDD VSS _14818_/B OAI21X1
X_11989_ _19233_/Q _14527_/B VDD VSS _12099_/A AND2X1
XFILLER_90_175 VSS VDD FILLER2
X_19304_ _19331_/CK _19304_/D _19304_/Q VDD VSS DFFQX1
X_16516_ _19698_/Q _16859_/B VDD VSS _16537_/A NAND2BX1
X_13728_ _13728_/A _13728_/B _13728_/C VDD VSS _14327_/C NOR3X1
X_17496_ _17496_/A _17496_/B _17496_/C _17496_/D VDD VSS _17497_/C AOAI211X1
XTAP_TAPCELL_ROW_101_923 VDD VSS WELLTAP
XFILLER_32_754 VSS VDD FILLER2
X_19235_ _20000_/CK _19235_/D _19235_/Q VDD VSS DFFQX1
X_16447_ _16447_/A _16447_/B VDD VSS _16472_/B NAND2X1
XFILLER_32_787 VSS VDD FILLER2
X_13659_ _18889_/Q _13807_/A _13807_/B VDD VSS _13660_/D XNOR3X1
X_19166_ _19166_/CK _19166_/D _19166_/Q VDD VSS DFFQX1
X_16378_ _19661_/Q _16819_/B VDD VSS _16390_/C XNOR2X1
XFILLER_129_174 VSS VDD FILLER2
X_18117_ _18117_/A _18117_/B _18116_/Y VDD VSS _19997_/D AOI21BX1
X_15329_ _15345_/B _15329_/B VDD VSS _15752_/B XOR2X1
XFILLER_129_185 VDD VSS FILLER1
XFILLER_144_111 VSS VDD FILLER2
X_19097_ _19126_/CK _19097_/D _19097_/Q VDD VSS DFFQX1
XFILLER_8_482 VDD VSS FILLER4
XFILLER_145_667 VSS VDD FILLER2
XFILLER_105_509 VSS VDD FILLER2
XFILLER_133_818 VDD VSS FILLER1
X_18048_ _18544_/Q _18048_/B _18545_/Q VDD VSS _18049_/C AOI21X1
XFILLER_132_328 VDD VSS FILLER4
XFILLER_132_339 VSS VDD FILLER2
XFILLER_125_391 VDD VSS DECAPHV8
XFILLER_141_840 VDD VSS DECAPHV16
XFILLER_98_231 VDD VSS FILLER1
X_20010_ _20013_/CK _20010_/D _20010_/Q VDD VSS DFFQX1
X_09821_ _14522_/A VDD VSS _10180_/A BUFX3
XFILLER_98_264 VDD VSS FILLER1
XFILLER_99_798 VSS VDD FILLER2
XFILLER_58_106 VDD VSS FILLER1
X_19999_ _20000_/CK _19999_/D _19999_/Q VDD VSS DFFQX1
XFILLER_101_737 VDD VSS FILLER4
Xclkbuf_0__09175_ _18224_/ECK VDD VSS clkbuf_0__09175_/Y BUFX12
XFILLER_58_128 VDD VSS FILLER4
X_09752_ _09753_/A _20192_/A VDD VSS _09753_/C NAND2X1
XTAP_TAPCELL_ROW_69_635 VDD VSS WELLTAP
XFILLER_67_640 VSS VDD FILLER2
XFILLER_100_258 VSS VDD FILLER2
XFILLER_104_26 VSS VDD FILLER2
X_09683_ _18415_/Q VDD VSS _20170_/A INVX1
XFILLER_39_375 VDD VSS DECAPHV8
XFILLER_94_481 VSS VDD FILLER2
XFILLER_67_695 VDD VSS FILLER4
XFILLER_55_835 VSS VDD FILLER2
XFILLER_27_526 VSS VDD FILLER2
XFILLER_54_323 VSS VDD FILLER2
XFILLER_81_131 VDD VSS FILLER1
XFILLER_23_721 VSS VDD FILLER2
XTAP_TAPCELL_ROW_24_226 VDD VSS WELLTAP
XFILLER_23_743 VDD VSS FILLER1
XFILLER_80_18 VSS VDD FILLER2
XFILLER_50_540 VDD VSS FILLER1
XFILLER_13_34 VSS VDD FILLER2
XFILLER_108_303 VDD VSS FILLER4
XFILLER_108_314 VSS VDD FILLER2
XFILLER_108_358 VDD VSS FILLER4
XFILLER_89_38 VDD VSS FILLER1
XFILLER_163_464 VDD VSS FILLER1
XFILLER_123_306 VSS VDD FILLER2
XTAP_TAPCELL_ROW_0_15 VDD VSS WELLTAP
XFILLER_1_102 VSS VDD FILLER2
XFILLER_123_339 VDD VSS DECAPHV8
XFILLER_150_125 VSS VDD FILLER2
Xmax_cap190 _18515_/Q VDD VSS _18494_/D BUFX8
X_11010_ _11033_/C _11195_/A _11010_/C VDD VSS _11011_/D AND3BX1
X_20208_ _20208_/A VDD VSS _20208_/Y BUFX3
XFILLER_131_350 VDD VSS FILLER4
XFILLER_49_117 VSS VDD FILLER2
X_20139_ _20139_/A VDD VSS _20139_/Y BUFX3
XFILLER_38_53 VSS VDD FILLER2
XFILLER_46_802 VSS VDD FILLER2
XFILLER_64_109 VSS VDD FILLER2
XFILLER_38_64 VDD VSS FILLER1
X_12961_ _19246_/Q _13150_/A _13047_/C VDD VSS _13133_/C XNOR3X1
XFILLER_58_673 VSS VDD FILLER2
XFILLER_58_695 VSS VDD FILLER2
X_14700_ _19471_/Q _14700_/B _15862_/B VDD VSS _15828_/B XNOR3X1
X_11912_ _19148_/Q _11912_/B VDD VSS _11973_/C _11912_/C NAND3X1
XFILLER_73_632 VDD VSS DECAPHV16
X_15680_ _15706_/A _15680_/B VDD VSS _19309_/D AND2X1
X_12892_ _12892_/A _14285_/B VDD VSS _12900_/A NOR2X1
XFILLER_73_654 VSS VDD FILLER2
XFILLER_72_131 VSS VDD FILLER2
XFILLER_161_98 VDD VSS FILLER1
XFILLER_72_142 VDD VSS FILLER4
X_14631_ _14672_/A _14672_/B _14640_/C VDD VSS _15796_/B XNOR3X1
XFILLER_54_30 VSS VDD FILLER2
X_11843_ _19994_/Q _19258_/Q VDD VSS _11881_/C NOR2X1
X_17350_ _17353_/C _17351_/B _17363_/C VDD VSS _17351_/C OAI21X1
XFILLER_14_743 VDD VSS FILLER4
X_14562_ _20001_/Q _14569_/B VDD VSS _19265_/D AND2X1
XFILLER_159_704 VDD VSS FILLER1
XFILLER_14_754 VDD VSS DECAPHV16
X_11774_ _14521_/B _14521_/C _19228_/Q VDD VSS _11776_/C AOI21X1
Xclkbuf_1_0__f__09164_ clkbuf_0__09164_/Y VDD VSS _18454_/CK BUFX12
X_16301_ _16302_/A _16302_/B _16302_/C VDD VSS _16301_/Y NOR3X1
XFILLER_158_203 VDD VSS FILLER4
XFILLER_14_776 VSS VDD FILLER2
X_13513_ _18998_/Q _14260_/B VDD VSS _13594_/C _14260_/C AND3X2
X_17281_ _17281_/A _17281_/B _17281_/C VDD VSS _17289_/A OA21X2
X_10725_ _10725_/A _10725_/B _10725_/C _11095_/C VDD VSS _10726_/D AOI31X1
XFILLER_9_213 VSS VDD FILLER2
X_14493_ _14493_/A _14493_/B VDD VSS _19204_/D NOR2X1
XFILLER_158_247 VDD VSS FILLER1
X_19020_ _19044_/CK _19020_/D _19020_/Q VDD VSS DFFQX1
X_16232_ _19591_/Q _16741_/B VDD VSS _16233_/C NOR2X1
X_13444_ _13444_/A _13444_/B _13444_/C _13444_/D VDD VSS _13447_/B AOAI211X1
X_10656_ _10945_/A _10656_/B _10656_/C _10947_/A VDD VSS _10657_/C AO211X2
XFILLER_126_111 VSS VDD FILLER2
X_16163_ _16163_/A _16182_/B VDD VSS _16774_/B XNOR2X1
Xclkload16 clkload16/A VDD VSS clkload16/Y INVX14
Xclkload27 _18799_/CK VDD VSS clkload27/Y INVX1
X_13375_ _18998_/Q _13509_/B _13375_/C VDD VSS _13401_/C XNOR3X1
X_10587_ _10587_/A _10596_/B VDD VSS _10589_/B XNOR2X1
Xclkload38 _19166_/CK VDD VSS clkload38/Y BUFX12
XFILLER_154_431 VDD VSS FILLER4
Xclkload49 _19072_/CK VDD VSS clkload49/Y INVX6
XFILLER_127_667 VDD VSS FILLER1
X_15114_ _15198_/B _15840_/B _19454_/Q VDD VSS _15139_/C AOI2B1X1
X_12326_ _19211_/Q _12326_/B _12391_/D VDD VSS _12474_/B XNOR3X1
XFILLER_114_306 VSS VDD FILLER2
X_16094_ _19650_/Q _16807_/B VDD VSS _16106_/B XOR2X1
XTAP_TAPCELL_ROW_117_1066 VDD VSS WELLTAP
XFILLER_142_626 VDD VSS FILLER1
XFILLER_114_328 VDD VSS DECAPHV8
XFILLER_5_485 VSS VDD FILLER2
X_15045_ _15045_/A _15045_/B _15045_/C _15045_/D VDD VSS _15069_/B AOAI211X1
X_19922_ _19924_/CK _19922_/D _19922_/Q VDD VSS DFFQX1
X_12257_ _12447_/A _12447_/B _12257_/C _12257_/D VDD VSS _12363_/B AOAI211X1
XFILLER_123_840 VSS VDD FILLER2
XFILLER_141_136 VSS VDD FILLER2
XFILLER_79_71 VSS VDD FILLER2
X_11208_ _11208_/A _11208_/B _11208_/C _11208_/D _11208_/E VDD VSS _11209_/C AOI221X1
X_19853_ _19853_/CK _19853_/D _19853_/Q VDD VSS DFFQX1
X_12188_ _12188_/A _12286_/B VDD VSS _14308_/B XNOR2X1
XFILLER_110_501 VSS VDD FILLER2
XFILLER_122_372 VDD VSS FILLER4
X_18804_ _18831_/CK _18804_/D _18804_/Q VDD VSS DFFQX1
XFILLER_122_394 VSS VDD FILLER2
X_11139_ _19961_/Q _18843_/Q VDD VSS _11143_/A XNOR2X1
X_16996_ _16996_/A _16996_/B _16996_/C _16996_/D VDD VSS _17000_/B OA211X2
X_19784_ _19785_/CK _19784_/D _19784_/Q VDD VSS DFFQX1
XFILLER_49_662 VSS VDD FILLER2
X_15947_ _19645_/Q _16802_/B VDD VSS _15975_/B XNOR2X1
X_18735_ _18818_/CK _18735_/D _18735_/Q VDD VSS DFFQX1
XTAP_TAPCELL_ROW_66_605 VDD VSS WELLTAP
XFILLER_95_289 VSS VDD FILLER2
XFILLER_95_92 VDD VSS FILLER1
XFILLER_48_172 VSS VDD FILLER2
XTAP_TAPCELL_ROW_128_1162 VDD VSS WELLTAP
XFILLER_36_323 VSS VDD FILLER2
X_18666_ _18801_/CK _18666_/D _18666_/Q VDD VSS DFFQX1
X_15878_ _14522_/Y _15878_/B _15878_/C VDD VSS _19486_/D AND3BX1
XFILLER_63_153 VDD VSS DECAPHV8
X_14829_ _19503_/Q _15897_/B VDD VSS _15015_/B XOR2X1
X_17617_ _17618_/A _17618_/B _17618_/D _17618_/C VDD VSS _17620_/C AOI211X1
X_18597_ _18612_/CK _18597_/D _18597_/Q VDD VSS DFFQX1
XTAP_TAPCELL_ROW_74_682 VDD VSS WELLTAP
XFILLER_51_337 VDD VSS FILLER4
XFILLER_17_592 VSS VDD FILLER2
X_17548_ _19870_/Q _19838_/Q VDD VSS _17549_/B XOR2X1
X_17479_ _17629_/B _17479_/B _17479_/C VDD VSS _17484_/C MIN3X1
XFILLER_32_573 VDD VSS DECAPHV8
XFILLER_81_0 VDD VSS FILLER4
X_19218_ _19250_/CK _19218_/D _19218_/Q VDD VSS DFFQX1
XFILLER_118_601 VSS VDD FILLER2
X_19149_ _19223_/CK _19149_/D _19149_/Q VDD VSS DFFQX1
XFILLER_145_420 VDD VSS DECAPHV8
XFILLER_118_645 VDD VSS FILLER1
XFILLER_106_807 VSS VDD FILLER2
XFILLER_117_166 VDD VSS DECAPHV16
XFILLER_132_125 VDD VSS FILLER4
XFILLER_160_456 VSS VDD FILLER2
Xfanout203 _09284_/AB VDD VSS _20045_/RB BUFX3
Xfanout214 _18373_/RB VDD VSS _20073_/RB BUFX3
XFILLER_113_361 VSS VDD FILLER2
Xfanout225 _18503_/RB VDD VSS _18486_/RB BUFX3
XFILLER_86_212 VSS VDD FILLER2
XFILLER_113_383 VDD VSS FILLER4
X_09804_ _20080_/Q _09818_/B _09818_/C _18274_/Q _09804_/E VDD VSS _09805_/C AOI221X1
XFILLER_101_534 VDD VSS FILLER4
XFILLER_101_556 VSS VDD FILLER2
XFILLER_86_245 VSS VDD FILLER2
X_09735_ _18306_/Q _09812_/B _09797_/C _20207_/A VDD VSS _09737_/C AOI22X1
X_09666_ _09666_/A _09666_/B VDD VSS _18285_/D NAND2X1
XFILLER_55_654 VSS VDD FILLER2
XFILLER_82_451 VSS VDD FILLER2
XFILLER_54_142 VSS VDD FILLER2
XFILLER_131_46 VSS VDD FILLER2
XFILLER_70_602 VSS VDD FILLER2
XFILLER_43_816 VSS VDD FILLER2
XFILLER_43_827 VDD VSS FILLER1
X_09597_ _18441_/Q _09751_/B _09772_/B _18345_/Q _09597_/E VDD VSS _09600_/C OAI221X1
XFILLER_24_11 VSS VDD FILLER2
XFILLER_24_44 VSS VDD FILLER2
XFILLER_23_573 VSS VDD FILLER2
XFILLER_10_201 VSS VDD FILLER2
XFILLER_24_66 VSS VDD FILLER2
XFILLER_10_223 VSS VDD FILLER2
X_10510_ _11272_/A _10510_/B VDD VSS _18557_/D NOR2X1
X_11490_ _18645_/Q _11496_/B VDD VSS _18672_/D AND2X1
XFILLER_11_768 VDD VSS FILLER1
XFILLER_149_770 VDD VSS FILLER1
XFILLER_7_717 VSS VDD FILLER2
XFILLER_108_100 VSS VDD FILLER2
X_10441_ _10441_/A _10441_/B _10441_/C _10441_/D VDD VSS _10514_/B AOAI211X1
XFILLER_109_634 VSS VDD FILLER2
XFILLER_156_10 VSS VDD FILLER2
XFILLER_108_144 VDD VSS FILLER1
X_13160_ _13212_/A _14352_/B _13212_/C VDD VSS _14353_/B OAI21X1
X_10372_ _10372_/A _10372_/B _10372_/C _10372_/D VDD VSS _10399_/B AOAI211X1
XFILLER_156_32 VSS VDD FILLER2
XFILLER_136_475 VDD VSS FILLER1
XFILLER_164_784 VDD VSS FILLER4
XFILLER_156_43 VSS VDD FILLER2
XFILLER_124_637 VDD VSS FILLER4
X_12111_ _19208_/Q _12111_/B _12158_/C VDD VSS _12160_/C XNOR3X1
X_13091_ _13091_/A _13091_/B _13091_/C VDD VSS _13095_/B XNOR3X1
XFILLER_105_840 VSS VDD FILLER2
X_12042_ _19179_/Q VDD VSS _12154_/A INVX1
XFILLER_78_702 VDD VSS FILLER1
XFILLER_111_309 VSS VDD FILLER2
XFILLER_120_832 VDD VSS FILLER4
XFILLER_2_499 VSS VDD FILLER2
X_16850_ _16859_/A _16850_/B VDD VSS _19689_/D AND2X1
XFILLER_78_757 VSS VDD FILLER2
XFILLER_120_854 VSS VDD FILLER2
XFILLER_78_768 VDD VSS FILLER1
XFILLER_49_96 VSS VDD FILLER2
X_15801_ _15817_/A VDD VSS _15816_/A BUFX3
X_16781_ _16793_/A _16781_/B VDD VSS _19627_/D AND2X1
X_13993_ _13993_/A _13993_/B _13993_/C _13993_/D VDD VSS _14169_/C OA211X2
XFILLER_1_48 VDD VSS FILLER1
XFILLER_19_835 VSS VDD FILLER2
X_18520_ _18520_/CK _18520_/D _18520_/Q _09316_/Y VDD VSS DFFRQX1
XFILLER_58_481 VSS VDD FILLER2
XFILLER_105_91 VSS VDD FILLER2
X_15732_ _15743_/A _15732_/B VDD VSS _19357_/D AND2X1
XFILLER_46_632 VDD VSS DECAPHV16
X_12944_ _19189_/Q VDD VSS _13032_/A INVX1
X_18451_ _18455_/CK _18451_/D _18451_/Q _20054_/RB VDD VSS DFFRQX1
XFILLER_34_827 VSS VDD FILLER2
X_15663_ _19331_/Q _15703_/B VDD VSS _15668_/A XOR2X1
XFILLER_61_613 VSS VDD FILLER2
X_12875_ _13004_/B _12890_/C VDD VSS _14216_/B NAND2X1
X_17402_ _17400_/B _17402_/B VDD VSS _17403_/C NOR2BX1
X_14614_ _19468_/Q VDD VSS _14616_/A INVX1
X_18382_ _18389_/CK _18515_/Q _20187_/A _20065_/RB VDD VSS DFFRQX1
X_11826_ _11874_/A _11874_/B _11874_/C VDD VSS _11869_/A OAI21X1
X_09963__234 _20081_/CK VDD VSS _18510_/CK INVX1
X_15594_ _19382_/Q _15759_/B VDD VSS _15620_/A NAND2X1
XFILLER_33_359 VSS VDD FILLER2
XFILLER_14_540 VSS VDD FILLER2
XTAP_TAPCELL_ROW_71_652 VDD VSS WELLTAP
X_17333_ _19824_/Q _19792_/Q VDD VSS _17338_/A XNOR2X1
XFILLER_60_167 VSS VDD FILLER2
X_14545_ _15672_/A _14545_/B VDD VSS _19250_/D NOR2X1
XFILLER_14_584 VDD VSS FILLER1
X_11757_ _19116_/Q _14394_/B VDD VSS _11819_/B NOR2X1
XFILLER_41_370 VSS VDD FILLER2
XFILLER_159_556 VSS VDD FILLER2
XTAP_TAPCELL_ROW_43_398 VDD VSS WELLTAP
XFILLER_159_567 VSS VDD FILLER2
X_17264_ _19809_/Q _19777_/Q VDD VSS _17266_/B XOR2X1
X_10708_ _10708_/A _10708_/B _10708_/C VDD VSS _10743_/B AO21X2
X_14476_ _14490_/A _14476_/B _14476_/C VDD VSS _19189_/D NOR3X1
X_11688_ _19987_/Q _19251_/Q VDD VSS _11706_/A NOR2X1
X_19003_ _19086_/CK _19003_/D _19003_/Q VDD VSS DFFQX1
X_16215_ _16230_/A _16215_/B VDD VSS _16813_/B XOR2X1
Xclkload105 _18578_/CK VDD VSS clkload105/Y INVX1
X_13427_ _13427_/A _14358_/B _14358_/C VDD VSS _13601_/C NOR3X1
X_17195_ _19794_/Q _19762_/Q VDD VSS _17197_/D XNOR2X1
Xclkload116 _18309_/CK VDD VSS clkload116/Y INVX2
X_10639_ _10640_/A _10687_/C VDD VSS _10639_/Y NAND2X1
XFILLER_155_751 VSS VDD FILLER2
X_16146_ _16146_/A _16152_/B VDD VSS _16880_/B XNOR2X1
XFILLER_155_773 VDD VSS FILLER1
X_13358_ _14417_/B _14417_/C _19137_/Q VDD VSS _13432_/B AOI21X1
XFILLER_115_648 VSS VDD FILLER2
X_12309_ _19210_/Q _12391_/A _12391_/B VDD VSS _12311_/D XNOR3X1
X_16077_ _16100_/A _16077_/B VDD VSS _19521_/D NOR2X1
XFILLER_5_282 VSS VDD FILLER2
X_13289_ _13290_/A _13290_/B _13290_/D _13290_/C VDD VSS _13393_/B OAOI211X1
XFILLER_130_607 VSS VDD FILLER2
X_15028_ _19368_/Q _15744_/B VDD VSS _15029_/B XNOR2X1
X_19905_ _19924_/CK _19905_/D _19905_/Q VDD VSS DFFQX1
XFILLER_123_670 VSS VDD FILLER2
XFILLER_96_510 VDD VSS FILLER1
XFILLER_111_832 VDD VSS FILLER4
XFILLER_96_532 VDD VSS FILLER4
XFILLER_68_223 VSS VDD FILLER2
X_19836_ _19895_/CK _19836_/D _19836_/Q VDD VSS DFFQX1
XFILLER_96_543 VSS VDD FILLER2
XFILLER_83_204 VSS VDD FILLER2
XFILLER_28_109 VDD VSS FILLER1
X_19767_ clkload4/A _19767_/D _19767_/Q VDD VSS DFFQX1
XFILLER_83_215 VDD VSS FILLER1
XFILLER_110_386 VSS VDD FILLER2
X_16979_ _19750_/Q _17049_/B _16984_/A _16984_/B VDD VSS _16979_/Y AOI211X1
Xinput3 rst_b VDD VSS input3/Y BUFX3
X_09520_ _20018_/Q _20017_/Q _20019_/Q _09520_/D VDD VSS _09521_/D AOAI211X1
X_18718_ _18773_/CK _18718_/D _18718_/Q VDD VSS DFFQX1
XFILLER_37_654 VDD VSS FILLER4
X_19698_ _19702_/CK _19698_/D _19698_/Q VDD VSS DFFQX1
XFILLER_36_131 VSS VDD FILLER2
XFILLER_36_142 VDD VSS FILLER4
X_09451_ _18456_/D _09468_/B _09451_/C VDD VSS _18257_/D AOI21X1
XFILLER_92_782 VDD VSS DECAPHV8
X_18649_ _19954_/CK _18649_/D _18649_/Q VDD VSS DFFQX1
XFILLER_92_793 VDD VSS FILLER4
XFILLER_25_849 VDD VSS FILLER4
XFILLER_36_186 VSS VDD FILLER2
XFILLER_101_16 VDD VSS DECAPHV8
XFILLER_52_646 VDD VSS FILLER4
XFILLER_24_337 VDD VSS FILLER4
XTAP_TAPCELL_ROW_34_321 VDD VSS WELLTAP
XFILLER_51_134 VDD VSS DECAPHV8
X_09382_ _11435_/A _11435_/B VDD VSS _09907_/A NOR2X1
XFILLER_40_819 VDD VSS FILLER1
XFILLER_51_178 VSS VDD FILLER2
XFILLER_51_189 VSS VDD FILLER2
XFILLER_118_431 VSS VDD FILLER2
XFILLER_146_784 VDD VSS FILLER4
XFILLER_118_497 VSS VDD FILLER2
XFILLER_145_294 VSS VDD FILLER2
XFILLER_161_743 VDD VSS FILLER1
XFILLER_105_136 VDD VSS FILLER1
XFILLER_121_607 VSS VDD FILLER2
XFILLER_160_264 VSS VDD FILLER2
XFILLER_102_810 VDD VSS FILLER1
XFILLER_160_275 VSS VDD FILLER2
XFILLER_114_681 VDD VSS FILLER4
XFILLER_99_370 VSS VDD FILLER2
XFILLER_102_832 VDD VSS FILLER4
XFILLER_99_381 VSS VDD FILLER2
XFILLER_160_297 VSS VDD FILLER2
XFILLER_101_320 VSS VDD FILLER2
XTAP_TAPCELL_ROW_148_1346 VDD VSS WELLTAP
XFILLER_75_727 VSS VDD FILLER2
XFILLER_101_375 VDD VSS FILLER4
XFILLER_142_45 VDD VSS FILLER1
X_09718_ _18337_/Q VDD VSS _20091_/A INVX1
X_10990_ _18570_/Q _10990_/B VDD VSS _10991_/B XNOR2X1
XFILLER_55_451 VSS VDD FILLER2
XTAP_TAPCELL_ROW_85_777 VDD VSS WELLTAP
XFILLER_55_462 VSS VDD FILLER2
XFILLER_16_816 VSS VDD FILLER2
X_09649_ _09729_/D _20121_/A _09649_/C _09788_/B VDD VSS _09650_/D AOAI211X1
XFILLER_35_32 VSS VDD FILLER2
XFILLER_82_281 VDD VSS FILLER1
XFILLER_70_421 VSS VDD FILLER2
X_12660_ _12486_/A _14504_/B _14504_/C VDD VSS _12662_/C AND3BX1
XFILLER_35_65 VSS VDD FILLER2
XFILLER_31_808 VSS VDD FILLER2
XFILLER_42_156 VSS VDD FILLER2
X_11611_ _18755_/Q _11612_/B VDD VSS _18782_/D AND2X1
XTAP_TAPCELL_ROW_6_69 VDD VSS WELLTAP
XFILLER_11_510 VDD VSS FILLER4
X_12591_ _19130_/Q _12591_/B _12643_/D VDD VSS _12732_/B XNOR3X1
XFILLER_23_370 VSS VDD FILLER2
XTAP_TAPCELL_ROW_159_1442 VDD VSS WELLTAP
XFILLER_51_690 VSS VDD FILLER2
X_14330_ _16273_/A VDD VSS _16726_/B BUFX3
XFILLER_129_729 VSS VDD FILLER2
X_11542_ _18693_/Q _11542_/B VDD VSS _18720_/D AND2X1
XFILLER_51_42 VDD VSS FILLER4
XFILLER_11_565 VSS VDD FILLER2
XFILLER_128_217 VSS VDD FILLER2
XFILLER_128_239 VSS VDD FILLER2
XFILLER_129_0 VDD VSS FILLER4
X_14261_ _14270_/A _14261_/B VDD VSS _18999_/D AND2X1
X_11473_ _18630_/Q _11473_/B VDD VSS _18657_/D AND2X1
X_16000_ _19615_/Q _16767_/B VDD VSS _16033_/B XNOR2X1
XFILLER_7_569 VDD VSS FILLER4
XFILLER_109_453 VSS VDD FILLER2
X_13212_ _13212_/A _14352_/B _13212_/C _13212_/D VDD VSS _13365_/A OAOI211X1
X_10424_ _10655_/A _10499_/A _10499_/B _10424_/D VDD VSS _10738_/B AOI31X1
X_14192_ _14219_/A _14192_/B _14192_/C VDD VSS _18942_/D NOR3X1
XFILLER_124_423 VDD VSS FILLER1
XFILLER_151_220 VSS VDD FILLER2
X_13143_ _20011_/Q _19275_/Q VDD VSS _13255_/B OR2X2
XTAP_TAPCELL_ROW_114_1036 VDD VSS WELLTAP
X_10355_ _18553_/Q _10357_/B _10357_/C VDD VSS _10356_/B XNOR3X1
XFILLER_3_742 VSS VDD FILLER2
XFILLER_112_607 VSS VDD FILLER2
Xclkbuf_leaf_0_sclk delaybuf_1_sclk/A VDD VSS _18223_/CK BUFX12
XFILLER_2_230 VSS VDD FILLER2
XFILLER_111_106 VSS VDD FILLER2
XFILLER_112_629 VDD VSS FILLER1
X_17951_ _18867_/Q VDD VSS _17957_/A INVX1
X_13074_ _18939_/Q _13086_/B _14189_/B VDD VSS _13178_/C XNOR3X1
X_10286_ _10338_/A _10338_/B _10803_/A VDD VSS _10287_/C OAI21X1
XFILLER_97_329 VDD VSS FILLER4
XFILLER_3_786 VSS VDD FILLER2
XFILLER_78_532 VDD VSS FILLER1
X_16902_ _17990_/A _16902_/B VDD VSS _19737_/D AND2X1
X_12025_ _12026_/B _12026_/C _19122_/Q VDD VSS _12087_/B AOI21X1
XFILLER_104_180 VDD VSS DECAPHV8
X_17882_ _17885_/A _17885_/B VDD VSS _17884_/B XNOR2X1
X_19621_ _19696_/CK _19621_/D _19621_/Q VDD VSS DFFQX1
XTAP_TAPCELL_ROW_76_700 VDD VSS WELLTAP
X_16833_ _16843_/A _16833_/B VDD VSS _19674_/D AND2X1
XFILLER_78_598 VDD VSS FILLER4
XFILLER_65_226 VSS VDD FILLER2
XFILLER_19_621 VSS VDD FILLER2
XFILLER_93_546 VSS VDD FILLER2
X_16764_ _16775_/A _16764_/B VDD VSS _19612_/D NOR2X1
X_19552_ _19584_/CK _19552_/D _19552_/Q VDD VSS DFFQX1
X_13976_ _14118_/A _17949_/B VDD VSS _18866_/D NOR2X1
XTAP_TAPCELL_ROW_48_446 VDD VSS WELLTAP
XFILLER_19_654 VSS VDD FILLER2
XFILLER_18_131 VSS VDD FILLER2
XFILLER_18_142 VSS VDD FILLER2
X_15715_ _15739_/A _15715_/B VDD VSS _19341_/D NOR2X1
X_18503_ _18503_/CK _18524_/Q _20116_/A _18503_/RB VDD VSS DFFRQX1
X_12927_ _14383_/B _14383_/C _19105_/Q VDD VSS _13017_/B AOI21X1
X_16695_ _19902_/Q _16702_/B VDD VSS _19550_/D AND2X1
X_19483_ _19484_/CK _19483_/D _19483_/Q VDD VSS DFFQX1
XFILLER_74_793 VSS VDD FILLER2
XFILLER_61_410 VDD VSS FILLER4
XFILLER_18_186 VDD VSS FILLER1
XFILLER_61_421 VDD VSS DECAPHV8
X_15646_ _19357_/Q _15732_/B VDD VSS _15647_/B XOR2X1
X_18434_ _18437_/CK _18519_/Q _18434_/Q _20075_/RB VDD VSS DFFRQX1
X_12858_ _12940_/A _12940_/C _12940_/B VDD VSS _12860_/C AO21X2
XFILLER_34_668 VDD VSS DECAPHV16
X_18365_ _18374_/CK _18365_/D _18365_/Q _18463_/RB VDD VSS DFFRQX1
X_11809_ _19146_/Q _11874_/A _11916_/B VDD VSS _11820_/B XNOR3X1
X_15577_ _19438_/Q _15823_/B VDD VSS _15599_/C XOR2X1
XFILLER_33_189 VSS VDD FILLER2
X_12789_ _12789_/A _12789_/B _12789_/C VDD VSS _14120_/B XNOR3X1
XFILLER_159_342 VSS VDD FILLER2
XFILLER_14_392 VDD VSS FILLER4
X_17316_ _19820_/Q _19788_/Q VDD VSS _17318_/D XNOR2X1
X_14528_ _14528_/A _14528_/B _15836_/C VDD VSS _19234_/D OA21X2
XFILLER_159_364 VDD VSS DECAPHV8
X_18296_ _18309_/CK _18525_/Q _18296_/Q _20078_/RB VDD VSS DFFRQX1
XFILLER_159_375 VDD VSS FILLER4
X_17247_ _17245_/B _17247_/B VDD VSS _17248_/C NOR2BX1
X_14459_ _14493_/A _14459_/B VDD VSS _19173_/D NOR2X1
XFILLER_162_507 VDD VSS FILLER4
X_17178_ _17178_/A _17180_/C _17178_/C VDD VSS _19790_/D AOI21X1
XFILLER_115_412 VSS VDD FILLER2
XFILLER_143_732 VSS VDD FILLER2
X_16129_ _16129_/A _16129_/B _16843_/B VDD VSS _16146_/A MIN3X1
XFILLER_142_231 VDD VSS FILLER1
XFILLER_115_456 VSS VDD FILLER2
XFILLER_142_242 VDD VSS FILLER4
XFILLER_143_765 VSS VDD FILLER2
XFILLER_142_253 VSS VDD FILLER2
XFILLER_69_521 VDD VSS FILLER1
XFILLER_102_128 VSS VDD FILLER2
XFILLER_69_543 VSS VDD FILLER2
XFILLER_57_705 VDD VSS FILLER1
XFILLER_110_150 VSS VDD FILLER2
X_19819_ _19853_/CK _19819_/D _19819_/Q VDD VSS DFFQX1
XFILLER_57_727 VDD VSS FILLER4
XFILLER_56_204 VDD VSS FILLER1
XFILLER_110_172 VSS VDD FILLER2
XFILLER_84_546 VDD VSS FILLER1
X_09503_ _18499_/D _09507_/B _09506_/C _20077_/Q VDD VSS _20077_/D AO22X2
XFILLER_25_624 VSS VDD FILLER2
XFILLER_64_270 VSS VDD FILLER2
XTAP_TAPCELL_ROW_82_747 VDD VSS WELLTAP
XFILLER_52_421 VDD VSS FILLER4
XFILLER_52_432 VSS VDD FILLER2
X_09434_ _09446_/A _09696_/B VDD VSS _18215_/E NOR2X1
XTAP_TAPCELL_ROW_19_181 VDD VSS WELLTAP
XTAP_TAPCELL_ROW_143_1298 VDD VSS WELLTAP
XFILLER_40_616 VSS VDD FILLER2
Xclkbuf_leaf_14__000_ clkload71/A VDD VSS _19696_/CK BUFX12
X_09365_ _18511_/Q VDD VSS _18490_/D INVX1
XFILLER_33_690 VSS VDD FILLER2
XFILLER_166_813 VDD VSS DECAPHV8
X_09296_ _09296_/A _09301_/B _09301_/A _09354_/B VDD VSS _09296_/Y AOI211X1
XFILLER_165_323 VDD VSS FILLER4
XFILLER_21_23 VSS VDD FILLER2
Xclkbuf_leaf_29__000_ clkload70/A VDD VSS _19379_/CK BUFX12
XFILLER_115_6 VDD VSS FILLER1
XFILLER_137_23 VSS VDD FILLER2
XFILLER_137_34 VSS VDD FILLER2
XFILLER_146_592 VDD VSS FILLER4
XFILLER_106_445 VDD VSS DECAPHV32
XFILLER_134_765 VSS VDD FILLER2
XFILLER_97_27 VDD VSS FILLER1
XFILLER_134_787 VSS VDD FILLER2
X_10140_ _18590_/Q VDD VSS _11367_/A INVX1
XFILLER_161_584 VSS VDD FILLER2
XFILLER_0_723 VSS VDD FILLER2
X_10071_ _10018_/B _10070_/Y _10167_/A VDD VSS _10071_/Y MUXI2X1
XFILLER_102_640 VDD VSS FILLER4
XFILLER_102_662 VDD VSS FILLER4
XFILLER_0_789 VDD VSS FILLER4
XFILLER_102_673 VSS VDD FILLER2
XFILLER_75_513 VDD VSS FILLER1
XFILLER_102_695 VSS VDD FILLER2
XFILLER_87_384 VSS VDD FILLER2
XTAP_TAPCELL_ROW_98_891 VDD VSS WELLTAP
XFILLER_75_535 VDD VSS FILLER1
X_13830_ _13830_/A _13830_/B _13830_/C _13830_/D VDD VSS _13891_/B AOAI211X1
XFILLER_75_557 VDD VSS FILLER1
XFILLER_47_259 VSS VDD FILLER2
XFILLER_75_579 VDD VSS DECAPHV16
X_13761_ _13816_/A _13816_/B VDD VSS _14196_/C _13816_/C NAND3X1
XTAP_TAPCELL_ROW_45_416 VDD VSS WELLTAP
X_10973_ _19955_/Q _18837_/Q _10932_/C VDD VSS _11004_/A AOI21BX1
XFILLER_56_793 VDD VSS DECAPHV8
XFILLER_55_270 VSS VDD FILLER2
XFILLER_83_590 VSS VDD FILLER2
X_15500_ _15674_/A _18149_/B VDD VSS _19295_/D AND2X1
X_12712_ _12712_/A _12712_/B _14214_/B VDD VSS _12796_/B MIN3X1
X_16480_ _16502_/B _16480_/B VDD VSS _16787_/B XNOR2X1
X_13692_ _13840_/A _13840_/B _13692_/C VDD VSS _14263_/C OAI21X1
XFILLER_71_763 VDD VSS DECAPHV8
XFILLER_31_605 VSS VDD FILLER2
XFILLER_16_679 VDD VSS FILLER4
XFILLER_15_167 VSS VDD FILLER2
X_15431_ _19462_/Q VDD VSS _15469_/A INVX1
XFILLER_70_262 VDD VSS FILLER1
XFILLER_31_627 VSS VDD FILLER2
X_12643_ _12643_/A _12643_/B _12643_/C _12643_/D VDD VSS _12816_/B AOAI211X1
XFILLER_62_41 VDD VSS FILLER4
XFILLER_15_189 VSS VDD FILLER2
XTAP_TAPCELL_ROW_53_493 VDD VSS WELLTAP
XFILLER_30_137 VSS VDD FILLER2
XFILLER_24_690 VDD VSS FILLER4
XFILLER_157_802 VSS VDD FILLER2
X_18150_ _18150_/A _18150_/B _18150_/C VDD VSS _18153_/C OAI21X1
X_15362_ _19488_/Q _15881_/B VDD VSS _15364_/C XNOR2X1
XFILLER_11_340 VDD VSS FILLER4
X_12574_ _12840_/A _12840_/B VDD VSS _12649_/B NOR2X1
XTAP_TAPCELL_ROW_120_1095 VDD VSS WELLTAP
X_17101_ _17390_/A _17101_/B VDD VSS _19774_/D NOR2X1
X_14313_ _14339_/A _14313_/B VDD VSS _19044_/D NOR2X1
X_18081_ _18083_/A _18083_/B _18083_/C VDD VSS _18090_/B AO21X2
X_11525_ _18677_/Q _11531_/B VDD VSS _18704_/D AND2X1
X_15293_ _19345_/Q _15293_/B _15719_/B VDD VSS _15299_/B MIN3X1
XFILLER_8_856 VDD VSS FILLER1
XFILLER_7_47 VSS VDD FILLER2
XFILLER_7_58 VSS VDD FILLER2
XFILLER_116_209 VSS VDD FILLER2
X_17032_ _17045_/A _17041_/A VDD VSS _17036_/C NAND2X1
X_14244_ _14244_/A _14244_/B VDD VSS _14245_/B XNOR2X1
XFILLER_156_378 VDD VSS DECAPHV16
X_11456_ _19949_/Q _11460_/B VDD VSS _18642_/D AND2X1
XFILLER_7_377 VDD VSS FILLER1
X_10407_ _18661_/Q _18769_/Q VDD VSS _10454_/B XOR2X1
XFILLER_124_231 VDD VSS FILLER1
X_14175_ _14197_/A _14175_/B VDD VSS _18927_/D AND2X1
XFILLER_125_765 VDD VSS FILLER4
X_11387_ _11392_/A _11387_/B _11387_/C VDD VSS _18594_/D AOI21X1
XFILLER_152_551 VDD VSS FILLER1
X_13126_ _13233_/A _14446_/B VDD VSS _14447_/C _13233_/C NAND3X1
XFILLER_97_104 VSS VDD FILLER2
X_10338_ _10338_/A _10338_/B _10338_/C _10338_/D VDD VSS _10402_/B OAOI211X1
XFILLER_98_638 VSS VDD FILLER2
XFILLER_3_561 VSS VDD FILLER2
X_18983_ _19037_/CK _18983_/D _18983_/Q VDD VSS DFFQX1
XFILLER_97_126 VSS VDD FILLER2
XFILLER_79_830 VSS VDD FILLER2
X_17934_ _17935_/A _17935_/B _18187_/C VDD VSS _17935_/C OAI21X1
X_13057_ _19219_/Q _13240_/A _13139_/B VDD VSS _13141_/D XNOR3X1
XFILLER_140_779 VSS VDD FILLER2
X_10269_ _11436_/C _10266_/Y _10269_/C _10269_/D VDD VSS _10346_/B AOI2BB2X1
XTAP_TAPCELL_ROW_131_1191 VDD VSS WELLTAP
XFILLER_39_705 VSS VDD FILLER2
XFILLER_23_5 VSS VDD FILLER2
Xclkbuf_leaf_1_clk_regs clkbuf_leaf_9_clk_regs/A VDD VSS clkload9/A BUFX12
X_12008_ _12010_/A _12010_/B _14238_/B VDD VSS _14205_/B XNOR3X1
XFILLER_120_470 VDD VSS FILLER1
X_17865_ _17866_/A _17866_/B _17917_/C VDD VSS _17866_/C OAI21X1
X_19604_ _19636_/CK _19604_/D _19604_/Q VDD VSS DFFQX1
X_16816_ _16826_/A _16816_/B VDD VSS _19658_/D NOR2X1
X_09969__240 _20080_/CK VDD VSS _18516_/CK INVX1
X_17796_ _19923_/Q _19891_/Q VDD VSS _17797_/B XOR2X1
X_19535_ _19536_/CK _19535_/D _19535_/Q VDD VSS DFFQX1
X_16747_ _16748_/A _16747_/B VDD VSS _19597_/D NOR2X1
X_13959_ _19005_/Q _14267_/B VDD VSS _14004_/A NOR2BX1
XFILLER_46_270 VSS VDD FILLER2
XFILLER_19_495 VSS VDD FILLER2
XFILLER_74_590 VDD VSS FILLER4
XFILLER_34_421 VSS VDD FILLER2
X_16678_ _19929_/Q _19577_/Q VDD VSS _16679_/B XOR2X1
X_19466_ _19466_/CK _19466_/D _19466_/Q VDD VSS DFFQX1
XFILLER_62_763 VSS VDD FILLER2
XFILLER_34_465 VSS VDD FILLER2
XFILLER_61_251 VDD VSS FILLER1
X_18417_ _18422_/CK _18518_/Q _20172_/A _18422_/RB VDD VSS DFFRQX1
XFILLER_34_487 VDD VSS FILLER1
X_15629_ _19356_/Q _15731_/B VDD VSS _15637_/B XNOR2X1
XFILLER_61_284 VDD VSS FILLER1
XFILLER_34_498 VDD VSS DECAPHV8
XFILLER_22_638 VDD VSS FILLER4
X_19397_ _19463_/CK _19397_/D _19397_/Q VDD VSS DFFQX1
XFILLER_15_690 VSS VDD FILLER2
X_18348_ _18357_/CK _18348_/D _18348_/Q _18491_/RB VDD VSS DFFRQX1
XFILLER_147_323 VSS VDD FILLER2
X_18279_ _18279_/CK _18279_/D _18279_/Q _09250_/Y VDD VSS DFFRQX1
XTAP_TAPCELL_ROW_0_1 VDD VSS WELLTAP
XFILLER_107_209 VSS VDD FILLER2
XFILLER_163_827 VSS VDD FILLER2
XFILLER_163_849 VSS VDD FILLER2
XFILLER_116_721 VSS VDD FILLER2
XFILLER_128_581 VSS VDD FILLER2
XFILLER_115_231 VDD VSS FILLER4
XFILLER_89_605 VDD VSS FILLER1
XFILLER_1_509 VSS VDD FILLER2
XFILLER_143_573 VSS VDD FILLER2
XFILLER_116_798 VDD VSS FILLER4
X_20172_ _20172_/A VDD VSS _20172_/Y BUFX3
X_09983_ _10362_/D VDD VSS _11095_/C BUFX3
XFILLER_89_649 VSS VDD FILLER2
XFILLER_88_137 VSS VDD FILLER2
XFILLER_130_256 VDD VSS FILLER1
XFILLER_85_800 VDD VSS FILLER4
XFILLER_97_671 VSS VDD FILLER2
XFILLER_69_384 VSS VDD FILLER2
XTAP_TAPCELL_ROW_145_1316 VDD VSS WELLTAP
XFILLER_84_332 VSS VDD FILLER2
XFILLER_45_708 VSS VDD FILLER2
XFILLER_83_18 VSS VDD FILLER2
XTAP_TAPCELL_ROW_95_872 VDD VSS WELLTAP
XFILLER_44_207 VDD VSS FILLER4
XFILLER_38_793 VSS VDD FILLER2
XTAP_TAPCELL_ROW_107_973 VDD VSS WELLTAP
XFILLER_53_741 VSS VDD FILLER2
XFILLER_16_45 VDD VSS FILLER1
XFILLER_52_262 VDD VSS FILLER4
X_09417_ _20065_/Q _16908_/C VDD VSS _18201_/B NAND2X1
XFILLER_13_638 VSS VDD FILLER2
XFILLER_52_284 VSS VDD FILLER2
XFILLER_52_295 VSS VDD FILLER2
XFILLER_40_446 VDD VSS FILLER4
XFILLER_12_148 VSS VDD FILLER2
XFILLER_40_457 VDD VSS FILLER1
X_09348_ _18457_/D _09347_/Y _09302_/A VDD VSS _18510_/D MUXI2X1
XFILLER_32_11 VSS VDD FILLER2
XFILLER_166_610 VDD VSS FILLER1
XFILLER_32_33 VDD VSS DECAPHV8
XFILLER_166_621 VSS VDD FILLER2
XFILLER_138_323 VSS VDD FILLER2
XTAP_TAPCELL_ROW_50_463 VDD VSS WELLTAP
XFILLER_32_55 VDD VSS FILLER1
X_09279_ output6/A hold260/Y wire168/Y VDD VSS hold261/A AOI2B1X1
XFILLER_148_44 VSS VDD FILLER2
XTAP_TAPCELL_ROW_3_37 VDD VSS WELLTAP
XFILLER_166_665 VSS VDD FILLER2
XFILLER_126_507 VDD VSS FILLER4
X_11310_ _11319_/A _11310_/B VDD VSS _11315_/B XNOR2X1
XFILLER_154_827 VSS VDD FILLER2
XFILLER_165_164 VSS VDD FILLER2
X_12290_ _12363_/A _12363_/B _12363_/C VDD VSS _12294_/B AOI21X1
XFILLER_148_99 VSS VDD FILLER2
X_11241_ _11241_/A _11241_/B VDD VSS _11264_/A NAND2X1
XFILLER_106_2 VDD VSS FILLER1
XFILLER_106_231 VDD VSS FILLER1
XFILLER_134_584 VSS VDD FILLER2
X_11172_ _11204_/A _11204_/B VDD VSS _11178_/D XOR2X1
XFILLER_122_735 VDD VSS FILLER4
XFILLER_106_297 VSS VDD FILLER2
X_10123_ _10123_/A _10123_/B _10123_/C VDD VSS _10126_/C OAI21X1
X_15980_ _19642_/Q _16797_/B VDD VSS _16833_/B XOR2X1
XFILLER_95_619 VDD VSS FILLER1
X_14931_ _14931_/A _14931_/B _14931_/C _14931_/D VDD VSS _15805_/B AOAI211X1
X_10054_ _18582_/Q _10054_/B VDD VSS _10079_/C NOR2BX1
XFILLER_76_822 VSS VDD FILLER2
XFILLER_48_535 VSS VDD FILLER2
XFILLER_76_855 VSS VDD FILLER2
XFILLER_57_63 VDD VSS FILLER4
XFILLER_57_74 VSS VDD FILLER2
X_14862_ _14911_/A _14911_/B _14911_/C VDD VSS _14887_/A AOI21X1
X_17650_ _17653_/C _17651_/B _17654_/C VDD VSS _17651_/C OAI21X1
XFILLER_57_85 VSS VDD FILLER2
XFILLER_57_96 VSS VDD FILLER2
XFILLER_91_825 VSS VDD FILLER2
X_16601_ _19925_/Q VDD VSS _16722_/A INVX1
X_13813_ _14196_/B _14196_/C _18946_/Q VDD VSS _13818_/B AOI21X1
XFILLER_91_836 VDD VSS FILLER1
X_17581_ _17581_/A _17581_/B _17581_/C VDD VSS _17589_/A OA21X2
XFILLER_29_782 VDD VSS FILLER4
X_14793_ _19475_/Q _15866_/B VDD VSS _14865_/B XNOR2X1
XFILLER_16_410 VSS VDD FILLER2
Xclkbuf_leaf_9__002_ clkbuf_leaf_9__002_/A VDD VSS _19946_/CK BUFX12
XFILLER_90_335 VDD VSS FILLER4
XFILLER_16_421 VSS VDD FILLER2
XFILLER_113_91 VSS VDD FILLER2
X_16532_ _16546_/B _16532_/B VDD VSS _16825_/B XNOR2X1
X_19320_ _19333_/CK _19320_/D _19320_/Q VDD VSS DFFQX1
XTAP_TAPCELL_ROW_122_1113 VDD VSS WELLTAP
XFILLER_90_357 VSS VDD FILLER2
X_13744_ _13872_/A _17920_/B _17921_/C VDD VSS _17925_/C OR3BX1
XFILLER_16_443 VDD VSS FILLER4
X_10956_ _18569_/Q VDD VSS _10957_/A INVX1
XFILLER_44_785 VDD VSS FILLER4
X_16463_ _19728_/Q _16892_/B VDD VSS _16465_/B XNOR2X1
X_19251_ _19988_/CK _19251_/D _19251_/Q VDD VSS DFFQX1
X_13675_ _13675_/A _13675_/B _13675_/C _13675_/D VDD VSS _13816_/B AOAI211X1
XFILLER_16_498 VDD VSS FILLER1
X_10887_ _18567_/Q _10887_/B VDD VSS _10888_/A NAND2X1
X_15414_ _19349_/Q _15723_/B VDD VSS _15456_/C NAND2X1
X_18202_ _18228_/E _18202_/B _18202_/C VDD VSS _18202_/Y OR3BX1
X_19182_ _19185_/CK _19182_/D _19182_/Q VDD VSS DFFQX1
X_12626_ _19073_/Q _14346_/B _14346_/C VDD VSS _12630_/D OR3BX1
X_16394_ _19565_/Q VDD VSS _16395_/A INVX1
XTAP_TAPCELL_ROW_13_132 VDD VSS WELLTAP
XFILLER_31_468 VDD VSS FILLER4
XFILLER_157_610 VDD VSS FILLER1
X_18133_ _19292_/Q _18133_/B VDD VSS _18136_/A NOR2BX1
XFILLER_8_620 VDD VSS FILLER1
XFILLER_129_334 VDD VSS DECAPHV8
X_15345_ _19403_/Q _15345_/B _15345_/C VDD VSS _15389_/A MIN3X1
XFILLER_156_120 VSS VDD FILLER2
XFILLER_129_345 VSS VDD FILLER2
X_12557_ _12557_/A _14378_/B _14378_/C VDD VSS _12558_/D NOR3X1
XFILLER_78_6 VSS VDD FILLER2
XFILLER_157_654 VSS VDD FILLER2
XFILLER_157_665 VDD VSS FILLER1
XFILLER_156_142 VSS VDD FILLER2
X_18064_ _18064_/A _18064_/B _18064_/C VDD VSS _18069_/A OAI21X1
X_11508_ _18662_/Q _11508_/B VDD VSS _18689_/D AND2X1
X_15276_ _19512_/Q _15276_/B VDD VSS _15311_/B NOR2X1
XFILLER_157_698 VSS VDD FILLER2
XFILLER_145_849 VSS VDD FILLER2
X_12488_ _19239_/Q _14533_/B VDD VSS _12571_/A NAND2X1
X_17015_ _19758_/Q VDD VSS _17180_/B INVX1
X_14227_ _14294_/A _14227_/B _14227_/C VDD VSS _18972_/D NOR3X1
XFILLER_125_540 VSS VDD FILLER2
X_11439_ _232_/E _11439_/B VDD VSS _18628_/D NOR2X1
XFILLER_113_702 VSS VDD FILLER2
XFILLER_140_510 VDD VSS FILLER1
X_14158_ _14158_/A _14158_/B VDD VSS _18913_/D AND2X1
XFILLER_113_735 VDD VSS DECAPHV8
XFILLER_152_381 VDD VSS FILLER4
XFILLER_113_757 VSS VDD FILLER2
X_13109_ _14446_/B _14446_/C _19162_/Q VDD VSS _13111_/C AOI21X1
XFILLER_3_391 VSS VDD FILLER2
X_18966_ _18997_/CK _18966_/D _18966_/Q VDD VSS DFFQX1
X_14089_ _14089_/A _14139_/B _14089_/C _14089_/D VDD VSS _14104_/B AOAI211X1
Xclkbuf_leaf_13__001_ clkload32/A VDD VSS _19059_/CK BUFX12
XFILLER_39_502 VDD VSS FILLER1
XFILLER_79_671 VSS VDD FILLER2
X_17917_ _17919_/C _17918_/B _17917_/C VDD VSS _17918_/C OAI21X1
XFILLER_39_524 VDD VSS FILLER1
X_18897_ _18924_/CK _18897_/D _18897_/Q VDD VSS DFFQX1
XFILLER_78_181 VSS VDD FILLER2
X_17848_ _18848_/Q VDD VSS _17853_/A INVX1
XFILLER_93_140 VSS VDD FILLER2
XFILLER_82_814 VDD VSS FILLER4
XFILLER_66_365 VSS VDD FILLER2
XFILLER_39_579 VSS VDD FILLER2
XFILLER_94_685 VDD VSS DECAPHV8
XFILLER_81_302 VDD VSS FILLER4
XFILLER_81_313 VSS VDD FILLER2
XFILLER_93_184 VSS VDD FILLER2
XFILLER_81_324 VSS VDD FILLER2
X_17779_ _17806_/A _17779_/B VDD VSS _19919_/D NOR2X1
Xclkbuf_leaf_28__001_ clkbuf_2_1__f__001_/Y VDD VSS _19068_/CK BUFX12
XTAP_TAPCELL_ROW_92_842 VDD VSS WELLTAP
X_19518_ _19737_/CK _19518_/D _19518_/Q VDD VSS DFFQX1
XFILLER_62_560 VSS VDD FILLER2
XFILLER_50_700 VSS VDD FILLER2
XTAP_TAPCELL_ROW_64_588 VDD VSS WELLTAP
X_19449_ _19478_/CK _19449_/D _19449_/Q VDD VSS DFFQX1
X_09202_ _18525_/Q VDD VSS _18440_/D INVX1
XFILLER_50_799 VDD VSS FILLER4
XFILLER_148_654 VSS VDD FILLER2
XFILLER_30_490 VSS VDD FILLER2
XFILLER_148_676 VSS VDD FILLER2
XFILLER_135_304 VDD VSS FILLER1
XFILLER_8_90 VDD VSS FILLER1
XFILLER_163_635 VSS VDD FILLER2
XFILLER_162_101 VDD VSS FILLER4
XFILLER_118_14 VSS VDD FILLER2
XFILLER_116_551 VDD VSS FILLER1
XFILLER_118_58 VDD VSS FILLER4
XFILLER_118_69 VSS VDD FILLER2
XFILLER_104_713 VDD VSS FILLER1
X_20224_ _20224_/A VDD VSS _20224_/Y BUFX3
XFILLER_143_370 VSS VDD FILLER2
XTAP_TAPCELL_ROW_151_1375 VDD VSS WELLTAP
X_20155_ _20155_/A VDD VSS _20155_/Y BUFX3
XFILLER_89_468 VSS VDD FILLER2
XFILLER_131_565 VSS VDD FILLER2
XFILLER_58_800 VSS VDD FILLER2
X_20086_ _20086_/A VDD VSS _20086_/Y BUFX3
X_09897_ _09869_/Y _09871_/Y _10966_/A VDD VSS _09897_/Y MUX2X1
XFILLER_27_11 VSS VDD FILLER2
XFILLER_45_505 VSS VDD FILLER2
XFILLER_85_674 VSS VDD FILLER2
XFILLER_27_33 VSS VDD FILLER2
XFILLER_73_836 VDD VSS FILLER1
XFILLER_17_218 VSS VDD FILLER2
XTAP_TAPCELL_ROW_55_511 VDD VSS WELLTAP
XFILLER_27_66 VDD VSS FILLER1
XFILLER_150_56 VSS VDD FILLER2
X_10810_ _10502_/B _10809_/Y _11120_/A VDD VSS _10816_/C MUXI2X1
XTAP_TAPCELL_ROW_162_1471 VDD VSS WELLTAP
X_11790_ _19117_/Q _11790_/B _11790_/C VDD VSS _11865_/B MIN3X1
XTAP_TAPCELL_ROW_27_257 VDD VSS WELLTAP
Xclkbuf_1_0__f__09180_ clkbuf_0__09180_/Y VDD VSS _18628_/CK BUFX12
XFILLER_41_711 VSS VDD FILLER2
XFILLER_26_785 VDD VSS FILLER4
XFILLER_53_582 VDD VSS FILLER4
X_10741_ _18563_/Q _10743_/B _10743_/C VDD VSS _10742_/B XNOR3X1
XFILLER_9_406 VDD VSS FILLER1
XFILLER_43_54 VSS VDD FILLER2
XFILLER_13_468 VSS VDD FILLER2
X_13460_ _19195_/Q VDD VSS _13559_/C INVX1
X_10672_ _10709_/A _10709_/B _11127_/A VDD VSS _10703_/A OAI21X1
XFILLER_43_87 VDD VSS FILLER4
XFILLER_40_265 VSS VDD FILLER2
X_12411_ _20004_/Q _19268_/Q VDD VSS _12583_/A AND2X1
XFILLER_139_654 VSS VDD FILLER2
X_13391_ _13391_/A _13391_/B _13391_/C _13391_/D VDD VSS _13516_/B AOAI211X1
XTAP_TAPCELL_ROW_10_102 VDD VSS WELLTAP
XFILLER_138_142 VSS VDD FILLER2
XFILLER_139_676 VDD VSS FILLER1
X_15130_ _15297_/A _18100_/B VDD VSS _19286_/D AND2X1
X_12342_ _18931_/Q _14179_/B _12353_/C VDD VSS _14147_/B XNOR3X1
XFILLER_5_623 VSS VDD FILLER2
XFILLER_111_0 VSS VDD FILLER2
XFILLER_126_337 VSS VDD FILLER2
XFILLER_153_123 VSS VDD FILLER2
X_15061_ _19535_/Q _15146_/C VDD VSS _15902_/B XNOR2X1
X_12273_ _18930_/Q VDD VSS _12341_/A INVX1
XFILLER_5_656 VDD VSS FILLER1
XFILLER_154_679 VDD VSS FILLER1
XFILLER_153_178 VSS VDD FILLER2
X_14012_ _14268_/A _14268_/B _19006_/Q VDD VSS _14013_/D OAI21X1
X_11224_ _18683_/Q _18791_/Q _11224_/C VDD VSS _11226_/B MIN3X1
XFILLER_122_510 VDD VSS FILLER1
XFILLER_134_370 VDD VSS FILLER4
XFILLER_153_189 VDD VSS DECAPHV16
XFILLER_122_521 VSS VDD FILLER2
XFILLER_150_830 VSS VDD FILLER2
XFILLER_4_59 VSS VDD FILLER2
X_18820_ _18823_/CK _18820_/D _18820_/Q VDD VSS DFFQX1
XFILLER_1_840 VSS VDD FILLER2
X_11155_ _18575_/Q _11158_/C VDD VSS _11156_/B XNOR2X1
XFILLER_1_851 VSS VDD FILLER2
X_10106_ _10059_/B _10105_/Y _10167_/A VDD VSS _10191_/B MUXI2X1
X_18751_ _19947_/CK _18751_/D _18751_/Q VDD VSS DFFQX1
X_15963_ _15963_/A _19901_/Q _15963_/C VDD VSS _15965_/A MIN3X1
X_11086_ _11086_/A _11086_/B _11086_/C VDD VSS _11088_/C AOI21X1
XFILLER_48_332 VDD VSS FILLER1
X_17702_ _17700_/B _17702_/B VDD VSS _17703_/C NOR2BX1
X_14914_ _14920_/A _15833_/B _14920_/C VDD VSS _15834_/C OR3X2
X_10037_ _18603_/Q _10050_/C VDD VSS _10038_/B XNOR2X1
X_15894_ _15895_/A _15894_/B VDD VSS _19501_/D NOR2X1
X_18682_ _18845_/CK _18682_/D _18682_/Q VDD VSS DFFQX1
XFILLER_48_365 VDD VSS FILLER1
XFILLER_64_825 VSS VDD FILLER2
XFILLER_48_387 VDD VSS FILLER4
X_17633_ _19888_/Q _19856_/Q VDD VSS _17638_/A XNOR2X1
X_14845_ _14858_/B _14845_/B VDD VSS _15739_/B XNOR2X1
XFILLER_75_184 VSS VDD FILLER2
XFILLER_91_644 VDD VSS FILLER4
XFILLER_75_195 VSS VDD FILLER2
XFILLER_91_677 VDD VSS FILLER1
X_14776_ _14776_/A _14776_/B _15830_/B VDD VSS _14818_/A MIN3X1
X_17564_ _17567_/C _17565_/B _17597_/C VDD VSS _17565_/C OAI21X1
X_11988_ _11988_/A _12055_/B VDD VSS _14527_/B XNOR2X1
XFILLER_51_519 VDD VSS FILLER1
XFILLER_32_700 VSS VDD FILLER2
X_19303_ _19331_/CK _19303_/D _19303_/Q VDD VSS DFFQX1
X_16515_ _16511_/B _16515_/B _16515_/C VDD VSS _16540_/A AOI2B1X1
X_13727_ _13727_/A _14326_/B _13728_/C VDD VSS _14327_/B AOI21BX1
XFILLER_90_187 VDD VSS FILLER4
X_10939_ _10940_/A _10940_/B _10940_/D _10940_/C VDD VSS _10942_/C AOAI211X1
XFILLER_90_198 VSS VDD FILLER2
X_17495_ _17496_/A _17496_/B _17496_/D _17496_/C VDD VSS _17498_/C AOI211X1
XFILLER_149_407 VSS VDD FILLER2
XTAP_TAPCELL_ROW_61_558 VDD VSS WELLTAP
XTAP_TAPCELL_ROW_101_924 VDD VSS WELLTAP
X_19234_ _20000_/CK _19234_/D _19234_/Q VDD VSS DFFQX1
X_16446_ _19631_/Q _16785_/B VDD VSS _16447_/A NAND2BX1
X_13658_ _13672_/A _13748_/B _13746_/C VDD VSS _13807_/B XNOR3X1
X_12609_ _18905_/Q _12609_/B _14149_/B VDD VSS _14117_/B XNOR3X1
X_16377_ _16392_/B _16377_/B VDD VSS _16819_/B XOR2X1
X_19165_ _19166_/CK _19165_/D _19165_/Q VDD VSS DFFQX1
X_13589_ _13656_/A _13656_/B _13656_/E _13589_/D VDD VSS _14162_/C OAOI211X1
XFILLER_157_451 VSS VDD FILLER2
XFILLER_157_462 VSS VDD FILLER2
X_15328_ _19403_/Q _15784_/B VDD VSS _15329_/B XOR2X1
X_18116_ _18163_/A _18121_/B VDD VSS _18116_/Y NOR2X1
XFILLER_117_315 VDD VSS FILLER4
X_19096_ _19126_/CK _19096_/D _19096_/Q VDD VSS DFFQX1
XFILLER_69_2 VDD VSS FILLER1
XFILLER_117_359 VSS VDD FILLER2
X_15259_ _19317_/Q _15259_/B _15259_/C VDD VSS _15335_/A MIN3X1
X_18047_ _18056_/A _18047_/B _18056_/C VDD VSS _19981_/D OAI21X1
XFILLER_99_700 VDD VSS FILLER4
XFILLER_99_711 VSS VDD FILLER2
XFILLER_160_649 VDD VSS FILLER1
XFILLER_153_690 VDD VSS FILLER4
X_09820_ _17906_/C VDD VSS _14522_/A BUFX3
XFILLER_99_777 VDD VSS FILLER4
XFILLER_59_619 VDD VSS DECAPHV8
X_19998_ _20000_/CK _19998_/D _19998_/Q VDD VSS DFFQX1
XFILLER_86_416 VSS VDD FILLER2
XFILLER_140_384 VSS VDD FILLER2
Xclkbuf_0__09174_ _18223_/ECK VDD VSS clkbuf_0__09174_/Y BUFX12
X_09751_ _18451_/Q _09751_/B _09751_/C _09751_/D VDD VSS _09754_/C OAI211X1
X_18949_ _19059_/CK _18949_/D _18949_/Q VDD VSS DFFQX1
XTAP_TAPCELL_ROW_69_636 VDD VSS WELLTAP
XFILLER_39_310 VSS VDD FILLER2
XFILLER_79_490 VDD VSS FILLER1
XFILLER_104_16 VDD VSS FILLER4
X_09682_ _09753_/D _09682_/B _09682_/C _09819_/A _09682_/E VDD VSS _18286_/D OAI221X1
XFILLER_67_663 VSS VDD FILLER2
XFILLER_104_49 VSS VDD FILLER2
XFILLER_55_825 VDD VSS FILLER4
XFILLER_66_162 VSS VDD FILLER2
XFILLER_54_302 VDD VSS FILLER4
XFILLER_27_538 VDD VSS DECAPHV16
XFILLER_54_335 VSS VDD FILLER2
XFILLER_81_154 VDD VSS FILLER1
XFILLER_82_688 VDD VSS FILLER4
XFILLER_120_15 VDD VSS DECAPHV8
XFILLER_35_582 VSS VDD FILLER2
XFILLER_81_198 VDD VSS FILLER4
XTAP_TAPCELL_ROW_24_227 VDD VSS WELLTAP
XFILLER_23_799 VDD VSS FILLER4
XFILLER_22_265 VSS VDD FILLER2
XFILLER_10_416 VSS VDD FILLER2
XFILLER_50_585 VSS VDD FILLER2
XFILLER_10_427 VSS VDD FILLER2
XFILLER_148_451 VSS VDD FILLER2
XFILLER_129_35 VDD VSS FILLER1
XFILLER_136_602 VSS VDD FILLER2
XFILLER_129_46 VSS VDD FILLER2
XFILLER_148_484 VDD VSS FILLER4
XFILLER_135_101 VDD VSS FILLER4
XFILLER_163_410 VSS VDD FILLER2
XFILLER_135_112 VSS VDD FILLER2
XFILLER_129_79 VDD VSS FILLER4
XFILLER_136_646 VSS VDD FILLER2
XFILLER_163_443 VSS VDD FILLER2
XFILLER_151_605 VDD VSS FILLER4
XFILLER_2_615 VSS VDD FILLER2
XFILLER_135_189 VSS VDD FILLER2
XFILLER_151_649 VSS VDD FILLER2
XTAP_TAPCELL_ROW_0_16 VDD VSS WELLTAP
XFILLER_116_381 VDD VSS FILLER4
XFILLER_144_690 VDD VSS FILLER4
XFILLER_145_34 VDD VSS FILLER4
XFILLER_1_114 VSS VDD FILLER2
XFILLER_2_648 VSS VDD FILLER2
XFILLER_1_136 VSS VDD FILLER2
XFILLER_145_56 VDD VSS FILLER4
X_20207_ _20207_/A VDD VSS _20207_/Y BUFX3
XFILLER_1_158 VSS VDD FILLER2
XFILLER_131_362 VDD VSS DECAPHV8
XFILLER_89_276 VSS VDD FILLER2
Xclkbuf_regs_1_sclk delaybuf_5_sclk/Y VDD VSS clkbuf_regs_1_sclk/Y BUFX12
X_20138_ _20138_/A VDD VSS _20138_/Y BUFX3
X_09949_ _09867_/Y _09948_/Y _11178_/C VDD VSS _09949_/Y MUX2X1
XFILLER_89_298 VSS VDD FILLER2
XFILLER_161_11 VSS VDD FILLER2
XFILLER_161_22 VSS VDD FILLER2
X_20069_ clkload6/A _20069_/D _20069_/Q _20071_/RB VDD VSS DFFRQX1
X_12960_ _13255_/A _13150_/B VDD VSS _13047_/C AND2X1
XFILLER_58_663 VDD VSS FILLER4
XFILLER_57_140 VDD VSS FILLER1
XFILLER_100_782 VSS VDD FILLER2
X_11911_ _11912_/B _11912_/C _19148_/Q VDD VSS _11973_/B AOI21X1
XFILLER_100_793 VSS VDD FILLER2
XFILLER_57_184 VSS VDD FILLER2
XFILLER_45_324 VDD VSS DECAPHV8
XFILLER_161_77 VDD VSS FILLER4
X_12891_ _12891_/A _12891_/B _12891_/C VDD VSS _13171_/A OA21X2
X_14630_ _19470_/Q _14671_/B _14671_/C VDD VSS _14640_/C XNOR3X1
XFILLER_61_806 VSS VDD FILLER2
X_11842_ _19994_/Q _19258_/Q VDD VSS _11881_/B NAND2X1
XFILLER_33_508 VDD VSS DECAPHV8
XFILLER_61_828 VSS VDD FILLER2
XFILLER_45_379 VSS VDD FILLER2
XFILLER_14_700 VSS VDD FILLER2
XFILLER_60_316 VSS VDD FILLER2
X_14561_ _20000_/Q _14569_/B VDD VSS _19264_/D AND2X1
XFILLER_159_0 VDD VSS FILLER1
X_11773_ _11778_/A _11778_/B _11778_/D _11778_/C VDD VSS _14521_/C OAI211X1
XFILLER_53_390 VSS VDD FILLER2
XFILLER_13_232 VDD VSS FILLER4
XFILLER_159_716 VDD VSS DECAPHV8
X_16300_ _19722_/Q _16886_/B VDD VSS _16302_/C XNOR2X1
X_13512_ _14260_/B _14260_/C _18998_/Q VDD VSS _13594_/B AO21X2
X_17280_ _19812_/Q _19780_/Q VDD VSS _17281_/C NAND2X1
X_10724_ _10725_/A _10725_/C _10725_/B VDD VSS _10749_/B AO21X2
XFILLER_158_215 VSS VDD FILLER2
X_14492_ _14491_/Y _14492_/B _14492_/C VDD VSS _19203_/D AND3BX1
XFILLER_9_203 VSS VDD FILLER2
XFILLER_159_749 VDD VSS FILLER1
XFILLER_110_70 VSS VDD FILLER2
XFILLER_14_799 VSS VDD FILLER2
X_16231_ _19623_/Q _16231_/B _16777_/B VDD VSS _16255_/B MIN3X1
Xclkbuf_leaf_12__002_ clkbuf_leaf_9__002_/A VDD VSS _18831_/CK BUFX12
X_13443_ _13443_/A _13443_/B _13443_/C _13443_/D VDD VSS _13459_/B AOAI211X1
XFILLER_139_440 VSS VDD FILLER2
X_10655_ _10655_/A VDD VSS _10947_/A BUFX3
XFILLER_9_247 VDD VSS FILLER1
XFILLER_127_602 VSS VDD FILLER2
X_16162_ _19589_/Q _16739_/B VDD VSS _16182_/B XNOR2X1
Xclkload17 _18818_/CK VDD VSS clkload17/Y INVX1
X_13374_ _13509_/A _13509_/C VDD VSS _13375_/C NAND2X1
XFILLER_127_635 VSS VDD FILLER2
Xclkload28 _18801_/CK VDD VSS clkload28/Y INVX1
X_10586_ _10625_/A _10880_/B _10586_/C VDD VSS _10596_/B AOI21X1
XFILLER_166_281 VDD VSS FILLER1
XFILLER_154_421 VSS VDD FILLER2
XFILLER_126_134 VDD VSS FILLER4
X_15113_ _15198_/B _15840_/B _19454_/Q VDD VSS _15139_/D NAND3BX1
Xclkload39 _19191_/CK VDD VSS clkload39/Y INVX2
X_12325_ _19239_/Q _12577_/A _12499_/B VDD VSS _12391_/D XNOR3X1
X_16093_ _16108_/B _16093_/B VDD VSS _16807_/B XNOR2X1
XFILLER_127_679 VDD VSS FILLER1
XTAP_TAPCELL_ROW_117_1067 VDD VSS WELLTAP
XFILLER_5_464 VDD VSS FILLER1
X_15044_ _15044_/A _15807_/B VDD VSS _15069_/A OR2X2
X_19921_ _19924_/CK _19921_/D _19921_/Q VDD VSS DFFQX1
XFILLER_5_475 VSS VDD FILLER2
XFILLER_107_370 VSS VDD FILLER2
X_12256_ _19096_/Q _14373_/B VDD VSS _12257_/C _14373_/C AND3X2
XFILLER_141_126 VSS VDD FILLER2
XFILLER_142_649 VDD VSS FILLER1
X_11207_ _11229_/A _11207_/B VDD VSS _11208_/E NOR2X1
X_19852_ _19880_/CK _19852_/D _19852_/Q VDD VSS DFFQX1
XFILLER_150_660 VSS VDD FILLER2
X_12187_ _19040_/Q VDD VSS _12189_/A INVX1
XFILLER_68_416 VSS VDD FILLER2
X_18803_ _18831_/CK _18803_/D _18803_/Q VDD VSS DFFQX1
X_11138_ _11138_/A _11138_/B _11229_/A VDD VSS _11144_/B AOI21X1
XFILLER_1_681 VSS VDD FILLER2
X_19783_ _19853_/CK _19783_/D _19783_/Q VDD VSS DFFQX1
XFILLER_110_546 VDD VSS DECAPHV8
X_16995_ _19752_/Q _19753_/Q _17011_/B VDD VSS _16996_/C OAI21X1
XFILLER_96_769 VSS VDD FILLER2
XFILLER_49_630 VSS VDD FILLER2
XFILLER_95_246 VSS VDD FILLER2
XFILLER_110_568 VDD VSS FILLER4
X_18734_ _18785_/CK _18734_/D _18734_/Q VDD VSS DFFQX1
X_15946_ _15969_/A _15946_/B VDD VSS _16802_/B XNOR2X1
X_11069_ _19959_/Q _18841_/Q VDD VSS _11072_/A XNOR2X1
XTAP_TAPCELL_ROW_66_606 VDD VSS WELLTAP
XFILLER_64_622 VDD VSS FILLER4
X_18665_ _18801_/CK _18665_/D _18665_/Q VDD VSS DFFQX1
XTAP_TAPCELL_ROW_128_1163 VDD VSS WELLTAP
X_15877_ _15879_/A _15877_/B VDD VSS _19485_/D AND2X1
XFILLER_64_644 VSS VDD FILLER2
XFILLER_63_121 VDD VSS FILLER1
X_17616_ _19884_/Q _19852_/Q VDD VSS _17618_/D XNOR2X1
XFILLER_91_452 VSS VDD FILLER2
X_14828_ _19530_/Q _14828_/B VDD VSS _15897_/B XOR2X1
X_18596_ _18622_/CK _18596_/D _18596_/Q VDD VSS DFFQX1
XFILLER_51_316 VDD VSS FILLER4
XTAP_TAPCELL_ROW_74_683 VDD VSS WELLTAP
X_17547_ _19869_/Q _19837_/Q _17547_/C VDD VSS _17551_/B AOI21X1
X_14759_ _14759_/A _14772_/C VDD VSS _15737_/B XNOR2X1
XFILLER_44_390 VDD VSS FILLER4
XFILLER_32_541 VDD VSS FILLER1
X_17478_ _19854_/Q VDD VSS _17629_/B INVX1
XFILLER_32_585 VDD VSS FILLER1
XFILLER_20_725 VDD VSS FILLER4
X_19217_ _19217_/CK _19217_/D _19217_/Q VDD VSS DFFQX1
XFILLER_165_708 VSS VDD FILLER2
X_16429_ _16429_/A _16429_/B _16429_/C VDD VSS _16430_/B NOR3X1
XFILLER_74_0 VSS VDD FILLER2
X_19148_ _19166_/CK _19148_/D _19148_/Q VDD VSS DFFQX1
XFILLER_158_793 VSS VDD FILLER2
XFILLER_9_792 VSS VDD FILLER2
XFILLER_145_454 VDD VSS FILLER4
X_19079_ _19134_/CK _19079_/D _19079_/Q VDD VSS DFFQX1
XFILLER_133_616 VSS VDD FILLER2
XFILLER_117_189 VSS VDD FILLER2
XFILLER_133_638 VDD VSS FILLER4
XFILLER_133_649 VSS VDD FILLER2
XFILLER_132_137 VSS VDD FILLER2
XFILLER_132_159 VDD VSS DECAPHV16
Xfanout204 _20067_/RB VDD VSS _20065_/RB BUFX3
XFILLER_5_91 VSS VDD FILLER2
Xfanout215 _18373_/RB VDD VSS _18374_/RB BUFX3
XFILLER_101_502 VSS VDD FILLER2
Xfanout226 _18405_/RB VDD VSS _18503_/RB BUFX3
XFILLER_99_585 VDD VSS DECAPHV8
X_09803_ _09803_/A _09803_/B _09802_/Y VDD VSS _09804_/E AOI21BX1
XFILLER_99_596 VSS VDD FILLER2
XFILLER_141_693 VDD VSS FILLER1
XFILLER_87_747 VSS VDD FILLER2
XFILLER_140_170 VSS VDD FILLER2
XFILLER_113_395 VDD VSS FILLER1
XFILLER_115_48 VSS VDD FILLER2
XFILLER_86_235 VSS VDD FILLER2
XFILLER_87_769 VSS VDD FILLER2
X_09734_ _18450_/Q VDD VSS _20162_/A INVX1
XFILLER_28_803 VSS VDD FILLER2
XFILLER_55_600 VSS VDD FILLER2
XFILLER_67_482 VDD VSS DECAPHV16
XFILLER_27_313 VSS VDD FILLER2
X_09665_ _18236_/Q _09818_/B _09818_/C _18265_/Q _09665_/E VDD VSS _09666_/B AOI221X1
XFILLER_39_184 VSS VDD FILLER2
XFILLER_27_335 VDD VSS FILLER4
X_09596_ _20164_/A _09784_/C _09815_/C _18313_/Q VDD VSS _09597_/E AOI22X1
XFILLER_27_379 VDD VSS FILLER1
XFILLER_131_69 VSS VDD FILLER2
XFILLER_70_636 VSS VDD FILLER2
XFILLER_54_187 VDD VSS FILLER4
XFILLER_54_198 VDD VSS FILLER4
XFILLER_50_371 VSS VDD FILLER2
XFILLER_11_747 VSS VDD FILLER2
XFILLER_10_235 VDD VSS FILLER4
XFILLER_155_207 VSS VDD FILLER2
XFILLER_149_782 VDD VSS FILLER1
XFILLER_10_268 VSS VDD FILLER2
X_10440_ _10476_/D VDD VSS _10441_/D INVX1
XFILLER_40_11 VSS VDD FILLER2
XFILLER_136_421 VSS VDD FILLER2
XFILLER_6_239 VSS VDD FILLER2
XFILLER_40_44 VSS VDD FILLER2
XFILLER_109_668 VSS VDD FILLER2
X_10371_ _18632_/Q _18794_/Q VDD VSS _10399_/A NAND2X1
XFILLER_108_156 VSS VDD FILLER2
X_12110_ _12222_/A _12236_/A _12233_/C VDD VSS _12158_/C XNOR3X1
XFILLER_40_88 VSS VDD FILLER2
XFILLER_136_498 VDD VSS FILLER4
X_13090_ _13192_/A _13192_/B _13192_/C VDD VSS _13168_/B AOI21X1
XFILLER_156_77 VSS VDD FILLER2
XFILLER_163_295 VSS VDD FILLER2
Xclkbuf_2_2__f__001_ clkbuf_0__001_/Y VDD VSS clkload32/A BUFX12
XFILLER_2_445 VDD VSS FILLER1
XFILLER_151_468 VSS VDD FILLER2
X_12041_ _12155_/A _14433_/B VDD VSS _12060_/B NOR2X1
XFILLER_104_340 VDD VSS FILLER1
XFILLER_2_456 VSS VDD FILLER2
XFILLER_78_714 VSS VDD FILLER2
XFILLER_132_682 VDD VSS FILLER1
XFILLER_77_202 VDD VSS FILLER4
X_15800_ _15800_/A _15800_/B VDD VSS _19418_/D NOR2X1
XFILLER_77_257 VSS VDD FILLER2
X_16780_ _16794_/A _16780_/B VDD VSS _19626_/D NOR2X1
X_13992_ _13993_/A _13993_/B _13993_/D _13993_/C VDD VSS _14169_/B OAOI211X1
XFILLER_92_205 VSS VDD FILLER2
XFILLER_93_739 VDD VSS FILLER4
XFILLER_58_460 VSS VDD FILLER2
X_15731_ _15739_/A _15731_/B VDD VSS _19356_/D NOR2X1
X_12943_ _13041_/A _14413_/B VDD VSS _12973_/B NOR2X1
XFILLER_65_74 VDD VSS DECAPHV16
X_18450_ _18455_/CK _18450_/D _18450_/Q _18450_/RB VDD VSS DFFRQX1
XFILLER_73_463 VSS VDD FILLER2
X_15662_ _19358_/Q _15733_/B _15662_/C VDD VSS _15703_/B MIN3X1
X_12874_ _12903_/A _12903_/B _12903_/D _12903_/C VDD VSS _12890_/C AOAI211X1
XFILLER_46_688 VSS VDD FILLER2
XFILLER_65_96 VSS VDD FILLER2
X_17401_ _17675_/A _17401_/B VDD VSS _19838_/D NOR2X1
X_14613_ _19441_/Q _14613_/B _14613_/C VDD VSS _14672_/B MIN3X1
X_11825_ _19174_/Q _14460_/B VDD VSS _11874_/C _14460_/C NAND3X1
XFILLER_45_198 VDD VSS FILLER4
X_15593_ _19354_/Q _15729_/B _15593_/C VDD VSS _15617_/A AOI21X1
X_18381_ _18391_/CK _18514_/Q _20186_/A _20067_/RB VDD VSS DFFRQX1
XFILLER_121_91 VSS VDD FILLER2
XTAP_TAPCELL_ROW_71_653 VDD VSS WELLTAP
X_17332_ _17334_/C _17332_/B _17332_/C VDD VSS _19823_/D AOI21X1
X_14544_ _14544_/A _14544_/B _15836_/C VDD VSS _19249_/D OA21X2
X_11756_ _11758_/A _11758_/B _14426_/B VDD VSS _14394_/B XNOR3X1
X_10707_ _18562_/Q _10707_/B VDD VSS _10708_/C AND2X1
XTAP_TAPCELL_ROW_43_399 VDD VSS WELLTAP
X_17263_ _17413_/B _17263_/B _17263_/C VDD VSS _17267_/C MIN3X1
X_14475_ _14490_/A _14475_/B _14475_/C VDD VSS _19188_/D NOR3X1
X_11687_ _19144_/Q VDD VSS _11758_/A INVX1
X_19002_ _19059_/CK _19002_/D _19002_/Q VDD VSS DFFQX1
XFILLER_146_229 VSS VDD FILLER2
X_16214_ _19623_/Q _16777_/B VDD VSS _16215_/B XNOR2X1
X_13426_ _13437_/A _13437_/B _13437_/C VDD VSS _14358_/C NOR3X1
X_17194_ _17197_/A _17194_/B _17194_/C VDD VSS _19793_/D AOI21X1
X_10638_ _10638_/A _10638_/B _10638_/C _10638_/D VDD VSS _10687_/C AOI31X1
Xclkload106 _18622_/CK VDD VSS clkload106/Y BUFX12
Xclkload117 _18327_/CK VDD VSS clkload117/Y INVX2
X_16145_ _19684_/Q _16845_/B VDD VSS _16152_/B XNOR2X1
XFILLER_127_454 VDD VSS FILLER4
X_13357_ _13430_/A _13430_/B VDD VSS _14417_/C _13430_/C NAND3X1
X_10569_ _10570_/A _10570_/B _10570_/D _10570_/C VDD VSS _10638_/B AOAI211X1
XFILLER_6_762 VSS VDD FILLER2
XFILLER_154_251 VSS VDD FILLER2
XFILLER_115_616 VDD VSS FILLER4
XFILLER_115_627 VSS VDD FILLER2
X_12308_ _12471_/A _12471_/B _12471_/C VDD VSS _12333_/B AOI21X1
X_16076_ _16076_/A _16079_/B VDD VSS _16077_/B XOR2X1
X_13288_ _18885_/Q _13288_/B _13288_/C VDD VSS _13486_/B MIN3X1
XFILLER_114_137 VSS VDD FILLER2
XFILLER_142_446 VSS VDD FILLER2
XFILLER_142_457 VSS VDD FILLER2
X_15027_ _15041_/A _15041_/B VDD VSS _15744_/B XNOR2X1
X_19904_ _19924_/CK _19904_/D _19904_/Q VDD VSS DFFQX1
X_12239_ _12239_/A _14499_/B _12239_/C _12239_/D VDD VSS _12391_/B AOAI211X1
XFILLER_69_714 VSS VDD FILLER2
XFILLER_96_522 VDD VSS FILLER4
XFILLER_68_213 VSS VDD FILLER2
X_19835_ _19895_/CK _19835_/D _19835_/Q VDD VSS DFFQX1
XTAP_TAPCELL_ROW_79_720 VDD VSS WELLTAP
XFILLER_69_747 VSS VDD FILLER2
XFILLER_68_235 VSS VDD FILLER2
XFILLER_110_332 VSS VDD FILLER2
XFILLER_96_566 VDD VSS FILLER4
X_19766_ clkload3/A _19766_/D _19766_/Q VDD VSS DFFQX1
X_16978_ _19751_/Q _16978_/B VDD VSS _16984_/B XOR2X1
Xinput4 input4/A VDD VSS input4/Y BUFX3
X_18717_ _18773_/CK _18717_/D _18717_/Q VDD VSS DFFQX1
X_15929_ _15929_/A _15929_/B VDD VSS _16763_/B XNOR2X1
XFILLER_36_110 VDD VSS FILLER4
X_19697_ _19702_/CK _19697_/D _19697_/Q VDD VSS DFFQX1
XFILLER_37_644 VDD VSS FILLER4
XFILLER_37_666 VSS VDD FILLER2
XFILLER_25_806 VSS VDD FILLER2
X_09450_ _19965_/Q _09467_/B _09483_/B VDD VSS _09451_/C AOI21X1
X_18648_ _19954_/CK _18648_/D _18648_/Q VDD VSS DFFQX1
XFILLER_52_603 VDD VSS FILLER1
XFILLER_91_260 VSS VDD FILLER2
XFILLER_64_485 VSS VDD FILLER2
XFILLER_91_282 VSS VDD FILLER2
X_09381_ _18624_/Q _18623_/Q VDD VSS _10274_/B NOR2BX1
X_18579_ _18583_/CK _18579_/D _18579_/Q VDD VSS DFFQX1
XTAP_TAPCELL_ROW_34_322 VDD VSS WELLTAP
XFILLER_52_658 VSS VDD FILLER2
XFILLER_137_207 VSS VDD FILLER2
XFILLER_20_566 VSS VDD FILLER2
XFILLER_165_538 VSS VDD FILLER2
XFILLER_118_421 VSS VDD FILLER2
XFILLER_118_454 VDD VSS FILLER4
XFILLER_161_700 VSS VDD FILLER2
XFILLER_145_251 VSS VDD FILLER2
XFILLER_161_711 VDD VSS FILLER1
XFILLER_105_104 VDD VSS FILLER1
XFILLER_161_722 VDD VSS FILLER1
XFILLER_160_221 VSS VDD FILLER2
XFILLER_126_25 VSS VDD FILLER2
XFILLER_126_36 VDD VSS FILLER1
XFILLER_161_766 VSS VDD FILLER2
XFILLER_133_468 VDD VSS DECAPHV8
XFILLER_87_500 VSS VDD FILLER2
XFILLER_161_799 VDD VSS FILLER4
XFILLER_114_693 VDD VSS FILLER4
XFILLER_141_490 VSS VDD FILLER2
XFILLER_87_544 VSS VDD FILLER2
XFILLER_59_257 VSS VDD FILLER2
XFILLER_75_717 VSS VDD FILLER2
XFILLER_47_408 VSS VDD FILLER2
XTAP_TAPCELL_ROW_148_1347 VDD VSS WELLTAP
XFILLER_87_577 VSS VDD FILLER2
XFILLER_101_365 VDD VSS FILLER1
X_09717_ _09753_/A _09717_/B _09717_/C _09717_/D VDD VSS _18288_/D OAI211X1
XFILLER_28_622 VDD VSS FILLER4
XFILLER_55_430 VDD VSS DECAPHV8
XTAP_TAPCELL_ROW_85_778 VDD VSS WELLTAP
XFILLER_27_143 VDD VSS FILLER4
X_09648_ _20105_/A _09729_/D VDD VSS _09649_/C NOR2BX1
XFILLER_83_794 VSS VDD FILLER2
XFILLER_55_496 VDD VSS FILLER1
X_09579_ _09782_/B VDD VSS _09812_/B BUFX3
XFILLER_43_658 VSS VDD FILLER2
XFILLER_43_669 VSS VDD FILLER2
XFILLER_150_4 VSS VDD FILLER2
X_11610_ _18754_/Q _11612_/B VDD VSS _18781_/D AND2X1
X_12590_ _19158_/Q _12771_/A _12655_/C VDD VSS _12643_/D XNOR3X1
XTAP_TAPCELL_ROW_159_1443 VDD VSS WELLTAP
X_11541_ _18692_/Q _11542_/B VDD VSS _18719_/D AND2X1
XFILLER_129_719 VDD VSS FILLER4
X_14260_ _14255_/Y _14260_/B _14260_/C VDD VSS _18998_/D AND3BX1
XTAP_TAPCELL_ROW_40_369 VDD VSS WELLTAP
X_11472_ _19963_/Q _11473_/B VDD VSS _18656_/D AND2X1
XFILLER_7_548 VDD VSS DECAPHV8
XFILLER_109_443 VDD VSS FILLER4
X_13211_ _13211_/A _14385_/B _14385_/C VDD VSS _13212_/D NOR3X1
X_10423_ _10655_/A _10500_/B VDD VSS _10424_/D NOR2X1
X_14191_ _14197_/A _14191_/B VDD VSS _18941_/D AND2X1
XFILLER_152_700 VSS VDD FILLER2
XFILLER_136_262 VSS VDD FILLER2
Xdelaybuf_5_clk clk VDD VSS delaybuf_6_clk/A BUFX12
XFILLER_164_582 VSS VDD FILLER2
XFILLER_136_284 VDD VSS FILLER1
X_13142_ _13329_/A _13329_/B VDD VSS _13155_/B NAND2X1
XFILLER_3_710 VDD VSS FILLER4
X_10354_ _10427_/C _10354_/B VDD VSS _10357_/C XOR2X1
XFILLER_152_744 VSS VDD FILLER2
XTAP_TAPCELL_ROW_114_1037 VDD VSS WELLTAP
XFILLER_4_0 VDD VSS FILLER1
XFILLER_151_254 VSS VDD FILLER2
X_17950_ _17958_/A _17958_/B VDD VSS _17955_/A OR2X2
X_13073_ _13083_/A _13083_/B VDD VSS _14189_/B XOR2X1
X_10285_ _18631_/Q _18793_/Q VDD VSS _10338_/B XNOR2X1
XFILLER_152_799 VDD VSS FILLER1
XFILLER_105_682 VSS VDD FILLER2
X_16901_ _16976_/A _16901_/B VDD VSS _19736_/D NOR2X1
X_12024_ _19094_/Q _12024_/B _12079_/C VDD VSS _12255_/B MIN3X1
X_17881_ _18854_/Q VDD VSS _17885_/A INVX1
XFILLER_104_192 VSS VDD FILLER2
X_19620_ _19696_/CK _19620_/D _19620_/Q VDD VSS DFFQX1
X_16832_ _16838_/A _16832_/B VDD VSS _19673_/D NOR2X1
XTAP_TAPCELL_ROW_76_701 VDD VSS WELLTAP
XFILLER_120_696 VDD VSS FILLER1
X_19551_ _19602_/CK _19551_/D _19551_/Q VDD VSS DFFQX1
X_16763_ _16775_/A _16763_/B VDD VSS _19611_/D NOR2X1
XFILLER_19_644 VDD VSS FILLER4
X_13975_ _17945_/B _17945_/C VDD VSS _17949_/B XNOR2X1
XTAP_TAPCELL_ROW_48_447 VDD VSS WELLTAP
XFILLER_46_441 VDD VSS FILLER1
X_18502_ _18503_/CK _18523_/Q _20115_/A _18503_/RB VDD VSS DFFRQX1
X_15714_ _15725_/A _15714_/B VDD VSS _19340_/D AND2X1
XFILLER_34_603 VDD VSS FILLER1
X_19482_ _19484_/CK _19482_/D _19482_/Q VDD VSS DFFQX1
X_12926_ _13023_/A _14382_/B VDD VSS _14383_/C _13023_/C NAND3X1
XFILLER_80_219 VDD VSS FILLER4
X_16694_ _19901_/Q _16702_/B VDD VSS _19549_/D AND2X1
XFILLER_46_485 VDD VSS FILLER4
XFILLER_73_282 VSS VDD FILLER2
X_18433_ _18437_/CK _18497_/D _18433_/Q _20075_/RB VDD VSS DFFRQX1
XFILLER_61_433 VSS VDD FILLER2
X_15645_ _15654_/A _15654_/B VDD VSS _15732_/B XNOR2X1
X_12857_ _12940_/A _12940_/B VDD VSS _12860_/B _12940_/C NAND3X1
XFILLER_92_83 VSS VDD FILLER2
X_18364_ _18374_/CK _18513_/Q _20201_/A _18463_/RB VDD VSS DFFRQX1
X_11808_ _19174_/Q _11808_/B _11830_/C VDD VSS _11916_/B XNOR3X1
XFILLER_159_310 VSS VDD FILLER2
XFILLER_14_360 VSS VDD FILLER2
X_15576_ _15576_/A _15601_/B VDD VSS _15823_/B XNOR2X1
X_12788_ _18879_/Q VDD VSS _12790_/A INVX1
XFILLER_30_831 VDD VSS FILLER1
X_17315_ _17318_/A _17315_/B _17315_/C VDD VSS _19819_/D AOI21X1
XFILLER_42_691 VDD VSS FILLER4
XFILLER_147_505 VSS VDD FILLER2
X_14527_ _14766_/A _14527_/B VDD VSS _19233_/D AND2X1
X_11739_ _11739_/A _11739_/B _14485_/B VDD VSS _11760_/B MIN3X1
X_18295_ _18295_/CK _18295_/D _18295_/Q VDD VSS DFFQX1
XFILLER_147_549 VDD VSS FILLER1
X_17246_ _17390_/A _17246_/B VDD VSS _19805_/D NOR2X1
XFILLER_128_730 VSS VDD FILLER2
X_14458_ _14493_/A _14458_/B VDD VSS _19172_/D NOR2X1
X_13409_ _13601_/A _13531_/B VDD VSS _14325_/B XNOR2X1
XTAP_TAPCELL_ROW_136_1240 VDD VSS WELLTAP
X_17177_ _17178_/A _17180_/C _17229_/C VDD VSS _17178_/C OAI21X1
X_14389_ _14381_/Y _14389_/B _14389_/C VDD VSS _19111_/D AND3BX1
XFILLER_143_711 VDD VSS FILLER4
XFILLER_155_582 VDD VSS FILLER4
X_16128_ _19683_/Q VDD VSS _16129_/A INVX1
XFILLER_127_295 VSS VDD FILLER2
XFILLER_115_468 VSS VDD FILLER2
X_16059_ _16059_/A _16059_/B _16768_/B VDD VSS _16083_/A MIN3X1
XFILLER_130_416 VSS VDD FILLER2
XFILLER_143_799 VDD VSS FILLER1
XFILLER_130_427 VSS VDD FILLER2
XFILLER_37_0 VDD VSS FILLER4
XFILLER_142_298 VDD VSS FILLER1
XFILLER_111_663 VSS VDD FILLER2
X_19818_ _19853_/CK _19818_/D _19818_/Q VDD VSS DFFQX1
XFILLER_96_363 VSS VDD FILLER2
XFILLER_84_514 VSS VDD FILLER2
XFILLER_110_162 VDD VSS FILLER1
XFILLER_84_536 VDD VSS FILLER1
X_19749_ _19785_/CK _19749_/D _19749_/Q VDD VSS DFFQX1
X_09502_ _18519_/Q _09507_/B _09506_/C _20076_/Q VDD VSS _20076_/D AO22X2
XFILLER_65_761 VSS VDD FILLER2
XFILLER_71_208 VDD VSS FILLER4
XFILLER_25_603 VSS VDD FILLER2
XFILLER_37_463 VSS VDD FILLER2
XFILLER_112_49 VDD VSS FILLER4
XFILLER_37_496 VSS VDD FILLER2
X_09433_ _09447_/B _09696_/B VDD VSS _18214_/E NOR2X1
XTAP_TAPCELL_ROW_82_748 VDD VSS WELLTAP
XFILLER_80_731 VSS VDD FILLER2
XTAP_TAPCELL_ROW_19_182 VDD VSS WELLTAP
XTAP_TAPCELL_ROW_143_1299 VDD VSS WELLTAP
X_09364_ _18514_/Q VDD VSS _18493_/D INVX1
XFILLER_52_477 VDD VSS FILLER1
XFILLER_80_797 VDD VSS FILLER1
XFILLER_21_820 VSS VDD FILLER2
X_09295_ _09380_/B _09362_/B VDD VSS _09295_/Y NOR2BX1
XFILLER_166_825 VDD VSS FILLER1
XFILLER_122_8 VSS VDD FILLER2
XFILLER_21_35 VSS VDD FILLER2
XFILLER_119_774 VSS VDD FILLER2
XFILLER_134_700 VSS VDD FILLER2
XFILLER_118_262 VDD VSS FILLER4
XFILLER_118_273 VSS VDD FILLER2
XFILLER_21_79 VSS VDD FILLER2
XFILLER_118_295 VDD VSS DECAPHV8
XFILLER_134_744 VDD VSS FILLER4
XFILLER_133_221 VSS VDD FILLER2
XTAP_TAPCELL_ROW_154_1395 VDD VSS WELLTAP
XFILLER_0_702 VSS VDD FILLER2
XFILLER_161_596 VDD VSS DECAPHV8
XFILLER_153_23 VDD VSS FILLER4
X_10070_ _10044_/Y _10069_/Y _10155_/A VDD VSS _10070_/Y MUXI2X1
XFILLER_0_768 VSS VDD FILLER2
XFILLER_153_56 VDD VSS FILLER4
XFILLER_48_717 VSS VDD FILLER2
XFILLER_75_503 VSS VDD FILLER2
XFILLER_153_67 VSS VDD FILLER2
XFILLER_153_89 VDD VSS FILLER4
XTAP_TAPCELL_ROW_98_892 VDD VSS WELLTAP
XFILLER_101_184 VSS VDD FILLER2
XFILLER_28_430 VDD VSS FILLER1
X_13760_ _13770_/A _13760_/B _13830_/D VDD VSS _13816_/C XNOR3X1
XFILLER_16_603 VDD VSS FILLER1
X_10972_ _11226_/A _10972_/B VDD VSS _10982_/B NOR2X1
XFILLER_28_474 VDD VSS DECAPHV8
XTAP_TAPCELL_ROW_45_417 VDD VSS WELLTAP
XFILLER_46_76 VSS VDD FILLER2
XFILLER_71_720 VSS VDD FILLER2
XFILLER_55_282 VSS VDD FILLER2
XFILLER_43_422 VSS VDD FILLER2
XFILLER_15_113 VSS VDD FILLER2
X_12711_ _18991_/Q _12713_/B _12713_/C VDD VSS _14214_/B XNOR3X1
XFILLER_71_742 VSS VDD FILLER2
X_13691_ _13736_/A _13840_/B _13692_/C VDD VSS _14263_/B OR3BX1
XFILLER_15_135 VSS VDD FILLER2
X_15430_ _19461_/Q _15430_/B _15849_/B VDD VSS _15469_/B MIN3X1
X_12642_ _12643_/A _12643_/B _12643_/D _12643_/C VDD VSS _14409_/C AOI211X1
XFILLER_15_179 VSS VDD FILLER2
XFILLER_62_64 VSS VDD FILLER2
X_15361_ _15396_/A _15396_/B VDD VSS _15881_/B XOR2X1
XTAP_TAPCELL_ROW_53_494 VDD VSS WELLTAP
X_12573_ _12659_/A _14505_/B VDD VSS _12840_/A NOR2X1
XFILLER_156_302 VDD VSS FILLER1
X_17100_ _17102_/B _17100_/B VDD VSS _17101_/B XOR2X1
XTAP_TAPCELL_ROW_120_1096 VDD VSS WELLTAP
XFILLER_157_836 VDD VSS FILLER1
X_14312_ _14457_/A VDD VSS _14339_/A BUFX3
X_11524_ _18676_/Q _11531_/B VDD VSS _18703_/D AND2X1
XFILLER_157_847 VSS VDD FILLER2
X_15292_ _19346_/Q _15720_/B VDD VSS _15294_/A XOR2X1
X_18080_ _19283_/Q _18084_/B VDD VSS _18083_/C XNOR2X1
XFILLER_7_323 VSS VDD FILLER2
XFILLER_7_345 VSS VDD FILLER2
X_17031_ _19758_/Q _19759_/Q _17047_/B VDD VSS _17041_/A OAI21X1
X_14243_ _14243_/A _14277_/B VDD VSS _14244_/B XNOR2X1
X_11455_ _19948_/Q _11460_/B VDD VSS _18641_/D AND2X1
XFILLER_137_582 VDD VSS FILLER4
XFILLER_109_284 VDD VSS FILLER1
X_10406_ _10406_/A _10406_/B _10406_/C _10406_/D VDD VSS _10454_/A AOAI211X1
X_14174_ _14174_/A _14174_/B _15836_/C VDD VSS _18926_/D OA21X2
X_11386_ _11392_/A _11387_/B _11386_/C VDD VSS _11387_/C OAI21X1
XFILLER_125_777 VSS VDD FILLER2
X_13125_ _19191_/Q _13141_/D _13125_/C VDD VSS _13233_/C XNOR3X1
XFILLER_112_405 VSS VDD FILLER2
XFILLER_125_788 VSS VDD FILLER2
X_10337_ _18632_/Q _18794_/Q VDD VSS _10338_/D XNOR2X1
XFILLER_124_265 VSS VDD FILLER2
X_18982_ _19037_/CK _18982_/D _18982_/Q VDD VSS DFFQX1
XFILLER_112_416 VSS VDD FILLER2
XFILLER_140_725 VSS VDD FILLER2
XFILLER_112_427 VDD VSS FILLER1
XFILLER_152_596 VDD VSS DECAPHV8
XFILLER_112_449 VDD VSS DECAPHV8
X_17933_ _17940_/A _17933_/B VDD VSS _17935_/B XNOR2X1
X_13056_ _13244_/A _13150_/D _13056_/C VDD VSS _13139_/B XNOR3X1
XFILLER_105_490 VSS VDD FILLER2
X_10268_ _11436_/C _10268_/B _10763_/A VDD VSS _10269_/C OAI21X1
XFILLER_140_769 VSS VDD FILLER2
XTAP_TAPCELL_ROW_131_1192 VDD VSS WELLTAP
X_12007_ _19010_/Q _12012_/B _14273_/B VDD VSS _14238_/B XNOR3X1
XFILLER_66_503 VSS VDD FILLER2
XFILLER_120_460 VDD VSS DECAPHV8
X_17864_ _18851_/Q _17870_/B VDD VSS _17866_/B XNOR2X1
XFILLER_66_514 VSS VDD FILLER2
X_10199_ _10200_/A _10200_/B _10200_/D _10200_/C VDD VSS _10199_/Y OAOI211X1
X_19603_ _19636_/CK _19603_/D _19603_/Q VDD VSS DFFQX1
XFILLER_66_536 VDD VSS FILLER1
X_16815_ _16843_/A _16815_/B VDD VSS _19657_/D AND2X1
X_17795_ _19922_/Q _19890_/Q _17795_/C VDD VSS _17800_/C AO21X2
XFILLER_66_569 VSS VDD FILLER2
X_19534_ _19536_/CK _19534_/D _19534_/Q VDD VSS DFFQX1
XFILLER_47_772 VSS VDD FILLER2
XFILLER_19_463 VSS VDD FILLER2
X_16746_ _16748_/A _16746_/B VDD VSS _19596_/D NOR2X1
XFILLER_93_388 VSS VDD FILLER2
XFILLER_53_219 VSS VDD FILLER2
X_13958_ wire153/Y _13958_/B VDD VSS _14267_/B XOR2X1
XFILLER_62_742 VDD VSS FILLER4
X_19465_ _19465_/CK _19465_/D _19465_/Q VDD VSS DFFQX1
X_12909_ _19076_/Q _14349_/B VDD VSS _12915_/C _14349_/C NAND3X1
X_16677_ _16677_/A _19928_/Q _16677_/C VDD VSS _16679_/A MIN3X1
XFILLER_62_753 VSS VDD FILLER2
X_13889_ _13889_/A _13889_/B _13889_/C _13889_/D VDD VSS _14265_/B AOAI211X1
XFILLER_61_241 VDD VSS FILLER4
X_18416_ _18422_/CK _18517_/Q _20171_/A _18422_/RB VDD VSS DFFRQX1
X_15628_ _15644_/B _15628_/B VDD VSS _15731_/B XNOR2X1
X_19396_ _19460_/CK _19396_/D _19396_/Q VDD VSS DFFQX1
XTAP_TAPCELL_ROW_7_80 VDD VSS WELLTAP
XFILLER_15_680 VDD VSS FILLER4
X_18347_ _18359_/CK _18347_/D _18347_/Q _18373_/RB VDD VSS DFFRQX1
X_15559_ _15566_/A _15566_/B VDD VSS _15697_/B XNOR2X1
XFILLER_159_151 VSS VDD FILLER2
XFILLER_147_302 VDD VSS FILLER1
XFILLER_159_184 VSS VDD FILLER2
X_18278_ _18278_/CK _18278_/D _18278_/Q _09262_/Y VDD VSS DFFRQX1
XFILLER_30_683 VDD VSS FILLER4
XTAP_TAPCELL_ROW_0_2 VDD VSS WELLTAP
XFILLER_147_368 VDD VSS FILLER4
X_17229_ _17230_/A _17230_/B _17229_/C VDD VSS _17230_/C OAI21X1
XFILLER_116_700 VDD VSS FILLER4
XFILLER_128_560 VDD VSS FILLER4
XFILLER_128_571 VDD VSS FILLER4
XFILLER_162_316 VDD VSS DECAPHV8
XFILLER_155_390 VSS VDD FILLER2
XFILLER_116_777 VDD VSS FILLER4
XFILLER_115_265 VSS VDD FILLER2
XFILLER_116_788 VSS VDD FILLER2
XFILLER_131_714 VDD VSS FILLER1
X_20171_ _20171_/A VDD VSS _20171_/Y BUFX3
X_09982_ _11435_/A _11435_/B _11438_/A VDD VSS _10362_/D OR3X2
XFILLER_89_628 VDD VSS DECAPHV8
XFILLER_88_105 VSS VDD FILLER2
XFILLER_103_416 VSS VDD FILLER2
XFILLER_115_276 VSS VDD FILLER2
XFILLER_107_49 VSS VDD FILLER2
XFILLER_131_747 VSS VDD FILLER2
XFILLER_130_235 VSS VDD FILLER2
XFILLER_69_352 VSS VDD FILLER2
XFILLER_130_268 VDD VSS FILLER4
XFILLER_97_683 VSS VDD FILLER2
XFILLER_29_205 VSS VDD FILLER2
XFILLER_69_396 VDD VSS FILLER4
XFILLER_29_227 VSS VDD FILLER2
XFILLER_85_856 VDD VSS FILLER1
XTAP_TAPCELL_ROW_145_1317 VDD VSS WELLTAP
XFILLER_29_249 VSS VDD FILLER2
XFILLER_72_506 VDD VSS FILLER4
XFILLER_53_720 VDD VSS FILLER1
XTAP_TAPCELL_ROW_107_974 VDD VSS WELLTAP
XFILLER_37_282 VDD VSS FILLER4
XFILLER_13_606 VSS VDD FILLER2
XFILLER_13_617 VDD VSS FILLER1
X_09416_ _20064_/Q VDD VSS _16908_/C INVX1
XFILLER_16_79 VDD VSS FILLER4
XFILLER_40_414 VDD VSS FILLER4
XFILLER_25_488 VDD VSS FILLER4
XFILLER_12_138 VDD VSS FILLER1
X_09347_ _18281_/Q _18525_/Q _09354_/B VDD VSS _09347_/Y MUXI2X1
XFILLER_139_836 VDD VSS FILLER1
XFILLER_21_650 VDD VSS FILLER1
XFILLER_138_313 VDD VSS FILLER4
XTAP_TAPCELL_ROW_156_1413 VDD VSS WELLTAP
XFILLER_148_12 VSS VDD FILLER2
XTAP_TAPCELL_ROW_50_464 VDD VSS WELLTAP
XFILLER_32_45 VDD VSS FILLER1
XFILLER_166_633 VSS VDD FILLER2
X_09278_ _18471_/D _09354_/B _09351_/C _09753_/A _09362_/B VDD VSS wire168/A AOI221X2
XFILLER_166_644 VSS VDD FILLER2
XTAP_TAPCELL_ROW_3_38 VDD VSS WELLTAP
XFILLER_20_182 VSS VDD FILLER2
XFILLER_32_89 VDD VSS DECAPHV8
XFILLER_153_316 VSS VDD FILLER2
XFILLER_113_4 VSS VDD FILLER2
XFILLER_4_315 VSS VDD FILLER2
XFILLER_106_210 VSS VDD FILLER2
X_11240_ _18578_/Q _11249_/B VDD VSS _11253_/A NAND2X1
XFILLER_134_530 VSS VDD FILLER2
XFILLER_107_755 VDD VSS FILLER1
XFILLER_134_563 VDD VSS FILLER4
XFILLER_134_574 VDD VSS FILLER4
X_11171_ _18654_/Q _18816_/Q _11171_/C VDD VSS _11204_/B AOI21X1
XFILLER_79_105 VSS VDD FILLER2
XFILLER_164_44 VSS VDD FILLER2
XFILLER_161_371 VDD VSS FILLER1
XFILLER_0_510 VSS VDD FILLER2
XFILLER_121_213 VDD VSS FILLER4
X_10122_ _10122_/A VDD VSS _10123_/A INVX1
XFILLER_0_543 VSS VDD FILLER2
XFILLER_121_257 VSS VDD FILLER2
XFILLER_164_99 VSS VDD FILLER2
X_14930_ _19450_/Q wire162/Y _14957_/B VDD VSS _14931_/D XNOR3X1
X_10053_ _10053_/A _10053_/B _10053_/C VDD VSS _10075_/A MIN3X1
XFILLER_94_119 VDD VSS FILLER1
XFILLER_75_300 VSS VDD FILLER2
XFILLER_57_31 VSS VDD FILLER2
XFILLER_48_514 VSS VDD FILLER2
XFILLER_88_694 VSS VDD FILLER2
XFILLER_87_171 VDD VSS FILLER4
X_14861_ _14861_/A _14861_/B _14861_/C VDD VSS _14911_/C NOR3X1
XTAP_TAPCELL_ROW_58_531 VDD VSS WELLTAP
XFILLER_48_558 VDD VSS DECAPHV8
XFILLER_75_355 VSS VDD FILLER2
X_16600_ _19574_/Q _19926_/Q VDD VSS _16603_/A XNOR2X1
X_13812_ _18891_/Q _13812_/B VDD VSS _13868_/C _13877_/B NAND3X1
X_17580_ _19876_/Q _19844_/Q VDD VSS _17581_/C NAND2X1
XFILLER_35_219 VSS VDD FILLER2
XFILLER_16_400 VDD VSS FILLER4
X_14792_ _15865_/B _14792_/B _14872_/C VDD VSS _15866_/B XNOR3X1
Xclkbuf_leaf_9__001_ clkload32/A VDD VSS _19988_/CK BUFX12
XFILLER_44_720 VSS VDD FILLER2
X_16531_ _19635_/Q _16789_/B VDD VSS _16532_/B XOR2X1
X_13743_ _18889_/Q _14130_/B VDD VSS _13872_/A NAND2X1
X_10955_ _10953_/Y _10957_/C _11431_/A VDD VSS _18569_/D AND3BX1
XTAP_TAPCELL_ROW_122_1114 VDD VSS WELLTAP
XFILLER_44_753 VSS VDD FILLER2
XFILLER_16_455 VDD VSS FILLER4
XFILLER_73_63 VSS VDD FILLER2
XFILLER_71_561 VSS VDD FILLER2
X_19250_ _19250_/CK _19250_/D _19250_/Q VDD VSS DFFQX1
XFILLER_71_572 VSS VDD FILLER2
X_16462_ _16462_/A _16469_/C VDD VSS _16892_/B XNOR2X1
XFILLER_73_85 VSS VDD FILLER2
X_13674_ _13675_/A _13675_/B _13675_/D _13675_/C VDD VSS _14195_/C AOI211X1
X_10886_ _10884_/Y _10888_/B _11431_/A VDD VSS _18567_/D AND3BX1
XFILLER_73_96 VDD VSS FILLER4
X_18201_ _18201_/A _18201_/B _18201_/C VDD VSS _18202_/C OAI21X1
X_15413_ _15413_/A _15425_/C VDD VSS _15723_/B XNOR2X1
X_19181_ _19217_/CK _19181_/D _19181_/Q VDD VSS DFFQX1
X_12625_ _12625_/A _12625_/B _12625_/C VDD VSS _12630_/B XNOR3X1
X_16393_ _19566_/Q _19918_/Q VDD VSS _16421_/A XOR2X1
XTAP_TAPCELL_ROW_13_133 VDD VSS WELLTAP
XFILLER_129_302 VSS VDD FILLER2
XFILLER_12_672 VSS VDD FILLER2
X_18132_ _18132_/A _18132_/B _18136_/B VDD VSS _20000_/D NOR3X1
X_15344_ _15784_/B VDD VSS _15345_/C INVX1
X_12556_ _12593_/A _12593_/B _12593_/E _12556_/D VDD VSS _14378_/C OAOI211X1
XFILLER_11_182 VDD VSS FILLER4
X_11507_ _18661_/Q _11508_/B VDD VSS _18688_/D AND2X1
X_18063_ _19279_/Q _18063_/B VDD VSS _18064_/C NAND2X1
X_15275_ _15275_/A _15275_/B _15275_/C _15275_/D VDD VSS _15311_/A AOI31X1
X_12487_ _12497_/A _14503_/B _12497_/C VDD VSS _14504_/B OAI21X1
XFILLER_144_316 VSS VDD FILLER2
X_17014_ _17095_/A _17014_/B VDD VSS _19757_/D NOR2X1
XTAP_TAPCELL_ROW_133_1210 VDD VSS WELLTAP
X_14226_ _14226_/A wire154/Y _14226_/C VDD VSS _14227_/C NOR3X1
X_11438_ _11438_/A _11438_/B VDD VSS _11439_/B XNOR2X1
X_14157_ _14186_/A _14157_/B VDD VSS _18912_/D NOR2X1
X_18209__255 _20052_/CK VDD VSS _18276_/CK INVX1
X_11369_ _11383_/A _11369_/B VDD VSS _18591_/D NOR2X1
XFILLER_112_202 VSS VDD FILLER2
XFILLER_140_522 VDD VSS FILLER1
XFILLER_113_747 VDD VSS FILLER4
XFILLER_3_370 VSS VDD FILLER2
XFILLER_152_393 VSS VDD FILLER2
X_13108_ _13108_/A _13108_/B _13108_/C _13108_/D VDD VSS _14446_/B AOAI211X1
XFILLER_112_235 VDD VSS FILLER4
X_18965_ _18997_/CK _18965_/D _18965_/Q VDD VSS DFFQX1
X_14088_ _14174_/B _14173_/B _18925_/Q VDD VSS _14089_/D OAI21X1
XFILLER_112_246 VSS VDD FILLER2
XFILLER_140_555 VDD VSS FILLER1
Xclkbuf_leaf_13__000_ clkload71/A VDD VSS _19667_/CK BUFX12
XFILLER_79_650 VDD VSS FILLER1
X_17916_ _18861_/Q _17919_/B VDD VSS _17918_/B XOR2X1
X_13039_ _13039_/A _13039_/B _13039_/C _13039_/D VDD VSS _14446_/C OAI211X1
XFILLER_85_119 VSS VDD FILLER2
XFILLER_140_599 VDD VSS FILLER4
X_18896_ _18924_/CK _18896_/D _18896_/Q VDD VSS DFFQX1
XFILLER_66_311 VDD VSS FILLER1
X_17847_ _18847_/Q _17847_/B _17847_/C VDD VSS _17853_/C MIN3X1
XFILLER_66_355 VSS VDD FILLER2
XFILLER_66_388 VDD VSS FILLER1
X_17778_ _17781_/C _17778_/B VDD VSS _17779_/B XNOR2X1
Xclkbuf_leaf_28__000_ clkload70/A VDD VSS _19412_/CK BUFX12
XFILLER_54_539 VSS VDD FILLER2
XFILLER_47_591 VSS VDD FILLER2
XFILLER_19_282 VSS VDD FILLER2
X_19517_ _19736_/CK _19517_/D _19517_/Q VDD VSS DFFQX1
XTAP_TAPCELL_ROW_92_843 VDD VSS WELLTAP
X_16729_ _16735_/A _16729_/B VDD VSS _19580_/D NOR2X1
XFILLER_34_230 VSS VDD FILLER2
X_19448_ _19466_/CK _19448_/D _19448_/Q VDD VSS DFFQX1
XTAP_TAPCELL_ROW_64_589 VDD VSS WELLTAP
XFILLER_35_797 VDD VSS FILLER4
XTAP_TAPCELL_ROW_140_1269 VDD VSS WELLTAP
XFILLER_62_594 VDD VSS FILLER1
XFILLER_34_285 VSS VDD FILLER2
X_09201_ _18510_/Q VDD VSS _18441_/D INVX1
X_19379_ _19379_/CK _19379_/D _19379_/Q VDD VSS DFFQX1
XFILLER_50_789 VDD VSS FILLER1
XFILLER_108_508 VSS VDD FILLER2
XFILLER_147_154 VSS VDD FILLER2
XFILLER_163_614 VDD VSS FILLER4
XFILLER_2_819 VDD VSS FILLER4
X_20223_ _20223_/A VDD VSS _20223_/Y BUFX3
XFILLER_89_403 VDD VSS FILLER1
XFILLER_1_307 VSS VDD FILLER2
XTAP_TAPCELL_ROW_151_1376 VDD VSS WELLTAP
XFILLER_1_329 VDD VSS FILLER4
XFILLER_103_213 VDD VSS DECAPHV8
XFILLER_89_436 VDD VSS DECAPHV8
XFILLER_143_393 VSS VDD FILLER2
XFILLER_104_758 VDD VSS FILLER4
X_20154_ _20154_/A VDD VSS _20154_/Y BUFX3
XFILLER_131_555 VSS VDD FILLER2
XFILLER_77_609 VSS VDD FILLER2
XFILLER_103_268 VSS VDD FILLER2
X_20085_ _20085_/A VDD VSS _20085_/Y BUFX3
X_09896_ _18598_/Q _09935_/B VDD VSS _09981_/A NAND2X1
XFILLER_85_620 VSS VDD FILLER2
XFILLER_57_322 VSS VDD FILLER2
XFILLER_57_344 VDD VSS FILLER4
XFILLER_27_23 VSS VDD FILLER2
XFILLER_73_826 VDD VSS FILLER1
XFILLER_150_13 VSS VDD FILLER2
XFILLER_72_303 VSS VDD FILLER2
XFILLER_150_24 VDD VSS FILLER1
XFILLER_150_35 VSS VDD FILLER2
XTAP_TAPCELL_ROW_55_512 VDD VSS WELLTAP
XFILLER_38_580 VDD VSS FILLER4
XFILLER_26_731 VSS VDD FILLER2
XFILLER_27_89 VDD VSS FILLER4
XTAP_TAPCELL_ROW_162_1472 VDD VSS WELLTAP
XFILLER_72_358 VDD VSS FILLER1
XFILLER_60_509 VSS VDD FILLER2
XTAP_TAPCELL_ROW_27_258 VDD VSS WELLTAP
XFILLER_53_561 VSS VDD FILLER2
X_10740_ _10740_/A _10785_/B VDD VSS _10743_/C XNOR2X1
XFILLER_80_380 VDD VSS FILLER4
XFILLER_41_756 VDD VSS FILLER4
X_10671_ _10671_/A _10671_/B VDD VSS _10708_/A NAND2X1
XFILLER_139_611 VDD VSS DECAPHV8
XFILLER_159_44 VSS VDD FILLER2
X_12410_ _20004_/Q _19268_/Q VDD VSS _12673_/A NOR2X1
X_13390_ _13391_/A _13391_/B _13391_/D _13391_/C VDD VSS _14192_/C AOI211X1
XFILLER_159_77 VSS VDD FILLER2
XTAP_TAPCELL_ROW_10_103 VDD VSS WELLTAP
XFILLER_166_441 VSS VDD FILLER2
X_12341_ _12341_/A _12341_/B _14178_/B VDD VSS _12353_/C MIN3X1
XFILLER_138_165 VSS VDD FILLER2
XFILLER_138_198 VSS VDD FILLER2
X_15060_ _19508_/Q _15144_/B VDD VSS _15108_/D NAND2X1
XFILLER_5_635 VSS VDD FILLER2
X_12272_ _18874_/Q _12272_/B _12272_/C VDD VSS _12610_/B MIN3X1
XFILLER_154_658 VDD VSS FILLER1
XFILLER_142_809 VDD VSS FILLER1
XFILLER_107_541 VDD VSS FILLER1
XFILLER_135_850 VSS VDD FILLER2
XFILLER_153_157 VDD VSS FILLER1
X_14011_ _19006_/Q _14268_/A _14268_/B VDD VSS _14013_/C NOR3X1
XFILLER_104_0 VDD VSS FILLER4
X_11223_ _11263_/A _11241_/A VDD VSS _11236_/A NOR2X1
XFILLER_4_27 VSS VDD FILLER2
XFILLER_4_49 VDD VSS FILLER4
X_11154_ _11154_/A _11159_/B VDD VSS _11158_/C XNOR2X1
XFILLER_122_577 VDD VSS FILLER4
X_10105_ _10081_/Y _10129_/B _10155_/A VDD VSS _10105_/Y MUX2X1
X_18750_ _19947_/CK _18750_/D _18750_/Q VDD VSS DFFQX1
X_15962_ _19549_/Q VDD VSS _15963_/A INVX1
X_11085_ _11086_/A _11086_/B _11086_/C _11273_/A VDD VSS _11085_/Y AOI31X1
XFILLER_48_311 VDD VSS FILLER1
XFILLER_88_480 VSS VDD FILLER2
X_17701_ _17806_/A _17701_/B VDD VSS _19902_/D NOR2X1
X_14913_ _14920_/A _15833_/B _14920_/C VDD VSS _15834_/B OAI21X1
X_10036_ _10027_/Y _10035_/Y _11208_/A VDD VSS _10050_/C MUXI2X1
XFILLER_76_642 VSS VDD FILLER2
XFILLER_102_290 VDD VSS FILLER4
X_18681_ _18845_/CK _18681_/D _18681_/Q VDD VSS DFFQX1
XFILLER_75_130 VSS VDD FILLER2
X_15893_ _15895_/A _15893_/B VDD VSS _19500_/D NOR2X1
XFILLER_48_355 VSS VDD FILLER2
XFILLER_91_601 VSS VDD FILLER2
XFILLER_124_91 VSS VDD FILLER2
X_17632_ _17634_/C _17632_/B _17632_/C VDD VSS _19887_/D AOI21X1
XFILLER_75_163 VSS VDD FILLER2
X_14844_ _19392_/Q _15770_/B VDD VSS _14845_/B XOR2X1
XFILLER_90_100 VSS VDD FILLER2
XFILLER_84_73 VDD VSS FILLER1
XFILLER_17_742 VSS VDD FILLER2
X_17563_ _19873_/Q _19841_/Q VDD VSS _17565_/B XOR2X1
XFILLER_84_95 VDD VSS FILLER4
X_14775_ _14775_/A _14775_/B VDD VSS _15830_/B XNOR2X1
XFILLER_16_230 VSS VDD FILLER2
X_11987_ _11987_/A _14462_/B _11987_/C _11987_/D VDD VSS _12113_/A OAOI211X2
XFILLER_90_155 VDD VSS FILLER1
X_19302_ _19331_/CK _19302_/D _19302_/Q VDD VSS DFFQX1
X_16514_ _19730_/Q _16895_/B VDD VSS _16515_/C NOR2X1
XFILLER_90_177 VDD VSS FILLER1
XFILLER_44_572 VSS VDD FILLER2
X_13726_ _13777_/A _13766_/B _13783_/C VDD VSS _13843_/A XNOR3X1
X_17494_ _19858_/Q _19826_/Q VDD VSS _17496_/D XNOR2X1
X_10938_ _18702_/Q _18756_/Q VDD VSS _10940_/C XNOR2X1
XFILLER_44_594 VSS VDD FILLER2
XFILLER_31_211 VSS VDD FILLER2
X_19233_ _20000_/CK _19233_/D _19233_/Q VDD VSS DFFQX1
XTAP_TAPCELL_ROW_101_925 VDD VSS WELLTAP
XFILLER_90_6 VSS VDD FILLER2
X_16445_ _19663_/Q _16821_/B VDD VSS _16459_/A NAND2BX1
XTAP_TAPCELL_ROW_61_559 VDD VSS WELLTAP
XFILLER_31_244 VDD VSS FILLER4
X_13657_ _13748_/A _13748_/C VDD VSS _13746_/C AND2X1
X_10869_ _18672_/Q _18780_/Q VDD VSS _10871_/C NAND2X1
XFILLER_32_789 VDD VSS FILLER1
XFILLER_31_266 VSS VDD FILLER2
XFILLER_129_110 VSS VDD FILLER2
XFILLER_31_277 VSS VDD FILLER2
X_19164_ _19166_/CK _19164_/D _19164_/Q VDD VSS DFFQX1
X_12608_ _13177_/A _17869_/B VDD VSS _18850_/D NOR2X1
X_16376_ _19629_/Q _16783_/B VDD VSS _16377_/B XNOR2X1
XFILLER_118_806 VSS VDD FILLER2
XFILLER_12_480 VSS VDD FILLER2
X_13588_ _13656_/A _13656_/B _13589_/D _13656_/E VDD VSS _14162_/B OA211X2
X_18115_ _18117_/A _18117_/B VDD VSS _18121_/B NOR2X1
XFILLER_129_165 VSS VDD FILLER2
X_15327_ _15347_/D _15327_/B VDD VSS _15784_/B XOR2X1
XFILLER_157_474 VSS VDD FILLER2
X_19095_ _19126_/CK _19095_/D _19095_/Q VDD VSS DFFQX1
X_12539_ _19045_/Q _14314_/B VDD VSS _12632_/A AND2X1
X_18046_ _18544_/Q _18048_/B VDD VSS _18047_/B XNOR2X1
XFILLER_145_669 VDD VSS FILLER1
X_15258_ _15688_/B VDD VSS _15259_/C INVX1
XFILLER_144_168 VDD VSS FILLER4
XFILLER_132_319 VDD VSS FILLER4
X_14209_ _14231_/A _14209_/B VDD VSS _18958_/D AND2X1
XFILLER_113_500 VSS VDD FILLER2
XFILLER_113_511 VSS VDD FILLER2
XFILLER_125_371 VDD VSS FILLER1
X_15189_ _19511_/Q _15905_/B VDD VSS _15275_/B NAND2BX1
XFILLER_99_756 VSS VDD FILLER2
XFILLER_99_767 VSS VDD FILLER2
XFILLER_98_244 VSS VDD FILLER2
XFILLER_140_341 VSS VDD FILLER2
X_19997_ _20000_/CK _19997_/D _19997_/Q VDD VSS DFFQX1
XFILLER_101_706 VSS VDD FILLER2
XFILLER_113_566 VSS VDD FILLER2
Xclkbuf_0__09173_ _18222_/ECK VDD VSS clkbuf_0__09173_/Y BUFX12
XFILLER_140_374 VDD VSS FILLER4
X_09750_ _18323_/Q _09769_/C VDD VSS _09751_/D NAND2X1
XFILLER_39_300 VSS VDD FILLER2
X_18948_ _19059_/CK _18948_/D _18948_/Q VDD VSS DFFQX1
XTAP_TAPCELL_ROW_69_637 VDD VSS WELLTAP
XFILLER_100_249 VSS VDD FILLER2
XFILLER_67_642 VDD VSS FILLER1
X_09681_ _09681_/A _09681_/B VDD VSS _09682_/E NAND2X1
X_18879_ _18934_/CK _18879_/D _18879_/Q VDD VSS DFFQX1
XFILLER_55_815 VDD VSS FILLER4
XFILLER_81_100 VSS VDD FILLER2
XFILLER_39_399 VDD VSS FILLER4
XFILLER_82_645 VSS VDD FILLER2
XFILLER_66_196 VSS VDD FILLER2
XFILLER_54_358 VSS VDD FILLER2
XFILLER_35_561 VSS VDD FILLER2
XFILLER_120_49 VSS VDD FILLER2
XTAP_TAPCELL_ROW_24_228 VDD VSS WELLTAP
XFILLER_23_734 VDD VSS FILLER1
XFILLER_23_756 VSS VDD FILLER2
XFILLER_23_767 VDD VSS FILLER1
XFILLER_50_564 VSS VDD FILLER2
XFILLER_13_36 VDD VSS FILLER1
XFILLER_148_430 VSS VDD FILLER2
XFILLER_109_817 VSS VDD FILLER2
XFILLER_129_25 VDD VSS FILLER1
XFILLER_13_69 VSS VDD FILLER2
XFILLER_136_614 VSS VDD FILLER2
XFILLER_148_496 VSS VDD FILLER2
XFILLER_123_308 VDD VSS FILLER1
XFILLER_123_319 VDD VSS FILLER4
XFILLER_151_628 VDD VSS FILLER4
Xclkbuf_leaf_8__002_ clkbuf_leaf_9__002_/A VDD VSS _18801_/CK BUFX12
XFILLER_145_13 VDD VSS FILLER4
XFILLER_163_499 VSS VDD FILLER2
XFILLER_132_831 VSS VDD FILLER2
XTAP_TAPCELL_ROW_0_17 VDD VSS WELLTAP
Xmax_cap170 _09797_/B VDD VSS _09782_/B BUFX4
X_20206_ _20206_/A VDD VSS _20206_/Y BUFX3
XFILLER_145_79 VDD VSS FILLER4
XFILLER_89_266 VSS VDD FILLER2
X_20137_ _20137_/A VDD VSS _20137_/Y BUFX3
X_09948_ _18577_/Q _09999_/C VDD VSS _09948_/Y XNOR2X1
XFILLER_38_44 VSS VDD FILLER2
X_20068_ clkload6/A _20068_/D _20068_/Q _20071_/RB VDD VSS DFFRQX1
XFILLER_92_409 VDD VSS FILLER1
X_09879_ _09908_/B _09911_/B _10966_/A VDD VSS _09925_/B MUXI2X1
XFILLER_100_761 VDD VSS DECAPHV8
XFILLER_45_303 VSS VDD FILLER2
XFILLER_38_88 VDD VSS FILLER4
XFILLER_161_56 VSS VDD FILLER2
X_11910_ _19120_/Q _11961_/B _11961_/C VDD VSS _11963_/A MIN3X1
XFILLER_85_472 VSS VDD FILLER2
XFILLER_38_99 VSS VDD FILLER2
XFILLER_46_848 VDD VSS FILLER4
X_12890_ _18965_/Q _13004_/B VDD VSS _12891_/C _12890_/C NAND3X1
XFILLER_72_122 VDD VSS FILLER4
XFILLER_57_196 VDD VSS DECAPHV8
X_11841_ _19995_/Q _19259_/Q VDD VSS _11881_/D XNOR2X1
XFILLER_54_21 VSS VDD FILLER2
XFILLER_72_155 VSS VDD FILLER2
XFILLER_26_572 VSS VDD FILLER2
X_14560_ _19999_/Q _14569_/B VDD VSS _19263_/D AND2X1
X_11772_ _19991_/Q _19255_/Q VDD VSS _11778_/C NAND2X1
XFILLER_60_328 VSS VDD FILLER2
XFILLER_54_65 VSS VDD FILLER2
XFILLER_13_211 VSS VDD FILLER2
X_13511_ _13511_/A _13511_/B _13511_/C _13511_/D VDD VSS wire154/A OAOI211X1
X_10723_ _19949_/Q _18831_/Q VDD VSS _10725_/B XNOR2X1
X_14491_ _14522_/A VDD VSS _14491_/Y BUFX3
XFILLER_14_789 VDD VSS FILLER1
XFILLER_41_575 VSS VDD FILLER2
XFILLER_13_277 VSS VDD FILLER2
X_16230_ _16230_/A VDD VSS _16231_/B INVX1
Xclkbuf_leaf_12__001_ clkload32/A VDD VSS _19115_/CK BUFX12
X_13442_ _19193_/Q _14480_/B VDD VSS _13459_/A NAND2X1
X_10654_ _10621_/B _10697_/B _10945_/A VDD VSS _10734_/B MUXI2X1
XFILLER_139_463 VSS VDD FILLER2
X_16161_ _16185_/C _16161_/B VDD VSS _16739_/B XNOR2X1
X_13373_ _13373_/A _13373_/B _14292_/B _13373_/D _13373_/E VDD VSS _13509_/C OAI221X1
XFILLER_166_260 VDD VSS DECAPHV8
X_10585_ _10625_/A _11267_/A _10585_/C VDD VSS _10586_/C NOR3X1
Xclkload18 _18785_/CK VDD VSS clkload18/Y INVX4
Xclkload29 _19943_/CK VDD VSS clkload29/Y INVX1
X_15112_ _15112_/A _15112_/B _15112_/C _15112_/D VDD VSS _15840_/B OAI211X1
X_12324_ _12407_/A _14531_/B _12407_/C _12407_/D VDD VSS _12499_/B AO31X2
X_16092_ _19618_/Q _16107_/A VDD VSS _16093_/B XOR2X1
XTAP_TAPCELL_ROW_117_1068 VDD VSS WELLTAP
Xclkbuf_leaf_27__001_ clkbuf_2_1__f__001_/Y VDD VSS _19037_/CK BUFX12
XFILLER_119_91 VSS VDD FILLER2
X_15043_ _15092_/A _15092_/B VDD VSS _15807_/B XNOR2X1
X_19920_ clkload9/A _19920_/D _19920_/Q VDD VSS DFFQX1
X_12255_ _12255_/A _12255_/B _14372_/B VDD VSS _12447_/A MIN3X1
XFILLER_154_499 VSS VDD FILLER2
XFILLER_107_382 VSS VDD FILLER2
X_11206_ _11227_/C _11206_/B VDD VSS _11207_/B XNOR2X1
X_19851_ _19853_/CK _19851_/D _19851_/Q VDD VSS DFFQX1
X_12186_ _19069_/Q _12283_/B _12449_/C VDD VSS _12203_/B XNOR3X1
XFILLER_122_341 VSS VDD FILLER2
XFILLER_110_514 VDD VSS FILLER4
X_18802_ _19946_/CK _18802_/D _18802_/Q VDD VSS DFFQX1
X_11137_ _11138_/A _11138_/B VDD VSS _11171_/C NOR2X1
X_19782_ _19825_/CK _19782_/D _19782_/Q VDD VSS DFFQX1
X_16994_ _16994_/A _16994_/B VDD VSS _16996_/B NAND2X1
XFILLER_110_536 VSS VDD FILLER2
XFILLER_95_236 VSS VDD FILLER2
X_18733_ _18785_/CK _18733_/D _18733_/Q VDD VSS DFFQX1
X_15945_ _19613_/Q _16765_/B VDD VSS _15946_/B XOR2X1
X_11068_ _11107_/B _11068_/B VDD VSS _11077_/B XOR2X1
XTAP_TAPCELL_ROW_66_607 VDD VSS WELLTAP
XFILLER_76_450 VDD VSS FILLER4
XFILLER_76_461 VDD VSS FILLER4
X_10019_ _10012_/Y _10018_/Y _11208_/A VDD VSS _10026_/B MUXI2X1
XFILLER_76_472 VSS VDD FILLER2
X_18664_ _18773_/CK _18664_/D _18664_/Q VDD VSS DFFQX1
XFILLER_36_314 VDD VSS FILLER4
X_15876_ _15879_/A _15876_/B VDD VSS _19484_/D AND2X1
XTAP_TAPCELL_ROW_128_1164 VDD VSS WELLTAP
XFILLER_76_494 VDD VSS FILLER1
XFILLER_48_185 VDD VSS FILLER1
X_17615_ _17618_/A _17615_/B _17615_/C VDD VSS _19883_/D AOI21X1
X_14827_ _19529_/Q _14877_/C VDD VSS _14828_/B NAND2X1
X_18595_ _18595_/CK _18595_/D _18595_/Q VDD VSS DFFQX1
XFILLER_24_509 VSS VDD FILLER2
XFILLER_64_689 VDD VSS FILLER1
XFILLER_63_166 VSS VDD FILLER2
XFILLER_17_561 VSS VDD FILLER2
X_17546_ _17544_/B _17546_/B VDD VSS _17547_/C NOR2BX1
XFILLER_51_328 VSS VDD FILLER2
X_14758_ _14758_/A _14758_/B _15767_/B VDD VSS _14772_/C MIN3X1
XFILLER_32_531 VDD VSS DECAPHV8
X_13709_ _13779_/A _13709_/B _14361_/B VDD VSS _13725_/B MIN3X1
X_17477_ _17477_/A _17479_/C _17477_/C VDD VSS _19854_/D AOI21X1
X_14689_ _14696_/B _14689_/B VDD VSS _15735_/B XNOR2X1
X_19216_ _19217_/CK _19216_/D _19216_/Q VDD VSS DFFQX1
X_16428_ _16429_/A _16429_/B _16429_/C VDD VSS _16447_/B OAI21X1
XFILLER_32_597 VDD VSS FILLER4
XFILLER_158_761 VSS VDD FILLER2
XFILLER_118_603 VDD VSS FILLER1
X_19147_ _19196_/CK _19147_/D _19147_/Q VDD VSS DFFQX1
X_16359_ _19692_/Q _16853_/B VDD VSS _16388_/A NAND2BX1
XTAP_TAPCELL_ROW_139_1260 VDD VSS WELLTAP
XFILLER_117_102 VDD VSS FILLER4
XFILLER_117_113 VSS VDD FILLER2
XFILLER_118_636 VSS VDD FILLER2
XFILLER_157_282 VSS VDD FILLER2
XFILLER_67_0 VSS VDD FILLER2
XFILLER_118_669 VSS VDD FILLER2
X_19078_ _19134_/CK _19078_/D _19078_/Q VDD VSS DFFQX1
XFILLER_105_319 VSS VDD FILLER2
X_18029_ _18056_/A _18029_/B _18056_/C VDD VSS _19972_/D OAI21X1
XFILLER_160_414 VDD VSS FILLER4
XFILLER_160_447 VDD VSS FILLER4
Xfanout205 _18442_/RB VDD VSS _20067_/RB BUFX3
Xfanout216 _18373_/RB VDD VSS _18464_/RB BUFX3
XFILLER_141_672 VDD VSS FILLER1
Xfanout227 input3/Y VDD VSS _18405_/RB BUFX3
X_09802_ _18454_/Q _09816_/B _09802_/C _09816_/D VDD VSS _09802_/Y OAI211X1
XFILLER_86_203 VSS VDD FILLER2
XFILLER_59_439 VDD VSS FILLER4
X_09733_ _18338_/Q VDD VSS _20092_/A INVX1
XFILLER_39_141 VSS VDD FILLER2
XFILLER_95_770 VSS VDD FILLER2
X_09664_ _09664_/A _09664_/B _09664_/C _09729_/D VDD VSS _09665_/E AOI31X1
XFILLER_55_634 VSS VDD FILLER2
XFILLER_94_280 VSS VDD FILLER2
XFILLER_54_111 VSS VDD FILLER2
X_09595_ _09811_/B VDD VSS _09784_/C BUFX3
XFILLER_55_678 VSS VDD FILLER2
XTAP_TAPCELL_ROW_37_342 VDD VSS WELLTAP
XFILLER_82_497 VSS VDD FILLER2
XFILLER_42_328 VDD VSS DECAPHV8
XFILLER_23_520 VSS VDD FILLER2
XFILLER_51_840 VSS VDD FILLER2
XFILLER_23_542 VDD VSS FILLER4
XFILLER_23_553 VDD VSS FILLER4
XFILLER_11_726 VDD VSS FILLER4
XFILLER_24_68 VDD VSS FILLER1
XFILLER_10_258 VSS VDD FILLER2
XFILLER_109_625 VSS VDD FILLER2
XFILLER_164_720 VSS VDD FILLER2
XFILLER_109_636 VDD VSS FILLER1
XFILLER_6_229 VSS VDD FILLER2
XFILLER_136_444 VSS VDD FILLER2
X_10370_ _10402_/A _10402_/B _10402_/C VDD VSS _10375_/C OAI21X1
XFILLER_40_56 VSS VDD FILLER2
XFILLER_136_466 VSS VDD FILLER2
XFILLER_163_252 VSS VDD FILLER2
XFILLER_156_45 VDD VSS FILLER1
XFILLER_156_67 VDD VSS FILLER4
XFILLER_117_680 VDD VSS FILLER4
XFILLER_151_436 VDD VSS DECAPHV16
Xclkbuf_2_2__f__000_ clkbuf_0__000_/Y VDD VSS clkload71/A BUFX12
X_12040_ _12040_/A _12040_/B _12040_/C _12040_/D VDD VSS _14433_/B OAOI211X1
XFILLER_77_214 VSS VDD FILLER2
XFILLER_104_385 VDD VSS FILLER4
XFILLER_131_171 VSS VDD FILLER2
XFILLER_104_396 VSS VDD FILLER2
XFILLER_120_856 VDD VSS FILLER1
XFILLER_131_193 VDD VSS FILLER1
XFILLER_93_707 VSS VDD FILLER2
X_13991_ _13991_/A _14036_/A _14045_/B VDD VSS _13993_/C XNOR3X1
XFILLER_77_269 VSS VDD FILLER2
XFILLER_105_60 VDD VSS FILLER1
X_15730_ _15743_/A _15730_/B VDD VSS _19355_/D AND2X1
X_12942_ _13028_/A _14445_/B VDD VSS _13041_/A NOR2X1
XFILLER_65_31 VDD VSS FILLER1
XFILLER_100_591 VDD VSS FILLER4
XFILLER_73_431 VDD VSS FILLER1
XFILLER_45_122 VSS VDD FILLER2
XFILLER_65_64 VDD VSS FILLER4
XFILLER_46_667 VDD VSS FILLER4
XFILLER_45_133 VDD VSS FILLER1
X_15661_ _15674_/A _18181_/B VDD VSS _19302_/D AND2X1
X_12873_ _12903_/A _12903_/B _12903_/C _12903_/D VDD VSS _13004_/B AO211X2
X_17400_ _17402_/B _17400_/B VDD VSS _17401_/B XOR2X1
XFILLER_73_486 VSS VDD FILLER2
X_14612_ _19440_/Q _15825_/B VDD VSS _14613_/B OR2X2
XFILLER_61_637 VSS VDD FILLER2
XFILLER_60_103 VSS VDD FILLER2
X_18380_ _18391_/CK _18513_/Q _20185_/A _20065_/RB VDD VSS DFFRQX1
X_11824_ _14460_/B _14460_/C _19174_/Q VDD VSS _11874_/B AOI21X1
X_15592_ _15592_/A _15592_/B VDD VSS _15593_/C NOR2X1
XFILLER_14_531 VSS VDD FILLER2
X_17331_ _17334_/C _17332_/B _17363_/C VDD VSS _17332_/C OAI21X1
X_14543_ _15672_/A _14543_/B VDD VSS _19248_/D NOR2X1
XTAP_TAPCELL_ROW_71_654 VDD VSS WELLTAP
XFILLER_60_158 VDD VSS FILLER4
XFILLER_159_514 VSS VDD FILLER2
X_11755_ _11793_/A _11793_/B _11762_/C VDD VSS _14426_/B XNOR3X1
XFILLER_81_52 VDD VSS FILLER4
XFILLER_81_63 VSS VDD FILLER2
XFILLER_41_361 VSS VDD FILLER2
XFILLER_14_597 VDD VSS FILLER4
X_17262_ _19808_/Q VDD VSS _17413_/B INVX1
X_10706_ _10708_/A _10708_/B _10706_/C _11378_/A VDD VSS _18562_/D AOI211X1
X_14474_ _14493_/A _14474_/B VDD VSS _19187_/D NOR2X1
XFILLER_81_96 VDD VSS FILLER4
X_11686_ _19009_/Q VDD VSS _11950_/A INVX1
XFILLER_146_208 VDD VSS DECAPHV8
X_19001_ _19086_/CK _19001_/D _19001_/Q VDD VSS DFFQX1
X_16213_ _16233_/A _16233_/B VDD VSS _16777_/B XNOR2X1
X_13425_ _13528_/A _14355_/A _13528_/C VDD VSS _14358_/B AOI21X1
X_17193_ _17197_/A _17194_/B _17229_/C VDD VSS _17194_/C OAI21X1
X_10637_ _18639_/Q _18801_/Q VDD VSS _10638_/D NOR2X1
Xclkload107 _20033_/CK VDD VSS clkload107/Y BUFX12
XFILLER_139_282 VSS VDD FILLER2
Xclkload118 _18341_/CK VDD VSS clkload118/Y INVX2
X_16144_ _16144_/A _16154_/B VDD VSS _16845_/B XNOR2X1
XFILLER_154_230 VSS VDD FILLER2
X_13356_ _13356_/A _13356_/B _13443_/D VDD VSS _13430_/C XNOR3X1
X_10568_ _10568_/A VDD VSS _10570_/C INVX1
XFILLER_114_105 VSS VDD FILLER2
XFILLER_127_488 VSS VDD FILLER2
X_12307_ _12307_/A _14437_/B _14437_/C VDD VSS _12471_/C NOR3X1
X_16075_ _19713_/Q _16876_/B VDD VSS _16079_/B XOR2X1
X_13287_ _13287_/A _13287_/B _14125_/B VDD VSS _13288_/B MIN3X1
X_10499_ _10499_/A _10499_/B _10655_/A VDD VSS _10659_/C AO21X2
XFILLER_108_691 VDD VSS FILLER4
X_15026_ _15026_/A _15026_/B _15026_/C VDD VSS _15041_/B OAI21X1
X_19903_ _19924_/CK _19903_/D _19903_/Q VDD VSS DFFQX1
XFILLER_130_609 VDD VSS FILLER1
X_12238_ _19237_/Q _14531_/B VDD VSS _12239_/D _14531_/C NAND3X1
XFILLER_111_801 VDD VSS FILLER4
XFILLER_111_823 VSS VDD FILLER2
XFILLER_123_683 VSS VDD FILLER2
X_19834_ _19895_/CK _19834_/D _19834_/Q VDD VSS DFFQX1
X_12169_ _19209_/Q _12172_/B _12224_/C VDD VSS _12329_/B XOR3X1
XTAP_TAPCELL_ROW_79_721 VDD VSS WELLTAP
XFILLER_68_225 VDD VSS FILLER1
XFILLER_150_491 VSS VDD FILLER2
X_16977_ _16975_/B _16977_/B VDD VSS _16984_/A NOR2BX1
X_19765_ clkload4/A _19765_/D _19765_/Q VDD VSS DFFQX1
XFILLER_84_729 VDD VSS FILLER4
XFILLER_110_377 VSS VDD FILLER2
X_15928_ _15936_/A _15936_/B VDD VSS _16764_/B XNOR2X1
X_18716_ _18773_/CK _18716_/D _18716_/Q VDD VSS DFFQX1
XFILLER_77_792 VSS VDD FILLER2
X_19696_ _19696_/CK _19696_/D _19696_/Q VDD VSS DFFQX1
XFILLER_83_239 VSS VDD FILLER2
XFILLER_49_494 VSS VDD FILLER2
XFILLER_37_634 VSS VDD FILLER2
XFILLER_36_122 VSS VDD FILLER2
X_18647_ _19954_/CK _18647_/D _18647_/Q VDD VSS DFFQX1
XFILLER_92_762 VSS VDD FILLER2
X_15859_ _15859_/A _15859_/B VDD VSS _15860_/B XNOR2X1
XFILLER_52_626 VDD VSS FILLER4
XFILLER_51_103 VSS VDD FILLER2
X_09380_ _18526_/Q _09380_/B VDD VSS _18223_/E AND2X1
XFILLER_24_328 VSS VDD FILLER2
X_18578_ _18578_/CK _18578_/D _18578_/Q VDD VSS DFFQX1
XTAP_TAPCELL_ROW_34_323 VDD VSS WELLTAP
XFILLER_33_840 VSS VDD FILLER2
XFILLER_17_391 VSS VDD FILLER2
XFILLER_51_147 VSS VDD FILLER2
X_17529_ _17529_/A _17529_/B VDD VSS _17530_/B XNOR2X1
XFILLER_51_169 VSS VDD FILLER2
XFILLER_32_350 VSS VDD FILLER2
XFILLER_32_372 VSS VDD FILLER2
XFILLER_138_709 VDD VSS FILLER4
XFILLER_32_394 VSS VDD FILLER2
XFILLER_165_528 VSS VDD FILLER2
XFILLER_146_742 VDD VSS FILLER4
XFILLER_106_628 VSS VDD FILLER2
XFILLER_160_200 VDD VSS FILLER4
XFILLER_10_37 VSS VDD FILLER2
XFILLER_133_447 VDD VSS DECAPHV8
XFILLER_160_244 VDD VSS DECAPHV8
XFILLER_114_650 VSS VDD FILLER2
XFILLER_120_108 VDD VSS FILLER4
XFILLER_102_823 VSS VDD FILLER2
XFILLER_87_556 VSS VDD FILLER2
XFILLER_101_344 VSS VDD FILLER2
XFILLER_142_14 VSS VDD FILLER2
XTAP_TAPCELL_ROW_148_1348 VDD VSS WELLTAP
Xclkbuf_leaf_11__002_ clkbuf_leaf_9__002_/A VDD VSS _19947_/CK BUFX12
XFILLER_74_206 VSS VDD FILLER2
XFILLER_68_770 VDD VSS FILLER1
X_09716_ _18268_/Q _09716_/B _09716_/C _09813_/C _09716_/E VDD VSS _09717_/D AOI221X1
XFILLER_142_58 VSS VDD FILLER2
XFILLER_27_122 VSS VDD FILLER2
XFILLER_27_133 VSS VDD FILLER2
XFILLER_55_453 VDD VSS FILLER1
X_09647_ _18264_/Q _09716_/B _09647_/C _09816_/D _09647_/E VDD VSS _09650_/C AOI221X1
XTAP_TAPCELL_ROW_85_779 VDD VSS WELLTAP
XFILLER_82_250 VDD VSS FILLER1
XFILLER_55_464 VDD VSS FILLER1
XFILLER_28_689 VSS VDD FILLER2
XFILLER_35_23 VSS VDD FILLER2
XFILLER_82_272 VSS VDD FILLER2
XFILLER_35_45 VSS VDD FILLER2
X_09578_ _18504_/Q _09578_/B VDD VSS _09797_/B NOR2BX1
XFILLER_42_125 VSS VDD FILLER2
XFILLER_27_199 VSS VDD FILLER2
XFILLER_42_147 VSS VDD FILLER2
X_11540_ _18691_/Q _11542_/B VDD VSS _18718_/D AND2X1
XTAP_TAPCELL_ROW_159_1444 VDD VSS WELLTAP
XFILLER_51_692 VDD VSS FILLER1
XFILLER_11_534 VSS VDD FILLER2
XFILLER_23_394 VSS VDD FILLER2
XFILLER_11_556 VSS VDD FILLER2
XFILLER_50_191 VSS VDD FILLER2
X_11471_ _19962_/Q _11473_/B VDD VSS _18655_/D AND2X1
XFILLER_156_539 VSS VDD FILLER2
XFILLER_11_589 VDD VSS FILLER4
X_13210_ _13373_/A _13373_/B _13373_/E VDD VSS _13300_/B OAI21X1
X_10422_ _10579_/D _10463_/B VDD VSS _10499_/B _10463_/C _10463_/D NAND4X2
XFILLER_136_230 VSS VDD FILLER2
X_14190_ _14136_/Y _14190_/B _14190_/C VDD VSS _18940_/D AND3BX1
X_13141_ _13141_/A _13141_/B _13141_/C _13141_/D VDD VSS _13329_/B AOAI211X1
X_10353_ _10595_/A _10388_/C VDD VSS _10354_/B NAND2X1
XFILLER_151_211 VSS VDD FILLER2
XFILLER_136_296 VSS VDD FILLER2
XTAP_TAPCELL_ROW_114_1038 VDD VSS WELLTAP
X_13072_ _18967_/Q _14218_/B VDD VSS _13083_/B XNOR2X1
XFILLER_105_650 VDD VSS FILLER1
XFILLER_124_469 VDD VSS FILLER4
X_10284_ _18630_/Q _18792_/Q VDD VSS _10338_/A NAND2X1
XFILLER_97_309 VDD VSS FILLER4
XFILLER_152_789 VDD VSS FILLER1
XFILLER_151_277 VSS VDD FILLER2
X_16900_ _16976_/A _16900_/B VDD VSS _19735_/D NOR2X1
X_12023_ _12023_/A _12023_/B _14370_/B VDD VSS _12024_/B MIN3X1
XFILLER_151_288 VDD VSS FILLER4
X_17880_ _18853_/Q _17880_/B _17880_/C VDD VSS _17885_/C MIN3X1
XFILLER_104_171 VSS VDD FILLER2
XFILLER_120_653 VSS VDD FILLER2
X_16831_ _16838_/A _16831_/B VDD VSS _19672_/D NOR2X1
XFILLER_76_30 VSS VDD FILLER2
XFILLER_116_92 VSS VDD FILLER2
XFILLER_120_675 VSS VDD FILLER2
XFILLER_76_63 VDD VSS FILLER4
X_19550_ _19602_/CK _19550_/D _19550_/Q VDD VSS DFFQX1
X_16762_ _16775_/A _16762_/B VDD VSS _19610_/D NOR2X1
Xdelaybuf_4_sclk delaybuf_4_sclk/A VDD VSS delaybuf_5_sclk/A BUFX12
X_13974_ _18894_/Q _13974_/B _14020_/C VDD VSS _17945_/C XNOR3X1
XFILLER_18_111 VSS VDD FILLER2
XFILLER_18_122 VDD VSS FILLER4
X_18501_ _18503_/CK _18501_/D _20114_/A _18503_/RB VDD VSS DFFRQX1
XTAP_TAPCELL_ROW_48_448 VDD VSS WELLTAP
X_15713_ _15739_/A _15713_/B VDD VSS _19339_/D NOR2X1
X_19481_ _19484_/CK _19481_/D _19481_/Q VDD VSS DFFQX1
X_12925_ _19133_/Q _13107_/D _12925_/C VDD VSS _13023_/C XNOR3X1
XFILLER_74_762 VDD VSS FILLER1
X_16693_ _16693_/A _16704_/B VDD VSS _19548_/D NOR2X1
XTAP_TAPCELL_ROW_125_1134 VDD VSS WELLTAP
XFILLER_61_401 VSS VDD FILLER2
XFILLER_19_689 VSS VDD FILLER2
XFILLER_18_166 VSS VDD FILLER2
XFILLER_18_177 VSS VDD FILLER2
X_18432_ _18439_/CK _18496_/D _18432_/Q _18464_/RB VDD VSS DFFRQX1
XFILLER_73_272 VSS VDD FILLER2
X_15644_ _19384_/Q _15644_/B _15644_/C VDD VSS _15654_/B MIN3X1
XFILLER_92_51 VDD VSS FILLER1
XFILLER_33_114 VSS VDD FILLER2
X_12856_ _19161_/Q _13039_/A _13108_/B VDD VSS _13107_/D XNOR3X1
XFILLER_15_840 VSS VDD FILLER2
XFILLER_15_851 VSS VDD FILLER2
X_18363_ _18374_/CK _18512_/Q _20200_/A _18471_/RB VDD VSS DFFRQX1
X_11807_ _19202_/Q _11807_/B _11828_/D VDD VSS _11830_/C XNOR3X1
XFILLER_159_300 VDD VSS FILLER4
X_15575_ _19466_/Q _15855_/B VDD VSS _15601_/B XNOR2X1
X_12787_ _13177_/A _17876_/B VDD VSS _18852_/D NOR2X1
X_17314_ _17318_/A _17315_/B _17363_/C VDD VSS _17315_/C OAI21X1
XFILLER_159_333 VSS VDD FILLER2
X_14526_ _14526_/A _14526_/B _17827_/B VDD VSS _19232_/D AOI21X1
X_18294_ _18295_/CK _18294_/D _18294_/Q VDD VSS DFFQX1
X_11738_ _11768_/A _11768_/B VDD VSS _14485_/B XNOR2X1
XFILLER_159_355 VSS VDD FILLER2
XFILLER_119_208 VSS VDD FILLER2
XFILLER_41_191 VDD VSS FILLER1
XFILLER_147_528 VSS VDD FILLER2
X_17245_ _17247_/B _17245_/B VDD VSS _17246_/B XOR2X1
X_14457_ _14457_/A VDD VSS _14493_/A BUFX3
X_11669_ _18808_/Q _11669_/B VDD VSS _18835_/D AND2X1
XFILLER_128_742 VDD VSS FILLER4
X_13408_ _13509_/A _13509_/B _13509_/C _13509_/D VDD VSS _13607_/A AOI31X1
X_17176_ _19789_/Q _19757_/Q _17176_/C VDD VSS _17180_/C MIN3X1
XTAP_TAPCELL_ROW_136_1241 VDD VSS WELLTAP
X_14388_ _14410_/A _14388_/B _14388_/C VDD VSS _19110_/D NOR3X1
XFILLER_155_550 VSS VDD FILLER2
XFILLER_155_561 VDD VSS FILLER4
XFILLER_128_797 VSS VDD FILLER2
X_16127_ _19716_/Q VDD VSS _16150_/A INVX1
X_13339_ _13339_/A _14543_/B VDD VSS _13447_/A OR2X2
XFILLER_115_436 VDD VSS DECAPHV16
XFILLER_115_458 VDD VSS FILLER1
X_16058_ _19616_/Q VDD VSS _16059_/A INVX1
XFILLER_102_108 VSS VDD FILLER2
X_15009_ _19532_/Q _19533_/Q VDD VSS _15058_/B _15009_/C NAND3X1
XFILLER_97_832 VDD VSS FILLER4
XFILLER_123_480 VSS VDD FILLER2
XFILLER_123_491 VDD VSS FILLER4
XFILLER_111_642 VSS VDD FILLER2
XFILLER_69_556 VSS VDD FILLER2
XFILLER_110_130 VSS VDD FILLER2
X_19817_ _19853_/CK _19817_/D _19817_/Q VDD VSS DFFQX1
XFILLER_110_152 VDD VSS FILLER1
XFILLER_2_71 VSS VDD FILLER2
X_19748_ _19785_/CK _19748_/D _19748_/Q VDD VSS DFFQX1
XFILLER_49_291 VDD VSS FILLER1
XFILLER_37_431 VDD VSS FILLER1
XFILLER_2_93 VSS VDD FILLER2
X_09501_ _18497_/D _09501_/B _09506_/C _20075_/Q VDD VSS _20075_/D AO22X2
X_19679_ _19722_/CK _19679_/D _19679_/Q VDD VSS DFFQX1
XFILLER_25_615 VSS VDD FILLER2
XFILLER_64_261 VDD VSS FILLER1
XFILLER_24_103 VSS VDD FILLER2
X_09432_ _09673_/C VDD VSS _09696_/B BUFX3
XTAP_TAPCELL_ROW_82_749 VDD VSS WELLTAP
XFILLER_24_125 VSS VDD FILLER2
XFILLER_64_294 VSS VDD FILLER2
XFILLER_25_659 VDD VSS DECAPHV8
XTAP_TAPCELL_ROW_19_183 VDD VSS WELLTAP
XFILLER_40_607 VSS VDD FILLER2
X_09363_ _09630_/C _09626_/B _09354_/Y VDD VSS _18504_/D MUX2X1
XFILLER_80_787 VSS VDD FILLER2
XFILLER_33_670 VDD VSS FILLER1
XFILLER_33_681 VSS VDD FILLER2
XFILLER_33_692 VDD VSS FILLER1
XFILLER_21_832 VDD VSS FILLER4
X_09294_ _18199_/A _09294_/B VDD VSS _20023_/D NOR2X1
XANTENNA_10 _17469_/B VDD VSS ANTENNA2
XFILLER_20_364 VSS VDD FILLER2
XFILLER_119_742 VSS VDD FILLER2
XFILLER_20_386 VDD VSS FILLER4
XFILLER_165_347 VSS VDD FILLER2
XFILLER_118_230 VSS VDD FILLER2
XFILLER_21_47 VSS VDD FILLER2
XFILLER_137_25 VDD VSS FILLER1
XFILLER_133_211 VSS VDD FILLER2
XTAP_TAPCELL_ROW_154_1396 VDD VSS WELLTAP
XFILLER_161_531 VSS VDD FILLER2
XFILLER_134_767 VDD VSS FILLER1
XFILLER_161_553 VDD VSS FILLER4
XFILLER_134_789 VDD VSS FILLER1
Xoutput150 _20205_/Y VDD VSS o_uwb_tx_cfg[8] BUFX3
XFILLER_133_277 VSS VDD FILLER2
XFILLER_153_13 VSS VDD FILLER2
XFILLER_88_854 VSS VDD FILLER2
XFILLER_87_320 VDD VSS FILLER1
XFILLER_0_758 VDD VSS FILLER1
XFILLER_48_707 VSS VDD FILLER2
XFILLER_87_375 VSS VDD FILLER2
XTAP_TAPCELL_ROW_98_893 VDD VSS WELLTAP
XFILLER_47_228 VSS VDD FILLER2
XFILLER_46_33 VSS VDD FILLER2
XFILLER_56_751 VSS VDD FILLER2
XFILLER_46_44 VSS VDD FILLER2
X_10971_ _11007_/A _10971_/B VDD VSS _10972_/B XNOR2X1
XTAP_TAPCELL_ROW_45_418 VDD VSS WELLTAP
XFILLER_55_272 VDD VSS FILLER1
X_12710_ _12710_/A _12717_/D VDD VSS _12713_/B XNOR2X1
XFILLER_46_99 VDD VSS DECAPHV8
X_13690_ _19028_/Q _14295_/B VDD VSS _13736_/A NAND2X1
XFILLER_70_242 VSS VDD FILLER2
XFILLER_102_72 VSS VDD FILLER2
X_12641_ _12804_/A _12804_/B _12804_/C VDD VSS _12689_/B AOI21X1
XFILLER_71_787 VSS VDD FILLER2
XFILLER_62_32 VSS VDD FILLER2
XFILLER_102_94 VSS VDD FILLER2
XFILLER_71_798 VSS VDD FILLER2
X_15360_ _15360_/A _15398_/C VDD VSS _15396_/B XNOR2X1
XFILLER_157_804 VDD VSS FILLER1
X_12572_ _12837_/A _12837_/B VDD VSS _14505_/B XNOR2X1
XFILLER_8_814 VSS VDD FILLER2
XFILLER_134_0 VDD VSS FILLER4
X_14311_ _14311_/A _14311_/B VDD VSS _19043_/D NOR2X1
XTAP_TAPCELL_ROW_120_1097 VDD VSS WELLTAP
X_11523_ _18675_/Q _11531_/B VDD VSS _18702_/D AND2X1
X_15291_ _15303_/B _15291_/B VDD VSS _15720_/B XNOR2X1
XFILLER_11_375 VDD VSS FILLER4
X_17030_ _17030_/A _17030_/B VDD VSS _17045_/A OR2X2
XFILLER_144_509 VSS VDD FILLER2
X_14242_ _14251_/A _14242_/B VDD VSS _18984_/D NOR2X1
X_11454_ _19947_/Q _11460_/B VDD VSS _18640_/D AND2X1
XFILLER_125_701 VSS VDD FILLER2
XFILLER_137_561 VSS VDD FILLER2
XFILLER_7_368 VDD VSS FILLER4
XFILLER_137_572 VSS VDD FILLER2
X_10405_ _10405_/A _10405_/B _10405_/C _10405_/D VDD VSS _10406_/B AOAI211X1
X_14173_ _14174_/B _14173_/B _15836_/C VDD VSS _18925_/D OA21X2
X_11385_ _18594_/Q _11390_/B VDD VSS _11387_/B XNOR2X1
XFILLER_164_391 VDD VSS FILLER1
X_13124_ _14477_/B _19190_/Q VDD VSS _13233_/A NAND2BX1
XFILLER_98_607 VDD VSS DECAPHV8
XFILLER_11_91 VSS VDD FILLER2
X_10336_ _18631_/Q _18793_/Q VDD VSS _10338_/C NAND2X1
X_18981_ _19037_/CK _18981_/D _18981_/Q VDD VSS DFFQX1
XFILLER_97_117 VSS VDD FILLER2
XFILLER_127_91 VSS VDD FILLER2
X_17932_ _17940_/B _17940_/C VDD VSS _17933_/B NOR2X1
X_13055_ _13255_/A _13255_/C VDD VSS _13056_/C NAND2X1
X_10267_ _11438_/A _11435_/B _11435_/A VDD VSS _10763_/A NAND3BX2
XFILLER_140_759 VSS VDD FILLER2
XTAP_TAPCELL_ROW_131_1193 VDD VSS WELLTAP
X_12006_ _19038_/Q _12076_/B _12016_/C VDD VSS _14273_/B XNOR3X1
XFILLER_94_802 VSS VDD FILLER2
XFILLER_87_84 VSS VDD FILLER2
X_17863_ _18850_/Q _17863_/B _17863_/C VDD VSS _17866_/A MIN3X1
XFILLER_120_450 VSS VDD FILLER2
X_10198_ _18618_/Q _10202_/B VDD VSS _10200_/C XOR2X1
XFILLER_94_813 VSS VDD FILLER2
XFILLER_78_375 VSS VDD FILLER2
XFILLER_94_835 VSS VDD FILLER2
X_19602_ _19602_/CK _19602_/D _19602_/Q VDD VSS DFFQX1
X_16814_ _16826_/A _16814_/B VDD VSS _19656_/D NOR2X1
X_17794_ _17795_/C _18127_/B _17794_/C VDD VSS _19922_/D AND3BX1
XFILLER_93_356 VSS VDD FILLER2
X_16745_ _16748_/A _16745_/B VDD VSS _19595_/D NOR2X1
X_19533_ _19536_/CK _19533_/D _19533_/Q VDD VSS DFFQX1
X_13957_ _13957_/A _14198_/B _13957_/C _13957_/D VDD VSS _14036_/A OAOI211X1
XFILLER_46_250 VSS VDD FILLER2
XFILLER_81_529 VDD VSS FILLER4
X_19464_ _19465_/CK _19464_/D _19464_/Q VDD VSS DFFQX1
X_12908_ _14349_/B _14349_/C _19076_/Q VDD VSS _12915_/B AOI21X1
X_16676_ _19576_/Q VDD VSS _16677_/A INVX1
X_13888_ _18976_/Q _14231_/B VDD VSS _13957_/A AND2X1
XFILLER_22_607 VSS VDD FILLER2
X_15627_ _19384_/Q _15762_/B VDD VSS _15628_/B XNOR2X1
X_18415_ _18423_/CK _18415_/D _18415_/Q _09380_/B VDD VSS DFFRQX1
X_19395_ _19460_/CK _19395_/D _19395_/Q VDD VSS DFFQX1
X_12839_ _12839_/A _14506_/B _14506_/C VDD VSS _12840_/D NOR3X1
XTAP_TAPCELL_ROW_16_153 VDD VSS WELLTAP
XFILLER_21_106 VSS VDD FILLER2
X_18346_ _18359_/CK _18346_/D _18346_/Q _18373_/RB VDD VSS DFFRQX1
XFILLER_148_804 VSS VDD FILLER2
X_15558_ _19353_/Q _15728_/B VDD VSS _15566_/B XNOR2X1
XFILLER_14_191 VDD VSS FILLER4
X_14509_ _14539_/A _14509_/B VDD VSS _19216_/D NOR2X1
XFILLER_147_325 VDD VSS FILLER1
X_18277_ _18277_/CK _18277_/D _18277_/Q _09270_/Y VDD VSS DFFRQX1
X_15489_ _15525_/A _15489_/B VDD VSS _15756_/B XNOR2X1
XTAP_TAPCELL_ROW_0_3 VDD VSS WELLTAP
XFILLER_30_695 VSS VDD FILLER2
X_17228_ _19801_/Q _19769_/Q VDD VSS _17230_/B XNOR2X1
XFILLER_135_509 VSS VDD FILLER2
XFILLER_163_818 VSS VDD FILLER2
XFILLER_162_328 VSS VDD FILLER2
X_17159_ _19786_/Q _19754_/Q VDD VSS _17160_/C NAND2X1
XFILLER_115_222 VDD VSS FILLER4
X_20170_ _20170_/A VDD VSS _20170_/Y BUFX3
XFILLER_107_28 VDD VSS FILLER4
X_09981_ _09981_/A _11399_/C _09981_/C VDD VSS _09996_/B AOI21X1
XFILLER_115_288 VSS VDD FILLER2
XFILLER_111_461 VDD VSS FILLER4
XFILLER_69_375 VSS VDD FILLER2
XFILLER_111_472 VDD VSS FILLER1
XFILLER_85_835 VSS VDD FILLER2
XFILLER_123_16 VSS VDD FILLER2
XFILLER_84_323 VSS VDD FILLER2
XFILLER_57_537 VSS VDD FILLER2
XFILLER_123_38 VSS VDD FILLER2
XTAP_TAPCELL_ROW_145_1318 VDD VSS WELLTAP
XFILLER_84_334 VDD VSS FILLER1
XFILLER_57_548 VSS VDD FILLER2
XFILLER_84_378 VDD VSS DECAPHV8
XFILLER_72_529 VSS VDD FILLER2
XFILLER_38_784 VDD VSS FILLER4
XFILLER_38_795 VDD VSS FILLER1
XTAP_TAPCELL_ROW_107_975 VDD VSS WELLTAP
XFILLER_16_25 VDD VSS FILLER1
XFILLER_53_743 VDD VSS FILLER1
XFILLER_80_540 VDD VSS FILLER4
XFILLER_53_765 VDD VSS FILLER4
XFILLER_52_242 VDD VSS FILLER4
X_09415_ _20067_/Q _20015_/Q VDD VSS _09421_/A NAND2X1
XFILLER_53_776 VSS VDD FILLER2
XFILLER_52_253 VSS VDD FILLER2
XFILLER_52_275 VSS VDD FILLER2
XFILLER_12_128 VSS VDD FILLER2
X_09346_ _20073_/RB _09346_/B VDD VSS _09346_/Y NOR2BX1
XFILLER_139_826 VSS VDD FILLER2
XTAP_TAPCELL_ROW_156_1414 VDD VSS WELLTAP
XTAP_TAPCELL_ROW_50_465 VDD VSS WELLTAP
X_09277_ _09277_/A _09277_/B VDD VSS _09351_/C NAND2X1
XFILLER_21_673 VDD VSS DECAPHV8
XFILLER_138_347 VSS VDD FILLER2
XFILLER_165_133 VSS VDD FILLER2
XFILLER_120_6 VSS VDD FILLER2
XTAP_TAPCELL_ROW_3_39 VDD VSS WELLTAP
XFILLER_166_678 VSS VDD FILLER2
XFILLER_119_550 VDD VSS DECAPHV8
XFILLER_166_689 VSS VDD FILLER2
XFILLER_165_155 VSS VDD FILLER2
XFILLER_119_561 VSS VDD FILLER2
XFILLER_107_712 VDD VSS FILLER1
XFILLER_119_572 VSS VDD FILLER2
XFILLER_153_328 VSS VDD FILLER2
XFILLER_165_199 VDD VSS FILLER4
XFILLER_4_338 VSS VDD FILLER2
XFILLER_106_244 VSS VDD FILLER2
X_11170_ _18655_/Q _18817_/Q VDD VSS _11204_/A XNOR2X1
XTAP_TAPCELL_ROW_111_1008 VDD VSS WELLTAP
XFILLER_106_277 VDD VSS DECAPHV8
X_10121_ _10122_/A _10123_/C _10123_/B VDD VSS _10124_/B OR3BX1
XFILLER_0_522 VSS VDD FILLER2
XFILLER_164_67 VSS VDD FILLER2
XFILLER_164_89 VSS VDD FILLER2
X_10052_ _10180_/A _11410_/C VDD VSS _18532_/D NOR2X1
XFILLER_76_802 VDD VSS FILLER4
XFILLER_94_109 VDD VSS DECAPHV8
XFILLER_76_813 VSS VDD FILLER2
XFILLER_76_824 VDD VSS FILLER1
XFILLER_0_588 VSS VDD FILLER2
XFILLER_0_599 VSS VDD FILLER2
XFILLER_75_323 VSS VDD FILLER2
X_14860_ _14861_/B _14861_/C _14861_/A VDD VSS _14911_/B OAI21X1
XTAP_TAPCELL_ROW_58_532 VDD VSS WELLTAP
X_13811_ _13812_/B _13877_/B _18891_/Q VDD VSS _13868_/B AOI21X1
XFILLER_63_507 VDD VSS DECAPHV8
X_14791_ _14872_/D _14826_/C VDD VSS _14872_/C NAND2X1
XFILLER_63_529 VDD VSS FILLER4
Xclkbuf_leaf_9__000_ clkload72/A VDD VSS _19636_/CK BUFX12
XFILLER_113_60 VSS VDD FILLER2
XFILLER_29_795 VSS VDD FILLER2
X_16530_ _16548_/A _16548_/B VDD VSS _16789_/B XNOR2X1
X_13742_ _17920_/A _17920_/B _17921_/C VDD VSS _17925_/B OAI21X1
XFILLER_90_348 VSS VDD FILLER2
X_10954_ _10954_/A _10954_/B _10954_/C _10954_/D VDD VSS _10957_/C AOAI211X1
XTAP_TAPCELL_ROW_122_1115 VDD VSS WELLTAP
X_16461_ _19696_/Q _16857_/B VDD VSS _16469_/C XOR2X1
X_13673_ _13807_/A _13807_/B _13807_/C VDD VSS _13741_/B AOI21X1
X_10885_ _10885_/A _10885_/B _10885_/C VDD VSS _10888_/B OAI21X1
XFILLER_31_415 VSS VDD FILLER2
X_18200_ _20014_/Q _20016_/Q _18201_/A VDD VSS _18200_/Y AOI2B1X1
X_15412_ _19377_/Q _15754_/B VDD VSS _15425_/C XOR2X1
XFILLER_31_437 VSS VDD FILLER2
X_19180_ _19191_/CK _19180_/D _19180_/Q VDD VSS DFFQX1
X_12624_ _19019_/Q VDD VSS _12892_/A INVX1
X_16392_ _16377_/B _16392_/B VDD VSS _16402_/B NAND2BX1
XTAP_TAPCELL_ROW_13_134 VDD VSS WELLTAP
X_18131_ _18131_/A _18131_/B _18131_/C VDD VSS _18136_/B OA21X2
X_15343_ _15343_/A _15343_/B VDD VSS _15376_/B AND2X1
XFILLER_156_100 VDD VSS FILLER4
X_12555_ _12593_/A _12593_/B _12556_/D _12593_/E VDD VSS _14378_/B OA211X2
XFILLER_157_634 VSS VDD FILLER2
XFILLER_156_111 VSS VDD FILLER2
XFILLER_12_695 VSS VDD FILLER2
XFILLER_157_656 VDD VSS FILLER1
X_18062_ _18064_/A _18064_/B _18062_/C VDD VSS _19987_/D AOI21X1
X_11506_ _18660_/Q _11508_/B VDD VSS _18687_/D AND2X1
XFILLER_129_369 VSS VDD FILLER2
X_15274_ _15274_/A _15274_/B _15274_/C _15274_/D VDD VSS _15307_/C AOAI211X1
X_12486_ _12486_/A _12486_/B _12497_/C VDD VSS _12566_/B XNOR3X1
XFILLER_144_328 VSS VDD FILLER2
X_17013_ _17019_/C _17013_/B VDD VSS _17014_/B XOR2X1
X_14225_ _14294_/A wire154/Y _14225_/C VDD VSS _18971_/D NOR3X1
X_11437_ _232_/E _11438_/B _11437_/C VDD VSS _18627_/D NOR3X1
XTAP_TAPCELL_ROW_133_1211 VDD VSS WELLTAP
XFILLER_125_531 VSS VDD FILLER2
XFILLER_153_840 VSS VDD FILLER2
XFILLER_152_350 VDD VSS FILLER4
X_14156_ _14186_/A _14156_/B VDD VSS _18911_/D NOR2X1
XFILLER_98_404 VDD VSS FILLER1
X_11368_ _11368_/A _11375_/C VDD VSS _11369_/B XOR2X1
XFILLER_113_726 VDD VSS FILLER4
X_13107_ _13107_/A _13107_/B _13107_/C _13107_/D VDD VSS _13111_/B AOAI211X1
XFILLER_98_94 VDD VSS FILLER4
X_10319_ _18657_/Q _18765_/Q VDD VSS _10323_/A NAND2X1
X_18964_ _18997_/CK _18964_/D _18964_/Q VDD VSS DFFQX1
X_14087_ _18925_/Q _14174_/B _14173_/B VDD VSS _14089_/C NOR3X1
X_11299_ _11182_/Y _11370_/B _11370_/A VDD VSS _11308_/C MUX2X1
X_17915_ _17920_/B _17915_/B VDD VSS _17919_/B NOR2X1
X_13038_ _13039_/A _13039_/B _13039_/D _13039_/C VDD VSS _13138_/B OAOI211X1
X_18895_ _18924_/CK _18895_/D _18895_/Q VDD VSS DFFQX1
XFILLER_67_835 VSS VDD FILLER2
XFILLER_121_792 VSS VDD FILLER2
XFILLER_78_172 VSS VDD FILLER2
XFILLER_66_323 VSS VDD FILLER2
X_17846_ _17847_/C _17846_/B _17846_/C VDD VSS _19937_/D AOI21X1
XFILLER_93_120 VSS VDD FILLER2
XFILLER_94_665 VDD VSS FILLER1
XFILLER_93_142 VDD VSS FILLER1
X_14989_ _19311_/Q _14989_/B _15682_/B VDD VSS _15036_/B MIN3X1
X_17777_ _19919_/Q _19887_/Q VDD VSS _17778_/B XOR2X1
XFILLER_47_570 VSS VDD FILLER2
X_19516_ _19736_/CK _19516_/D _19516_/Q VDD VSS DFFQX1
XTAP_TAPCELL_ROW_92_844 VDD VSS WELLTAP
X_16728_ _16735_/A _16728_/B VDD VSS _19579_/D NOR2X1
XFILLER_81_348 VDD VSS FILLER4
XFILLER_34_220 VSS VDD FILLER2
XFILLER_35_765 VSS VDD FILLER2
XFILLER_62_551 VSS VDD FILLER2
XFILLER_34_242 VDD VSS FILLER4
XTAP_TAPCELL_ROW_104_945 VDD VSS WELLTAP
X_16659_ _19640_/Q _16673_/A VDD VSS _16660_/B XNOR2X1
X_19447_ _19466_/CK _19447_/D _19447_/Q VDD VSS DFFQX1
XFILLER_50_724 VSS VDD FILLER2
XFILLER_22_415 VSS VDD FILLER2
X_09200_ _18511_/Q VDD VSS _18442_/D INVX1
XFILLER_97_0 VSS VDD FILLER2
X_19378_ _19379_/CK _19378_/D _19378_/Q VDD VSS DFFQX1
XFILLER_147_100 VSS VDD FILLER2
XFILLER_148_623 VDD VSS FILLER1
X_18329_ _18341_/CK _18510_/Q _20083_/A _18374_/RB VDD VSS DFFRQX1
XFILLER_147_122 VSS VDD FILLER2
XFILLER_30_492 VDD VSS FILLER1
XFILLER_148_678 VDD VSS FILLER1
XFILLER_116_520 VSS VDD FILLER2
XFILLER_163_648 VSS VDD FILLER2
XFILLER_118_38 VSS VDD FILLER2
XFILLER_118_49 VSS VDD FILLER2
X_20222_ _20222_/A VDD VSS _20222_/Y BUFX3
XFILLER_116_586 VSS VDD FILLER2
XFILLER_131_523 VSS VDD FILLER2
X_20153_ _20153_/A VDD VSS _20153_/Y BUFX3
XFILLER_58_802 VDD VSS FILLER1
X_20084_ _20084_/A VDD VSS _20084_/Y BUFX3
XFILLER_69_150 VDD VSS FILLER4
XFILLER_112_770 VSS VDD FILLER2
X_09895_ _11208_/A _09895_/B _09895_/C _09895_/D VDD VSS _09935_/B AOI211X1
XFILLER_85_610 VSS VDD FILLER2
XFILLER_112_781 VSS VDD FILLER2
XFILLER_85_654 VDD VSS FILLER4
XFILLER_84_142 VDD VSS FILLER4
XFILLER_73_816 VDD VSS DECAPHV8
XFILLER_57_367 VDD VSS FILLER4
XFILLER_17_209 VSS VDD FILLER2
XFILLER_57_389 VDD VSS FILLER4
XFILLER_84_175 VSS VDD FILLER2
XTAP_TAPCELL_ROW_162_1473 VDD VSS WELLTAP
XTAP_TAPCELL_ROW_27_259 VDD VSS WELLTAP
XFILLER_25_242 VDD VSS FILLER4
XFILLER_26_776 VSS VDD FILLER2
XFILLER_41_713 VDD VSS FILLER1
XFILLER_13_426 VSS VDD FILLER2
XFILLER_41_735 VDD VSS DECAPHV8
XFILLER_25_286 VSS VDD FILLER2
XFILLER_80_392 VDD VSS FILLER4
X_10670_ _18561_/Q _10670_/B VDD VSS _10671_/A NAND2X1
XFILLER_41_768 VDD VSS FILLER4
XFILLER_40_245 VSS VDD FILLER2
XFILLER_43_78 VSS VDD FILLER2
XFILLER_40_256 VDD VSS FILLER4
X_09329_ _18287_/Q _18515_/Q _09299_/Y VDD VSS _09329_/Y MUXI2X1
XFILLER_166_420 VSS VDD FILLER2
XTAP_TAPCELL_ROW_10_104 VDD VSS WELLTAP
XFILLER_138_144 VDD VSS FILLER1
XFILLER_166_453 VDD VSS DECAPHV8
X_12340_ _12354_/A _12354_/B _14210_/B VDD VSS _14179_/B XNOR3X1
XFILLER_126_306 VSS VDD FILLER2
XFILLER_154_615 VDD VSS FILLER1
XFILLER_126_317 VDD VSS FILLER1
XFILLER_126_328 VSS VDD FILLER2
XFILLER_138_188 VSS VDD FILLER2
X_09959__230 _20052_/CK VDD VSS _18506_/CK INVX1
XFILLER_5_625 VDD VSS FILLER1
XFILLER_126_339 VDD VSS FILLER1
XFILLER_154_648 VDD VSS DECAPHV8
XFILLER_111_2 VDD VSS FILLER1
X_12271_ _18873_/Q _14113_/B VDD VSS _12272_/B OR2X2
XFILLER_135_840 VDD VSS FILLER4
X_14010_ wire153/Y _14010_/B _14010_/C _14010_/D VDD VSS _14268_/B OAOI211X1
X_11222_ _11222_/A _11222_/B VDD VSS _11241_/A AND2X1
XFILLER_107_575 VSS VDD FILLER2
XFILLER_134_361 VSS VDD FILLER2
XFILLER_122_523 VDD VSS FILLER1
XFILLER_150_832 VDD VSS FILLER1
X_11153_ _10881_/B _11152_/Y _11289_/A VDD VSS _11159_/B MUXI2X1
XFILLER_1_831 VDD VSS FILLER4
XFILLER_161_191 VDD VSS FILLER1
XFILLER_68_53 VSS VDD FILLER2
X_10104_ _10090_/Y _10103_/Y _10127_/A VDD VSS _10129_/B MUX2X1
X_15961_ _19581_/Q _15961_/B _16730_/B VDD VSS _15993_/A MIN3X1
X_11084_ _18573_/Q _11084_/B VDD VSS _11086_/C XOR2X1
XFILLER_67_109 VSS VDD FILLER2
XFILLER_103_770 VSS VDD FILLER2
XFILLER_122_589 VDD VSS FILLER4
XFILLER_0_363 VDD VSS FILLER4
XFILLER_88_470 VSS VDD FILLER2
XFILLER_49_835 VSS VDD FILLER2
X_14912_ _14956_/A _14956_/B VDD VSS _14940_/A AND2X1
X_17700_ _17702_/B _17700_/B VDD VSS _17701_/B XOR2X1
X_10035_ _09950_/Y _10033_/Y _10167_/A VDD VSS _10035_/Y MUXI2X1
XFILLER_48_323 VSS VDD FILLER2
X_15892_ _15895_/A _15892_/B VDD VSS _19499_/D NOR2X1
X_18680_ _19959_/CK _18680_/D _18680_/Q VDD VSS DFFQX1
X_14843_ _19420_/Q _14911_/A _15803_/B VDD VSS _15770_/B XNOR3X1
X_17631_ _17634_/C _17632_/B _17654_/C VDD VSS _17632_/C OAI21X1
XFILLER_76_687 VDD VSS DECAPHV8
XFILLER_36_529 VSS VDD FILLER2
XFILLER_63_315 VDD VSS FILLER4
XFILLER_91_635 VDD VSS FILLER4
X_17562_ _17712_/B _17562_/B _17562_/C VDD VSS _17567_/C MIN3X1
XFILLER_63_348 VDD VSS FILLER4
X_14774_ _19418_/Q _14774_/B _14774_/C VDD VSS _14813_/B MIN3X1
XFILLER_90_134 VDD VSS FILLER4
X_11986_ _12099_/B _14494_/C _19205_/Q VDD VSS _11987_/D AND3BX1
XFILLER_91_668 VSS VDD FILLER2
XFILLER_17_754 VSS VDD FILLER2
X_16513_ _16776_/A VDD VSS _16735_/A BUFX3
Xclkbuf_2_1__f__09182_ clkbuf_0__09182_/Y VDD VSS _18589_/CK BUFX12
X_19301_ _19331_/CK _19301_/D _19301_/Q VDD VSS DFFQX1
X_13725_ _19058_/Q _13725_/B _13781_/C VDD VSS _13783_/C XOR3X1
X_17493_ _17496_/A _17493_/B _17493_/C VDD VSS _19857_/D AOI21X1
X_10937_ _10937_/A _10967_/C VDD VSS _10943_/B XNOR2X1
XFILLER_71_370 VSS VDD FILLER2
XFILLER_17_798 VDD VSS FILLER4
X_16444_ _16469_/A _16469_/B VDD VSS _16462_/A NAND2X1
X_19232_ _19995_/CK _19232_/D _19232_/Q VDD VSS DFFQX1
X_13656_ _13656_/A _13656_/B _14194_/B _13656_/D _13656_/E VDD VSS _13748_/C OAI221X1
XTAP_TAPCELL_ROW_101_926 VDD VSS WELLTAP
X_10868_ _18673_/Q _18781_/Q VDD VSS _10873_/A XOR2X1
XFILLER_31_256 VDD VSS FILLER1
X_19163_ _19166_/CK _19163_/D _19163_/Q VDD VSS DFFQX1
X_12607_ _17861_/A _17862_/A _17861_/B VDD VSS _17869_/B XNOR3X1
X_16375_ _16398_/A _16375_/B VDD VSS _16783_/B XOR2X1
X_13587_ _13656_/D _13688_/A _13675_/B VDD VSS _13589_/D XNOR3X1
X_10799_ _18671_/Q _18779_/Q VDD VSS _10801_/C XOR2X1
XFILLER_157_442 VSS VDD FILLER2
X_18114_ _18114_/A VDD VSS _18117_/B INVX1
X_15326_ _15347_/A _15347_/B _15347_/C VDD VSS _15327_/B AOI21X1
XFILLER_129_155 VDD VSS FILLER4
XFILLER_145_604 VSS VDD FILLER2
X_19094_ _19094_/CK _19094_/D _19094_/Q VDD VSS DFFQX1
X_12538_ _12630_/A _12803_/B VDD VSS _14314_/B XNOR2X1
XFILLER_8_452 VSS VDD FILLER2
XFILLER_157_464 VDD VSS FILLER1
XFILLER_157_486 VSS VDD FILLER2
X_18045_ _18048_/B _18045_/B _18045_/C _18049_/D VDD VSS _19980_/D OAI31X1
X_15257_ _15672_/A _18118_/B VDD VSS _19289_/D NOR2X1
X_12469_ _19128_/Q _14407_/B VDD VSS _12593_/E _14407_/C NAND3X1
XFILLER_160_607 VSS VDD FILLER2
XFILLER_144_158 VSS VDD FILLER2
X_14208_ _14218_/A _14208_/B VDD VSS _18957_/D NOR2X1
XFILLER_125_350 VDD VSS DECAPHV8
XFILLER_99_713 VDD VSS FILLER1
X_15188_ _19511_/Q _15905_/B VDD VSS _15275_/D NOR2BX1
XFILLER_153_670 VDD VSS FILLER4
XFILLER_99_735 VSS VDD FILLER2
XFILLER_153_681 VSS VDD FILLER2
XFILLER_4_680 VSS VDD FILLER2
X_14139_ _14136_/Y _14139_/B _14139_/C VDD VSS _18896_/D AND3BX1
XFILLER_4_691 VDD VSS FILLER1
XFILLER_113_556 VSS VDD FILLER2
X_19996_ _19996_/CK _19996_/D _19996_/Q VDD VSS DFFQX1
Xclkbuf_0__09172_ _18221_/ECK VDD VSS clkbuf_0__09172_/Y BUFX12
X_18947_ _19059_/CK _18947_/D _18947_/Q VDD VSS DFFQX1
XFILLER_86_429 VSS VDD FILLER2
XFILLER_79_470 VDD VSS FILLER1
XFILLER_100_228 VDD VSS FILLER4
XTAP_TAPCELL_ROW_69_638 VDD VSS WELLTAP
X_09680_ _09680_/A _09680_/B VDD VSS _09681_/B _09680_/C NAND3X1
XFILLER_66_120 VSS VDD FILLER2
X_18878_ _18905_/CK _18878_/D _18878_/Q VDD VSS DFFQX1
XFILLER_67_654 VDD VSS FILLER4
XFILLER_66_131 VDD VSS FILLER1
XFILLER_12_0 VSS VDD FILLER2
XFILLER_66_142 VSS VDD FILLER2
XFILLER_82_602 VSS VDD FILLER2
XFILLER_27_518 VDD VSS FILLER1
X_17829_ _19930_/Q _19931_/Q _17829_/C VDD VSS _19931_/D AOI21X1
XFILLER_82_624 VSS VDD FILLER2
XFILLER_39_389 VSS VDD FILLER2
XFILLER_66_186 VSS VDD FILLER2
XFILLER_81_123 VDD VSS DECAPHV8
XFILLER_70_819 VDD VSS FILLER1
XFILLER_23_713 VSS VDD FILLER2
XFILLER_120_39 VSS VDD FILLER2
XFILLER_81_189 VSS VDD FILLER2
XFILLER_50_510 VDD VSS FILLER1
XFILLER_35_584 VDD VSS FILLER1
XTAP_TAPCELL_ROW_24_229 VDD VSS WELLTAP
XFILLER_50_521 VDD VSS DECAPHV8
XFILLER_148_475 VSS VDD FILLER2
XFILLER_108_328 VDD VSS FILLER4
XFILLER_163_434 VSS VDD FILLER2
XFILLER_163_445 VDD VSS FILLER1
XFILLER_117_840 VDD VSS FILLER4
Xclkbuf_leaf_8__001_ clkload32/A VDD VSS _19996_/CK BUFX12
XFILLER_145_25 VSS VDD FILLER2
XFILLER_104_523 VSS VDD FILLER2
Xmax_cap171 _10330_/B VDD VSS _10875_/C BUFX6
X_20205_ _20205_/A VDD VSS _20205_/Y BUFX3
XFILLER_145_47 VDD VSS FILLER4
XFILLER_104_556 VSS VDD FILLER2
XFILLER_131_342 VSS VDD FILLER2
XFILLER_104_578 VSS VDD FILLER2
X_20136_ _20136_/A VDD VSS _20136_/Y BUFX3
X_09947_ _18576_/Q _09947_/B VDD VSS _09999_/C NOR2BX1
XFILLER_89_278 VDD VSS FILLER1
XFILLER_77_418 VDD VSS FILLER4
XFILLER_131_375 VDD VSS FILLER4
XFILLER_131_397 VDD VSS FILLER4
XFILLER_58_621 VDD VSS FILLER1
X_20067_ clkload6/A _20067_/D _20067_/Q _20067_/RB VDD VSS DFFRQX1
X_09878_ _18565_/Q _09878_/B VDD VSS _09911_/B XNOR2X1
XFILLER_161_46 VDD VSS FILLER4
XFILLER_57_164 VDD VSS FILLER4
XFILLER_100_784 VDD VSS FILLER1
XFILLER_57_175 VSS VDD FILLER2
XFILLER_45_315 VDD VSS FILLER4
X_11840_ _11979_/A _14490_/B VDD VSS _11871_/B NOR2X1
XFILLER_26_551 VSS VDD FILLER2
XFILLER_72_167 VSS VDD FILLER2
XFILLER_54_44 VSS VDD FILLER2
X_11771_ _19992_/Q _19256_/Q VDD VSS _11778_/D XNOR2X1
XFILLER_53_370 VSS VDD FILLER2
XFILLER_14_735 VSS VDD FILLER2
X_13510_ _18999_/Q _13683_/A _13683_/B VDD VSS _13511_/D XNOR3X1
XFILLER_54_88 VDD VSS FILLER4
X_10722_ _10722_/A _10722_/B VDD VSS _10725_/C OR2X2
XFILLER_54_99 VDD VSS FILLER4
X_14490_ _14490_/A _14490_/B _14490_/C VDD VSS _19202_/D NOR3X1
XFILLER_13_245 VSS VDD FILLER2
XFILLER_41_565 VSS VDD FILLER2
XFILLER_13_267 VSS VDD FILLER2
XFILLER_70_10 VSS VDD FILLER2
XFILLER_110_72 VDD VSS FILLER1
Xclkbuf_leaf_12__000_ clkload71/A VDD VSS _19722_/CK BUFX12
X_13441_ _19166_/Q VDD VSS _13542_/A INVX1
XFILLER_158_239 VDD VSS FILLER1
X_10653_ _10686_/D _10653_/B _10653_/C _10653_/D VDD VSS _10697_/B AOI211X1
XFILLER_139_453 VSS VDD FILLER2
X_16160_ _19557_/Q _19909_/Q VDD VSS _16161_/B XNOR2X1
X_13372_ _13373_/D _14292_/B VDD VSS _13509_/A NAND2X1
XFILLER_139_475 VDD VSS DECAPHV8
X_10584_ _11267_/A _10737_/B _10737_/C _10584_/D VDD VSS _10880_/B OAI31X1
Xclkload19 _18788_/CK VDD VSS clkload19/Y INVX2
XFILLER_5_400 VSS VDD FILLER2
X_15111_ _15112_/A _15112_/B _15112_/D _15112_/C VDD VSS _15198_/B OAOI211X1
XFILLER_126_125 VSS VDD FILLER2
X_12323_ _20003_/Q _19267_/Q VDD VSS _12577_/A XOR2X1
X_16091_ _16109_/B _16091_/B VDD VSS _16107_/A XNOR2X1
XFILLER_166_294 VDD VSS DECAPHV8
XFILLER_108_851 VSS VDD FILLER2
XFILLER_142_607 VSS VDD FILLER2
Xclkbuf_leaf_27__000_ clkload70/A VDD VSS _19385_/CK BUFX12
XFILLER_126_169 VSS VDD FILLER2
X_15042_ _19397_/Q VDD VSS _15082_/A INVX1
XTAP_TAPCELL_ROW_117_1069 VDD VSS WELLTAP
XFILLER_5_455 VSS VDD FILLER2
X_12254_ _12254_/A _12254_/B VDD VSS _14372_/B XNOR2X1
XFILLER_107_361 VSS VDD FILLER2
XFILLER_5_477 VDD VSS FILLER1
XFILLER_135_681 VDD VSS FILLER4
XFILLER_141_128 VDD VSS FILLER1
X_11205_ _18656_/Q _18818_/Q VDD VSS _11206_/B XNOR2X1
XFILLER_48_9 VSS VDD FILLER2
XFILLER_122_320 VDD VSS FILLER4
X_19850_ _19853_/CK _19850_/D _19850_/Q VDD VSS DFFQX1
X_12185_ _12206_/A _12210_/D VDD VSS _12449_/C XNOR2X1
XFILLER_150_651 VSS VDD FILLER2
XFILLER_79_96 VDD VSS FILLER4
X_18801_ _18801_/CK _18801_/D _18801_/Q VDD VSS DFFQX1
X_11136_ _18653_/Q _18815_/Q _11136_/C VDD VSS _11138_/B MIN3X1
X_19781_ _19785_/CK _19781_/D _19781_/Q VDD VSS DFFQX1
XFILLER_96_738 VSS VDD FILLER2
XFILLER_150_695 VSS VDD FILLER2
X_16993_ _17095_/A _16993_/B VDD VSS _19753_/D NOR2X1
XFILLER_1_683 VDD VSS FILLER1
XFILLER_135_91 VSS VDD FILLER2
XFILLER_49_632 VDD VSS FILLER1
X_18732_ _18788_/CK _18732_/D _18732_/Q VDD VSS DFFQX1
X_15944_ _15960_/A _15944_/B VDD VSS _16765_/B XOR2X1
X_11067_ _18678_/Q _18786_/Q _11067_/C VDD VSS _11068_/B MIN3X1
XFILLER_95_259 VSS VDD FILLER2
XFILLER_49_654 VSS VDD FILLER2
XFILLER_48_131 VDD VSS DECAPHV8
XTAP_TAPCELL_ROW_66_608 VDD VSS WELLTAP
XFILLER_48_142 VDD VSS FILLER4
XFILLER_64_602 VSS VDD FILLER2
XFILLER_37_816 VSS VDD FILLER2
X_10018_ _10034_/A _10018_/B _10018_/C VDD VSS _10018_/Y AO21X2
X_15875_ _14522_/Y _15875_/B _15875_/C VDD VSS _19483_/D AND3BX1
X_18663_ _18799_/CK _18663_/D _18663_/Q VDD VSS DFFQX1
XFILLER_37_849 VSS VDD FILLER2
XTAP_TAPCELL_ROW_128_1165 VDD VSS WELLTAP
X_14826_ _14826_/A _14826_/B _14826_/C _14826_/D VDD VSS _15015_/A OAOI211X1
X_17614_ _17618_/A _17615_/B _17654_/C VDD VSS _17615_/C OAI21X1
X_18594_ _18595_/CK _18594_/D _18594_/Q VDD VSS DFFQX1
XFILLER_64_679 VSS VDD FILLER2
X_14757_ _19390_/Q _15768_/B VDD VSS _14759_/A XOR2X1
X_17545_ _17675_/A _17545_/B VDD VSS _19869_/D NOR2X1
X_11969_ _11969_/A _11973_/D VDD VSS _14400_/B XNOR2X1
XFILLER_63_189 VDD VSS FILLER4
XFILLER_32_510 VDD VSS FILLER1
XFILLER_60_830 VSS VDD FILLER2
X_13708_ _13779_/B _13779_/C VDD VSS _14361_/B OR2X2
X_17476_ _17477_/A _17479_/C _17509_/C VDD VSS _17477_/C OAI21X1
X_14688_ _19388_/Q _15766_/B VDD VSS _14689_/B XOR2X1
XFILLER_149_217 VSS VDD FILLER2
XFILLER_32_565 VSS VDD FILLER2
X_19215_ _19217_/CK _19215_/D _19215_/Q VDD VSS DFFQX1
X_16427_ _19631_/Q _16785_/B VDD VSS _16429_/C XNOR2X1
X_13639_ _14453_/A _14453_/B _13639_/C VDD VSS _13640_/D AOI21X1
X_16358_ _16355_/A _16358_/B _16358_/C VDD VSS _16383_/A AOI2B1X1
X_19146_ _19196_/CK _19146_/D _19146_/Q VDD VSS DFFQX1
XTAP_TAPCELL_ROW_139_1261 VDD VSS WELLTAP
XFILLER_74_2 VDD VSS FILLER1
XFILLER_8_260 VSS VDD FILLER2
X_15309_ _19486_/Q _15878_/B _15878_/C _15844_/B VDD VSS _15364_/A AOI31X1
XFILLER_9_794 VDD VSS FILLER1
X_16289_ _16289_/A _16311_/B VDD VSS _16780_/B XOR2X1
X_19077_ _19134_/CK _19077_/D _19077_/Q VDD VSS DFFQX1
XFILLER_133_607 VSS VDD FILLER2
X_18028_ _18535_/Q _18030_/B VDD VSS _18029_/B XNOR2X1
XFILLER_99_521 VSS VDD FILLER2
XFILLER_160_437 VDD VSS FILLER1
XFILLER_114_832 VSS VDD FILLER2
Xfanout206 _18442_/RB VDD VSS _09380_/B BUFX3
Xfanout217 _20075_/RB VDD VSS _18491_/RB BUFX3
X_09801_ _20226_/A _09811_/C _09815_/C _18326_/Q _09801_/E VDD VSS _09802_/C AOI221X1
XFILLER_101_504 VDD VSS FILLER1
XFILLER_59_418 VDD VSS FILLER4
XFILLER_113_375 VSS VDD FILLER2
XFILLER_140_161 VSS VDD FILLER2
X_19979_ _19986_/CK _19979_/D _19979_/Q VDD VSS DFFQX1
XFILLER_87_749 VDD VSS FILLER1
XFILLER_86_237 VDD VSS FILLER1
XFILLER_101_548 VSS VDD FILLER2
X_09732_ _18354_/Q VDD VSS _20222_/A INVX1
X_09663_ _18301_/Q _09782_/B _09813_/C _20138_/A _09663_/E VDD VSS _09664_/C AOI221X1
XFILLER_94_270 VSS VDD FILLER2
XFILLER_28_849 VSS VDD FILLER2
XFILLER_82_421 VSS VDD FILLER2
XFILLER_82_443 VSS VDD FILLER2
X_09594_ _09729_/D _09594_/B VDD VSS _09601_/C NAND2BX1
XFILLER_43_808 VDD VSS DECAPHV8
XFILLER_27_359 VDD VSS FILLER4
XTAP_TAPCELL_ROW_37_343 VDD VSS WELLTAP
XFILLER_42_307 VDD VSS FILLER4
XFILLER_70_638 VDD VSS FILLER1
XFILLER_23_510 VSS VDD FILLER2
XFILLER_35_370 VSS VDD FILLER2
XFILLER_23_565 VDD VSS FILLER1
XFILLER_24_58 VSS VDD FILLER2
XFILLER_23_598 VDD VSS DECAPHV8
XFILLER_50_384 VSS VDD FILLER2
XFILLER_138_7 VSS VDD FILLER2
XFILLER_149_762 VSS VDD FILLER2
XFILLER_10_248 VSS VDD FILLER2
XFILLER_148_261 VSS VDD FILLER2
XFILLER_148_283 VDD VSS FILLER1
XFILLER_40_35 VDD VSS FILLER4
XFILLER_164_743 VSS VDD FILLER2
XFILLER_163_220 VSS VDD FILLER2
XFILLER_164_765 VSS VDD FILLER2
XFILLER_124_607 VSS VDD FILLER2
XFILLER_124_629 VDD VSS FILLER1
XFILLER_164_798 VSS VDD FILLER2
XFILLER_105_832 VDD VSS FILLER4
Xhold260 hold264/Y VDD VSS hold260/Y BUFX3
XFILLER_132_640 VSS VDD FILLER2
XFILLER_120_802 VSS VDD FILLER2
XFILLER_78_716 VDD VSS FILLER1
XFILLER_104_375 VSS VDD FILLER2
XFILLER_132_695 VSS VDD FILLER2
XFILLER_77_237 VDD VSS FILLER4
XFILLER_49_88 VDD VSS FILLER4
X_20119_ _20119_/A VDD VSS _20119_/Y BUFX3
X_13990_ _13990_/A _14166_/B _13990_/C _13990_/D VDD VSS _13993_/B OAOI211X1
XFILLER_1_29 VSS VDD FILLER2
XFILLER_46_602 VSS VDD FILLER2
X_12941_ _13108_/A _13108_/B VDD VSS _14445_/B XNOR2X1
XFILLER_65_21 VDD VSS DECAPHV8
XFILLER_86_793 VSS VDD FILLER2
XFILLER_100_581 VDD VSS FILLER4
XFILLER_65_43 VDD VSS DECAPHV16
X_15660_ _15660_/A _15660_/B VDD VSS _18181_/B XNOR2X1
X_12872_ _12779_/Y _12872_/B _18992_/Q VDD VSS _12903_/D AOI2B1X1
XFILLER_45_156 VDD VSS FILLER4
X_14611_ _19442_/Q VDD VSS _14672_/A INVX1
XFILLER_164_0 VSS VDD FILLER2
X_11823_ _11830_/A _11830_/B _11830_/C VDD VSS _14460_/C OR3X2
XFILLER_45_178 VSS VDD FILLER2
X_15591_ _15591_/A _15591_/B _15591_/C VDD VSS _15611_/A AOI21X1
XFILLER_45_189 VSS VDD FILLER2
XFILLER_61_649 VSS VDD FILLER2
X_17330_ _19823_/Q _19791_/Q VDD VSS _17332_/B XOR2X1
XFILLER_81_20 VSS VDD FILLER2
X_14542_ _15817_/A VDD VSS _15672_/A BUFX3
X_11754_ _19200_/Q _11797_/A _14488_/B VDD VSS _11762_/C XOR3X1
XTAP_TAPCELL_ROW_71_655 VDD VSS WELLTAP
XFILLER_14_565 VSS VDD FILLER2
X_17261_ _17263_/C _17261_/B _17261_/C VDD VSS _19808_/D AOI21X1
X_10705_ _10708_/A _10708_/B VDD VSS _10706_/C NOR2X1
XFILLER_81_75 VSS VDD FILLER2
XFILLER_159_548 VSS VDD FILLER2
X_14473_ _14490_/A _14473_/B _14473_/C VDD VSS _19186_/D NOR3X1
X_11685_ _18982_/Q VDD VSS _12010_/A INVX1
XFILLER_41_395 VDD VSS FILLER4
X_16212_ _19591_/Q _16741_/B VDD VSS _16233_/B XOR2X1
X_19000_ _19086_/CK _19000_/D _19000_/Q VDD VSS DFFQX1
X_13424_ _19110_/Q _13616_/D _13424_/C VDD VSS _13528_/C XNOR3X1
X_17192_ _17197_/C _17197_/B VDD VSS _17194_/B NAND2BX1
X_10636_ _18639_/Q _18801_/Q VDD VSS _10638_/C NAND2X1
XFILLER_127_401 VDD VSS DECAPHV8
XFILLER_155_710 VDD VSS DECAPHV8
Xclkload108 _18217_/CK VDD VSS clkload108/Y INVX1
X_16143_ _19652_/Q _16809_/B VDD VSS _16154_/B XNOR2X1
Xclkload119 _18375_/CK VDD VSS clkload119/Y INVX2
XFILLER_6_720 VSS VDD FILLER2
XFILLER_155_743 VDD VSS FILLER1
X_13355_ _13355_/A _14448_/B VDD VSS _13430_/A OR2X2
XFILLER_10_793 VSS VDD FILLER2
X_10567_ _18638_/Q _18800_/Q VDD VSS _10568_/A XNOR2X1
XFILLER_155_765 VDD VSS DECAPHV8
XFILLER_154_242 VSS VDD FILLER2
X_12306_ _12313_/A _14436_/B _12373_/C VDD VSS _14437_/C NOR3X1
X_16074_ _16074_/A _16074_/B VDD VSS _16876_/B XNOR2X1
XFILLER_155_798 VDD VSS FILLER4
XFILLER_142_415 VSS VDD FILLER2
X_13286_ _18912_/Q _13286_/B _13286_/C VDD VSS _14125_/B XNOR3X1
XFILLER_53_7 VSS VDD FILLER2
X_10498_ _10581_/A _10582_/B _10582_/C _10655_/A VDD VSS _10659_/B OAI211X1
XFILLER_142_437 VSS VDD FILLER2
X_15025_ _19396_/Q _15775_/B VDD VSS _15041_/A XNOR2X1
X_19902_ _19924_/CK _19902_/D _19902_/Q VDD VSS DFFQX1
X_12237_ _14531_/B _14531_/C _19237_/Q VDD VSS _12239_/C AOI21X1
XFILLER_107_191 VDD VSS FILLER1
XFILLER_96_502 VSS VDD FILLER2
X_19833_ clkload5/A _19833_/D _19833_/Q VDD VSS DFFQX1
X_12168_ _19237_/Q _12236_/D _12168_/C VDD VSS _12224_/C XNOR3X1
XTAP_TAPCELL_ROW_79_722 VDD VSS WELLTAP
XFILLER_122_172 VDD VSS FILLER4
XFILLER_150_481 VSS VDD FILLER2
XFILLER_110_323 VSS VDD FILLER2
XFILLER_110_334 VDD VSS FILLER1
X_11119_ _11298_/A _11119_/B _11119_/C VDD VSS _11119_/Y OAI21X1
X_19764_ _19934_/CK _19764_/D _19764_/Q VDD VSS DFFQX1
X_16976_ _16976_/A _16976_/B VDD VSS _19750_/D NOR2X1
X_12099_ _12099_/A _12099_/B _12099_/C _12099_/D VDD VSS _12158_/A OAOI211X1
XFILLER_49_451 VDD VSS DECAPHV8
X_18715_ _18795_/CK _18715_/D _18715_/Q VDD VSS DFFQX1
X_15927_ _19580_/Q _16729_/B VDD VSS _15936_/B XOR2X1
XFILLER_83_229 VSS VDD FILLER2
X_19695_ _19695_/CK _19695_/D _19695_/Q VDD VSS DFFQX1
XFILLER_64_421 VSS VDD FILLER2
X_18646_ _19940_/CK _18646_/D _18646_/Q VDD VSS DFFQX1
X_15858_ _15858_/A _15858_/B VDD VSS _15859_/B OR2X2
XFILLER_92_774 VSS VDD FILLER2
XFILLER_64_476 VSS VDD FILLER2
XFILLER_24_307 VSS VDD FILLER2
X_14809_ _14809_/A _14809_/B _14809_/C VDD VSS _14896_/B OA21X2
X_18577_ _18583_/CK _18577_/D _18577_/Q VDD VSS DFFQX1
XFILLER_17_370 VSS VDD FILLER2
X_15789_ _15800_/A _15789_/B VDD VSS _19408_/D NOR2X1
Xclkbuf_leaf_7__002_ clkbuf_leaf_9__002_/A VDD VSS _18773_/CK BUFX12
XFILLER_91_295 VSS VDD FILLER2
X_17528_ _19865_/Q _19833_/Q VDD VSS _17529_/B XNOR2X1
XFILLER_51_159 VSS VDD FILLER2
XFILLER_32_340 VDD VSS FILLER1
X_17459_ _19850_/Q _19818_/Q VDD VSS _17460_/C NAND2X1
XFILLER_137_209 VDD VSS FILLER1
XTAP_TAPCELL_ROW_42_390 VDD VSS WELLTAP
XFILLER_158_570 VSS VDD FILLER2
XFILLER_146_721 VSS VDD FILLER2
X_19129_ _19157_/CK _19129_/D _19129_/Q VDD VSS DFFQX1
XFILLER_9_591 VDD VSS FILLER4
XFILLER_146_754 VSS VDD FILLER2
XFILLER_106_607 VDD VSS DECAPHV16
XFILLER_145_253 VDD VSS FILLER1
XFILLER_145_275 VDD VSS FILLER4
XFILLER_10_27 VSS VDD FILLER2
XFILLER_145_286 VSS VDD FILLER2
XFILLER_10_49 VSS VDD FILLER2
XFILLER_160_256 VDD VSS FILLER1
XFILLER_126_49 VSS VDD FILLER2
XFILLER_102_802 VDD VSS DECAPHV8
XFILLER_160_289 VDD VSS FILLER1
XFILLER_141_481 VSS VDD FILLER2
XFILLER_59_226 VDD VSS FILLER4
XFILLER_87_546 VDD VSS FILLER1
XFILLER_19_14 VSS VDD FILLER2
XFILLER_19_36 VSS VDD FILLER2
Xclkbuf_leaf_11__001_ clkload32/A VDD VSS _19171_/CK BUFX12
XTAP_TAPCELL_ROW_148_1349 VDD VSS WELLTAP
XFILLER_87_579 VDD VSS FILLER1
XFILLER_75_719 VDD VSS FILLER1
XFILLER_142_26 VSS VDD FILLER2
XFILLER_28_602 VSS VDD FILLER2
X_09715_ _09819_/A _09715_/B VDD VSS _09716_/E NOR2X1
XFILLER_19_58 VSS VDD FILLER2
XFILLER_142_37 VSS VDD FILLER2
XFILLER_68_793 VSS VDD FILLER2
XFILLER_83_730 VDD VSS DECAPHV8
X_09646_ _09753_/D _09646_/B VDD VSS _09647_/E NOR2X1
XFILLER_55_443 VDD VSS DECAPHV8
XFILLER_83_785 VSS VDD FILLER2
Xclkbuf_leaf_26__001_ clkbuf_2_1__f__001_/Y VDD VSS _19025_/CK BUFX12
X_09577_ _09716_/B VDD VSS _09818_/C BUFX3
XFILLER_27_189 VSS VDD FILLER2
XFILLER_70_435 VSS VDD FILLER2
XFILLER_43_649 VSS VDD FILLER2
XFILLER_36_690 VDD VSS FILLER4
XFILLER_24_830 VDD VSS FILLER1
XFILLER_42_137 VSS VDD FILLER2
XFILLER_11_524 VDD VSS FILLER4
XTAP_TAPCELL_ROW_159_1445 VDD VSS WELLTAP
XFILLER_23_384 VSS VDD FILLER2
XFILLER_109_401 VDD VSS FILLER1
X_11470_ _19961_/Q _11473_/B VDD VSS _18654_/D AND2X1
XFILLER_7_528 VSS VDD FILLER2
XFILLER_51_67 VSS VDD FILLER2
XFILLER_109_423 VDD VSS FILLER4
XFILLER_137_743 VDD VSS FILLER1
X_10421_ _10414_/Y _10421_/B _10419_/Y _10421_/D VDD VSS _10463_/D AOI2B2BX1
XFILLER_137_765 VDD VSS DECAPHV8
X_13140_ _14512_/B _19219_/Q VDD VSS _13329_/A NAND2BX1
XFILLER_137_798 VSS VDD FILLER2
X_10352_ _10585_/C _10465_/B _10538_/A _10550_/A VDD VSS _10388_/C AOI211X1
XFILLER_152_735 VSS VDD FILLER2
XTAP_TAPCELL_ROW_114_1039 VDD VSS WELLTAP
X_13071_ _13192_/A _13192_/B VDD VSS _14218_/B XNOR2X1
X_10283_ _10281_/Y _10283_/B _11438_/A _18712_/Q VDD VSS _10283_/Y AOI2B2X1
XFILLER_2_244 VDD VSS FILLER4
X_12022_ _12022_/A _12022_/B VDD VSS _14370_/B XNOR2X1
XFILLER_120_621 VDD VSS FILLER1
XFILLER_104_194 VDD VSS FILLER1
X_16830_ _16838_/A _16830_/B VDD VSS _19671_/D NOR2X1
XFILLER_78_568 VSS VDD FILLER2
XFILLER_78_579 VSS VDD FILLER2
XFILLER_93_527 VSS VDD FILLER2
XFILLER_59_782 VSS VDD FILLER2
X_16761_ _16775_/A _16761_/B VDD VSS _19609_/D NOR2X1
X_13973_ _18922_/Q _13983_/B _13983_/C VDD VSS _14020_/C XNOR3X1
XFILLER_76_75 VSS VDD FILLER2
XFILLER_86_590 VSS VDD FILLER2
XFILLER_46_421 VSS VDD FILLER2
X_18500_ _18503_/CK _18521_/Q _20113_/A _18503_/RB VDD VSS DFFRQX1
XTAP_TAPCELL_ROW_48_449 VDD VSS WELLTAP
XFILLER_74_741 VDD VSS FILLER4
X_15712_ _15817_/A VDD VSS _15739_/A BUFX3
X_12924_ _19132_/Q _14411_/B VDD VSS _13023_/A NAND2X1
X_16692_ _16692_/A _16704_/B VDD VSS _19547_/D NOR2X1
X_19480_ _19508_/CK _19480_/D _19480_/Q VDD VSS DFFQX1
XTAP_TAPCELL_ROW_125_1135 VDD VSS WELLTAP
XFILLER_18_156 VDD VSS FILLER1
X_18431_ _18439_/CK _18431_/D _18431_/Q _18463_/RB VDD VSS DFFRQX1
X_15643_ _15762_/B VDD VSS _15644_/C INVX1
X_12855_ _19189_/Q _13032_/B _13032_/C VDD VSS _13108_/B XNOR3X1
XFILLER_46_498 VSS VDD FILLER2
XFILLER_61_435 VDD VSS FILLER1
XFILLER_92_74 VSS VDD FILLER2
X_11806_ _19230_/Q wire166/Y _11838_/C VDD VSS _11828_/D XNOR3X1
X_15574_ _15574_/A _15574_/B _15855_/B VDD VSS _15576_/A MIN3X1
X_18362_ _18374_/CK _18362_/D _18362_/Q _18464_/RB VDD VSS DFFRQX1
XFILLER_61_468 VSS VDD FILLER2
X_12786_ _12884_/A _12884_/B _12791_/C VDD VSS _17876_/B XNOR3X1
X_17313_ _17838_/A VDD VSS _17363_/C BUFX3
X_14525_ _14522_/Y _14525_/B _14525_/C VDD VSS _19231_/D AND3BX1
XFILLER_30_822 VSS VDD FILLER2
X_11737_ _11737_/A _11737_/B _14518_/B VDD VSS _11768_/A MIN3X1
X_18293_ _18295_/CK _18293_/D _18293_/Q VDD VSS DFFQX1
X_17244_ _19805_/Q _19773_/Q VDD VSS _17245_/B XOR2X1
X_14456_ _14456_/A _14456_/B VDD VSS _19171_/D NOR2X1
XFILLER_128_710 VSS VDD FILLER2
X_11668_ _18807_/Q _11669_/B VDD VSS _18834_/D AND2X1
X_13407_ _14293_/C _19026_/Q _13604_/B VDD VSS _13509_/D AND3BX1
X_17175_ _19790_/Q _19758_/Q VDD VSS _17178_/A XNOR2X1
X_10619_ _10619_/A _10619_/B _10619_/C _10619_/D VDD VSS _10621_/B AND4X2
X_14387_ _14393_/A _14387_/B VDD VSS _19109_/D NOR2X1
XFILLER_155_540 VDD VSS FILLER4
XFILLER_128_765 VSS VDD FILLER2
X_11599_ _18744_/Q _11600_/B VDD VSS _18771_/D AND2X1
XFILLER_115_404 VSS VDD FILLER2
X_16126_ _19715_/Q _16126_/B _16879_/B VDD VSS _16150_/B MIN3X1
XFILLER_127_264 VSS VDD FILLER2
X_13338_ _13347_/A _14513_/B _13347_/C VDD VSS _14514_/B OAI21X1
XFILLER_6_561 VSS VDD FILLER2
XFILLER_155_595 VSS VDD FILLER2
X_16057_ _16057_/A _16057_/B _16057_/C VDD VSS _16081_/B AOI21X1
X_13269_ _19053_/Q _13269_/B _14323_/C VDD VSS _13406_/A XNOR3X1
XFILLER_143_779 VSS VDD FILLER2
XFILLER_130_407 VSS VDD FILLER2
X_15008_ _19506_/Q _15018_/B VDD VSS _15013_/C AND2X1
XFILLER_142_278 VSS VDD FILLER2
XFILLER_97_855 VSS VDD FILLER2
XFILLER_110_120 VDD VSS FILLER4
X_19816_ _19853_/CK _19816_/D _19816_/Q VDD VSS DFFQX1
XFILLER_111_654 VSS VDD FILLER2
XFILLER_110_142 VDD VSS DECAPHV8
X_19747_ _19785_/CK _19747_/D _19747_/Q VDD VSS DFFQX1
X_16959_ _19746_/Q _17049_/B _16962_/A _16962_/B VDD VSS _16960_/B AOAI211X1
XFILLER_110_197 VSS VDD FILLER2
X_09500_ _18496_/D _09501_/B _09506_/C _20074_/Q VDD VSS _20074_/D AO22X2
XFILLER_112_18 VSS VDD FILLER2
X_19678_ _19722_/CK _19678_/D _19678_/Q VDD VSS DFFQX1
XFILLER_112_29 VDD VSS FILLER1
XFILLER_80_700 VSS VDD FILLER2
XFILLER_65_785 VDD VSS FILLER4
XFILLER_37_476 VDD VSS DECAPHV16
X_09431_ _18506_/Q _18505_/Q _09630_/C VDD VSS _09673_/C NAND3BX1
X_18629_ clkload3/A _18629_/D _18629_/Q VDD VSS DFFQX1
XFILLER_92_593 VSS VDD FILLER2
XFILLER_64_284 VSS VDD FILLER2
XFILLER_24_115 VSS VDD FILLER2
XFILLER_25_649 VSS VDD FILLER2
XTAP_TAPCELL_ROW_19_184 VDD VSS WELLTAP
XFILLER_24_137 VSS VDD FILLER2
XFILLER_80_766 VDD VSS FILLER1
X_09362_ _20065_/RB _09362_/B VDD VSS _09362_/Y NOR2BX1
XFILLER_21_800 VSS VDD FILLER2
XFILLER_21_811 VSS VDD FILLER2
X_09293_ _20045_/Q _20040_/Q VDD VSS _09294_/B XOR2X1
XANTENNA_11 _20178_/Y VDD VSS ANTENNA2
XFILLER_21_844 VDD VSS FILLER1
XFILLER_32_181 VSS VDD FILLER2
XFILLER_21_855 VSS VDD FILLER2
XFILLER_32_192 VDD VSS FILLER4
XFILLER_166_838 VSS VDD FILLER2
XFILLER_165_304 VSS VDD FILLER2
XFILLER_118_242 VDD VSS FILLER4
XFILLER_4_509 VSS VDD FILLER2
XFILLER_21_59 VSS VDD FILLER2
XFILLER_119_787 VDD VSS FILLER1
XFILLER_106_415 VSS VDD FILLER2
XFILLER_134_724 VSS VDD FILLER2
XFILLER_146_584 VDD VSS DECAPHV8
XFILLER_106_437 VDD VSS FILLER1
XFILLER_133_223 VDD VSS FILLER1
XTAP_TAPCELL_ROW_154_1397 VDD VSS WELLTAP
XFILLER_133_245 VSS VDD FILLER2
Xoutput140 _20223_/Y VDD VSS o_uwb_tx_cfg[26] BUFX3
Xoutput151 _20206_/Y VDD VSS o_uwb_tx_cfg[9] BUFX3
XFILLER_88_811 VSS VDD FILLER2
XFILLER_161_576 VDD VSS DECAPHV8
XFILLER_0_715 VDD VSS FILLER4
XFILLER_121_418 VSS VDD FILLER2
XFILLER_121_429 VDD VSS FILLER4
XFILLER_0_737 VSS VDD FILLER2
XFILLER_102_632 VSS VDD FILLER2
XFILLER_101_120 VSS VDD FILLER2
XFILLER_47_207 VDD VSS FILLER4
XTAP_TAPCELL_ROW_98_894 VDD VSS WELLTAP
XFILLER_28_421 VSS VDD FILLER2
XFILLER_56_741 VDD VSS FILLER4
X_10970_ _11007_/C _11007_/B VDD VSS _10971_/B NAND2BX1
XFILLER_46_67 VSS VDD FILLER2
XTAP_TAPCELL_ROW_45_419 VDD VSS WELLTAP
XFILLER_46_78 VDD VSS FILLER1
XFILLER_43_402 VDD VSS FILLER4
XFILLER_16_627 VSS VDD FILLER2
X_09629_ _20215_/A _09797_/C _09629_/C VDD VSS _09635_/B AOI21X1
XFILLER_83_582 VDD VSS DECAPHV8
XFILLER_71_722 VDD VSS FILLER1
XFILLER_43_413 VSS VDD FILLER2
XFILLER_15_104 VDD VSS FILLER4
XFILLER_55_284 VDD VSS FILLER1
XFILLER_16_638 VSS VDD FILLER2
XFILLER_70_221 VSS VDD FILLER2
X_12640_ _12640_/A _14379_/B _14379_/C VDD VSS _12804_/C NOR3X1
XFILLER_43_468 VDD VSS DECAPHV8
XFILLER_43_479 VSS VDD FILLER2
XFILLER_31_619 VDD VSS DECAPHV8
X_12571_ _12571_/A _12571_/B _12571_/C _12571_/D VDD VSS _12837_/A AOAI211X1
XFILLER_12_855 VSS VDD FILLER2
X_14310_ _14311_/A _14310_/B VDD VSS _19042_/D NOR2X1
XFILLER_62_88 VSS VDD FILLER2
XFILLER_129_518 VDD VSS DECAPHV16
X_11522_ _11522_/A _11641_/B VDD VSS _18701_/D NOR2X1
X_15290_ _19374_/Q _15751_/B VDD VSS _15291_/B XNOR2X1
XFILLER_8_826 VSS VDD FILLER2
XFILLER_109_220 VSS VDD FILLER2
X_14241_ _14251_/A _14241_/B VDD VSS _18983_/D NOR2X1
X_11453_ _19946_/Q _11460_/B VDD VSS _18639_/D AND2X1
X_10404_ _10965_/A _18715_/Q _10404_/C _10404_/D VDD VSS _10463_/B AOI22X1
XFILLER_109_275 VDD VSS FILLER4
X_14172_ _17172_/A VDD VSS _15836_/C BUFX3
X_11384_ _11384_/A _11390_/B _11384_/C VDD VSS _11392_/A MIN3X1
XFILLER_164_370 VDD VSS FILLER4
XFILLER_125_757 VDD VSS FILLER1
X_13123_ _13138_/A _13138_/B _13138_/C VDD VSS _14447_/B OAI21X1
X_10335_ _10372_/A _10372_/B _10372_/D _10372_/C VDD VSS _10339_/B AOI211X1
X_18980_ _19171_/CK _18980_/D _18980_/Q VDD VSS DFFQX1
XFILLER_152_576 VDD VSS FILLER4
XFILLER_124_289 VDD VSS FILLER4
X_17931_ _18864_/Q VDD VSS _17940_/A INVX1
X_13054_ _13054_/A _13054_/B _13150_/B _13054_/D VDD VSS _13255_/C OAI211X1
X_10266_ _11438_/A _11432_/B _10266_/C _10266_/D VDD VSS _10266_/Y AOI22X1
XFILLER_87_52 VDD VSS DECAPHV16
X_12005_ _19066_/Q _12080_/B _12075_/C VDD VSS _12016_/C XNOR3X1
XTAP_TAPCELL_ROW_131_1194 VDD VSS WELLTAP
XFILLER_120_440 VSS VDD FILLER2
X_17862_ _17862_/A _17862_/B VDD VSS _17863_/B XNOR2X1
X_10197_ _10117_/Y _10166_/C _10224_/A VDD VSS _10202_/B MUX2X1
XFILLER_87_96 VSS VDD FILLER2
X_19601_ _19602_/CK _19601_/D _19601_/Q VDD VSS DFFQX1
X_16813_ _16826_/A _16813_/B VDD VSS _19655_/D NOR2X1
XFILLER_120_495 VSS VDD FILLER2
X_17793_ _17793_/A _17793_/B _17793_/C _17793_/D VDD VSS _17794_/C AOAI211X1
XFILLER_93_346 VSS VDD FILLER2
XFILLER_19_432 VSS VDD FILLER2
XFILLER_143_91 VSS VDD FILLER2
X_19532_ _19536_/CK _19532_/D _19532_/Q VDD VSS DFFQX1
XFILLER_47_752 VDD VSS FILLER4
XFILLER_19_443 VDD VSS FILLER4
X_16744_ _16748_/A _16744_/B VDD VSS _19594_/D NOR2X1
XFILLER_81_508 VDD VSS FILLER4
X_13956_ _14004_/B _14232_/C _18977_/Q VDD VSS _13957_/D AND3BX1
XFILLER_62_700 VSS VDD FILLER2
X_19463_ _19463_/CK _19463_/D _19463_/Q VDD VSS DFFQX1
X_12907_ _12996_/A _12996_/B _12996_/C VDD VSS _12978_/B AOI21X1
X_16675_ _19608_/Q _16759_/B _16675_/C VDD VSS _16681_/A OAI21X1
X_13887_ _13955_/A _13998_/B VDD VSS _14231_/B XNOR2X1
XFILLER_61_210 VSS VDD FILLER2
XFILLER_46_284 VDD VSS FILLER4
X_18414_ _18422_/CK _18414_/D _18414_/Q _18422_/RB VDD VSS DFFRQX1
XFILLER_34_457 VSS VDD FILLER2
X_15626_ _15641_/A _15639_/A VDD VSS _15762_/B XNOR2X1
X_12838_ _14506_/B _14506_/C _12839_/A VDD VSS _12840_/C OAI21X1
X_19394_ _19463_/CK _19394_/D _19394_/Q VDD VSS DFFQX1
XFILLER_62_788 VSS VDD FILLER2
XFILLER_34_479 VDD VSS DECAPHV8
XTAP_TAPCELL_ROW_16_154 VDD VSS WELLTAP
XTAP_TAPCELL_ROW_142_1290 VDD VSS WELLTAP
XFILLER_15_671 VSS VDD FILLER2
XFILLER_99_4 VDD VSS FILLER1
XFILLER_21_118 VSS VDD FILLER2
X_18345_ _18359_/CK _18345_/D _18345_/Q _20067_/RB VDD VSS DFFRQX1
X_15557_ _15568_/A _15568_/B VDD VSS _15728_/B XNOR2X1
X_12769_ _19187_/Q VDD VSS _12771_/D INVX1
XFILLER_148_838 VSS VDD FILLER2
X_14508_ _15806_/A _14508_/B _14508_/C VDD VSS _19215_/D NOR3X1
XFILLER_30_652 VDD VSS DECAPHV8
X_15488_ _15525_/C _15525_/B VDD VSS _15489_/B NOR2BX1
X_18276_ _18276_/CK _18276_/D _18276_/Q _09274_/Y VDD VSS DFFRQX1
XTAP_TAPCELL_ROW_0_4 VDD VSS WELLTAP
X_17227_ _17227_/A _17227_/B _17227_/C VDD VSS _17230_/A OA21X2
Xclkbuf_leaf_10__002_ clkbuf_leaf_9__002_/A VDD VSS _19943_/CK BUFX12
X_14439_ _14421_/Y _14439_/B _14439_/C VDD VSS _19156_/D AND3BX1
XFILLER_115_201 VDD VSS FILLER4
X_17158_ _17160_/A _17160_/B _17158_/C VDD VSS _19786_/D AOI21X1
XFILLER_155_370 VSS VDD FILLER2
X_09976__247 _20080_/CK VDD VSS _18523_/CK INVX1
X_16109_ _19586_/Q _16109_/B _16735_/B VDD VSS _16134_/B MIN3X1
X_17089_ _17091_/B _17089_/B VDD VSS _17090_/B XOR2X1
X_09980_ _18599_/Q _09980_/B VDD VSS _09996_/A NOR2BX1
XFILLER_131_705 VSS VDD FILLER2
XFILLER_42_0 VSS VDD FILLER2
XFILLER_115_278 VDD VSS FILLER1
XFILLER_143_587 VSS VDD FILLER2
XFILLER_143_598 VSS VDD FILLER2
XFILLER_97_630 VSS VDD FILLER2
XFILLER_97_685 VDD VSS FILLER1
XFILLER_96_184 VSS VDD FILLER2
XTAP_TAPCELL_ROW_145_1319 VDD VSS WELLTAP
XFILLER_38_752 VSS VDD FILLER2
XTAP_TAPCELL_ROW_95_864 VDD VSS WELLTAP
XFILLER_37_240 VDD VSS FILLER1
XFILLER_25_413 VSS VDD FILLER2
XTAP_TAPCELL_ROW_107_976 VDD VSS WELLTAP
XFILLER_25_435 VSS VDD FILLER2
X_09414_ _20047_/Q _09414_/B _18258_/Q _09414_/D VDD VSS _20047_/D OAI2B2BX1
XFILLER_80_552 VDD VSS FILLER4
XFILLER_25_468 VDD VSS FILLER4
XFILLER_80_574 VSS VDD FILLER2
XFILLER_80_585 VDD VSS FILLER1
XFILLER_12_118 VDD VSS FILLER4
X_09345_ _18442_/D _09344_/Y _09302_/A VDD VSS _18511_/D MUXI2X1
XFILLER_138_304 VDD VSS FILLER4
X_09276_ _09256_/C _20046_/Q _18258_/Q VDD VSS _09277_/B OR3BX1
XTAP_TAPCELL_ROW_156_1415 VDD VSS WELLTAP
XTAP_TAPCELL_ROW_50_466 VDD VSS WELLTAP
XFILLER_166_646 VDD VSS FILLER1
XFILLER_153_307 VSS VDD FILLER2
XFILLER_5_818 VSS VDD FILLER2
XFILLER_5_829 VDD VSS FILLER1
XFILLER_165_178 VSS VDD FILLER2
XFILLER_113_6 VDD VSS FILLER1
XFILLER_134_510 VDD VSS FILLER1
XFILLER_4_317 VDD VSS FILLER1
XFILLER_165_189 VDD VSS FILLER4
XFILLER_4_328 VSS VDD FILLER2
XFILLER_146_392 VDD VSS FILLER4
XFILLER_107_779 VSS VDD FILLER2
XFILLER_161_351 VSS VDD FILLER2
XTAP_TAPCELL_ROW_111_1009 VDD VSS WELLTAP
XFILLER_121_204 VSS VDD FILLER2
X_10120_ _10120_/A _10120_/B VDD VSS _10123_/B AND2X1
XFILLER_161_384 VSS VDD FILLER2
XFILLER_0_534 VDD VSS FILLER4
XFILLER_121_259 VDD VSS FILLER1
X_10051_ _10051_/A _10053_/C VDD VSS _11410_/C XNOR2X1
XFILLER_0_567 VSS VDD FILLER2
XFILLER_88_696 VDD VSS FILLER1
XFILLER_87_162 VSS VDD FILLER2
XFILLER_130_793 VSS VDD FILLER2
XFILLER_87_184 VSS VDD FILLER2
XTAP_TAPCELL_ROW_58_533 VDD VSS WELLTAP
XFILLER_75_346 VSS VDD FILLER2
XFILLER_29_741 VSS VDD FILLER2
X_13810_ _13876_/A _14131_/B VDD VSS _13877_/B _13876_/C NAND3X1
X_14790_ _19502_/Q _15895_/B VDD VSS _14826_/C NAND2BX1
XFILLER_90_305 VSS VDD FILLER2
XFILLER_44_700 VDD VSS FILLER4
XFILLER_28_251 VDD VSS FILLER4
XFILLER_44_711 VSS VDD FILLER2
X_13741_ _18890_/Q _13741_/B _13807_/D VDD VSS _17921_/C XNOR3X1
X_10953_ _10954_/A _10954_/B _10954_/C _10954_/D VDD VSS _10953_/Y AOI211X1
XFILLER_43_210 VSS VDD FILLER2
XFILLER_43_232 VSS VDD FILLER2
X_16460_ _16470_/C _16460_/B VDD VSS _16857_/B AND2X1
X_13672_ _13672_/A _14163_/B _14163_/C VDD VSS _13807_/C NOR3X1
X_10884_ _10885_/A _10885_/B _10885_/C VDD VSS _10884_/Y NOR3X1
X_15411_ _15427_/A _15427_/B VDD VSS _15754_/B XNOR2X1
X_12623_ _12717_/A _12717_/B _12717_/C VDD VSS _12710_/A AOI21X1
X_16391_ _19629_/Q _16783_/B VDD VSS _16402_/A OR2X2
X_15342_ _19375_/Q _15752_/B VDD VSS _15376_/A NOR2BX1
X_18130_ _18131_/A _18131_/B _18131_/C VDD VSS _18132_/B NOR3X1
XFILLER_8_601 VSS VDD FILLER2
X_12554_ _12593_/D _12656_/A _12643_/B VDD VSS _12556_/D XNOR3X1
XFILLER_157_624 VDD VSS FILLER4
XFILLER_11_173 VDD VSS FILLER4
X_11505_ _18659_/Q _11508_/B VDD VSS _18686_/D AND2X1
XFILLER_145_808 VDD VSS FILLER4
X_15273_ _15311_/D VDD VSS _15274_/D INVX1
X_18061_ _18064_/A _18064_/B _18187_/C VDD VSS _18062_/C OAI21X1
XFILLER_145_819 VDD VSS FILLER4
X_12485_ _19212_/Q VDD VSS _12486_/A INVX1
XFILLER_11_195 VSS VDD FILLER2
X_17012_ _19756_/Q _17078_/B _17012_/C VDD VSS _17013_/B AOI21X1
X_14224_ _14251_/A _14224_/B VDD VSS _18970_/D NOR2X1
XFILLER_8_689 VSS VDD FILLER2
X_11436_ _18626_/Q _18624_/Q _11436_/C _18627_/Q VDD VSS _11437_/C AOI31X1
XTAP_TAPCELL_ROW_133_1212 VDD VSS WELLTAP
XFILLER_125_554 VDD VSS FILLER4
X_14155_ _14522_/A VDD VSS _14186_/A BUFX3
X_11367_ _11367_/A _11367_/B _11367_/C VDD VSS _11375_/C MIN3X1
XFILLER_125_565 VDD VSS FILLER1
XFILLER_98_62 VSS VDD FILLER2
XFILLER_125_587 VSS VDD FILLER2
XFILLER_152_373 VDD VSS DECAPHV8
X_13106_ _19134_/Q _14414_/B VDD VSS _13113_/C _14414_/C NAND3X1
XFILLER_98_427 VSS VDD FILLER2
XFILLER_112_215 VSS VDD FILLER2
X_10318_ _10405_/A _10405_/B _10405_/D _10405_/C VDD VSS _10325_/B AOI211X1
XFILLER_3_361 VSS VDD FILLER2
X_18963_ _18997_/CK _18963_/D _18963_/Q VDD VSS DFFQX1
X_14086_ _14086_/A _14086_/B _14086_/C _14086_/D VDD VSS _14173_/B OAOI211X1
XFILLER_140_535 VDD VSS FILLER1
X_11298_ _11298_/A _11298_/B _11298_/C VDD VSS _11370_/B OAI21X1
XFILLER_140_568 VSS VDD FILLER2
X_17914_ _17914_/A _17914_/B _17914_/C VDD VSS _17919_/C MIN3X1
X_13037_ _19190_/Q _13141_/A _13042_/B VDD VSS _13039_/C XNOR3X1
X_10249_ _11436_/C _10362_/D _11431_/B VDD VSS _10315_/B NOR3X1
XFILLER_79_663 VDD VSS DECAPHV8
XFILLER_140_579 VSS VDD FILLER2
X_18894_ _18924_/CK _18894_/D _18894_/Q VDD VSS DFFQX1
XFILLER_21_5 VSS VDD FILLER2
XFILLER_94_611 VSS VDD FILLER2
X_17845_ _17847_/C _17846_/B _17917_/C VDD VSS _17846_/C OAI21X1
XFILLER_39_549 VSS VDD FILLER2
XFILLER_66_346 VSS VDD FILLER2
XFILLER_54_508 VSS VDD FILLER2
X_17776_ _17776_/A _17776_/B _17776_/C VDD VSS _17781_/C MIN3X1
XFILLER_66_379 VSS VDD FILLER2
X_14988_ _15297_/A _18084_/B VDD VSS _19283_/D AND2X1
X_19515_ _19736_/CK _19515_/D _19515_/Q VDD VSS DFFQX1
X_16727_ _16735_/A _16727_/B VDD VSS _19578_/D NOR2X1
XFILLER_47_593 VDD VSS FILLER1
X_13939_ _13981_/A _13981_/B _13981_/D _13981_/C VDD VSS _14135_/C AOI211X1
XTAP_TAPCELL_ROW_92_845 VDD VSS WELLTAP
XFILLER_34_210 VSS VDD FILLER2
X_19446_ _19478_/CK _19446_/D _19446_/Q VDD VSS DFFQX1
X_16658_ _16675_/C _16658_/B VDD VSS _16673_/A AND2X1
XTAP_TAPCELL_ROW_104_946 VDD VSS WELLTAP
XFILLER_62_574 VSS VDD FILLER2
XFILLER_34_287 VDD VSS FILLER1
X_15609_ _15617_/A _15609_/B VDD VSS _15699_/B XNOR2X1
XFILLER_34_298 VSS VDD FILLER2
X_19377_ _19379_/CK _19377_/D _19377_/Q VDD VSS DFFQX1
X_16589_ _16589_/A _16589_/B _18168_/C VDD VSS _16590_/B OAI21X1
XFILLER_148_602 VSS VDD FILLER2
X_18328_ _18341_/CK _18525_/Q _20082_/A _18491_/RB VDD VSS DFFRQX1
XFILLER_148_635 VSS VDD FILLER2
XFILLER_148_646 VSS VDD FILLER2
XFILLER_136_819 VDD VSS DECAPHV8
XFILLER_147_145 VSS VDD FILLER2
X_18259_ _20080_/CK hold261/Y output6/A _18208_/Y VDD VSS DFFRQX1
XFILLER_147_189 VDD VSS FILLER4
XFILLER_162_137 VSS VDD FILLER2
X_20221_ _20221_/A VDD VSS _20221_/Y BUFX3
XFILLER_104_727 VSS VDD FILLER2
X_20152_ _20152_/A VDD VSS _20152_/Y BUFX3
XFILLER_103_226 VSS VDD FILLER2
XFILLER_103_237 VSS VDD FILLER2
XFILLER_131_557 VDD VSS FILLER1
XFILLER_134_27 VSS VDD FILLER2
X_20083_ _20083_/A VDD VSS _20083_/Y BUFX3
X_09894_ _10032_/A _09928_/A _09894_/C VDD VSS _09895_/D NOR3X1
XFILLER_134_49 VDD VSS FILLER4
XFILLER_85_600 VDD VSS FILLER4
XFILLER_58_825 VSS VDD FILLER2
XFILLER_112_793 VSS VDD FILLER2
XFILLER_85_633 VSS VDD FILLER2
XFILLER_97_493 VDD VSS DECAPHV8
XFILLER_69_184 VSS VDD FILLER2
XFILLER_69_195 VSS VDD FILLER2
XFILLER_84_154 VSS VDD FILLER2
XFILLER_26_700 VDD VSS DECAPHV8
XFILLER_150_37 VDD VSS FILLER1
XFILLER_25_221 VDD VSS FILLER1
XTAP_TAPCELL_ROW_162_1474 VDD VSS WELLTAP
XFILLER_81_850 VDD VSS FILLER1
XFILLER_25_254 VSS VDD FILLER2
XFILLER_53_574 VDD VSS DECAPHV8
XFILLER_43_24 VSS VDD FILLER2
XTAP_TAPCELL_ROW_63_580 VDD VSS WELLTAP
XFILLER_41_747 VSS VDD FILLER2
XFILLER_13_449 VSS VDD FILLER2
XFILLER_40_235 VSS VDD FILLER2
XFILLER_159_35 VDD VSS FILLER4
X_09328_ _18469_/RB _09346_/B VDD VSS _09328_/Y NOR2BX1
XFILLER_138_101 VSS VDD FILLER2
XFILLER_139_624 VSS VDD FILLER2
XFILLER_40_279 VDD VSS FILLER4
XFILLER_159_68 VSS VDD FILLER2
XTAP_TAPCELL_ROW_10_105 VDD VSS WELLTAP
XFILLER_127_808 VSS VDD FILLER2
X_09259_ _09277_/A _09301_/A VDD VSS _09265_/C NOR2BX1
XFILLER_166_465 VSS VDD FILLER2
XFILLER_138_167 VDD VSS FILLER1
XFILLER_119_370 VSS VDD FILLER2
X_12270_ _18875_/Q VDD VSS _12610_/A INVX1
XFILLER_166_498 VSS VDD FILLER2
XFILLER_4_114 VSS VDD FILLER2
X_11221_ _11221_/A _11221_/B VDD VSS _11222_/A NOR2X1
XFILLER_4_136 VSS VDD FILLER2
X_11152_ _11016_/Y _11151_/Y _11298_/A VDD VSS _11152_/Y MUXI2X1
XFILLER_68_32 VDD VSS FILLER4
XFILLER_108_94 VSS VDD FILLER2
X_10103_ _18587_/Q _10103_/B VDD VSS _10103_/Y XOR2X1
XFILLER_122_568 VSS VDD FILLER2
XFILLER_95_408 VDD VSS FILLER1
X_15960_ _15960_/A VDD VSS _15961_/B INVX1
X_11083_ _11083_/A _11090_/C VDD VSS _11084_/B XOR2X1
X_14911_ _14911_/A _14911_/B _14911_/C _14911_/D VDD VSS _14956_/B AOAI211X1
X_10034_ _10034_/A VDD VSS _10167_/A BUFX3
XFILLER_0_397 VSS VDD FILLER2
X_15891_ _15895_/A _15891_/B VDD VSS _19498_/D NOR2X1
XFILLER_75_132 VDD VSS FILLER1
XFILLER_48_357 VDD VSS FILLER1
X_17630_ _19887_/Q _19855_/Q VDD VSS _17632_/B XOR2X1
XFILLER_36_508 VSS VDD FILLER2
XFILLER_124_82 VSS VDD FILLER2
X_14842_ _14861_/B _14861_/C VDD VSS _15803_/B OR2X2
XFILLER_84_31 VSS VDD FILLER2
XFILLER_75_176 VSS VDD FILLER2
XFILLER_63_327 VDD VSS FILLER4
X_17561_ _19872_/Q VDD VSS _17712_/B INVX1
X_14773_ _19446_/Q _14840_/A _14773_/C VDD VSS _14774_/C XNOR3X1
X_11985_ _11985_/A _11985_/B _11985_/C _11985_/D VDD VSS _14494_/C OAI211X1
XFILLER_16_221 VDD VSS FILLER4
X_19300_ _19331_/CK _19300_/D _19300_/Q VDD VSS DFFQX1
X_16512_ _16512_/A _16512_/B VDD VSS _19538_/D NOR2X1
XFILLER_16_243 VSS VDD FILLER2
X_13724_ _19086_/Q _13857_/A _13784_/B VDD VSS _13781_/C XNOR3X1
X_10936_ _11522_/A _11641_/A _10936_/C VDD VSS _10967_/C MIN3X1
X_17492_ _17496_/A _17493_/B _17509_/C VDD VSS _17493_/C OAI21X1
XFILLER_17_91 VSS VDD FILLER2
XFILLER_16_265 VDD VSS FILLER4
XFILLER_16_276 VSS VDD FILLER2
X_19231_ _19995_/CK _19231_/D _19231_/Q VDD VSS DFFQX1
XFILLER_44_596 VDD VSS FILLER1
XFILLER_32_736 VSS VDD FILLER2
X_16443_ _19695_/Q _16856_/B VDD VSS _16469_/A NAND2BX1
X_13655_ _13656_/D _14194_/B VDD VSS _13748_/A NAND2X1
X_10867_ _10874_/A _10896_/C _11014_/A VDD VSS _10874_/C OAI21X1
X_19162_ _19191_/CK _19162_/D _19162_/Q VDD VSS DFFQX1
X_12606_ _18906_/Q _12701_/B _14150_/B VDD VSS _17861_/B XNOR3X1
X_16374_ _16398_/B _16398_/C VDD VSS _16375_/B NAND2BX1
X_13586_ _13586_/A _14192_/B _13586_/C _13586_/D VDD VSS _13688_/A OAOI211X1
X_10798_ _10798_/A _10798_/B _10798_/C _10798_/D VDD VSS _10866_/B AO211X2
X_18113_ _19289_/Q _18118_/B VDD VSS _18114_/A XNOR2X1
X_15325_ _19430_/Q _15814_/B VDD VSS _15347_/C NOR2BX1
X_12537_ _18989_/Q _12537_/B _14249_/B VDD VSS _12693_/B MIN3X1
XTAP_TAPCELL_ROW_4_50 VDD VSS WELLTAP
X_19093_ _19094_/CK _19093_/D _19093_/Q VDD VSS DFFQX1
XFILLER_117_329 VDD VSS FILLER4
XFILLER_129_189 VDD VSS FILLER4
XFILLER_145_638 VDD VSS FILLER4
X_18044_ _18543_/Q _18044_/B VDD VSS _18045_/C NOR2X1
XFILLER_157_498 VDD VSS FILLER4
XFILLER_144_126 VSS VDD FILLER2
XFILLER_145_649 VSS VDD FILLER2
X_15256_ _15259_/B _15256_/B VDD VSS _18118_/B XNOR2X1
X_12468_ _12480_/A _12553_/B _12553_/C VDD VSS _14407_/C OR3BX1
XFILLER_144_137 VSS VDD FILLER2
X_14207_ _14231_/A _14207_/B VDD VSS _18956_/D AND2X1
X_11419_ _11422_/A _17990_/B _11419_/C VDD VSS _18613_/D NOR3X1
X_15187_ _19538_/Q _15270_/C VDD VSS _15905_/B XNOR2X1
X_12399_ _14531_/B _14531_/C _19237_/Q VDD VSS _12401_/C AO21X2
XFILLER_125_362 VSS VDD FILLER2
X_14138_ _14158_/A _14138_/B VDD VSS _18895_/D AND2X1
XFILLER_99_747 VSS VDD FILLER2
XFILLER_152_181 VDD VSS FILLER4
X_19995_ _19995_/CK _19995_/D _19995_/Q VDD VSS DFFQX1
XFILLER_98_235 VSS VDD FILLER2
XFILLER_152_192 VDD VSS DECAPHV8
XFILLER_99_769 VDD VSS FILLER1
Xclkbuf_0__09171_ _18220_/ECK VDD VSS clkbuf_0__09171_/Y BUFX12
XFILLER_101_719 VSS VDD FILLER2
X_18946_ _18973_/CK _18946_/D _18946_/Q VDD VSS DFFQX1
X_14069_ _18952_/Q _14203_/A _14203_/B VDD VSS _14086_/B NOR3X1
XFILLER_98_279 VDD VSS FILLER4
XFILLER_100_218 VSS VDD FILLER2
XFILLER_67_611 VDD VSS DECAPHV8
X_18877_ _18905_/CK _18877_/D _18877_/Q VDD VSS DFFQX1
X_17828_ _19930_/Q _19931_/Q _17828_/C VDD VSS _17829_/C OAI21X1
XFILLER_39_368 VDD VSS FILLER4
XFILLER_67_688 VSS VDD FILLER2
XFILLER_94_474 VSS VDD FILLER2
XFILLER_67_699 VSS VDD FILLER2
X_17759_ _19915_/Q _19883_/Q VDD VSS _17766_/C NOR2X1
XFILLER_23_703 VDD VSS FILLER4
XFILLER_22_213 VDD VSS FILLER1
X_19429_ _19460_/CK _19429_/D _19429_/Q VDD VSS DFFQX1
XFILLER_62_382 VSS VDD FILLER2
XFILLER_23_747 VSS VDD FILLER2
XFILLER_22_235 VDD VSS FILLER4
XTAP_TAPCELL_ROW_60_550 VDD VSS WELLTAP
XFILLER_148_421 VSS VDD FILLER2
XFILLER_108_307 VSS VDD FILLER2
XFILLER_136_616 VDD VSS FILLER1
XFILLER_135_126 VDD VSS FILLER4
Xclkbuf_leaf_8__000_ clkload72/A VDD VSS _19705_/CK BUFX12
XFILLER_163_468 VDD VSS FILLER4
XFILLER_2_607 VSS VDD FILLER2
XFILLER_104_502 VSS VDD FILLER2
XFILLER_150_107 VSS VDD FILLER2
XFILLER_132_822 VSS VDD FILLER2
X_20204_ _20204_/A VDD VSS _20204_/Y BUFX3
XFILLER_89_213 VDD VSS FILLER1
XFILLER_132_833 VDD VSS FILLER1
Xmax_cap172 _10330_/B VDD VSS _11208_/D BUFX6
Xmax_cap183 _18524_/Q VDD VSS _18471_/D BUFX12
XFILLER_131_354 VDD VSS FILLER1
X_20135_ _20135_/A VDD VSS _20135_/Y BUFX3
XFILLER_89_268 VDD VSS FILLER1
X_09946_ _09898_/Y _09902_/Y _10190_/B VDD VSS _09946_/Y MUXI2X1
X_20066_ clkload6/A _20196_/A _20067_/D _20067_/RB VDD VSS DFFRQX1
X_09877_ _18566_/Q _09881_/B VDD VSS _09908_/B XOR2X1
XFILLER_85_463 VSS VDD FILLER2
XFILLER_46_828 VDD VSS FILLER4
XFILLER_72_146 VSS VDD FILLER2
XFILLER_166_4 VDD VSS FILLER4
X_11770_ _19991_/Q _19255_/Q VDD VSS _11778_/B XNOR2X1
X_10721_ _10721_/A _10721_/B _10721_/C _10721_/D VDD VSS _10726_/B AOI31X1
XFILLER_158_207 VDD VSS FILLER1
X_13440_ _13548_/A _14388_/B VDD VSS _13614_/B NOR2X1
X_10652_ _10763_/A _10652_/B _10652_/C VDD VSS _10653_/D OAI21X1
XFILLER_139_432 VSS VDD FILLER2
XFILLER_110_95 VSS VDD FILLER2
XFILLER_70_44 VSS VDD FILLER2
XFILLER_70_55 VDD VSS FILLER4
X_13371_ _19025_/Q VDD VSS _13373_/D INVX1
X_10583_ _10738_/B _11267_/A VDD VSS _10584_/D NAND2BX1
XFILLER_70_66 VDD VSS DECAPHV16
X_15110_ _19482_/Q _15183_/A _15183_/B VDD VSS _15112_/C XNOR3X1
X_12322_ _12391_/A _12391_/B _12391_/C VDD VSS _12326_/B AOI21X1
XFILLER_70_99 VSS VDD FILLER2
XFILLER_166_273 VDD VSS DECAPHV8
X_16090_ _19586_/Q _16735_/B VDD VSS _16091_/B XOR2X1
XFILLER_127_649 VSS VDD FILLER2
XFILLER_154_435 VDD VSS FILLER1
XFILLER_5_423 VSS VDD FILLER2
XFILLER_119_60 VDD VSS FILLER4
X_15041_ _15041_/A _15041_/B _15041_/C VDD VSS _15072_/A AOI21X1
XFILLER_5_445 VSS VDD FILLER2
X_12253_ _14374_/B _19097_/Q VDD VSS _12363_/A NAND2BX1
XFILLER_119_82 VSS VDD FILLER2
XFILLER_107_351 VDD VSS FILLER4
XFILLER_141_118 VDD VSS DECAPHV8
X_11204_ _11204_/A _11204_/B _11204_/C VDD VSS _11227_/C OA21X2
XFILLER_79_53 VSS VDD FILLER2
XFILLER_135_693 VDD VSS DECAPHV16
X_12184_ _19097_/Q wire159/Y _12208_/B VDD VSS _12210_/D XOR3X1
XFILLER_134_192 VDD VSS FILLER4
X_18800_ _18801_/CK _18800_/D _18800_/Q VDD VSS DFFQX1
XFILLER_122_354 VSS VDD FILLER2
X_11135_ _18654_/Q _18816_/Q VDD VSS _11138_/A XNOR2X1
XFILLER_96_717 VDD VSS FILLER4
X_19780_ _19825_/CK _19780_/D _19780_/Q VDD VSS DFFQX1
X_16992_ _16994_/B _16992_/B VDD VSS _16993_/B XOR2X1
XFILLER_122_376 VSS VDD FILLER2
XFILLER_49_611 VSS VDD FILLER2
XFILLER_0_150 VSS VDD FILLER2
X_18731_ _19939_/CK _18731_/D _18731_/Q VDD VSS DFFQX1
X_15943_ _19581_/Q _16730_/B VDD VSS _15944_/B XNOR2X1
X_11066_ _18679_/Q _18787_/Q VDD VSS _11107_/B XOR2X1
XFILLER_0_183 VSS VDD FILLER2
XFILLER_95_52 VSS VDD FILLER2
XFILLER_0_194 VSS VDD FILLER2
X_10017_ _10032_/A _10017_/B _10017_/C _10034_/A VDD VSS _10018_/C AOI211X1
XTAP_TAPCELL_ROW_66_609 VDD VSS WELLTAP
XFILLER_95_74 VDD VSS DECAPHV16
X_18662_ _18799_/CK _18662_/D _18662_/Q VDD VSS DFFQX1
XFILLER_48_154 VSS VDD FILLER2
X_15874_ _15879_/A _15874_/B VDD VSS _19482_/D AND2X1
XFILLER_95_96 VSS VDD FILLER2
XFILLER_76_474 VDD VSS FILLER1
XTAP_TAPCELL_ROW_128_1166 VDD VSS WELLTAP
X_17613_ _17618_/C _17618_/B VDD VSS _17615_/B NAND2BX1
XFILLER_63_113 VDD VSS DECAPHV8
X_14825_ _14872_/D VDD VSS _14826_/D INVX1
XFILLER_91_433 VSS VDD FILLER2
XFILLER_36_338 VDD VSS DECAPHV8
X_18593_ _18595_/CK _18593_/D _18593_/Q VDD VSS DFFQX1
XFILLER_63_146 VSS VDD FILLER2
XFILLER_151_91 VSS VDD FILLER2
X_17544_ _17546_/B _17544_/B VDD VSS _17545_/B XOR2X1
XFILLER_91_477 VSS VDD FILLER2
XFILLER_17_563 VDD VSS FILLER1
X_14756_ _19418_/Q _14774_/B _15800_/B VDD VSS _15768_/B XNOR3X1
XTAP_TAPCELL_ROW_74_675 VDD VSS WELLTAP
X_11968_ _11968_/A _14399_/B _11968_/C VDD VSS _12022_/A MIN3X1
XFILLER_60_820 VDD VSS FILLER1
XFILLER_32_522 VDD VSS FILLER4
X_13707_ _13716_/A _13716_/B _13716_/C VDD VSS _13779_/C NOR3X1
X_17475_ _19853_/Q _19821_/Q _17475_/C VDD VSS _17479_/C MIN3X1
X_10919_ _10954_/A _10919_/B VDD VSS _10920_/B XNOR2X1
XFILLER_149_207 VSS VDD FILLER2
X_14687_ _19416_/Q _14698_/B _15798_/B VDD VSS _15766_/B XNOR3X1
X_11899_ _11899_/A _11899_/B _14398_/B VDD VSS _11961_/C MIN3X1
X_19214_ _19217_/CK _19214_/D _19214_/Q VDD VSS DFFQX1
X_16426_ _16453_/B _16426_/B VDD VSS _16785_/B XNOR2X1
X_13638_ _13639_/C _14453_/A VDD VSS _13640_/C _14453_/B NAND3X1
XFILLER_9_740 VDD VSS FILLER4
XFILLER_158_752 VSS VDD FILLER2
X_19145_ _19196_/CK _19145_/D _19145_/Q VDD VSS DFFQX1
X_16357_ _19724_/Q _16888_/B VDD VSS _16358_/C NOR2X1
X_13569_ _13675_/A _13675_/B VDD VSS _14194_/B XNOR2X1
XTAP_TAPCELL_ROW_139_1262 VDD VSS WELLTAP
XFILLER_158_785 VDD VSS FILLER4
XFILLER_118_627 VSS VDD FILLER2
XFILLER_117_115 VDD VSS FILLER1
X_15308_ _15308_/A _15308_/B VDD VSS _15878_/C OR2X2
X_19076_ _19126_/CK _19076_/D _19076_/Q VDD VSS DFFQX1
X_16288_ _19594_/Q _16744_/B VDD VSS _16311_/B XOR2X1
XFILLER_117_159 VSS VDD FILLER2
XFILLER_145_468 VDD VSS FILLER4
X_18027_ _18030_/B _18045_/B _18027_/C _18049_/D VDD VSS _19971_/D OAI31X1
XFILLER_145_479 VSS VDD FILLER2
X_15239_ _15311_/C _15274_/B VDD VSS _15240_/B NAND2X1
XFILLER_114_811 VSS VDD FILLER2
XFILLER_132_107 VSS VDD FILLER2
XFILLER_132_129 VDD VSS FILLER1
XFILLER_99_533 VDD VSS FILLER1
Xfanout207 _09284_/AB VDD VSS _18442_/RB BUFX3
X_09800_ _20177_/A _09814_/B _09813_/C _20195_/A VDD VSS _09801_/E AO22X2
Xfanout218 _18373_/RB VDD VSS _20075_/RB BUFX3
XFILLER_140_151 VDD VSS FILLER4
X_19978_ _19985_/CK _19978_/D _19978_/Q VDD VSS DFFQX1
XFILLER_113_387 VDD VSS FILLER1
XFILLER_101_538 VDD VSS FILLER1
X_18929_ _18961_/CK _18929_/D _18929_/Q VDD VSS DFFQX1
X_09731_ _09753_/D _09731_/B _09731_/C _09731_/D VDD VSS _18289_/D OAI211X1
XFILLER_140_195 VSS VDD FILLER2
XFILLER_39_143 VDD VSS FILLER1
X_09662_ _18493_/Q _09819_/A _09673_/C _18429_/Q VDD VSS _09663_/E OAI22X1
XFILLER_67_463 VSS VDD FILLER2
XFILLER_28_839 VSS VDD FILLER2
XFILLER_55_625 VSS VDD FILLER2
XFILLER_55_636 VDD VSS FILLER1
XFILLER_54_113 VDD VSS FILLER1
XFILLER_131_28 VSS VDD FILLER2
X_09593_ _18457_/Q _09751_/B _09593_/C _09593_/D VDD VSS _09594_/B OAI211X1
XTAP_TAPCELL_ROW_37_344 VDD VSS WELLTAP
XFILLER_82_477 VDD VSS FILLER4
XFILLER_42_319 VDD VSS FILLER4
XFILLER_51_831 VDD VSS FILLER4
XFILLER_50_341 VDD VSS FILLER1
XFILLER_23_588 VDD VSS FILLER4
XFILLER_164_700 VSS VDD FILLER2
XFILLER_40_25 VDD VSS FILLER4
XFILLER_108_137 VSS VDD FILLER2
XFILLER_156_25 VSS VDD FILLER2
XFILLER_163_243 VDD VSS FILLER4
XFILLER_164_788 VSS VDD FILLER2
XFILLER_123_107 VDD VSS FILLER4
XFILLER_151_427 VSS VDD FILLER2
XFILLER_104_310 VSS VDD FILLER2
XFILLER_144_490 VSS VDD FILLER2
Xhold261 hold261/A VDD VSS hold261/Y BUFX3
XFILLER_104_354 VSS VDD FILLER2
XFILLER_104_365 VSS VDD FILLER2
XFILLER_120_814 VSS VDD FILLER2
XFILLER_131_151 VSS VDD FILLER2
XFILLER_78_739 VSS VDD FILLER2
XFILLER_120_836 VSS VDD FILLER2
XFILLER_131_184 VSS VDD FILLER2
X_20118_ _20118_/A VDD VSS _20118_/Y BUFX3
X_09929_ _11178_/C _09929_/B _09929_/C _09944_/A VDD VSS _09930_/C AOAI211X1
XFILLER_86_761 VDD VSS DECAPHV8
X_20049_ clkload3/A _20049_/D _20050_/D input3/Y VDD VSS DFFRQX1
X_12940_ _12940_/A _12940_/B _12940_/C _12940_/D VDD VSS _13108_/A AO31X2
XFILLER_86_783 VDD VSS FILLER4
XFILLER_85_260 VSS VDD FILLER2
XFILLER_85_282 VDD VSS FILLER4
X_12871_ _18993_/Q _12996_/A _12996_/B VDD VSS _12903_/C XNOR3X1
XFILLER_34_809 VSS VDD FILLER2
X_14610_ _19413_/Q _15795_/B VDD VSS _14635_/B OR2X2
X_11822_ _11830_/A _11830_/B _11830_/C VDD VSS _14460_/B OAI21X1
X_15590_ _19326_/Q _15698_/B VDD VSS _15591_/C NOR2BX1
XFILLER_60_105 VDD VSS FILLER1
XFILLER_33_319 VSS VDD FILLER2
X_14541_ _15806_/A _14541_/B _14541_/C VDD VSS _19247_/D NOR3X1
X_11753_ _11764_/B _11764_/C VDD VSS _14488_/B NAND2X1
XFILLER_60_138 VDD VSS FILLER1
XFILLER_157_0 VDD VSS FILLER4
XFILLER_42_853 VDD VSS FILLER4
XFILLER_159_505 VSS VDD FILLER2
XTAP_TAPCELL_ROW_71_656 VDD VSS WELLTAP
X_10704_ _18562_/Q _10707_/B VDD VSS _10708_/B XOR2X1
XFILLER_41_352 VSS VDD FILLER2
XFILLER_159_538 VDD VSS FILLER4
X_17260_ _17263_/C _17261_/B _17306_/C VDD VSS _17261_/C OAI21X1
XFILLER_14_588 VSS VDD FILLER2
X_14472_ _14421_/Y _14472_/B _14472_/C VDD VSS _19185_/D AND3BX1
X_11684_ _18955_/Q VDD VSS _12070_/A INVX1
X_16211_ _16236_/C _16211_/B VDD VSS _16741_/B XNOR2X1
XFILLER_139_240 VDD VSS FILLER1
X_13423_ _14387_/B _19109_/Q VDD VSS _13528_/A NAND2BX1
X_10635_ _18640_/Q _18802_/Q VDD VSS _10640_/A XOR2X1
X_17191_ _19793_/Q _19761_/Q VDD VSS _17197_/B NAND2X1
Xclkload109 _18234_/CK VDD VSS clkload109/Y INVX1
Xdelaybuf_8_clk delaybuf_8_clk/A VDD VSS delaybuf_8_clk/Y BUFX12
XFILLER_155_722 VSS VDD FILLER2
X_16142_ _16155_/B _16142_/B VDD VSS _16809_/B XNOR2X1
X_13354_ _13354_/A _14416_/B _13354_/C VDD VSS _14417_/B OAI21X1
X_10566_ _18637_/Q _18799_/Q VDD VSS _10570_/D AND2X1
XFILLER_154_221 VSS VDD FILLER2
X_12305_ _19181_/Q _14467_/B VDD VSS _12313_/A AND2X1
XFILLER_6_754 VSS VDD FILLER2
XFILLER_5_231 VDD VSS FILLER4
XFILLER_127_468 VDD VSS FILLER4
XFILLER_5_242 VSS VDD FILLER2
X_16073_ _16080_/C _16080_/B VDD VSS _16074_/B NAND2BX1
X_13285_ _18886_/Q VDD VSS _13486_/A INVX1
XFILLER_155_788 VSS VDD FILLER2
X_10497_ _10535_/B _10581_/A VDD VSS _10582_/C NAND2BX1
XFILLER_6_787 VSS VDD FILLER2
XFILLER_114_129 VDD VSS FILLER4
X_15024_ _15024_/A _15045_/D VDD VSS _15775_/B XOR2X1
X_19901_ _19924_/CK _19901_/D _19901_/Q VDD VSS DFFQX1
X_12236_ _12236_/A _12236_/B _12236_/C _12236_/D VDD VSS _14531_/C AOAI211X1
XFILLER_123_641 VDD VSS FILLER1
XFILLER_69_706 VSS VDD FILLER2
XFILLER_123_663 VSS VDD FILLER2
X_19832_ clkload5/A _19832_/D _19832_/Q VDD VSS DFFQX1
X_12167_ _12236_/A _12236_/B _12236_/C VDD VSS _12168_/C AOI21X1
XFILLER_96_514 VDD VSS DECAPHV8
XFILLER_68_205 VDD VSS FILLER4
XFILLER_110_302 VDD VSS FILLER4
XFILLER_111_836 VDD VSS FILLER1
XTAP_TAPCELL_ROW_79_723 VDD VSS WELLTAP
XFILLER_96_536 VDD VSS FILLER1
X_11118_ _11118_/A _11118_/B VDD VSS _11119_/C NAND2X1
X_19763_ _19934_/CK _19763_/D _19763_/Q VDD VSS DFFQX1
XFILLER_122_195 VSS VDD FILLER2
X_16975_ _16977_/B _16975_/B VDD VSS _16976_/B XOR2X1
X_12098_ _14528_/A _14528_/B _19234_/Q VDD VSS _12099_/D OA21X2
XFILLER_96_558 VDD VSS FILLER1
X_18714_ _18795_/CK _18714_/D _18714_/Q VDD VSS DFFQX1
XFILLER_77_761 VDD VSS FILLER4
X_15926_ _15939_/A _15939_/B VDD VSS _16729_/B XNOR2X1
X_11049_ _10984_/Y _11048_/Y _10947_/Y VDD VSS _11049_/Y MUXI2X1
XFILLER_49_463 VSS VDD FILLER2
Xclkbuf_leaf_4_clk_regs clkload1/A VDD VSS _19895_/CK BUFX12
X_19694_ _19695_/CK _19694_/D _19694_/Q VDD VSS DFFQX1
XFILLER_83_219 VSS VDD FILLER2
XFILLER_64_400 VSS VDD FILLER2
XFILLER_64_411 VDD VSS FILLER1
XFILLER_37_636 VDD VSS FILLER1
XFILLER_49_496 VDD VSS FILLER1
X_18645_ _19949_/CK _18645_/D _18645_/Q VDD VSS DFFQX1
XFILLER_76_293 VSS VDD FILLER2
X_15857_ _15867_/A _15857_/B VDD VSS _19468_/D NOR2X1
XFILLER_37_658 VSS VDD FILLER2
XFILLER_36_146 VSS VDD FILLER2
X_14808_ _15297_/A _18063_/B VDD VSS _19279_/D AND2X1
XFILLER_36_168 VSS VDD FILLER2
X_18576_ _18595_/CK _18576_/D _18576_/Q VDD VSS DFFQX1
XFILLER_92_797 VSS VDD FILLER2
X_15788_ _15793_/A _15788_/B VDD VSS _19407_/D AND2X1
Xclkbuf_leaf_7__001_ clkload32/A VDD VSS _19995_/CK BUFX12
XFILLER_45_680 VSS VDD FILLER2
X_17527_ _17527_/A _17527_/B _17527_/C VDD VSS _17529_/A OA21X2
X_14739_ _14739_/A _14739_/B _14739_/C _14739_/D VDD VSS _14746_/A AOAI211X1
X_17458_ _17460_/A _17460_/B _17458_/C VDD VSS _19850_/D AOI21X1
XFILLER_20_514 VDD VSS FILLER4
XFILLER_60_683 VSS VDD FILLER2
XFILLER_20_525 VSS VDD FILLER2
X_16409_ _16409_/A _16416_/B VDD VSS _16890_/B XOR2X1
XFILLER_146_700 VDD VSS FILLER4
X_17389_ _17392_/B _17389_/B VDD VSS _17390_/B XOR2X1
XTAP_TAPCELL_ROW_42_391 VDD VSS WELLTAP
XFILLER_118_402 VSS VDD FILLER2
XFILLER_72_0 VSS VDD FILLER2
XFILLER_146_733 VSS VDD FILLER2
X_19128_ _19157_/CK _19128_/D _19128_/Q VDD VSS DFFQX1
XFILLER_118_468 VDD VSS FILLER4
XFILLER_146_777 VSS VDD FILLER2
XFILLER_146_788 VSS VDD FILLER2
X_19059_ _19059_/CK _19059_/D _19059_/Q VDD VSS DFFQX1
XFILLER_161_747 VSS VDD FILLER2
XFILLER_126_17 VDD VSS FILLER4
XFILLER_160_235 VSS VDD FILLER2
XFILLER_99_352 VSS VDD FILLER2
XFILLER_102_814 VSS VDD FILLER2
XFILLER_113_151 VSS VDD FILLER2
XFILLER_114_685 VSS VDD FILLER2
XFILLER_101_313 VSS VDD FILLER2
XFILLER_102_836 VSS VDD FILLER2
XFILLER_113_184 VSS VDD FILLER2
XFILLER_101_346 VDD VSS FILLER1
Xclkbuf_leaf_11__000_ clkload71/A VDD VSS _19724_/CK BUFX12
XFILLER_75_709 VDD VSS DECAPHV8
X_09714_ _20109_/A _20125_/A _09773_/D VDD VSS _09715_/B MUXI2X1
XFILLER_74_208 VDD VSS FILLER1
XFILLER_142_49 VSS VDD FILLER2
XFILLER_67_282 VSS VDD FILLER2
XFILLER_83_742 VSS VDD FILLER2
X_09645_ _20137_/A _20185_/A _09626_/B VDD VSS _09646_/B MUXI2X1
XFILLER_82_230 VSS VDD FILLER2
XFILLER_83_764 VDD VSS DECAPHV8
XFILLER_55_477 VDD VSS FILLER4
XFILLER_15_308 VSS VDD FILLER2
X_09576_ _09626_/B _09576_/B VDD VSS _09716_/B AND2X1
XFILLER_82_263 VSS VDD FILLER2
Xclkbuf_leaf_26__000_ clkload70/A VDD VSS _19331_/CK BUFX12
XFILLER_70_414 VDD VSS FILLER4
XFILLER_42_105 VDD VSS FILLER4
XFILLER_42_116 VDD VSS FILLER4
XFILLER_35_58 VSS VDD FILLER2
XFILLER_11_514 VSS VDD FILLER2
XTAP_TAPCELL_ROW_159_1446 VDD VSS WELLTAP
XFILLER_51_24 VSS VDD FILLER2
XFILLER_11_547 VSS VDD FILLER2
XFILLER_7_507 VSS VDD FILLER2
XFILLER_137_722 VSS VDD FILLER2
X_10420_ _10448_/A _10448_/B VDD VSS _10421_/D NAND2X1
XFILLER_149_593 VDD VSS DECAPHV8
XFILLER_109_468 VDD VSS FILLER4
X_10351_ _10625_/A _10660_/B VDD VSS _10427_/C NAND2X1
XFILLER_124_405 VSS VDD FILLER2
XFILLER_124_416 VSS VDD FILLER2
XFILLER_151_202 VSS VDD FILLER2
X_13070_ _18995_/Q _13070_/B _13097_/C VDD VSS _13192_/B XNOR3X1
X_10282_ _10329_/A _10329_/B _10763_/A VDD VSS _10283_/B AOI21X1
XFILLER_3_768 VSS VDD FILLER2
X_12021_ _19093_/Q VDD VSS _12023_/A INVX1
XFILLER_2_256 VSS VDD FILLER2
XFILLER_105_674 VSS VDD FILLER2
XFILLER_78_514 VDD VSS DECAPHV16
XFILLER_2_278 VSS VDD FILLER2
XFILLER_78_547 VSS VDD FILLER2
XFILLER_120_644 VSS VDD FILLER2
XFILLER_116_83 VSS VDD FILLER2
XFILLER_120_655 VDD VSS FILLER1
XFILLER_66_709 VSS VDD FILLER2
XFILLER_93_506 VSS VDD FILLER2
XFILLER_19_603 VSS VDD FILLER2
X_16760_ _16776_/A VDD VSS _16775_/A BUFX3
X_13972_ _13991_/A _14201_/B VDD VSS _13983_/C XNOR2X1
XFILLER_58_271 VSS VDD FILLER2
X_15711_ _15725_/A _15711_/B VDD VSS _19338_/D AND2X1
XFILLER_76_98 VSS VDD FILLER2
X_12923_ _12939_/A _12939_/B _12939_/C VDD VSS _14383_/B OAI21X1
X_16691_ _19898_/Q _16702_/B VDD VSS _19546_/D AND2X1
XTAP_TAPCELL_ROW_125_1136 VDD VSS WELLTAP
X_18430_ _18439_/CK _18430_/D _18430_/Q _18464_/RB VDD VSS DFFRQX1
XFILLER_46_477 VSS VDD FILLER2
XFILLER_132_82 VSS VDD FILLER2
X_15642_ _15655_/A _15653_/A VDD VSS _15654_/A XNOR2X1
XFILLER_73_263 VSS VDD FILLER2
X_12854_ _19217_/Q _12854_/B _12951_/D VDD VSS _13032_/C XNOR3X1
XTAP_TAPCELL_ROW_84_770 VDD VSS WELLTAP
XFILLER_61_414 VSS VDD FILLER2
XFILLER_15_820 VSS VDD FILLER2
X_18361_ _18374_/CK _18510_/Q _20198_/A _18471_/RB VDD VSS DFFRQX1
X_11805_ _19994_/Q _19258_/Q VDD VSS _11838_/C XOR2X1
X_15573_ _19465_/Q VDD VSS _15574_/A INVX1
XFILLER_61_458 VDD VSS FILLER4
X_12785_ _18908_/Q _12883_/B _14152_/B VDD VSS _12791_/C XNOR3X1
XFILLER_14_341 VSS VDD FILLER2
XFILLER_42_650 VSS VDD FILLER2
X_17312_ _17318_/C _17318_/B VDD VSS _17315_/B NAND2BX1
X_14524_ _14539_/A _14524_/B VDD VSS _19230_/D NOR2X1
X_18292_ _18295_/CK _18292_/D _18292_/Q VDD VSS DFFQX1
X_11736_ _11736_/A _11736_/B VDD VSS _14518_/B XNOR2X1
XFILLER_25_91 VSS VDD FILLER2
X_17243_ _19804_/Q _19772_/Q _17243_/C VDD VSS _17247_/B AOI21X1
XFILLER_30_856 VDD VSS FILLER1
XFILLER_128_700 VDD VSS FILLER4
XFILLER_147_519 VSS VDD FILLER2
X_14455_ _14467_/A _14455_/B VDD VSS _19170_/D AND2X1
X_11667_ _18806_/Q _11669_/B VDD VSS _18833_/D AND2X1
X_13406_ _13406_/A _13406_/B _13406_/C _13406_/D VDD VSS _13604_/B AOAI211X1
X_17174_ _17176_/C _17174_/B _17174_/C VDD VSS _19789_/D AOI21X1
X_10618_ _10616_/Y _10618_/B _18720_/Q _10965_/A VDD VSS _10619_/D AOI2B2X1
X_14386_ _14381_/Y _14386_/B _14386_/C VDD VSS _19108_/D AND3BX1
X_11598_ _18743_/Q _11600_/B VDD VSS _18770_/D AND2X1
XFILLER_127_232 VDD VSS FILLER4
XFILLER_6_540 VDD VSS FILLER1
X_16125_ _16512_/A _16125_/B VDD VSS _19523_/D NOR2X1
XFILLER_128_788 VSS VDD FILLER2
X_13337_ _13451_/A _14449_/B VDD VSS _13542_/B NOR2X1
X_10549_ _11263_/A _10596_/A VDD VSS _10587_/A NOR2X1
XFILLER_155_574 VSS VDD FILLER2
XFILLER_128_799 VDD VSS FILLER1
XFILLER_6_584 VSS VDD FILLER2
XFILLER_51_5 VSS VDD FILLER2
XFILLER_143_747 VSS VDD FILLER2
XFILLER_142_235 VSS VDD FILLER2
X_16056_ _19648_/Q _16805_/B VDD VSS _16057_/C NOR2X1
X_13268_ _19081_/Q _13268_/B _13364_/D VDD VSS _14323_/C XNOR3X1
XFILLER_44_4 VSS VDD FILLER2
X_15007_ _15052_/A _15052_/B VDD VSS _15021_/B NAND2X1
X_12219_ _19181_/Q _14467_/B VDD VSS _12382_/A NAND2X1
X_13199_ _14257_/B _14257_/C _18995_/Q VDD VSS _13203_/B AOI21X1
XFILLER_123_482 VDD VSS FILLER1
X_19815_ _19853_/CK _19815_/D _19815_/Q VDD VSS DFFQX1
X_16958_ _19746_/Q _17049_/B _16962_/A _16962_/B VDD VSS _16958_/Y AOI211X1
X_19746_ _19785_/CK _19746_/D _19746_/Q VDD VSS DFFQX1
XFILLER_96_399 VSS VDD FILLER2
XFILLER_49_282 VSS VDD FILLER2
X_15909_ _16100_/A _15909_/B VDD VSS _19514_/D NOR2X1
XFILLER_65_742 VSS VDD FILLER2
X_19677_ _19722_/CK _19677_/D _19677_/Q VDD VSS DFFQX1
XFILLER_65_753 VSS VDD FILLER2
X_16889_ _16899_/A wire155/Y VDD VSS _19725_/D AND2X1
X_09430_ _09446_/A _09751_/B VDD VSS _18213_/E NOR2X1
XFILLER_64_252 VSS VDD FILLER2
X_18628_ _18628_/CK _18628_/D _18628_/Q VDD VSS DFFQX1
XFILLER_52_425 VSS VDD FILLER2
XFILLER_80_745 VSS VDD FILLER2
X_09361_ _18505_/Q _09630_/C _09354_/Y VDD VSS _18505_/D MUX2X1
XTAP_TAPCELL_ROW_19_185 VDD VSS WELLTAP
X_18559_ _18583_/CK _18559_/D _18559_/Q VDD VSS DFFQX1
XFILLER_52_458 VSS VDD FILLER2
XFILLER_80_789 VDD VSS FILLER1
XFILLER_33_661 VSS VDD FILLER2
X_09292_ _18201_/A VDD VSS _18199_/A BUFX3
XANTENNA_12 _11378_/A VDD VSS ANTENNA2
XFILLER_165_349 VDD VSS FILLER1
XFILLER_146_541 VDD VSS FILLER1
XFILLER_119_766 VDD VSS FILLER4
XFILLER_146_563 VDD VSS FILLER1
XFILLER_106_405 VSS VDD FILLER2
XFILLER_161_500 VDD VSS DECAPHV8
XFILLER_133_213 VDD VSS FILLER1
XFILLER_134_736 VSS VDD FILLER2
XFILLER_146_596 VSS VDD FILLER2
Xclkbuf_2_3__f_sclk_regs clkbuf_0_sclk_regs/Y VDD VSS _20081_/CK BUFX12
XTAP_TAPCELL_ROW_154_1398 VDD VSS WELLTAP
Xoutput130 _20214_/Y VDD VSS o_uwb_tx_cfg[17] BUFX3
Xoutput141 _20224_/Y VDD VSS o_uwb_tx_cfg[27] BUFX3
XFILLER_121_408 VSS VDD FILLER2
XFILLER_88_856 VDD VSS FILLER1
XFILLER_102_644 VSS VDD FILLER2
XFILLER_153_48 VDD VSS DECAPHV8
XFILLER_48_709 VDD VSS FILLER1
XFILLER_102_666 VDD VSS FILLER1
XFILLER_102_688 VSS VDD FILLER2
XFILLER_47_219 VSS VDD FILLER2
XTAP_TAPCELL_ROW_98_895 VDD VSS WELLTAP
XFILLER_28_444 VSS VDD FILLER2
XFILLER_90_509 VSS VDD FILLER2
XFILLER_83_550 VSS VDD FILLER2
XFILLER_46_57 VSS VDD FILLER2
XFILLER_28_455 VSS VDD FILLER2
XTAP_TAPCELL_ROW_165_1494 VDD VSS WELLTAP
XFILLER_83_561 VDD VSS DECAPHV8
XFILLER_55_252 VDD VSS FILLER4
XFILLER_71_712 VDD VSS DECAPHV8
XFILLER_55_263 VSS VDD FILLER2
X_09628_ _18443_/Q _09816_/B _09628_/C _09628_/D VDD VSS _09629_/C OAI211X1
XFILLER_28_499 VSS VDD FILLER2
XFILLER_71_756 VSS VDD FILLER2
XFILLER_43_447 VDD VSS FILLER4
X_09559_ _20098_/A _09784_/B _09729_/D VDD VSS _09569_/A AOI21X1
XTAP_TAPCELL_ROW_81_740 VDD VSS WELLTAP
XFILLER_70_244 VDD VSS FILLER1
XFILLER_12_801 VSS VDD FILLER2
XFILLER_102_96 VDD VSS FILLER1
X_12570_ _14534_/A _14534_/B _19240_/Q VDD VSS _12571_/D OAI21X1
XFILLER_62_45 VDD VSS FILLER1
XFILLER_24_683 VSS VDD FILLER2
XFILLER_12_834 VSS VDD FILLER2
XTAP_TAPCELL_ROW_53_486 VDD VSS WELLTAP
XFILLER_24_694 VSS VDD FILLER2
XFILLER_8_805 VDD VSS FILLER4
X_11521_ _18673_/Q _11531_/B VDD VSS _18700_/D AND2X1
XFILLER_23_193 VDD VSS FILLER1
XFILLER_7_18 VSS VDD FILLER2
X_14240_ _14240_/A _14240_/B VDD VSS _14241_/B XNOR2X1
X_11452_ _19945_/Q _11460_/B VDD VSS _18638_/D AND2X1
XFILLER_156_349 VDD VSS FILLER4
XFILLER_11_388 VSS VDD FILLER2
X_10403_ _10476_/A _10476_/B _10927_/C VDD VSS _10404_/D AOI21X1
X_14171_ _14186_/A _14171_/B VDD VSS _18924_/D NOR2X1
X_11383_ _11383_/A _11383_/B VDD VSS _18593_/D NOR2X1
XFILLER_137_596 VSS VDD FILLER2
XFILLER_125_747 VSS VDD FILLER2
XFILLER_164_382 VSS VDD FILLER2
XFILLER_11_60 VDD VSS FILLER4
X_13122_ _13122_/A _13122_/B _13138_/C VDD VSS _13316_/B XNOR3X1
X_10334_ _18631_/Q _18793_/Q VDD VSS _10372_/C AND2X1
XFILLER_124_235 VSS VDD FILLER2
XFILLER_125_769 VDD VSS FILLER1
XFILLER_124_257 VDD VSS FILLER4
XFILLER_152_566 VDD VSS FILLER4
X_17930_ _17941_/A _17941_/B VDD VSS _17935_/A OR2X2
Xclkbuf_leaf_6__002_ clkbuf_leaf_9__002_/A VDD VSS _18799_/CK BUFX12
X_13053_ _20011_/Q _19275_/Q VDD VSS _13150_/D XNOR2X1
XFILLER_79_812 VSS VDD FILLER2
XFILLER_152_588 VSS VDD FILLER2
X_10265_ _18623_/Q _18624_/Q VDD VSS _11432_/B NAND2BX1
XFILLER_133_791 VDD VSS FILLER4
X_12004_ _19094_/Q _12083_/B _12079_/C VDD VSS _12075_/C XNOR3X1
X_17861_ _17861_/A _17861_/B VDD VSS _17862_/B XNOR2X1
XTAP_TAPCELL_ROW_131_1195 VDD VSS WELLTAP
X_10196_ _13177_/A _11424_/C VDD VSS _18545_/D NOR2X1
XFILLER_94_815 VDD VSS FILLER1
X_16812_ _17391_/A VDD VSS _16826_/A BUFX3
X_19600_ _19600_/CK _19600_/D _19600_/Q VDD VSS DFFQX1
X_17792_ _17793_/A _17793_/B _17793_/D _17793_/C VDD VSS _17795_/C AOI211X1
XFILLER_19_400 VSS VDD FILLER2
XFILLER_78_399 VDD VSS FILLER4
XFILLER_47_731 VSS VDD FILLER2
XFILLER_19_422 VSS VDD FILLER2
X_19531_ _19531_/CK _19531_/D _19531_/Q VDD VSS DFFQX1
X_16743_ _16748_/A _16743_/B VDD VSS _19593_/D NOR2X1
X_13955_ _13955_/A _13955_/B _13955_/C _13955_/D VDD VSS _14232_/C OAI211X1
XFILLER_46_230 VSS VDD FILLER2
XFILLER_74_550 VSS VDD FILLER2
X_19462_ _19463_/CK _19462_/D _19462_/Q VDD VSS DFFQX1
X_12906_ _12906_/A _14287_/B _14287_/C VDD VSS _12996_/C NOR3X1
X_16674_ _19640_/Q _16674_/B _16794_/B VDD VSS _16683_/A MIN3X1
XFILLER_19_488 VSS VDD FILLER2
X_13886_ _13981_/A _13981_/B _13981_/C VDD VSS _13931_/B AOI21X1
XFILLER_74_594 VSS VDD FILLER2
XFILLER_62_734 VDD VSS DECAPHV8
XFILLER_46_296 VSS VDD FILLER2
X_18413_ _18423_/CK _18413_/D _18413_/Q _18422_/RB VDD VSS DFFRQX1
XFILLER_34_447 VDD VSS FILLER4
X_15625_ _19411_/Q _15625_/B _15625_/C VDD VSS _15639_/A MIN3X1
XFILLER_61_233 VDD VSS DECAPHV8
X_19393_ _19465_/CK _19393_/D _19393_/Q VDD VSS DFFQX1
X_12837_ _12837_/A _12837_/B _12837_/C _12837_/D VDD VSS _14506_/C AOI211X1
XFILLER_36_90 VDD VSS FILLER1
XTAP_TAPCELL_ROW_7_72 VDD VSS WELLTAP
XFILLER_61_266 VDD VSS FILLER4
XTAP_TAPCELL_ROW_16_155 VDD VSS WELLTAP
XTAP_TAPCELL_ROW_142_1291 VDD VSS WELLTAP
X_18344_ _18357_/CK _18344_/D _18344_/Q _20078_/RB VDD VSS DFFRQX1
XFILLER_61_277 VSS VDD FILLER2
X_15556_ _19381_/Q _15758_/B VDD VSS _15568_/B XNOR2X1
X_12768_ _19188_/Q _12768_/B _12827_/D VDD VSS _12940_/B XNOR3X1
XFILLER_148_806 VDD VSS FILLER1
XFILLER_30_631 VSS VDD FILLER2
X_14507_ _12832_/C _14507_/B VDD VSS _14508_/C NOR2BX1
X_18275_ _18275_/CK _18275_/D _18275_/Q _20080_/RB VDD VSS DFFRQX1
X_11719_ _14519_/B _14519_/C _19226_/Q VDD VSS _11745_/B AOI21X1
X_15487_ _19407_/Q _15788_/B VDD VSS _15525_/B NOR2X1
X_12699_ _13283_/A _17870_/B VDD VSS _18851_/D AND2X1
X_17226_ _19800_/Q _19768_/Q VDD VSS _17227_/C NAND2X1
Xclkbuf_leaf_10__001_ clkload32/A VDD VSS _18924_/CK BUFX12
X_14438_ _14456_/A _14438_/B VDD VSS _19155_/D NOR2X1
XTAP_TAPCELL_ROW_0_5 VDD VSS WELLTAP
XFILLER_143_500 VDD VSS FILLER1
X_17157_ _17160_/A _17160_/B _17164_/C VDD VSS _17158_/C OAI21X1
X_14369_ _14457_/A VDD VSS _14393_/A BUFX3
XFILLER_143_511 VSS VDD FILLER2
XFILLER_155_382 VDD VSS DECAPHV8
X_16108_ _19618_/Q _16108_/B _16770_/B VDD VSS _16133_/B MIN3X1
XFILLER_115_235 VSS VDD FILLER2
XFILLER_116_758 VDD VSS FILLER4
XFILLER_143_555 VSS VDD FILLER2
X_17088_ _19772_/Q _19740_/Q VDD VSS _17089_/B XOR2X1
XFILLER_115_257 VSS VDD FILLER2
Xclkbuf_leaf_25__001_ clkbuf_2_1__f__001_/Y VDD VSS _19094_/CK BUFX12
X_16039_ _16039_/A _16062_/C VDD VSS _16733_/B XNOR2X1
XFILLER_131_739 VDD VSS FILLER4
XFILLER_35_0 VSS VDD FILLER2
X_19729_ _19730_/CK _19729_/D _19729_/Q VDD VSS DFFQX1
XTAP_TAPCELL_ROW_95_865 VDD VSS WELLTAP
XFILLER_65_550 VDD VSS DECAPHV8
XFILLER_38_775 VSS VDD FILLER2
XFILLER_65_561 VSS VDD FILLER2
XFILLER_53_701 VSS VDD FILLER2
XTAP_TAPCELL_ROW_107_977 VDD VSS WELLTAP
XFILLER_52_222 VDD VSS FILLER1
X_09413_ _09506_/C VDD VSS _18225_/E INVX1
XFILLER_53_756 VSS VDD FILLER2
XFILLER_16_49 VSS VDD FILLER2
XFILLER_52_266 VSS VDD FILLER2
X_09344_ _18282_/Q _18510_/Q _09354_/B VDD VSS _09344_/Y MUXI2X1
XFILLER_40_439 VSS VDD FILLER2
XFILLER_139_817 VDD VSS FILLER4
X_09275_ _09273_/A _09265_/C _18276_/Q VDD VSS _18276_/D MUXI2X1
XTAP_TAPCELL_ROW_50_467 VDD VSS WELLTAP
XTAP_TAPCELL_ROW_156_1416 VDD VSS WELLTAP
XFILLER_165_113 VDD VSS FILLER4
XFILLER_138_338 VSS VDD FILLER2
XFILLER_165_124 VSS VDD FILLER2
XFILLER_154_809 VDD VSS FILLER4
XFILLER_165_157 VDD VSS FILLER1
XFILLER_119_574 VDD VSS FILLER1
XFILLER_134_500 VDD VSS FILLER4
XFILLER_146_371 VDD VSS DECAPHV8
XFILLER_107_736 VSS VDD FILLER2
XFILLER_107_747 VDD VSS DECAPHV8
XFILLER_106_235 VDD VSS FILLER4
XFILLER_134_555 VDD VSS DECAPHV8
XFILLER_122_706 VDD VSS FILLER4
X_10050_ _18603_/Q _10050_/B _10050_/C VDD VSS _10053_/C MIN3X1
XFILLER_88_642 VDD VSS FILLER4
XFILLER_114_290 VSS VDD FILLER2
XFILLER_88_664 VSS VDD FILLER2
XFILLER_57_12 VSS VDD FILLER2
XFILLER_0_579 VDD VSS FILLER4
XFILLER_75_314 VSS VDD FILLER2
XFILLER_57_56 VSS VDD FILLER2
XFILLER_102_496 VSS VDD FILLER2
XFILLER_87_196 VSS VDD FILLER2
XTAP_TAPCELL_ROW_58_534 VDD VSS WELLTAP
XFILLER_28_230 VSS VDD FILLER2
XFILLER_29_764 VSS VDD FILLER2
XFILLER_28_241 VSS VDD FILLER2
XFILLER_29_786 VDD VSS FILLER1
X_13740_ _18918_/Q _13818_/A _13918_/B VDD VSS _13807_/D XNOR3X1
XFILLER_90_328 VSS VDD FILLER2
XFILLER_113_73 VDD VSS FILLER1
X_10952_ _18569_/Q _10957_/B VDD VSS _10954_/D XNOR2X1
XFILLER_90_339 VSS VDD FILLER2
XFILLER_73_22 VDD VSS FILLER1
XFILLER_16_447 VDD VSS FILLER1
X_13671_ _13748_/A _13748_/C _13748_/B VDD VSS _14163_/C AOI21X1
XFILLER_44_778 VSS VDD FILLER2
X_10883_ _18567_/Q _10887_/B VDD VSS _10885_/C XOR2X1
XFILLER_43_255 VSS VDD FILLER2
XFILLER_44_789 VDD VSS FILLER1
X_15410_ _19405_/Q _15786_/B VDD VSS _15427_/B XNOR2X1
XFILLER_43_277 VSS VDD FILLER2
X_12622_ _19018_/Q _14284_/B VDD VSS _12717_/C _14284_/C AND3X2
X_16390_ _16390_/A _16390_/B _16390_/C VDD VSS _16406_/B AOI21X1
XFILLER_12_642 VDD VSS FILLER4
X_15341_ _15341_/A _15341_/B _15721_/B VDD VSS _15386_/B MIN3X1
X_12553_ _12553_/A _12553_/B _12553_/C _12553_/D VDD VSS _12656_/A OAOI211X1
XFILLER_12_664 VDD VSS DECAPHV8
X_18060_ _19279_/Q _18063_/B VDD VSS _18064_/B XNOR2X1
X_11504_ _18658_/Q _11508_/B VDD VSS _18685_/D AND2X1
X_15272_ _19513_/Q _15908_/B VDD VSS _15311_/D XOR2X1
X_12484_ _14440_/A _14440_/B VDD VSS _12504_/B NOR2X1
XFILLER_7_134 VSS VDD FILLER2
X_17011_ _19757_/Q _17011_/B VDD VSS _17019_/C XOR2X1
X_14223_ _14457_/A VDD VSS _14251_/A BUFX3
XFILLER_7_156 VSS VDD FILLER2
X_11435_ _11435_/A _11435_/B _18624_/Q _11436_/C VDD VSS _11438_/B AND4X2
XTAP_TAPCELL_ROW_133_1213 VDD VSS WELLTAP
XFILLER_7_189 VSS VDD FILLER2
XFILLER_22_92 VSS VDD FILLER2
XFILLER_138_70 VSS VDD FILLER2
XFILLER_137_393 VSS VDD FILLER2
XFILLER_138_92 VSS VDD FILLER2
X_14154_ _14154_/A _14154_/B VDD VSS _18910_/D NOR2X1
X_11366_ _18591_/Q _11375_/B VDD VSS _11368_/A XNOR2X1
X_13105_ _14414_/B _14414_/C _19134_/Q VDD VSS _13113_/B AOI21X1
X_10317_ _18658_/Q _18766_/Q VDD VSS _10405_/C AND2X1
XFILLER_140_514 VDD VSS DECAPHV8
XFILLER_152_385 VDD VSS FILLER1
X_18962_ _18997_/CK _18962_/D _18962_/Q VDD VSS DFFQX1
X_14085_ _14085_/A _14085_/B _14085_/C _14085_/D VDD VSS _14139_/B AOAI211X1
X_11297_ _11308_/A _11308_/B _11379_/A VDD VSS _11300_/A AOI21X1
XFILLER_79_631 VSS VDD FILLER2
XFILLER_3_384 VSS VDD FILLER2
X_17913_ _18173_/A _17913_/B VDD VSS _19950_/D NOR2X1
X_13036_ _13036_/A _13036_/B _13036_/C _13036_/D VDD VSS _13141_/A AOAI211X1
X_10248_ _18623_/Q _18624_/Q VDD VSS _11431_/B XOR2X1
X_18893_ _18973_/CK _18893_/D _18893_/Q VDD VSS DFFQX1
X_17844_ _18847_/Q _17847_/B VDD VSS _17846_/B XOR2X1
X_10179_ _10184_/A _10179_/B VDD VSS _11421_/C XNOR2X1
X_17775_ _17775_/A _17776_/C _17775_/C VDD VSS _19918_/D AOI21X1
X_14987_ _14989_/B _14987_/B VDD VSS _18084_/B XNOR2X1
XFILLER_94_678 VSS VDD FILLER2
XFILLER_81_306 VSS VDD FILLER2
XFILLER_47_561 VSS VDD FILLER2
X_16726_ _19929_/Q _16726_/B VDD VSS _19577_/D AND2X1
X_19514_ _19734_/CK _19514_/D _19514_/Q VDD VSS DFFQX1
X_13938_ _13938_/A _13938_/B _13938_/C _13938_/D VDD VSS _14135_/B OAOI211X1
XFILLER_93_199 VDD VSS FILLER4
XFILLER_35_756 VSS VDD FILLER2
X_19445_ _19478_/CK _19445_/D _19445_/Q VDD VSS DFFQX1
X_16657_ _16657_/A _16657_/B VDD VSS _16658_/B _16657_/C NAND3X1
X_13869_ _13869_/A _13869_/B _13869_/C _13869_/D VDD VSS _13872_/B AOAI211X1
XTAP_TAPCELL_ROW_104_947 VDD VSS WELLTAP
XFILLER_34_266 VSS VDD FILLER2
XFILLER_22_417 VDD VSS FILLER1
X_15608_ _19355_/Q _15730_/B VDD VSS _15609_/B XOR2X1
X_19376_ _19379_/CK _19376_/D _19376_/Q VDD VSS DFFQX1
X_16588_ _16589_/A _16589_/B VDD VSS _16616_/B AND2X1
XFILLER_50_759 VSS VDD FILLER2
X_18327_ _18327_/CK _18471_/D _18327_/Q _20067_/RB VDD VSS DFFRQX1
X_15539_ _15539_/A _15539_/B _15539_/C VDD VSS _15566_/A OAI21X1
XFILLER_30_450 VSS VDD FILLER2
XFILLER_147_124 VDD VSS FILLER1
X_18258_ _18258_/CK _18258_/D _18258_/Q _09281_/Y VDD VSS DFFRQX1
X_17209_ _19797_/Q _19765_/Q VDD VSS _17211_/B XOR2X1
XFILLER_147_179 VDD VSS FILLER4
XFILLER_162_105 VDD VSS FILLER1
X_18189_ _19304_/Q _18194_/A VDD VSS _18192_/A XOR2X1
XFILLER_118_29 VSS VDD FILLER2
X_20220_ _20220_/A VDD VSS _20220_/Y BUFX3
XFILLER_162_149 VDD VSS DECAPHV8
XFILLER_116_577 VSS VDD FILLER2
XFILLER_143_363 VSS VDD FILLER2
XTAP_TAPCELL_ROW_151_1368 VDD VSS WELLTAP
XFILLER_89_417 VDD VSS FILLER4
X_20151_ _20151_/A VDD VSS _20151_/Y BUFX3
XFILLER_131_525 VDD VSS FILLER1
X_20082_ _20082_/A VDD VSS output7/A BUFX3
X_09893_ _11178_/C _09893_/B VDD VSS _09894_/C NOR2X1
XFILLER_58_815 VSS VDD FILLER2
XFILLER_112_783 VDD VSS FILLER1
XFILLER_111_260 VDD VSS FILLER1
XFILLER_69_174 VSS VDD FILLER2
XFILLER_57_314 VSS VDD FILLER2
XFILLER_84_111 VDD VSS FILLER4
XFILLER_111_282 VDD VSS FILLER4
XFILLER_84_122 VSS VDD FILLER2
XFILLER_111_293 VDD VSS FILLER4
XTAP_TAPCELL_ROW_55_504 VDD VSS WELLTAP
XFILLER_27_48 VDD VSS DECAPHV16
XFILLER_72_328 VDD VSS FILLER4
XFILLER_26_723 VDD VSS FILLER4
XFILLER_150_49 VSS VDD FILLER2
XFILLER_81_840 VSS VDD FILLER2
XTAP_TAPCELL_ROW_162_1475 VDD VSS WELLTAP
XFILLER_26_756 VDD VSS FILLER4
XFILLER_53_553 VDD VSS FILLER4
XFILLER_26_789 VDD VSS FILLER1
XFILLER_53_586 VDD VSS FILLER1
XFILLER_41_726 VDD VSS FILLER4
XFILLER_25_277 VSS VDD FILLER2
XFILLER_53_597 VDD VSS FILLER4
XFILLER_25_288 VDD VSS FILLER1
XFILLER_43_36 VSS VDD FILLER2
XTAP_TAPCELL_ROW_63_581 VDD VSS WELLTAP
XFILLER_40_247 VDD VSS FILLER1
X_09327_ _18448_/D _09326_/Y _09302_/Y VDD VSS _18517_/D MUXI2X1
XFILLER_21_450 VSS VDD FILLER2
XFILLER_159_58 VSS VDD FILLER2
XTAP_TAPCELL_ROW_10_106 VDD VSS WELLTAP
X_09258_ _09362_/B _09258_/B VDD VSS _09301_/A OR2X2
XFILLER_153_105 VSS VDD FILLER2
XFILLER_5_616 VSS VDD FILLER2
X_09189_ _18471_/D VDD VSS _18455_/D INVX1
XFILLER_147_680 VSS VDD FILLER2
XFILLER_119_382 VSS VDD FILLER2
X_11220_ _11220_/A _11220_/B _11220_/C VDD VSS _11249_/C MIN3X1
XFILLER_5_649 VSS VDD FILLER2
XFILLER_146_190 VSS VDD FILLER2
XFILLER_107_566 VSS VDD FILLER2
XFILLER_134_352 VSS VDD FILLER2
XFILLER_122_514 VSS VDD FILLER2
X_11151_ _11079_/Y _11150_/Y _10947_/Y VDD VSS _11151_/Y MUXI2X1
XFILLER_68_11 VSS VDD FILLER2
XFILLER_122_547 VDD VSS FILLER4
XFILLER_150_856 VDD VSS FILLER1
X_10102_ _18586_/Q _10113_/C VDD VSS _10103_/B NAND2X1
XFILLER_68_44 VSS VDD FILLER2
XFILLER_110_709 VDD VSS FILLER4
X_11082_ _10809_/Y _11081_/Y _11120_/A VDD VSS _11090_/C MUX2X1
XFILLER_68_55 VDD VSS FILLER1
XFILLER_103_761 VSS VDD FILLER2
XFILLER_76_601 VSS VDD FILLER2
X_14910_ _14910_/A _15804_/B VDD VSS _14956_/A OR2X2
X_10033_ _10001_/Y _10031_/Y _10155_/A VDD VSS _10033_/Y MUXI2X1
XFILLER_88_472 VDD VSS FILLER1
XFILLER_68_99 VSS VDD FILLER2
XFILLER_130_580 VDD VSS FILLER4
X_15890_ _15895_/A _15890_/B VDD VSS _19497_/D NOR2X1
XFILLER_75_100 VDD VSS FILLER1
X_14841_ _14867_/A _14867_/B _14867_/C VDD VSS _14861_/C NOR3X1
XFILLER_84_21 VSS VDD FILLER2
XFILLER_64_818 VSS VDD FILLER2
XFILLER_75_155 VDD VSS DECAPHV8
XFILLER_29_550 VSS VDD FILLER2
XFILLER_63_306 VSS VDD FILLER2
XFILLER_29_561 VSS VDD FILLER2
X_17560_ _17562_/C _17560_/B _17560_/C VDD VSS _19872_/D AOI21X1
X_14772_ _19390_/Q _15768_/B _14772_/C VDD VSS _14811_/B MIN3X1
XFILLER_91_648 VSS VDD FILLER2
X_11984_ _11985_/A _11985_/B _11985_/D _11985_/C VDD VSS _12099_/B OAOI211X1
XFILLER_44_520 VSS VDD FILLER2
XFILLER_84_87 VDD VSS DECAPHV8
X_16511_ _16515_/B _16511_/B VDD VSS _16512_/B XOR2X1
X_13723_ _19114_/Q _13791_/B _13723_/C VDD VSS _13784_/B XOR3X1
X_17491_ _17496_/C _17496_/B VDD VSS _17493_/B NAND2BX1
X_10935_ _18782_/Q VDD VSS _11641_/A INVX1
XFILLER_17_70 VDD VSS FILLER1
XFILLER_90_169 VSS VDD FILLER2
X_19230_ _19995_/CK _19230_/D _19230_/Q VDD VSS DFFQX1
XTAP_TAPCELL_ROW_26_250 VDD VSS WELLTAP
XFILLER_44_586 VDD VSS DECAPHV8
X_16442_ _19727_/Q _16442_/B _16891_/B VDD VSS _16467_/B MIN3X1
X_13654_ _18945_/Q _13654_/B _13675_/D VDD VSS _13748_/B XNOR3X1
X_10866_ _10866_/A _10866_/B _10866_/C _10866_/D VDD VSS _10896_/C AOI31X1
XFILLER_31_236 VSS VDD FILLER2
X_19161_ _19191_/CK _19161_/D _19161_/Q VDD VSS DFFQX1
X_12605_ _18934_/Q _12617_/B _14182_/B VDD VSS _14150_/B XNOR3X1
X_16373_ _19597_/Q _16747_/B VDD VSS _16398_/C NAND2X1
X_13585_ _13585_/A wire154/Y _14225_/C VDD VSS _13586_/D NOR3X1
X_10797_ _10798_/A _10798_/B _10798_/D _10798_/C VDD VSS _10803_/B AOAI211X1
X_18112_ _18112_/A _18112_/B _18112_/C VDD VSS _18117_/A OA21X2
XFILLER_40_770 VDD VSS FILLER1
X_15324_ _19430_/Q _15814_/B VDD VSS _15347_/B NAND2BX1
XFILLER_8_421 VSS VDD FILLER2
X_19092_ _19094_/CK _19092_/D _19092_/Q VDD VSS DFFQX1
X_12536_ _18990_/Q VDD VSS _12693_/A INVX1
XTAP_TAPCELL_ROW_4_51 VDD VSS WELLTAP
XFILLER_8_443 VDD VSS FILLER4
XFILLER_117_308 VSS VDD FILLER2
XFILLER_117_319 VDD VSS FILLER1
X_18043_ _18044_/B _18045_/B _18043_/C _18049_/D VDD VSS _19979_/D OAI31X1
X_15255_ _19317_/Q _15688_/B VDD VSS _15256_/B XNOR2X1
XFILLER_8_476 VSS VDD FILLER2
X_12467_ _12467_/A _14438_/B VDD VSS _12480_/A OR2X2
X_14206_ _14218_/A _14206_/B VDD VSS _18955_/D NOR2X1
XFILLER_126_853 VDD VSS FILLER4
X_11418_ _18540_/D _11428_/B VDD VSS _18612_/D NOR2BX1
X_15186_ _19537_/Q _15186_/B VDD VSS _15270_/C NOR2BX1
XFILLER_141_801 VSS VDD FILLER2
X_12398_ _19238_/Q _12402_/A _12402_/B VDD VSS _12405_/A NOR3X1
XFILLER_153_661 VDD VSS FILLER4
XFILLER_4_660 VDD VSS FILLER4
X_14137_ _14136_/Y _14137_/B _14137_/C VDD VSS _18894_/D AND3BX1
XFILLER_99_737 VDD VSS FILLER1
X_11349_ _11364_/A _11349_/B _11356_/C VDD VSS _11358_/B AOI21X1
XFILLER_153_694 VSS VDD FILLER2
X_19994_ _19996_/CK _19994_/D _19994_/Q VDD VSS DFFQX1
XFILLER_141_856 VDD VSS FILLER1
Xclkbuf_0__09170_ _18219_/ECK VDD VSS clkbuf_0__09170_/Y BUFX12
X_18945_ _18999_/CK _18945_/D _18945_/Q VDD VSS DFFQX1
X_14068_ _14068_/A _14068_/B _14068_/C VDD VSS _14203_/B NOR3X1
XFILLER_86_409 VSS VDD FILLER2
XFILLER_100_208 VDD VSS FILLER4
X_13019_ _13102_/A _13102_/B _13102_/D _13102_/C VDD VSS _14352_/C AOI211X1
X_18876_ _18905_/CK _18876_/D _18876_/Q VDD VSS DFFQX1
XFILLER_94_431 VDD VSS DECAPHV16
XFILLER_12_2 VDD VSS FILLER1
XFILLER_55_807 VDD VSS FILLER4
X_17827_ _19930_/Q _17827_/B VDD VSS _19930_/D NOR2X1
XFILLER_66_155 VSS VDD FILLER2
XFILLER_55_829 VSS VDD FILLER2
XFILLER_54_306 VDD VSS FILLER1
XFILLER_54_328 VSS VDD FILLER2
X_17758_ _17758_/A _17758_/B _17758_/C VDD VSS _17766_/A OA21X2
XFILLER_63_840 VSS VDD FILLER2
X_16709_ _19914_/Q _16726_/B VDD VSS _19562_/D AND2X1
X_17689_ _19900_/Q _19868_/Q VDD VSS _17690_/B XOR2X1
X_19428_ _19463_/CK _19428_/D _19428_/Q VDD VSS DFFQX1
X_19359_ _19412_/CK _19359_/D _19359_/Q VDD VSS DFFQX1
XTAP_TAPCELL_ROW_60_551 VDD VSS WELLTAP
XFILLER_129_17 VDD VSS DECAPHV8
XFILLER_148_466 VSS VDD FILLER2
XTAP_TAPCELL_ROW_32_297 VDD VSS WELLTAP
XFILLER_148_488 VSS VDD FILLER2
XFILLER_135_138 VSS VDD FILLER2
XFILLER_116_363 VSS VDD FILLER2
X_20203_ _20203_/A VDD VSS _20203_/Y BUFX3
XFILLER_104_514 VSS VDD FILLER2
Xmax_cap173 _10304_/A VDD VSS _10383_/A BUFX3
XFILLER_144_694 VSS VDD FILLER2
XFILLER_145_38 VSS VDD FILLER2
Xmax_cap184 _18523_/Q VDD VSS _18470_/D BUFX12
XFILLER_104_547 VSS VDD FILLER2
XFILLER_132_856 VDD VSS FILLER1
X_20134_ _20134_/A VDD VSS _20134_/Y BUFX3
X_09945_ _10032_/A _09945_/B _10166_/D VDD VSS _09953_/C OA21X2
XFILLER_77_409 VDD VSS FILLER4
X_20065_ clkload6/A _20065_/D _20065_/Q _20065_/RB VDD VSS DFFRQX1
X_09876_ _09944_/A _09876_/B _09876_/C VDD VSS _09895_/B AOI21X1
XFILLER_58_645 VSS VDD FILLER2
XFILLER_97_291 VDD VSS FILLER4
XFILLER_85_442 VDD VSS FILLER4
XFILLER_161_37 VSS VDD FILLER2
XFILLER_58_667 VDD VSS FILLER1
XFILLER_73_604 VDD VSS FILLER4
XFILLER_57_155 VSS VDD FILLER2
XFILLER_73_626 VSS VDD FILLER2
XFILLER_72_114 VSS VDD FILLER2
XFILLER_73_648 VSS VDD FILLER2
XFILLER_53_361 VSS VDD FILLER2
XFILLER_41_501 VSS VDD FILLER2
X_10720_ _10721_/A _10721_/C _10721_/B VDD VSS _10757_/C AOI21X1
XFILLER_110_30 VDD VSS FILLER1
XFILLER_80_180 VSS VDD FILLER2
XFILLER_13_236 VDD VSS FILLER1
XFILLER_80_191 VDD VSS FILLER1
XFILLER_41_545 VDD VSS FILLER4
XTAP_TAPCELL_ROW_23_220 VDD VSS WELLTAP
XFILLER_41_556 VSS VDD FILLER2
XFILLER_41_567 VDD VSS FILLER1
XFILLER_13_269 VDD VSS FILLER1
X_10651_ _18628_/Q _18721_/Q VDD VSS _10652_/C NAND2X1
XFILLER_9_218 VSS VDD FILLER2
XFILLER_139_422 VSS VDD FILLER2
X_13370_ _19026_/Q _13370_/B _13406_/D VDD VSS _13509_/B XNOR3X1
X_10582_ _11116_/A _10582_/B _10582_/C _11255_/A VDD VSS _10737_/C OA211X2
XFILLER_127_628 VSS VDD FILLER2
X_12321_ _14532_/A _14532_/B _19238_/Q VDD VSS _12391_/C AOI21BX1
XFILLER_126_138 VDD VSS FILLER1
X_15040_ _19396_/Q _15775_/B VDD VSS _15041_/C NOR2BX1
X_12252_ _12300_/A _12300_/B _12300_/C VDD VSS _12451_/B OAI21X1
XFILLER_135_650 VDD VSS FILLER1
XFILLER_123_801 VSS VDD FILLER2
XFILLER_5_468 VSS VDD FILLER2
X_11203_ _18655_/Q _18817_/Q VDD VSS _11204_/C NAND2X1
XFILLER_122_300 VSS VDD FILLER2
XFILLER_134_160 VSS VDD FILLER2
X_12183_ _19125_/Q _12183_/B _12183_/C VDD VSS _12208_/B XNOR3X1
XFILLER_122_311 VSS VDD FILLER2
XFILLER_123_834 VSS VDD FILLER2
XFILLER_162_491 VDD VSS FILLER4
X_11134_ _11196_/A _18735_/Q _11134_/C _11134_/D VDD VSS _11149_/A AOI22X1
X_16991_ _19752_/Q _17078_/B _16991_/C VDD VSS _16992_/B MIN3X1
XFILLER_68_409 VSS VDD FILLER2
XFILLER_135_82 VSS VDD FILLER2
X_15942_ _15963_/C _15942_/B VDD VSS _16730_/B XNOR2X1
X_18730_ _19939_/CK _18730_/D _18730_/Q VDD VSS DFFQX1
X_11065_ _11102_/C _11065_/B VDD VSS _11078_/C NOR2X1
XFILLER_88_280 VDD VSS DECAPHV8
XFILLER_48_122 VSS VDD FILLER2
X_10016_ _09987_/Y _10015_/Y _10032_/A VDD VSS _10018_/B MUXI2X1
X_18661_ _18795_/CK _18661_/D _18661_/Q VDD VSS DFFQX1
XFILLER_37_807 VDD VSS FILLER4
X_15873_ _15879_/A _15873_/B VDD VSS _19481_/D AND2X1
XFILLER_64_626 VSS VDD FILLER2
X_14824_ _15865_/B _14824_/B _14824_/C VDD VSS _14918_/A NOR3X1
X_17612_ _19883_/Q _19851_/Q VDD VSS _17618_/B NAND2X1
XTAP_TAPCELL_ROW_128_1167 VDD VSS WELLTAP
XFILLER_36_328 VDD VSS FILLER4
X_18592_ _18595_/CK _18592_/D _18592_/Q VDD VSS DFFQX1
XFILLER_45_840 VSS VDD FILLER2
X_17543_ _19869_/Q _19837_/Q VDD VSS _17544_/B XOR2X1
XFILLER_17_553 VDD VSS FILLER4
X_14755_ _14778_/A _14840_/A _14773_/C VDD VSS _15800_/B XNOR3X1
X_11967_ _19119_/Q _11967_/B _11967_/C VDD VSS _11968_/C MIN3X1
XTAP_TAPCELL_ROW_74_676 VDD VSS WELLTAP
XFILLER_91_489 VDD VSS DECAPHV32
XFILLER_60_810 VSS VDD FILLER2
XFILLER_44_361 VSS VDD FILLER2
XFILLER_17_586 VSS VDD FILLER2
X_13706_ _13716_/A _13716_/B _13716_/C VDD VSS _13779_/B OA21X2
X_17474_ _19854_/Q _19822_/Q VDD VSS _17477_/A XNOR2X1
X_10918_ _10954_/B _10954_/C VDD VSS _10919_/B NOR2BX1
XFILLER_72_692 VDD VSS FILLER4
X_14686_ _14733_/A _14733_/B _14702_/C VDD VSS _15798_/B XNOR3X1
XFILLER_44_394 VDD VSS FILLER1
X_11898_ _11966_/A _11966_/B VDD VSS _14398_/B XNOR2X1
XFILLER_60_854 VSS VDD FILLER2
X_16425_ _19599_/Q _16750_/B VDD VSS _16426_/B XOR2X1
X_19213_ _19217_/CK _19213_/D _19213_/Q VDD VSS DFFQX1
XFILLER_32_567 VDD VSS FILLER1
XFILLER_20_707 VSS VDD FILLER2
X_13637_ _13637_/A _13637_/B _13637_/C _13637_/D VDD VSS _14453_/B AOAI211X1
X_10849_ _18565_/Q _10849_/B VDD VSS _10851_/A NAND2X1
XFILLER_20_729 VDD VSS FILLER1
XFILLER_158_742 VDD VSS FILLER4
X_19144_ _19196_/CK _19144_/D _19144_/Q VDD VSS DFFQX1
X_16356_ _16512_/A _16356_/B VDD VSS _19532_/D NOR2X1
X_13568_ _18972_/Q _13568_/B _14226_/C VDD VSS _13675_/B XNOR3X1
XTAP_TAPCELL_ROW_139_1263 VDD VSS WELLTAP
X_15307_ _15307_/A _15307_/B VDD VSS _15878_/B _15307_/C _15307_/D NAND4X2
XFILLER_8_251 VDD VSS FILLER4
XFILLER_145_414 VSS VDD FILLER2
X_19075_ _19126_/CK _19075_/D _19075_/Q VDD VSS DFFQX1
X_12519_ _19044_/Q _12519_/B _12519_/C VDD VSS _12540_/C OR3BX1
X_16287_ _16287_/A _16313_/C VDD VSS _16744_/B XNOR2X1
X_13499_ _18915_/Q _14161_/B VDD VSS _13662_/A AND2X1
XFILLER_145_447 VSS VDD FILLER2
XFILLER_117_149 VSS VDD FILLER2
XFILLER_145_458 VDD VSS FILLER1
X_18026_ _18534_/Q _18026_/B VDD VSS _18027_/C NOR2X1
X_15238_ _19512_/Q _15906_/B VDD VSS _15274_/B NAND2BX1
XFILLER_114_801 VDD VSS FILLER4
XFILLER_160_406 VSS VDD FILLER2
XFILLER_126_661 VSS VDD FILLER2
XFILLER_113_311 VSS VDD FILLER2
X_15169_ _15171_/B _15169_/B VDD VSS _18102_/B XNOR2X1
XFILLER_141_631 VDD VSS DECAPHV8
XFILLER_99_556 VSS VDD FILLER2
Xfanout208 _18450_/RB VDD VSS _18422_/RB BUFX3
Xfanout219 _18405_/RB VDD VSS _18373_/RB BUFX3
XFILLER_99_578 VSS VDD FILLER2
X_19977_ _19986_/CK _19977_/D _19977_/Q VDD VSS DFFQX1
XFILLER_101_517 VSS VDD FILLER2
X_09730_ _09753_/A _09730_/B _09730_/C VDD VSS _09731_/D AOI21X1
X_18928_ _18961_/CK _18928_/D _18928_/Q VDD VSS DFFQX1
XFILLER_95_740 VDD VSS FILLER4
X_09661_ _20202_/A _09811_/C _09770_/C _20087_/A VDD VSS _09664_/B AOI22X1
XFILLER_95_762 VSS VDD FILLER2
XFILLER_67_453 VDD VSS FILLER4
X_18859_ _18915_/CK _18859_/D _18859_/Q VDD VSS DFFQX1
XFILLER_67_475 VSS VDD FILLER2
XFILLER_95_795 VSS VDD FILLER2
XFILLER_94_261 VSS VDD FILLER2
XFILLER_54_103 VDD VSS FILLER1
X_09592_ _18240_/Q _09770_/B _09797_/C _20198_/A _09592_/E VDD VSS _09593_/D AOI221X1
XFILLER_82_445 VDD VSS FILLER1
XTAP_TAPCELL_ROW_37_345 VDD VSS WELLTAP
XFILLER_70_607 VDD VSS FILLER4
XFILLER_54_169 VSS VDD FILLER2
XFILLER_70_629 VSS VDD FILLER2
XFILLER_35_361 VSS VDD FILLER2
XFILLER_23_512 VDD VSS FILLER1
XFILLER_24_38 VSS VDD FILLER2
XFILLER_24_49 VSS VDD FILLER2
XFILLER_149_720 VDD VSS FILLER1
XFILLER_149_742 VSS VDD FILLER2
XFILLER_148_230 VSS VDD FILLER2
XFILLER_50_397 VSS VDD FILLER2
XFILLER_136_436 VDD VSS FILLER4
XFILLER_163_222 VDD VSS FILLER1
XFILLER_136_458 VSS VDD FILLER2
XFILLER_164_767 VDD VSS FILLER1
XFILLER_151_406 VDD VSS FILLER4
XFILLER_163_277 VSS VDD FILLER2
XTAP_TAPCELL_ROW_116_1060 VDD VSS WELLTAP
XFILLER_2_416 VSS VDD FILLER2
Xhold262 ss VDD VSS hold262/Y BUFX3
XFILLER_49_24 VSS VDD FILLER2
XFILLER_120_804 VDD VSS FILLER1
XFILLER_77_206 VDD VSS FILLER1
XFILLER_49_57 VSS VDD FILLER2
XFILLER_104_377 VDD VSS FILLER1
X_20117_ _20117_/A VDD VSS _20117_/Y BUFX3
X_09928_ _09928_/A _09928_/B _09928_/C VDD VSS _09929_/C OAI21X1
XFILLER_105_30 VSS VDD FILLER2
X_20048_ _20048_/CK _20048_/D _20048_/Q _09280_/Y VDD VSS DFFRQX1
XFILLER_58_453 VSS VDD FILLER2
X_09859_ _10966_/A VDD VSS _11229_/A BUFX3
XFILLER_19_818 VSS VDD FILLER2
XFILLER_105_74 VDD VSS FILLER4
XFILLER_85_250 VDD VSS FILLER4
XFILLER_58_475 VSS VDD FILLER2
XFILLER_46_626 VSS VDD FILLER2
XFILLER_73_412 VSS VDD FILLER2
XFILLER_105_96 VDD VSS DECAPHV8
XFILLER_45_114 VSS VDD FILLER2
XFILLER_18_328 VSS VDD FILLER2
X_12870_ _12906_/A _13005_/B _12997_/C VDD VSS _12996_/B XNOR3X1
XFILLER_85_294 VSS VDD FILLER2
XFILLER_46_648 VDD VSS FILLER1
XFILLER_46_659 VDD VSS DECAPHV8
XFILLER_27_840 VDD VSS FILLER4
XFILLER_27_851 VSS VDD FILLER2
X_11821_ _19118_/Q _11821_/B _11821_/C VDD VSS _11899_/B MIN3X1
XFILLER_45_169 VSS VDD FILLER2
XFILLER_14_523 VSS VDD FILLER2
X_14540_ _14540_/A _14540_/B _17827_/B VDD VSS _19246_/D AOI21X1
XFILLER_81_11 VSS VDD FILLER2
XFILLER_54_692 VDD VSS FILLER4
X_11752_ _11776_/A _11835_/B _11835_/C VDD VSS _11764_/C OR3BX1
XFILLER_41_331 VDD VSS FILLER1
X_10703_ _10703_/A _10709_/C VDD VSS _10707_/B XNOR2X1
X_14471_ _14766_/A _14471_/B VDD VSS _19184_/D AND2X1
X_11683_ _18928_/Q VDD VSS _12129_/A INVX1
XFILLER_41_375 VDD VSS FILLER4
X_16210_ _19559_/Q _19911_/Q VDD VSS _16211_/B XNOR2X1
X_13422_ _14323_/A _13422_/B _13422_/C _13422_/D VDD VSS _13601_/B AOI31X1
X_17190_ _19793_/Q _19761_/Q VDD VSS _17197_/C NOR2X1
X_10634_ _10681_/B _10634_/B VDD VSS _10653_/B XNOR2X1
XFILLER_155_701 VDD VSS FILLER4
XFILLER_6_700 VDD VSS DECAPHV8
X_16141_ _19620_/Q _16773_/B VDD VSS _16142_/B XOR2X1
X_13353_ _19138_/Q _13546_/A _13617_/B VDD VSS _13616_/D XNOR3X1
X_10565_ _18637_/Q _18799_/Q VDD VSS _10570_/B OR2X2
XFILLER_10_784 VDD VSS FILLER4
X_12304_ _12382_/A _12382_/B _12382_/C VDD VSS _14437_/B AOI21X1
X_16072_ _19681_/Q _16841_/B VDD VSS _16080_/B NAND2X1
X_13284_ _14522_/A VDD VSS _14118_/A BUFX3
XFILLER_108_661 VSS VDD FILLER2
XFILLER_142_406 VSS VDD FILLER2
X_10496_ _10496_/A _10496_/B _10496_/C _10496_/D VDD VSS _10582_/B AND4X2
XFILLER_142_417 VDD VSS FILLER1
X_15023_ _15044_/A _15092_/A _15092_/B VDD VSS _15045_/D XNOR3X1
X_19900_ clkload2/A _19900_/D _19900_/Q VDD VSS DFFQX1
X_12235_ _12236_/A _12236_/B _12236_/D _12236_/C VDD VSS _14531_/B AO211X2
XFILLER_107_182 VDD VSS FILLER4
XFILLER_146_70 VSS VDD FILLER2
X_19831_ clkload5/A _19831_/D _19831_/Q VDD VSS DFFQX1
X_12166_ _20000_/Q _19264_/Q VDD VSS _12236_/C NOR2X1
XFILLER_96_526 VSS VDD FILLER2
X_11117_ _11048_/Y _11116_/Y _10947_/Y VDD VSS _11118_/B MUXI2X1
XTAP_TAPCELL_ROW_79_724 VDD VSS WELLTAP
X_19762_ _19934_/CK _19762_/D _19762_/Q VDD VSS DFFQX1
XFILLER_1_482 VSS VDD FILLER2
X_16974_ _19750_/Q _16978_/B VDD VSS _16975_/B XOR2X1
X_12097_ _12160_/A _14465_/B VDD VSS _12112_/B NOR2X1
X_18713_ _18767_/CK _18713_/D _18713_/Q VDD VSS DFFQX1
X_15925_ _19548_/Q _19900_/Q VDD VSS _15939_/B XNOR2X1
X_11048_ _11014_/Y _11047_/Y _10984_/A VDD VSS _11048_/Y MUX2X1
X_19693_ _19695_/CK _19693_/D _19693_/Q VDD VSS DFFQX1
XFILLER_49_475 VSS VDD FILLER2
XFILLER_76_272 VDD VSS FILLER4
XFILLER_36_103 VSS VDD FILLER2
XFILLER_36_114 VSS VDD FILLER2
X_15856_ _15867_/A _15856_/B VDD VSS _19467_/D NOR2X1
X_18644_ _19949_/CK _18644_/D _18644_/Q VDD VSS DFFQX1
XFILLER_37_648 VSS VDD FILLER2
XFILLER_91_242 VSS VDD FILLER2
X_14807_ _14809_/A _14807_/B VDD VSS _18063_/B XNOR2X1
XFILLER_52_607 VDD VSS FILLER4
XFILLER_24_309 VDD VSS FILLER1
X_15787_ _15793_/A _15787_/B VDD VSS _19406_/D AND2X1
X_18575_ _18589_/CK _18575_/D _18575_/Q VDD VSS DFFQX1
Xclkbuf_leaf_7__000_ clkload72/A VDD VSS _19737_/CK BUFX12
X_12999_ _13007_/A _13095_/A _13270_/B VDD VSS _13008_/D XNOR3X1
XFILLER_17_361 VSS VDD FILLER2
XTAP_TAPCELL_ROW_34_315 VDD VSS WELLTAP
XFILLER_91_297 VDD VSS FILLER1
XFILLER_51_128 VSS VDD FILLER2
X_14738_ _14781_/A _14781_/B VDD VSS _14751_/B NAND2X1
X_17526_ _19864_/Q _19832_/Q VDD VSS _17527_/C NAND2X1
XFILLER_44_180 VSS VDD FILLER2
X_17457_ _17460_/A _17460_/B _17509_/C VDD VSS _17458_/C OAI21X1
X_14669_ _14669_/A _14669_/B _15797_/B VDD VSS _14698_/B MIN3X1
XFILLER_60_695 VSS VDD FILLER2
X_16408_ _19694_/Q _16855_/B VDD VSS _16416_/B XNOR2X1
X_17388_ _19836_/Q _19804_/Q VDD VSS _17389_/B XOR2X1
XTAP_TAPCELL_ROW_42_392 VDD VSS WELLTAP
X_16339_ _19915_/Q VDD VSS _16710_/A INVX1
X_19127_ _19185_/CK _19127_/D _19127_/Q VDD VSS DFFQX1
XFILLER_9_582 VSS VDD FILLER2
XFILLER_158_594 VSS VDD FILLER2
XFILLER_118_447 VSS VDD FILLER2
XFILLER_118_458 VSS VDD FILLER2
XFILLER_145_244 VSS VDD FILLER2
X_19058_ _19086_/CK _19058_/D _19058_/Q VDD VSS DFFQX1
XFILLER_145_288 VDD VSS FILLER1
X_18009_ _18549_/Q _18057_/C _18058_/B VDD VSS _18054_/A OAI21X1
XFILLER_145_299 VDD VSS FILLER4
XFILLER_99_342 VDD VSS FILLER4
XFILLER_113_130 VDD VSS FILLER1
XFILLER_114_664 VDD VSS FILLER1
XFILLER_99_364 VSS VDD FILLER2
XFILLER_141_461 VDD VSS FILLER4
XFILLER_99_375 VSS VDD FILLER2
XFILLER_141_472 VSS VDD FILLER2
XFILLER_59_239 VSS VDD FILLER2
XFILLER_101_336 VSS VDD FILLER2
X_09713_ _20141_/A _20189_/A _09753_/A VDD VSS _09716_/C MUX2X1
XFILLER_68_762 VDD VSS DECAPHV8
XFILLER_67_250 VDD VSS FILLER4
XFILLER_55_412 VDD VSS FILLER4
X_09644_ _18444_/Q _09751_/B _09772_/B _18348_/Q _09644_/E VDD VSS _09647_/C OAI221X1
XFILLER_55_423 VSS VDD FILLER2
XFILLER_28_648 VDD VSS DECAPHV8
XFILLER_82_242 VDD VSS DECAPHV8
X_09575_ _18344_/Q _09772_/B _09575_/C VDD VSS _09581_/B OAI21X1
XFILLER_36_681 VSS VDD FILLER2
XFILLER_11_504 VSS VDD FILLER2
XFILLER_50_150 VDD VSS FILLER4
XFILLER_23_375 VSS VDD FILLER2
XFILLER_50_161 VDD VSS FILLER4
XTAP_TAPCELL_ROW_159_1447 VDD VSS WELLTAP
XFILLER_51_14 VSS VDD FILLER2
XFILLER_149_561 VDD VSS DECAPHV8
XFILLER_136_200 VSS VDD FILLER2
XFILLER_136_211 VSS VDD FILLER2
XFILLER_164_520 VDD VSS FILLER1
XFILLER_109_436 VSS VDD FILLER2
XFILLER_109_447 VDD VSS FILLER1
XFILLER_136_255 VSS VDD FILLER2
X_10350_ _10512_/A _10500_/B _10500_/C _10550_/A VDD VSS _10660_/B OAOI211X1
XFILLER_137_789 VDD VSS FILLER4
XFILLER_164_575 VSS VDD FILLER2
XFILLER_124_428 VSS VDD FILLER2
XFILLER_124_439 VSS VDD FILLER2
X_10281_ _10329_/A _10329_/B VDD VSS _10281_/Y NOR2X1
XFILLER_117_491 VDD VSS FILLER4
XFILLER_151_236 VSS VDD FILLER2
XFILLER_3_747 VDD VSS FILLER4
XFILLER_105_642 VDD VSS DECAPHV8
XFILLER_2_235 VSS VDD FILLER2
X_12020_ _19066_/Q _12020_/B _12075_/C VDD VSS _12284_/B MIN3X1
XFILLER_78_504 VDD VSS FILLER1
XFILLER_132_461 VSS VDD FILLER2
XFILLER_104_163 VSS VDD FILLER2
XFILLER_59_740 VDD VSS FILLER4
XFILLER_76_44 VSS VDD FILLER2
X_13971_ _14036_/A _14045_/B VDD VSS _14201_/B XNOR2X1
XFILLER_93_529 VDD VSS FILLER1
XFILLER_58_261 VDD VSS FILLER4
X_15710_ _15710_/A _15710_/B VDD VSS _19337_/D NOR2X1
X_12922_ _19078_/Q VDD VSS _13020_/A INVX1
X_16690_ _16690_/A _16690_/B _16690_/C VDD VSS _19545_/D AOI21X1
XFILLER_19_648 VSS VDD FILLER2
XFILLER_74_754 VDD VSS DECAPHV8
X_15641_ _15641_/A _15641_/B _15641_/C VDD VSS _15653_/A OAI21X1
XTAP_TAPCELL_ROW_125_1137 VDD VSS WELLTAP
XFILLER_46_467 VSS VDD FILLER2
XFILLER_34_607 VDD VSS DECAPHV8
X_12853_ _19245_/Q _13049_/A _13054_/B VDD VSS _12951_/D XNOR3X1
XFILLER_74_787 VSS VDD FILLER2
XTAP_TAPCELL_ROW_84_771 VDD VSS WELLTAP
XFILLER_46_489 VSS VDD FILLER2
X_18360_ _18375_/CK _18525_/Q _20197_/A _18464_/RB VDD VSS DFFRQX1
X_11804_ _11804_/A _11804_/B _11804_/C _11804_/D VDD VSS wire166/A OAOI211X1
XFILLER_73_297 VSS VDD FILLER2
X_15572_ _15599_/A _15599_/B VDD VSS _15578_/A NAND2X1
X_12784_ _18936_/Q _12877_/B _14184_/B VDD VSS _14152_/B XNOR3X1
X_17311_ _19819_/Q _19787_/Q VDD VSS _17318_/B NAND2X1
XFILLER_14_353 VDD VSS FILLER4
X_14523_ _14522_/Y _14523_/B _14523_/C VDD VSS _19229_/D AND3BX1
XFILLER_30_802 VDD VSS FILLER4
X_18291_ _18295_/CK _18291_/D _18291_/Q VDD VSS DFFQX1
X_11735_ _19225_/Q VDD VSS _11737_/A INVX1
XFILLER_42_684 VSS VDD FILLER2
XFILLER_42_695 VSS VDD FILLER2
X_17242_ _17240_/B _17242_/B VDD VSS _17243_/C NOR2BX1
X_14454_ _14467_/A _14454_/B VDD VSS _19169_/D AND2X1
X_11666_ _18805_/Q _11669_/B VDD VSS _18832_/D AND2X1
X_13405_ _13406_/A _13406_/B _13406_/D _13406_/C VDD VSS _14293_/C AOI211X1
X_17173_ _17176_/C _17174_/B _17229_/C VDD VSS _17174_/C OAI21X1
X_10617_ _10638_/A _10638_/B VDD VSS _10618_/B _10617_/C NAND3X1
XFILLER_127_211 VDD VSS FILLER1
X_14385_ _14410_/A _14385_/B _14385_/C VDD VSS _19107_/D NOR3X1
X_11597_ _18742_/Q _11600_/B VDD VSS _18769_/D AND2X1
XFILLER_155_531 VDD VSS FILLER1
XTAP_TAPCELL_ROW_136_1233 VDD VSS WELLTAP
XFILLER_128_767 VDD VSS FILLER1
X_16124_ _16126_/B _16124_/B VDD VSS _16125_/B XNOR2X1
XFILLER_6_530 VDD VSS DECAPHV8
X_13336_ _19193_/Q _14480_/B VDD VSS _13451_/A AND2X1
XFILLER_41_80 VSS VDD FILLER2
XFILLER_127_255 VSS VDD FILLER2
X_10548_ _10548_/A _10548_/B _10548_/C VDD VSS _10596_/A NOR3X1
XFILLER_115_406 VDD VSS FILLER1
XFILLER_143_715 VDD VSS FILLER1
XFILLER_127_277 VSS VDD FILLER2
XFILLER_155_586 VSS VDD FILLER2
X_16055_ _16049_/A _16055_/B _16055_/C VDD VSS _16074_/A AOI2B1X1
XFILLER_142_225 VDD VSS FILLER4
X_13267_ _19109_/Q _13432_/A _13322_/C VDD VSS _13364_/D XNOR3X1
XFILLER_108_491 VDD VSS FILLER1
X_10479_ _10514_/D _10514_/C VDD VSS _10481_/D NOR2BX1
X_15006_ _15054_/A _15054_/B VDD VSS _15022_/B NOR2X1
X_12218_ _12329_/A _12218_/B VDD VSS _14467_/B XNOR2X1
XFILLER_123_461 VDD VSS FILLER4
X_13198_ _13198_/A _13198_/B _13198_/C _13198_/D VDD VSS _13203_/A OAOI211X1
XFILLER_69_515 VDD VSS FILLER4
XFILLER_37_4 VDD VSS FILLER1
X_19814_ _19825_/CK _19814_/D _19814_/Q VDD VSS DFFQX1
XFILLER_96_323 VSS VDD FILLER2
XFILLER_69_537 VSS VDD FILLER2
XFILLER_110_111 VSS VDD FILLER2
X_12149_ _12149_/A _12149_/B _12149_/C _12149_/D VDD VSS wire159/A OAOI211X1
XFILLER_96_345 VSS VDD FILLER2
XFILLER_84_507 VDD VSS FILLER4
X_19745_ _19785_/CK _19745_/D _19745_/Q VDD VSS DFFQX1
XFILLER_110_166 VSS VDD FILLER2
X_16957_ _19747_/Q _16978_/B VDD VSS _16962_/B XOR2X1
XFILLER_49_250 VSS VDD FILLER2
XTAP_TAPCELL_ROW_147_1340 VDD VSS WELLTAP
XFILLER_77_570 VSS VDD FILLER2
XFILLER_77_581 VDD VSS FILLER1
XFILLER_65_732 VSS VDD FILLER2
X_15908_ _16100_/A _15908_/B VDD VSS _19513_/D NOR2X1
X_19676_ _19724_/CK _19676_/D _19676_/Q VDD VSS DFFQX1
X_16888_ _16891_/A _16888_/B VDD VSS _19724_/D NOR2X1
XFILLER_64_231 VDD VSS FILLER1
XFILLER_64_242 VDD VSS FILLER4
XTAP_TAPCELL_ROW_47_440 VDD VSS WELLTAP
X_18627_ _18628_/CK _18627_/D _18627_/Q VDD VSS DFFQX1
X_15839_ _17172_/A VDD VSS _17986_/C BUFX3
XFILLER_92_584 VDD VSS FILLER4
XFILLER_64_286 VDD VSS FILLER1
XFILLER_18_681 VDD VSS FILLER4
X_09360_ _20065_/RB _09362_/B VDD VSS _09360_/Y NOR2BX1
XTAP_TAPCELL_ROW_19_186 VDD VSS WELLTAP
X_18558_ _18583_/CK _18558_/D _18558_/Q VDD VSS DFFQX1
XFILLER_17_180 VDD VSS FILLER4
X_17509_ _17512_/C _17510_/B _17509_/C VDD VSS _17510_/C OAI21X1
X_09291_ _09516_/B VDD VSS _18201_/A BUFX3
X_18489_ _18495_/CK _18510_/Q _20102_/A _18491_/RB VDD VSS DFFRQX1
XANTENNA_13 _14522_/A VDD VSS ANTENNA2
XFILLER_166_807 VSS VDD FILLER2
XFILLER_138_509 VSS VDD FILLER2
XFILLER_20_323 VSS VDD FILLER2
XFILLER_165_317 VSS VDD FILLER2
XFILLER_119_734 VSS VDD FILLER2
XFILLER_146_531 VDD VSS DECAPHV8
XFILLER_21_17 VSS VDD FILLER2
XFILLER_158_391 VDD VSS FILLER4
XFILLER_119_756 VDD VSS FILLER4
XFILLER_137_17 VSS VDD FILLER2
XFILLER_106_417 VDD VSS FILLER1
XFILLER_161_512 VDD VSS FILLER1
XFILLER_118_288 VSS VDD FILLER2
XFILLER_134_748 VDD VSS FILLER1
XTAP_TAPCELL_ROW_154_1399 VDD VSS WELLTAP
XFILLER_133_236 VSS VDD FILLER2
Xoutput120 _20189_/Y VDD VSS o_tst_ctrl[8] BUFX3
Xoutput131 _20215_/Y VDD VSS o_uwb_tx_cfg[18] BUFX3
Xoutput142 _20225_/Y VDD VSS o_uwb_tx_cfg[28] BUFX3
XTAP_TAPCELL_ROW_113_1030 VDD VSS WELLTAP
XFILLER_87_301 VDD VSS FILLER1
XFILLER_99_183 VSS VDD FILLER2
XFILLER_153_38 VDD VSS FILLER4
XFILLER_101_166 VSS VDD FILLER2
XTAP_TAPCELL_ROW_98_896 VDD VSS WELLTAP
XFILLER_56_732 VSS VDD FILLER2
XFILLER_83_540 VDD VSS FILLER1
XTAP_TAPCELL_ROW_165_1495 VDD VSS WELLTAP
XFILLER_56_776 VDD VSS FILLER4
XFILLER_16_607 VDD VSS DECAPHV16
X_09627_ _20166_/A _09811_/B _09627_/C VDD VSS _09628_/D AOI21X1
X_09558_ _09766_/C VDD VSS _09784_/B BUFX3
XTAP_TAPCELL_ROW_81_741 VDD VSS WELLTAP
XFILLER_43_459 VDD VSS FILLER4
XFILLER_24_640 VDD VSS FILLER4
X_09489_ _18457_/D _09501_/B _09489_/C VDD VSS _18240_/D AOI21X1
XFILLER_141_4 VSS VDD FILLER2
XTAP_TAPCELL_ROW_53_487 VDD VSS WELLTAP
X_11520_ _16860_/A VDD VSS _11531_/B BUFX3
XFILLER_62_79 VSS VDD FILLER2
XTAP_TAPCELL_ROW_120_1089 VDD VSS WELLTAP
XFILLER_156_317 VDD VSS DECAPHV8
XFILLER_156_328 VDD VSS FILLER4
X_11451_ _19944_/Q _11460_/B VDD VSS _18637_/D AND2X1
XFILLER_165_840 VSS VDD FILLER2
XFILLER_137_542 VDD VSS FILLER4
X_10402_ _10402_/A _10402_/B _10402_/C _10402_/D VDD VSS _10476_/B OAOI211X1
X_14170_ _14219_/A _14170_/B _14170_/C VDD VSS _18923_/D NOR3X1
XFILLER_109_266 VSS VDD FILLER2
X_11382_ _11382_/A _11384_/C VDD VSS _11383_/B XNOR2X1
XFILLER_124_203 VDD VSS FILLER1
XFILLER_137_586 VDD VSS FILLER1
XFILLER_3_500 VDD VSS FILLER1
X_13121_ _19163_/Q VDD VSS _13122_/A INVX1
X_10333_ _18632_/Q _18794_/Q VDD VSS _10372_/D XOR2X1
Xclkbuf_leaf_6__001_ clkload32/A VDD VSS _19200_/CK BUFX12
XFILLER_140_718 VSS VDD FILLER2
X_13052_ _19247_/Q VDD VSS _13244_/A INVX1
X_10264_ _10264_/A _10264_/B VDD VSS _10349_/B NAND2X1
XFILLER_79_835 VSS VDD FILLER2
XFILLER_105_483 VSS VDD FILLER2
X_12003_ _19122_/Q _12087_/A _14401_/B VDD VSS _12079_/C XOR3X1
XFILLER_3_599 VSS VDD FILLER2
XFILLER_78_323 VSS VDD FILLER2
XFILLER_132_280 VSS VDD FILLER2
X_17860_ _17863_/C _17860_/B _17860_/C VDD VSS _19940_/D AOI21X1
X_10195_ _10200_/A _10195_/B VDD VSS _11424_/C XNOR2X1
XTAP_TAPCELL_ROW_131_1196 VDD VSS WELLTAP
X_16811_ _16811_/A _16811_/B VDD VSS _19654_/D NOR2X1
X_17791_ _19922_/Q _19890_/Q VDD VSS _17793_/D XNOR2X1
X_19530_ _19531_/CK _19530_/D _19530_/Q VDD VSS DFFQX1
X_16742_ _16748_/A _16742_/B VDD VSS _19592_/D NOR2X1
X_13954_ _13955_/A _13955_/B _13955_/D _13955_/C VDD VSS _14004_/B OAOI211X1
XFILLER_93_348 VDD VSS FILLER1
XFILLER_47_743 VDD VSS FILLER1
X_12905_ _13005_/A _13005_/C _13005_/B VDD VSS _14287_/C AOI21X1
X_16673_ _16673_/A VDD VSS _16794_/B INVX1
X_19461_ _19463_/CK _19461_/D _19461_/Q VDD VSS DFFQX1
X_13885_ _18920_/Q _14167_/B VDD VSS _13981_/C _14167_/C AND3X2
XFILLER_74_584 VSS VDD FILLER2
X_18412_ _18423_/CK _18513_/Q _20167_/A _09380_/B VDD VSS DFFRQX1
XTAP_TAPCELL_ROW_44_410 VDD VSS WELLTAP
XFILLER_62_746 VSS VDD FILLER2
X_15624_ _15792_/B VDD VSS _15625_/C INVX1
X_12836_ _12841_/B _12841_/C _19215_/Q VDD VSS _12843_/A AOI21X1
X_19392_ _19466_/CK _19392_/D _19392_/Q VDD VSS DFFQX1
XFILLER_34_459 VDD VSS FILLER1
XTAP_TAPCELL_ROW_7_73 VDD VSS WELLTAP
X_15555_ _15569_/A _15569_/B VDD VSS _15758_/B XNOR2X1
X_18343_ _18343_/CK _18343_/D _18343_/Q _18374_/RB VDD VSS DFFRQX1
XTAP_TAPCELL_ROW_16_156 VDD VSS WELLTAP
XTAP_TAPCELL_ROW_142_1292 VDD VSS WELLTAP
X_12767_ _19216_/Q _12968_/A _12951_/B VDD VSS _12827_/D XNOR3X1
XFILLER_159_111 VDD VSS FILLER4
XFILLER_14_161 VSS VDD FILLER2
XFILLER_15_684 VDD VSS FILLER1
XFILLER_159_133 VSS VDD FILLER2
X_14506_ _15806_/A _14506_/B _14506_/C VDD VSS _19214_/D NOR3X1
X_18274_ _18275_/CK _18274_/D _18274_/Q _20080_/RB VDD VSS DFFRQX1
X_11718_ _11742_/A _11742_/B VDD VSS _14519_/C _11742_/C NAND3X1
X_15486_ _19407_/Q _15788_/B VDD VSS _15525_/C NAND2X1
XFILLER_30_643 VSS VDD FILLER2
X_12698_ _18879_/Q _12790_/B _12703_/C VDD VSS _17870_/B XNOR3X1
XFILLER_30_676 VSS VDD FILLER2
X_17225_ _17227_/A _17227_/B _17225_/C VDD VSS _19800_/D AOI21X1
Xclkbuf_leaf_10__000_ clkload71/A VDD VSS _19702_/CK BUFX12
X_14437_ _14449_/A _14437_/B _14437_/C VDD VSS _19154_/D NOR3X1
XFILLER_30_687 VDD VSS FILLER1
X_11649_ _18789_/Q _11658_/B VDD VSS _18816_/D AND2X1
XTAP_TAPCELL_ROW_0_6 VDD VSS WELLTAP
XFILLER_128_553 VSS VDD FILLER2
XFILLER_116_704 VDD VSS FILLER1
X_17156_ _19785_/Q _19753_/Q _17156_/C VDD VSS _17160_/B MIN3X1
X_14368_ _14368_/A _14368_/B VDD VSS _19092_/D NOR2X1
XFILLER_155_361 VDD VSS FILLER1
XFILLER_115_214 VDD VSS DECAPHV8
X_16107_ _16107_/A VDD VSS _16770_/B INVX1
XFILLER_6_360 VSS VDD FILLER2
X_13319_ _13319_/A _13319_/B _13319_/C _13319_/D VDD VSS _13616_/A AOAI211X1
X_17087_ _19771_/Q _19739_/Q _17087_/C VDD VSS _17091_/B AOI21X1
XFILLER_6_382 VSS VDD FILLER2
X_14299_ _14334_/A _14299_/B VDD VSS _19031_/D AND2X1
Xclkbuf_leaf_25__000_ clkload70/A VDD VSS _19333_/CK BUFX12
X_16038_ _19551_/Q _16696_/A _16038_/C VDD VSS _16062_/C MIN3X1
XFILLER_131_729 VSS VDD FILLER2
XFILLER_69_323 VSS VDD FILLER2
XFILLER_69_334 VDD VSS FILLER4
Xclkbuf_1_0__f_clk clkbuf_0_clk/Y VDD VSS _231_/CK BUFX12
XFILLER_97_654 VSS VDD FILLER2
XFILLER_96_142 VDD VSS FILLER4
XFILLER_96_153 VDD VSS FILLER4
XFILLER_85_816 VDD VSS FILLER4
XFILLER_28_0 VDD VSS FILLER1
XFILLER_96_164 VDD VSS FILLER4
XFILLER_69_389 VSS VDD FILLER2
X_17989_ _17989_/A _17989_/B _17989_/C _18163_/A VDD VSS _19963_/D OAOI211X1
XFILLER_111_497 VDD VSS DECAPHV8
XFILLER_38_732 VDD VSS FILLER4
X_19728_ _19730_/CK _19728_/D _19728_/Q VDD VSS DFFQX1
XFILLER_84_359 VSS VDD FILLER2
XTAP_TAPCELL_ROW_95_866 VDD VSS WELLTAP
X_19659_ _19661_/CK _19659_/D _19659_/Q VDD VSS DFFQX1
XTAP_TAPCELL_ROW_107_978 VDD VSS WELLTAP
X_09412_ _09507_/C VDD VSS _09506_/C BUFX3
XFILLER_40_407 VSS VDD FILLER2
X_09343_ _20067_/RB _09346_/B VDD VSS _09343_/Y NOR2BX1
XFILLER_21_610 VSS VDD FILLER2
XFILLER_21_632 VSS VDD FILLER2
X_09274_ _09284_/AB _09362_/B VDD VSS _09274_/Y NOR2BX1
XFILLER_166_604 VDD VSS FILLER4
XFILLER_21_654 VDD VSS FILLER4
XFILLER_166_615 VSS VDD FILLER2
XFILLER_138_317 VDD VSS FILLER1
XTAP_TAPCELL_ROW_156_1417 VDD VSS WELLTAP
XFILLER_138_328 VDD VSS FILLER4
XFILLER_20_142 VSS VDD FILLER2
XFILLER_32_49 VDD VSS FILLER4
XFILLER_20_164 VSS VDD FILLER2
XFILLER_147_840 VSS VDD FILLER2
XFILLER_20_175 VSS VDD FILLER2
XFILLER_166_659 VSS VDD FILLER2
XFILLER_148_49 VDD VSS DECAPHV8
XFILLER_5_809 VSS VDD FILLER2
XFILLER_134_523 VSS VDD FILLER2
XFILLER_146_383 VSS VDD FILLER2
XFILLER_106_225 VDD VSS FILLER4
XFILLER_134_545 VDD VSS FILLER4
XFILLER_134_567 VSS VDD FILLER2
XFILLER_164_26 VSS VDD FILLER2
XFILLER_134_578 VDD VSS FILLER1
XFILLER_161_375 VSS VDD FILLER2
XFILLER_121_228 VDD VSS FILLER4
XFILLER_87_153 VSS VDD FILLER2
XFILLER_87_175 VSS VDD FILLER2
XFILLER_76_849 VSS VDD FILLER2
XFILLER_75_337 VSS VDD FILLER2
XTAP_TAPCELL_ROW_58_535 VDD VSS WELLTAP
XFILLER_29_743 VDD VSS FILLER1
XFILLER_91_819 VSS VDD FILLER2
XFILLER_56_562 VSS VDD FILLER2
X_10951_ _10951_/A _10958_/B VDD VSS _10957_/B XOR2X1
XFILLER_28_264 VSS VDD FILLER2
XFILLER_16_404 VDD VSS FILLER1
XFILLER_83_370 VSS VDD FILLER2
XFILLER_44_735 VSS VDD FILLER2
XFILLER_28_286 VSS VDD FILLER2
XTAP_TAPCELL_ROW_122_1107 VDD VSS WELLTAP
XFILLER_71_521 VDD VSS FILLER1
XFILLER_113_96 VSS VDD FILLER2
XFILLER_83_392 VDD VSS FILLER4
X_13670_ _13748_/A _13748_/B VDD VSS _14163_/B _13748_/C AND3X2
XFILLER_43_234 VDD VSS FILLER1
X_10882_ _10882_/A _10921_/B VDD VSS _10887_/B XNOR2X1
X_12621_ _12632_/A _12632_/B _12632_/C VDD VSS _14284_/C OR3X2
XFILLER_12_621 VDD VSS FILLER1
XFILLER_24_481 VSS VDD FILLER2
X_15340_ _15340_/A _15690_/B _15340_/C VDD VSS _15385_/B MIN3X1
X_12552_ _14440_/B _14439_/C _19156_/Q VDD VSS _12553_/D AND3BX1
XTAP_TAPCELL_ROW_13_126 VDD VSS WELLTAP
XFILLER_8_603 VDD VSS FILLER1
XFILLER_132_0 VDD VSS FILLER1
X_11503_ _18657_/Q _11508_/B VDD VSS _18684_/D AND2X1
X_15271_ _19540_/Q _15313_/B VDD VSS _15908_/B XOR2X1
X_12483_ _12483_/A _12483_/B _12483_/C _12483_/D VDD VSS _14440_/B OAOI211X1
XFILLER_156_136 VSS VDD FILLER2
X_17010_ _17010_/A _17010_/B _17012_/C VDD VSS _19756_/D NOR3X1
Xclkbuf_leaf_6_sclk delaybuf_1_sclk/A VDD VSS _18217_/CK BUFX12
X_14222_ _14294_/A _14222_/B _14222_/C VDD VSS _18969_/D NOR3X1
X_11434_ _232_/E _11434_/B VDD VSS _18626_/D NOR2X1
XFILLER_22_82 VDD VSS FILLER4
XFILLER_165_670 VSS VDD FILLER2
XFILLER_125_523 VDD VSS FILLER4
XTAP_TAPCELL_ROW_133_1214 VDD VSS WELLTAP
X_14153_ _14154_/A _14153_/B VDD VSS _18909_/D NOR2X1
XFILLER_98_20 VSS VDD FILLER2
X_11365_ _11371_/B _11365_/B VDD VSS _11375_/B XOR2X1
XFILLER_164_180 VSS VDD FILLER2
X_13104_ _13211_/A _13104_/B _13314_/D VDD VSS _13161_/C XNOR3X1
X_10316_ _18659_/Q _18767_/Q VDD VSS _10405_/D XOR2X1
X_18961_ _18961_/CK _18961_/D _18961_/Q VDD VSS DFFQX1
X_14084_ _14104_/C _14104_/A VDD VSS _14096_/A NOR2BX1
X_11296_ _18583_/Q _11296_/B _11296_/C VDD VSS _11304_/A MIN3X1
XFILLER_98_86 VSS VDD FILLER2
XFILLER_112_239 VSS VDD FILLER2
X_17912_ _17912_/A _17914_/C VDD VSS _17913_/B XNOR2X1
X_13035_ _19217_/Q _14510_/B VDD VSS _13036_/D _14510_/C NAND3X1
X_10247_ _10247_/A _11430_/B _10266_/D _10266_/C VDD VSS _10315_/A AO22X2
XFILLER_78_120 VDD VSS FILLER1
XFILLER_105_291 VDD VSS FILLER4
X_18892_ _18973_/CK _18892_/D _18892_/Q VDD VSS DFFQX1
XFILLER_79_654 VSS VDD FILLER2
XFILLER_78_142 VSS VDD FILLER2
XFILLER_154_81 VDD VSS FILLER1
XFILLER_120_250 VSS VDD FILLER2
X_17843_ _18846_/Q _17843_/B VDD VSS _17847_/C OR2X2
XFILLER_94_613 VDD VSS FILLER1
XFILLER_39_518 VDD VSS FILLER4
X_10178_ _10184_/C _10184_/B VDD VSS _10179_/B NAND2BX1
XFILLER_67_849 VDD VSS FILLER4
XFILLER_94_657 VDD VSS DECAPHV8
XFILLER_19_220 VSS VDD FILLER2
X_17774_ _17775_/A _17776_/C _17828_/C VDD VSS _17775_/C OAI21X1
X_14986_ _19311_/Q _15682_/B VDD VSS _14987_/B XNOR2X1
XTAP_TAPCELL_ROW_144_1310 VDD VSS WELLTAP
X_19513_ _19734_/CK _19513_/D _19513_/Q VDD VSS DFFQX1
X_16725_ _19928_/Q _16726_/B VDD VSS _19576_/D AND2X1
XFILLER_19_264 VDD VSS FILLER4
X_13937_ _18921_/Q _13949_/A _13949_/B VDD VSS _13938_/D XNOR3X1
XFILLER_93_189 VSS VDD FILLER2
XFILLER_35_724 VDD VSS FILLER4
XFILLER_74_370 VDD VSS FILLER4
XTAP_TAPCELL_ROW_29_270 VDD VSS WELLTAP
X_19444_ _19478_/CK _19444_/D _19444_/Q VDD VSS DFFQX1
X_16656_ _16657_/A _16657_/B _16657_/C VDD VSS _16675_/C AO21X2
X_13868_ _13868_/A _13868_/B _13868_/C _13868_/D VDD VSS _17940_/B OAOI211X1
XTAP_TAPCELL_ROW_104_948 VDD VSS WELLTAP
X_15607_ _15607_/A _15620_/C VDD VSS _15730_/B XNOR2X1
X_12819_ _12819_/A _12819_/B _12819_/C _12819_/D VDD VSS _14382_/C OAI211X1
X_19375_ _19406_/CK _19375_/D _19375_/Q VDD VSS DFFQX1
X_16587_ _19733_/Q _16898_/B VDD VSS _16589_/B XOR2X1
X_13799_ _18975_/Q _13827_/B _13845_/C VDD VSS _13987_/B XNOR3X1
X_18326_ _18327_/CK _18470_/D _18326_/Q _18471_/RB VDD VSS DFFRQX1
X_15538_ _19352_/Q _15727_/B VDD VSS _15539_/C NAND2X1
X_15469_ _15469_/A _15469_/B _15850_/B VDD VSS _15511_/A MIN3X1
X_18257_ _18257_/CK _18257_/D _18260_/D _18486_/RB VDD VSS DFFRQX1
XFILLER_129_840 VSS VDD FILLER2
X_17208_ _17357_/B _17208_/B _17208_/C VDD VSS _17212_/C MIN3X1
XFILLER_163_618 VDD VSS FILLER1
XFILLER_128_361 VSS VDD FILLER2
XFILLER_144_810 VSS VDD FILLER2
X_18188_ _18191_/C _18188_/B _18188_/C VDD VSS _20011_/D AOI21X1
XFILLER_162_128 VSS VDD FILLER2
X_17139_ _17140_/A _17140_/B _17140_/D _17140_/C VDD VSS _17142_/C AOI211X1
XFILLER_155_180 VDD VSS FILLER4
XFILLER_143_342 VDD VSS DECAPHV8
XFILLER_104_707 VDD VSS FILLER4
X_20150_ _20150_/A VDD VSS _20150_/Y BUFX3
XTAP_TAPCELL_ROW_151_1369 VDD VSS WELLTAP
XFILLER_103_206 VSS VDD FILLER2
XFILLER_143_375 VSS VDD FILLER2
XFILLER_89_429 VSS VDD FILLER2
XTAP_TAPCELL_ROW_110_1000 VDD VSS WELLTAP
XFILLER_103_239 VDD VSS FILLER1
XFILLER_131_548 VSS VDD FILLER2
X_20081_ _20081_/CK _20081_/D _20081_/Q _20081_/RB VDD VSS DFFRQX1
X_09892_ _18561_/Q _09892_/B VDD VSS _09893_/B XOR2X1
XFILLER_69_197 VDD VSS FILLER1
XFILLER_57_337 VSS VDD FILLER2
XFILLER_57_348 VSS VDD FILLER2
XFILLER_84_167 VSS VDD FILLER2
XFILLER_27_38 VSS VDD FILLER2
XTAP_TAPCELL_ROW_55_505 VDD VSS WELLTAP
XFILLER_80_351 VSS VDD FILLER2
XFILLER_25_256 VDD VSS FILLER1
XFILLER_43_15 VSS VDD FILLER2
XFILLER_80_373 VSS VDD FILLER2
Xclkbuf_leaf_5__002_ clkbuf_leaf_9__002_/A VDD VSS _18795_/CK BUFX12
XFILLER_80_384 VSS VDD FILLER2
XTAP_TAPCELL_ROW_63_582 VDD VSS WELLTAP
XFILLER_40_226 VDD VSS FILLER4
X_09326_ _18288_/Q _18516_/Q _09299_/Y VDD VSS _09326_/Y MUXI2X1
XFILLER_21_440 VSS VDD FILLER2
X_09257_ _20047_/Q _20048_/Q _09257_/C VDD VSS _09258_/B AND3BX1
XFILLER_166_434 VSS VDD FILLER2
XTAP_TAPCELL_ROW_10_107 VDD VSS WELLTAP
XFILLER_154_607 VDD VSS DECAPHV8
XFILLER_119_350 VSS VDD FILLER2
X_09188_ _18525_/Q VDD VSS _18456_/D INVX1
XTAP_TAPCELL_ROW_119_1080 VDD VSS WELLTAP
XFILLER_4_138 VDD VSS FILLER1
XFILLER_107_556 VSS VDD FILLER2
XFILLER_108_30 VDD VSS FILLER1
XFILLER_150_802 VSS VDD FILLER2
X_11150_ _11116_/B _11149_/Y _10984_/A VDD VSS _11150_/Y MUXI2X1
XFILLER_161_161 VDD VSS FILLER1
XFILLER_162_695 VSS VDD FILLER2
XFILLER_0_311 VDD VSS FILLER4
XFILLER_108_85 VSS VDD FILLER2
X_10101_ _10101_/A _10101_/B _10101_/C VDD VSS _10120_/A MIN3X1
XFILLER_122_559 VSS VDD FILLER2
X_11081_ _10948_/Y _11080_/Y _11118_/A VDD VSS _11081_/Y MUXI2X1
XFILLER_88_451 VSS VDD FILLER2
X_10032_ _10032_/A VDD VSS _10155_/A BUFX3
XFILLER_49_827 VSS VDD FILLER2
XFILLER_48_304 VSS VDD FILLER2
XFILLER_0_388 VDD VSS FILLER4
XFILLER_76_635 VSS VDD FILLER2
XFILLER_102_283 VSS VDD FILLER2
XFILLER_75_123 VDD VSS FILLER1
X_14840_ _14840_/A _14840_/B _14840_/C _14840_/D VDD VSS _14867_/B OAOI211X1
XFILLER_64_808 VDD VSS FILLER4
XFILLER_76_668 VDD VSS FILLER4
XFILLER_84_33 VDD VSS FILLER1
XFILLER_17_702 VSS VDD FILLER2
X_14771_ _19391_/Q VDD VSS _14811_/A INVX1
XFILLER_75_178 VDD VSS FILLER1
X_11983_ _19233_/Q _12055_/A _12055_/B VDD VSS _11985_/C XNOR3X1
XFILLER_75_189 VSS VDD FILLER2
XFILLER_44_510 VDD VSS FILLER1
XFILLER_90_126 VDD VSS DECAPHV8
XFILLER_17_735 VSS VDD FILLER2
X_16510_ _19730_/Q _16895_/B VDD VSS _16511_/B XNOR2X1
X_13722_ _13791_/A _13791_/C VDD VSS _13723_/C NOR2X1
X_09966__237 _20081_/CK VDD VSS _18513_/CK INVX1
XFILLER_84_99 VDD VSS FILLER1
X_10934_ _18674_/Q VDD VSS _11522_/A INVX1
XFILLER_17_60 VSS VDD FILLER2
X_17490_ _19857_/Q _19825_/Q VDD VSS _17496_/B NAND2X1
XFILLER_44_565 VSS VDD FILLER2
XFILLER_17_779 VDD VSS FILLER4
XFILLER_140_61 VSS VDD FILLER2
XFILLER_71_362 VDD VSS FILLER1
X_16441_ _16442_/B _16441_/B _16441_/C VDD VSS _19535_/D AOI21X1
X_13653_ _18973_/Q _13768_/A _13830_/B VDD VSS _13675_/D XNOR3X1
XTAP_TAPCELL_ROW_26_251 VDD VSS WELLTAP
Xclkbuf_leaf_24__001_ clkbuf_2_1__f__001_/Y VDD VSS _19119_/CK BUFX12
X_10865_ _18645_/Q _18807_/Q VDD VSS _10866_/D NOR2X1
XFILLER_71_384 VDD VSS FILLER4
XFILLER_16_289 VDD VSS FILLER4
XFILLER_31_226 VSS VDD FILLER2
XTAP_TAPCELL_ROW_101_918 VDD VSS WELLTAP
X_12604_ _18962_/Q _12619_/B _14213_/B VDD VSS _14182_/B XNOR3X1
X_16372_ _19597_/Q _16747_/B VDD VSS _16398_/B NOR2X1
X_19160_ _19191_/CK _19160_/D _19160_/Q VDD VSS DFFQX1
XFILLER_31_248 VDD VSS FILLER1
X_13584_ _18944_/Q VDD VSS _13656_/D INVX1
XFILLER_157_401 VSS VDD FILLER2
X_10796_ _18644_/Q _18806_/Q VDD VSS _10798_/C XNOR2X1
X_15323_ _19431_/Q _15815_/B VDD VSS _15347_/D XNOR2X1
X_18111_ _18173_/A _18111_/B VDD VSS _19996_/D NOR2X1
X_12535_ _12535_/A _12535_/B _14212_/B VDD VSS _12619_/B MIN3X1
X_19091_ _19119_/CK _19091_/D _19091_/Q VDD VSS DFFQX1
XFILLER_33_81 VDD VSS FILLER1
XTAP_TAPCELL_ROW_4_52 VDD VSS WELLTAP
XFILLER_40_793 VSS VDD FILLER2
XFILLER_33_92 VDD VSS FILLER1
XFILLER_12_495 VDD VSS FILLER4
X_15254_ _15293_/B _15254_/B VDD VSS _15688_/B XNOR2X1
X_18042_ _18541_/Q _18042_/B _18542_/Q VDD VSS _18043_/C AOI21X1
Xclkbuf_leaf_39__001_ clkbuf_leaf_4__001_/A VDD VSS _19269_/CK BUFX12
X_12466_ _12553_/A _12553_/B _12553_/C VDD VSS _14407_/B OAI21X1
XFILLER_144_117 VSS VDD FILLER2
X_14205_ _14231_/A _14205_/B VDD VSS _18954_/D AND2X1
X_11417_ _11422_/A _17990_/B _11417_/C VDD VSS _18611_/D NOR3X1
X_15185_ _15198_/A _15198_/B _15198_/C _15185_/D VDD VSS _15243_/A OAOI211X1
X_12397_ _12407_/A _14531_/B _12397_/C VDD VSS _12402_/B AOI21X1
XFILLER_125_342 VDD VSS FILLER1
XFILLER_125_364 VDD VSS FILLER1
X_14136_ _18163_/A VDD VSS _14136_/Y BUFX3
X_11348_ _11383_/A _11348_/B VDD VSS _18588_/D NOR2X1
XFILLER_125_375 VDD VSS DECAPHV16
X_19993_ _19996_/CK _19993_/D _19993_/Q VDD VSS DFFQX1
XFILLER_98_215 VDD VSS FILLER4
XFILLER_141_835 VSS VDD FILLER2
XFILLER_140_323 VSS VDD FILLER2
XFILLER_3_171 VSS VDD FILLER2
XFILLER_165_91 VSS VDD FILLER2
X_18944_ _18999_/CK _18944_/D _18944_/Q VDD VSS DFFQX1
X_14067_ _14068_/A _14068_/C _14068_/B VDD VSS _14203_/A OA21X2
X_11279_ _11119_/Y _11364_/C _11289_/A VDD VSS _11286_/B MUXI2X1
XFILLER_3_193 VSS VDD FILLER2
XFILLER_140_356 VSS VDD FILLER2
XFILLER_140_378 VSS VDD FILLER2
X_13018_ _19105_/Q _14383_/B VDD VSS _13102_/C _14383_/C AND3X2
X_18875_ _18905_/CK _18875_/D _18875_/Q VDD VSS DFFQX1
XFILLER_94_410 VDD VSS FILLER1
XFILLER_67_635 VSS VDD FILLER2
XFILLER_94_421 VDD VSS FILLER4
XFILLER_66_112 VSS VDD FILLER2
X_17826_ _17826_/A _17826_/B _17826_/C VDD VSS _19929_/D AOI21X1
XFILLER_94_476 VDD VSS FILLER1
XFILLER_66_178 VDD VSS DECAPHV8
X_17757_ _19914_/Q _19882_/Q VDD VSS _17758_/C NAND2X1
X_14969_ _19506_/Q _15018_/B VDD VSS _15056_/C NAND2X1
XFILLER_47_370 VSS VDD FILLER2
XFILLER_47_381 VSS VDD FILLER2
X_16708_ _19913_/Q _16726_/B VDD VSS _19561_/D AND2X1
XFILLER_81_148 VDD VSS FILLER4
X_17688_ _19899_/Q _19867_/Q _17688_/C VDD VSS _17692_/B AOI21X1
X_19427_ _19463_/CK _19427_/D _19427_/Q VDD VSS DFFQX1
X_16639_ _19735_/Q _16900_/B VDD VSS _16643_/C XOR2X1
XFILLER_62_373 VSS VDD FILLER2
XFILLER_62_395 VDD VSS FILLER4
XFILLER_50_546 VSS VDD FILLER2
XFILLER_95_0 VDD VSS FILLER4
X_19358_ _19385_/CK _19358_/D _19358_/Q VDD VSS DFFQX1
XFILLER_22_259 VSS VDD FILLER2
XTAP_TAPCELL_ROW_60_552 VDD VSS WELLTAP
X_18309_ _18309_/CK _18501_/D _18309_/Q _20078_/RB VDD VSS DFFRQX1
X_19289_ _19306_/CK _19289_/D _19289_/Q VDD VSS DFFQX1
XFILLER_136_607 VSS VDD FILLER2
XTAP_TAPCELL_ROW_32_298 VDD VSS WELLTAP
XFILLER_117_810 VSS VDD FILLER2
XFILLER_144_640 VDD VSS FILLER4
X_20202_ _20202_/A VDD VSS _20202_/Y BUFX3
XFILLER_145_17 VDD VSS FILLER1
Xmax_cap152 _17957_/B VDD VSS _17959_/B BUFX3
XFILLER_131_301 VSS VDD FILLER2
XFILLER_144_684 VSS VDD FILLER2
Xmax_cap163 _14907_/B VDD VSS _15833_/B BUFX3
XFILLER_1_108 VSS VDD FILLER2
Xmax_cap174 _09785_/B VDD VSS _09766_/C BUFX3
XFILLER_104_537 VDD VSS FILLER4
Xmax_cap185 _18522_/Q VDD VSS _18501_/D BUFX12
XFILLER_131_323 VSS VDD FILLER2
X_20133_ _20133_/A VDD VSS _20133_/Y BUFX3
X_09944_ _09944_/A VDD VSS _10166_/D BUFX3
XFILLER_58_602 VSS VDD FILLER2
X_20064_ clkload6/A _20064_/D _20064_/Q _20065_/RB VDD VSS DFFRQX1
XFILLER_131_389 VDD VSS DECAPHV8
X_09875_ _09885_/A _10017_/B _10017_/C _09944_/A VDD VSS _09876_/C AOI211X1
XFILLER_98_793 VSS VDD FILLER2
XFILLER_85_410 VDD VSS FILLER4
XFILLER_100_732 VSS VDD FILLER2
XFILLER_57_134 VDD VSS FILLER4
XFILLER_100_754 VSS VDD FILLER2
XFILLER_57_145 VSS VDD FILLER2
XFILLER_57_189 VSS VDD FILLER2
XFILLER_72_126 VDD VSS FILLER1
XFILLER_72_137 VSS VDD FILLER2
XFILLER_54_36 VDD VSS FILLER4
XFILLER_53_340 VDD VSS FILLER4
XFILLER_14_716 VSS VDD FILLER2
XFILLER_81_671 VDD VSS FILLER4
XFILLER_80_170 VSS VDD FILLER2
XFILLER_53_384 VSS VDD FILLER2
XFILLER_110_20 VDD VSS DECAPHV8
X_10650_ _10729_/C _10729_/D VDD VSS _10652_/B XNOR2X1
XTAP_TAPCELL_ROW_23_221 VDD VSS WELLTAP
XFILLER_9_208 VSS VDD FILLER2
XFILLER_110_64 VSS VDD FILLER2
XFILLER_110_86 VSS VDD FILLER2
X_09309_ _18454_/D _09308_/Y _09302_/Y VDD VSS _18523_/D MUXI2X1
XFILLER_110_97 VDD VSS FILLER1
X_10581_ _10581_/A VDD VSS _11116_/A BUFX3
XFILLER_22_793 VDD VSS FILLER4
X_12320_ _12396_/A _12396_/B _12396_/C VDD VSS _14532_/B OAI21X1
XFILLER_139_489 VDD VSS DECAPHV16
XFILLER_119_51 VSS VDD FILLER2
X_12251_ _12299_/A _12258_/B _12258_/C VDD VSS _12300_/C XNOR3X1
XFILLER_107_331 VDD VSS FILLER4
X_11202_ _11228_/C _11202_/B VDD VSS _11208_/C XNOR2X1
XFILLER_79_44 VDD VSS FILLER4
XFILLER_107_375 VSS VDD FILLER2
X_12182_ _12372_/A _12372_/C VDD VSS _12183_/C AND2X1
X_11133_ _11226_/A _11163_/C VDD VSS _11134_/D NOR2X1
X_16990_ _19753_/Q _17011_/B VDD VSS _16994_/B XOR2X1
XFILLER_110_507 VDD VSS FILLER4
XFILLER_110_518 VSS VDD FILLER2
XFILLER_1_675 VSS VDD FILLER2
X_15941_ _19549_/Q _19901_/Q VDD VSS _15942_/B XNOR2X1
X_11064_ _11064_/A _11064_/B _11208_/D VDD VSS _11065_/B OAI21X1
XFILLER_49_613 VDD VSS FILLER1
XFILLER_95_229 VSS VDD FILLER2
XFILLER_76_421 VSS VDD FILLER2
XFILLER_48_112 VDD VSS FILLER4
X_10015_ _10000_/Y _10014_/Y _11178_/C VDD VSS _10015_/Y MUX2X1
XFILLER_88_292 VSS VDD FILLER2
X_18660_ _18795_/CK _18660_/D _18660_/Q VDD VSS DFFQX1
XFILLER_76_443 VSS VDD FILLER2
X_15872_ _14522_/Y _15872_/B _15872_/C VDD VSS _19480_/D AND3BX1
XFILLER_49_668 VDD VSS DECAPHV8
XFILLER_76_465 VDD VSS FILLER1
XFILLER_95_98 VDD VSS FILLER1
XFILLER_64_616 VSS VDD FILLER2
XFILLER_36_307 VSS VDD FILLER2
X_17611_ _19883_/Q _19851_/Q VDD VSS _17618_/C NOR2X1
X_14823_ _14826_/A _14872_/B _14872_/C VDD VSS _14824_/C AND3BX1
XFILLER_63_104 VSS VDD FILLER2
X_18591_ _18595_/CK _18591_/D _18591_/Q VDD VSS DFFQX1
XTAP_TAPCELL_ROW_128_1168 VDD VSS WELLTAP
XFILLER_91_424 VSS VDD FILLER2
XFILLER_29_370 VSS VDD FILLER2
XFILLER_151_60 VSS VDD FILLER2
XFILLER_91_435 VDD VSS FILLER1
XFILLER_63_137 VDD VSS FILLER4
XFILLER_151_82 VSS VDD FILLER2
X_17542_ _19868_/Q _19836_/Q _17542_/C VDD VSS _17546_/B AOI21X1
X_14754_ _15831_/B _15831_/C VDD VSS _14773_/C NOR2X1
X_11966_ _11966_/A _11966_/B VDD VSS _11967_/C XOR2X1
XFILLER_91_468 VDD VSS FILLER4
XTAP_TAPCELL_ROW_74_677 VDD VSS WELLTAP
XFILLER_44_351 VDD VSS FILLER4
X_13705_ _19085_/Q VDD VSS _13779_/A INVX1
X_10917_ _18568_/Q _10917_/B VDD VSS _10954_/C AND2X1
X_14685_ _14737_/A _14737_/B VDD VSS _14702_/C XOR2X1
X_17473_ _17475_/C _17473_/B _17473_/C VDD VSS _19853_/D AOI21X1
XFILLER_17_598 VSS VDD FILLER2
X_11897_ _19119_/Q VDD VSS _11899_/A INVX1
X_19212_ _19217_/CK _19212_/D _19212_/Q VDD VSS DFFQX1
X_16424_ _16450_/C _16424_/B VDD VSS _16750_/B XNOR2X1
X_13636_ _19168_/Q VDD VSS _13639_/C INVX1
X_10848_ _18566_/Q _10848_/B VDD VSS _10851_/D NOR2X1
XFILLER_158_710 VDD VSS FILLER1
XFILLER_13_782 VSS VDD FILLER2
X_19143_ _19200_/CK _19143_/D _19143_/Q VDD VSS DFFQX1
X_16355_ _16355_/A _16358_/B VDD VSS _16356_/B XOR2X1
X_13567_ _19000_/Q _13567_/B _13683_/D VDD VSS _14226_/C XNOR3X1
XFILLER_12_270 VSS VDD FILLER2
X_10779_ _18564_/Q _10780_/B VDD VSS _10814_/A AND2X1
XFILLER_118_607 VDD VSS FILLER4
X_15306_ _19458_/Q _15306_/B _15306_/C VDD VSS _15351_/A MIN3X1
X_12518_ _19045_/Q _12803_/A _12803_/B VDD VSS _12540_/D XNOR3X1
XTAP_TAPCELL_ROW_139_1264 VDD VSS WELLTAP
XFILLER_9_775 VSS VDD FILLER2
X_16286_ _19913_/Q _19561_/Q _16286_/C VDD VSS _16313_/C AOI2B1X1
X_19074_ _19126_/CK _19074_/D _19074_/Q VDD VSS DFFQX1
XFILLER_157_275 VDD VSS FILLER4
X_13498_ _13656_/A _13498_/B VDD VSS _14161_/B XNOR2X1
XFILLER_145_437 VDD VSS FILLER4
X_18025_ _18026_/B _18045_/B _18025_/C _18049_/D VDD VSS _19970_/D OAI31X1
XFILLER_8_296 VDD VSS FILLER4
X_15237_ _19539_/Q _15237_/B VDD VSS _15906_/B XOR2X1
X_12449_ _19069_/Q _12449_/B _12449_/C VDD VSS _12452_/A MIN3X1
XFILLER_5_30 VSS VDD FILLER2
X_15168_ _19315_/Q _15686_/B VDD VSS _15169_/B XOR2X1
XFILLER_5_52 VSS VDD FILLER2
XFILLER_126_695 VSS VDD FILLER2
X_14119_ _14522_/A VDD VSS _14142_/A BUFX3
XFILLER_141_654 VDD VSS FILLER4
X_15099_ _15108_/A _15145_/B _15099_/C VDD VSS _15100_/B OR3BX1
Xfanout209 _20054_/RB VDD VSS _18450_/RB BUFX3
X_19976_ _19986_/CK _19976_/D _19976_/Q VDD VSS DFFQX1
XFILLER_5_96 VDD VSS FILLER4
XFILLER_140_142 VSS VDD FILLER2
XFILLER_113_367 VDD VSS FILLER4
XFILLER_141_698 VSS VDD FILLER2
X_18927_ _18961_/CK _18927_/D _18927_/Q VDD VSS DFFQX1
XFILLER_67_410 VDD VSS FILLER4
XFILLER_67_421 VSS VDD FILLER2
XFILLER_39_123 VSS VDD FILLER2
X_09660_ _18461_/Q _09784_/B VDD VSS _09664_/A NAND2X1
X_18858_ _18915_/CK _18858_/D _18858_/Q VDD VSS DFFQX1
XFILLER_10_0 VDD VSS FILLER1
XFILLER_55_616 VDD VSS FILLER4
X_17809_ _17810_/B _17809_/B VDD VSS _17811_/B NOR2BX1
XTAP_TAPCELL_ROW_65_600 VDD VSS WELLTAP
X_09591_ _18425_/Q _09696_/B VDD VSS _09592_/E NOR2X1
XFILLER_67_498 VDD VSS DECAPHV8
XFILLER_39_189 VDD VSS FILLER4
X_18789_ _18845_/CK _18789_/D _18789_/Q VDD VSS DFFQX1
XFILLER_55_649 VSS VDD FILLER2
XFILLER_54_137 VSS VDD FILLER2
XFILLER_36_852 VSS VDD FILLER2
XTAP_TAPCELL_ROW_37_346 VDD VSS WELLTAP
XFILLER_82_468 VSS VDD FILLER2
XFILLER_54_159 VSS VDD FILLER2
XFILLER_50_321 VDD VSS FILLER4
XFILLER_23_535 VSS VDD FILLER2
XFILLER_23_546 VDD VSS FILLER1
XFILLER_23_557 VDD VSS FILLER1
XFILLER_11_719 VSS VDD FILLER2
XFILLER_10_229 VSS VDD FILLER2
XFILLER_149_754 VSS VDD FILLER2
XFILLER_148_253 VSS VDD FILLER2
XFILLER_149_776 VDD VSS FILLER4
XFILLER_109_618 VSS VDD FILLER2
XFILLER_108_128 VSS VDD FILLER2
XFILLER_40_49 VSS VDD FILLER2
XFILLER_156_49 VDD VSS FILLER4
XFILLER_163_267 VSS VDD FILLER2
XFILLER_151_418 VDD VSS FILLER4
XTAP_TAPCELL_ROW_116_1061 VDD VSS WELLTAP
Xclkbuf_2_0__f__09182_ clkbuf_0__09182_/Y VDD VSS _18595_/CK BUFX12
XFILLER_144_481 VDD VSS FILLER4
Xhold263 hold263/A VDD VSS input4/A BUFX3
XFILLER_120_816 VDD VSS FILLER1
Xclkbuf_leaf_23__002_ clkload16/A VDD VSS _19986_/CK BUFX12
XFILLER_131_164 VSS VDD FILLER2
X_20116_ _20116_/A VDD VSS _20116_/Y BUFX3
XFILLER_120_838 VDD VSS FILLER1
X_09927_ _09941_/C _09927_/B VDD VSS _09928_/B NOR2X1
XFILLER_58_421 VDD VSS DECAPHV8
X_20047_ _20047_/CK _20047_/D _20047_/Q _09284_/Y VDD VSS DFFRQX1
X_09858_ _18571_/Q _09858_/B VDD VSS _09901_/B XOR2X1
XFILLER_100_551 VDD VSS FILLER4
XFILLER_65_13 VSS VDD FILLER2
X_09789_ _09788_/Y _09816_/D _18273_/Q _09818_/C VDD VSS _09791_/C AOI2B2X1
XFILLER_65_68 VSS VDD FILLER2
X_11820_ _11854_/B _11820_/B VDD VSS _11821_/C XNOR2X1
XFILLER_73_457 VSS VDD FILLER2
XFILLER_73_468 VSS VDD FILLER2
XFILLER_121_41 VDD VSS FILLER4
XFILLER_121_52 VSS VDD FILLER2
X_11751_ _11751_/A _14520_/B VDD VSS _11776_/A OR2X2
XFILLER_121_63 VDD VSS FILLER1
XFILLER_41_310 VDD VSS FILLER1
XFILLER_121_96 VSS VDD FILLER2
X_10702_ _10960_/A _10987_/B _10702_/C VDD VSS _10709_/C OAI21X1
XFILLER_81_45 VSS VDD FILLER2
X_14470_ _15383_/A VDD VSS _14766_/A BUFX3
X_11682_ _18901_/Q VDD VSS _12197_/A INVX1
X_13421_ _13533_/A _14293_/B VDD VSS _13599_/B NOR2X1
X_10633_ _10633_/A _10633_/B _10633_/C _10633_/D VDD VSS _10634_/B AO31X2
XFILLER_139_231 VDD VSS FILLER1
X_16140_ _16157_/A _16157_/B VDD VSS _16773_/B XNOR2X1
X_13352_ _19166_/Q _13542_/B _13542_/C VDD VSS _13617_/B XNOR3X1
XFILLER_139_275 VDD VSS FILLER4
X_10564_ _10649_/B _10763_/A _10564_/C VDD VSS _10578_/B OR3BX1
XFILLER_6_712 VDD VSS FILLER1
XFILLER_154_212 VDD VSS FILLER4
X_12303_ _19182_/Q _12303_/B _12303_/C VDD VSS _12382_/C XNOR3X1
XFILLER_154_223 VDD VSS FILLER1
X_16071_ _19681_/Q _16841_/B VDD VSS _16080_/C NOR2X1
XFILLER_6_745 VSS VDD FILLER2
X_13283_ _13283_/A _17901_/B VDD VSS _18857_/D AND2X1
X_10495_ _10525_/A _10525_/B _10525_/C _10495_/D VDD VSS _10496_/D AOAI211X1
XFILLER_5_244 VDD VSS FILLER1
X_15022_ _19452_/Q _15022_/B _15054_/C VDD VSS _15092_/B XNOR3X1
X_12234_ _12234_/A _12234_/B _12234_/C _12234_/D VDD VSS _14499_/B AOAI211X1
XTAP_TAPCELL_ROW_1_20 VDD VSS WELLTAP
XFILLER_6_789 VDD VSS FILLER1
XFILLER_5_266 VDD VSS FILLER4
XFILLER_142_429 VDD VSS FILLER4
XFILLER_5_277 VSS VDD FILLER2
XFILLER_108_695 VSS VDD FILLER2
XFILLER_135_470 VDD VSS FILLER1
X_19830_ clkload4/A _19830_/D _19830_/Q VDD VSS DFFQX1
XFILLER_123_654 VSS VDD FILLER2
X_12165_ _20000_/Q _19264_/Q VDD VSS _12236_/B NAND2X1
XFILLER_111_805 VSS VDD FILLER2
XFILLER_122_142 VDD VSS FILLER4
XFILLER_123_676 VSS VDD FILLER2
X_11116_ _11116_/A _11116_/B _11116_/C VDD VSS _11116_/Y OAI21X1
X_19761_ _19934_/CK _19761_/D _19761_/Q VDD VSS DFFQX1
XTAP_TAPCELL_ROW_79_725 VDD VSS WELLTAP
X_16973_ _16973_/A _16973_/B _16973_/C _16973_/D VDD VSS _16977_/B OA211X2
X_12096_ _12113_/A _12113_/B _12113_/D _12113_/C VDD VSS _14465_/B OAOI211X2
XFILLER_122_186 VDD VSS FILLER4
XFILLER_77_730 VSS VDD FILLER2
XFILLER_49_421 VDD VSS FILLER1
XFILLER_77_741 VSS VDD FILLER2
XFILLER_1_494 VSS VDD FILLER2
X_18712_ _18767_/CK _18712_/D _18712_/Q VDD VSS DFFQX1
XFILLER_110_359 VSS VDD FILLER2
X_15924_ _19547_/Q _16692_/A _15924_/C VDD VSS _15939_/A OAI21X1
X_11047_ _11229_/A _11047_/B _11047_/C _11047_/D VDD VSS _11047_/Y OA211X2
XFILLER_39_80 VDD VSS FILLER4
X_19692_ _19695_/CK _19692_/D _19692_/Q VDD VSS DFFQX1
XFILLER_76_240 VSS VDD FILLER2
XFILLER_92_700 VSS VDD FILLER2
XFILLER_77_774 VSS VDD FILLER2
XFILLER_39_91 VSS VDD FILLER2
XFILLER_37_616 VDD VSS FILLER4
XFILLER_37_627 VSS VDD FILLER2
X_18643_ _19949_/CK _18643_/D _18643_/Q VDD VSS DFFQX1
X_15855_ _18196_/A _15855_/B VDD VSS _19466_/D NOR2X1
XFILLER_36_137 VSS VDD FILLER2
X_14806_ _14809_/C _14809_/B VDD VSS _14807_/B NOR2BX1
X_18574_ _18589_/CK _18574_/D _18574_/Q VDD VSS DFFQX1
X_15786_ _15800_/A _15786_/B VDD VSS _19405_/D NOR2X1
XFILLER_33_800 VSS VDD FILLER2
X_12998_ _19022_/Q VDD VSS _13007_/A INVX1
XFILLER_45_671 VSS VDD FILLER2
X_17525_ _17675_/A _17525_/B VDD VSS _19864_/D NOR2X1
X_14737_ _14737_/A _14737_/B _14737_/C _14775_/B VDD VSS _14837_/B OAOI211X1
XTAP_TAPCELL_ROW_34_316 VDD VSS WELLTAP
X_11949_ _18981_/Q _14237_/B VDD VSS _12010_/B NOR2X1
X_17456_ _17838_/A VDD VSS _17509_/C BUFX3
XFILLER_60_663 VSS VDD FILLER2
X_14668_ _19415_/Q VDD VSS _14669_/A INVX1
X_16407_ _16433_/B _16407_/B VDD VSS _16855_/B OR2X2
X_13619_ _19139_/Q _14420_/B VDD VSS _13620_/D _14420_/C NAND3X1
X_17387_ _19835_/Q _19803_/Q _17387_/C VDD VSS _17392_/B AOI21X1
XFILLER_20_549 VSS VDD FILLER2
X_14599_ _19522_/Q _15887_/B VDD VSS _15888_/B XNOR2X1
XTAP_TAPCELL_ROW_42_393 VDD VSS WELLTAP
XFILLER_118_404 VDD VSS FILLER1
X_19126_ _19126_/CK _19126_/D _19126_/Q VDD VSS DFFQX1
X_16338_ _19564_/Q _19916_/Q VDD VSS _16368_/A XNOR2X1
XFILLER_9_561 VDD VSS FILLER4
XFILLER_146_746 VDD VSS FILLER1
XFILLER_145_234 VSS VDD FILLER2
X_19057_ _19086_/CK _19057_/D _19057_/Q VDD VSS DFFQX1
X_16269_ _19689_/Q _16850_/B VDD VSS _16270_/B XNOR2X1
X_18008_ _18528_/Q _18527_/Q VDD VSS _18013_/B XNOR2X1
XFILLER_58_0 VDD VSS FILLER1
XFILLER_160_204 VDD VSS FILLER1
XFILLER_133_429 VSS VDD FILLER2
XFILLER_161_749 VDD VSS FILLER1
XFILLER_114_632 VSS VDD FILLER2
XFILLER_101_304 VSS VDD FILLER2
XFILLER_114_687 VDD VSS FILLER1
XFILLER_87_527 VSS VDD FILLER2
XFILLER_113_175 VSS VDD FILLER2
X_19959_ _19959_/CK _19959_/D _19959_/Q VDD VSS DFFQX1
XFILLER_113_197 VDD VSS FILLER4
X_09712_ _09753_/A _09712_/B VDD VSS _09717_/C NAND2X1
XFILLER_101_359 VDD VSS FILLER4
XFILLER_28_616 VSS VDD FILLER2
XFILLER_68_785 VDD VSS FILLER4
X_09643_ _20167_/A _09811_/B _09815_/C _18316_/Q VDD VSS _09644_/E AOI22X1
XFILLER_27_115 VSS VDD FILLER2
X_09574_ _20163_/A _09811_/B _09770_/C _18312_/Q _09574_/E VDD VSS _09575_/C AOI221X1
XFILLER_55_468 VSS VDD FILLER2
XFILLER_35_38 VDD VSS FILLER4
XFILLER_24_822 VSS VDD FILLER2
XFILLER_63_490 VSS VDD FILLER2
XFILLER_51_641 VSS VDD FILLER2
XFILLER_24_855 VSS VDD FILLER2
XFILLER_51_663 VDD VSS FILLER4
XFILLER_11_516 VDD VSS FILLER1
XTAP_TAPCELL_ROW_159_1448 VDD VSS WELLTAP
XFILLER_50_173 VSS VDD FILLER2
XFILLER_109_415 VSS VDD FILLER2
XFILLER_164_565 VSS VDD FILLER2
XFILLER_136_278 VDD VSS FILLER4
XFILLER_152_727 VSS VDD FILLER2
XFILLER_151_204 VDD VSS FILLER1
XFILLER_136_289 VSS VDD FILLER2
X_10280_ _18685_/Q _18739_/Q VDD VSS _10329_/B XOR2X1
XFILLER_105_621 VDD VSS FILLER1
XFILLER_105_654 VDD VSS FILLER4
XFILLER_104_142 VSS VDD FILLER2
XFILLER_105_676 VDD VSS FILLER1
XFILLER_132_473 VDD VSS DECAPHV8
XFILLER_160_793 VSS VDD FILLER2
XFILLER_120_668 VSS VDD FILLER2
X_13970_ _18978_/Q _13970_/B _14004_/C VDD VSS _14045_/B XNOR3X1
XFILLER_76_56 VDD VSS FILLER4
XFILLER_86_560 VDD VSS FILLER4
XFILLER_74_700 VSS VDD FILLER2
XFILLER_19_605 VDD VSS FILLER1
XFILLER_46_402 VSS VDD FILLER2
XFILLER_18_104 VSS VDD FILLER2
X_12921_ _13021_/A _13021_/B VDD VSS _13091_/B NOR2X1
XFILLER_100_370 VSS VDD FILLER2
XFILLER_18_126 VSS VDD FILLER2
XFILLER_18_137 VSS VDD FILLER2
Xclkbuf_leaf_12_clk_regs clkload1/A VDD VSS clkload3/A BUFX12
X_15640_ _19412_/Q _15793_/B VDD VSS _15641_/C NAND2X1
XTAP_TAPCELL_ROW_125_1138 VDD VSS WELLTAP
XFILLER_132_73 VSS VDD FILLER2
X_12852_ _12955_/A _12955_/B _12955_/C _12955_/D VDD VSS _13054_/B AO31X2
XFILLER_92_22 VSS VDD FILLER2
XTAP_TAPCELL_ROW_84_772 VDD VSS WELLTAP
XFILLER_15_811 VSS VDD FILLER2
XFILLER_92_44 VSS VDD FILLER2
XFILLER_162_0 VDD VSS FILLER4
XFILLER_15_822 VDD VSS FILLER1
X_11803_ _19993_/Q _19257_/Q VDD VSS _11804_/D AND2X1
X_15571_ _19437_/Q _15822_/B VDD VSS _15599_/A NAND2X1
X_12783_ _18964_/Q _12796_/B _14215_/B VDD VSS _14184_/B XNOR3X1
X_17310_ _19819_/Q _19787_/Q VDD VSS _17318_/C NOR2X1
XFILLER_26_192 VSS VDD FILLER2
XFILLER_159_304 VDD VSS FILLER1
X_14522_ _14522_/A VDD VSS _14522_/Y BUFX3
X_11734_ _19198_/Q VDD VSS _11739_/A INVX1
X_18290_ _18295_/CK _18290_/D _18290_/Q VDD VSS DFFQX1
XFILLER_14_365 VSS VDD FILLER2
XFILLER_25_82 VSS VDD FILLER2
XFILLER_14_387 VSS VDD FILLER2
X_17241_ _17390_/A _17241_/B VDD VSS _19804_/D NOR2X1
X_14453_ _14453_/A _14453_/B _17827_/B VDD VSS _19168_/D AOI21X1
X_11665_ _18804_/Q _11669_/B VDD VSS _18831_/D AND2X1
XFILLER_41_184 VSS VDD FILLER2
X_13404_ _18971_/Q VDD VSS _13585_/A INVX1
X_10616_ _10638_/A _10638_/B _10617_/C _10803_/A VDD VSS _10616_/Y AOAI211X1
XFILLER_127_201 VDD VSS FILLER1
X_17172_ _17172_/A VDD VSS _17229_/C BUFX3
X_14384_ _14393_/A _14384_/B VDD VSS _19106_/D NOR2X1
X_11596_ _18741_/Q _11600_/B VDD VSS _18768_/D AND2X1
XFILLER_128_746 VSS VDD FILLER2
X_16123_ _19715_/Q _16879_/B VDD VSS _16124_/B XNOR2X1
X_13335_ _13457_/A _13466_/B VDD VSS _14480_/B XNOR2X1
XTAP_TAPCELL_ROW_136_1234 VDD VSS WELLTAP
X_10547_ _10547_/A VDD VSS _11263_/A BUFX3
XFILLER_143_705 VSS VDD FILLER2
XFILLER_155_565 VSS VDD FILLER2
XFILLER_142_204 VDD VSS FILLER4
XFILLER_108_470 VSS VDD FILLER2
XFILLER_115_429 VSS VDD FILLER2
XFILLER_143_738 VDD VSS FILLER4
X_16054_ _16051_/A _16054_/B _16054_/C VDD VSS _16076_/A AOI2B1X1
X_13266_ _19137_/Q _13266_/B _13354_/C VDD VSS _13322_/C XNOR3X1
X_10478_ _18636_/Q _18798_/Q VDD VSS _10514_/C NOR2X1
X_15005_ _19479_/Q _15871_/B VDD VSS _15054_/A NOR2BX1
X_12217_ _19154_/Q VDD VSS _12307_/A INVX1
XFILLER_44_6 VDD VSS FILLER1
X_13197_ _13097_/B _14256_/C _18994_/Q VDD VSS _13198_/D AND3BX1
X_19813_ _19853_/CK _19813_/D _19813_/Q VDD VSS DFFQX1
XFILLER_97_836 VDD VSS FILLER1
X_12148_ _19124_/Q _14403_/B _14403_/C VDD VSS _12149_/D NOR3BX1
XFILLER_111_635 VSS VDD FILLER2
XFILLER_123_495 VDD VSS FILLER1
X_19744_ _19785_/CK _19744_/D _19744_/Q VDD VSS DFFQX1
X_16956_ _16954_/A _16956_/B VDD VSS _16962_/A NOR2BX1
X_12079_ _12083_/A _12083_/B _12079_/C VDD VSS _14338_/B XNOR3X1
X_15907_ _16776_/A VDD VSS _16100_/A BUFX3
X_19675_ _19724_/CK _19675_/D _19675_/Q VDD VSS DFFQX1
XFILLER_49_284 VDD VSS FILLER1
X_16887_ _16891_/A _16887_/B VDD VSS _19723_/D NOR2X1
XFILLER_65_755 VDD VSS FILLER1
X_18626_ _18628_/CK _18626_/D _18626_/Q VDD VSS DFFQX1
XFILLER_37_457 VSS VDD FILLER2
X_15838_ _15849_/A _15838_/B VDD VSS _19453_/D AND2X1
XFILLER_64_254 VDD VSS FILLER1
XFILLER_37_468 VSS VDD FILLER2
XFILLER_25_608 VSS VDD FILLER2
XFILLER_52_416 VSS VDD FILLER2
X_18557_ _18583_/CK _18557_/D _18557_/Q VDD VSS DFFQX1
X_15769_ _15780_/A _15769_/B VDD VSS _19391_/D NOR2X1
XTAP_TAPCELL_ROW_19_187 VDD VSS WELLTAP
X_17508_ _19861_/Q _19829_/Q VDD VSS _17510_/B XOR2X1
X_09290_ _20057_/Q _20061_/D VDD VSS _09516_/B NAND2X1
X_18488_ _18495_/CK _18525_/Q _20101_/A _18491_/RB VDD VSS DFFRQX1
XFILLER_60_482 VSS VDD FILLER2
XFILLER_21_836 VDD VSS FILLER1
XFILLER_20_313 VSS VDD FILLER2
XANTENNA_14 _14467_/A VDD VSS ANTENNA2
X_17439_ _17439_/A _17439_/B _17439_/C _17439_/D VDD VSS _17440_/C AOAI211X1
XFILLER_119_702 VDD VSS FILLER4
XFILLER_118_212 VSS VDD FILLER2
XFILLER_146_521 VSS VDD FILLER2
X_19109_ _19139_/CK _19109_/D _19109_/Q VDD VSS DFFQX1
XFILLER_9_380 VSS VDD FILLER2
XFILLER_21_29 VSS VDD FILLER2
XFILLER_161_524 VSS VDD FILLER2
Xoutput110 _20194_/Y VDD VSS o_tst_ctrl[13] BUFX3
Xoutput121 _20190_/Y VDD VSS o_tst_ctrl[9] BUFX3
Xoutput132 _20216_/Y VDD VSS o_uwb_tx_cfg[19] BUFX3
XFILLER_161_557 VDD VSS FILLER1
Xoutput143 _20226_/Y VDD VSS o_uwb_tx_cfg[29] BUFX3
XTAP_TAPCELL_ROW_113_1031 VDD VSS WELLTAP
XFILLER_102_602 VSS VDD FILLER2
XFILLER_0_729 VSS VDD FILLER2
XFILLER_114_473 VDD VSS DECAPHV8
XFILLER_88_836 VSS VDD FILLER2
XFILLER_142_793 VSS VDD FILLER2
XFILLER_99_195 VSS VDD FILLER2
XFILLER_87_357 VDD VSS FILLER4
XFILLER_75_519 VDD VSS FILLER4
XFILLER_56_700 VSS VDD FILLER2
XTAP_TAPCELL_ROW_98_897 VDD VSS WELLTAP
XFILLER_101_189 VDD VSS FILLER4
XFILLER_68_593 VSS VDD FILLER2
XFILLER_46_59 VDD VSS FILLER1
XFILLER_28_457 VDD VSS FILLER1
X_09626_ _20120_/A _09626_/B _09626_/C VDD VSS _09627_/C AOI2B1X1
XTAP_TAPCELL_ROW_165_1496 VDD VSS WELLTAP
XFILLER_56_788 VSS VDD FILLER2
XFILLER_83_574 VSS VDD FILLER2
XFILLER_71_736 VDD VSS FILLER1
X_09557_ _18505_/Q _09630_/C _18506_/Q VDD VSS _09785_/B NOR3BX1
XFILLER_71_747 VSS VDD FILLER2
XFILLER_102_54 VSS VDD FILLER2
XFILLER_70_235 VSS VDD FILLER2
XFILLER_36_490 VSS VDD FILLER2
XTAP_TAPCELL_ROW_81_742 VDD VSS WELLTAP
X_09488_ _19982_/Q _09490_/B _09507_/B VDD VSS _09489_/C AOI21X1
XFILLER_70_279 VDD VSS FILLER4
XFILLER_62_58 VSS VDD FILLER2
XFILLER_23_162 VSS VDD FILLER2
XTAP_TAPCELL_ROW_53_488 VDD VSS WELLTAP
XFILLER_24_696 VDD VSS FILLER1
XFILLER_23_184 VSS VDD FILLER2
X_11450_ _16860_/A VDD VSS _11460_/B BUFX3
XFILLER_149_370 VSS VDD FILLER2
XFILLER_109_212 VSS VDD FILLER2
XFILLER_11_379 VSS VDD FILLER2
XFILLER_137_532 VSS VDD FILLER2
X_10401_ _18633_/Q _18795_/Q VDD VSS _10402_/D AND2X1
X_11381_ _11381_/A _11381_/B _11381_/C VDD VSS _11384_/C OA21X2
XFILLER_109_256 VDD VSS FILLER4
XFILLER_164_362 VSS VDD FILLER2
XFILLER_125_727 VDD VSS DECAPHV8
X_13120_ _19136_/Q VDD VSS _13230_/A INVX1
X_10332_ _18631_/Q _18793_/Q VDD VSS _10372_/B XOR2X1
XFILLER_3_512 VSS VDD FILLER2
XFILLER_152_535 VSS VDD FILLER2
XFILLER_152_557 VDD VSS FILLER4
Xclkbuf_leaf_6__000_ clkbuf_leaf_6__000_/A VDD VSS _19736_/CK BUFX12
X_13051_ _13133_/A _13133_/C _13133_/B _13129_/D VDD VSS _13240_/A AOI31X1
X_10263_ _11208_/D _10263_/B _10263_/C _10383_/A _10263_/E VDD VSS _10264_/B AOI221X1
XFILLER_79_803 VSS VDD FILLER2
XFILLER_3_556 VSS VDD FILLER2
XFILLER_87_22 VSS VDD FILLER2
XFILLER_3_578 VDD VSS FILLER4
X_12002_ _12026_/B _12026_/C VDD VSS _14401_/B NAND2X1
XFILLER_132_270 VSS VDD FILLER2
XFILLER_120_421 VSS VDD FILLER2
X_10194_ _10200_/D _10200_/B VDD VSS _10195_/B NOR2BX1
XFILLER_120_432 VDD VSS DECAPHV8
X_16810_ _16811_/A _16810_/B VDD VSS _19653_/D NOR2X1
XFILLER_78_357 VSS VDD FILLER2
X_17790_ _17793_/A _17790_/B _17790_/C VDD VSS _19921_/D AOI21X1
XFILLER_47_711 VDD VSS FILLER1
XFILLER_120_487 VSS VDD FILLER2
X_16741_ _16748_/A _16741_/B VDD VSS _19591_/D NOR2X1
X_13953_ _19005_/Q wire153/Y _13958_/B VDD VSS _13955_/C XOR3X1
XFILLER_47_733 VDD VSS FILLER1
XFILLER_101_690 VSS VDD FILLER2
X_19460_ _19460_/CK _19460_/D _19460_/Q VDD VSS DFFQX1
X_12904_ _13005_/A _13005_/B VDD VSS _14287_/B _13005_/C AND3X2
XFILLER_74_552 VDD VSS FILLER1
XFILLER_46_243 VSS VDD FILLER2
XFILLER_19_468 VDD VSS FILLER4
X_16672_ _19672_/Q _16672_/B _16831_/B VDD VSS _16685_/A MIN3X1
X_13884_ _13990_/A _14166_/B _13884_/C VDD VSS _14167_/C OAI21X1
XFILLER_19_479 VSS VDD FILLER2
XFILLER_46_276 VDD VSS FILLER4
XFILLER_34_416 VSS VDD FILLER2
X_18411_ _18423_/CK _18512_/Q _20166_/A _09380_/B VDD VSS DFFRQX1
XFILLER_74_596 VDD VSS FILLER1
X_15623_ _19412_/Q _15793_/B VDD VSS _15641_/A XNOR2X1
X_19391_ _19466_/CK _19391_/D _19391_/Q VDD VSS DFFQX1
X_12835_ _12835_/A _14506_/B _12835_/C _12835_/D VDD VSS _12841_/B OAI211X1
XTAP_TAPCELL_ROW_44_411 VDD VSS WELLTAP
X_18342_ _18343_/CK _18342_/D _18342_/Q _18374_/RB VDD VSS DFFRQX1
XTAP_TAPCELL_ROW_7_74 VDD VSS WELLTAP
X_15554_ _19409_/Q _15790_/B VDD VSS _15569_/B XNOR2X1
XTAP_TAPCELL_ROW_142_1293 VDD VSS WELLTAP
X_12766_ _12967_/C _12966_/B _12966_/C VDD VSS _12951_/B XNOR3X1
XTAP_TAPCELL_ROW_16_157 VDD VSS WELLTAP
X_14505_ _14539_/A _14505_/B VDD VSS _19213_/D NOR2X1
XFILLER_30_622 VSS VDD FILLER2
XFILLER_15_696 VSS VDD FILLER2
X_18273_ _18275_/CK _18273_/D _18273_/Q _20080_/RB VDD VSS DFFRQX1
X_11717_ _19990_/Q _19254_/Q VDD VSS _11742_/C XNOR2X1
XFILLER_14_195 VDD VSS FILLER1
X_15485_ _15509_/B _15485_/B VDD VSS _15788_/B XNOR2X1
X_12697_ _18907_/Q _12789_/B _12789_/C VDD VSS _12703_/C XNOR3X1
X_17224_ _17227_/A _17227_/B _17229_/C VDD VSS _17225_/C OAI21X1
XFILLER_30_666 VDD VSS FILLER4
XFILLER_128_510 VDD VSS FILLER1
X_14436_ _14449_/A _14436_/B _14436_/C VDD VSS _19153_/D NOR3X1
X_11648_ _11648_/A VDD VSS _11658_/B BUFX3
XFILLER_159_189 VDD VSS FILLER4
XTAP_TAPCELL_ROW_0_7 VDD VSS WELLTAP
XFILLER_128_543 VSS VDD FILLER2
XFILLER_7_840 VSS VDD FILLER2
X_17155_ _19786_/Q _19754_/Q VDD VSS _17160_/A XNOR2X1
XFILLER_7_851 VSS VDD FILLER2
X_14367_ _14368_/A _14367_/B VDD VSS _19091_/D NOR2X1
X_11579_ _11648_/A VDD VSS _11589_/B BUFX3
X_16106_ _16106_/A _16106_/B _16106_/C VDD VSS _16120_/A AOI21X1
X_13318_ _19136_/Q _13430_/B VDD VSS _13319_/D _13318_/C NAND3X1
X_17086_ _17536_/A _17086_/B _17087_/C VDD VSS _19771_/D NOR3X1
X_14298_ _14352_/A _14298_/B _14298_/C VDD VSS _19030_/D NOR3X1
XFILLER_143_557 VDD VSS FILLER1
XFILLER_115_259 VDD VSS FILLER1
X_16037_ _19903_/Q VDD VSS _16696_/A INVX1
X_13249_ _13254_/A _14478_/B _13329_/D _13254_/C VDD VSS _14479_/B OAI211X1
XFILLER_130_218 VDD VSS FILLER4
XFILLER_124_793 VSS VDD FILLER2
XFILLER_151_590 VSS VDD FILLER2
XFILLER_69_346 VSS VDD FILLER2
X_17988_ _17982_/B _18872_/Q VDD VSS _17989_/C NAND2BX1
XFILLER_84_305 VSS VDD FILLER2
XFILLER_57_519 VSS VDD FILLER2
XFILLER_38_700 VSS VDD FILLER2
X_19727_ _19730_/CK _19727_/D _19727_/Q VDD VSS DFFQX1
X_16939_ _16943_/C _16939_/B VDD VSS _16940_/B XNOR2X1
XTAP_TAPCELL_ROW_95_867 VDD VSS WELLTAP
XFILLER_65_541 VSS VDD FILLER2
X_19658_ _19695_/CK _19658_/D _19658_/Q VDD VSS DFFQX1
XFILLER_38_788 VSS VDD FILLER2
X_09411_ _09496_/B _09496_/C VDD VSS _09507_/C NOR2X1
X_18609_ _18622_/CK _18609_/D _18609_/Q VDD VSS DFFQX1
XTAP_TAPCELL_ROW_107_979 VDD VSS WELLTAP
XFILLER_53_747 VSS VDD FILLER2
X_19589_ _19664_/CK _19589_/D _19589_/Q VDD VSS DFFQX1
XFILLER_80_544 VDD VSS FILLER1
XFILLER_52_235 VSS VDD FILLER2
XFILLER_53_769 VDD VSS FILLER1
X_09342_ _18443_/D _09341_/Y _09302_/A VDD VSS _18512_/D MUXI2X1
X_09273_ _09273_/A _09273_/B _09273_/C VDD VSS _18277_/D OAI21X1
XFILLER_33_493 VSS VDD FILLER2
XFILLER_32_17 VDD VSS DECAPHV16
XTAP_TAPCELL_ROW_156_1418 VDD VSS WELLTAP
XFILLER_148_39 VSS VDD FILLER2
XFILLER_147_852 VDD VSS FILLER4
XFILLER_107_727 VSS VDD FILLER2
XFILLER_106_215 VSS VDD FILLER2
XFILLER_162_833 VDD VSS FILLER4
XFILLER_161_310 VSS VDD FILLER2
XFILLER_106_259 VDD VSS FILLER4
XFILLER_122_719 VDD VSS DECAPHV16
XFILLER_0_504 VSS VDD FILLER2
XFILLER_164_49 VSS VDD FILLER2
XFILLER_161_398 VDD VSS FILLER4
XFILLER_88_633 VSS VDD FILLER2
XFILLER_102_421 VSS VDD FILLER2
XFILLER_114_281 VSS VDD FILLER2
XFILLER_57_14 VDD VSS FILLER1
XFILLER_102_476 VDD VSS FILLER4
XFILLER_57_47 VDD VSS FILLER4
XFILLER_87_198 VDD VSS FILLER1
XFILLER_29_733 VDD VSS FILLER1
XTAP_TAPCELL_ROW_58_536 VDD VSS WELLTAP
XFILLER_56_541 VDD VSS FILLER4
X_10950_ _10661_/B _11213_/B _11120_/A VDD VSS _10958_/B MUXI2X1
XFILLER_71_500 VSS VDD FILLER2
XFILLER_16_416 VSS VDD FILLER2
XFILLER_56_596 VSS VDD FILLER2
X_09609_ _18346_/Q _09772_/B _09609_/C _09609_/D VDD VSS _09612_/C OAI211X1
XTAP_TAPCELL_ROW_122_1108 VDD VSS WELLTAP
X_10881_ _10960_/A _10881_/B _10881_/C VDD VSS _10921_/B OAI21X1
XFILLER_73_57 VSS VDD FILLER2
X_12620_ _12632_/A _12632_/B _12632_/C VDD VSS _14284_/B OAI21X1
XFILLER_12_611 VDD VSS FILLER1
X_12551_ _19129_/Q VDD VSS _12593_/D INVX1
XTAP_TAPCELL_ROW_13_127 VDD VSS WELLTAP
XFILLER_24_493 VSS VDD FILLER2
XFILLER_157_616 VDD VSS DECAPHV8
XFILLER_129_318 VDD VSS DECAPHV16
X_11502_ _18656_/Q _11508_/B VDD VSS _18683_/D AND2X1
XFILLER_156_104 VSS VDD FILLER2
X_15270_ _19538_/Q _19539_/Q VDD VSS _15313_/B _15270_/C NAND3X1
X_12482_ _19184_/Q _14471_/B VDD VSS _14440_/A AND2X1
XFILLER_7_103 VDD VSS FILLER4
XFILLER_157_649 VSS VDD FILLER2
XFILLER_8_637 VDD VSS DECAPHV8
XFILLER_125_0 VSS VDD FILLER2
X_14221_ _14221_/A _14221_/B _14221_/C VDD VSS _14222_/C NOR3X1
X_11433_ _11435_/A _11433_/B VDD VSS _11434_/B XOR2X1
XFILLER_22_61 VSS VDD FILLER2
X_14152_ _14154_/A _14152_/B VDD VSS _18908_/D NOR2X1
X_11364_ _11364_/A _11364_/B _11364_/C _11364_/D VDD VSS _11365_/B AO31X2
XFILLER_138_83 VSS VDD FILLER2
XFILLER_153_855 VSS VDD FILLER2
XFILLER_152_343 VSS VDD FILLER2
X_13103_ _19107_/Q VDD VSS _13211_/A INVX1
X_10315_ _10315_/A _10315_/B VDD VSS _10512_/A _10315_/C _10315_/D OR4X1
XFILLER_113_719 VSS VDD FILLER2
X_18960_ _18961_/CK _18960_/D _18960_/Q VDD VSS DFFQX1
X_14083_ _18926_/Q _14174_/A _14174_/B VDD VSS _14104_/A NOR3X1
XFILLER_152_365 VSS VDD FILLER2
X_11295_ _11296_/B _11295_/B _11295_/C _11378_/A VDD VSS _18583_/D AOI211X1
XFILLER_140_527 VDD VSS DECAPHV8
X_17911_ _18859_/Q _17911_/B _17911_/C VDD VSS _17914_/C MIN3X1
X_13034_ _14510_/B _14510_/C _19217_/Q VDD VSS _13036_/C AOI21X1
XFILLER_98_98 VSS VDD FILLER2
XFILLER_3_375 VSS VDD FILLER2
XFILLER_106_793 VDD VSS FILLER4
X_10246_ _18623_/Q _18624_/Q VDD VSS _10266_/D NOR2X1
XFILLER_3_386 VDD VSS FILLER1
XFILLER_140_549 VDD VSS FILLER4
X_18891_ _18973_/CK _18891_/D _18891_/Q VDD VSS DFFQX1
XFILLER_79_644 VDD VSS FILLER4
X_17842_ _19935_/Q _19936_/Q _17842_/C _17842_/D VDD VSS _19936_/D AOI31X1
XFILLER_94_603 VDD VSS FILLER1
XFILLER_67_817 VSS VDD FILLER2
X_10177_ _18615_/Q _10177_/B VDD VSS _10184_/B NAND2X1
XFILLER_66_305 VDD VSS FILLER4
XFILLER_93_102 VSS VDD FILLER2
X_17773_ _19917_/Q _19885_/Q _17773_/C VDD VSS _17776_/C MIN3X1
X_14985_ _14991_/B _14985_/B VDD VSS _15682_/B XNOR2X1
XFILLER_94_669 VSS VDD FILLER2
X_19512_ _19734_/CK _19512_/D _19512_/Q VDD VSS DFFQX1
XTAP_TAPCELL_ROW_144_1311 VDD VSS WELLTAP
X_16724_ _16724_/A _16724_/B VDD VSS _19575_/D NOR2X1
XFILLER_93_168 VDD VSS FILLER4
X_13936_ _18949_/Q _13936_/B _13957_/C VDD VSS _13949_/A XNOR3X1
XFILLER_93_179 VSS VDD FILLER2
XTAP_TAPCELL_ROW_92_837 VDD VSS WELLTAP
XFILLER_35_736 VDD VSS DECAPHV8
X_19443_ _19508_/CK _19443_/D _19443_/Q VDD VSS DFFQX1
XFILLER_90_831 VDD VSS FILLER1
XFILLER_62_522 VDD VSS FILLER4
XFILLER_35_747 VSS VDD FILLER2
X_16655_ _19608_/Q _16759_/B VDD VSS _16657_/C XNOR2X1
XTAP_TAPCELL_ROW_29_271 VDD VSS WELLTAP
XFILLER_62_533 VSS VDD FILLER2
XFILLER_19_298 VSS VDD FILLER2
X_13867_ _18892_/Q _13981_/A _13981_/B VDD VSS _13868_/D XNOR3X1
XFILLER_34_235 VSS VDD FILLER2
XTAP_TAPCELL_ROW_104_949 VDD VSS WELLTAP
X_15606_ _19383_/Q _15761_/B VDD VSS _15620_/C XOR2X1
XFILLER_50_717 VSS VDD FILLER2
X_19374_ _19573_/CK _19374_/D _19374_/Q VDD VSS DFFQX1
X_12818_ _12819_/A _12819_/B _12819_/D _12819_/C VDD VSS _12939_/B OAOI211X1
X_16586_ _16620_/B _16586_/B VDD VSS _16898_/B NAND2X1
XFILLER_62_588 VDD VSS FILLER4
X_13798_ _19003_/Q _13833_/B _13889_/D VDD VSS _13845_/C XNOR3X1
XFILLER_50_739 VDD VSS FILLER4
XFILLER_43_780 VSS VDD FILLER2
X_18325_ _18325_/CK _18501_/D _18325_/Q _18442_/RB VDD VSS DFFRQX1
X_15537_ _19325_/Q VDD VSS _15563_/A INVX1
XFILLER_15_493 VDD VSS FILLER4
X_12749_ _19160_/Q VDD VSS _12936_/A INVX1
X_18256_ _18256_/CK _18256_/D _18261_/D _18486_/RB VDD VSS DFFRQX1
X_15468_ _15468_/A VDD VSS _15850_/B INVX1
X_17207_ _19796_/Q VDD VSS _17357_/B INVX1
X_14419_ _14467_/A _14419_/B VDD VSS _19138_/D AND2X1
X_18187_ _18191_/C _18188_/B _18187_/C VDD VSS _18188_/C OAI21X1
XFILLER_156_660 VSS VDD FILLER2
X_15399_ _19541_/Q _19542_/Q VDD VSS _15439_/B _15399_/C NAND3X1
X_17138_ _19782_/Q _19750_/Q VDD VSS _17140_/D XNOR2X1
XFILLER_128_395 VSS VDD FILLER2
XFILLER_155_170 VSS VDD FILLER2
XFILLER_116_568 VSS VDD FILLER2
XFILLER_89_408 VDD VSS FILLER4
XFILLER_104_719 VSS VDD FILLER2
XFILLER_131_505 VSS VDD FILLER2
XFILLER_143_365 VDD VSS FILLER1
X_17069_ _19767_/Q _17073_/B VDD VSS _17070_/B XOR2X1
XFILLER_40_0 VDD VSS FILLER1
XTAP_TAPCELL_ROW_110_1001 VDD VSS WELLTAP
X_20080_ _20080_/CK _20080_/D _20080_/Q _20080_/RB VDD VSS DFFRQX1
X_09891_ _18560_/Q _09941_/C VDD VSS _09892_/B NAND2X1
XFILLER_58_806 VSS VDD FILLER2
XFILLER_58_817 VDD VSS FILLER1
XFILLER_97_463 VSS VDD FILLER2
XFILLER_69_154 VDD VSS FILLER1
XFILLER_57_305 VSS VDD FILLER2
XFILLER_69_176 VDD VSS FILLER1
XFILLER_57_316 VDD VSS FILLER1
XFILLER_111_273 VDD VSS FILLER4
XFILLER_85_669 VSS VDD FILLER2
XFILLER_84_146 VSS VDD FILLER2
XFILLER_27_17 VSS VDD FILLER2
XFILLER_27_28 VSS VDD FILLER2
XFILLER_38_552 VDD VSS FILLER4
XTAP_TAPCELL_ROW_55_506 VDD VSS WELLTAP
XFILLER_65_371 VDD VSS FILLER1
XFILLER_53_511 VSS VDD FILLER2
XFILLER_81_842 VDD VSS FILLER1
XFILLER_53_544 VDD VSS FILLER4
XFILLER_41_717 VSS VDD FILLER2
Xclkbuf_leaf_5__001_ clkload32/A VDD VSS _19196_/CK BUFX12
XFILLER_40_216 VSS VDD FILLER2
XFILLER_34_780 VSS VDD FILLER2
X_09325_ _18469_/RB _09346_/B VDD VSS _09325_/Y NOR2BX1
XTAP_TAPCELL_ROW_63_583 VDD VSS WELLTAP
XFILLER_80_396 VSS VDD FILLER2
XFILLER_139_605 VSS VDD FILLER2
XFILLER_33_290 VSS VDD FILLER2
X_09256_ _18258_/Q _20046_/Q VDD VSS _09277_/A _09256_/C NAND3X1
XFILLER_21_463 VSS VDD FILLER2
XFILLER_138_137 VSS VDD FILLER2
XFILLER_21_485 VSS VDD FILLER2
X_09187_ _18510_/Q VDD VSS _18457_/D INVX1
XFILLER_147_671 VSS VDD FILLER2
XFILLER_135_844 VDD VSS FILLER1
XFILLER_146_170 VDD VSS FILLER4
XTAP_TAPCELL_ROW_119_1081 VDD VSS WELLTAP
XFILLER_161_140 VDD VSS FILLER1
XFILLER_1_802 VSS VDD FILLER2
XFILLER_162_685 VSS VDD FILLER2
X_10100_ _10180_/A _11414_/C VDD VSS _18536_/D NOR2X1
XFILLER_1_824 VSS VDD FILLER2
XFILLER_68_24 VDD VSS DECAPHV8
X_11080_ _11015_/Y _11079_/Y _10947_/Y VDD VSS _11080_/Y MUX2X1
XFILLER_1_835 VSS VDD FILLER2
XFILLER_161_184 VSS VDD FILLER2
XFILLER_0_323 VSS VDD FILLER2
XFILLER_49_806 VDD VSS FILLER4
X_10031_ _10014_/Y _10029_/Y _10127_/A VDD VSS _10031_/Y MUX2X1
XFILLER_76_603 VDD VSS FILLER1
XFILLER_0_367 VDD VSS FILLER1
XFILLER_130_571 VSS VDD FILLER2
XFILLER_48_349 VSS VDD FILLER2
XFILLER_84_23 VDD VSS FILLER1
X_14770_ _19334_/Q _14770_/B _15706_/B VDD VSS _14850_/B MIN3X1
XFILLER_63_319 VDD VSS FILLER1
X_11982_ _19997_/Q _19261_/Q VDD VSS _12055_/A XNOR2X1
XFILLER_84_67 VDD VSS FILLER4
XFILLER_29_596 VSS VDD FILLER2
X_13721_ _13721_/A _13721_/B _14423_/B _19141_/Q _13721_/E VDD VSS _13791_/C AOI221X1
XFILLER_90_138 VDD VSS FILLER1
XFILLER_17_747 VSS VDD FILLER2
X_10933_ _18675_/Q _18783_/Q VDD VSS _10937_/A XNOR2X1
XFILLER_44_544 VDD VSS FILLER4
XFILLER_16_235 VSS VDD FILLER2
XFILLER_140_51 VDD VSS FILLER1
X_16440_ _16442_/B _16441_/B _18168_/C VDD VSS _16441_/C OAI21X1
XFILLER_32_717 VDD VSS FILLER4
Xclkbuf_leaf_24__000_ clkload70/A VDD VSS _19306_/CK BUFX12
X_13652_ _19001_/Q _13652_/B _13692_/C VDD VSS _13830_/B XNOR3X1
X_10864_ _18645_/Q _18807_/Q VDD VSS _10866_/C NAND2X1
XTAP_TAPCELL_ROW_101_919 VDD VSS WELLTAP
X_12603_ _12693_/A _12693_/B _14250_/B VDD VSS _14213_/B XNOR3X1
X_16371_ _16395_/C _16371_/B VDD VSS _16747_/B XNOR2X1
X_13583_ _18888_/Q _14129_/B VDD VSS _13660_/C _14129_/C NAND3X1
X_10795_ _11229_/D _10795_/B VDD VSS _10804_/D NOR2X1
XFILLER_12_441 VSS VDD FILLER2
XFILLER_129_104 VSS VDD FILLER2
X_18110_ _18110_/A _18112_/B VDD VSS _18111_/B XOR2X1
XFILLER_157_413 VDD VSS FILLER1
X_15322_ _15351_/A _15322_/B VDD VSS _15815_/B XNOR2X1
X_19090_ _19119_/CK _19090_/D _19090_/Q VDD VSS DFFQX1
X_12534_ _18933_/Q _12534_/B _14181_/B VDD VSS _12617_/B MIN3X1
XFILLER_8_412 VDD VSS FILLER4
XFILLER_129_137 VSS VDD FILLER2
XTAP_TAPCELL_ROW_4_53 VDD VSS WELLTAP
X_18041_ _18056_/A _18041_/B _18056_/C VDD VSS _19978_/D OAI21X1
XFILLER_157_468 VSS VDD FILLER2
X_15253_ _19345_/Q _15719_/B VDD VSS _15254_/B XOR2X1
XFILLER_149_82 VSS VDD FILLER2
X_12465_ _12558_/A _14345_/B VDD VSS _12625_/B NOR2X1
XFILLER_126_811 VDD VSS DECAPHV16
X_14204_ _14218_/A _14204_/B VDD VSS _18953_/D NOR2X1
XFILLER_137_170 VSS VDD FILLER2
X_11416_ _18538_/D _11428_/B VDD VSS _18610_/D NOR2BX1
XFILLER_125_321 VDD VSS FILLER1
X_15184_ _19483_/Q _15875_/B VDD VSS _15185_/D _15875_/C AND3X2
X_12396_ _12396_/A _12396_/B _12396_/C VDD VSS _12402_/A NOR3X1
XFILLER_153_630 VSS VDD FILLER2
X_14135_ _14163_/A _14135_/B _14135_/C VDD VSS _18893_/D NOR3X1
X_11347_ _11352_/A _11347_/B VDD VSS _11348_/B XNOR2X1
XFILLER_152_151 VDD VSS DECAPHV8
X_19992_ _19996_/CK _19992_/D _19992_/Q VDD VSS DFFQX1
XFILLER_153_674 VSS VDD FILLER2
XFILLER_141_825 VDD VSS FILLER4
XFILLER_113_538 VSS VDD FILLER2
XFILLER_152_173 VDD VSS DECAPHV8
XFILLER_98_227 VDD VSS FILLER4
XFILLER_4_695 VSS VDD FILLER2
X_18943_ _18999_/CK _18943_/D _18943_/Q VDD VSS DFFQX1
X_14066_ _18953_/Q _14204_/B VDD VSS _14086_/D XNOR2X1
X_11278_ _11298_/A _11278_/B _11298_/C VDD VSS _11364_/C OA21X2
X_13017_ _13017_/A _13017_/B _13017_/C _13017_/D VDD VSS _14352_/B OAOI211X1
X_10229_ _10229_/A _10229_/B _10229_/C VDD VSS _10234_/A OAI21X1
X_18874_ _18905_/CK _18874_/D _18874_/Q VDD VSS DFFQX1
XFILLER_79_463 VSS VDD FILLER2
XFILLER_121_582 VSS VDD FILLER2
XFILLER_79_496 VDD VSS FILLER4
X_17825_ _17826_/A _17826_/B _17828_/C VDD VSS _17826_/C OAI21X1
XFILLER_39_338 VSS VDD FILLER2
XFILLER_67_658 VDD VSS FILLER1
XFILLER_66_157 VDD VSS FILLER1
X_17756_ _17758_/A _17758_/B _17756_/C VDD VSS _19914_/D AOI21X1
X_14968_ _19533_/Q _14970_/B VDD VSS _15018_/B XNOR2X1
XFILLER_35_500 VDD VSS FILLER4
X_16707_ _17748_/A _16724_/B VDD VSS _19560_/D NOR2X1
X_13919_ _13827_/A _14230_/B _14230_/C VDD VSS _13987_/D AND3BX1
X_17687_ _18132_/A _17687_/B _17688_/C VDD VSS _19899_/D NOR3X1
XFILLER_62_330 VDD VSS FILLER1
X_14899_ _19309_/Q _15680_/B _14899_/C VDD VSS _14951_/B MIN3X1
XFILLER_35_555 VSS VDD FILLER2
X_19426_ _19463_/CK _19426_/D _19426_/Q VDD VSS DFFQX1
X_16638_ _16645_/B _16638_/B VDD VSS _16900_/B XOR2X1
XFILLER_62_363 VSS VDD FILLER2
XFILLER_90_683 VDD VSS FILLER4
XFILLER_50_514 VSS VDD FILLER2
X_19357_ _19385_/CK _19357_/D _19357_/Q VDD VSS DFFQX1
X_16569_ _16558_/A _16569_/B _16569_/C VDD VSS _16582_/A AOI2B1X1
XFILLER_15_290 VSS VDD FILLER2
XTAP_TAPCELL_ROW_60_553 VDD VSS WELLTAP
X_18308_ _18309_/CK _18521_/Q _18308_/Q _20078_/RB VDD VSS DFFRQX1
XFILLER_88_0 VDD VSS FILLER4
X_19288_ _19306_/CK _19288_/D _19288_/Q VDD VSS DFFQX1
XFILLER_148_446 VSS VDD FILLER2
XTAP_TAPCELL_ROW_32_299 VDD VSS WELLTAP
X_18239_ _18240_/CK _18239_/D _18239_/Q _20080_/RB VDD VSS DFFRQX1
XFILLER_129_660 VDD VSS FILLER4
XFILLER_135_118 VDD VSS DECAPHV8
XFILLER_117_844 VDD VSS FILLER1
XFILLER_117_855 VSS VDD FILLER2
X_20201_ _20201_/A VDD VSS _20201_/Y BUFX3
XFILLER_116_354 VDD VSS FILLER4
XFILLER_144_663 VDD VSS FILLER4
XFILLER_144_696 VDD VSS FILLER1
Xmax_cap175 _09785_/B VDD VSS _09813_/B BUFX4
XFILLER_143_184 VSS VDD FILLER2
Xmax_cap186 _18520_/Q VDD VSS _18499_/D BUFX8
X_20132_ _20132_/A VDD VSS _20132_/Y BUFX3
X_09943_ _18563_/Q _11178_/C _09942_/Y VDD VSS _09945_/B AOI21BX1
XFILLER_131_379 VSS VDD FILLER2
X_20063_ clkload6/A _20195_/A _20065_/D _20065_/RB VDD VSS DFFRQX1
XFILLER_100_700 VSS VDD FILLER2
X_09874_ _09885_/A _09874_/B VDD VSS _10017_/C NOR2X1
XFILLER_38_27 VSS VDD FILLER2
XFILLER_100_722 VSS VDD FILLER2
XFILLER_97_282 VSS VDD FILLER2
XFILLER_57_113 VDD VSS FILLER4
XFILLER_38_49 VDD VSS FILLER4
XFILLER_85_433 VSS VDD FILLER2
XFILLER_100_788 VSS VDD FILLER2
XFILLER_57_168 VSS VDD FILLER2
XFILLER_72_105 VSS VDD FILLER2
XFILLER_45_319 VDD VSS FILLER1
XFILLER_81_683 VDD VSS DECAPHV8
XFILLER_26_599 VDD VSS FILLER4
XFILLER_13_227 VSS VDD FILLER2
XFILLER_41_536 VDD VSS FILLER4
XTAP_TAPCELL_ROW_23_222 VDD VSS WELLTAP
X_09308_ _18294_/Q _18501_/D _09299_/Y VDD VSS _09308_/Y MUXI2X1
X_10580_ _10945_/A _10656_/B _10656_/C _11255_/A VDD VSS _10737_/B AOI211X1
XFILLER_70_36 VSS VDD FILLER2
XFILLER_22_783 VSS VDD FILLER2
XFILLER_21_282 VDD VSS FILLER4
XFILLER_139_468 VSS VDD FILLER2
X_09239_ _18511_/Q VDD VSS _18346_/D INVX1
XFILLER_154_416 VSS VDD FILLER2
XFILLER_166_287 VSS VDD FILLER2
XFILLER_108_833 VSS VDD FILLER2
XFILLER_119_41 VDD VSS FILLER4
X_12250_ wire159/Y _12298_/B _12298_/D VDD VSS _12258_/C OAI21X1
XFILLER_79_12 VSS VDD FILLER2
X_11201_ _18710_/Q _18764_/Q VDD VSS _11202_/B XOR2X1
XFILLER_119_96 VSS VDD FILLER2
X_12181_ wire160/A _12181_/B _14435_/B _12181_/D _12181_/E VDD VSS _12372_/C OAI221X1
XFILLER_134_151 VDD VSS FILLER4
XFILLER_123_825 VSS VDD FILLER2
XFILLER_135_685 VSS VDD FILLER2
XFILLER_162_471 VDD VSS FILLER1
XFILLER_123_836 VDD VSS FILLER1
XFILLER_122_324 VDD VSS FILLER1
XFILLER_150_633 VSS VDD FILLER2
X_11132_ _11132_/A _11132_/B _11132_/C _11132_/D VDD VSS _11163_/C AOI211X1
XFILLER_79_78 VDD VSS DECAPHV8
XFILLER_1_610 VSS VDD FILLER2
XFILLER_134_184 VSS VDD FILLER2
XFILLER_1_632 VSS VDD FILLER2
XFILLER_1_643 VDD VSS FILLER1
XFILLER_1_654 VDD VSS FILLER4
X_15940_ _19548_/Q _16693_/A _15940_/C VDD VSS _15963_/C OAI21X1
X_11063_ _11064_/A _11064_/B VDD VSS _11102_/C AND2X1
XFILLER_135_73 VDD VSS FILLER4
X_10014_ _18580_/Q _10042_/C VDD VSS _10014_/Y XNOR2X1
X_15871_ _15895_/A _15871_/B VDD VSS _19479_/D NOR2X1
XFILLER_48_146 VDD VSS FILLER1
X_17610_ _17610_/A _17610_/B _17610_/C VDD VSS _17618_/A OA21X2
X_14822_ _14872_/A _14872_/B _14872_/C VDD VSS _14824_/B AOI21X1
X_18590_ _18595_/CK _18590_/D _18590_/Q VDD VSS DFFQX1
XFILLER_64_628 VDD VSS FILLER1
XTAP_TAPCELL_ROW_128_1169 VDD VSS WELLTAP
XFILLER_17_522 VSS VDD FILLER2
X_17541_ _17539_/B _17541_/B VDD VSS _17542_/C NOR2BX1
X_14753_ _14837_/A _14837_/B _14837_/C VDD VSS _15831_/C NOR3X1
X_11965_ _19148_/Q _11973_/A _14431_/B VDD VSS _14399_/B XNOR3X1
X_13704_ _13783_/A _14297_/B VDD VSS _13766_/B NOR2X1
XTAP_TAPCELL_ROW_74_678 VDD VSS WELLTAP
XFILLER_17_577 VSS VDD FILLER2
X_17472_ _17475_/C _17473_/B _17509_/C VDD VSS _17473_/C OAI21X1
X_10916_ _18568_/Q _10917_/B VDD VSS _10954_/B OR2X2
X_14684_ _19472_/Q _15863_/B VDD VSS _14737_/B XNOR2X1
XFILLER_32_514 VDD VSS DECAPHV8
X_11896_ _19148_/Q _11973_/A _14431_/B VDD VSS _11961_/B XOR3X1
X_19211_ _19269_/CK _19211_/D _19211_/Q VDD VSS DFFQX1
X_16423_ _19567_/Q _19919_/Q VDD VSS _16424_/B XOR2X1
XFILLER_60_856 VDD VSS FILLER1
XFILLER_32_547 VSS VDD FILLER2
X_13635_ _19169_/Q _14454_/B VDD VSS _13719_/A XOR2X1
XFILLER_71_193 VDD VSS FILLER1
XFILLER_44_70 VDD VSS FILLER1
X_10847_ _18566_/Q _10848_/B VDD VSS _10885_/A AND2X1
XFILLER_158_700 VDD VSS DECAPHV8
X_19142_ _19196_/CK _19142_/D _19142_/Q VDD VSS DFFQX1
X_16354_ _19724_/Q _16888_/B VDD VSS _16358_/B XOR2X1
X_13566_ _19028_/Q _13733_/A _13610_/B VDD VSS _13683_/D XNOR3X1
X_10778_ _10778_/A _10816_/B VDD VSS _10780_/B XOR2X1
XFILLER_9_754 VSS VDD FILLER2
X_15305_ _15305_/A _15305_/B _15305_/C _15305_/D VDD VSS _15345_/B AOAI211X1
XFILLER_8_231 VDD VSS FILLER1
X_19073_ _19126_/CK _19073_/D _19073_/Q VDD VSS DFFQX1
X_12517_ _12517_/A _12517_/B _12517_/C _12517_/D VDD VSS _12803_/A AOAI211X1
XFILLER_9_765 VDD VSS FILLER4
X_16285_ _19561_/Q _19913_/Q _16285_/C VDD VSS _16286_/C AOI2B1X1
XTAP_TAPCELL_ROW_139_1265 VDD VSS WELLTAP
X_13497_ _13497_/A _14128_/B _13497_/C VDD VSS _13869_/A MIN3X1
X_18024_ _18532_/Q _18024_/B _18533_/Q VDD VSS _18025_/C AOI21X1
X_15236_ _19512_/Q _15276_/B VDD VSS _15311_/C NAND2X1
XFILLER_60_80 VSS VDD FILLER2
X_12448_ _12448_/A _12448_/B _14341_/B VDD VSS _12449_/B MIN3X1
XFILLER_60_91 VSS VDD FILLER2
XFILLER_99_503 VSS VDD FILLER2
XFILLER_125_151 VSS VDD FILLER2
XFILLER_141_600 VSS VDD FILLER2
X_15167_ _15172_/A _15167_/B VDD VSS _15686_/B XNOR2X1
XFILLER_141_611 VSS VDD FILLER2
X_12379_ _12553_/B _14406_/C _19127_/Q VDD VSS _12380_/D AND3BX1
XFILLER_125_162 VSS VDD FILLER2
XFILLER_141_622 VSS VDD FILLER2
XFILLER_4_470 VSS VDD FILLER2
XFILLER_125_184 VSS VDD FILLER2
X_14118_ _14118_/A _14118_/B VDD VSS _18878_/D NOR2X1
XFILLER_140_121 VDD VSS FILLER4
X_15098_ _19507_/Q _15098_/B VDD VSS _15108_/A NAND2X1
X_19975_ _19985_/CK _19975_/D _19975_/Q VDD VSS DFFQX1
XFILLER_87_709 VDD VSS DECAPHV8
Xclkbuf_leaf_4__002_ clkbuf_leaf_9__002_/A VDD VSS _18767_/CK BUFX12
X_18926_ _19171_/CK _18926_/D _18926_/Q VDD VSS DFFQX1
X_14049_ _18896_/Q _14049_/B _14085_/D VDD VSS _17960_/C XNOR3X1
XFILLER_79_271 VSS VDD FILLER2
XFILLER_140_187 VSS VDD FILLER2
XFILLER_79_282 VSS VDD FILLER2
X_18857_ _18915_/CK _18857_/D _18857_/Q VDD VSS DFFQX1
XFILLER_94_230 VSS VDD FILLER2
XFILLER_95_764 VDD VSS FILLER1
XFILLER_94_241 VSS VDD FILLER2
X_17808_ _19926_/Q _19894_/Q VDD VSS _17809_/B XOR2X1
X_09590_ _09811_/C VDD VSS _09797_/C BUFX3
XFILLER_82_403 VDD VSS FILLER4
X_18788_ _18788_/CK _18788_/D _18788_/Q VDD VSS DFFQX1
XTAP_TAPCELL_ROW_65_601 VDD VSS WELLTAP
XFILLER_95_797 VDD VSS FILLER1
XFILLER_82_414 VDD VSS FILLER4
XFILLER_36_820 VDD VSS FILLER4
XFILLER_82_436 VSS VDD FILLER2
XFILLER_54_127 VDD VSS FILLER4
X_17739_ _17740_/C _18127_/B _17739_/C VDD VSS _19910_/D AND3BX1
XTAP_TAPCELL_ROW_37_347 VDD VSS WELLTAP
XFILLER_63_672 VSS VDD FILLER2
XFILLER_23_503 VDD VSS FILLER1
XFILLER_90_491 VDD VSS FILLER4
XFILLER_24_29 VDD VSS FILLER4
X_19409_ _19412_/CK _19409_/D _19409_/Q VDD VSS DFFQX1
XFILLER_164_714 VSS VDD FILLER2
XFILLER_136_416 VSS VDD FILLER2
XFILLER_149_799 VDD VSS FILLER4
XFILLER_40_17 VDD VSS DECAPHV8
XFILLER_108_118 VSS VDD FILLER2
XFILLER_40_39 VDD VSS FILLER1
XFILLER_148_298 VDD VSS FILLER4
XFILLER_156_17 VSS VDD FILLER2
XFILLER_163_235 VSS VDD FILLER2
XFILLER_156_39 VDD VSS FILLER4
XFILLER_117_674 VSS VDD FILLER2
XFILLER_105_836 VDD VSS FILLER1
Xhold264 input4/Y VDD VSS hold264/Y BUFX3
XFILLER_131_121 VSS VDD FILLER2
XFILLER_104_346 VSS VDD FILLER2
XFILLER_131_143 VDD VSS FILLER1
Xclkbuf_leaf_23__001_ clkload32/A VDD VSS _19086_/CK BUFX12
X_20115_ _20115_/A VDD VSS _20115_/Y BUFX3
X_09926_ _18558_/Q _10247_/A _18559_/Q VDD VSS _09927_/B AOI21X1
X_18205__252 _20052_/CK VDD VSS _20047_/CK INVX1
X_20046_ _20046_/CK _20046_/D _20046_/Q _09285_/Y VDD VSS DFFRQX1
X_09857_ _18572_/Q _09864_/B VDD VSS _09857_/Y XNOR2X1
XFILLER_105_54 VDD VSS FILLER4
XFILLER_86_775 VDD VSS DECAPHV8
XFILLER_46_617 VSS VDD FILLER2
XFILLER_100_574 VSS VDD FILLER2
XFILLER_105_87 VDD VSS FILLER4
Xclkbuf_leaf_38__001_ clkbuf_leaf_4__001_/A VDD VSS _19217_/CK BUFX12
X_09788_ _20130_/A _09788_/B _09813_/C _20194_/A _09788_/E VDD VSS _09788_/Y AOI221X1
XFILLER_73_425 VDD VSS FILLER4
XFILLER_85_296 VDD VSS FILLER1
XFILLER_27_831 VDD VSS FILLER4
XFILLER_45_149 VSS VDD FILLER2
XFILLER_26_341 VSS VDD FILLER2
XFILLER_26_363 VDD VSS FILLER4
XFILLER_14_514 VSS VDD FILLER2
X_11750_ _11835_/A _11835_/B _11835_/C VDD VSS _11764_/B OAI21X1
XTAP_TAPCELL_ROW_71_648 VDD VSS WELLTAP
XFILLER_41_322 VSS VDD FILLER2
XFILLER_121_86 VSS VDD FILLER2
XFILLER_14_547 VSS VDD FILLER2
X_10701_ _10960_/A _10843_/A VDD VSS _10702_/C _10701_/C NAND3X1
XFILLER_41_344 VDD VSS FILLER4
X_11681_ _18818_/Q _14547_/B VDD VSS _18845_/D AND2X1
X_13420_ _13420_/A _13420_/B _13420_/C _13420_/D VDD VSS _14293_/B OAOI211X1
X_10632_ _19947_/Q _18829_/Q VDD VSS _10681_/B XOR2X1
XFILLER_41_399 VDD VSS FILLER1
XFILLER_14_73 VDD VSS FILLER4
XFILLER_22_591 VDD VSS FILLER1
XFILLER_14_84 VDD VSS FILLER4
X_13351_ _19194_/Q _13449_/B _13454_/C VDD VSS _13542_/C XNOR3X1
X_10563_ _10563_/A _10563_/B _10563_/C _10563_/D VDD VSS _10564_/C AOI211X1
XFILLER_10_764 VDD VSS FILLER4
X_12302_ _12380_/A _14375_/B VDD VSS _12334_/B NOR2X1
XFILLER_155_747 VDD VSS FILLER4
XFILLER_127_449 VSS VDD FILLER2
X_16070_ _16081_/B _16070_/B VDD VSS _16841_/B XNOR2X1
XFILLER_155_758 VSS VDD FILLER2
XFILLER_154_235 VSS VDD FILLER2
XFILLER_108_630 VDD VSS FILLER1
X_13282_ _18885_/Q _13495_/B _13288_/C VDD VSS _17901_/B XNOR3X1
X_10494_ _10525_/A _10525_/B _10525_/C _10763_/A VDD VSS _10495_/D AOI31X1
XFILLER_5_223 VSS VDD FILLER2
X_15021_ _19480_/Q _15021_/B _15021_/C VDD VSS _15054_/C XOR3X1
XFILLER_107_140 VSS VDD FILLER2
X_12233_ _19236_/Q _12236_/A _12233_/C VDD VSS _12234_/D XNOR3X1
XFILLER_108_674 VSS VDD FILLER2
XTAP_TAPCELL_ROW_1_21 VDD VSS WELLTAP
XFILLER_146_61 VSS VDD FILLER2
XFILLER_30_94 VDD VSS FILLER4
XFILLER_135_493 VDD VSS DECAPHV16
X_12164_ _20001_/Q _19265_/Q VDD VSS _12236_/D XNOR2X1
XFILLER_162_290 VSS VDD FILLER2
XFILLER_146_83 VDD VSS FILLER4
XFILLER_146_94 VDD VSS FILLER4
X_11115_ _11116_/A _11115_/B VDD VSS _11116_/C NAND2X1
XFILLER_122_165 VSS VDD FILLER2
X_16972_ _19748_/Q _19749_/Q _16978_/B VDD VSS _16973_/C OAI21X1
X_19760_ _19934_/CK _19760_/D _19760_/Q VDD VSS DFFQX1
X_12095_ _19207_/Q _14498_/B VDD VSS _12160_/A NOR2BX1
XFILLER_68_219 VDD VSS FILLER4
XFILLER_122_176 VSS VDD FILLER2
XTAP_TAPCELL_ROW_79_726 VDD VSS WELLTAP
X_15923_ _15923_/A _15923_/B VDD VSS _15924_/C NAND2X1
X_18711_ _18767_/CK _18711_/D _18711_/Q VDD VSS DFFQX1
X_11046_ _11196_/A _18732_/Q _11208_/D _11046_/D VDD VSS _11047_/D AOI22X1
X_19691_ _19695_/CK _19691_/D _19691_/Q VDD VSS DFFQX1
XFILLER_76_230 VSS VDD FILLER2
XFILLER_162_71 VSS VDD FILLER2
X_18642_ _19949_/CK _18642_/D _18642_/Q VDD VSS DFFQX1
XFILLER_92_712 VSS VDD FILLER2
XFILLER_76_263 VDD VSS FILLER4
XFILLER_49_477 VDD VSS FILLER1
XFILLER_162_82 VSS VDD FILLER2
X_15854_ _15867_/A _15855_/B VDD VSS _19465_/D NOR2X1
XFILLER_92_734 VDD VSS FILLER4
XFILLER_36_116 VDD VSS FILLER1
XTAP_TAPCELL_ROW_87_792 VDD VSS WELLTAP
XFILLER_92_745 VSS VDD FILLER2
X_14805_ _19307_/Q _15677_/B VDD VSS _14809_/B NOR2X1
XFILLER_91_233 VSS VDD FILLER2
X_18573_ _18589_/CK _18573_/D _18573_/Q VDD VSS DFFQX1
XFILLER_64_458 VSS VDD FILLER2
X_15785_ _15793_/A _15785_/B VDD VSS _19404_/D AND2X1
X_12997_ _19021_/Q _13005_/B _12997_/C VDD VSS _13008_/B XNOR3X1
X_17524_ _17527_/A _17527_/B VDD VSS _17525_/B XNOR2X1
XFILLER_91_277 VSS VDD FILLER2
X_14736_ _19473_/Q _15864_/B VDD VSS _14837_/A NOR2BX1
X_11948_ _11950_/A _11950_/B _14271_/B VDD VSS _14237_/B XNOR3X1
XTAP_TAPCELL_ROW_34_317 VDD VSS WELLTAP
XFILLER_55_91 VSS VDD FILLER2
XFILLER_32_300 VDD VSS FILLER1
XFILLER_72_491 VDD VSS FILLER1
X_17455_ _19849_/Q _19817_/Q _17455_/C VDD VSS _17460_/B MIN3X1
X_14667_ _14667_/A _14667_/B _15765_/B VDD VSS _14696_/B MIN3X1
X_11879_ _11918_/A _11918_/B _11918_/D VDD VSS _11891_/B OAI21X1
XFILLER_60_675 VDD VSS DECAPHV8
X_16406_ _16406_/A _16406_/B _16406_/C VDD VSS _16407_/B NOR3X1
X_13618_ _14420_/B _14420_/C _19139_/Q VDD VSS _13620_/C AOI21X1
X_17386_ _17536_/A _17386_/B _17387_/C VDD VSS _19835_/D NOR3X1
X_14598_ _14615_/A _14598_/B VDD VSS _15859_/A _14645_/B NAND3X1
XFILLER_158_541 VDD VSS DECAPHV8
X_19125_ _19191_/CK _19125_/D _19125_/Q VDD VSS DFFQX1
XTAP_TAPCELL_ROW_42_394 VDD VSS WELLTAP
X_16337_ _16317_/A _16337_/B _16337_/C VDD VSS _16366_/B AOI2B1X1
XFILLER_71_90 VSS VDD FILLER2
X_13549_ _13637_/A _13549_/B VDD VSS _14452_/B XNOR2X1
XFILLER_118_416 VSS VDD FILLER2
X_19056_ _19119_/CK _19056_/D _19056_/Q VDD VSS DFFQX1
XFILLER_9_595 VDD VSS FILLER1
X_16268_ _16296_/B _16268_/B VDD VSS _16850_/B NOR2BX1
X_18007_ _18049_/B VDD VSS _18056_/A BUFX3
X_15219_ _19372_/Q VDD VSS _15221_/A INVX1
X_16199_ _16196_/A _16199_/B VDD VSS _16222_/B NOR2BX1
XFILLER_161_739 VDD VSS FILLER4
XFILLER_99_333 VSS VDD FILLER2
XFILLER_141_441 VDD VSS FILLER4
XFILLER_59_208 VSS VDD FILLER2
X_19958_ _19959_/CK _19958_/D _19958_/Q VDD VSS DFFQX1
XFILLER_101_327 VSS VDD FILLER2
XFILLER_99_399 VDD VSS FILLER4
XFILLER_68_720 VSS VDD FILLER2
XFILLER_141_496 VSS VDD FILLER2
X_09711_ _18448_/Q _09751_/B _09711_/C _09711_/D VDD VSS _09712_/B OAI211X1
X_18909_ _18939_/CK _18909_/D _18909_/Q VDD VSS DFFQX1
X_19889_ _19924_/CK _19889_/D _19889_/Q VDD VSS DFFQX1
XFILLER_95_550 VDD VSS FILLER1
XFILLER_95_561 VDD VSS FILLER4
XFILLER_83_712 VSS VDD FILLER2
X_09642_ _18237_/Q _09770_/B _09797_/C _20201_/A _09642_/E VDD VSS _09650_/B AOI221X1
XFILLER_95_583 VSS VDD FILLER2
XFILLER_67_296 VDD VSS FILLER4
X_09573_ _18440_/Q _09816_/B _09573_/C _09753_/A VDD VSS _09574_/E OAI211X1
XFILLER_55_458 VDD VSS FILLER4
XFILLER_83_778 VSS VDD FILLER2
XFILLER_82_255 VDD VSS FILLER4
XFILLER_36_650 VSS VDD FILLER2
XFILLER_70_428 VSS VDD FILLER2
XFILLER_36_694 VSS VDD FILLER2
XFILLER_51_686 VDD VSS FILLER4
XFILLER_11_528 VDD VSS FILLER1
XFILLER_51_49 VSS VDD FILLER2
XFILLER_149_585 VDD VSS FILLER4
XFILLER_109_427 VDD VSS FILLER1
XFILLER_136_213 VDD VSS FILLER1
XFILLER_137_747 VSS VDD FILLER2
XFILLER_136_235 VDD VSS FILLER4
XFILLER_164_555 VDD VSS FILLER4
XFILLER_105_600 VSS VDD FILLER2
XFILLER_164_599 VDD VSS FILLER4
XFILLER_3_738 VDD VSS FILLER4
XFILLER_104_121 VSS VDD FILLER2
XFILLER_2_248 VDD VSS FILLER1
XFILLER_116_20 VDD VSS DECAPHV8
XFILLER_104_165 VDD VSS FILLER1
XFILLER_116_64 VSS VDD FILLER2
XFILLER_132_496 VDD VSS FILLER4
XFILLER_76_24 VSS VDD FILLER2
X_09909_ _11014_/A _09909_/B _09909_/C VDD VSS _09939_/B AOI21X1
XFILLER_116_97 VDD VSS DECAPHV8
XFILLER_58_230 VSS VDD FILLER2
XFILLER_58_252 VSS VDD FILLER2
X_20029_ _20033_/CK _20029_/D _20029_/Q _20030_/RB VDD VSS DFFRQX1
X_12920_ _19077_/Q _14351_/B VDD VSS _13021_/A AND2X1
XFILLER_86_572 VSS VDD FILLER2
XFILLER_19_628 VDD VSS DECAPHV16
XFILLER_74_734 VSS VDD FILLER2
XFILLER_74_745 VSS VDD FILLER2
XFILLER_100_393 VSS VDD FILLER2
X_12851_ _20008_/Q _19272_/Q VDD VSS _12955_/D NOR2X1
XFILLER_73_244 VSS VDD FILLER2
XFILLER_46_458 VSS VDD FILLER2
XTAP_TAPCELL_ROW_125_1139 VDD VSS WELLTAP
XFILLER_74_778 VSS VDD FILLER2
XFILLER_46_469 VDD VSS FILLER1
XFILLER_74_789 VDD VSS FILLER1
X_11802_ _11828_/A _11828_/B _11828_/C VDD VSS _11807_/B AOI21X1
XTAP_TAPCELL_ROW_84_773 VDD VSS WELLTAP
XFILLER_73_277 VSS VDD FILLER2
X_15570_ _19409_/Q _15790_/B _15570_/C VDD VSS _15597_/A AOI21X1
XFILLER_27_683 VDD VSS FILLER4
X_12782_ _18992_/Q _12903_/A _14253_/B VDD VSS _14215_/B XOR3X1
XFILLER_26_182 VSS VDD FILLER2
X_14521_ _14491_/Y _14521_/B _14521_/C VDD VSS _19228_/D AND3BX1
XFILLER_155_0 VSS VDD FILLER2
X_11733_ _19171_/Q _11733_/B _11733_/C VDD VSS _11793_/B MIN3X1
XFILLER_25_50 VSS VDD FILLER2
X_17240_ _17242_/B _17240_/B VDD VSS _17241_/B XOR2X1
X_14452_ _14456_/A _14452_/B VDD VSS _19167_/D NOR2X1
X_11664_ _18803_/Q _11669_/B VDD VSS _18830_/D AND2X1
X_13403_ _13586_/A _14192_/B VDD VSS _13490_/B NOR2X1
X_17171_ _19789_/Q _19757_/Q VDD VSS _17174_/B XOR2X1
X_10615_ _18639_/Q _18801_/Q VDD VSS _10617_/C XNOR2X1
X_14383_ _14381_/Y _14383_/B _14383_/C VDD VSS _19105_/D AND3BX1
X_11595_ _18740_/Q _11600_/B VDD VSS _18767_/D AND2X1
XFILLER_128_736 VSS VDD FILLER2
X_16122_ _16129_/B _16122_/B VDD VSS _16879_/B XNOR2X1
X_13334_ _13354_/A _14416_/B _13354_/C _13334_/D VDD VSS _13546_/A OAOI211X1
XTAP_TAPCELL_ROW_136_1235 VDD VSS WELLTAP
XFILLER_155_544 VDD VSS FILLER1
XFILLER_10_583 VSS VDD FILLER2
X_10546_ _10546_/A _10546_/B VDD VSS _10547_/A AND2X1
XFILLER_41_71 VDD VSS FILLER4
XFILLER_115_419 VSS VDD FILLER2
X_16053_ _19712_/Q _16875_/B VDD VSS _16054_/C NOR2X1
XFILLER_157_71 VSS VDD FILLER2
XFILLER_155_588 VDD VSS FILLER1
X_13265_ _19165_/Q _13356_/B _13443_/D VDD VSS _13354_/C XNOR3X1
XFILLER_136_780 VSS VDD FILLER2
XFILLER_142_216 VSS VDD FILLER2
X_10477_ _18636_/Q _18798_/Q VDD VSS _10514_/D NAND2X1
X_15004_ _15052_/A _15052_/B VDD VSS _15871_/B XNOR2X1
X_12216_ _12372_/A _12372_/B _12372_/C _12372_/D VDD VSS _12471_/A AO31X2
X_13196_ _18996_/Q _14258_/B VDD VSS _14221_/A AND2X1
XFILLER_151_761 VDD VSS DECAPHV8
XFILLER_97_815 VSS VDD FILLER2
X_19812_ _19825_/CK _19812_/D _19812_/Q VDD VSS DFFQX1
XFILLER_123_474 VSS VDD FILLER2
X_12147_ wire160/Y _12181_/B _12181_/E _12147_/D VDD VSS _14403_/C OAOI211X1
XFILLER_151_794 VSS VDD FILLER2
XFILLER_2_793 VSS VDD FILLER2
XFILLER_110_124 VSS VDD FILLER2
X_19743_ _19841_/CK _19743_/D _19743_/Q VDD VSS DFFQX1
X_16955_ _16976_/A _16955_/B VDD VSS _19746_/D NOR2X1
X_12078_ _19094_/Q VDD VSS _12083_/A INVX1
XFILLER_49_230 VSS VDD FILLER2
XFILLER_49_241 VSS VDD FILLER2
XFILLER_2_43 VSS VDD FILLER2
XFILLER_77_561 VSS VDD FILLER2
XFILLER_65_701 VSS VDD FILLER2
XFILLER_110_179 VSS VDD FILLER2
X_15906_ _15906_/A _15906_/B VDD VSS _19512_/D NOR2X1
X_11029_ _18812_/Q VDD VSS _11675_/A INVX1
X_16886_ _16899_/A _16886_/B VDD VSS _19722_/D AND2X1
X_19674_ _19724_/CK _19674_/D _19674_/Q VDD VSS DFFQX1
XFILLER_49_296 VSS VDD FILLER2
X_15837_ _17010_/A _15837_/B _15837_/C VDD VSS _19452_/D NOR3X1
X_18625_ _18625_/CK _18625_/D _18625_/Q VDD VSS DFFQX1
XFILLER_66_90 VDD VSS FILLER4
XFILLER_65_778 VSS VDD FILLER2
XFILLER_92_575 VDD VSS FILLER4
XFILLER_65_789 VSS VDD FILLER2
X_15768_ _15770_/A _15768_/B VDD VSS _19390_/D AND2X1
X_18556_ _18583_/CK _18556_/D _18556_/Q VDD VSS DFFQX1
XTAP_TAPCELL_ROW_19_188 VDD VSS WELLTAP
X_14719_ _19417_/Q _14730_/B _15799_/B VDD VSS _15767_/B XNOR3X1
X_17507_ _17657_/B _17507_/B _17507_/C VDD VSS _17512_/C MIN3X1
X_18487_ _18487_/CK _18524_/Q _20132_/A _18503_/RB VDD VSS DFFRQX1
X_15699_ _15706_/A _15699_/B VDD VSS _19327_/D AND2X1
XFILLER_60_450 VSS VDD FILLER2
XFILLER_21_826 VSS VDD FILLER2
X_17438_ _17439_/A _17439_/B _17439_/D _17439_/C VDD VSS _17441_/C AOI211X1
Xclkbuf_leaf_22__002_ clkload16/A VDD VSS _19985_/CK BUFX12
XFILLER_166_809 VDD VSS FILLER1
XANTENNA_15 _20102_/A VDD VSS ANTENNA2
XFILLER_32_196 VDD VSS FILLER1
XFILLER_146_500 VSS VDD FILLER2
X_17369_ _17372_/A _17370_/B _17452_/C VDD VSS _17370_/C OAI21X1
XFILLER_119_725 VSS VDD FILLER2
XFILLER_119_736 VDD VSS FILLER1
XFILLER_70_0 VSS VDD FILLER2
XFILLER_119_747 VSS VDD FILLER2
XFILLER_9_370 VSS VDD FILLER2
X_19108_ _19139_/CK _19108_/D _19108_/Q VDD VSS DFFQX1
XFILLER_118_235 VSS VDD FILLER2
X_19039_ _19068_/CK _19039_/D _19039_/Q VDD VSS DFFQX1
XFILLER_118_279 VSS VDD FILLER2
Xoutput100 _20169_/Y VDD VSS o_lf_cfg[6] BUFX3
Xoutput111 _20195_/Y VDD VSS o_tst_ctrl[14] BUFX3
Xoutput122 _20197_/Y VDD VSS o_uwb_tx_cfg[0] BUFX3
Xoutput133 _20198_/Y VDD VSS o_uwb_tx_cfg[1] BUFX3
Xoutput144 _20199_/Y VDD VSS o_uwb_tx_cfg[2] BUFX3
XTAP_TAPCELL_ROW_113_1032 VDD VSS WELLTAP
XFILLER_99_130 VDD VSS FILLER4
XFILLER_161_569 VDD VSS FILLER1
XFILLER_0_708 VSS VDD FILLER2
XFILLER_0_719 VDD VSS FILLER1
XFILLER_114_463 VDD VSS FILLER4
XFILLER_102_614 VSS VDD FILLER2
XFILLER_142_783 VDD VSS FILLER4
XFILLER_114_485 VDD VSS FILLER4
XFILLER_99_174 VSS VDD FILLER2
XFILLER_99_185 VDD VSS FILLER1
XFILLER_141_282 VDD VSS FILLER4
XFILLER_141_293 VDD VSS FILLER4
XTAP_TAPCELL_ROW_98_898 VDD VSS WELLTAP
XFILLER_56_734 VDD VSS FILLER1
XFILLER_46_27 VSS VDD FILLER2
XFILLER_56_745 VDD VSS FILLER1
XFILLER_55_222 VDD VSS FILLER4
XFILLER_46_38 VSS VDD FILLER2
X_09625_ _18315_/Q _09815_/C VDD VSS _09628_/C NAND2X1
XFILLER_55_233 VDD VSS FILLER4
XFILLER_46_49 VDD VSS DECAPHV8
XFILLER_55_244 VDD VSS FILLER4
XTAP_TAPCELL_ROW_165_1497 VDD VSS WELLTAP
XFILLER_43_406 VSS VDD FILLER2
XFILLER_55_277 VSS VDD FILLER2
XFILLER_102_22 VDD VSS FILLER4
X_09556_ _20133_/A _20181_/A _09753_/A VDD VSS _09582_/B MUXI2X1
XFILLER_102_44 VSS VDD FILLER2
XTAP_TAPCELL_ROW_81_743 VDD VSS WELLTAP
XFILLER_62_15 VSS VDD FILLER2
X_09487_ _18456_/D _09501_/B _09487_/C VDD VSS _18241_/D AOI21X1
XFILLER_141_6 VDD VSS FILLER1
XTAP_TAPCELL_ROW_53_489 VDD VSS WELLTAP
XFILLER_8_819 VSS VDD FILLER2
XFILLER_156_308 VSS VDD FILLER2
XFILLER_137_511 VSS VDD FILLER2
XFILLER_7_318 VSS VDD FILLER2
XFILLER_127_4 VDD VSS FILLER4
X_10400_ _10441_/A _10441_/B VDD VSS _10404_/C NAND2X1
X_11380_ _11384_/A _11390_/B VDD VSS _11382_/A XNOR2X1
XFILLER_152_503 VSS VDD FILLER2
XFILLER_152_514 VDD VSS FILLER4
X_10331_ _18630_/Q _18792_/Q VDD VSS _10372_/A AND2X1
XFILLER_164_374 VSS VDD FILLER2
XFILLER_118_780 VSS VDD FILLER2
XFILLER_124_227 VDD VSS FILLER4
XFILLER_152_547 VDD VSS FILLER4
XFILLER_11_85 VSS VDD FILLER2
X_13050_ _14540_/A _14540_/B _19246_/Q VDD VSS _13129_/D AOI21BX1
X_10262_ _11438_/A _18711_/Q VDD VSS _10263_/E AND2X1
XFILLER_105_430 VSS VDD FILLER2
XFILLER_11_96 VSS VDD FILLER2
XFILLER_127_63 VSS VDD FILLER2
XFILLER_2_3 VSS VDD FILLER2
XFILLER_133_772 VDD VSS FILLER4
X_12001_ _12031_/A _12031_/B _12031_/C VDD VSS _12026_/C OR3X2
XFILLER_87_34 VSS VDD FILLER2
XFILLER_127_96 VSS VDD FILLER2
XFILLER_133_783 VDD VSS DECAPHV8
XFILLER_120_400 VDD VSS DECAPHV8
X_10193_ _18617_/Q _10193_/B VDD VSS _10200_/B NOR2BX1
XTAP_TAPCELL_ROW_89_810 VDD VSS WELLTAP
XFILLER_78_314 VSS VDD FILLER2
XFILLER_105_485 VDD VSS FILLER1
XFILLER_94_807 VSS VDD FILLER2
XFILLER_87_89 VDD VSS FILLER4
XFILLER_66_509 VSS VDD FILLER2
XFILLER_93_317 VSS VDD FILLER2
XFILLER_59_561 VSS VDD FILLER2
XFILLER_143_62 VSS VDD FILLER2
X_16740_ _16748_/A _16740_/B VDD VSS _19590_/D NOR2X1
X_13952_ _19004_/Q _14266_/B _14266_/C VDD VSS _13955_/D OR3BX1
XFILLER_143_73 VSS VDD FILLER2
XFILLER_93_339 VSS VDD FILLER2
XFILLER_59_594 VDD VSS FILLER4
XFILLER_86_380 VSS VDD FILLER2
X_12903_ _12903_/A _12903_/B _12903_/C _12903_/D VDD VSS _13198_/B AOI211X1
XFILLER_19_447 VDD VSS FILLER1
X_16671_ _16671_/A VDD VSS _16831_/B INVX1
X_13883_ _13924_/A _14166_/B _13884_/C VDD VSS _14167_/B OR3BX1
XFILLER_47_789 VDD VSS DECAPHV8
XFILLER_46_266 VDD VSS FILLER4
X_15622_ _15622_/A _15622_/B _15824_/B VDD VSS _15793_/B MIN3X1
X_18410_ _18423_/CK _18511_/Q _20165_/A _09380_/B VDD VSS DFFRQX1
XFILLER_62_726 VSS VDD FILLER2
X_19390_ _19465_/CK _19390_/D _19390_/Q VDD VSS DFFQX1
X_12834_ _12945_/A _14509_/B VDD VSS _12953_/A NOR2X1
XFILLER_46_288 VDD VSS FILLER1
XTAP_TAPCELL_ROW_44_412 VDD VSS WELLTAP
XFILLER_62_748 VDD VSS FILLER1
XFILLER_61_225 VSS VDD FILLER2
XFILLER_34_439 VDD VSS DECAPHV8
XFILLER_15_620 VDD VSS FILLER1
X_18341_ _18341_/CK _18341_/D _18341_/Q _18374_/RB VDD VSS DFFRQX1
XFILLER_15_642 VSS VDD FILLER2
X_15553_ _15599_/B _15553_/B VDD VSS _15790_/B NOR2BX1
X_12765_ _20008_/Q _19272_/Q VDD VSS _12966_/C XOR2X1
XTAP_TAPCELL_ROW_7_75 VDD VSS WELLTAP
XTAP_TAPCELL_ROW_16_158 VDD VSS WELLTAP
XTAP_TAPCELL_ROW_142_1294 VDD VSS WELLTAP
XFILLER_14_152 VSS VDD FILLER2
XFILLER_14_163 VDD VSS FILLER1
X_14504_ _14491_/Y _14504_/B _14504_/C VDD VSS _19212_/D AND3BX1
X_18272_ _18275_/CK _18272_/D _18272_/Q _20080_/RB VDD VSS DFFRQX1
X_11716_ _11716_/A _11716_/B _11716_/C _11716_/D VDD VSS _11742_/B AOAI211X1
X_15484_ _19435_/Q _15820_/B VDD VSS _15485_/B XNOR2X1
X_12696_ _18935_/Q _12708_/B _14183_/B VDD VSS _12789_/C XNOR3X1
X_17223_ _19800_/Q _19768_/Q VDD VSS _17227_/B XNOR2X1
XFILLER_147_319 VDD VSS FILLER4
X_14435_ _14456_/A _14435_/B VDD VSS _19152_/D NOR2X1
X_11647_ _18788_/Q _11647_/B VDD VSS _18815_/D AND2X1
XTAP_TAPCELL_ROW_0_8 VDD VSS WELLTAP
X_17154_ _17156_/C _17154_/B _17154_/C VDD VSS _19785_/D AOI21X1
X_14366_ _14368_/A _14366_/B VDD VSS _19090_/D NOR2X1
X_11578_ _18725_/Q _11578_/B VDD VSS _18752_/D AND2X1
X_16105_ _19650_/Q _16807_/B VDD VSS _16106_/C NOR2X1
XFILLER_115_205 VSS VDD FILLER2
X_13317_ _13430_/B _13318_/C _19136_/Q VDD VSS _13319_/C AOI21X1
XFILLER_128_599 VDD VSS FILLER4
X_17085_ _19770_/Q _19738_/Q VDD VSS _17087_/C _17085_/C AND3X2
X_10529_ _19943_/Q _18825_/Q VDD VSS _10530_/D NAND2X1
X_14297_ _14352_/A _14297_/B _14297_/C VDD VSS _19029_/D NOR3X1
X_16036_ _19552_/Q _19904_/Q VDD VSS _16039_/A XNOR2X1
X_13248_ _14513_/B _14513_/C _13253_/A VDD VSS _13254_/C OAI21X1
XTAP_TAPCELL_ROW_153_1390 VDD VSS WELLTAP
XFILLER_151_580 VSS VDD FILLER2
X_13179_ _18881_/Q VDD VSS _13181_/A INVX1
XFILLER_111_422 VSS VDD FILLER2
XFILLER_123_282 VSS VDD FILLER2
XFILLER_111_433 VDD VSS DECAPHV16
X_17987_ _17987_/A _17987_/B _17987_/C VDD VSS _17989_/B AOI21X1
XFILLER_111_477 VDD VSS DECAPHV8
X_19726_ _19730_/CK _19726_/D _19726_/Q VDD VSS DFFQX1
XFILLER_84_328 VDD VSS FILLER4
XFILLER_38_723 VSS VDD FILLER2
X_16938_ _19743_/Q _17078_/B VDD VSS _16939_/B XOR2X1
XFILLER_96_199 VDD VSS FILLER4
XFILLER_65_520 VSS VDD FILLER2
XFILLER_93_840 VSS VDD FILLER2
XTAP_TAPCELL_ROW_95_868 VDD VSS WELLTAP
X_19657_ _19661_/CK _19657_/D _19657_/Q VDD VSS DFFQX1
X_16869_ _16876_/A _16869_/B VDD VSS _19706_/D NOR2X1
XFILLER_92_361 VDD VSS DECAPHV8
X_09410_ _09422_/B _09410_/B VDD VSS _09496_/C AND2X1
XFILLER_37_277 VSS VDD FILLER2
X_18608_ _18612_/CK _18608_/D _18608_/Q VDD VSS DFFQX1
XFILLER_65_597 VSS VDD FILLER2
XFILLER_53_737 VDD VSS FILLER4
XFILLER_80_523 VSS VDD FILLER2
X_19588_ _19664_/CK _19588_/D _19588_/Q VDD VSS DFFQX1
XFILLER_80_556 VSS VDD FILLER2
X_09341_ _18283_/Q _18511_/Q _09354_/B VDD VSS _09341_/Y MUXI2X1
X_18539_ _18550_/CK _18539_/D _18539_/Q VDD VSS DFFQX1
XFILLER_33_461 VDD VSS FILLER4
X_09272_ _18277_/Q _09354_/A VDD VSS _09273_/C NAND2X1
XFILLER_20_100 VSS VDD FILLER2
XFILLER_60_280 VSS VDD FILLER2
XTAP_TAPCELL_ROW_50_459 VDD VSS WELLTAP
XTAP_TAPCELL_ROW_156_1419 VDD VSS WELLTAP
XFILLER_21_667 VSS VDD FILLER2
XFILLER_166_628 VSS VDD FILLER2
XFILLER_165_105 VSS VDD FILLER2
XFILLER_119_544 VSS VDD FILLER2
XFILLER_20_188 VSS VDD FILLER2
XFILLER_158_190 VDD VSS FILLER1
XFILLER_162_801 VDD VSS FILLER4
XFILLER_146_363 VSS VDD FILLER2
XFILLER_134_514 VSS VDD FILLER2
XFILLER_162_856 VDD VSS FILLER1
XFILLER_161_344 VSS VDD FILLER2
XFILLER_0_516 VSS VDD FILLER2
XFILLER_102_400 VDD VSS FILLER4
XFILLER_88_623 VDD VSS FILLER4
XFILLER_115_794 VDD VSS FILLER4
XFILLER_0_538 VSS VDD FILLER2
XFILLER_142_580 VDD VSS FILLER4
XFILLER_0_549 VSS VDD FILLER2
XFILLER_87_133 VDD VSS FILLER4
XFILLER_130_753 VDD VSS FILLER4
XFILLER_130_764 VDD VSS FILLER4
XFILLER_48_509 VSS VDD FILLER2
XFILLER_130_786 VDD VSS FILLER4
XFILLER_29_712 VSS VDD FILLER2
XFILLER_75_328 VSS VDD FILLER2
XTAP_TAPCELL_ROW_58_537 VDD VSS WELLTAP
XFILLER_28_255 VDD VSS FILLER1
XFILLER_83_361 VSS VDD FILLER2
X_09608_ _20165_/A _09784_/C _09769_/C _18314_/Q VDD VSS _09609_/D AOI22X1
XFILLER_44_737 VDD VSS FILLER1
XFILLER_43_203 VSS VDD FILLER2
XFILLER_113_87 VDD VSS FILLER4
X_10880_ _10960_/A _10880_/B VDD VSS _10881_/C NAND2X1
XTAP_TAPCELL_ROW_122_1109 VDD VSS WELLTAP
XFILLER_71_556 VSS VDD FILLER2
X_09539_ _20033_/Q _09547_/B VDD VSS _20034_/D NOR2BX1
XFILLER_71_567 VSS VDD FILLER2
X_12550_ _12803_/A _12803_/B _12803_/C VDD VSS _12597_/B AOI21X1
XTAP_TAPCELL_ROW_13_128 VDD VSS WELLTAP
X_11501_ _18655_/Q _11508_/B VDD VSS _18682_/D AND2X1
XFILLER_11_144 VSS VDD FILLER2
XFILLER_8_616 VDD VSS FILLER4
XFILLER_157_628 VSS VDD FILLER2
XFILLER_12_678 VSS VDD FILLER2
XFILLER_138_820 VDD VSS FILLER1
X_12481_ _12566_/A _12662_/B VDD VSS _14471_/B XNOR2X1
XFILLER_11_177 VDD VSS FILLER1
X_14220_ _17566_/A VDD VSS _14294_/A BUFX3
XFILLER_156_138 VDD VSS FILLER1
X_11432_ _11433_/B _11432_/B wire167/Y _11432_/D VDD VSS _18625_/D AND4X2
XFILLER_165_661 VDD VSS FILLER4
XFILLER_125_503 VDD VSS DECAPHV8
XFILLER_4_800 VSS VDD FILLER2
X_14151_ _14154_/A _14151_/B VDD VSS _18907_/D NOR2X1
X_11363_ _11370_/A _11363_/B _11370_/C VDD VSS _11371_/B OAI21X1
XFILLER_4_822 VSS VDD FILLER2
XFILLER_152_322 VSS VDD FILLER2
XFILLER_164_182 VDD VSS FILLER1
XFILLER_125_547 VSS VDD FILLER2
X_13102_ _13102_/A _13102_/B _13102_/C _13102_/D VDD VSS _13161_/B AOAI211X1
XFILLER_98_44 VSS VDD FILLER2
X_10314_ _10237_/B _10314_/B _10314_/C VDD VSS _10625_/A AOI2B1X1
XFILLER_4_855 VSS VDD FILLER2
X_14082_ _14174_/A _14174_/B _18926_/Q VDD VSS _14104_/C OAI21X1
XFILLER_140_506 VDD VSS FILLER4
X_11294_ _11296_/B _11295_/B VDD VSS _11295_/C NOR2X1
XFILLER_106_761 VSS VDD FILLER2
XFILLER_0_0 VDD VSS FILLER1
XFILLER_112_208 VSS VDD FILLER2
XFILLER_106_783 VDD VSS FILLER4
X_17910_ _17914_/A _17914_/B VDD VSS _17912_/A XNOR2X1
X_13033_ _19189_/Q _14476_/B _14476_/C VDD VSS _13039_/D OR3BX1
X_10245_ _10304_/A _10314_/C VDD VSS _10346_/A NAND2X1
XFILLER_121_720 VSS VDD FILLER2
X_18890_ _18915_/CK _18890_/D _18890_/Q VDD VSS DFFQX1
XFILLER_105_282 VSS VDD FILLER2
X_17841_ _19935_/Q _17842_/C _19936_/Q _18087_/D VDD VSS _17842_/D AOAI211X1
X_10176_ _18615_/Q _10177_/B VDD VSS _10184_/C NOR2X1
XFILLER_120_241 VSS VDD FILLER2
XFILLER_121_764 VSS VDD FILLER2
XFILLER_79_689 VDD VSS DECAPHV8
XFILLER_78_166 VSS VDD FILLER2
XFILLER_120_263 VDD VSS FILLER4
XFILLER_66_328 VSS VDD FILLER2
XFILLER_120_285 VSS VDD FILLER2
X_14984_ _19339_/Q _15713_/B VDD VSS _14985_/B XNOR2X1
X_17772_ _19918_/Q _19886_/Q VDD VSS _17775_/A XNOR2X1
XFILLER_78_199 VSS VDD FILLER2
XFILLER_19_211 VSS VDD FILLER2
XFILLER_93_136 VDD VSS FILLER4
XFILLER_75_840 VSS VDD FILLER2
X_19511_ _19734_/CK _19511_/D _19511_/Q VDD VSS DFFQX1
XTAP_TAPCELL_ROW_144_1312 VDD VSS WELLTAP
X_16723_ _19926_/Q _16726_/B VDD VSS _19574_/D AND2X1
X_13935_ _18920_/Q _14167_/B VDD VSS _13938_/C _14167_/C NAND3X1
XFILLER_47_92 VDD VSS FILLER1
XFILLER_35_715 VSS VDD FILLER2
XFILLER_90_810 VSS VDD FILLER2
XTAP_TAPCELL_ROW_92_838 VDD VSS WELLTAP
XFILLER_19_277 VSS VDD FILLER2
X_16654_ _16677_/C _16654_/B VDD VSS _16759_/B XNOR2X1
X_19442_ _19508_/CK _19442_/D _19442_/Q VDD VSS DFFQX1
XFILLER_74_383 VSS VDD FILLER2
XFILLER_19_288 VSS VDD FILLER2
X_13866_ _18920_/Q _13866_/B _13884_/C VDD VSS _13981_/B XNOR3X1
XTAP_TAPCELL_ROW_29_272 VDD VSS WELLTAP
XFILLER_90_854 VSS VDD FILLER2
X_15605_ _15625_/B _15605_/B VDD VSS _15761_/B XNOR2X1
X_12817_ _19132_/Q _13107_/A _12822_/B VDD VSS _12819_/C XNOR3X1
XFILLER_62_567 VSS VDD FILLER2
X_16585_ _16585_/A _16585_/B _16585_/C VDD VSS _16586_/B OR3X2
X_19373_ _19573_/CK _19373_/D _19373_/Q VDD VSS DFFQX1
X_13797_ _19031_/Q _13912_/A _13846_/B VDD VSS _13889_/D XNOR3X1
X_15536_ _15564_/A _15564_/B VDD VSS _15561_/A NAND2X1
X_18324_ _18325_/CK _18521_/Q _18324_/Q _20081_/RB VDD VSS DFFRQX1
X_12748_ _12748_/A _14409_/B _12813_/C _12748_/D VDD VSS _12932_/A OAOI211X1
XFILLER_63_91 VSS VDD FILLER2
X_18255_ _18256_/CK _18255_/D _18262_/D _18486_/RB VDD VSS DFFRQX1
XFILLER_8_20 VSS VDD FILLER2
X_15467_ _19434_/Q _15819_/B _15448_/Y VDD VSS _15509_/B AOI21BX1
X_12679_ _19241_/Q _14535_/B _14535_/C VDD VSS _12755_/C OR3BX1
XFILLER_8_42 VDD VSS FILLER4
XFILLER_30_475 VDD VSS FILLER4
X_17206_ _17206_/A _17208_/C _17206_/C VDD VSS _19796_/D AOI21X1
XFILLER_30_486 VDD VSS FILLER4
X_14418_ _15383_/A VDD VSS _14467_/A BUFX3
X_18186_ _19303_/Q _18190_/A VDD VSS _18188_/B XNOR2X1
X_15398_ _15398_/A _15910_/B _15398_/C VDD VSS _15440_/B MIN3X1
XFILLER_128_363 VDD VSS FILLER1
XFILLER_116_514 VSS VDD FILLER2
X_17137_ _17140_/A _17137_/B _17137_/C VDD VSS _19781_/D AOI21X1
XFILLER_143_300 VDD VSS FILLER4
X_14349_ _14316_/Y _14349_/B _14349_/C VDD VSS _19076_/D AND3BX1
XFILLER_7_671 VSS VDD FILLER2
XFILLER_116_547 VDD VSS FILLER4
XFILLER_144_856 VDD VSS FILLER1
X_17068_ _19766_/Q _17073_/B _17068_/C VDD VSS _17073_/C AO21X2
XFILLER_143_355 VDD VSS DECAPHV8
X_16019_ _19706_/Q _16869_/B VDD VSS _16022_/C NAND2X1
XTAP_TAPCELL_ROW_110_1002 VDD VSS WELLTAP
XFILLER_69_100 VDD VSS FILLER1
XFILLER_112_720 VDD VSS DECAPHV8
X_09890_ _11014_/A VDD VSS _11178_/C BUFX3
XFILLER_33_0 VSS VDD FILLER2
XFILLER_111_230 VSS VDD FILLER2
XFILLER_97_475 VSS VDD FILLER2
X_19709_ _19724_/CK _19709_/D _19709_/Q VDD VSS DFFQX1
XFILLER_84_169 VDD VSS FILLER1
XTAP_TAPCELL_ROW_55_507 VDD VSS WELLTAP
XFILLER_38_564 VDD VSS DECAPHV16
XFILLER_26_715 VDD VSS DECAPHV8
XFILLER_81_832 VDD VSS FILLER4
XTAP_TAPCELL_ROW_162_1467 VDD VSS WELLTAP
XFILLER_26_748 VDD VSS DECAPHV8
XFILLER_65_394 VDD VSS FILLER4
Xclkbuf_leaf_5__000_ clkbuf_leaf_6__000_/A VDD VSS _19484_/CK BUFX12
XFILLER_80_375 VDD VSS FILLER1
XFILLER_80_386 VDD VSS FILLER1
X_09324_ _18449_/D _09323_/Y _09302_/Y VDD VSS _18518_/D MUXI2X1
XTAP_TAPCELL_ROW_63_584 VDD VSS WELLTAP
XFILLER_159_17 VSS VDD FILLER2
XFILLER_159_39 VDD VSS FILLER1
X_09255_ _20047_/Q _20048_/Q VDD VSS _09256_/C NOR2X1
XFILLER_166_447 VSS VDD FILLER2
XFILLER_119_330 VSS VDD FILLER2
XFILLER_107_503 VDD VSS DECAPHV8
XFILLER_162_620 VDD VSS FILLER1
XTAP_TAPCELL_ROW_119_1082 VDD VSS WELLTAP
XFILLER_107_547 VSS VDD FILLER2
XFILLER_135_856 VDD VSS FILLER1
XFILLER_162_664 VDD VSS FILLER4
XFILLER_150_826 VDD VSS FILLER4
XFILLER_68_36 VSS VDD FILLER2
XFILLER_1_847 VDD VSS FILLER4
XFILLER_115_591 VDD VSS FILLER4
XFILLER_88_431 VDD VSS DECAPHV16
XFILLER_0_335 VSS VDD FILLER2
XFILLER_103_742 VSS VDD FILLER2
X_10030_ _11178_/C VDD VSS _10127_/A BUFX3
XFILLER_102_230 VSS VDD FILLER2
XFILLER_0_357 VSS VDD FILLER2
XFILLER_88_453 VDD VSS FILLER1
XFILLER_49_829 VDD VSS FILLER1
XFILLER_88_486 VSS VDD FILLER2
XFILLER_102_274 VSS VDD FILLER2
XFILLER_103_797 VSS VDD FILLER2
XFILLER_48_328 VDD VSS FILLER4
XFILLER_84_13 VDD VSS DECAPHV8
XFILLER_76_659 VSS VDD FILLER2
XFILLER_57_840 VSS VDD FILLER2
XFILLER_124_97 VSS VDD FILLER2
X_11981_ _14526_/A _14526_/B _11981_/C VDD VSS _11985_/D AO21X2
XFILLER_91_618 VSS VDD FILLER2
XFILLER_56_350 VDD VSS FILLER1
XFILLER_90_106 VDD VSS FILLER4
XFILLER_56_361 VDD VSS DECAPHV8
X_13720_ _19141_/Q _14423_/B VDD VSS _13791_/A NOR2X1
XFILLER_16_203 VSS VDD FILLER2
X_10932_ _11039_/C _10932_/B VDD VSS _10944_/B _10932_/C NAND3X1
XFILLER_16_225 VDD VSS FILLER1
X_13651_ _13839_/A _13837_/C _13651_/C VDD VSS _13692_/C XNOR3X1
XFILLER_16_258 VSS VDD FILLER2
X_10863_ _18646_/Q _18808_/Q VDD VSS _10874_/A XOR2X1
XFILLER_16_269 VSS VDD FILLER2
XFILLER_71_375 VSS VDD FILLER2
XFILLER_140_85 VDD VSS FILLER4
XFILLER_31_217 VSS VDD FILLER2
XFILLER_25_770 VSS VDD FILLER2
X_12602_ _12717_/A _12717_/B VDD VSS _14250_/B XNOR2X1
X_16370_ _19565_/Q _19917_/Q VDD VSS _16371_/B XNOR2X1
X_13582_ _14129_/B _14129_/C _18888_/Q VDD VSS _13660_/B AOI21X1
X_10794_ _10794_/A _10794_/B _10794_/C _10794_/D VDD VSS _10795_/B OAOI211X1
X_15321_ _19459_/Q _15845_/B VDD VSS _15322_/B XNOR2X1
XFILLER_40_751 VSS VDD FILLER2
X_12533_ _12533_/A _12609_/B _14149_/B VDD VSS _12701_/B MIN3X1
XFILLER_33_72 VSS VDD FILLER2
XFILLER_157_436 VSS VDD FILLER2
XFILLER_149_50 VSS VDD FILLER2
X_18040_ _18541_/Q _18042_/B VDD VSS _18041_/B XNOR2X1
X_15252_ _15260_/B _15252_/B VDD VSS _15719_/B XNOR2X1
XFILLER_157_458 VDD VSS FILLER4
X_12464_ _12543_/A _14377_/B VDD VSS _12558_/A NOR2X1
X_14203_ _14203_/A _14203_/B _15836_/C VDD VSS _18952_/D OA21X2
XFILLER_138_683 VSS VDD FILLER2
X_11415_ _11422_/A _17990_/B _11415_/C VDD VSS _18609_/D NOR3X1
X_15183_ _15183_/A _15183_/B _15183_/C _15183_/D VDD VSS _15875_/C AO22X2
X_12395_ _19239_/Q _14533_/B VDD VSS _12497_/A AND2X1
X_14134_ _14158_/A _14134_/B VDD VSS _18892_/D AND2X1
X_11346_ _11352_/C _11352_/B VDD VSS _11347_/B NAND2BX1
X_19991_ _19996_/CK _19991_/D _19991_/Q VDD VSS DFFQX1
XFILLER_99_729 VSS VDD FILLER2
XFILLER_125_399 VDD VSS FILLER4
X_18942_ _18999_/CK _18942_/D _18942_/Q VDD VSS DFFQX1
X_14065_ _14068_/A _14068_/C _14068_/B _14065_/D VDD VSS _14204_/B OAOI211X1
XTAP_TAPCELL_ROW_150_1360 VDD VSS WELLTAP
XFILLER_152_185 VSS VDD FILLER2
X_11277_ _11379_/A _11286_/A VDD VSS _11280_/A NOR2X1
XFILLER_3_173 VDD VSS FILLER1
XFILLER_3_184 VSS VDD FILLER2
X_13016_ _13101_/A _13113_/A _13314_/B VDD VSS _13017_/D XNOR3X1
X_10228_ _10229_/A _10228_/B _10228_/C VDD VSS _18549_/D OA21X2
X_18873_ _18905_/CK _18873_/D _18873_/Q VDD VSS DFFQX1
XFILLER_121_561 VSS VDD FILLER2
XFILLER_79_475 VDD VSS FILLER4
XFILLER_67_626 VSS VDD FILLER2
XFILLER_39_317 VDD VSS DECAPHV16
XFILLER_79_486 VDD VSS FILLER4
XFILLER_66_103 VSS VDD FILLER2
X_17824_ _19929_/Q _19897_/Q VDD VSS _17826_/B XNOR2X1
X_10159_ _11226_/D _10159_/B _10159_/C _18613_/Q VDD VSS _10172_/B AOAI211X1
XFILLER_67_648 VSS VDD FILLER2
XFILLER_94_456 VSS VDD FILLER2
XFILLER_48_851 VSS VDD FILLER2
XFILLER_82_607 VSS VDD FILLER2
X_14967_ _19532_/Q _15009_/C VDD VSS _14970_/B NAND2X1
X_17755_ _17758_/A _17758_/B _17828_/C VDD VSS _17756_/C OAI21X1
XFILLER_66_169 VSS VDD FILLER2
XFILLER_47_361 VSS VDD FILLER2
Xclkbuf_leaf_7_clk_regs clkbuf_leaf_9_clk_regs/A VDD VSS _19853_/CK BUFX12
X_16706_ _17812_/A VDD VSS _16724_/B BUFX3
X_13918_ _13918_/A _13918_/B _13918_/C _13918_/D VDD VSS _13924_/B AOAI211X1
X_14898_ _15297_/A _18073_/B VDD VSS _19281_/D AND2X1
X_17686_ _19898_/Q _19866_/Q VDD VSS _17688_/C _17686_/C AND3X2
XFILLER_74_180 VSS VDD FILLER2
XFILLER_90_640 VDD VSS FILLER1
X_19425_ _19463_/CK _19425_/D _19425_/Q VDD VSS DFFQX1
XFILLER_90_662 VDD VSS FILLER4
X_16637_ _19703_/Q _16865_/B VDD VSS _16638_/B XNOR2X1
X_13849_ _13860_/A _14329_/B _13850_/C VDD VSS _13849_/Y AOI21X1
XFILLER_35_578 VDD VSS FILLER4
XFILLER_90_695 VSS VDD FILLER2
X_19356_ _19385_/CK _19356_/D _19356_/Q VDD VSS DFFQX1
X_16568_ _19668_/Q _16826_/B VDD VSS _16569_/C NOR2X1
X_18307_ _18309_/CK _18499_/D _18307_/Q _20078_/RB VDD VSS DFFRQX1
XTAP_TAPCELL_ROW_60_554 VDD VSS WELLTAP
X_15519_ _15520_/A _15520_/B _15520_/C VDD VSS _15546_/C OA21X2
X_16499_ _16525_/A _16525_/B VDD VSS _16753_/B XNOR2X1
X_19287_ _19306_/CK _19287_/D _19287_/Q VDD VSS DFFQX1
XFILLER_148_436 VSS VDD FILLER2
XFILLER_31_795 VDD VSS FILLER4
X_18238_ _18240_/CK _18238_/D _18238_/Q _20080_/RB VDD VSS DFFRQX1
XFILLER_117_801 VDD VSS FILLER4
XFILLER_163_417 VSS VDD FILLER2
X_18169_ _19299_/Q _18169_/B VDD VSS _18170_/A NAND2X1
XFILLER_128_193 VSS VDD FILLER2
X_20200_ _20200_/A VDD VSS _20200_/Y BUFX3
XFILLER_143_130 VSS VDD FILLER2
XFILLER_132_804 VSS VDD FILLER2
X_20131_ _20131_/A VDD VSS _20131_/Y BUFX3
X_09942_ _09942_/A _09942_/B _11229_/A VDD VSS _09942_/Y OAI21X1
XFILLER_131_325 VDD VSS FILLER1
Xmax_cap187 _18518_/Q VDD VSS _18497_/D BUFX12
XFILLER_143_196 VDD VSS FILLER4
XFILLER_98_740 VDD VSS FILLER1
X_20062_ clkload6/A _20194_/A _20064_/D _20067_/RB VDD VSS DFFRQX1
X_09873_ _09871_/Y _09872_/Y _11229_/A VDD VSS _09874_/B MUXI2X1
XFILLER_58_615 VDD VSS FILLER4
XFILLER_112_594 VSS VDD FILLER2
XTAP_TAPCELL_ROW_68_621 VDD VSS WELLTAP
XFILLER_57_125 VSS VDD FILLER2
XFILLER_161_18 VDD VSS FILLER4
XFILLER_100_745 VSS VDD FILLER2
XFILLER_39_840 VSS VDD FILLER2
XFILLER_57_147 VDD VSS FILLER1
XFILLER_100_778 VDD VSS FILLER4
XFILLER_66_670 VSS VDD FILLER2
XFILLER_54_821 VDD VSS DECAPHV8
XFILLER_26_534 VSS VDD FILLER2
XFILLER_65_191 VDD VSS FILLER1
XFILLER_54_49 VDD VSS DECAPHV16
XFILLER_14_718 VDD VSS FILLER1
XFILLER_80_161 VSS VDD FILLER2
XFILLER_53_375 VSS VDD FILLER2
XFILLER_26_589 VSS VDD FILLER2
XFILLER_13_217 VSS VDD FILLER2
XFILLER_80_172 VDD VSS FILLER1
XFILLER_53_397 VSS VDD FILLER2
XFILLER_110_44 VSS VDD FILLER2
XTAP_TAPCELL_ROW_23_223 VDD VSS WELLTAP
X_09307_ _20080_/RB _09322_/B VDD VSS _09307_/Y NOR2BX1
XFILLER_110_77 VSS VDD FILLER2
XFILLER_139_447 VSS VDD FILLER2
XFILLER_70_59 VSS VDD FILLER2
XFILLER_127_609 VSS VDD FILLER2
X_09238_ _18512_/Q VDD VSS _18347_/D INVX1
XFILLER_21_294 VSS VDD FILLER2
XFILLER_154_406 VSS VDD FILLER2
XFILLER_126_119 VSS VDD FILLER2
XFILLER_107_300 VDD VSS FILLER4
XFILLER_119_64 VSS VDD FILLER2
XFILLER_119_193 VDD VSS FILLER1
X_11200_ _18709_/Q _18763_/Q _11200_/C VDD VSS _11228_/C AOI21X1
XFILLER_107_355 VDD VSS FILLER1
XFILLER_135_664 VDD VSS FILLER4
X_12180_ _12181_/D _14435_/B VDD VSS _12372_/A NAND2X1
XFILLER_135_675 VSS VDD FILLER2
X_11131_ _11132_/A _11132_/B _11132_/D _11132_/C VDD VSS _11134_/C AOAI211X1
XFILLER_134_196 VSS VDD FILLER2
XFILLER_122_347 VSS VDD FILLER2
X_09972__243 _20080_/CK VDD VSS _18519_/CK INVX1
XFILLER_150_678 VDD VSS FILLER4
X_11062_ _11556_/A _11616_/A _11062_/C VDD VSS _11064_/B MIN3X1
XFILLER_150_689 VSS VDD FILLER2
XFILLER_88_250 VDD VSS FILLER4
XFILLER_103_561 VSS VDD FILLER2
XFILLER_95_34 VSS VDD FILLER2
XFILLER_48_103 VSS VDD FILLER2
XFILLER_135_96 VSS VDD FILLER2
X_10013_ _18579_/Q _10013_/B VDD VSS _10042_/C NOR2BX1
XFILLER_1_699 VSS VDD FILLER2
X_15870_ _16776_/A VDD VSS _15895_/A BUFX3
XFILLER_76_423 VDD VSS FILLER1
XFILLER_95_67 VSS VDD FILLER2
X_14821_ _19501_/Q _14877_/C _14821_/C VDD VSS _14872_/A OR3BX1
XFILLER_64_607 VSS VDD FILLER2
XFILLER_45_810 VSS VDD FILLER2
X_14752_ _14837_/A _14837_/B _14837_/C VDD VSS _15831_/B OA21X2
X_17540_ _17675_/A _17540_/B VDD VSS _19868_/D NOR2X1
X_11964_ _19093_/Q _12018_/A _11964_/C VDD VSS _12083_/B MIN3X1
XFILLER_29_394 VSS VDD FILLER2
XFILLER_56_180 VSS VDD FILLER2
XFILLER_45_854 VSS VDD FILLER2
X_13703_ _13733_/A _13733_/B _13733_/D _13733_/C VDD VSS _14297_/B OAOI211X1
X_17471_ _19853_/Q _19821_/Q VDD VSS _17473_/B XOR2X1
X_10915_ _10915_/A _10921_/C VDD VSS _10917_/B XNOR2X1
XTAP_TAPCELL_ROW_74_679 VDD VSS WELLTAP
XFILLER_60_802 VSS VDD FILLER2
X_14683_ _14708_/A _14683_/B _14739_/C VDD VSS _15863_/B XNOR3X1
X_11895_ _11912_/B _11912_/C VDD VSS _14431_/B NAND2X1
XFILLER_72_684 VDD VSS DECAPHV8
XFILLER_60_824 VSS VDD FILLER2
X_19210_ _19217_/CK _19210_/D _19210_/Q VDD VSS DFFQX1
X_16422_ _19566_/Q _19918_/Q _16422_/C VDD VSS _16450_/C AOI2B1X1
X_13634_ _13634_/A _14483_/B _14453_/A VDD VSS _14454_/B OAI21X1
X_10846_ _10846_/A _10853_/B VDD VSS _10848_/B XNOR2X1
X_16353_ _16388_/B _16353_/B VDD VSS _16888_/B NAND2X1
X_19141_ _19196_/CK _19141_/D _19141_/Q VDD VSS DFFQX1
X_13565_ _19056_/Q _13565_/B _13728_/C VDD VSS _13610_/B XNOR3X1
XFILLER_12_250 VSS VDD FILLER2
XFILLER_13_784 VDD VSS FILLER1
X_10777_ _10467_/B _10776_/Y _11120_/A VDD VSS _10816_/B MUX2X1
X_15304_ _15304_/A _15783_/B VDD VSS _15305_/D OR2X2
X_19072_ _19072_/CK _19072_/D _19072_/Q VDD VSS DFFQX1
X_12516_ _19072_/Q _14345_/B _14345_/C VDD VSS _12517_/D OR3BX1
XFILLER_158_767 VSS VDD FILLER2
X_16284_ _19562_/Q _19914_/Q VDD VSS _16287_/A XNOR2X1
XFILLER_145_406 VDD VSS FILLER1
X_13496_ _18886_/Q _13496_/B _13496_/C VDD VSS _13497_/C MIN3X1
XTAP_TAPCELL_ROW_139_1266 VDD VSS WELLTAP
XFILLER_74_7 VSS VDD FILLER2
XFILLER_158_789 VDD VSS FILLER1
XFILLER_8_265 VSS VDD FILLER2
XFILLER_145_428 VDD VSS FILLER4
X_15235_ _19539_/Q _15237_/B VDD VSS _15276_/B XNOR2X1
X_18023_ _18056_/A _18023_/B _18056_/C VDD VSS _19969_/D OAI21X1
X_12447_ _12447_/A _12447_/B VDD VSS _14341_/B XNOR2X1
XFILLER_8_287 VSS VDD FILLER2
X_15166_ _19343_/Q _15717_/B VDD VSS _15167_/B XOR2X1
X_12378_ _12378_/A _12378_/B _12378_/C _12378_/D VDD VSS _14406_/C OAI211X1
XFILLER_126_686 VSS VDD FILLER2
X_14117_ _14118_/A _14117_/B VDD VSS _18877_/D NOR2X1
XFILLER_4_460 VSS VDD FILLER2
X_11329_ _11370_/A _11379_/B VDD VSS _11370_/C NAND2X1
X_15097_ _15901_/B VDD VSS _15098_/B INVX1
X_19974_ _19985_/CK _19974_/D _19974_/Q VDD VSS DFFQX1
XFILLER_140_133 VDD VSS FILLER4
Xclkbuf_leaf_4__001_ clkbuf_leaf_4__001_/A VDD VSS _19223_/CK BUFX12
X_18925_ _19171_/CK _18925_/D _18925_/Q VDD VSS DFFQX1
X_14048_ _18924_/Q _14086_/A _14061_/B VDD VSS _14085_/D XNOR3X1
XFILLER_140_155 VDD VSS FILLER1
XFILLER_141_689 VDD VSS FILLER4
XFILLER_39_103 VDD VSS FILLER4
XFILLER_95_732 VSS VDD FILLER2
XFILLER_39_114 VSS VDD FILLER2
X_18856_ _18915_/CK _18856_/D _18856_/Q VDD VSS DFFQX1
X_17807_ _19925_/Q _19893_/Q _17807_/C VDD VSS _17810_/B MIN3X1
X_18787_ _18788_/CK _18787_/D _18787_/Q VDD VSS DFFQX1
XTAP_TAPCELL_ROW_65_602 VDD VSS WELLTAP
X_15999_ _15999_/A _16035_/B VDD VSS _16767_/B XNOR2X1
X_17738_ _17738_/A _17738_/B _17738_/C _17738_/D VDD VSS _17739_/C AOAI211X1
XFILLER_82_459 VSS VDD FILLER2
XTAP_TAPCELL_ROW_37_348 VDD VSS WELLTAP
X_17669_ _17672_/A _17670_/B _17746_/C VDD VSS _17670_/C OAI21X1
XFILLER_35_375 VSS VDD FILLER2
XFILLER_51_835 VSS VDD FILLER2
XFILLER_50_312 VSS VDD FILLER2
X_19408_ _19412_/CK _19408_/D _19408_/Q VDD VSS DFFQX1
XFILLER_35_397 VDD VSS DECAPHV8
XFILLER_50_367 VDD VSS FILLER4
X_19339_ _19349_/CK _19339_/D _19339_/Q VDD VSS DFFQX1
XFILLER_136_428 VDD VSS DECAPHV8
XFILLER_40_29 VSS VDD FILLER2
XFILLER_117_620 VSS VDD FILLER2
XFILLER_129_480 VDD VSS FILLER1
XFILLER_116_130 VSS VDD FILLER2
XFILLER_163_269 VDD VSS FILLER1
XFILLER_105_815 VSS VDD FILLER2
XFILLER_132_601 VSS VDD FILLER2
XFILLER_144_472 VSS VDD FILLER2
XFILLER_104_336 VDD VSS FILLER4
XFILLER_116_196 VSS VDD FILLER2
Xclkbuf_leaf_23__000_ clkload70/A VDD VSS _19314_/CK BUFX12
X_20114_ _20114_/A VDD VSS _20114_/Y BUFX3
X_09925_ _09928_/C _09925_/B _09925_/C VDD VSS _09930_/B OAI21X1
XFILLER_132_678 VDD VSS FILLER4
XFILLER_86_721 VSS VDD FILLER2
X_20045_ _20045_/CK _20045_/D _20045_/Q _20045_/RB VDD VSS DFFRQX1
XFILLER_131_199 VSS VDD FILLER2
X_09856_ _18571_/Q _09858_/B VDD VSS _09864_/B NOR2BX1
XFILLER_100_531 VSS VDD FILLER2
Xclkbuf_1_1__f__09179_ clkbuf_0__09179_/Y VDD VSS _20022_/CK BUFX12
XFILLER_100_542 VSS VDD FILLER2
XFILLER_46_607 VSS VDD FILLER2
XFILLER_86_787 VSS VDD FILLER2
XFILLER_73_404 VSS VDD FILLER2
X_09787_ _18357_/Q wire176/Y _09787_/C _09787_/D VDD VSS _09788_/E OAI211X1
XFILLER_65_37 VSS VDD FILLER2
XFILLER_85_286 VDD VSS FILLER1
XFILLER_39_681 VDD VSS FILLER1
XFILLER_73_437 VDD VSS FILLER4
XFILLER_54_684 VDD VSS DECAPHV8
XFILLER_42_835 VSS VDD FILLER2
X_10700_ _10844_/B _10699_/Y _10843_/A VDD VSS _10987_/B MUX2X1
XFILLER_81_481 VSS VDD FILLER2
XFILLER_53_172 VDD VSS FILLER4
XTAP_TAPCELL_ROW_71_649 VDD VSS WELLTAP
XFILLER_81_36 VSS VDD FILLER2
X_11680_ _18817_/Q _14547_/B VDD VSS _18844_/D AND2X1
XFILLER_81_69 VSS VDD FILLER2
X_10631_ _11127_/A _10709_/A VDD VSS _10662_/A NAND2X1
X_13350_ _19222_/Q _13464_/A _13464_/B VDD VSS _13454_/C XNOR3X1
X_10562_ _10563_/A _10563_/B _10563_/D _10563_/C VDD VSS _10649_/B AOAI211X1
XFILLER_139_266 VSS VDD FILLER2
XFILLER_127_417 VDD VSS DECAPHV16
X_12301_ _19126_/Q _14405_/B VDD VSS _12380_/A NOR2BX1
X_13281_ _18913_/Q _13494_/B _14158_/B VDD VSS _13288_/C XNOR3X1
XFILLER_10_798 VDD VSS FILLER4
X_10493_ _18690_/Q _18744_/Q VDD VSS _10525_/C XNOR2X1
X_15020_ _15108_/B _15052_/D VDD VSS _15021_/C NAND2X1
XFILLER_5_235 VDD VSS FILLER1
XFILLER_108_653 VDD VSS DECAPHV8
X_12232_ _12101_/A _14529_/B _14529_/C VDD VSS _12234_/C AND3BX1
XFILLER_123_601 VSS VDD FILLER2
XTAP_TAPCELL_ROW_1_22 VDD VSS WELLTAP
XFILLER_163_770 VSS VDD FILLER2
X_12163_ _12401_/A _12401_/B VDD VSS _12172_/B NOR2X1
XFILLER_150_431 VSS VDD FILLER2
XFILLER_122_133 VDD VSS FILLER4
X_11114_ _11096_/Y _11114_/B _11114_/C VDD VSS _11116_/B OR3BX1
XFILLER_1_441 VSS VDD FILLER2
XFILLER_110_306 VDD VSS FILLER1
XFILLER_150_475 VSS VDD FILLER2
X_16971_ _16971_/A _16971_/B VDD VSS _16973_/B NAND2X1
X_12094_ _12234_/A _12234_/B VDD VSS _14498_/B XNOR2X1
XTAP_TAPCELL_ROW_79_727 VDD VSS WELLTAP
XFILLER_1_463 VSS VDD FILLER2
XFILLER_1_474 VSS VDD FILLER2
XFILLER_110_328 VDD VSS FILLER4
XFILLER_150_497 VSS VDD FILLER2
X_18710_ _18818_/CK _18710_/D _18710_/Q VDD VSS DFFQX1
X_15922_ _19899_/Q VDD VSS _16692_/A INVX1
X_11045_ _11062_/C _11045_/B VDD VSS _11046_/D XNOR2X1
X_19690_ _19695_/CK _19690_/D _19690_/Q VDD VSS DFFQX1
XFILLER_77_743 VDD VSS FILLER1
XFILLER_39_71 VSS VDD FILLER2
XFILLER_77_754 VSS VDD FILLER2
XFILLER_77_765 VSS VDD FILLER2
X_18641_ _18831_/CK _18641_/D _18641_/Q VDD VSS DFFQX1
X_15853_ _15879_/A _15853_/B VDD VSS _19464_/D AND2X1
XTAP_TAPCELL_ROW_87_793 VDD VSS WELLTAP
X_14804_ _19307_/Q _15677_/B VDD VSS _14809_/C NAND2X1
X_18572_ _18589_/CK _18572_/D _18572_/Q VDD VSS DFFQX1
XFILLER_64_448 VSS VDD FILLER2
X_15784_ _15800_/A _15784_/B VDD VSS _19403_/D NOR2X1
X_12996_ _12996_/A _12996_/B _12996_/C _12996_/D VDD VSS _14256_/B AOAI211X1
XFILLER_45_640 VDD VSS FILLER4
X_17523_ _19863_/Q _19831_/Q _17523_/C VDD VSS _17527_/B MIN3X1
X_14735_ _14781_/A _14781_/B VDD VSS _15864_/B XNOR2X1
X_11947_ _12015_/A _12015_/B _11955_/C VDD VSS _14271_/B XNOR3X1
XFILLER_51_109 VDD VSS FILLER4
XFILLER_17_375 VDD VSS FILLER4
XTAP_TAPCELL_ROW_34_318 VDD VSS WELLTAP
XFILLER_33_835 VSS VDD FILLER2
XFILLER_32_323 VSS VDD FILLER2
X_17454_ _19850_/Q _19818_/Q VDD VSS _17460_/A XNOR2X1
X_14666_ _19387_/Q VDD VSS _14667_/A INVX1
X_11878_ _19203_/Q _14492_/B VDD VSS _11918_/D _14492_/C NAND3X1
X_16405_ _16406_/A _16406_/B _16406_/C VDD VSS _16433_/B OA21X2
X_13617_ _13617_/A _13617_/B _13617_/C _13617_/D VDD VSS _14420_/B AOAI211X1
XFILLER_20_507 VDD VSS FILLER4
X_10829_ _18671_/Q _18779_/Q VDD VSS _10871_/A NAND2X1
XFILLER_20_518 VSS VDD FILLER2
X_17385_ _19834_/Q _19802_/Q VDD VSS _17387_/C _17385_/C AND3X2
X_14597_ _14601_/A _14601_/B _14615_/B _14601_/D VDD VSS _14645_/B AO211X2
XFILLER_13_592 VDD VSS FILLER4
X_19124_ _19134_/CK _19124_/D _19124_/Q VDD VSS DFFQX1
XFILLER_146_704 VDD VSS FILLER1
X_16336_ _19595_/Q _16745_/B VDD VSS _16337_/C NOR2X1
X_13548_ _13548_/A _14388_/B _13614_/C _13548_/D VDD VSS _13714_/A OAOI211X1
XTAP_TAPCELL_ROW_42_395 VDD VSS WELLTAP
XFILLER_158_564 VSS VDD FILLER2
XFILLER_118_439 VSS VDD FILLER2
X_16267_ _16267_/A _16267_/B _16267_/C VDD VSS _16268_/B NOR3X1
X_19055_ _19119_/CK _19055_/D _19055_/Q VDD VSS DFFQX1
X_13479_ _18998_/Q _14260_/B VDD VSS _13511_/C _14260_/C NAND3X1
X_15218_ _15218_/A _15218_/B _15718_/B VDD VSS _15293_/B MIN3X1
X_18006_ _18058_/B _18006_/B _18006_/C VDD VSS _18049_/B OAI21X1
XFILLER_161_707 VDD VSS FILLER4
XFILLER_161_718 VDD VSS FILLER4
X_16198_ _19718_/Q _16882_/B VDD VSS _16222_/A NOR2X1
XFILLER_126_461 VDD VSS FILLER1
XFILLER_160_228 VDD VSS FILLER4
X_15149_ _19510_/Q _15149_/B VDD VSS _15191_/C NAND2X1
XFILLER_141_420 VSS VDD FILLER2
XFILLER_153_291 VSS VDD FILLER2
XFILLER_114_656 VDD VSS DECAPHV8
X_19957_ _19959_/CK _19957_/D _19957_/Q VDD VSS DFFQX1
XFILLER_87_518 VSS VDD FILLER2
XFILLER_141_486 VDD VSS FILLER4
X_09710_ _20171_/A _09784_/C _09797_/C _20220_/A VDD VSS _09711_/D AOI22X1
X_18908_ _18939_/CK _18908_/D _18908_/Q VDD VSS DFFQX1
XFILLER_67_220 VDD VSS FILLER1
X_19888_ clkload9/A _19888_/D _19888_/Q VDD VSS DFFQX1
XFILLER_110_851 VSS VDD FILLER2
XFILLER_67_231 VSS VDD FILLER2
XFILLER_28_607 VSS VDD FILLER2
X_09641_ _18428_/Q _09696_/B _09641_/C _09641_/D VDD VSS _09642_/E OAI211X1
X_18839_ _19959_/CK _18839_/D _18839_/Q VDD VSS DFFQX1
XFILLER_27_106 VSS VDD FILLER2
XFILLER_27_128 VSS VDD FILLER2
X_09572_ _20117_/A _09767_/B VDD VSS _09573_/C NAND2X1
XFILLER_35_18 VSS VDD FILLER2
XFILLER_24_813 VSS VDD FILLER2
XFILLER_82_289 VDD VSS FILLER4
XFILLER_23_301 VDD VSS FILLER1
XFILLER_63_481 VSS VDD FILLER2
XFILLER_51_632 VDD VSS FILLER4
XFILLER_51_654 VSS VDD FILLER2
XFILLER_50_142 VSS VDD FILLER2
XFILLER_137_715 VSS VDD FILLER2
XFILLER_129_8 VSS VDD FILLER2
XFILLER_164_567 VDD VSS FILLER1
XFILLER_136_269 VSS VDD FILLER2
XFILLER_152_718 VSS VDD FILLER2
XFILLER_145_770 VSS VDD FILLER2
XFILLER_105_667 VSS VDD FILLER2
XFILLER_104_144 VDD VSS FILLER1
XFILLER_120_615 VDD VSS FILLER4
XFILLER_120_626 VSS VDD FILLER2
XFILLER_104_188 VDD VSS FILLER4
XFILLER_59_732 VSS VDD FILLER2
XFILLER_104_199 VDD VSS FILLER4
X_09908_ _11014_/A _09908_/B VDD VSS _09909_/C NOR2X1
XFILLER_101_840 VSS VDD FILLER2
XFILLER_76_36 VDD VSS DECAPHV8
XFILLER_86_551 VSS VDD FILLER2
X_20028_ _20033_/CK _20028_/D _20028_/Q _20030_/RB VDD VSS DFFRQX1
X_09839_ _18564_/Q _11195_/A VDD VSS _09910_/B XNOR2X1
XFILLER_73_212 VDD VSS FILLER4
XFILLER_18_117 VSS VDD FILLER2
XFILLER_73_223 VDD VSS FILLER4
X_12850_ _20008_/Q _19272_/Q VDD VSS _12955_/C NAND2X1
X_11801_ _19229_/Q _14523_/B VDD VSS _11828_/C _14523_/C AND3X2
XFILLER_15_802 VDD VSS FILLER4
XFILLER_33_109 VSS VDD FILLER2
X_12781_ _12779_/Y _12872_/B VDD VSS _14253_/B NAND2BX1
XFILLER_61_429 VDD VSS FILLER4
XFILLER_92_68 VSS VDD FILLER2
XFILLER_15_835 VSS VDD FILLER2
X_14520_ _14539_/A _14520_/B VDD VSS _19227_/D NOR2X1
XFILLER_15_846 VSS VDD FILLER2
XFILLER_14_323 VSS VDD FILLER2
X_11732_ _19170_/Q _14455_/B VDD VSS _11733_/B OR2X2
XFILLER_54_492 VDD VSS FILLER4
XFILLER_25_40 VSS VDD FILLER2
XFILLER_42_643 VSS VDD FILLER2
XFILLER_26_194 VDD VSS FILLER1
XFILLER_41_131 VSS VDD FILLER2
XFILLER_25_73 VDD VSS FILLER4
XFILLER_159_328 VSS VDD FILLER2
XFILLER_148_0 VDD VSS FILLER4
X_14451_ _14490_/A _14451_/B _14451_/C VDD VSS _19166_/D NOR3X1
X_11663_ _18802_/Q _11669_/B VDD VSS _18829_/D AND2X1
Xclkbuf_leaf_3__002_ clkbuf_leaf_9__002_/A VDD VSS _18823_/CK BUFX12
XFILLER_41_175 VDD VSS FILLER4
XFILLER_30_838 VSS VDD FILLER2
X_13402_ _13402_/A _13402_/B _13402_/C _13402_/D VDD VSS _14192_/B OAOI211X1
X_17170_ _19788_/Q _19756_/Q _17170_/C VDD VSS _17176_/C AO21X2
X_10614_ _18638_/Q _18800_/Q VDD VSS _10638_/A NAND2X1
XFILLER_41_197 VSS VDD FILLER2
XFILLER_128_704 VDD VSS FILLER1
X_14382_ _14381_/Y _14382_/B _14382_/C VDD VSS _19104_/D AND3BX1
X_11594_ _18739_/Q _11600_/B VDD VSS _18766_/D AND2X1
XFILLER_155_501 VDD VSS FILLER1
XFILLER_128_726 VDD VSS FILLER4
X_16121_ _19683_/Q _16843_/B VDD VSS _16122_/B XNOR2X1
XFILLER_128_748 VDD VSS FILLER1
X_13333_ _13356_/A _14449_/B _14449_/C VDD VSS _13334_/D NOR3X1
XFILLER_155_523 VDD VSS DECAPHV8
XFILLER_10_573 VSS VDD FILLER2
XFILLER_127_225 VSS VDD FILLER2
X_10545_ _10543_/Y _10592_/B _11431_/A VDD VSS _18558_/D AND3BX1
XFILLER_127_236 VSS VDD FILLER2
XTAP_TAPCELL_ROW_136_1236 VDD VSS WELLTAP
XFILLER_155_556 VSS VDD FILLER2
X_16052_ _16100_/A _16052_/B VDD VSS _19520_/D NOR2X1
XFILLER_6_555 VDD VSS FILLER1
X_13264_ _19193_/Q _13457_/A _13466_/B VDD VSS _13443_/D XNOR3X1
X_10476_ _10476_/A _10476_/B _10476_/C _10476_/D VDD VSS _10481_/C OAOI211X1
XFILLER_6_577 VSS VDD FILLER2
XFILLER_108_472 VDD VSS FILLER1
X_15003_ _15003_/A _15805_/B _15003_/C _15003_/D VDD VSS _15092_/A AOAI211X1
X_12215_ _14436_/C _19153_/Q _12382_/B VDD VSS _12372_/D AND3BX1
X_13195_ _13373_/A _13195_/B VDD VSS _14258_/B XNOR2X1
XFILLER_123_453 VSS VDD FILLER2
X_19811_ _19825_/CK _19811_/D _19811_/Q VDD VSS DFFQX1
X_12146_ wire160/Y _12181_/B _12147_/D _12181_/E VDD VSS _14403_/B OA211X2
XFILLER_111_626 VDD VSS FILLER4
XFILLER_97_849 VSS VDD FILLER2
X_19742_ _19841_/CK _19742_/D _19742_/Q VDD VSS DFFQX1
XFILLER_110_136 VSS VDD FILLER2
X_16954_ _16954_/A _16956_/B VDD VSS _16955_/B XOR2X1
X_12077_ _19039_/Q _12077_/B _12077_/C VDD VSS _12189_/B MIN3X1
XFILLER_49_220 VDD VSS FILLER4
XFILLER_1_282 VDD VSS FILLER4
XFILLER_2_33 VSS VDD FILLER2
XFILLER_77_551 VDD VSS FILLER4
X_15905_ _15906_/A _15905_/B VDD VSS _19511_/D NOR2X1
X_11028_ _18650_/Q VDD VSS _11495_/A INVX1
XTAP_TAPCELL_ROW_147_1332 VDD VSS WELLTAP
X_19673_ _19705_/CK _19673_/D _19673_/Q VDD VSS DFFQX1
X_16885_ _16891_/A _16885_/B VDD VSS _19721_/D NOR2X1
XFILLER_92_510 VDD VSS FILLER1
XFILLER_65_724 VSS VDD FILLER2
X_18624_ _18625_/CK _18624_/D _18624_/Q VDD VSS DFFQX1
X_15836_ _15054_/B _15836_/B _15836_/C VDD VSS _19451_/D AND3BX1
XFILLER_37_448 VSS VDD FILLER2
XTAP_TAPCELL_ROW_47_432 VDD VSS WELLTAP
X_18555_ _18583_/CK _18555_/D _18555_/Q VDD VSS DFFQX1
XFILLER_24_109 VSS VDD FILLER2
X_15767_ _15780_/A _15767_/B VDD VSS _19389_/D NOR2X1
X_12979_ _13198_/A _13198_/B _13198_/C VDD VSS _12994_/B OAI21X1
XFILLER_80_738 VSS VDD FILLER2
XFILLER_18_695 VSS VDD FILLER2
X_17506_ _19860_/Q VDD VSS _17657_/B INVX1
X_14718_ _14776_/A _14776_/B _14734_/C VDD VSS _15799_/B XNOR3X1
X_18486_ _18487_/CK _18523_/Q _20131_/A _18486_/RB VDD VSS DFFRQX1
XFILLER_33_654 VSS VDD FILLER2
X_15698_ _15710_/A _15698_/B VDD VSS _19326_/D NOR2X1
XFILLER_32_142 VSS VDD FILLER2
XFILLER_32_153 VSS VDD FILLER2
X_17437_ _19846_/Q _19814_/Q VDD VSS _17439_/D XNOR2X1
Xclkbuf_leaf_22__001_ clkload33/A VDD VSS _18999_/CK BUFX12
XFILLER_20_304 VSS VDD FILLER2
X_14649_ _19523_/Q _19524_/Q _14649_/C _19525_/Q VDD VSS _14705_/C AOI31X1
XFILLER_159_840 VSS VDD FILLER2
XANTENNA_16 _20113_/A VDD VSS ANTENNA2
XFILLER_21_849 VSS VDD FILLER2
X_17368_ _17838_/A VDD VSS _17452_/C BUFX3
XFILLER_118_203 VSS VDD FILLER2
XFILLER_9_360 VSS VDD FILLER2
XFILLER_146_523 VDD VSS FILLER1
X_19107_ _19139_/CK _19107_/D _19107_/Q VDD VSS DFFQX1
X_16319_ _16320_/A _16320_/B _16320_/C VDD VSS _16335_/C OA21X2
X_17299_ _19816_/Q VDD VSS _17450_/B INVX1
XFILLER_63_0 VSS VDD FILLER2
XFILLER_134_718 VSS VDD FILLER2
XFILLER_146_578 VSS VDD FILLER2
X_19038_ _19068_/CK _19038_/D _19038_/Q VDD VSS DFFQX1
Xclkbuf_leaf_37__001_ clkbuf_leaf_4__001_/A VDD VSS _19185_/CK BUFX12
XFILLER_127_770 VSS VDD FILLER2
Xoutput101 _20170_/Y VDD VSS o_lf_cfg[7] BUFX3
Xoutput112 _20196_/Y VDD VSS o_tst_ctrl[15] BUFX3
XFILLER_161_537 VDD VSS DECAPHV16
Xoutput123 _20207_/Y VDD VSS o_uwb_tx_cfg[10] BUFX3
XFILLER_126_280 VSS VDD FILLER2
Xoutput134 _20217_/Y VDD VSS o_uwb_tx_cfg[20] BUFX3
Xoutput145 _20200_/Y VDD VSS o_uwb_tx_cfg[3] BUFX3
XTAP_TAPCELL_ROW_113_1033 VDD VSS WELLTAP
XFILLER_99_142 VSS VDD FILLER2
XFILLER_142_773 VSS VDD FILLER2
XFILLER_101_103 VDD VSS FILLER4
XFILLER_101_114 VSS VDD FILLER2
XFILLER_87_337 VDD VSS FILLER4
XFILLER_87_348 VSS VDD FILLER2
XFILLER_101_147 VSS VDD FILLER2
XTAP_TAPCELL_ROW_98_899 VDD VSS WELLTAP
XFILLER_56_724 VDD VSS DECAPHV8
XFILLER_95_370 VSS VDD FILLER2
XFILLER_28_426 VDD VSS FILLER4
XFILLER_95_381 VDD VSS FILLER1
XFILLER_68_595 VDD VSS FILLER1
X_09624_ _09626_/B _09624_/B _09788_/B _20104_/A VDD VSS _09635_/A AOI22X1
XTAP_TAPCELL_ROW_165_1498 VDD VSS WELLTAP
XFILLER_55_256 VSS VDD FILLER2
X_09555_ _18392_/Q VDD VSS _20133_/A INVX1
XFILLER_70_215 VSS VDD FILLER2
XFILLER_36_492 VDD VSS FILLER1
XFILLER_24_632 VSS VDD FILLER2
XTAP_TAPCELL_ROW_81_744 VDD VSS WELLTAP
X_09486_ _19981_/Q _09490_/B _09507_/B VDD VSS _09487_/C AOI21X1
XFILLER_62_49 VSS VDD FILLER2
XFILLER_12_827 VSS VDD FILLER2
XFILLER_12_849 VSS VDD FILLER2
XFILLER_8_809 VDD VSS FILLER1
XFILLER_11_348 VSS VDD FILLER2
XFILLER_109_203 VSS VDD FILLER2
XFILLER_137_556 VSS VDD FILLER2
XFILLER_125_707 VDD VSS FILLER4
XFILLER_164_353 VSS VDD FILLER2
X_10330_ _10328_/Y _10330_/B _10413_/B VDD VSS _10345_/B AND3BX1
XFILLER_127_20 VSS VDD FILLER2
XFILLER_11_64 VDD VSS FILLER1
XFILLER_152_537 VDD VSS FILLER1
X_10261_ _18657_/Q _18765_/Q VDD VSS _10263_/C XOR2X1
XFILLER_117_291 VSS VDD FILLER2
XFILLER_3_547 VSS VDD FILLER2
X_12000_ _12031_/A _12031_/B _12031_/C VDD VSS _12026_/B OAI21X1
XFILLER_105_464 VDD VSS FILLER1
XFILLER_127_86 VSS VDD FILLER2
XFILLER_78_304 VSS VDD FILLER2
XFILLER_105_475 VDD VSS DECAPHV8
X_10192_ _18617_/Q _10193_/B VDD VSS _10200_/D NAND2BX1
XTAP_TAPCELL_ROW_89_811 VDD VSS WELLTAP
XFILLER_133_795 VSS VDD FILLER2
XFILLER_132_272 VDD VSS FILLER1
XTAP_TAPCELL_ROW_131_1188 VDD VSS WELLTAP
XFILLER_78_348 VDD VSS FILLER4
XFILLER_143_41 VDD VSS FILLER4
XFILLER_120_489 VDD VSS FILLER1
X_13951_ _13951_/A _13951_/B _13951_/C VDD VSS _13955_/B XNOR3X1
XFILLER_74_532 VSS VDD FILLER2
XFILLER_46_223 VSS VDD FILLER2
XFILLER_143_96 VSS VDD FILLER2
X_12902_ _18993_/Q _14254_/B VDD VSS _13198_/A AND2X1
X_16670_ _19704_/Q _16670_/B _16867_/B VDD VSS _16687_/A MIN3X1
X_13882_ _18947_/Q _14197_/B VDD VSS _13924_/A NAND2X1
X_15621_ _19439_/Q VDD VSS _15622_/A INVX1
X_12833_ _12951_/A _12951_/B VDD VSS _14509_/B XNOR2X1
XFILLER_15_610 VSS VDD FILLER2
XTAP_TAPCELL_ROW_44_413 VDD VSS WELLTAP
XFILLER_27_481 VSS VDD FILLER2
X_18340_ _18341_/CK _18340_/D _18340_/Q _18491_/RB VDD VSS DFFRQX1
X_15552_ _15552_/A _15552_/B _15552_/C VDD VSS _15553_/B NOR3X1
X_12764_ _12955_/A _12955_/B VDD VSS _12966_/B NAND2X1
XFILLER_61_259 VSS VDD FILLER2
XFILLER_15_654 VSS VDD FILLER2
XFILLER_14_142 VSS VDD FILLER2
XTAP_TAPCELL_ROW_7_76 VDD VSS WELLTAP
XTAP_TAPCELL_ROW_16_159 VDD VSS WELLTAP
XTAP_TAPCELL_ROW_142_1295 VDD VSS WELLTAP
X_14503_ _15806_/A _14503_/B _14503_/C VDD VSS _19211_/D NOR3X1
X_11715_ _11724_/A _11724_/B _11724_/C VDD VSS _14519_/B OAI21X1
XFILLER_70_771 VSS VDD FILLER2
XFILLER_30_602 VSS VDD FILLER2
X_15483_ _15511_/A _15511_/B VDD VSS _15820_/B XNOR2X1
X_18271_ _18275_/CK _18271_/D _18271_/Q _18486_/RB VDD VSS DFFRQX1
X_12695_ _12712_/A _12712_/B _12705_/C VDD VSS _14183_/B XNOR3X1
XFILLER_70_793 VDD VSS FILLER4
X_17222_ _19799_/Q _19767_/Q _17222_/C VDD VSS _17227_/A AOI21X1
XFILLER_159_169 VDD VSS DECAPHV8
X_14434_ _14449_/A _14434_/B _14434_/C VDD VSS _19151_/D NOR3X1
X_11646_ _18787_/Q _11647_/B VDD VSS _18814_/D AND2X1
XFILLER_128_523 VDD VSS FILLER4
XFILLER_128_534 VSS VDD FILLER2
X_17153_ _17156_/C _17154_/B _17164_/C VDD VSS _17154_/C OAI21X1
X_14365_ _14415_/A _14365_/B VDD VSS _19089_/D AND2X1
XTAP_TAPCELL_ROW_0_9 VDD VSS WELLTAP
XFILLER_155_320 VDD VSS FILLER1
X_11577_ _18724_/Q _11578_/B VDD VSS _18751_/D AND2X1
XFILLER_6_330 VDD VSS FILLER1
X_16104_ _19682_/Q _16104_/B _16842_/B VDD VSS _16129_/B MIN3X1
X_13316_ _13316_/A _13316_/B _13316_/C _13316_/D VDD VSS _13318_/C OAI211X1
X_17084_ _19770_/Q _19738_/Q _17085_/C VDD VSS _17086_/B AOI21X1
X_10528_ _10522_/Y _10528_/B _10527_/Y _10875_/C VDD VSS _10579_/B AOI2B2BX1
X_14296_ _17566_/A VDD VSS _14352_/A BUFX3
XFILLER_155_375 VSS VDD FILLER2
XFILLER_143_526 VDD VSS FILLER4
X_16035_ _15999_/A _16035_/B _16035_/C VDD VSS _16060_/B AOI2B1X1
X_13247_ _19220_/Q VDD VSS _13253_/A INVX1
X_10459_ _10460_/A _10460_/B _10460_/D _10460_/C VDD VSS _10525_/B AOAI211X1
XTAP_TAPCELL_ROW_153_1391 VDD VSS WELLTAP
X_13178_ _13178_/A _13178_/B _13178_/C VDD VSS _14124_/B XNOR3X1
XFILLER_97_613 VDD VSS FILLER1
XFILLER_96_101 VDD VSS FILLER1
XFILLER_123_272 VSS VDD FILLER2
X_12129_ _12129_/A _12129_/B _14176_/B VDD VSS _12198_/B MIN3X1
XFILLER_85_808 VDD VSS DECAPHV8
X_17986_ _17984_/Y _17986_/B _17986_/C VDD VSS _19962_/D AND3BX1
XFILLER_97_679 VDD VSS FILLER4
X_19725_ _19730_/CK _19725_/D _19725_/Q VDD VSS DFFQX1
XFILLER_111_489 VSS VDD FILLER2
X_16937_ _16937_/A _16937_/B _16937_/C VDD VSS _16943_/C OAI21X1
X_19656_ _19695_/CK _19656_/D _19656_/Q VDD VSS DFFQX1
XTAP_TAPCELL_ROW_95_869 VDD VSS WELLTAP
XFILLER_65_543 VDD VSS FILLER1
X_16868_ _16876_/A _16868_/B VDD VSS _19705_/D NOR2X1
XFILLER_92_340 VDD VSS FILLER4
X_18607_ _18612_/CK _18607_/D _18607_/Q VDD VSS DFFQX1
XFILLER_80_502 VDD VSS FILLER1
XFILLER_37_267 VSS VDD FILLER2
X_15819_ _15849_/A _15819_/B VDD VSS _19434_/D AND2X1
X_19587_ _19667_/CK _19587_/D _19587_/Q VDD VSS DFFQX1
X_16799_ _17391_/A VDD VSS _16811_/A BUFX3
X_09340_ _20073_/RB _09346_/B VDD VSS _09340_/Y NOR2BX1
X_18538_ _18550_/CK _18538_/D _18538_/Q VDD VSS DFFQX1
X_09271_ _18277_/Q _18276_/Q VDD VSS _09273_/B XNOR2X1
X_18469_ _18469_/CK _18501_/D _18469_/Q _18469_/RB VDD VSS DFFRQX1
XFILLER_21_646 VDD VSS FILLER4
XFILLER_119_512 VDD VSS FILLER1
XFILLER_159_692 VDD VSS DECAPHV8
XFILLER_158_180 VDD VSS FILLER1
XFILLER_107_718 VSS VDD FILLER2
XFILLER_119_589 VSS VDD FILLER2
XFILLER_162_824 VSS VDD FILLER2
XFILLER_161_301 VSS VDD FILLER2
XFILLER_134_537 VSS VDD FILLER2
XFILLER_164_18 VSS VDD FILLER2
XFILLER_115_762 VDD VSS FILLER4
XFILLER_88_602 VSS VDD FILLER2
XFILLER_142_570 VSS VDD FILLER2
XFILLER_0_528 VSS VDD FILLER2
XFILLER_88_646 VSS VDD FILLER2
XFILLER_87_112 VDD VSS FILLER4
XFILLER_102_467 VSS VDD FILLER2
XFILLER_29_702 VSS VDD FILLER2
XFILLER_87_189 VSS VDD FILLER2
XTAP_TAPCELL_ROW_58_538 VDD VSS WELLTAP
X_09607_ _20154_/A _09784_/B VDD VSS _09609_/C NAND2X1
XFILLER_83_384 VSS VDD FILLER2
X_09538_ _20032_/Q _09547_/B VDD VSS _20033_/D NOR2BX1
XTAP_TAPCELL_ROW_106_970 VDD VSS WELLTAP
XFILLER_12_602 VSS VDD FILLER2
XFILLER_24_462 VSS VDD FILLER2
X_09469_ _09496_/B VDD VSS _09490_/B BUFX3
XFILLER_24_473 VSS VDD FILLER2
XFILLER_52_793 VSS VDD FILLER2
XFILLER_11_123 VDD VSS FILLER1
XFILLER_12_646 VSS VDD FILLER2
X_11500_ _18654_/Q _11508_/B VDD VSS _18681_/D AND2X1
XTAP_TAPCELL_ROW_13_129 VDD VSS WELLTAP
X_12480_ _12480_/A _14406_/B _12480_/C _12480_/D VDD VSS _12643_/A AOAI211X1
XFILLER_11_156 VSS VDD FILLER2
XFILLER_11_167 VSS VDD FILLER2
X_11431_ _11431_/A _11431_/B VDD VSS _18624_/D AND2X1
XFILLER_11_189 VSS VDD FILLER2
XFILLER_137_353 VDD VSS FILLER1
X_14150_ _14154_/A _14150_/B VDD VSS _18906_/D NOR2X1
XFILLER_22_74 VSS VDD FILLER2
XFILLER_137_364 VDD VSS DECAPHV8
X_11362_ _11383_/A _11362_/B VDD VSS _18590_/D NOR2X1
XTAP_TAPCELL_ROW_133_1206 VDD VSS WELLTAP
XFILLER_137_375 VSS VDD FILLER2
XFILLER_153_835 VSS VDD FILLER2
X_13101_ _13101_/A _14384_/B VDD VSS _13161_/A OR2X2
X_10313_ _11436_/C _10313_/B VDD VSS _10314_/B NOR2X1
XFILLER_152_334 VSS VDD FILLER2
X_14081_ _14086_/A _14086_/B _14086_/D _14086_/C VDD VSS _14174_/B OA211X2
X_11293_ _18583_/Q _11296_/C VDD VSS _11295_/B XOR2X1
X_13032_ _13032_/A _13032_/B _13032_/C VDD VSS _13039_/B XNOR3X1
XFILLER_98_78 VSS VDD FILLER2
XFILLER_105_250 VSS VDD FILLER2
X_10244_ _11436_/C _10358_/B _10358_/C VDD VSS _10550_/A OAI21X1
XFILLER_79_624 VSS VDD FILLER2
XFILLER_121_743 VDD VSS FILLER1
X_17840_ _19935_/Q _17842_/C _17840_/C VDD VSS _19935_/D AOI21X1
XFILLER_120_231 VDD VSS FILLER1
X_10175_ _11435_/B _10175_/B _11226_/D _10175_/D VDD VSS _10177_/B AOI2B2X1
XFILLER_67_808 VSS VDD FILLER2
Xclkbuf_leaf_21__002_ clkload16/A VDD VSS _19963_/CK BUFX12
XFILLER_121_787 VSS VDD FILLER2
XFILLER_94_627 VDD VSS FILLER4
X_17771_ _17806_/A _17771_/B VDD VSS _19917_/D NOR2X1
XFILLER_94_638 VDD VSS FILLER4
X_14983_ _14992_/B _14983_/B VDD VSS _15713_/B XNOR2X1
Xfanout180 _18627_/Q VDD VSS _11435_/B BUFX3
XFILLER_59_370 VSS VDD FILLER2
Xfanout191 _09816_/D VDD VSS _09626_/B BUFX3
X_19510_ _19734_/CK _19510_/D _19510_/Q VDD VSS DFFQX1
X_16722_ _16722_/A _16724_/B VDD VSS _19573_/D NOR2X1
X_13934_ _14167_/B _14167_/C _18920_/Q VDD VSS _13938_/B AOI21X1
XTAP_TAPCELL_ROW_144_1313 VDD VSS WELLTAP
XFILLER_93_159 VSS VDD FILLER2
X_19441_ _19531_/CK _19441_/D _19441_/Q VDD VSS DFFQX1
XFILLER_47_587 VDD VSS FILLER4
X_16653_ _19576_/Q _19928_/Q VDD VSS _16654_/B XNOR2X1
XTAP_TAPCELL_ROW_92_839 VDD VSS WELLTAP
X_13865_ _13989_/A _13865_/B _13987_/C VDD VSS _13884_/C XNOR3X1
XTAP_TAPCELL_ROW_29_273 VDD VSS WELLTAP
X_15604_ _19411_/Q _15792_/B VDD VSS _15605_/B XNOR2X1
X_19372_ _19573_/CK _19372_/D _19372_/Q VDD VSS DFFQX1
X_12816_ _12816_/A _12816_/B _12816_/C _12816_/D VDD VSS _13107_/A AOAI211X1
X_16584_ _16585_/A _16585_/B _16585_/C VDD VSS _16620_/B OAI21X1
X_13796_ _19059_/Q _13831_/B _13850_/C VDD VSS _13846_/B XOR3X1
X_18323_ _18325_/CK _18520_/Q _18323_/Q _18450_/RB VDD VSS DFFRQX1
XFILLER_63_70 VSS VDD FILLER2
X_15535_ _15532_/A _15535_/B VDD VSS _15564_/B NAND2BX1
X_12747_ _12747_/A _14443_/B _14443_/C VDD VSS _12748_/D NOR3X1
XFILLER_97_6 VSS VDD FILLER2
XFILLER_15_484 VSS VDD FILLER2
XFILLER_30_421 VDD VSS FILLER4
XFILLER_148_607 VDD VSS DECAPHV16
XFILLER_30_432 VSS VDD FILLER2
XFILLER_148_629 VSS VDD FILLER2
X_18254_ _18257_/CK _18254_/D _18263_/D _20080_/RB VDD VSS DFFRQX1
X_15466_ _19406_/Q _15787_/B _15466_/C VDD VSS _15525_/A AOI21X1
X_12678_ _19242_/Q _12763_/A _12678_/C VDD VSS _12755_/D XNOR3X1
X_17205_ _17206_/A _17208_/C _17229_/C VDD VSS _17206_/C OAI21X1
X_14417_ _14381_/Y _14417_/B _14417_/C VDD VSS _19137_/D AND3BX1
X_11629_ _18771_/Q _11635_/B VDD VSS _18798_/D AND2X1
X_18185_ _18185_/A _18185_/B _18185_/C VDD VSS _18191_/C AO21X2
X_15397_ _19515_/Q VDD VSS _15398_/A INVX1
XFILLER_156_651 VSS VDD FILLER2
X_17136_ _17140_/A _17137_/B _17164_/C VDD VSS _17137_/C OAI21X1
X_14348_ _14316_/Y _14348_/B _14348_/C VDD VSS _19075_/D AND3BX1
XFILLER_128_386 VSS VDD FILLER2
XFILLER_156_695 VSS VDD FILLER2
XFILLER_155_161 VSS VDD FILLER2
XFILLER_143_334 VSS VDD FILLER2
X_17067_ _17536_/A _17067_/B _17068_/C VDD VSS _19766_/D NOR3X1
X_14279_ _14279_/A _14279_/B VDD VSS _14280_/B XNOR2X1
X_16018_ _19674_/Q _16833_/B VDD VSS _16869_/B XNOR2X1
XTAP_TAPCELL_ROW_110_1003 VDD VSS WELLTAP
XFILLER_124_592 VSS VDD FILLER2
XFILLER_69_134 VDD VSS DECAPHV16
XFILLER_97_454 VSS VDD FILLER2
XFILLER_69_167 VSS VDD FILLER2
XFILLER_85_627 VSS VDD FILLER2
X_17969_ _18870_/Q _17969_/B VDD VSS _17971_/C XNOR2X1
XFILLER_69_189 VSS VDD FILLER2
XFILLER_57_329 VSS VDD FILLER2
XFILLER_38_510 VDD VSS FILLER1
XFILLER_111_286 VSS VDD FILLER2
XFILLER_85_649 VSS VDD FILLER2
XFILLER_84_137 VSS VDD FILLER2
X_19708_ _19724_/CK _19708_/D _19708_/Q VDD VSS DFFQX1
XFILLER_84_148 VDD VSS FILLER1
XTAP_TAPCELL_ROW_55_508 VDD VSS WELLTAP
XFILLER_65_351 VSS VDD FILLER2
XFILLER_93_671 VSS VDD FILLER2
X_19639_ _19705_/CK _19639_/D _19639_/Q VDD VSS DFFQX1
XFILLER_53_513 VDD VSS FILLER1
XTAP_TAPCELL_ROW_162_1468 VDD VSS WELLTAP
XFILLER_80_343 VDD VSS FILLER4
XFILLER_53_557 VDD VSS FILLER1
XFILLER_53_568 VSS VDD FILLER2
X_09323_ _18289_/Q _18517_/Q _09299_/Y VDD VSS _09323_/Y MUXI2X1
XTAP_TAPCELL_ROW_103_940 VDD VSS WELLTAP
XFILLER_43_29 VSS VDD FILLER2
XFILLER_34_793 VDD VSS DECAPHV8
X_09254_ _18279_/Q _09408_/C _09299_/A VDD VSS _09351_/B AOI21BX1
XFILLER_166_426 VSS VDD FILLER2
XFILLER_21_487 VDD VSS FILLER1
XFILLER_147_662 VDD VSS FILLER4
XFILLER_135_813 VDD VSS FILLER4
XFILLER_119_375 VSS VDD FILLER2
XFILLER_111_8 VSS VDD FILLER2
XFILLER_135_835 VSS VDD FILLER2
XFILLER_107_537 VDD VSS FILLER4
XFILLER_134_323 VSS VDD FILLER2
XTAP_TAPCELL_ROW_119_1083 VDD VSS WELLTAP
XFILLER_108_44 VSS VDD FILLER2
XFILLER_162_676 VSS VDD FILLER2
XFILLER_1_815 VSS VDD FILLER2
XFILLER_134_389 VDD VSS DECAPHV8
XFILLER_150_838 VSS VDD FILLER2
XFILLER_161_175 VSS VDD FILLER2
XFILLER_88_421 VDD VSS FILLER4
XFILLER_103_754 VSS VDD FILLER2
XFILLER_102_242 VDD VSS DECAPHV8
XFILLER_49_819 VSS VDD FILLER2
XFILLER_130_562 VSS VDD FILLER2
XFILLER_76_616 VSS VDD FILLER2
XFILLER_102_264 VDD VSS FILLER4
XFILLER_124_32 VDD VSS FILLER4
XFILLER_130_584 VSS VDD FILLER2
XFILLER_75_115 VDD VSS DECAPHV8
XFILLER_124_76 VSS VDD FILLER2
X_11980_ _19232_/Q _11980_/B _11980_/C VDD VSS _11985_/B XNOR3X1
XFILLER_44_502 VSS VDD FILLER2
X_10931_ _10931_/A _10931_/B _10931_/C _10931_/D VDD VSS _10932_/C AO211X2
XFILLER_29_598 VDD VSS FILLER1
XFILLER_16_237 VDD VSS FILLER1
XFILLER_140_42 VDD VSS FILLER4
XFILLER_16_248 VSS VDD FILLER2
X_13650_ _13733_/A _13733_/B _13733_/D VDD VSS _13651_/C OAI21X1
X_10862_ _10862_/A _10903_/C VDD VSS _10875_/D XNOR2X1
XFILLER_71_354 VDD VSS DECAPHV8
XFILLER_44_579 VSS VDD FILLER2
XFILLER_17_96 VSS VDD FILLER2
XTAP_TAPCELL_ROW_26_243 VDD VSS WELLTAP
X_12601_ _12894_/A _12894_/B _12894_/C VDD VSS _12717_/B OAI21X1
X_13581_ _13591_/A _13591_/B VDD VSS _14129_/C _13591_/C NAND3X1
X_10793_ _10794_/A _10794_/B _10794_/D _10794_/C VDD VSS _10804_/C OAI211X1
XFILLER_12_421 VSS VDD FILLER2
XFILLER_52_590 VSS VDD FILLER2
XFILLER_12_432 VDD VSS FILLER4
X_15320_ _15364_/A _15364_/B VDD VSS _15845_/B XOR2X1
X_12532_ _18877_/Q _12532_/B _12532_/C VDD VSS _17862_/A MIN3X1
XFILLER_33_51 VDD VSS FILLER1
XFILLER_129_128 VSS VDD FILLER2
XFILLER_12_476 VDD VSS FILLER4
XFILLER_12_487 VSS VDD FILLER2
X_15251_ _19373_/Q _15750_/B VDD VSS _15252_/B XNOR2X1
X_12463_ _12593_/A _12593_/B VDD VSS _14377_/B XNOR2X1
XFILLER_138_640 VDD VSS FILLER1
XFILLER_149_73 VDD VSS FILLER4
X_14202_ _14219_/A _14202_/B _14202_/C VDD VSS _18951_/D NOR3X1
X_11414_ _11422_/A _17990_/B _11414_/C VDD VSS _18608_/D NOR3X1
X_15182_ _15183_/A _15183_/B VDD VSS _15875_/B _15183_/C _15183_/D NAND4X2
X_12394_ _12577_/A _12499_/B VDD VSS _14533_/B XNOR2X1
XFILLER_126_835 VSS VDD FILLER2
XFILLER_165_481 VDD VSS FILLER1
XFILLER_153_632 VDD VSS FILLER1
X_14133_ _14163_/A _14133_/B _14133_/C VDD VSS _18891_/D NOR3X1
X_11345_ _11357_/A _11345_/B _11345_/C _18588_/Q VDD VSS _11352_/B AOAI211X1
X_19990_ _19996_/CK _19990_/D _19990_/Q VDD VSS DFFQX1
XFILLER_153_654 VSS VDD FILLER2
XFILLER_152_142 VSS VDD FILLER2
XFILLER_4_653 VSS VDD FILLER2
XFILLER_113_507 VDD VSS FILLER4
XFILLER_113_529 VSS VDD FILLER2
XFILLER_152_164 VSS VDD FILLER2
X_18941_ _18999_/CK _18941_/D _18941_/Q VDD VSS DFFQX1
X_14064_ _18980_/Q _14236_/B VDD VSS _14065_/D NOR2BX1
X_11276_ _11276_/A _11276_/B VDD VSS _11286_/A AND2X1
XTAP_TAPCELL_ROW_150_1361 VDD VSS WELLTAP
XFILLER_140_337 VDD VSS FILLER4
XFILLER_140_348 VSS VDD FILLER2
X_13015_ _19106_/Q VDD VSS _13101_/A INVX1
X_10227_ _10229_/A _10228_/B _17906_/C VDD VSS _10228_/C AOI21X1
X_18872_ _18924_/CK _18872_/D _18872_/Q VDD VSS DFFQX1
XFILLER_79_454 VDD VSS FILLER4
X_17823_ _17823_/A _17823_/B _17823_/C VDD VSS _17826_/A OA21X2
X_10158_ _11226_/D _10159_/B _10159_/C _18613_/Q VDD VSS _10172_/C AOI211X1
XFILLER_121_595 VDD VSS FILLER4
XFILLER_58_81 VDD VSS FILLER4
XFILLER_66_137 VSS VDD FILLER2
XFILLER_66_148 VDD VSS FILLER4
X_17754_ _19913_/Q _19881_/Q _17754_/C VDD VSS _17758_/B MIN3X1
X_14966_ _14966_/A _14966_/B _14966_/C _15016_/A VDD VSS _15013_/A AOAI211X1
X_10089_ _18585_/Q _10089_/B VDD VSS _10113_/C NOR2BX1
XFILLER_81_107 VDD VSS DECAPHV16
X_16705_ _19911_/Q _16726_/B VDD VSS _19559_/D AND2X1
XFILLER_63_822 VDD VSS FILLER4
X_13917_ _18949_/Q _13936_/B _13957_/C VDD VSS _13993_/A XOR3X1
X_17685_ _19898_/Q _19866_/Q _17686_/C VDD VSS _17687_/B AOI21X1
XFILLER_62_310 VDD VSS FILLER1
X_14897_ _14897_/A _14899_/C VDD VSS _18073_/B XNOR2X1
XFILLER_35_535 VDD VSS FILLER4
X_19424_ _19463_/CK _19424_/D _19424_/Q VDD VSS DFFQX1
XFILLER_74_192 VSS VDD FILLER2
XFILLER_35_557 VDD VSS FILLER1
X_16636_ _16647_/B _16636_/B VDD VSS _16865_/B XOR2X1
X_13848_ _13903_/A _13903_/B VDD VSS _13951_/B NOR2X1
XFILLER_74_91 VDD VSS DECAPHV8
XFILLER_90_674 VSS VDD FILLER2
XFILLER_62_365 VDD VSS FILLER1
X_19355_ _19385_/CK _19355_/D _19355_/Q VDD VSS DFFQX1
XFILLER_62_387 VDD VSS FILLER4
X_16567_ _19700_/Q _16862_/B VDD VSS _16585_/A NOR2X1
XFILLER_50_538 VSS VDD FILLER2
XFILLER_16_793 VSS VDD FILLER2
X_13779_ _13779_/A _13779_/B _13779_/C VDD VSS _13781_/D NOR3X1
X_18306_ _18309_/CK _18519_/Q _18306_/Q _20075_/RB VDD VSS DFFRQX1
XTAP_TAPCELL_ROW_100_910 VDD VSS WELLTAP
X_15518_ _19464_/Q _15853_/B VDD VSS _15520_/C XOR2X1
XFILLER_31_752 VSS VDD FILLER2
X_19286_ _19306_/CK _19286_/D _19286_/Q VDD VSS DFFQX1
XTAP_TAPCELL_ROW_60_555 VDD VSS WELLTAP
X_16498_ _19569_/Q _16717_/A _16498_/C VDD VSS _16525_/B MIN3X1
X_18237_ _18241_/CK _18237_/D _18237_/Q _18469_/RB VDD VSS DFFRQX1
X_15449_ _15449_/A _15449_/B _15449_/C VDD VSS _15450_/B NOR3X1
XFILLER_129_684 VDD VSS FILLER4
X_18168_ _18166_/Y _18170_/B _18168_/C VDD VSS _20007_/D AND3BX1
XFILLER_117_835 VSS VDD FILLER2
XFILLER_129_695 VSS VDD FILLER2
XFILLER_144_621 VDD VSS FILLER4
XFILLER_116_323 VSS VDD FILLER2
XFILLER_156_492 VDD VSS FILLER4
X_17119_ _19778_/Q _19746_/Q VDD VSS _17120_/B XOR2X1
X_18099_ _18173_/A _18099_/B VDD VSS _19994_/D NOR2X1
X_20130_ _20130_/A VDD VSS _20130_/Y BUFX3
XFILLER_89_218 VDD VSS DECAPHV32
XFILLER_132_838 VSS VDD FILLER2
X_09941_ _18560_/Q _18561_/Q _09941_/C _18562_/Q VDD VSS _09942_/B AOI31X1
Xmax_cap188 _18517_/Q VDD VSS _18496_/D BUFX8
X_20061_ clkload7/A _20061_/D _20061_/Q _20071_/RB VDD VSS DFFRQX1
XFILLER_112_540 VDD VSS FILLER4
X_09872_ _18573_/Q _09872_/B VDD VSS _09872_/Y XOR2X1
XFILLER_97_240 VSS VDD FILLER2
XFILLER_98_785 VDD VSS FILLER4
XFILLER_38_18 VSS VDD FILLER2
XFILLER_100_724 VDD VSS FILLER1
XFILLER_58_638 VSS VDD FILLER2
XFILLER_85_424 VSS VDD FILLER2
XTAP_TAPCELL_ROW_68_622 VDD VSS WELLTAP
XFILLER_97_295 VSS VDD FILLER2
XFILLER_85_446 VDD VSS FILLER1
XFILLER_85_468 VDD VSS FILLER4
XFILLER_73_608 VSS VDD FILLER2
XFILLER_26_502 VSS VDD FILLER2
XFILLER_54_833 VDD VSS FILLER1
XFILLER_54_17 VDD VSS FILLER4
XFILLER_81_641 VSS VDD FILLER2
XFILLER_26_568 VDD VSS FILLER4
XFILLER_26_579 VSS VDD FILLER2
XFILLER_80_151 VSS VDD FILLER2
XFILLER_110_12 VDD VSS FILLER4
XFILLER_41_549 VSS VDD FILLER2
XFILLER_110_56 VDD VSS FILLER4
X_09306_ _18455_/D _09305_/Y _09302_/Y VDD VSS _18524_/D MUXI2X1
XTAP_TAPCELL_ROW_23_224 VDD VSS WELLTAP
XFILLER_70_38 VDD VSS FILLER1
XFILLER_70_49 VSS VDD FILLER2
XFILLER_166_223 VSS VDD FILLER2
X_09237_ _18513_/Q VDD VSS _18348_/D INVX1
XTAP_TAPCELL_ROW_31_290 VDD VSS WELLTAP
XFILLER_5_406 VSS VDD FILLER2
XFILLER_166_289 VDD VSS FILLER1
XFILLER_147_481 VDD VSS DECAPHV8
XFILLER_135_654 VSS VDD FILLER2
XFILLER_79_36 VDD VSS DECAPHV8
XFILLER_102_4 VDD VSS FILLER4
XFILLER_134_142 VSS VDD FILLER2
XFILLER_150_602 VSS VDD FILLER2
X_11130_ _18681_/Q _18789_/Q VDD VSS _11132_/C XNOR2X1
XFILLER_107_389 VSS VDD FILLER2
XFILLER_134_175 VSS VDD FILLER2
XFILLER_1_612 VDD VSS FILLER1
XFILLER_134_186 VDD VSS FILLER1
XFILLER_162_495 VDD VSS FILLER1
XFILLER_122_337 VDD VSS FILLER4
XFILLER_135_20 VDD VSS FILLER1
XFILLER_0_122 VDD VSS FILLER1
X_11061_ _18759_/Q VDD VSS _11616_/A INVX1
XFILLER_0_133 VSS VDD FILLER2
XFILLER_0_144 VSS VDD FILLER2
XFILLER_135_64 VSS VDD FILLER2
XFILLER_95_13 VDD VSS FILLER4
X_10012_ _09876_/B _09887_/B _10166_/D VDD VSS _10012_/Y MUX2X1
XFILLER_89_796 VSS VDD FILLER2
XFILLER_0_188 VSS VDD FILLER2
XFILLER_95_57 VSS VDD FILLER2
XFILLER_49_649 VSS VDD FILLER2
X_14820_ _14865_/A _14865_/B _14865_/D VDD VSS _14833_/B OAI21X1
XFILLER_57_660 VSS VDD FILLER2
XFILLER_57_682 VSS VDD FILLER2
XFILLER_28_84 VSS VDD FILLER2
X_14751_ _19474_/Q _14751_/B _14751_/C VDD VSS _14837_/C XNOR3X1
X_11963_ _11963_/A _12022_/B VDD VSS _11964_/C XNOR2X1
XFILLER_29_384 VSS VDD FILLER2
XFILLER_56_192 VDD VSS FILLER4
XFILLER_17_546 VSS VDD FILLER2
XFILLER_151_96 VSS VDD FILLER2
X_13702_ _19057_/Q _13781_/A _13781_/B VDD VSS _13733_/C XNOR3X1
XFILLER_44_343 VDD VSS DECAPHV8
XFILLER_17_557 VDD VSS FILLER1
X_17470_ _19852_/Q _19820_/Q _17470_/C VDD VSS _17475_/C AO21X2
X_10914_ _10624_/Y _10913_/Y _11120_/A VDD VSS _10921_/C MUXI2X1
X_14682_ _14739_/D _14710_/C VDD VSS _14739_/C NAND2X1
X_11894_ _11922_/A _12035_/B _12035_/C VDD VSS _11912_/C OR3BX1
X_16421_ _16421_/A _16421_/B VDD VSS _16422_/C NOR2X1
XFILLER_72_696 VDD VSS FILLER1
XFILLER_60_836 VSS VDD FILLER2
X_13633_ _13637_/A _13637_/B _13637_/D _13637_/C VDD VSS _14453_/A AO211X2
X_10845_ _11120_/A _10845_/B _10845_/C VDD VSS _10853_/B AOI21X1
XFILLER_44_398 VSS VDD FILLER2
XFILLER_71_184 VSS VDD FILLER2
X_19140_ _19196_/CK _19140_/D _19140_/Q VDD VSS DFFQX1
X_16352_ _16352_/A _16352_/B _16352_/C VDD VSS _16353_/B OR3X2
X_13564_ _19084_/Q _13564_/B _13696_/D VDD VSS _13728_/C XNOR3X1
X_10776_ _10746_/Y _10775_/Y _10843_/A VDD VSS _10776_/Y MUXI2X1
XFILLER_8_200 VSS VDD FILLER2
XFILLER_158_735 VSS VDD FILLER2
XFILLER_9_734 VSS VDD FILLER2
X_15303_ _15303_/A _15303_/B _15751_/B VDD VSS _15343_/A MIN3X1
X_19071_ _19072_/CK _19071_/D _19071_/Q VDD VSS DFFQX1
X_12515_ _12519_/B _12519_/C _12515_/C VDD VSS _12540_/B OA21X2
XFILLER_8_222 VSS VDD FILLER2
X_16283_ _16262_/B _16283_/B _16283_/C VDD VSS _16289_/A AOI2B1X1
X_13495_ _13495_/A _13495_/B _14126_/B VDD VSS _13496_/B MIN3X1
XFILLER_157_245 VDD VSS DECAPHV8
XTAP_TAPCELL_ROW_139_1267 VDD VSS WELLTAP
XFILLER_8_255 VDD VSS FILLER1
XFILLER_157_267 VDD VSS DECAPHV8
X_18022_ _18532_/Q _18024_/B VDD VSS _18023_/B XNOR2X1
X_15234_ _19538_/Q _15270_/C VDD VSS _15237_/B NAND2X1
X_12446_ _19068_/Q VDD VSS _12448_/A INVX1
XFILLER_126_632 VDD VSS FILLER4
XFILLER_126_643 VSS VDD FILLER2
XFILLER_5_11 VSS VDD FILLER2
XFILLER_153_440 VDD VSS FILLER4
X_15165_ _15176_/B _15165_/B VDD VSS _15717_/B XNOR2X1
X_12377_ _12378_/A _12378_/B _12378_/D _12378_/C VDD VSS _12553_/B OAOI211X1
XFILLER_114_805 VSS VDD FILLER2
XFILLER_141_602 VDD VSS FILLER1
X_14116_ _14118_/A _14116_/B VDD VSS _18876_/D NOR2X1
X_11328_ _11383_/A _11328_/B VDD VSS _18586_/D NOR2X1
XFILLER_125_175 VSS VDD FILLER2
X_15096_ _15145_/A _15145_/B _15099_/C VDD VSS _15100_/A OAI21X1
X_19973_ _19986_/CK _19973_/D _19973_/Q VDD VSS DFFQX1
XFILLER_153_495 VSS VDD FILLER2
XFILLER_113_337 VDD VSS DECAPHV8
Xclkbuf_leaf_4__000_ clkbuf_leaf_6__000_/A VDD VSS _19734_/CK BUFX12
X_18924_ _18924_/CK _18924_/D _18924_/Q VDD VSS DFFQX1
XFILLER_141_668 VDD VSS FILLER4
X_14047_ _18952_/Q _14068_/B _14047_/C VDD VSS _14061_/B XOR3X1
X_11259_ _18580_/Q _11262_/C VDD VSS _11261_/B XOR2X1
XFILLER_69_91 VSS VDD FILLER2
XFILLER_95_700 VDD VSS FILLER1
XFILLER_79_262 VSS VDD FILLER2
XFILLER_121_370 VSS VDD FILLER2
XFILLER_140_189 VDD VSS FILLER1
X_18855_ _18905_/CK _18855_/D _18855_/Q VDD VSS DFFQX1
XFILLER_94_210 VSS VDD FILLER2
XFILLER_121_381 VDD VSS FILLER1
XFILLER_95_755 VSS VDD FILLER2
X_17806_ _17806_/A _17806_/B VDD VSS _19925_/D NOR2X1
XFILLER_67_457 VSS VDD FILLER2
XFILLER_67_468 VSS VDD FILLER2
X_18786_ _18788_/CK _18786_/D _18786_/Q VDD VSS DFFQX1
X_15998_ _19583_/Q _16732_/B VDD VSS _16035_/B XOR2X1
XFILLER_36_811 VSS VDD FILLER2
XFILLER_94_287 VSS VDD FILLER2
XFILLER_82_427 VDD VSS FILLER4
X_17737_ _17738_/A _17738_/B _17738_/D _17738_/C VDD VSS _17740_/C AOI211X1
X_14949_ _15297_/A _18079_/B VDD VSS _19282_/D AND2X1
XFILLER_35_310 VSS VDD FILLER2
XFILLER_35_332 VSS VDD FILLER2
XTAP_TAPCELL_ROW_37_349 VDD VSS WELLTAP
X_17668_ _19895_/Q _19863_/Q VDD VSS _17670_/B XNOR2X1
XFILLER_51_814 VSS VDD FILLER2
X_19407_ _19463_/CK _19407_/D _19407_/Q VDD VSS DFFQX1
X_16619_ _19702_/Q _16864_/B VDD VSS _16620_/D NAND2BX1
XFILLER_90_482 VSS VDD FILLER2
X_17599_ _19880_/Q VDD VSS _17748_/B INVX1
XFILLER_93_0 VSS VDD FILLER2
X_19338_ _19349_/CK _19338_/D _19338_/Q VDD VSS DFFQX1
XFILLER_149_735 VSS VDD FILLER2
XFILLER_148_223 VSS VDD FILLER2
XFILLER_149_768 VSS VDD FILLER2
X_19269_ _19269_/CK _19269_/D _19269_/Q VDD VSS DFFQX1
XFILLER_148_289 VSS VDD FILLER2
XFILLER_164_738 VSS VDD FILLER2
XFILLER_157_790 VDD VSS DECAPHV8
XFILLER_156_19 VDD VSS FILLER1
XFILLER_117_654 VDD VSS FILLER4
XFILLER_116_142 VSS VDD FILLER2
XTAP_TAPCELL_ROW_116_1053 VDD VSS WELLTAP
XFILLER_144_462 VSS VDD FILLER2
XFILLER_132_635 VSS VDD FILLER2
XFILLER_131_112 VSS VDD FILLER2
XFILLER_104_348 VDD VSS FILLER1
X_20113_ _20113_/A VDD VSS _20113_/Y BUFX3
XFILLER_104_359 VSS VDD FILLER2
XFILLER_120_808 VSS VDD FILLER2
X_09924_ _09928_/C _09924_/B VDD VSS _09925_/C NAND2X1
XFILLER_131_156 VDD VSS DECAPHV8
XFILLER_86_700 VSS VDD FILLER2
XFILLER_58_402 VSS VDD FILLER2
XFILLER_131_178 VSS VDD FILLER2
XFILLER_131_189 VDD VSS FILLER4
X_20044_ _20045_/CK _20044_/D _20044_/Q _20045_/RB VDD VSS DFFRQX1
XFILLER_98_582 VDD VSS FILLER1
Xclkbuf_1_1__f__09178_ clkbuf_0__09178_/Y VDD VSS _20045_/CK BUFX12
X_09855_ _18570_/Q _09855_/B VDD VSS _09858_/B NAND2X1
XFILLER_85_210 VSS VDD FILLER2
XFILLER_112_381 VSS VDD FILLER2
XFILLER_58_435 VSS VDD FILLER2
XFILLER_85_254 VSS VDD FILLER2
XFILLER_105_78 VDD VSS FILLER1
X_09786_ _20176_/A _09811_/B VDD VSS _09787_/D NAND2X1
XFILLER_85_276 VSS VDD FILLER2
XFILLER_27_822 VSS VDD FILLER2
XFILLER_45_129 VDD VSS FILLER4
XFILLER_27_844 VSS VDD FILLER2
XTAP_TAPCELL_ROW_127_1160 VDD VSS WELLTAP
XFILLER_121_22 VDD VSS FILLER1
XFILLER_14_505 VDD VSS FILLER4
XFILLER_81_460 VDD VSS FILLER4
XFILLER_53_151 VDD VSS FILLER4
XFILLER_54_696 VDD VSS FILLER1
XFILLER_26_387 VSS VDD FILLER2
XFILLER_53_184 VSS VDD FILLER2
X_10630_ _10630_/A _10630_/B VDD VSS _10709_/A OR2X2
XFILLER_139_201 VSS VDD FILLER2
XFILLER_10_700 VSS VDD FILLER2
XFILLER_14_53 VDD VSS FILLER1
X_10561_ _10561_/A VDD VSS _10563_/C INVX1
X_18212__258 _20052_/CK VDD VSS _18279_/CK INVX1
XFILLER_10_744 VDD VSS FILLER4
XFILLER_14_97 VSS VDD FILLER2
X_12300_ _12300_/A _12300_/B _12300_/C _12300_/D VDD VSS _12457_/A OAOI211X1
XFILLER_155_727 VDD VSS FILLER4
XFILLER_154_204 VDD VSS DECAPHV8
X_13280_ _13280_/A _13290_/C VDD VSS _14158_/B XNOR2X1
XFILLER_10_788 VSS VDD FILLER2
X_10492_ _18689_/Q _18743_/Q VDD VSS _10525_/A NAND2X1
XFILLER_6_737 VSS VDD FILLER2
XFILLER_154_237 VDD VSS FILLER1
X_12231_ _19238_/Q _12231_/B _12397_/C VDD VSS _12391_/A XNOR3X1
XFILLER_107_120 VSS VDD FILLER2
XFILLER_30_41 VDD VSS FILLER4
XFILLER_5_258 VSS VDD FILLER2
XFILLER_163_760 VSS VDD FILLER2
XTAP_TAPCELL_ROW_1_23 VDD VSS WELLTAP
X_12162_ _12222_/A _14530_/B VDD VSS _12401_/A NOR2X1
XFILLER_135_484 VSS VDD FILLER2
XFILLER_150_421 VDD VSS FILLER4
X_11113_ _11226_/A _11113_/B _11113_/C VDD VSS _11114_/C OAI21X1
X_16970_ _16976_/A _16970_/B VDD VSS _19749_/D NOR2X1
X_12093_ wire160/Y _12181_/B _12181_/E VDD VSS _12118_/B OA21X2
XFILLER_96_508 VSS VDD FILLER2
XFILLER_122_156 VSS VDD FILLER2
XFILLER_1_453 VSS VDD FILLER2
XFILLER_122_178 VDD VSS FILLER1
XFILLER_150_487 VDD VSS FILLER4
XTAP_TAPCELL_ROW_79_728 VDD VSS WELLTAP
XFILLER_77_711 VDD VSS FILLER4
X_15921_ _19579_/Q _16728_/B _15921_/C VDD VSS _15936_/A OAI21X1
X_11044_ _18705_/Q _18759_/Q VDD VSS _11045_/B XOR2X1
XFILLER_77_722 VSS VDD FILLER2
XFILLER_103_370 VSS VDD FILLER2
XFILLER_89_593 VDD VSS DECAPHV8
XFILLER_49_435 VDD VSS DECAPHV16
X_18640_ _19946_/CK _18640_/D _18640_/Q VDD VSS DFFQX1
X_15852_ _16795_/A VDD VSS _15879_/A BUFX3
XFILLER_76_254 VSS VDD FILLER2
XFILLER_49_468 VSS VDD FILLER2
XFILLER_92_714 VDD VSS FILLER1
XFILLER_162_84 VDD VSS FILLER1
XFILLER_76_276 VDD VSS FILLER1
XFILLER_64_416 VSS VDD FILLER2
X_14803_ _14850_/B _14803_/B VDD VSS _15677_/B XNOR2X1
XFILLER_64_427 VDD VSS DECAPHV16
XFILLER_18_822 VSS VDD FILLER2
X_18571_ _18589_/CK _18571_/D _18571_/Q VDD VSS DFFQX1
XTAP_TAPCELL_ROW_87_794 VDD VSS WELLTAP
XFILLER_76_298 VSS VDD FILLER2
XFILLER_18_833 VDD VSS FILLER1
X_15783_ _15800_/A _15783_/B VDD VSS _19402_/D NOR2X1
X_12995_ _13171_/A _13171_/B _13171_/E VDD VSS _13083_/A OA21X2
X_17522_ _17522_/A VDD VSS _17523_/C INVX1
X_14734_ _19445_/Q _14734_/B _14734_/C VDD VSS _14840_/A MIN3X1
X_11946_ _12014_/A _12019_/C VDD VSS _11955_/C XNOR2X1
XFILLER_44_151 VSS VDD FILLER2
XTAP_TAPCELL_ROW_34_319 VDD VSS WELLTAP
XFILLER_17_387 VDD VSS FILLER4
X_17453_ _17455_/C _17453_/B _17453_/C VDD VSS _19849_/D AOI21X1
XFILLER_72_482 VSS VDD FILLER2
X_14665_ _19359_/Q _15734_/B VDD VSS _14694_/B NOR2X1
X_11877_ _11884_/A _14490_/B _11979_/C VDD VSS _14492_/C OR3BX1
X_16404_ _19662_/Q _16820_/B VDD VSS _16406_/C XOR2X1
X_13616_ _13616_/A _13616_/B _13616_/C _13616_/D VDD VSS _13620_/B AOAI211X1
X_17384_ _19834_/Q _19802_/Q _17385_/C VDD VSS _17386_/B AOI21X1
X_10828_ _10826_/Y _10875_/C _10828_/C VDD VSS _10838_/C AND3BX1
X_14596_ _14601_/A _14601_/B _14601_/D _14615_/B VDD VSS _14598_/B AOAI211X1
XFILLER_60_688 VSS VDD FILLER2
X_19123_ _19134_/CK _19123_/D _19123_/Q VDD VSS DFFQX1
X_16335_ _19627_/Q _16781_/B _16335_/C VDD VSS _16345_/A AOI2B1X1
X_13547_ _13640_/B _14420_/C _19139_/Q VDD VSS _13548_/D AND3BX1
X_10759_ _18670_/Q _18778_/Q VDD VSS _10801_/B AND2X1
XFILLER_71_92 VDD VSS FILLER1
X_19054_ _19119_/CK _19054_/D _19054_/Q VDD VSS DFFQX1
X_16266_ _16267_/A _16267_/B _16267_/C VDD VSS _16296_/B OAI21X1
X_13478_ _14260_/B _14260_/C _18998_/Q VDD VSS _13511_/B AOI21X1
X_18005_ _18549_/Q _18057_/C _18550_/Q VDD VSS _18006_/B OA21X2
XFILLER_65_4 VSS VDD FILLER2
XFILLER_145_259 VDD VSS DECAPHV16
X_15217_ _15217_/A _15217_/B _15687_/B VDD VSS _15259_/B MIN3X1
X_12429_ _12429_/A _12429_/B _14147_/B VDD VSS _12527_/C MIN3X1
X_16197_ _16512_/A _16197_/B VDD VSS _19526_/D NOR2X1
XFILLER_114_602 VSS VDD FILLER2
XFILLER_154_771 VSS VDD FILLER2
X_15148_ _15904_/B VDD VSS _15149_/B INVX1
XFILLER_154_793 VSS VDD FILLER2
XFILLER_113_112 VSS VDD FILLER2
XFILLER_99_346 VSS VDD FILLER2
XFILLER_141_454 VSS VDD FILLER2
X_15079_ _15297_/A _18094_/B VDD VSS _19285_/D AND2X1
X_19956_ _19956_/CK _19956_/D _19956_/Q VDD VSS DFFQX1
XFILLER_68_700 VSS VDD FILLER2
XFILLER_113_189 VSS VDD FILLER2
X_18907_ _18961_/CK _18907_/D _18907_/Q VDD VSS DFFQX1
X_19887_ clkload9/A _19887_/D _19887_/Q VDD VSS DFFQX1
XFILLER_68_744 VSS VDD FILLER2
XFILLER_67_243 VSS VDD FILLER2
X_09640_ _18300_/Q _09797_/B _09813_/B _18460_/Q VDD VSS _09641_/D AOI22X1
X_18838_ _19954_/CK _18838_/D _18838_/Q VDD VSS DFFQX1
XFILLER_83_714 VDD VSS FILLER1
XFILLER_67_276 VSS VDD FILLER2
XFILLER_55_416 VSS VDD FILLER2
X_09571_ _09814_/B VDD VSS _09811_/B BUFX3
XFILLER_83_747 VSS VDD FILLER2
X_18769_ _18795_/CK _18769_/D _18769_/Q VDD VSS DFFQX1
XFILLER_82_224 VSS VDD FILLER2
XFILLER_82_235 VSS VDD FILLER2
XFILLER_36_641 VSS VDD FILLER2
XFILLER_82_279 VSS VDD FILLER2
XFILLER_36_696 VDD VSS FILLER1
XFILLER_23_313 VSS VDD FILLER2
XFILLER_50_110 VSS VDD FILLER2
XFILLER_35_184 VSS VDD FILLER2
XFILLER_23_335 VDD VSS FILLER4
XFILLER_149_521 VDD VSS FILLER1
XFILLER_50_165 VDD VSS FILLER1
XFILLER_149_532 VSS VDD FILLER2
Xclkbuf_0_clk_regs clkbuf_regs_0_clk/Y VDD VSS clkbuf_0_clk_regs/Y BUFX12
XFILLER_109_407 VSS VDD FILLER2
XFILLER_149_576 VSS VDD FILLER2
XFILLER_164_546 VSS VDD FILLER2
XFILLER_117_462 VSS VDD FILLER2
XFILLER_3_729 VSS VDD FILLER2
XFILLER_117_484 VSS VDD FILLER2
XFILLER_151_229 VSS VDD FILLER2
XFILLER_144_270 VSS VDD FILLER2
XFILLER_132_421 VDD VSS DECAPHV8
XFILLER_116_44 VSS VDD FILLER2
XFILLER_160_785 VDD VSS FILLER4
XFILLER_132_487 VSS VDD FILLER2
XFILLER_116_66 VDD VSS FILLER1
X_09907_ _09907_/A _10247_/A VDD VSS _09938_/A NOR2X1
XFILLER_113_690 VSS VDD FILLER2
XFILLER_59_755 VDD VSS FILLER4
X_20027_ _20033_/CK _20027_/D _20027_/Q _20030_/RB VDD VSS DFFRQX1
XFILLER_100_340 VSS VDD FILLER2
X_09838_ _18563_/Q _10803_/A _09942_/A VDD VSS _09910_/A MIN3X1
XFILLER_100_351 VSS VDD FILLER2
XFILLER_58_265 VSS VDD FILLER2
XFILLER_46_416 VSS VDD FILLER2
XFILLER_132_21 VDD VSS FILLER1
XFILLER_74_747 VDD VSS FILLER1
XFILLER_58_298 VDD VSS DECAPHV8
X_09769_ _20078_/Q _09770_/B _09769_/C _20094_/A _09769_/E VDD VSS _09776_/B AOI221X1
XFILLER_73_235 VDD VSS FILLER4
XFILLER_73_246 VDD VSS FILLER1
XFILLER_92_14 VDD VSS FILLER4
X_11800_ _11804_/A _11804_/B _11804_/C VDD VSS _14523_/C OR3X2
X_12780_ _12801_/A _12801_/B VDD VSS _12872_/B _12801_/C NAND3X1
XFILLER_42_600 VDD VSS FILLER4
XFILLER_42_611 VDD VSS FILLER1
X_11731_ _19172_/Q VDD VSS _11793_/A INVX1
XFILLER_30_806 VDD VSS FILLER1
X_14450_ _17566_/A VDD VSS _14490_/A BUFX3
XFILLER_42_677 VSS VDD FILLER2
Xclkbuf_leaf_3__001_ clkbuf_leaf_4__001_/A VDD VSS _19250_/CK BUFX12
X_11662_ _18801_/Q _11669_/B VDD VSS _18828_/D AND2X1
XFILLER_25_96 VSS VDD FILLER2
X_13401_ _18970_/Q _13594_/A _13401_/C VDD VSS _13402_/D XNOR3X1
X_10613_ _10642_/A _10642_/B _10613_/C _10613_/D VDD VSS _10619_/C AO31X2
X_14381_ _18163_/A VDD VSS _14381_/Y BUFX3
X_11593_ _18738_/Q _11600_/B VDD VSS _18765_/D AND2X1
XFILLER_10_552 VDD VSS FILLER4
X_16120_ _16120_/A _16131_/B VDD VSS _16843_/B XNOR2X1
X_13332_ _13443_/A _13443_/B _13443_/D _13443_/C VDD VSS _14449_/C AOI211X1
X_10544_ _10544_/A _10544_/B _10544_/C _10544_/D VDD VSS _10592_/B AOAI211X1
XTAP_TAPCELL_ROW_136_1237 VDD VSS WELLTAP
X_16051_ _16051_/A _16054_/B VDD VSS _16052_/B XOR2X1
X_13263_ _19221_/Q _13263_/B _13347_/C VDD VSS _13466_/B XNOR3X1
X_10475_ _18635_/Q _18797_/Q VDD VSS _10514_/A NAND2X1
XFILLER_136_771 VDD VSS FILLER4
X_15002_ _15054_/B _15836_/B _19451_/Q VDD VSS _15003_/D NAND3BX1
XFILLER_142_229 VSS VDD FILLER2
X_12214_ _12214_/A wire161/Y _12214_/C _12214_/D VDD VSS _12382_/B AOAI211X1
XFILLER_135_270 VDD VSS DECAPHV8
XFILLER_136_793 VSS VDD FILLER2
X_13194_ _13295_/A _13295_/B _13295_/C _13295_/D VDD VSS _13391_/A AO31X2
XFILLER_151_741 VSS VDD FILLER2
X_19810_ _19825_/CK _19810_/D _19810_/Q VDD VSS DFFQX1
X_12145_ _12210_/A _12210_/B _12210_/C VDD VSS _12206_/A OAI21X1
XFILLER_69_508 VSS VDD FILLER2
XFILLER_2_751 VSS VDD FILLER2
XFILLER_150_251 VDD VSS FILLER4
XFILLER_69_519 VSS VDD FILLER2
XFILLER_150_262 VDD VSS FILLER4
XFILLER_96_316 VSS VDD FILLER2
XFILLER_1_250 VSS VDD FILLER2
XFILLER_111_649 VSS VDD FILLER2
X_16953_ _19745_/Q _16978_/B _16953_/C VDD VSS _16956_/B MIN3X1
X_19741_ clkload4/A _19741_/D _19741_/Q VDD VSS DFFQX1
X_12076_ _12076_/A _12076_/B _14306_/B VDD VSS _12077_/B MIN3X1
XFILLER_1_272 VSS VDD FILLER2
X_15904_ _15906_/A _15904_/B VDD VSS _19510_/D NOR2X1
X_11027_ _11127_/A _11090_/A VDD VSS _11052_/A NAND2X1
XFILLER_2_45 VDD VSS FILLER1
X_19672_ _19705_/CK _19672_/D _19672_/Q VDD VSS DFFQX1
X_16884_ _16891_/A _16884_/B VDD VSS _19720_/D NOR2X1
XTAP_TAPCELL_ROW_147_1333 VDD VSS WELLTAP
XFILLER_37_405 VSS VDD FILLER2
XFILLER_92_500 VDD VSS FILLER1
X_18623_ _18625_/CK _18623_/D _18623_/Q VDD VSS DFFQX1
XFILLER_37_427 VDD VSS FILLER4
X_15835_ _15849_/A _15835_/B VDD VSS _19450_/D AND2X1
XFILLER_65_747 VSS VDD FILLER2
XFILLER_64_235 VSS VDD FILLER2
XTAP_TAPCELL_ROW_47_433 VDD VSS WELLTAP
XFILLER_64_246 VSS VDD FILLER2
X_18554_ _18583_/CK _18554_/D _18554_/Q VDD VSS DFFQX1
XFILLER_80_717 VDD VSS DECAPHV8
XFILLER_52_408 VDD VSS FILLER4
XFILLER_18_663 VSS VDD FILLER2
X_15766_ _15770_/A _15766_/B VDD VSS _19388_/D AND2X1
X_12978_ _18994_/Q _12978_/B _12996_/D VDD VSS _13198_/C XNOR3X1
XFILLER_18_685 VSS VDD FILLER2
X_17505_ _17505_/A _17507_/C _17505_/C VDD VSS _19860_/D AOI21X1
X_14717_ _14775_/A _14775_/B VDD VSS _14734_/C XOR2X1
X_18485_ _18487_/CK _18501_/D _20130_/A _18486_/RB VDD VSS DFFRQX1
X_11929_ _12048_/A _12048_/B _12048_/C VDD VSS _11936_/B AOI21X1
XFILLER_17_184 VSS VDD FILLER2
X_15697_ _15710_/A _15697_/B VDD VSS _19325_/D NOR2X1
XFILLER_60_441 VDD VSS FILLER4
XFILLER_21_806 VSS VDD FILLER2
X_17436_ _17439_/A _17436_/B _17436_/C VDD VSS _19845_/D AOI21X1
XFILLER_82_80 VDD VSS FILLER1
XFILLER_33_677 VDD VSS FILLER4
Xclkbuf_leaf_22__000_ clkload70/A VDD VSS _19349_/CK BUFX12
X_14648_ _19523_/Q _19524_/Q _19525_/Q _14649_/C VDD VSS _14742_/C AND4X2
XFILLER_20_338 VSS VDD FILLER2
X_17367_ _19831_/Q _19799_/Q VDD VSS _17370_/B XNOR2X1
X_14579_ _19520_/Q _19519_/Q VDD VSS _15886_/B XOR2X1
X_19106_ _19134_/CK _19106_/D _19106_/Q VDD VSS DFFQX1
X_16318_ _19627_/Q _16781_/B VDD VSS _16320_/C XNOR2X1
XFILLER_70_2 VDD VSS FILLER1
XFILLER_158_373 VSS VDD FILLER2
X_17298_ _17298_/A _17300_/C _17298_/C VDD VSS _19816_/D AOI21X1
XFILLER_158_395 VDD VSS FILLER1
XFILLER_146_568 VSS VDD FILLER2
X_19037_ _19037_/CK _19037_/D _19037_/Q VDD VSS DFFQX1
X_16249_ _19720_/Q _16884_/B VDD VSS _16250_/C NOR2X1
XFILLER_133_207 VDD VSS FILLER4
Xoutput102 _20171_/Y VDD VSS o_lf_cfg[8] BUFX3
XFILLER_133_229 VSS VDD FILLER2
Xoutput113 _20182_/Y VDD VSS o_tst_ctrl[1] BUFX3
XFILLER_56_0 VSS VDD FILLER2
XFILLER_126_270 VSS VDD FILLER2
Xoutput124 _20208_/Y VDD VSS o_uwb_tx_cfg[11] BUFX3
XFILLER_114_421 VDD VSS DECAPHV8
XFILLER_154_590 VSS VDD FILLER2
Xoutput135 _20218_/Y VDD VSS o_uwb_tx_cfg[21] BUFX3
Xoutput146 _20201_/Y VDD VSS o_uwb_tx_cfg[4] BUFX3
XTAP_TAPCELL_ROW_113_1034 VDD VSS WELLTAP
XFILLER_114_498 VDD VSS FILLER4
X_19939_ _19939_/CK _19939_/D _19939_/Q VDD VSS DFFQX1
XFILLER_83_511 VSS VDD FILLER2
XFILLER_68_585 VSS VDD FILLER2
XFILLER_46_18 VSS VDD FILLER2
XFILLER_28_416 VSS VDD FILLER2
X_09623_ _20200_/A _09797_/C _09769_/C _20085_/A _09623_/E VDD VSS _09636_/B AOI221X1
XFILLER_28_449 VSS VDD FILLER2
XFILLER_83_544 VSS VDD FILLER2
XTAP_TAPCELL_ROW_165_1499 VDD VSS WELLTAP
XFILLER_71_706 VSS VDD FILLER2
X_09554_ _18424_/Q VDD VSS _20049_/D INVX1
XTAP_TAPCELL_ROW_124_1130 VDD VSS WELLTAP
XFILLER_71_728 VDD VSS DECAPHV8
XFILLER_24_600 VDD VSS FILLER4
XFILLER_24_611 VSS VDD FILLER2
XFILLER_64_780 VDD VSS DECAPHV8
X_09485_ _09496_/C VDD VSS _09507_/B BUFX3
XTAP_TAPCELL_ROW_81_745 VDD VSS WELLTAP
XFILLER_70_249 VDD VSS FILLER4
XFILLER_24_666 VSS VDD FILLER2
XFILLER_51_463 VSS VDD FILLER2
XFILLER_51_496 VDD VSS FILLER4
XFILLER_23_198 VSS VDD FILLER2
XFILLER_149_351 VDD VSS FILLER1
XFILLER_165_800 VDD VSS FILLER1
XFILLER_20_850 VSS VDD FILLER2
XFILLER_149_395 VDD VSS FILLER4
XFILLER_137_546 VSS VDD FILLER2
XFILLER_165_855 VSS VDD FILLER2
XFILLER_11_21 VSS VDD FILLER2
XFILLER_118_782 VDD VSS FILLER1
XFILLER_124_218 VSS VDD FILLER2
XFILLER_152_527 VSS VDD FILLER2
XFILLER_118_793 VSS VDD FILLER2
X_10260_ _18684_/Q _18738_/Q VDD VSS _10263_/B XOR2X1
XFILLER_164_398 VSS VDD FILLER2
XFILLER_133_730 VSS VDD FILLER2
XFILLER_127_54 VSS VDD FILLER2
XFILLER_133_741 VSS VDD FILLER2
XFILLER_11_98 VDD VSS FILLER1
X_10191_ _11226_/D _10191_/B _10191_/C VDD VSS _10193_/B AOI21X1
XTAP_TAPCELL_ROW_89_812 VDD VSS WELLTAP
Xdelaybuf_1_clk _232_/CK VDD VSS delaybuf_2_clk/A BUFX12
XTAP_TAPCELL_ROW_131_1189 VDD VSS WELLTAP
XFILLER_143_31 VDD VSS FILLER4
XFILLER_120_468 VSS VDD FILLER2
XFILLER_120_479 VDD VSS DECAPHV8
X_13950_ _18950_/Q VDD VSS _13991_/A INVX1
XFILLER_101_682 VSS VDD FILLER2
XFILLER_19_427 VSS VDD FILLER2
X_12901_ wire156/Y _12996_/B VDD VSS _14254_/B XNOR2X1
XFILLER_47_747 VSS VDD FILLER2
XFILLER_100_181 VSS VDD FILLER2
X_13881_ _18892_/Q _14134_/B VDD VSS _13978_/A AND2X1
XFILLER_46_235 VDD VSS FILLER4
X_15620_ _15620_/A _15620_/B _15620_/C _15620_/D VDD VSS _15644_/B AOAI211X1
X_12832_ _12832_/A _12832_/B _12832_/C _12835_/C VDD VSS _12951_/A AOAI211X1
XTAP_TAPCELL_ROW_109_990 VDD VSS WELLTAP
XFILLER_61_227 VDD VSS FILLER1
XFILLER_55_791 VDD VSS DECAPHV16
XFILLER_36_84 VDD VSS FILLER4
X_15551_ _15552_/A _15552_/B _15552_/C VDD VSS _15599_/B OAI21X1
X_12763_ _12763_/A _12763_/B _12763_/C _12763_/D VDD VSS _12955_/B OAI211X1
XFILLER_61_249 VSS VDD FILLER2
XTAP_TAPCELL_ROW_7_77 VDD VSS WELLTAP
X_14502_ _17566_/A VDD VSS _15806_/A BUFX3
X_18270_ _18275_/CK _18270_/D _18270_/Q _20080_/RB VDD VSS DFFRQX1
X_11714_ _19198_/Q _11714_/B _11714_/C VDD VSS _11728_/B MIN3X1
XFILLER_159_115 VSS VDD FILLER2
X_15482_ _19463_/Q _15851_/B VDD VSS _15511_/B XNOR2X1
X_12694_ _18991_/Q _14251_/B _12713_/C VDD VSS _12705_/C XNOR3X1
X_17221_ _17219_/B _17221_/B VDD VSS _17222_/C NOR2BX1
X_14433_ _14449_/A _14433_/B _14433_/C VDD VSS _19150_/D NOR3X1
XTAP_TAPCELL_ROW_52_480 VDD VSS WELLTAP
X_11645_ _18786_/Q _11647_/B VDD VSS _18813_/D AND2X1
X_17152_ _19785_/Q _19753_/Q VDD VSS _17154_/B XOR2X1
X_14364_ _14415_/A _14364_/B VDD VSS _19088_/D AND2X1
X_11576_ _18723_/Q _11578_/B VDD VSS _18750_/D AND2X1
XFILLER_7_832 VDD VSS FILLER4
X_16103_ _16099_/A _16103_/B _16103_/C VDD VSS _16126_/B AOI2B1X1
X_13315_ _13315_/A _13315_/B _13315_/C _13315_/D VDD VSS _13430_/B AOAI211X1
X_17083_ _19771_/Q _19739_/Q VDD VSS _17085_/C XOR2X1
X_10527_ _10563_/A _10563_/B VDD VSS _10527_/Y XNOR2X1
XFILLER_109_760 VSS VDD FILLER2
X_14295_ _14334_/A _14295_/B VDD VSS _19028_/D AND2X1
XFILLER_143_538 VSS VDD FILLER2
X_16034_ _19583_/Q _16732_/B VDD VSS _16035_/C NOR2X1
XFILLER_143_549 VSS VDD FILLER2
X_13246_ _19220_/Q _14513_/B _14513_/C VDD VSS _13329_/D OR3BX1
X_10458_ _10458_/A VDD VSS _10460_/C INVX1
XFILLER_124_752 VSS VDD FILLER2
XTAP_TAPCELL_ROW_153_1392 VDD VSS WELLTAP
X_13177_ _13177_/A _17894_/B VDD VSS _18856_/D NOR2X1
X_10389_ _10427_/B _10389_/B VDD VSS _10390_/B XNOR2X1
XFILLER_111_402 VDD VSS DECAPHV8
XFILLER_69_316 VSS VDD FILLER2
XFILLER_151_582 VDD VSS FILLER1
XFILLER_111_424 VDD VSS FILLER1
XFILLER_123_284 VDD VSS FILLER1
X_12128_ _18900_/Q _14143_/B VDD VSS _12197_/B NOR2X1
XFILLER_69_338 VDD VSS FILLER1
XFILLER_2_581 VSS VDD FILLER2
X_17985_ _17987_/A _17987_/B _17987_/C _17989_/A VDD VSS _17986_/B AOAI211X1
XFILLER_96_135 VDD VSS FILLER4
XFILLER_111_468 VDD VSS FILLER4
X_16936_ _19742_/Q wire164/Y VDD VSS _16937_/C NAND2X1
X_19724_ _19724_/CK _19724_/D _19724_/Q VDD VSS DFFQX1
X_12059_ _12154_/A _12059_/B _12113_/C VDD VSS _12091_/C XNOR3X1
XFILLER_77_91 VSS VDD FILLER2
XFILLER_77_371 VDD VSS FILLER1
XFILLER_37_213 VSS VDD FILLER2
X_16867_ _16876_/A _16867_/B VDD VSS _19704_/D NOR2X1
X_19655_ _19695_/CK _19655_/D _19655_/Q VDD VSS DFFQX1
XFILLER_38_769 VSS VDD FILLER2
XFILLER_92_352 VDD VSS FILLER4
XFILLER_37_257 VSS VDD FILLER2
X_15818_ _15830_/A _15818_/B VDD VSS _19433_/D NOR2X1
X_18606_ _18612_/CK _18606_/D _18606_/Q VDD VSS DFFQX1
X_19586_ _19667_/CK _19586_/D _19586_/Q VDD VSS DFFQX1
X_16798_ _17906_/C VDD VSS _17391_/A BUFX3
XFILLER_80_514 VSS VDD FILLER2
XFILLER_18_460 VDD VSS FILLER1
XFILLER_46_780 VSS VDD FILLER2
X_18537_ _18543_/CK _18537_/D _18537_/Q VDD VSS DFFQX1
X_15749_ _15758_/A _15749_/B VDD VSS _19372_/D NOR2X1
XFILLER_33_430 VSS VDD FILLER2
X_09270_ _20071_/RB _09362_/B VDD VSS _09270_/Y NOR2BX1
X_18468_ _18469_/CK _18521_/Q _18468_/Q _20078_/RB VDD VSS DFFRQX1
XFILLER_21_625 VSS VDD FILLER2
XFILLER_20_102 VDD VSS FILLER1
X_17419_ _17420_/B _17419_/B VDD VSS _17421_/B NOR2BX1
XFILLER_166_608 VSS VDD FILLER2
X_18399_ _18407_/CK _18399_/D _18399_/Q _18422_/RB VDD VSS DFFRQX1
XFILLER_21_658 VSS VDD FILLER2
XFILLER_119_502 VSS VDD FILLER2
XFILLER_147_811 VDD VSS FILLER1
XFILLER_119_535 VSS VDD FILLER2
XFILLER_107_708 VDD VSS FILLER4
XFILLER_119_568 VDD VSS FILLER4
XFILLER_146_354 VSS VDD FILLER2
XFILLER_106_229 VSS VDD FILLER2
XFILLER_134_549 VDD VSS FILLER1
XFILLER_161_335 VSS VDD FILLER2
XFILLER_130_700 VSS VDD FILLER2
XFILLER_115_785 VSS VDD FILLER2
XFILLER_114_273 VSS VDD FILLER2
XFILLER_69_850 VSS VDD FILLER2
Xclkbuf_leaf_2__002_ clkbuf_leaf_9__002_/A VDD VSS _19939_/CK BUFX12
XFILLER_130_799 VDD VSS FILLER4
XFILLER_68_371 VDD VSS FILLER4
XFILLER_113_12 VSS VDD FILLER2
XTAP_TAPCELL_ROW_58_539 VDD VSS WELLTAP
XFILLER_29_747 VSS VDD FILLER2
XFILLER_113_23 VSS VDD FILLER2
XFILLER_68_393 VSS VDD FILLER2
XFILLER_28_235 VSS VDD FILLER2
XFILLER_113_56 VDD VSS FILLER4
X_09606_ _18362_/Q VDD VSS _20199_/A INVX1
XFILLER_83_352 VSS VDD FILLER2
XFILLER_113_78 VSS VDD FILLER2
XFILLER_83_396 VSS VDD FILLER2
XFILLER_71_547 VSS VDD FILLER2
XFILLER_37_791 VDD VSS FILLER4
X_09537_ _18201_/A VDD VSS _09547_/B BUFX3
XTAP_TAPCELL_ROW_106_971 VDD VSS WELLTAP
X_09468_ _18448_/D _09468_/B _09468_/C VDD VSS _18249_/D AOI21X1
XFILLER_12_636 VSS VDD FILLER2
XFILLER_51_282 VDD VSS FILLER4
XFILLER_8_607 VSS VDD FILLER2
X_09399_ input3/Y _20051_/Q VDD VSS _09400_/A AND2X1
XFILLER_137_310 VDD VSS FILLER4
X_11430_ wire167/Y _11430_/B VDD VSS _18623_/D AND2X1
XFILLER_156_129 VSS VDD FILLER2
XFILLER_165_641 VSS VDD FILLER2
XFILLER_20_691 VDD VSS FILLER4
X_11361_ _11367_/B _11361_/B VDD VSS _11362_/B XNOR2X1
XFILLER_138_53 VDD VSS FILLER1
XTAP_TAPCELL_ROW_133_1207 VDD VSS WELLTAP
XFILLER_22_86 VSS VDD FILLER2
X_13100_ _13415_/A _13415_/B VDD VSS _13201_/B NOR2X1
X_10312_ _10312_/A _10312_/B _10312_/C VDD VSS _10357_/B MIN3X1
XFILLER_152_324 VDD VSS FILLER1
XFILLER_153_847 VDD VSS DECAPHV8
X_14080_ _18953_/Q _14204_/B VDD VSS _14174_/A NOR2BX1
X_11292_ _11292_/A _11308_/B VDD VSS _11296_/C XNOR2X1
XFILLER_106_752 VSS VDD FILLER2
X_13031_ _13314_/A _13314_/B _13314_/C VDD VSS _13104_/B AOI21X1
X_10243_ _10314_/C _11430_/B _10304_/A VDD VSS _10358_/C OAI21X1
XFILLER_121_711 VDD VSS FILLER4
XFILLER_105_273 VDD VSS FILLER4
XFILLER_133_582 VSS VDD FILLER2
XFILLER_79_636 VDD VSS DECAPHV8
XFILLER_154_41 VDD VSS FILLER4
X_10174_ _18614_/Q _10174_/B _10174_/C VDD VSS _10184_/A AOI21X1
XFILLER_105_295 VDD VSS FILLER1
XFILLER_120_221 VDD VSS FILLER1
XFILLER_121_755 VSS VDD FILLER2
XFILLER_154_74 VSS VDD FILLER2
Xclkbuf_leaf_21__001_ clkload33/A VDD VSS _18997_/CK BUFX12
XFILLER_78_157 VSS VDD FILLER2
X_17770_ _17773_/C _17770_/B VDD VSS _17771_/B XNOR2X1
XFILLER_121_799 VDD VSS DECAPHV8
X_14982_ _19367_/Q _15743_/B VDD VSS _14983_/B XOR2X1
XFILLER_66_319 VDD VSS FILLER4
Xfanout181 _18626_/Q VDD VSS _11435_/A BUFX3
XFILLER_93_127 VSS VDD FILLER2
X_16721_ _17803_/A _16724_/B VDD VSS _19572_/D NOR2X1
Xfanout192 _09816_/D VDD VSS _09753_/A BUFX3
XFILLER_87_691 VDD VSS DECAPHV8
X_13933_ _18196_/A _17937_/A _17937_/B VDD VSS _18865_/D AND3BX1
XFILLER_47_533 VDD VSS DECAPHV8
XFILLER_101_490 VDD VSS DECAPHV8
XFILLER_19_235 VDD VSS FILLER4
XFILLER_47_72 VDD VSS DECAPHV16
X_19440_ _19508_/CK _19440_/D _19440_/Q VDD VSS DFFQX1
XFILLER_74_352 VSS VDD FILLER2
XFILLER_19_257 VSS VDD FILLER2
X_16652_ _19575_/Q _16724_/A _16652_/C VDD VSS _16677_/C MIN3X1
XFILLER_47_577 VDD VSS FILLER4
XFILLER_19_268 VSS VDD FILLER2
X_13864_ _18976_/Q _13955_/A _13998_/B VDD VSS _13987_/C XNOR3X1
XFILLER_74_374 VSS VDD FILLER2
XFILLER_62_514 VSS VDD FILLER2
XFILLER_35_728 VDD VSS FILLER1
XFILLER_34_205 VSS VDD FILLER2
Xclkbuf_leaf_36__001_ clkbuf_leaf_4__001_/A VDD VSS _19191_/CK BUFX12
X_15603_ _15622_/B _15603_/B VDD VSS _15792_/B XNOR2X1
XTAP_TAPCELL_ROW_29_274 VDD VSS WELLTAP
X_19371_ _19406_/CK _19371_/D _19371_/Q VDD VSS DFFQX1
X_12815_ _19159_/Q _14443_/B _14443_/C VDD VSS _12816_/D OR3BX1
XFILLER_90_856 VDD VSS FILLER1
X_16583_ _19701_/Q _16863_/B VDD VSS _16585_/C XNOR2X1
X_13795_ _19087_/Q _13857_/D _13854_/C VDD VSS _13850_/C XNOR3X1
X_18322_ _18325_/CK _18519_/Q _18322_/Q _18450_/RB VDD VSS DFFRQX1
X_15534_ _19324_/Q _15696_/B VDD VSS _15564_/A NAND2X1
XFILLER_15_463 VSS VDD FILLER2
X_12746_ _12771_/A _12771_/B _12771_/E _12746_/D VDD VSS _14443_/C OAOI211X1
XFILLER_63_82 VSS VDD FILLER2
X_18253_ _18257_/CK _18253_/D _18264_/D _18469_/RB VDD VSS DFFRQX1
X_15465_ _15465_/A _15465_/B VDD VSS _15466_/C NOR2X1
X_12677_ _12677_/A _12677_/B _12677_/C VDD VSS _12755_/B XNOR3X1
XFILLER_129_811 VDD VSS FILLER1
XFILLER_147_118 VDD VSS FILLER4
X_17204_ _19795_/Q _19763_/Q _17204_/C VDD VSS _17208_/C MIN3X1
X_14416_ _14449_/A _14416_/B _14416_/C VDD VSS _19136_/D NOR3X1
X_18184_ _18196_/A _18184_/B VDD VSS _20010_/D NOR2X1
X_11628_ _18770_/Q _11635_/B VDD VSS _18797_/D AND2X1
XTAP_TAPCELL_ROW_155_1410 VDD VSS WELLTAP
X_15396_ _15396_/A _15396_/B VDD VSS _15434_/A NAND2X1
XFILLER_128_332 VDD VSS FILLER1
XFILLER_129_855 VSS VDD FILLER2
XFILLER_8_77 VSS VDD FILLER2
XFILLER_128_343 VSS VDD FILLER2
XFILLER_8_88 VSS VDD FILLER2
XFILLER_144_803 VSS VDD FILLER2
X_17135_ _17140_/C _17140_/B VDD VSS _17137_/B NAND2BX1
XFILLER_116_505 VDD VSS FILLER4
X_14347_ _14368_/A _14347_/B VDD VSS _19074_/D NOR2X1
X_11559_ _18707_/Q _11567_/B VDD VSS _18734_/D AND2X1
XFILLER_7_662 VDD VSS FILLER4
XFILLER_6_150 VSS VDD FILLER2
XFILLER_116_538 VSS VDD FILLER2
X_17066_ _17062_/Y _17066_/B _17066_/C VDD VSS _17068_/C AOI2B1X1
XFILLER_155_184 VSS VDD FILLER2
X_14278_ _14278_/A _14278_/B VDD VSS _14279_/B XNOR2X1
X_16017_ _19675_/Q _16834_/B VDD VSS _16022_/B XNOR2X1
X_13229_ _13315_/A _13315_/B _13315_/D _13315_/C VDD VSS _14416_/C AOI211X1
XFILLER_112_700 VSS VDD FILLER2
XFILLER_124_560 VSS VDD FILLER2
XFILLER_112_711 VSS VDD FILLER2
XTAP_TAPCELL_ROW_110_1004 VDD VSS WELLTAP
XFILLER_97_444 VDD VSS FILLER4
XFILLER_112_755 VDD VSS FILLER4
XFILLER_112_766 VDD VSS FILLER4
XFILLER_112_777 VDD VSS FILLER4
XFILLER_111_254 VDD VSS FILLER4
XFILLER_112_788 VSS VDD FILLER2
XFILLER_84_105 VSS VDD FILLER2
X_17968_ _18869_/Q _17968_/B VDD VSS _17976_/A AND2X1
XFILLER_38_500 VDD VSS FILLER1
XFILLER_38_522 VSS VDD FILLER2
X_19707_ _19724_/CK _19707_/D _19707_/Q VDD VSS DFFQX1
XFILLER_19_0 VSS VDD FILLER2
X_16919_ _19739_/Q _17078_/B VDD VSS _16922_/B XOR2X1
XFILLER_38_544 VDD VSS DECAPHV8
X_17899_ _18858_/Q VDD VSS _17905_/A INVX1
XTAP_TAPCELL_ROW_55_509 VDD VSS WELLTAP
X_19638_ _19705_/CK _19638_/D _19638_/Q VDD VSS DFFQX1
XFILLER_81_823 VSS VDD FILLER2
XTAP_TAPCELL_ROW_162_1469 VDD VSS WELLTAP
XFILLER_53_536 VSS VDD FILLER2
X_19569_ _19602_/CK _19569_/D _19569_/Q VDD VSS DFFQX1
XTAP_TAPCELL_ROW_121_1100 VDD VSS WELLTAP
XFILLER_18_290 VSS VDD FILLER2
X_09322_ _18450_/RB _09322_/B VDD VSS _09322_/Y NOR2BX1
XTAP_TAPCELL_ROW_103_941 VDD VSS WELLTAP
XFILLER_34_772 VDD VSS FILLER1
XFILLER_33_282 VSS VDD FILLER2
X_09253_ _20048_/Q _09257_/C _20047_/Q VDD VSS _09299_/A AND3BX1
XFILLER_166_416 VDD VSS FILLER4
XFILLER_21_477 VSS VDD FILLER2
XFILLER_166_449 VDD VSS FILLER1
XFILLER_119_321 VSS VDD FILLER2
XFILLER_147_641 VSS VDD FILLER2
XFILLER_119_343 VDD VSS FILLER1
XFILLER_119_365 VDD VSS FILLER1
XFILLER_146_162 VSS VDD FILLER2
XFILLER_134_313 VDD VSS FILLER4
XTAP_TAPCELL_ROW_119_1084 VDD VSS WELLTAP
XFILLER_134_346 VSS VDD FILLER2
XFILLER_161_132 VDD VSS DECAPHV8
XFILLER_122_508 VSS VDD FILLER2
XFILLER_108_67 VSS VDD FILLER2
XFILLER_68_38 VDD VSS FILLER1
XFILLER_103_733 VSS VDD FILLER2
XFILLER_68_49 VDD VSS FILLER4
XFILLER_102_221 VSS VDD FILLER2
XFILLER_0_359 VDD VSS FILLER1
XFILLER_124_11 VSS VDD FILLER2
XFILLER_48_319 VDD VSS FILLER4
XFILLER_124_44 VSS VDD FILLER2
XFILLER_102_298 VSS VDD FILLER2
XFILLER_17_717 VDD VSS FILLER4
X_10930_ _10931_/A _10931_/B _10931_/D _10931_/C VDD VSS _10932_/B AOAI211X1
XFILLER_17_728 VSS VDD FILLER2
XFILLER_83_160 VSS VDD FILLER2
XFILLER_44_514 VSS VDD FILLER2
XFILLER_84_694 VSS VDD FILLER2
XFILLER_56_385 VDD VSS FILLER4
XFILLER_44_536 VSS VDD FILLER2
XFILLER_72_856 VDD VSS FILLER1
X_10861_ _11550_/A _11609_/A _10861_/C VDD VSS _10903_/C MIN3X1
XTAP_TAPCELL_ROW_26_244 VDD VSS WELLTAP
X_12600_ _19017_/Q _12600_/B VDD VSS _12894_/C _12600_/C NAND3X1
X_13580_ _13661_/A _13580_/B _13580_/C VDD VSS _13591_/C XNOR3X1
XFILLER_71_388 VSS VDD FILLER2
X_10792_ _18698_/Q _18752_/Q VDD VSS _10794_/D XOR2X1
X_12531_ _18878_/Q VDD VSS _17861_/A INVX1
XFILLER_40_742 VSS VDD FILLER2
XFILLER_33_41 VDD VSS DECAPHV8
XFILLER_12_455 VDD VSS FILLER4
X_15250_ _15262_/A _15262_/B VDD VSS _15750_/B XOR2X1
X_12462_ _19128_/Q _12462_/B _12553_/C VDD VSS _12593_/B XOR3X1
XTAP_TAPCELL_ROW_4_45 VDD VSS WELLTAP
XFILLER_33_96 VDD VSS FILLER4
XFILLER_123_0 VSS VDD FILLER2
X_14201_ _14231_/A _14201_/B VDD VSS _18950_/D AND2X1
XFILLER_8_459 VSS VDD FILLER2
X_11413_ _18535_/D _11428_/B VDD VSS _18607_/D NOR2BX1
XFILLER_149_96 VSS VDD FILLER2
X_15181_ _19428_/Q VDD VSS _15204_/C INVX1
X_12393_ _12474_/A _12474_/B _12474_/C _12474_/D VDD VSS _12566_/A AOI31X1
XFILLER_165_460 VDD VSS FILLER4
XFILLER_153_611 VDD VSS FILLER4
XFILLER_125_313 VSS VDD FILLER2
XFILLER_153_622 VDD VSS DECAPHV8
XFILLER_137_184 VSS VDD FILLER2
X_14132_ _14132_/A _14132_/B _14132_/C VDD VSS _14133_/C NOR3X1
X_11344_ _11357_/A _11345_/B _18588_/Q _11345_/C VDD VSS _11352_/C AOI211X1
XFILLER_98_208 VSS VDD FILLER2
X_18940_ _18999_/CK _18940_/D _18940_/Q VDD VSS DFFQX1
X_14063_ _14078_/A _14078_/B VDD VSS _14073_/B NOR2X1
XFILLER_98_219 VDD VSS FILLER1
XFILLER_140_316 VSS VDD FILLER2
X_11275_ _11271_/A _11275_/B _11275_/C VDD VSS _11285_/A AOI2B1X1
XTAP_TAPCELL_ROW_150_1362 VDD VSS WELLTAP
XFILLER_106_582 VDD VSS FILLER4
X_13014_ _13270_/A _13270_/B _13270_/C VDD VSS _13069_/B AOI21X1
X_10226_ _10229_/C _10226_/B VDD VSS _10228_/B NAND2X1
XFILLER_79_433 VDD VSS FILLER4
X_18871_ _19988_/CK _18871_/D _18871_/Q VDD VSS DFFQX1
XFILLER_121_552 VDD VSS FILLER4
X_17822_ _19928_/Q _19896_/Q VDD VSS _17823_/C NAND2X1
X_10157_ _11226_/D _10222_/B VDD VSS _10159_/C NOR2X1
XFILLER_94_447 VSS VDD FILLER2
XFILLER_48_842 VSS VDD FILLER2
X_14965_ _14963_/Y _14965_/B _15868_/B VDD VSS _15052_/A AND3BX1
X_17753_ _19914_/Q _19882_/Q VDD VSS _17758_/A XNOR2X1
X_10088_ _18608_/Q VDD VSS _10101_/A INVX1
X_16704_ _16704_/A _16704_/B VDD VSS _19558_/D NOR2X1
X_13916_ _18977_/Q _13916_/B _13998_/D VDD VSS _13957_/C XNOR3X1
XFILLER_75_672 VSS VDD FILLER2
X_17684_ _19899_/Q _19867_/Q VDD VSS _17686_/C XOR2X1
X_14896_ _14896_/A _14896_/B _15679_/B VDD VSS _14899_/C MIN3X1
X_16635_ _19671_/Q _16830_/B VDD VSS _16636_/B XNOR2X1
X_19423_ _19465_/CK _19423_/D _19423_/Q VDD VSS DFFQX1
XFILLER_35_547 VSS VDD FILLER2
X_13847_ _19031_/Q _14299_/B VDD VSS _13903_/A AND2X1
XFILLER_16_750 VSS VDD FILLER2
X_16566_ _19732_/Q _16566_/B _16897_/B VDD VSS _16589_/A MIN3X1
X_19354_ _19385_/CK _19354_/D _19354_/Q VDD VSS DFFQX1
XFILLER_16_783 VSS VDD FILLER2
X_13778_ _13889_/A _13889_/B _13889_/C VDD VSS _13833_/B AOI21X1
XFILLER_62_399 VSS VDD FILLER2
XFILLER_15_271 VSS VDD FILLER2
XFILLER_95_4 VSS VDD FILLER2
XFILLER_15_282 VSS VDD FILLER2
X_15517_ _15547_/B _15517_/B VDD VSS _15853_/B XNOR2X1
X_18305_ _18311_/CK _18497_/D _18305_/Q _18464_/RB VDD VSS DFFRQX1
X_19285_ _19306_/CK _19285_/D _19285_/Q VDD VSS DFFQX1
X_12729_ _12729_/A _12729_/B _12729_/C _12729_/D VDD VSS _14348_/C OAI211X1
XTAP_TAPCELL_ROW_100_911 VDD VSS WELLTAP
XFILLER_148_416 VSS VDD FILLER2
X_16497_ _19921_/Q VDD VSS _16717_/A INVX1
XTAP_TAPCELL_ROW_60_556 VDD VSS WELLTAP
XFILLER_30_252 VSS VDD FILLER2
XFILLER_148_438 VDD VSS FILLER1
X_18236_ _18241_/CK _18236_/D _18236_/Q _18469_/RB VDD VSS DFFRQX1
X_15448_ _15449_/A _15449_/B _15449_/C VDD VSS _15448_/Y OAI21X1
XFILLER_30_274 VSS VDD FILLER2
XFILLER_129_641 VSS VDD FILLER2
XFILLER_30_296 VSS VDD FILLER2
XFILLER_129_674 VSS VDD FILLER2
X_18167_ _18167_/A _18167_/B _18167_/C VDD VSS _18170_/B OAI21X1
X_15379_ _15386_/B _15379_/B VDD VSS _15691_/B XNOR2X1
XFILLER_144_633 VSS VDD FILLER2
X_17118_ _19777_/Q _19745_/Q _17118_/C VDD VSS _17121_/B MIN3X1
XFILLER_128_184 VSS VDD FILLER2
XFILLER_144_644 VSS VDD FILLER2
X_18098_ _18100_/C _18098_/B VDD VSS _18099_/B XNOR2X1
X_17049_ _19762_/Q _17049_/B _17064_/A _17064_/B VDD VSS _17050_/B AOAI211X1
X_09940_ _10190_/B _09940_/B _09940_/C VDD VSS _09953_/B OAI21X1
XFILLER_143_165 VSS VDD FILLER2
Xmax_cap189 _18516_/Q VDD VSS _18495_/D BUFX8
X_20060_ clkload6/A _20060_/D _20061_/D _20071_/RB VDD VSS DFFRQX1
XFILLER_112_530 VSS VDD FILLER2
X_09871_ _18574_/Q _09871_/B VDD VSS _09871_/Y XNOR2X1
XFILLER_112_563 VDD VSS FILLER4
XFILLER_85_414 VSS VDD FILLER2
XFILLER_112_585 VSS VDD FILLER2
XTAP_TAPCELL_ROW_68_623 VDD VSS WELLTAP
XFILLER_57_138 VSS VDD FILLER2
XFILLER_100_769 VDD VSS FILLER4
XFILLER_66_661 VSS VDD FILLER2
XFILLER_54_801 VDD VSS FILLER4
XFILLER_66_672 VDD VSS FILLER1
XFILLER_26_514 VDD VSS FILLER4
XFILLER_53_311 VSS VDD FILLER2
XFILLER_53_333 VSS VDD FILLER2
XFILLER_26_558 VDD VSS FILLER4
XFILLER_14_709 VSS VDD FILLER2
XFILLER_53_344 VDD VSS FILLER1
XFILLER_81_675 VDD VSS FILLER1
XFILLER_110_35 VSS VDD FILLER2
XFILLER_80_196 VSS VDD FILLER2
XFILLER_22_731 VSS VDD FILLER2
X_09305_ _18295_/Q _18470_/D _09299_/Y VDD VSS _09305_/Y MUXI2X1
XFILLER_139_405 VDD VSS FILLER4
XFILLER_70_28 VSS VDD FILLER2
XFILLER_22_764 VSS VDD FILLER2
X_09236_ _18514_/Q VDD VSS _18349_/D INVX1
Xclkbuf_leaf_20__002_ clkload16/A VDD VSS _18845_/CK BUFX12
XFILLER_22_797 VSS VDD FILLER2
XFILLER_166_268 VSS VDD FILLER2
XFILLER_154_408 VDD VSS FILLER1
XFILLER_119_140 VSS VDD FILLER2
XFILLER_119_22 VSS VDD FILLER2
XTAP_TAPCELL_ROW_31_291 VDD VSS WELLTAP
XFILLER_108_825 VDD VSS FILLER4
XFILLER_107_313 VSS VDD FILLER2
XFILLER_119_184 VSS VDD FILLER2
XFILLER_134_110 VSS VDD FILLER2
XFILLER_162_430 VDD VSS FILLER4
XFILLER_79_48 VDD VSS FILLER1
XFILLER_162_485 VSS VDD FILLER2
XFILLER_1_624 VSS VDD FILLER2
XFILLER_134_198 VDD VSS FILLER1
X_11060_ _18705_/Q VDD VSS _11556_/A INVX1
XFILLER_89_742 VSS VDD FILLER2
XFILLER_115_390 VSS VDD FILLER2
XFILLER_150_669 VSS VDD FILLER2
XFILLER_88_230 VSS VDD FILLER2
X_10011_ _10008_/B _10011_/B VDD VSS _10022_/B NOR2BX1
XFILLER_0_156 VSS VDD FILLER2
X_20189_ _20189_/A VDD VSS _20189_/Y BUFX3
XFILLER_0_178 VSS VDD FILLER2
XFILLER_48_116 VDD VSS FILLER1
XFILLER_76_436 VSS VDD FILLER2
XFILLER_151_20 VDD VSS FILLER1
XFILLER_57_650 VDD VSS FILLER1
XFILLER_91_406 VSS VDD FILLER2
X_14750_ _14872_/B _14781_/D VDD VSS _14751_/C AND2X1
X_11962_ _11962_/A _11962_/B _14368_/B VDD VSS _12018_/A MIN3X1
XFILLER_17_514 VDD VSS DECAPHV8
X_13701_ _19057_/Q _14328_/B VDD VSS _13783_/A NOR2BX1
XFILLER_45_856 VDD VSS FILLER1
X_10913_ _10775_/Y _10912_/Y _11118_/A VDD VSS _10913_/Y MUXI2X1
XFILLER_72_642 VSS VDD FILLER2
Xclkbuf_leaf_15_clk_regs clkload1/A VDD VSS clkload6/A BUFX12
X_14681_ _14681_/A _15892_/B VDD VSS _14710_/C NAND2X1
X_11893_ _19175_/Q _14461_/B VDD VSS _11922_/A NAND2X1
XFILLER_44_355 VDD VSS FILLER1
XFILLER_17_569 VDD VSS FILLER4
XFILLER_72_675 VSS VDD FILLER2
XFILLER_32_506 VDD VSS FILLER4
X_16420_ _16399_/B _16420_/B _16420_/C VDD VSS _16453_/B AOI2B1X1
X_13632_ _13721_/A _13721_/B _13721_/E VDD VSS _13642_/B AOI21X1
X_10844_ _11118_/A _10844_/B _10844_/C _11120_/A VDD VSS _10845_/C AOI211X1
XFILLER_32_539 VSS VDD FILLER2
X_16351_ _16352_/A _16352_/B _16352_/C VDD VSS _16388_/B OAI21X1
XFILLER_12_230 VSS VDD FILLER2
X_13563_ _19112_/Q _13714_/A _13721_/B VDD VSS _13696_/D XNOR3X1
X_10775_ _10698_/Y _10774_/Y _10947_/A VDD VSS _10775_/Y MUXI2X1
X_15302_ _19374_/Q VDD VSS _15303_/A INVX1
XFILLER_12_263 VSS VDD FILLER2
X_19070_ _19072_/CK _19070_/D _19070_/Q VDD VSS DFFQX1
X_12514_ _19043_/Q _12514_/B _12514_/C VDD VSS _12540_/A MIN3X1
X_16282_ _19593_/Q _16743_/B VDD VSS _16283_/C NOR2X1
X_13494_ _13494_/A _13494_/B _14158_/B VDD VSS _14126_/B XNOR3X1
X_18021_ _18024_/B _18045_/B _18021_/C _18056_/C VDD VSS _19968_/D OAI31X1
XTAP_TAPCELL_ROW_139_1268 VDD VSS WELLTAP
XFILLER_8_245 VSS VDD FILLER2
X_15233_ _15275_/A _15275_/B _15275_/C _15275_/D VDD VSS _15274_/A AO31X2
X_12445_ _12515_/C _12519_/B _12519_/C VDD VSS _12510_/C NOR3X1
XFILLER_60_72 VDD VSS DECAPHV8
X_15164_ _19371_/Q _15748_/B VDD VSS _15165_/B XNOR2X1
XFILLER_126_655 VSS VDD FILLER2
X_12376_ _12467_/A _12483_/A _12472_/B VDD VSS _12378_/C XNOR3X1
XFILLER_153_463 VSS VDD FILLER2
X_14115_ _14118_/A _14115_/B VDD VSS _18875_/D NOR2X1
XFILLER_114_828 VDD VSS FILLER4
X_11327_ _11333_/A _11327_/B VDD VSS _11328_/B XNOR2X1
X_15095_ _19481_/Q _15873_/B VDD VSS _15112_/D NAND2X1
X_19972_ _19985_/CK _19972_/D _19972_/Q VDD VSS DFFQX1
XFILLER_5_67 VDD VSS FILLER4
XFILLER_140_113 VDD VSS FILLER4
XFILLER_4_484 VSS VDD FILLER2
XFILLER_125_198 VSS VDD FILLER2
XFILLER_141_647 VDD VSS FILLER4
XFILLER_141_658 VSS VDD FILLER2
X_18923_ _18924_/CK _18923_/D _18923_/Q VDD VSS DFFQX1
X_14046_ _14068_/A _14068_/C VDD VSS _14047_/C NOR2X1
XFILLER_106_390 VSS VDD FILLER2
X_11258_ _11258_/A _11264_/C VDD VSS _11262_/C XOR2X1
XFILLER_140_179 VDD VSS DECAPHV8
X_10209_ _10217_/A _10209_/B VDD VSS _11426_/C XNOR2X1
X_18854_ _18915_/CK _18854_/D _18854_/Q VDD VSS DFFQX1
XFILLER_67_414 VSS VDD FILLER2
X_11189_ _11272_/A _11189_/B VDD VSS _18576_/D NOR2X1
XFILLER_79_296 VDD VSS FILLER4
XFILLER_0_690 VSS VDD FILLER2
X_17805_ _17807_/C _17805_/B VDD VSS _17806_/B XNOR2X1
XFILLER_67_447 VSS VDD FILLER2
X_15997_ _16038_/C _15997_/B VDD VSS _16732_/B XNOR2X1
X_18785_ _18785_/CK _18785_/D _18785_/Q VDD VSS DFFQX1
XFILLER_95_778 VSS VDD FILLER2
XFILLER_55_609 VSS VDD FILLER2
XFILLER_85_80 VDD VSS FILLER4
X_14948_ _14951_/B _14948_/B VDD VSS _18079_/B XNOR2X1
X_17736_ _19910_/Q _19878_/Q VDD VSS _17738_/D XNOR2X1
XFILLER_54_119 VSS VDD FILLER2
XFILLER_85_91 VSS VDD FILLER2
X_14879_ _19504_/Q _15898_/B VDD VSS _15015_/D XOR2X1
X_17667_ _17667_/A _17667_/B _17667_/C VDD VSS _17672_/A OA21X2
X_19406_ _19406_/CK _19406_/D _19406_/Q VDD VSS DFFQX1
X_16618_ _16899_/B _19734_/Q VDD VSS _16643_/A NOR2BX1
XTAP_TAPCELL_ROW_73_670 VDD VSS WELLTAP
XFILLER_23_528 VSS VDD FILLER2
X_17598_ _17598_/A _17600_/C _17598_/C VDD VSS _19880_/D AOI21X1
XFILLER_62_174 VDD VSS FILLER4
XFILLER_149_714 VDD VSS FILLER4
X_16549_ _19572_/Q _19924_/Q VDD VSS _16573_/A XOR2X1
X_19337_ _19349_/CK _19337_/D _19337_/Q VDD VSS DFFQX1
XFILLER_50_358 VSS VDD FILLER2
XFILLER_31_561 VSS VDD FILLER2
XFILLER_149_747 VSS VDD FILLER2
XFILLER_86_0 VDD VSS FILLER1
XFILLER_148_235 VSS VDD FILLER2
X_19268_ _19269_/CK _19268_/D _19268_/Q VDD VSS DFFQX1
XFILLER_31_594 VDD VSS FILLER4
XFILLER_148_279 VDD VSS FILLER4
X_18219_ _18219_/CK _18219_/E _18219_/ECK VDD VSS CGX3
X_19199_ _19200_/CK _19199_/D _19199_/Q VDD VSS DFFQX1
XFILLER_117_611 VSS VDD FILLER2
XFILLER_163_216 VDD VSS FILLER4
XFILLER_116_121 VSS VDD FILLER2
XFILLER_144_430 VDD VSS FILLER1
XFILLER_132_603 VDD VSS FILLER1
XTAP_TAPCELL_ROW_116_1054 VDD VSS WELLTAP
XFILLER_132_614 VDD VSS FILLER4
XFILLER_144_485 VDD VSS FILLER1
XFILLER_116_198 VDD VSS FILLER1
X_20112_ _20112_/A VDD VSS _20112_/Y BUFX3
XFILLER_49_18 VSS VDD FILLER2
XFILLER_132_658 VDD VSS FILLER4
X_09923_ _09912_/B _09922_/Y _10966_/A VDD VSS _09924_/B MUXI2X1
XFILLER_49_29 VDD VSS FILLER4
X_20043_ _20045_/CK _20043_/D _20043_/Q _20045_/RB VDD VSS DFFRQX1
XFILLER_98_572 VSS VDD FILLER2
X_09854_ _09902_/B _09850_/Y _10966_/A VDD VSS _09862_/B MUXI2X1
Xclkbuf_1_1__f__09177_ clkbuf_0__09177_/Y VDD VSS _18256_/CK BUFX12
XFILLER_100_522 VSS VDD FILLER2
XFILLER_140_691 VDD VSS FILLER4
XFILLER_86_745 VDD VSS DECAPHV16
XFILLER_105_46 VDD VSS DECAPHV8
XFILLER_85_244 VSS VDD FILLER2
XFILLER_100_555 VSS VDD FILLER2
XFILLER_105_68 VSS VDD FILLER2
X_09785_ _20151_/A _09785_/B _09815_/C _18325_/Q VDD VSS _09787_/C AOI22X1
XFILLER_58_469 VSS VDD FILLER2
XFILLER_86_789 VDD VSS FILLER1
XFILLER_73_406 VDD VSS FILLER1
XFILLER_39_694 VSS VDD FILLER2
XFILLER_53_130 VSS VDD FILLER2
XFILLER_54_675 VSS VDD FILLER2
X_10560_ _18692_/Q _18746_/Q VDD VSS _10561_/A XNOR2X1
XFILLER_139_257 VDD VSS FILLER4
X_09219_ _18516_/Q VDD VSS _18399_/D INVX1
XFILLER_6_716 VDD VSS FILLER4
XFILLER_108_611 VDD VSS FILLER1
X_10491_ _10530_/A _10530_/B _10530_/C _10491_/D VDD VSS _10496_/C AOAI211X1
XFILLER_6_727 VSS VDD FILLER2
XFILLER_155_739 VDD VSS FILLER4
X_12230_ _20002_/Q _19266_/Q VDD VSS _12397_/C XOR2X1
XTAP_TAPCELL_ROW_1_24 VDD VSS WELLTAP
XFILLER_135_463 VSS VDD FILLER2
X_12161_ _12236_/A _12233_/C VDD VSS _14530_/B XOR2X1
XFILLER_107_176 VSS VDD FILLER2
XFILLER_146_53 VSS VDD FILLER2
XFILLER_150_411 VDD VSS FILLER1
X_11112_ _11196_/A _18734_/Q VDD VSS _11113_/C NAND2X1
XFILLER_122_146 VSS VDD FILLER2
XFILLER_150_455 VDD VSS FILLER4
X_12092_ _19151_/Q _14434_/B _14434_/C VDD VSS _12181_/E OR3BX1
XFILLER_150_466 VSS VDD FILLER2
XFILLER_89_561 VSS VDD FILLER2
X_15920_ _15929_/A _15929_/B VDD VSS _15921_/C NAND2X1
X_11043_ _11002_/B _11043_/B _11043_/C VDD VSS _11062_/C AOI2B1X1
XFILLER_1_476 VDD VSS FILLER1
XFILLER_131_680 VSS VDD FILLER2
XFILLER_39_62 VSS VDD FILLER2
XFILLER_1_487 VSS VDD FILLER2
X_15851_ _15867_/A _15851_/B VDD VSS _19463_/D NOR2X1
XFILLER_77_767 VDD VSS FILLER1
X_14802_ _19335_/Q _15707_/B VDD VSS _14803_/B XNOR2X1
X_15782_ _15817_/A VDD VSS _15800_/A BUFX3
X_18570_ _18589_/CK _18570_/D _18570_/Q VDD VSS DFFQX1
X_12994_ _18966_/Q _12994_/B VDD VSS _13171_/E _12994_/C NAND3X1
XTAP_TAPCELL_ROW_87_795 VDD VSS WELLTAP
XFILLER_18_856 VDD VSS FILLER1
X_14733_ _14733_/A _14733_/B _15829_/B VDD VSS _14734_/B MIN3X1
X_17521_ _19864_/Q _19832_/Q VDD VSS _17527_/A XNOR2X1
X_11945_ _19064_/Q _11945_/B _11953_/C VDD VSS _12019_/C MIN3X1
XFILLER_91_269 VDD VSS FILLER4
XFILLER_72_461 VDD VSS FILLER4
X_17452_ _17455_/C _17453_/B _17452_/C VDD VSS _17453_/C OAI21X1
XFILLER_72_472 VSS VDD FILLER2
X_14664_ _14667_/B _14664_/B VDD VSS _15734_/B XNOR2X1
XFILLER_45_697 VSS VDD FILLER2
XFILLER_44_174 VSS VDD FILLER2
X_11876_ _11876_/A _14524_/B VDD VSS _11884_/A OR2X2
XFILLER_60_634 VDD VSS DECAPHV8
X_16403_ _16429_/B _16403_/B VDD VSS _16820_/B NAND2BX1
X_13615_ _19111_/Q _14389_/B VDD VSS _13623_/D _14389_/C NAND3X1
X_17383_ _19835_/Q _19803_/Q VDD VSS _17385_/C XOR2X1
X_10827_ _10861_/C _10827_/B VDD VSS _10828_/C NAND2X1
XTAP_TAPCELL_ROW_70_640 VDD VSS WELLTAP
XFILLER_158_500 VSS VDD FILLER2
X_14595_ _19468_/Q _14595_/B _14595_/C VDD VSS _14608_/B MIN3X1
XFILLER_13_561 VDD VSS DECAPHV8
X_16334_ _19659_/Q _16817_/B VDD VSS _16348_/D NOR2X1
X_19122_ _19134_/CK _19122_/D _19122_/Q VDD VSS DFFQX1
X_13546_ _13546_/A _13546_/B _13546_/C _13546_/D VDD VSS _14420_/C OAI211X1
X_10758_ _18670_/Q _18778_/Q VDD VSS _10801_/D OR2X2
XFILLER_158_555 VDD VSS FILLER4
X_19053_ _19119_/CK _19053_/D _19053_/Q VDD VSS DFFQX1
XFILLER_9_565 VSS VDD FILLER2
X_16265_ _19657_/Q _16815_/B VDD VSS _16267_/C XNOR2X1
XFILLER_158_588 VSS VDD FILLER2
X_13477_ _13509_/A _13509_/C _13509_/B VDD VSS _14260_/C AO21X2
XFILLER_145_227 VDD VSS FILLER4
X_10689_ _10715_/A _10689_/B VDD VSS _10695_/D XNOR2X1
X_15216_ _19316_/Q VDD VSS _15217_/A INVX1
X_18004_ _18549_/Q _18057_/C _18550_/Q VDD VSS _18058_/B AOI21X1
X_12428_ _18932_/Q _12438_/B _14180_/B VDD VSS _14148_/B XNOR3X1
X_16196_ _16196_/A _16199_/B VDD VSS _16197_/B XOR2X1
XFILLER_154_750 VDD VSS FILLER1
X_15147_ _19537_/Q _15186_/B VDD VSS _15904_/B XOR2X1
X_12359_ _12421_/A _12457_/A _12544_/B VDD VSS _12452_/D XNOR3X1
XFILLER_153_282 VSS VDD FILLER2
XFILLER_5_793 VSS VDD FILLER2
XFILLER_141_433 VDD VSS FILLER4
X_15078_ _15080_/B _15078_/B VDD VSS _18094_/B XNOR2X1
X_19955_ _19956_/CK _19955_/D _19955_/Q VDD VSS DFFQX1
XFILLER_99_358 VSS VDD FILLER2
XFILLER_87_509 VSS VDD FILLER2
X_18906_ _18934_/CK _18906_/D _18906_/Q VDD VSS DFFQX1
X_14029_ _14038_/A _14169_/B _14054_/C VDD VSS _14170_/C NOR3X1
X_19886_ clkload9/A _19886_/D _19886_/Q VDD VSS DFFQX1
X_18837_ _19954_/CK _18837_/D _18837_/Q VDD VSS DFFQX1
XFILLER_83_704 VDD VSS DECAPHV8
XFILLER_68_778 VSS VDD FILLER2
XFILLER_68_789 VDD VSS FILLER1
XFILLER_67_266 VSS VDD FILLER2
X_09570_ _18506_/Q _18505_/Q _09630_/C VDD VSS _09814_/B AND3BX1
XFILLER_82_214 VSS VDD FILLER2
XFILLER_67_288 VDD VSS DECAPHV8
X_18768_ _18795_/CK _18768_/D _18768_/Q VDD VSS DFFQX1
X_17719_ _17718_/B _17719_/B VDD VSS _17721_/C NOR2BX1
X_18699_ _19940_/CK _18699_/D _18699_/Q VDD VSS DFFQX1
XFILLER_35_152 VSS VDD FILLER2
XFILLER_63_472 VSS VDD FILLER2
XFILLER_35_174 VSS VDD FILLER2
X_09962__233 _20052_/CK VDD VSS _18509_/CK INVX1
XFILLER_51_667 VSS VDD FILLER2
XFILLER_50_144 VDD VSS FILLER1
XFILLER_149_544 VDD VSS FILLER4
XFILLER_137_706 VSS VDD FILLER2
XFILLER_137_728 VDD VSS FILLER4
XFILLER_164_514 VDD VSS FILLER4
XFILLER_137_739 VDD VSS FILLER4
XFILLER_132_400 VDD VSS FILLER1
XFILLER_144_260 VSS VDD FILLER2
XFILLER_105_636 VSS VDD FILLER2
XFILLER_132_433 VDD VSS FILLER1
XFILLER_160_742 VDD VSS FILLER4
XFILLER_105_658 VSS VDD FILLER2
XFILLER_78_509 VSS VDD FILLER2
X_09906_ _10032_/A _09929_/B _09944_/A VDD VSS _09915_/C OAI21X1
XFILLER_101_820 VSS VDD FILLER2
XFILLER_58_200 VDD VSS FILLER1
X_20026_ _20033_/CK _20026_/D _20026_/Q _20030_/RB VDD VSS DFFRQX1
XFILLER_76_49 VSS VDD FILLER2
X_09837_ _18560_/Q _18561_/Q _18562_/Q _09941_/C VDD VSS _09942_/A AND4X2
XFILLER_86_564 VSS VDD FILLER2
XFILLER_74_715 VSS VDD FILLER2
XFILLER_100_363 VSS VDD FILLER2
X_09768_ _18372_/Q _09772_/B _09768_/C _09768_/D VDD VSS _09769_/E OAI211X1
XFILLER_46_439 VSS VDD FILLER2
XFILLER_132_44 VSS VDD FILLER2
XFILLER_132_55 VSS VDD FILLER2
XFILLER_27_631 VDD VSS DECAPHV8
XTAP_TAPCELL_ROW_84_765 VDD VSS WELLTAP
X_09699_ _20073_/Q _09818_/B _09813_/C _09699_/D _09699_/E VDD VSS _09700_/B AOI221X1
XFILLER_92_37 VSS VDD FILLER2
XFILLER_54_450 VSS VDD FILLER2
XFILLER_162_4 VDD VSS FILLER1
X_11730_ _19143_/Q _14425_/B VDD VSS _11758_/B NOR2X1
XFILLER_54_472 VDD VSS FILLER4
XFILLER_42_634 VSS VDD FILLER2
XFILLER_14_347 VSS VDD FILLER2
XFILLER_41_133 VDD VSS FILLER1
Xclkbuf_leaf_3__000_ clkbuf_leaf_6__000_/A VDD VSS _19730_/CK BUFX12
X_11661_ _18800_/Q _11669_/B VDD VSS _18827_/D AND2X1
XFILLER_41_166 VSS VDD FILLER2
X_13400_ _18969_/Q _13400_/B VDD VSS _13402_/C _13400_/C NAND3X1
X_10612_ _10642_/A _10642_/B _10613_/C _11195_/A VDD VSS _10613_/D AOAI211X1
X_14380_ _14393_/A _14380_/B VDD VSS _19103_/D NOR2X1
X_11592_ _18737_/Q _11600_/B VDD VSS _18764_/D AND2X1
X_13331_ _13331_/A _13331_/B _13331_/C _13331_/D VDD VSS _14449_/B OAOI211X1
XFILLER_41_30 VSS VDD FILLER2
X_10543_ _10544_/A _10544_/B _10544_/D _10544_/C VDD VSS _10543_/Y AOI211X1
XFILLER_127_216 VSS VDD FILLER2
XFILLER_10_575 VDD VSS FILLER1
XFILLER_41_63 VDD VSS FILLER1
XFILLER_127_238 VDD VSS FILLER1
XTAP_TAPCELL_ROW_136_1238 VDD VSS WELLTAP
X_16050_ _19712_/Q _16875_/B VDD VSS _16054_/B XOR2X1
X_13262_ _19249_/Q _13262_/B _13345_/D VDD VSS _13347_/C XNOR3X1
XFILLER_136_750 VDD VSS FILLER1
X_10474_ _18556_/Q _10474_/B _10474_/C VDD VSS _10544_/A AO21X2
XFILLER_41_96 VSS VDD FILLER2
XFILLER_136_761 VDD VSS FILLER4
XFILLER_142_208 VDD VSS FILLER1
X_15001_ _15054_/B _15836_/B _19451_/Q VDD VSS _15003_/C AOI2B1X1
X_12213_ _19153_/Q _12213_/B _12214_/D VDD VSS _12372_/B XNOR3X1
XFILLER_157_96 VSS VDD FILLER2
XFILLER_108_485 VDD VSS FILLER4
X_13193_ _14219_/C _18968_/Q _13395_/B VDD VSS _13295_/D AND3BX1
XFILLER_135_282 VSS VDD FILLER2
XFILLER_150_230 VSS VDD FILLER2
X_12144_ _19096_/Q _14373_/B VDD VSS _12210_/C _14373_/C NAND3X1
XFILLER_123_455 VDD VSS FILLER1
XFILLER_37_9 VSS VDD FILLER2
XFILLER_110_105 VSS VDD FILLER2
XFILLER_150_274 VDD VSS FILLER4
X_19740_ clkload4/A _19740_/D _19740_/Q VDD VSS DFFQX1
XFILLER_96_328 VDD VSS FILLER4
XFILLER_150_285 VSS VDD FILLER2
X_16952_ _19746_/Q _16978_/B VDD VSS _16954_/A XOR2X1
X_12075_ _12080_/A _12080_/B _12075_/C VDD VSS _14306_/B XNOR3X1
XFILLER_96_339 VSS VDD FILLER2
XFILLER_49_211 VSS VDD FILLER2
XFILLER_110_138 VDD VSS FILLER1
X_15903_ _15906_/A _15903_/B VDD VSS _19509_/D NOR2X1
X_11026_ _10996_/A _11026_/B _11026_/C VDD VSS _11090_/A OR3BX1
X_19671_ _19705_/CK _19671_/D _19671_/Q VDD VSS DFFQX1
X_16883_ _16899_/A _16883_/B VDD VSS _19719_/D AND2X1
XTAP_TAPCELL_ROW_147_1334 VDD VSS WELLTAP
XFILLER_49_277 VSS VDD FILLER2
X_18622_ _18622_/CK _18622_/D _18622_/Q VDD VSS DFFQX1
X_15834_ _14522_/Y _15834_/B _15834_/C VDD VSS _19449_/D AND3BX1
XFILLER_92_534 VDD VSS DECAPHV8
XFILLER_64_225 VDD VSS FILLER4
XTAP_TAPCELL_ROW_47_434 VDD VSS WELLTAP
X_18553_ _18578_/CK _18553_/D _18553_/Q VDD VSS DFFQX1
XFILLER_92_567 VDD VSS DECAPHV8
X_15765_ _15780_/A _15765_/B VDD VSS _19387_/D NOR2X1
X_12977_ _19022_/Q _13095_/A _13270_/B VDD VSS _12996_/D XNOR3X1
XFILLER_45_450 VDD VSS DECAPHV8
X_17504_ _17505_/A _17507_/C _17509_/C VDD VSS _17505_/C OAI21X1
XFILLER_73_781 VDD VSS DECAPHV16
X_14716_ _19473_/Q _14781_/A _14781_/B VDD VSS _14775_/B XNOR3X1
X_11928_ _14526_/A _14526_/B _11981_/C VDD VSS _12048_/C AOI21X1
X_15696_ _15706_/A _15696_/B VDD VSS _19324_/D AND2X1
X_18484_ _18487_/CK _18521_/Q _20129_/A _18486_/RB VDD VSS DFFRQX1
XFILLER_45_494 VDD VSS FILLER4
XFILLER_17_196 VSS VDD FILLER2
X_17435_ _17439_/A _17436_/B _17452_/C VDD VSS _17436_/C OAI21X1
X_14647_ _19497_/Q _14655_/B VDD VSS _14652_/C AND2X1
X_11859_ _19035_/Q _14303_/B VDD VSS _11954_/B NOR2X1
XFILLER_60_464 VSS VDD FILLER2
XFILLER_60_497 VDD VSS DECAPHV8
XFILLER_20_328 VSS VDD FILLER2
X_17366_ _17366_/A _17366_/B _17366_/C VDD VSS _17372_/A OA21X2
X_14578_ _19521_/Q _19494_/Q _14578_/C VDD VSS _14584_/B XOR3X1
XFILLER_158_341 VSS VDD FILLER2
XFILLER_119_706 VSS VDD FILLER2
X_19105_ _19134_/CK _19105_/D _19105_/Q VDD VSS DFFQX1
XFILLER_146_514 VSS VDD FILLER2
X_16317_ _16317_/A _16337_/B VDD VSS _16781_/B XNOR2X1
X_13529_ _19083_/Q _13696_/A _13696_/B VDD VSS _13531_/C XNOR3X1
X_17297_ _17298_/A _17300_/C _17306_/C VDD VSS _17298_/C OAI21X1
XFILLER_146_547 VDD VSS DECAPHV16
X_16248_ _16512_/A _16248_/B VDD VSS _19528_/D NOR2X1
X_19036_ _19037_/CK _19036_/D _19036_/Q VDD VSS DFFQX1
XFILLER_127_772 VDD VSS FILLER1
XFILLER_161_517 VSS VDD FILLER2
Xoutput103 _20172_/Y VDD VSS o_lf_cfg[9] BUFX3
X_16179_ _16179_/A _16179_/B _16774_/B VDD VSS _16205_/B MIN3X1
Xoutput114 _20183_/Y VDD VSS o_tst_ctrl[2] BUFX3
Xoutput125 _20209_/Y VDD VSS o_uwb_tx_cfg[12] BUFX3
XFILLER_142_731 VSS VDD FILLER2
Xoutput136 _20219_/Y VDD VSS o_uwb_tx_cfg[22] BUFX3
Xoutput147 _20202_/Y VDD VSS o_uwb_tx_cfg[5] BUFX3
XFILLER_49_0 VSS VDD FILLER2
XFILLER_142_764 VSS VDD FILLER2
XFILLER_142_775 VDD VSS FILLER1
XFILLER_99_166 VSS VDD FILLER2
XFILLER_88_829 VSS VDD FILLER2
X_19938_ _19939_/CK _19938_/D _19938_/Q VDD VSS DFFQX1
XFILLER_101_138 VSS VDD FILLER2
XFILLER_101_149 VDD VSS FILLER1
XFILLER_110_650 VSS VDD FILLER2
X_19869_ _19895_/CK _19869_/D _19869_/Q VDD VSS DFFQX1
XFILLER_83_501 VSS VDD FILLER2
X_09622_ _18427_/Q _09696_/B VDD VSS _09623_/E NOR2X1
XFILLER_110_683 VDD VSS FILLER1
XFILLER_28_439 VSS VDD FILLER2
XFILLER_56_759 VSS VDD FILLER2
XFILLER_83_556 VSS VDD FILLER2
X_09553_ _18456_/Q VDD VSS _20098_/A INVX1
XTAP_TAPCELL_ROW_124_1131 VDD VSS WELLTAP
XFILLER_70_228 VDD VSS FILLER4
XFILLER_24_623 VSS VDD FILLER2
X_09484_ _09496_/C VDD VSS _09501_/B BUFX3
XFILLER_23_100 VSS VDD FILLER2
XTAP_TAPCELL_ROW_81_746 VDD VSS WELLTAP
XFILLER_51_420 VSS VDD FILLER2
XFILLER_164_300 VSS VDD FILLER2
XFILLER_164_322 VSS VDD FILLER2
XFILLER_109_238 VSS VDD FILLER2
XFILLER_11_11 VSS VDD FILLER2
XFILLER_117_282 VSS VDD FILLER2
XFILLER_132_230 VSS VDD FILLER2
X_10190_ _11435_/B _10190_/B _10190_/C VDD VSS _10191_/C NOR3X1
XFILLER_132_252 VSS VDD FILLER2
XFILLER_78_306 VDD VSS FILLER1
XTAP_TAPCELL_ROW_89_813 VDD VSS WELLTAP
XFILLER_133_797 VDD VSS FILLER1
XFILLER_78_328 VDD VSS FILLER4
XFILLER_105_499 VDD VSS FILLER4
XFILLER_78_339 VSS VDD FILLER2
XFILLER_160_594 VSS VDD FILLER2
XFILLER_87_840 VSS VDD FILLER2
XFILLER_101_650 VDD VSS FILLER1
XFILLER_101_661 VDD VSS FILLER4
X_12900_ _12900_/A _12900_/B _12900_/C _12900_/D VDD VSS wire156/A OAOI211X1
XFILLER_86_372 VDD VSS FILLER1
XFILLER_46_203 VDD VSS FILLER4
X_20009_ _20013_/CK _20009_/D _20009_/Q VDD VSS DFFQX1
X_13880_ _13938_/A _13981_/B VDD VSS _14134_/B XNOR2X1
XFILLER_143_98 VDD VSS FILLER1
XTAP_TAPCELL_ROW_97_890 VDD VSS WELLTAP
XFILLER_46_225 VDD VSS FILLER1
X_12831_ _19243_/Q _14537_/B _14537_/C VDD VSS _12835_/C OR3BX1
XFILLER_74_567 VSS VDD FILLER2
XTAP_TAPCELL_ROW_109_991 VDD VSS WELLTAP
XFILLER_36_41 VDD VSS FILLER4
XFILLER_15_601 VSS VDD FILLER2
XFILLER_61_217 VSS VDD FILLER2
XFILLER_36_63 VDD VSS FILLER4
XFILLER_27_472 VSS VDD FILLER2
X_15550_ _19437_/Q _15822_/B VDD VSS _15552_/C XOR2X1
X_12762_ _20007_/Q _19271_/Q VDD VSS _12955_/A NAND2X1
XFILLER_36_96 VSS VDD FILLER2
X_14501_ _14539_/A _14501_/B VDD VSS _19210_/D NOR2X1
X_11713_ _19197_/Q _14484_/B VDD VSS _11714_/B OR2X2
XTAP_TAPCELL_ROW_7_78 VDD VSS WELLTAP
XFILLER_159_105 VSS VDD FILLER2
X_15481_ _15512_/B _15481_/B VDD VSS _15851_/B XNOR2X1
X_12693_ _12693_/A _12693_/B _14250_/B VDD VSS _12713_/C MIN3X1
X_17220_ _17390_/A _17220_/B VDD VSS _19799_/D NOR2X1
X_14432_ _14456_/A _14432_/B VDD VSS _19149_/D NOR2X1
X_11644_ _18785_/Q _11647_/B VDD VSS _18812_/D AND2X1
XFILLER_14_199 VSS VDD FILLER2
XTAP_TAPCELL_ROW_52_481 VDD VSS WELLTAP
XFILLER_52_62 VSS VDD FILLER2
XFILLER_11_840 VDD VSS FILLER4
XFILLER_128_503 VDD VSS FILLER1
XFILLER_156_812 VSS VDD FILLER2
XFILLER_11_851 VSS VDD FILLER2
X_17151_ _17300_/B _17151_/B _17151_/C VDD VSS _17156_/C MIN3X1
XFILLER_128_514 VSS VDD FILLER2
X_14363_ _14363_/A _14363_/B _15836_/C VDD VSS _19087_/D OA21X2
XFILLER_155_300 VSS VDD FILLER2
X_11575_ _18722_/Q _11578_/B VDD VSS _18749_/D AND2X1
X_16102_ _19714_/Q _16878_/B VDD VSS _16103_/C NOR2X1
XFILLER_156_856 VDD VSS FILLER1
X_13314_ _13314_/A _13314_/B _13314_/C _13314_/D VDD VSS _13319_/B AOAI211X1
X_17082_ _19770_/Q _19738_/Q _17082_/C VDD VSS _19770_/D AOI21X1
X_10526_ _18691_/Q _18745_/Q VDD VSS _10563_/B XOR2X1
XFILLER_10_394 VSS VDD FILLER2
X_14294_ _14294_/A _14294_/B _14294_/C VDD VSS _19027_/D NOR3X1
XFILLER_155_355 VDD VSS FILLER4
XFILLER_143_517 VSS VDD FILLER2
X_16033_ _16033_/A _16033_/B _16033_/C VDD VSS _16059_/B AO21X2
X_13245_ _13444_/A _13444_/B _13444_/D _13444_/C VDD VSS _14513_/C AOI211X1
XFILLER_109_794 VDD VSS DECAPHV8
X_10457_ _18689_/Q _18743_/Q VDD VSS _10458_/A XNOR2X1
XTAP_TAPCELL_ROW_153_1393 VDD VSS WELLTAP
XFILLER_123_230 VDD VSS FILLER1
XFILLER_124_764 VDD VSS FILLER4
X_13176_ _13287_/A _13287_/B _13184_/C VDD VSS _17894_/B XNOR3X1
XFILLER_124_775 VDD VSS DECAPHV8
X_10388_ _10625_/A _10660_/B _10388_/C _10595_/A VDD VSS _10389_/B AOAI211X1
XFILLER_151_561 VSS VDD FILLER2
XFILLER_123_263 VSS VDD FILLER2
X_12127_ _12129_/A _12129_/B _14176_/B VDD VSS _14143_/B XNOR3X1
XFILLER_69_328 VSS VDD FILLER2
X_17984_ _17987_/A _17987_/B _17989_/A _17987_/C VDD VSS _17984_/Y AOI211X1
X_19723_ _19724_/CK _19723_/D _19723_/Q VDD VSS DFFQX1
XFILLER_28_5 VSS VDD FILLER2
X_16935_ _16937_/A _16937_/B _16935_/C VDD VSS _19742_/D AOI21X1
X_12058_ _19207_/Q _12234_/A _12234_/B VDD VSS _12113_/C XNOR3X1
X_11009_ _11009_/A _11009_/B VDD VSS _11010_/C NAND2X1
X_19654_ _19696_/CK _19654_/D _19654_/Q VDD VSS DFFQX1
X_16866_ _17391_/A VDD VSS _16876_/A BUFX3
XFILLER_77_394 VSS VDD FILLER2
XFILLER_37_236 VDD VSS FILLER4
X_18605_ _18612_/CK _18605_/D _18605_/Q VDD VSS DFFQX1
X_15817_ _15817_/A VDD VSS _15830_/A BUFX3
X_19585_ _19600_/CK _19585_/D _19585_/Q VDD VSS DFFQX1
XFILLER_53_718 VSS VDD FILLER2
X_16797_ _16843_/A _16797_/B VDD VSS _19642_/D AND2X1
XFILLER_92_386 VSS VDD FILLER2
X_18536_ _18543_/CK _18536_/D _18536_/Q VDD VSS DFFQX1
XFILLER_52_228 VDD VSS FILLER4
X_15748_ _15758_/A _15748_/B VDD VSS _19371_/D NOR2X1
XFILLER_93_91 VSS VDD FILLER2
XFILLER_33_453 VSS VDD FILLER2
X_18467_ _18469_/CK _18499_/D _18467_/Q _20078_/RB VDD VSS DFFRQX1
X_15679_ _15693_/A _15679_/B VDD VSS _19308_/D NOR2X1
XTAP_TAPCELL_ROW_15_150 VDD VSS WELLTAP
XFILLER_61_795 VSS VDD FILLER2
XFILLER_60_272 VDD VSS DECAPHV8
XFILLER_33_486 VSS VDD FILLER2
X_17418_ _19842_/Q _19810_/Q VDD VSS _17419_/B XOR2X1
XFILLER_20_114 VSS VDD FILLER2
X_18398_ _18407_/CK _18515_/Q _20139_/A _09380_/B VDD VSS DFFRQX1
XFILLER_20_136 VSS VDD FILLER2
XFILLER_146_300 VSS VDD FILLER2
XFILLER_147_834 VSS VDD FILLER2
X_17349_ _19827_/Q _19795_/Q VDD VSS _17351_/B XOR2X1
XFILLER_146_322 VSS VDD FILLER2
XFILLER_147_856 VDD VSS FILLER1
X_19019_ _19044_/CK _19019_/D _19019_/Q VDD VSS DFFQX1
XFILLER_162_837 VSS VDD FILLER2
XFILLER_134_539 VDD VSS FILLER1
XFILLER_115_742 VSS VDD FILLER2
XFILLER_114_230 VSS VDD FILLER2
XFILLER_161_369 VSS VDD FILLER2
XFILLER_114_252 VSS VDD FILLER2
XFILLER_142_561 VDD VSS FILLER1
XFILLER_114_263 VSS VDD FILLER2
XFILLER_102_447 VDD VSS FILLER4
Xclkbuf_leaf_2__001_ clkbuf_leaf_4__001_/A VDD VSS _20000_/CK BUFX12
XFILLER_69_840 VSS VDD FILLER2
XFILLER_75_309 VSS VDD FILLER2
XFILLER_29_704 VDD VSS FILLER1
XFILLER_84_821 VSS VDD FILLER2
XFILLER_56_534 VSS VDD FILLER2
XFILLER_56_545 VDD VSS FILLER1
X_09605_ _18394_/Q VDD VSS _20135_/A INVX1
XTAP_TAPCELL_ROW_94_860 VDD VSS WELLTAP
XFILLER_44_729 VSS VDD FILLER2
XFILLER_83_375 VSS VDD FILLER2
XFILLER_83_386 VDD VSS FILLER1
XFILLER_73_39 VSS VDD FILLER2
X_09536_ _20031_/Q _18199_/A VDD VSS _20032_/D NOR2BX1
XFILLER_71_537 VSS VDD FILLER2
XFILLER_52_740 VDD VSS FILLER4
XFILLER_24_453 VSS VDD FILLER2
X_09467_ _19973_/Q _09467_/B _09476_/C VDD VSS _09468_/C AOI21X1
X_09398_ _18231_/E _11378_/A VDD VSS _18230_/E AND2X1
XFILLER_138_812 VDD VSS DECAPHV8
XFILLER_7_107 VSS VDD FILLER2
XFILLER_138_834 VDD VSS FILLER4
XFILLER_149_160 VSS VDD FILLER2
XFILLER_165_620 VDD VSS FILLER4
XFILLER_7_129 VSS VDD FILLER2
XFILLER_138_856 VDD VSS FILLER1
X_11360_ _11367_/A _11367_/C VDD VSS _11361_/B XNOR2X1
XFILLER_125_517 VSS VDD FILLER2
XTAP_TAPCELL_ROW_133_1208 VDD VSS WELLTAP
XFILLER_4_814 VSS VDD FILLER2
X_10311_ _11273_/A VDD VSS _11272_/A BUFX3
XFILLER_137_399 VSS VDD FILLER2
X_11291_ _11291_/A VDD VSS _11308_/B INVX1
XFILLER_98_58 VDD VSS FILLER4
XFILLER_152_358 VSS VDD FILLER2
X_13030_ _19134_/Q _14414_/B VDD VSS _13314_/C _14414_/C AND3X2
X_10242_ _18624_/Q _11436_/C _18623_/Q VDD VSS _11430_/B AOI21X1
XFILLER_98_69 VSS VDD FILLER2
XFILLER_133_561 VDD VSS FILLER4
XFILLER_106_797 VDD VSS FILLER1
XFILLER_120_200 VSS VDD FILLER2
X_10173_ _10174_/C _16273_/A _10173_/C VDD VSS _18542_/D AND3BX1
XFILLER_79_648 VSS VDD FILLER2
Xclkbuf_leaf_21__000_ clkload70/A VDD VSS _19573_/CK BUFX12
XFILLER_160_391 VDD VSS FILLER1
XFILLER_94_607 VDD VSS FILLER4
XFILLER_121_778 VSS VDD FILLER2
XFILLER_94_618 VSS VDD FILLER2
XFILLER_66_309 VSS VDD FILLER2
X_14981_ _15026_/A _14981_/B VDD VSS _15743_/B XNOR2X1
XFILLER_120_277 VSS VDD FILLER2
X_16720_ _19924_/Q VDD VSS _17803_/A INVX1
Xfanout182 _18625_/Q VDD VSS _11436_/C BUFX3
XFILLER_47_40 VSS VDD FILLER2
Xfanout193 _18508_/Q VDD VSS _09816_/D BUFX3
X_13932_ _13941_/A _13941_/B VDD VSS _17937_/B _13941_/C NAND3X1
XFILLER_47_556 VSS VDD FILLER2
XFILLER_35_707 VDD VSS DECAPHV8
X_16651_ _19927_/Q VDD VSS _16724_/A INVX1
X_13863_ _19004_/Q _13951_/B _13951_/C VDD VSS _13998_/B XNOR3X1
Xclkbuf_leaf_36__000_ clkbuf_leaf_6__000_/A VDD VSS _19528_/CK BUFX12
XFILLER_62_526 VDD VSS FILLER1
X_15602_ _19439_/Q _15824_/B VDD VSS _15603_/B XNOR2X1
X_12814_ _19131_/Q _14410_/B _14410_/C VDD VSS _12819_/D OR3BX1
XTAP_TAPCELL_ROW_29_275 VDD VSS WELLTAP
XFILLER_74_397 VSS VDD FILLER2
X_19370_ _19406_/CK _19370_/D _19370_/Q VDD VSS DFFQX1
X_16582_ _16582_/A _16595_/B VDD VSS _16863_/B XNOR2X1
X_13794_ _13857_/A _13857_/B _13857_/C VDD VSS _13854_/C OAI21X1
XFILLER_27_291 VSS VDD FILLER2
X_18321_ _18327_/CK _18518_/Q _18321_/Q _20067_/RB VDD VSS DFFRQX1
X_15533_ _15674_/A _18153_/B VDD VSS _19296_/D AND2X1
X_12745_ _12771_/A _12771_/B _12746_/D _12771_/E VDD VSS _14443_/B OA211X2
XFILLER_63_61 VSS VDD FILLER2
XFILLER_15_475 VSS VDD FILLER2
XFILLER_30_412 VDD VSS FILLER4
XFILLER_70_581 VDD VSS FILLER1
X_15464_ _15464_/A _15464_/B VDD VSS _15492_/B AND2X1
X_18252_ _18257_/CK _18252_/D _18265_/D _18469_/RB VDD VSS DFFRQX1
XFILLER_15_497 VDD VSS FILLER1
X_12676_ _19215_/Q _14507_/B _12832_/C VDD VSS _12827_/A XNOR3X1
X_17203_ _19796_/Q _19764_/Q VDD VSS _17206_/A XNOR2X1
X_14415_ _14415_/A _14415_/B VDD VSS _19135_/D AND2X1
XTAP_TAPCELL_ROW_12_120 VDD VSS WELLTAP
X_11627_ _18769_/Q _11635_/B VDD VSS _18796_/D AND2X1
X_15395_ _19488_/Q _15881_/B _15395_/C VDD VSS _15405_/A AOI21X1
X_18183_ _18185_/A _18183_/B VDD VSS _18184_/B XOR2X1
XTAP_TAPCELL_ROW_155_1411 VDD VSS WELLTAP
XFILLER_11_681 VSS VDD FILLER2
XFILLER_156_642 VSS VDD FILLER2
X_17134_ _19781_/Q _19749_/Q VDD VSS _17140_/B NAND2X1
X_14346_ _14352_/A _14346_/B _14346_/C VDD VSS _19073_/D NOR3X1
XFILLER_128_355 VSS VDD FILLER2
X_11558_ _18706_/Q _11567_/B VDD VSS _18733_/D AND2X1
XFILLER_128_377 VSS VDD FILLER2
XFILLER_155_152 VSS VDD FILLER2
XFILLER_144_837 VSS VDD FILLER2
XFILLER_143_314 VDD VSS FILLER4
X_17065_ _17062_/Y _17066_/C _17066_/B VDD VSS _17067_/B AND3BX1
X_10509_ _10544_/A _10509_/B VDD VSS _10510_/B XOR2X1
XFILLER_143_325 VSS VDD FILLER2
X_14277_ _14285_/A _14277_/B VDD VSS _19013_/D NOR2X1
XFILLER_7_696 VDD VSS DECAPHV16
X_11489_ _18644_/Q _11496_/B VDD VSS _18671_/D AND2X1
X_16016_ _19707_/Q VDD VSS _16022_/A INVX1
X_13228_ _13122_/A _14447_/B _14447_/C VDD VSS _13315_/C AND3BX1
XTAP_TAPCELL_ROW_110_1005 VDD VSS WELLTAP
XFILLER_111_200 VSS VDD FILLER2
XFILLER_124_594 VDD VSS FILLER1
X_13159_ _19080_/Q _13364_/A _13364_/B VDD VSS _13271_/D XNOR3X1
XFILLER_111_244 VSS VDD FILLER2
XFILLER_69_158 VSS VDD FILLER2
X_17967_ _17976_/B _18127_/B _17967_/C VDD VSS _19959_/D AND3BX1
XFILLER_111_266 VSS VDD FILLER2
XFILLER_111_277 VSS VDD FILLER2
X_19706_ _19724_/CK _19706_/D _19706_/Q VDD VSS DFFQX1
X_16918_ _17073_/B VDD VSS _17078_/B BUFX3
X_17898_ _17901_/C _17898_/B _17898_/C _17898_/D VDD VSS _19947_/D AOI31X1
XFILLER_66_854 VSS VDD FILLER2
XFILLER_38_556 VSS VDD FILLER2
X_19637_ _19702_/CK _19637_/D _19637_/Q VDD VSS DFFQX1
XFILLER_93_662 VSS VDD FILLER2
X_16849_ _16865_/A _16849_/B VDD VSS _19688_/D NOR2X1
XFILLER_65_375 VSS VDD FILLER2
XFILLER_19_781 VSS VDD FILLER2
XFILLER_80_323 VSS VDD FILLER2
Xdelaybuf_0_sclk delaybuf_0_sclk/A VDD VSS _18219_/CK BUFX12
X_19568_ _19584_/CK _19568_/D _19568_/Q VDD VSS DFFQX1
XTAP_TAPCELL_ROW_91_830 VDD VSS WELLTAP
XTAP_TAPCELL_ROW_121_1101 VDD VSS WELLTAP
X_09321_ _18450_/D _09320_/Y _09302_/Y VDD VSS _18519_/D MUXI2X1
X_18519_ _18519_/CK _18519_/D _18519_/Q _09319_/Y VDD VSS DFFRQX1
X_19499_ _19528_/CK _19499_/D _19499_/Q VDD VSS DFFQX1
XTAP_TAPCELL_ROW_63_576 VDD VSS WELLTAP
XTAP_TAPCELL_ROW_103_942 VDD VSS WELLTAP
XFILLER_21_412 VSS VDD FILLER2
X_09252_ _20046_/Q _18258_/Q VDD VSS _09257_/C NOR2BX1
XFILLER_138_119 VSS VDD FILLER2
XFILLER_147_620 VDD VSS FILLER1
XFILLER_135_804 VSS VDD FILLER2
XFILLER_107_517 VDD VSS DECAPHV16
XFILLER_135_826 VSS VDD FILLER2
XFILLER_119_388 VDD VSS DECAPHV8
XTAP_TAPCELL_ROW_119_1085 VDD VSS WELLTAP
XFILLER_108_24 VDD VSS FILLER4
XFILLER_104_9 VSS VDD FILLER2
XFILLER_108_35 VSS VDD FILLER2
XFILLER_161_155 VDD VSS FILLER4
XFILLER_115_561 VSS VDD FILLER2
XFILLER_1_817 VDD VSS FILLER1
XFILLER_0_305 VSS VDD FILLER2
XFILLER_161_199 VDD VSS FILLER4
XFILLER_142_380 VSS VDD FILLER2
XFILLER_130_531 VDD VSS DECAPHV8
XFILLER_103_756 VDD VSS FILLER1
XFILLER_76_607 VSS VDD FILLER2
XFILLER_76_618 VDD VSS FILLER1
XFILLER_48_309 VSS VDD FILLER2
XFILLER_75_106 VSS VDD FILLER2
XFILLER_75_139 VDD VSS DECAPHV16
Xclkbuf_0_sclk sclk VDD VSS clkbuf_0_sclk/Y BUFX12
XFILLER_84_38 VDD VSS DECAPHV8
XFILLER_68_191 VDD VSS FILLER4
XFILLER_84_651 VSS VDD FILLER2
XFILLER_84_49 VSS VDD FILLER2
XFILLER_29_556 VSS VDD FILLER2
XFILLER_72_802 VSS VDD FILLER2
XFILLER_17_32 VSS VDD FILLER2
XFILLER_17_54 VSS VDD FILLER2
X_10860_ _18753_/Q VDD VSS _11609_/A INVX1
XFILLER_44_548 VDD VSS FILLER1
XFILLER_140_55 VSS VDD FILLER2
XFILLER_71_345 VSS VDD FILLER2
X_09519_ _20018_/Q _20017_/Q _09519_/C VDD VSS _20018_/D AOI21X1
XTAP_TAPCELL_ROW_26_245 VDD VSS WELLTAP
XFILLER_140_77 VDD VSS DECAPHV8
X_10791_ _11039_/C _10856_/B VDD VSS _10805_/B NAND2X1
XFILLER_52_570 VSS VDD FILLER2
XFILLER_40_721 VSS VDD FILLER2
X_12530_ _13283_/A _17868_/B VDD VSS _18849_/D AND2X1
XFILLER_33_20 VSS VDD FILLER2
XFILLER_33_31 VSS VDD FILLER2
XFILLER_149_31 VSS VDD FILLER2
XFILLER_8_416 VSS VDD FILLER2
XFILLER_157_428 VSS VDD FILLER2
X_12461_ _12461_/A _12461_/B _12461_/C _12461_/D VDD VSS _12630_/A OAOI211X1
XFILLER_40_787 VSS VDD FILLER2
XTAP_TAPCELL_ROW_4_46 VDD VSS WELLTAP
XFILLER_12_489 VDD VSS FILLER1
X_14200_ _15383_/A VDD VSS _14231_/A BUFX3
X_11412_ _18534_/D _11428_/B VDD VSS _18606_/D NOR2BX1
X_15180_ _15161_/B _15180_/B _15180_/C VDD VSS _15206_/A AOI2B1X1
X_12392_ _14503_/C _19211_/Q _12571_/B VDD VSS _12474_/D AND3BX1
XFILLER_138_675 VSS VDD FILLER2
XFILLER_137_163 VSS VDD FILLER2
XFILLER_116_0 VDD VSS DECAPHV8
X_14131_ _18196_/A _14131_/B _14131_/C VDD VSS _18890_/D AND3BX1
X_11343_ _11379_/A _11343_/B VDD VSS _11345_/C AND2X1
XFILLER_125_358 VDD VSS FILLER4
XFILLER_125_369 VSS VDD FILLER2
X_14062_ _18924_/Q _14171_/B VDD VSS _14078_/A NOR2BX1
XFILLER_165_52 VSS VDD FILLER2
X_11274_ _18581_/Q _11274_/B VDD VSS _11275_/C NOR2BX1
XFILLER_106_572 VDD VSS FILLER4
XFILLER_140_328 VSS VDD FILLER2
X_13013_ _13091_/A _14320_/B _14320_/C VDD VSS _13270_/C NOR3X1
XTAP_TAPCELL_ROW_150_1363 VDD VSS WELLTAP
XFILLER_165_85 VSS VDD FILLER2
X_10225_ _10229_/B VDD VSS _10226_/B INVX1
XFILLER_165_96 VSS VDD FILLER2
X_18870_ _18924_/CK _18870_/D _18870_/Q VDD VSS DFFQX1
XFILLER_121_542 VSS VDD FILLER2
X_17821_ _17823_/A _17823_/B _17821_/C VDD VSS _19928_/D AOI21X1
X_10156_ _10105_/Y _10166_/D _10156_/C VDD VSS _10222_/B AOI2B1X1
XFILLER_94_404 VDD VSS FILLER4
XFILLER_48_821 VDD VSS FILLER4
X_17752_ _17754_/C _17752_/B _17752_/C VDD VSS _19913_/D AOI21X1
XFILLER_12_8 VSS VDD FILLER2
X_14964_ _14966_/A _14966_/B VDD VSS _14965_/B _14966_/C NAND3X1
X_10087_ _17812_/A _10087_/B VDD VSS _18535_/D NOR2X1
XFILLER_59_191 VDD VSS FILLER1
XFILLER_47_342 VSS VDD FILLER2
X_16703_ _16703_/A _16704_/B VDD VSS _19557_/D NOR2X1
X_13915_ _19005_/Q wire153/Y _13958_/B VDD VSS _13998_/D XNOR3X1
X_17683_ _19898_/Q _19866_/Q _17683_/C VDD VSS _19898_/D AOI21X1
X_14895_ _19308_/Q VDD VSS _14896_/A INVX1
XFILLER_74_161 VDD VSS DECAPHV8
XFILLER_47_375 VSS VDD FILLER2
XFILLER_63_835 VSS VDD FILLER2
X_19422_ _19465_/CK _19422_/D _19422_/Q VDD VSS DFFQX1
X_16634_ _16649_/B _16634_/B VDD VSS _16830_/B XNOR2X1
XFILLER_62_323 VSS VDD FILLER2
X_13846_ _13912_/A _13846_/B VDD VSS _14299_/B XNOR2X1
XFILLER_90_676 VDD VSS FILLER1
X_19353_ _19385_/CK _19353_/D _19353_/Q VDD VSS DFFQX1
XFILLER_22_209 VDD VSS FILLER4
X_16565_ _16735_/A _16565_/B VDD VSS _19540_/D NOR2X1
X_13777_ _13777_/A _14298_/B _14298_/C VDD VSS _13889_/C NOR3X1
XFILLER_90_687 VSS VDD FILLER2
XFILLER_15_250 VSS VDD FILLER2
X_10989_ _10989_/A _11026_/B VDD VSS _10990_/B XNOR2X1
XFILLER_50_529 VDD VSS FILLER4
XFILLER_15_261 VSS VDD FILLER2
X_18304_ _18309_/CK _18496_/D _18304_/Q _20075_/RB VDD VSS DFFRQX1
X_15516_ _19492_/Q _15885_/B VDD VSS _15517_/B XOR2X1
XFILLER_43_592 VDD VSS FILLER4
XFILLER_31_732 VSS VDD FILLER2
X_19284_ _19306_/CK _19284_/D _19284_/Q VDD VSS DFFQX1
X_12728_ _12729_/A _12729_/B _12729_/D _12729_/C VDD VSS _12821_/B OAOI211X1
XTAP_TAPCELL_ROW_100_912 VDD VSS WELLTAP
XFILLER_31_743 VDD VSS FILLER1
XFILLER_148_406 VSS VDD FILLER2
X_16496_ _19570_/Q _19922_/Q VDD VSS _16525_/A XNOR2X1
XFILLER_30_231 VDD VSS FILLER1
XTAP_TAPCELL_ROW_60_557 VDD VSS WELLTAP
XFILLER_88_4 VSS VDD FILLER2
X_18235_ _18235_/CK _18235_/E _18235_/ECK VDD VSS CGX3
XFILLER_90_70 VSS VDD FILLER2
X_15447_ _19434_/Q _15819_/B VDD VSS _15449_/C XOR2X1
Xclkbuf_leaf_1__002_ clkload16/A VDD VSS _18785_/CK BUFX12
X_12659_ _12659_/A _14505_/B VDD VSS _12683_/A OR2X2
XFILLER_129_631 VSS VDD FILLER2
XFILLER_90_92 VSS VDD FILLER2
XFILLER_129_664 VSS VDD FILLER2
X_18166_ _18167_/A _18167_/B _18167_/C VDD VSS _18166_/Y NOR3X1
X_15378_ _19348_/Q _15722_/B VDD VSS _15379_/B XOR2X1
XFILLER_128_163 VDD VSS FILLER4
X_17117_ _17118_/C _17117_/B _17117_/C VDD VSS _19777_/D AOI21X1
X_14329_ _14316_/Y _14329_/B _14329_/C VDD VSS _19058_/D AND3BX1
XFILLER_116_336 VSS VDD FILLER2
X_18097_ _19286_/Q _18100_/B VDD VSS _18098_/B XOR2X1
XFILLER_7_493 VSS VDD FILLER2
XFILLER_144_667 VDD VSS FILLER1
XFILLER_104_509 VSS VDD FILLER2
X_17048_ _19762_/Q _17049_/B _17064_/A _17064_/B VDD VSS _17048_/Y AOI211X1
Xmax_cap157 _13215_/A VDD VSS _13271_/A BUFX4
XFILLER_89_209 VDD VSS FILLER4
X_09870_ _09867_/Y _09869_/Y _11229_/A VDD VSS _10017_/B MUX2X1
XFILLER_98_776 VSS VDD FILLER2
XFILLER_58_607 VSS VDD FILLER2
X_18999_ _18999_/CK _18999_/D _18999_/Q VDD VSS DFFQX1
XFILLER_57_117 VDD VSS FILLER1
XTAP_TAPCELL_ROW_68_624 VDD VSS WELLTAP
XFILLER_66_695 VSS VDD FILLER2
XFILLER_93_481 VSS VDD FILLER2
XFILLER_65_172 VSS VDD FILLER2
XFILLER_81_654 VSS VDD FILLER2
XFILLER_80_142 VSS VDD FILLER2
XFILLER_80_153 VDD VSS FILLER1
X_09304_ _18450_/RB _09322_/B VDD VSS _09304_/Y NOR2BX1
XFILLER_22_754 VSS VDD FILLER2
XFILLER_21_231 VSS VDD FILLER2
XFILLER_166_203 VDD VSS FILLER4
X_09235_ _18494_/D VDD VSS _18350_/D INVX1
XFILLER_166_214 VDD VSS FILLER4
Xclkbuf_leaf_20__001_ clkload33/A VDD VSS _18961_/CK BUFX12
XTAP_TAPCELL_ROW_31_292 VDD VSS WELLTAP
XFILLER_79_27 VSS VDD FILLER2
Xclkbuf_leaf_35__001_ clkbuf_leaf_4__001_/A VDD VSS _19166_/CK BUFX12
XFILLER_162_453 VDD VSS FILLER1
XFILLER_134_155 VSS VDD FILLER2
XFILLER_150_615 VSS VDD FILLER2
XFILLER_134_166 VDD VSS FILLER4
XFILLER_89_710 VSS VDD FILLER2
XFILLER_122_328 VSS VDD FILLER2
XFILLER_131_840 VSS VDD FILLER2
XFILLER_135_44 VDD VSS FILLER4
XFILLER_135_55 VSS VDD FILLER2
XFILLER_1_658 VSS VDD FILLER2
XFILLER_103_553 VDD VSS FILLER4
X_10010_ _18601_/Q _10010_/B VDD VSS _10022_/A AND2X1
XFILLER_88_242 VDD VSS DECAPHV8
XFILLER_135_77 VDD VSS FILLER1
XFILLER_130_361 VSS VDD FILLER2
X_20188_ _20188_/A VDD VSS _20188_/Y BUFX3
X_09999_ _18577_/Q _18578_/Q VDD VSS _10013_/B _09999_/C NAND3X1
XFILLER_88_275 VSS VDD FILLER2
XFILLER_103_597 VSS VDD FILLER2
XFILLER_95_59 VDD VSS FILLER1
XFILLER_130_394 VSS VDD FILLER2
XFILLER_28_53 VDD VSS FILLER1
X_11961_ _19120_/Q _11961_/B _11961_/C VDD VSS _14368_/B XNOR3X1
XFILLER_57_673 VDD VSS FILLER4
XFILLER_28_86 VDD VSS FILLER1
XFILLER_29_375 VSS VDD FILLER2
XFILLER_45_835 VSS VDD FILLER2
X_13700_ _13781_/A _13781_/B VDD VSS _14328_/B XNOR2X1
X_10912_ _10840_/Y _10911_/Y _10947_/A VDD VSS _10912_/Y MUXI2X1
XFILLER_45_846 VDD VSS FILLER4
XFILLER_44_323 VSS VDD FILLER2
X_14680_ _14681_/A _15892_/B VDD VSS _14739_/D OR2X2
XFILLER_17_548 VDD VSS FILLER1
X_11892_ _12035_/A _12035_/B _12035_/C VDD VSS _11912_/B OAI21X1
XFILLER_71_131 VDD VSS FILLER1
X_13631_ _19140_/Q _14422_/B VDD VSS _13721_/E _14422_/C AND3X2
X_10843_ _10843_/A VDD VSS _11118_/A BUFX3
XFILLER_13_732 VSS VDD FILLER2
XFILLER_13_743 VDD VSS FILLER1
X_16350_ _19692_/Q _16853_/B VDD VSS _16352_/C XNOR2X1
X_13562_ _19140_/Q _13562_/B _13630_/C VDD VSS _13721_/B XNOR3X1
X_10774_ _10774_/A _10774_/B VDD VSS _10774_/Y NOR2X1
XFILLER_158_726 VSS VDD FILLER2
XFILLER_157_203 VDD VSS FILLER4
XFILLER_13_776 VSS VDD FILLER2
X_15301_ _19347_/Q VDD VSS _15341_/A INVX1
X_12513_ _14278_/A _12513_/B _14310_/B VDD VSS _12514_/B MIN3X1
X_16281_ _16264_/A _16281_/B VDD VSS _16292_/B NAND2BX1
XFILLER_157_225 VDD VSS FILLER4
X_13493_ _18885_/Q VDD VSS _13495_/A INVX1
XFILLER_8_213 VDD VSS FILLER4
XFILLER_9_747 VSS VDD FILLER2
XFILLER_40_584 VSS VDD FILLER2
XFILLER_157_236 VSS VDD FILLER2
XFILLER_100_80 VDD VSS FILLER4
XFILLER_8_235 VDD VSS FILLER4
X_18020_ _18531_/Q _18020_/B VDD VSS _18021_/C NOR2X1
XFILLER_9_769 VSS VDD FILLER2
XFILLER_157_258 VSS VDD FILLER2
X_15232_ _15875_/B _15232_/B _15232_/C VDD VSS _15307_/A NOR3X1
X_12444_ _12519_/B _12519_/C _12515_/C VDD VSS _12510_/B OAI21X1
XFILLER_60_51 VDD VSS FILLER1
XFILLER_125_100 VDD VSS FILLER1
X_15163_ _15178_/A _15178_/B VDD VSS _15748_/B XNOR2X1
XFILLER_138_494 VSS VDD FILLER2
X_12375_ _19155_/Q VDD VSS _12467_/A INVX1
XFILLER_125_133 VSS VDD FILLER2
XFILLER_114_807 VDD VSS FILLER1
X_14114_ _14118_/A _14114_/B VDD VSS _18874_/D NOR2X1
X_11326_ _11333_/C _11333_/B VDD VSS _11327_/B NOR2BX1
X_15094_ _19481_/Q _15873_/B VDD VSS _15112_/B XNOR2X1
X_19971_ _19985_/CK _19971_/D _19971_/Q VDD VSS DFFQX1
XFILLER_99_529 VDD VSS FILLER4
XFILLER_5_57 VSS VDD FILLER2
XFILLER_153_486 VSS VDD FILLER2
X_18922_ _18924_/CK _18922_/D _18922_/Q VDD VSS DFFQX1
X_14045_ _14045_/A _14045_/B _14235_/B _18979_/Q _14045_/E VDD VSS _14068_/C AOI221X1
XFILLER_140_125 VDD VSS FILLER1
X_11257_ _11050_/Y _11341_/B _11289_/A VDD VSS _11264_/C MUXI2X1
X_10208_ _10217_/C _10217_/B VDD VSS _10209_/B NAND2BX1
X_18853_ _18915_/CK _18853_/D _18853_/Q VDD VSS DFFQX1
X_11188_ _11217_/A _11188_/B VDD VSS _11189_/B XNOR2X1
X_17804_ _19925_/Q _19893_/Q VDD VSS _17805_/B XOR2X1
X_10139_ _18589_/Q _10163_/C VDD VSS _10153_/B XNOR2X1
X_18784_ _18788_/CK _18784_/D _18784_/Q VDD VSS DFFQX1
X_15996_ _19551_/Q _19903_/Q VDD VSS _15997_/B XOR2X1
XFILLER_94_256 VSS VDD FILLER2
X_17735_ _17738_/A _17735_/B _17735_/C VDD VSS _19909_/D AOI21X1
X_14947_ _19310_/Q _15681_/B VDD VSS _14948_/B XNOR2X1
XFILLER_63_610 VDD VSS FILLER4
XFILLER_36_824 VDD VSS FILLER1
XFILLER_48_695 VSS VDD FILLER2
XFILLER_36_835 VSS VDD FILLER2
X_17666_ _19894_/Q _19862_/Q VDD VSS _17667_/C NAND2X1
XFILLER_63_643 VDD VSS DECAPHV8
X_14878_ _15009_/C _14921_/C VDD VSS _15898_/B OR2X2
XFILLER_63_654 VSS VDD FILLER2
XFILLER_90_451 VDD VSS FILLER4
XFILLER_62_142 VDD VSS DECAPHV8
X_19405_ _19406_/CK _19405_/D _19405_/Q VDD VSS DFFQX1
X_16617_ _17010_/A _16617_/B _16643_/B VDD VSS _19542_/D NOR3X1
X_13829_ _19002_/Q _14264_/B VDD VSS _13891_/A NAND2X1
XFILLER_90_473 VSS VDD FILLER2
X_17597_ _17598_/A _17600_/C _17597_/C VDD VSS _17598_/C OAI21X1
XTAP_TAPCELL_ROW_73_671 VDD VSS WELLTAP
XFILLER_90_495 VDD VSS FILLER1
XFILLER_50_337 VDD VSS FILLER4
XFILLER_16_581 VDD VSS FILLER1
XFILLER_149_704 VDD VSS FILLER4
X_19336_ _19349_/CK _19336_/D _19336_/Q VDD VSS DFFQX1
X_16548_ _16548_/A _16548_/B _16548_/C VDD VSS _16572_/B AOI21X1
XFILLER_31_551 VDD VSS FILLER1
X_19267_ _19269_/CK _19267_/D _19267_/Q VDD VSS DFFQX1
X_16479_ _19601_/Q _16501_/A VDD VSS _16480_/B XOR2X1
XFILLER_164_707 VSS VDD FILLER2
X_18218_ _18220_/CK _18218_/E _18218_/ECK VDD VSS CGX3
XFILLER_129_461 VDD VSS FILLER4
X_19198_ _19200_/CK _19198_/D _19198_/Q VDD VSS DFFQX1
XFILLER_163_206 VSS VDD FILLER2
XFILLER_163_228 VSS VDD FILLER2
XFILLER_129_483 VDD VSS FILLER4
X_18149_ _19295_/Q _18149_/B VDD VSS _18150_/C NAND2X1
XFILLER_117_667 VSS VDD FILLER2
XFILLER_116_144 VDD VSS FILLER1
XTAP_TAPCELL_ROW_116_1055 VDD VSS WELLTAP
XFILLER_144_464 VDD VSS FILLER1
XFILLER_104_317 VDD VSS DECAPHV8
XFILLER_132_626 VSS VDD FILLER2
XFILLER_104_328 VDD VSS DECAPHV8
XFILLER_144_497 VDD VSS DECAPHV8
X_20111_ _20111_/A VDD VSS _20111_/Y BUFX3
X_09922_ _09942_/A _09922_/B VDD VSS _09922_/Y XNOR2X1
XFILLER_113_840 VSS VDD FILLER2
X_20042_ _20045_/CK _20042_/D _20042_/Q _20045_/RB VDD VSS DFFRQX1
X_09853_ _10927_/C VDD VSS _10966_/A BUFX3
Xclkbuf_1_1__f__09176_ clkbuf_0__09176_/Y VDD VSS _18240_/CK BUFX12
XFILLER_86_713 VSS VDD FILLER2
X_09784_ _18469_/Q _09784_/B _09784_/C _18437_/Q _09784_/E VDD VSS _09791_/B AOI221X1
XFILLER_105_58 VSS VDD FILLER2
XFILLER_85_267 VSS VDD FILLER2
XFILLER_65_29 VSS VDD FILLER2
XFILLER_85_278 VDD VSS FILLER1
XFILLER_38_150 VDD VSS FILLER4
XFILLER_73_429 VSS VDD FILLER2
XFILLER_66_470 VSS VDD FILLER2
XFILLER_27_835 VSS VDD FILLER2
XFILLER_54_621 VDD VSS FILLER1
XFILLER_27_846 VDD VSS FILLER1
XFILLER_26_323 VSS VDD FILLER2
XFILLER_121_35 VSS VDD FILLER2
XTAP_TAPCELL_ROW_36_340 VDD VSS WELLTAP
XFILLER_41_304 VDD VSS FILLER4
XFILLER_121_68 VSS VDD FILLER2
XFILLER_41_315 VSS VDD FILLER2
XFILLER_81_28 VSS VDD FILLER2
XFILLER_41_337 VSS VDD FILLER2
XFILLER_14_22 VSS VDD FILLER2
XFILLER_139_203 VDD VSS FILLER1
XFILLER_22_551 VSS VDD FILLER2
XFILLER_14_44 VSS VDD FILLER2
XFILLER_10_724 VDD VSS FILLER4
XFILLER_14_66 VSS VDD FILLER2
XFILLER_14_77 VSS VDD FILLER2
XFILLER_14_88 VDD VSS FILLER1
X_09218_ _18520_/Q VDD VSS _18403_/D INVX1
XFILLER_10_757 VSS VDD FILLER2
XFILLER_127_409 VDD VSS FILLER1
XFILLER_155_718 VDD VSS FILLER4
X_10490_ _10530_/A _10530_/B _10530_/C _11095_/C VDD VSS _10491_/D AOI31X1
XFILLER_5_216 VSS VDD FILLER2
XFILLER_107_111 VSS VDD FILLER2
XFILLER_30_32 VSS VDD FILLER2
XFILLER_163_740 VDD VSS FILLER4
XFILLER_107_133 VSS VDD FILLER2
XFILLER_5_249 VSS VDD FILLER2
X_12160_ _12160_/A _14465_/B _12160_/C _12160_/D VDD VSS _12329_/A OAOI211X2
XTAP_TAPCELL_ROW_1_25 VDD VSS WELLTAP
XFILLER_162_250 VSS VDD FILLER2
XFILLER_122_103 VDD VSS FILLER4
XFILLER_123_637 VDD VSS FILLER4
X_11111_ _11132_/A _11111_/B VDD VSS _11113_/B XNOR2X1
XFILLER_107_199 VSS VDD FILLER2
XFILLER_146_87 VSS VDD FILLER2
X_12091_ _12116_/A _12116_/B _12091_/C VDD VSS _14434_/C AOI21X1
XFILLER_146_98 VSS VDD FILLER2
XFILLER_104_851 VDD VSS FILLER4
X_11042_ _18704_/Q _18758_/Q VDD VSS _11043_/C AND2X1
XFILLER_49_415 VDD VSS FILLER4
XFILLER_76_223 VSS VDD FILLER2
X_15850_ _15867_/A _15850_/B VDD VSS _19462_/D NOR2X1
XFILLER_162_53 VDD VSS FILLER1
XFILLER_49_459 VDD VSS FILLER4
XFILLER_39_96 VSS VDD FILLER2
X_14801_ _14801_/A _14810_/C VDD VSS _15707_/B XNOR2X1
XFILLER_64_407 VDD VSS FILLER4
XFILLER_92_727 VSS VDD FILLER2
XFILLER_18_813 VSS VDD FILLER2
X_15781_ _15793_/A _15781_/B VDD VSS _19401_/D AND2X1
XFILLER_91_215 VSS VDD FILLER2
X_12993_ _12994_/B _12994_/C _18966_/Q VDD VSS _13171_/B AOI21X1
XTAP_TAPCELL_ROW_87_796 VDD VSS WELLTAP
XFILLER_17_312 VSS VDD FILLER2
X_17520_ _17522_/A _17520_/B _17520_/C VDD VSS _19863_/D AOI21X1
XFILLER_57_492 VSS VDD FILLER2
XFILLER_45_632 VDD VSS DECAPHV8
X_14732_ _14737_/A _14737_/B VDD VSS _15829_/B XNOR2X1
XFILLER_17_334 VSS VDD FILLER2
X_11944_ _11944_/A _11944_/B _14335_/B VDD VSS _11945_/B MIN3X1
XFILLER_45_654 VSS VDD FILLER2
XFILLER_55_62 VSS VDD FILLER2
XFILLER_44_142 VSS VDD FILLER2
XFILLER_17_356 VSS VDD FILLER2
XFILLER_60_602 VSS VDD FILLER2
X_17451_ _19849_/Q _19817_/Q VDD VSS _17453_/B XOR2X1
X_14663_ _19387_/Q _15765_/B VDD VSS _14664_/B XNOR2X1
X_11875_ _11979_/A _14490_/B _11979_/C VDD VSS _14492_/B OAI21X1
X_16402_ _16402_/A _16402_/B VDD VSS _16403_/B _16402_/C NAND3X1
XFILLER_60_646 VSS VDD FILLER2
X_13614_ _19111_/Q _13614_/B _13614_/C VDD VSS _13623_/B XOR3X1
X_10826_ _10861_/C _10827_/B VDD VSS _10826_/Y NOR2X1
X_17382_ _19834_/Q _19802_/Q _17382_/C VDD VSS _19834_/D AOI21X1
X_14594_ _14594_/A _15856_/B VDD VSS _14595_/B NAND2X1
XTAP_TAPCELL_ROW_70_641 VDD VSS WELLTAP
X_19121_ _19134_/CK _19121_/D _19121_/Q VDD VSS DFFQX1
XFILLER_158_523 VDD VSS FILLER4
X_16333_ _19691_/Q _16852_/B VDD VSS _16352_/A NOR2X1
XFILLER_158_534 VSS VDD FILLER2
X_13545_ _13546_/A _13546_/B _13546_/D _13546_/C VDD VSS _13640_/B OAOI211X1
X_10757_ _18669_/Q _18777_/Q _10757_/C VDD VSS _10801_/A AO21X2
XFILLER_40_370 VSS VDD FILLER2
XTAP_TAPCELL_ROW_42_387 VDD VSS WELLTAP
XFILLER_40_381 VDD VSS FILLER1
XFILLER_9_555 VSS VDD FILLER2
XFILLER_118_409 VSS VDD FILLER2
X_19052_ _19119_/CK _19052_/D _19052_/Q VDD VSS DFFQX1
XFILLER_146_729 VDD VSS FILLER4
X_16264_ _16264_/A _16281_/B VDD VSS _16815_/B XNOR2X1
X_13476_ _13509_/A _13509_/B VDD VSS _14260_/B _13509_/C NAND3X1
X_10688_ _18641_/Q _18803_/Q VDD VSS _10689_/B XOR2X1
X_18003_ _18548_/Q _18055_/B VDD VSS _18057_/C NOR2BX1
X_15215_ _15297_/A _18107_/B VDD VSS _19288_/D AND2X1
X_12427_ _18960_/Q _12440_/B _14211_/B VDD VSS _14180_/B XNOR3X1
XFILLER_126_431 VDD VSS FILLER1
X_16195_ _19718_/Q _16882_/B VDD VSS _16199_/B XNOR2X1
XFILLER_153_250 VSS VDD FILLER2
X_15146_ _19535_/Q _19536_/Q VDD VSS _15186_/B _15146_/C NAND3X1
X_12358_ _19071_/Q VDD VSS _12421_/A INVX1
XFILLER_58_5 VSS VDD FILLER2
XFILLER_154_773 VDD VSS FILLER1
XFILLER_99_315 VSS VDD FILLER2
XFILLER_113_103 VSS VDD FILLER2
X_11309_ _11379_/A _11319_/B VDD VSS _11310_/B NOR2X1
X_15077_ _19313_/Q _15684_/B VDD VSS _15078_/B XNOR2X1
X_19954_ _19954_/CK _19954_/D _19954_/Q VDD VSS DFFQX1
XFILLER_141_445 VSS VDD FILLER2
X_12289_ _19042_/Q _14279_/A _14278_/B VDD VSS _12361_/B MIN3X1
XFILLER_113_147 VDD VSS FILLER4
XFILLER_4_293 VSS VDD FILLER2
X_18905_ _18905_/CK _18905_/D _18905_/Q VDD VSS DFFQX1
X_14028_ _14038_/A _14169_/B _14054_/C VDD VSS _14170_/B OA21X2
XFILLER_113_169 VSS VDD FILLER2
X_19885_ clkload8/A _19885_/D _19885_/Q VDD VSS DFFQX1
XFILLER_122_681 VDD VSS DECAPHV8
XFILLER_68_746 VDD VSS FILLER1
X_18836_ _19954_/CK _18836_/D _18836_/Q VDD VSS DFFQX1
XFILLER_96_91 VDD VSS FILLER4
XFILLER_95_565 VSS VDD FILLER2
XFILLER_67_278 VDD VSS FILLER1
X_18767_ _18767_/CK _18767_/D _18767_/Q VDD VSS DFFQX1
XFILLER_83_738 VDD VSS FILLER4
X_15979_ _15979_/A _15979_/B VDD VSS _16834_/B XNOR2X1
X_17718_ _17719_/B _17718_/B VDD VSS _17720_/B NOR2BX1
XFILLER_48_492 VSS VDD FILLER2
X_18698_ _19943_/CK _18698_/D _18698_/Q VDD VSS DFFQX1
XFILLER_35_131 VSS VDD FILLER2
XFILLER_51_602 VSS VDD FILLER2
XFILLER_36_676 VSS VDD FILLER2
X_17649_ _19891_/Q _19859_/Q VDD VSS _17651_/B XOR2X1
XFILLER_24_838 VSS VDD FILLER2
XFILLER_51_624 VDD VSS DECAPHV8
XFILLER_50_101 VSS VDD FILLER2
XTAP_TAPCELL_ROW_33_310 VDD VSS WELLTAP
XFILLER_35_197 VSS VDD FILLER2
XFILLER_23_348 VSS VDD FILLER2
X_19319_ _19333_/CK _19319_/D _19319_/Q VDD VSS DFFQX1
XFILLER_149_556 VSS VDD FILLER2
XFILLER_31_370 VSS VDD FILLER2
XFILLER_149_578 VDD VSS FILLER1
Xclkbuf_leaf_0_clk_regs clkbuf_leaf_9_clk_regs/A VDD VSS clkload8/A BUFX12
XFILLER_145_740 VDD VSS FILLER4
XFILLER_164_559 VDD VSS FILLER1
XFILLER_129_291 VDD VSS FILLER4
XFILLER_117_464 VDD VSS FILLER1
XFILLER_105_615 VDD VSS FILLER4
XFILLER_2_208 VSS VDD FILLER2
XFILLER_104_103 VSS VDD FILLER2
XFILLER_160_765 VDD VSS FILLER4
XFILLER_104_158 VSS VDD FILLER2
XFILLER_120_607 VDD VSS DECAPHV8
XFILLER_132_467 VSS VDD FILLER2
XFILLER_160_776 VSS VDD FILLER2
X_09905_ _18560_/Q _09941_/C VDD VSS _09929_/B XNOR2X1
XFILLER_101_810 VSS VDD FILLER2
XFILLER_113_681 VSS VDD FILLER2
X_20025_ _20033_/CK _20025_/D _20025_/Q _20030_/RB VDD VSS DFFRQX1
XFILLER_86_532 VSS VDD FILLER2
XFILLER_58_223 VSS VDD FILLER2
XFILLER_101_854 VSS VDD FILLER2
X_09836_ _18558_/Q _18559_/Q VDD VSS _09941_/C _10247_/A AND3X2
XFILLER_59_768 VDD VSS DECAPHV8
XFILLER_100_353 VDD VSS FILLER1
XFILLER_73_204 VDD VSS DECAPHV8
X_09767_ _20113_/A _09767_/B _09811_/B _18436_/Q VDD VSS _09768_/D AOI22X1
XFILLER_58_289 VSS VDD FILLER2
X_09698_ _09698_/A _09698_/B _09729_/D VDD VSS _09699_/E AOI21X1
XFILLER_27_654 VDD VSS DECAPHV8
XTAP_TAPCELL_ROW_84_766 VDD VSS WELLTAP
XFILLER_26_142 VSS VDD FILLER2
XFILLER_92_49 VSS VDD FILLER2
XFILLER_82_782 VDD VSS DECAPHV8
XFILLER_26_164 VSS VDD FILLER2
XFILLER_82_793 VDD VSS FILLER4
XFILLER_54_484 VDD VSS DECAPHV8
X_11660_ _18799_/Q _11669_/B VDD VSS _18826_/D AND2X1
XFILLER_41_156 VSS VDD FILLER2
X_10611_ _10642_/D _10642_/C VDD VSS _10613_/C NAND2BX1
X_11591_ _18736_/Q _11600_/B VDD VSS _18763_/D AND2X1
XFILLER_41_189 VSS VDD FILLER2
XFILLER_50_690 VDD VSS FILLER4
XFILLER_10_532 VDD VSS FILLER4
X_13330_ _19193_/Q _13466_/A _13466_/B VDD VSS _13331_/D XNOR3X1
X_10542_ _18558_/Q _10542_/B VDD VSS _10544_/D XNOR2X1
XFILLER_6_514 VDD VSS DECAPHV16
X_13261_ _20013_/Q _19277_/Q VDD VSS _13345_/D XOR2X1
XTAP_TAPCELL_ROW_136_1239 VDD VSS WELLTAP
XFILLER_41_75 VDD VSS FILLER1
X_10473_ _10471_/Y _10474_/C VDD VSS _18556_/D NOR2BX1
XFILLER_136_740 VSS VDD FILLER2
XFILLER_6_547 VDD VSS DECAPHV8
XFILLER_157_53 VDD VSS FILLER4
X_15000_ wire162/Y _15000_/B _15000_/C _15000_/D VDD VSS _15836_/B OAI211X1
X_12212_ _12214_/A wire161/Y _12214_/C VDD VSS _12213_/B AOI21X1
XFILLER_6_569 VSS VDD FILLER2
X_13192_ _13192_/A _13192_/B _13192_/C _13192_/D VDD VSS _13395_/B AOAI211X1
XFILLER_108_497 VSS VDD FILLER2
XFILLER_163_592 VDD VSS FILLER4
XFILLER_151_743 VDD VSS FILLER1
X_12143_ _14373_/B _14373_/C _19096_/Q VDD VSS _12210_/B AOI21X1
XFILLER_9_0 VDD VSS FILLER1
XFILLER_96_307 VSS VDD FILLER2
XFILLER_111_618 VDD VSS DECAPHV8
XFILLER_151_787 VSS VDD FILLER2
XFILLER_1_241 VDD VSS FILLER4
X_16951_ _16953_/C _16951_/B _16951_/C VDD VSS _19745_/D AOI21X1
X_12074_ _19066_/Q VDD VSS _12080_/A INVX1
XFILLER_2_775 VDD VSS FILLER4
X_15902_ _15906_/A _15902_/B VDD VSS _19508_/D NOR2X1
X_11025_ _11021_/B _18571_/Q VDD VSS _11055_/A NAND2BX1
XFILLER_2_25 VSS VDD FILLER2
X_19670_ _19702_/CK _19670_/D _19670_/Q VDD VSS DFFQX1
X_16882_ _16891_/A _16882_/B VDD VSS _19718_/D NOR2X1
XTAP_TAPCELL_ROW_147_1335 VDD VSS WELLTAP
X_18621_ _18622_/CK _18621_/D _18621_/Q VDD VSS DFFQX1
X_15833_ _17010_/A _15833_/B _15833_/C VDD VSS _19448_/D NOR3X1
XFILLER_77_598 VDD VSS FILLER4
XFILLER_49_289 VSS VDD FILLER2
XFILLER_18_621 VSS VDD FILLER2
X_18552_ _18578_/CK _18552_/D _18552_/Q VDD VSS DFFQX1
XTAP_TAPCELL_ROW_47_435 VDD VSS WELLTAP
XFILLER_66_94 VSS VDD FILLER2
X_15764_ _15770_/A _15764_/B VDD VSS _19386_/D AND2X1
XFILLER_64_259 VSS VDD FILLER2
X_12976_ _19050_/Q _13091_/B _13091_/C VDD VSS _13270_/B XNOR3X1
XFILLER_92_579 VDD VSS FILLER1
X_17503_ _19859_/Q _19827_/Q _17503_/C VDD VSS _17507_/C MIN3X1
XFILLER_73_771 VDD VSS FILLER4
XFILLER_45_462 VSS VDD FILLER2
X_14715_ _14785_/A _14746_/B VDD VSS _14781_/B XNOR2X1
XFILLER_33_613 VDD VSS FILLER4
XFILLER_18_687 VDD VSS FILLER1
X_18483_ _18487_/CK _18499_/D _20128_/A _18486_/RB VDD VSS DFFRQX1
X_11927_ _11933_/A _14525_/B _11980_/C VDD VSS _14526_/B AO21X2
X_15695_ _15710_/A _15695_/B VDD VSS _19323_/D NOR2X1
XFILLER_72_270 VSS VDD FILLER2
XFILLER_60_421 VDD VSS FILLER4
X_17434_ _17439_/C _17439_/B VDD VSS _17436_/B NAND2BX1
XFILLER_82_60 VSS VDD FILLER2
X_14646_ _19524_/Q _14646_/B VDD VSS _14655_/B XNOR2X1
XFILLER_33_668 VSS VDD FILLER2
X_11858_ _19063_/Q _11944_/B _11861_/C VDD VSS _14303_/B XNOR3X1
X_17365_ _19830_/Q _19798_/Q VDD VSS _17366_/C NAND2X1
X_10809_ _10658_/B _10808_/Y _10843_/A VDD VSS _10809_/Y MUXI2X1
XFILLER_13_370 VSS VDD FILLER2
X_14577_ _19520_/Q _19519_/Q VDD VSS _14578_/C NAND2X1
X_11789_ _19116_/Q _14394_/B VDD VSS _11790_/B OR2X2
XTAP_TAPCELL_ROW_158_1431 VDD VSS WELLTAP
XFILLER_159_854 VSS VDD FILLER2
X_19104_ _19157_/CK _19104_/D _19104_/Q VDD VSS DFFQX1
Xclkbuf_1_0__f__09179_ clkbuf_0__09179_/Y VDD VSS _20019_/CK BUFX12
X_16316_ _19595_/Q _16745_/B VDD VSS _16337_/B XOR2X1
X_13528_ _13528_/A _14355_/A _13528_/C _13528_/D VDD VSS _13696_/A AOAI211X1
XFILLER_158_364 VSS VDD FILLER2
X_17296_ _19815_/Q _19783_/Q _17296_/C VDD VSS _17300_/C MIN3X1
X_19035_ _19037_/CK _19035_/D _19035_/Q VDD VSS DFFQX1
X_16247_ _16250_/B _16247_/B VDD VSS _16248_/B XOR2X1
X_13459_ _13459_/A _13459_/B _13459_/C _13459_/D VDD VSS _13637_/A AOAI211X1
XFILLER_127_751 VSS VDD FILLER2
Xoutput104 _20179_/Y VDD VSS o_rst_ctrl_b[0] BUFX3
X_16178_ _19621_/Q VDD VSS _16179_/A INVX1
Xoutput115 _20184_/Y VDD VSS o_tst_ctrl[3] BUFX3
XFILLER_127_795 VSS VDD FILLER2
Xoutput126 _20210_/Y VDD VSS o_uwb_tx_cfg[13] BUFX3
Xoutput137 _20220_/Y VDD VSS o_uwb_tx_cfg[23] BUFX3
XFILLER_154_592 VDD VSS FILLER1
XFILLER_126_294 VDD VSS FILLER4
X_15129_ _15132_/B _15129_/B VDD VSS _18100_/B XNOR2X1
Xoutput148 _20203_/Y VDD VSS o_uwb_tx_cfg[6] BUFX3
XFILLER_99_134 VDD VSS FILLER1
XFILLER_102_607 VSS VDD FILLER2
XFILLER_141_253 VDD VSS DECAPHV16
XFILLER_142_787 VSS VDD FILLER2
XFILLER_87_318 VSS VDD FILLER2
XFILLER_114_489 VDD VSS FILLER1
XFILLER_142_798 VSS VDD FILLER2
X_19937_ _19939_/CK _19937_/D _19937_/Q VDD VSS DFFQX1
XFILLER_99_189 VSS VDD FILLER2
XFILLER_141_286 VSS VDD FILLER2
XFILLER_141_297 VSS VDD FILLER2
X_19868_ clkload2/A _19868_/D _19868_/Q VDD VSS DFFQX1
XFILLER_95_362 VDD VSS DECAPHV8
XFILLER_68_576 VSS VDD FILLER2
X_09621_ _18299_/Q _09812_/B _09784_/B _18459_/Q VDD VSS _09636_/A AOI22X1
XFILLER_83_513 VDD VSS FILLER1
XFILLER_68_587 VDD VSS FILLER1
X_18819_ _18823_/CK _18819_/D _18819_/Q VDD VSS DFFQX1
XFILLER_110_695 VSS VDD FILLER2
X_19799_ clkload5/A _19799_/D _19799_/Q VDD VSS DFFQX1
XFILLER_55_215 VSS VDD FILLER2
XFILLER_49_790 VDD VSS FILLER1
X_09552_ _18344_/Q VDD VSS _20212_/A INVX1
XFILLER_102_26 VSS VDD FILLER2
XTAP_TAPCELL_ROW_124_1132 VDD VSS WELLTAP
XFILLER_64_771 VDD VSS FILLER4
X_09483_ _18455_/D _09483_/B _09483_/C VDD VSS _18242_/D AOI21X1
XFILLER_36_473 VSS VDD FILLER2
XFILLER_24_613 VDD VSS FILLER1
XFILLER_64_793 VSS VDD FILLER2
XFILLER_23_123 VDD VSS FILLER4
XFILLER_12_819 VSS VDD FILLER2
XFILLER_23_156 VSS VDD FILLER2
XFILLER_11_318 VSS VDD FILLER2
XFILLER_23_189 VDD VSS FILLER4
XFILLER_149_342 VSS VDD FILLER2
XFILLER_137_504 VSS VDD FILLER2
XFILLER_20_852 VDD VSS FILLER1
XFILLER_165_813 VDD VSS FILLER4
XFILLER_149_375 VDD VSS FILLER4
XFILLER_137_526 VDD VSS FILLER1
XFILLER_165_835 VSS VDD FILLER2
XFILLER_127_8 VDD VSS FILLER1
XFILLER_118_773 VSS VDD FILLER2
XFILLER_124_209 VDD VSS FILLER4
XFILLER_152_518 VSS VDD FILLER2
XFILLER_164_389 VSS VDD FILLER2
XFILLER_133_743 VDD VSS FILLER1
XFILLER_160_562 VDD VSS DECAPHV32
XTAP_TAPCELL_ROW_89_814 VDD VSS WELLTAP
XFILLER_132_297 VDD VSS FILLER4
XFILLER_143_22 VSS VDD FILLER2
XFILLER_59_543 VDD VSS FILLER4
X_20008_ _20013_/CK _20008_/D _20008_/Q VDD VSS DFFQX1
XFILLER_47_727 VDD VSS FILLER4
X_09819_ _09819_/A _09819_/B _09819_/C VDD VSS _18295_/D OAI21X1
XFILLER_59_587 VSS VDD FILLER2
XFILLER_101_684 VDD VSS FILLER1
XFILLER_100_172 VSS VDD FILLER2
X_12830_ _19216_/Q VDD VSS _12945_/A INVX1
XFILLER_62_708 VSS VDD FILLER2
XFILLER_46_259 VSS VDD FILLER2
XTAP_TAPCELL_ROW_109_992 VDD VSS WELLTAP
XTAP_TAPCELL_ROW_44_405 VDD VSS WELLTAP
X_12761_ _19244_/Q VDD VSS _12967_/C INVX1
XFILLER_42_421 VSS VDD FILLER2
X_14500_ _14491_/Y _14500_/B _14500_/C VDD VSS _19209_/D AND3BX1
X_11712_ _19170_/Q _14455_/B VDD VSS _11761_/B NOR2X1
XTAP_TAPCELL_ROW_7_79 VDD VSS WELLTAP
XTAP_TAPCELL_ROW_142_1287 VDD VSS WELLTAP
XFILLER_70_752 VSS VDD FILLER2
X_15480_ _19491_/Q _15884_/B VDD VSS _15481_/B XOR2X1
X_12692_ _12710_/A _12896_/D VDD VSS _14251_/B XNOR2X1
XFILLER_70_763 VDD VSS FILLER1
XFILLER_42_454 VDD VSS FILLER4
XFILLER_14_167 VDD VSS FILLER4
XFILLER_42_476 VDD VSS DECAPHV8
XFILLER_146_0 VDD VSS FILLER1
X_14431_ _14456_/A _14431_/B VDD VSS _19148_/D NOR2X1
X_11643_ _18784_/Q _11647_/B VDD VSS _18811_/D AND2X1
XTAP_TAPCELL_ROW_52_482 VDD VSS WELLTAP
XFILLER_156_802 VSS VDD FILLER2
X_17150_ _19784_/Q VDD VSS _17300_/B INVX1
X_14362_ _14415_/A _14362_/B VDD VSS _19086_/D AND2X1
X_11574_ _18721_/Q _11578_/B VDD VSS _18748_/D AND2X1
XFILLER_156_835 VDD VSS FILLER4
X_16101_ _16776_/A VDD VSS _16512_/A BUFX3
XFILLER_10_373 VDD VSS FILLER1
X_13313_ _13406_/A _13406_/B _13406_/C VDD VSS _13370_/B AOI21X1
X_10525_ _10525_/A _10525_/B _10525_/C _10525_/D VDD VSS _10563_/A AOAI211X1
XFILLER_7_845 VSS VDD FILLER2
X_17081_ _19770_/Q _19738_/Q _17081_/C VDD VSS _17082_/C OAI21X1
X_14293_ _14294_/A _14293_/B _14293_/C VDD VSS _19026_/D NOR3X1
XFILLER_143_507 VDD VSS FILLER4
X_16032_ _16767_/B _19615_/Q VDD VSS _16033_/C NOR2BX1
X_13244_ _13244_/A _14541_/B _14541_/C VDD VSS _13444_/C NOR3X1
XFILLER_109_784 VSS VDD FILLER2
X_10456_ _18688_/Q _18742_/Q VDD VSS _10460_/D AND2X1
X_13175_ _18912_/Q _13286_/B _14157_/B VDD VSS _13184_/C XNOR3X1
XTAP_TAPCELL_ROW_153_1394 VDD VSS WELLTAP
X_10387_ _10625_/A _10511_/A VDD VSS _10427_/B _10701_/C NAND3X1
XFILLER_69_307 VSS VDD FILLER2
X_12126_ _18956_/Q _12131_/B _14207_/B VDD VSS _14176_/B XNOR3X1
X_17983_ _18871_/Q _17983_/B _17983_/C VDD VSS _17987_/C NOR3X1
XFILLER_97_638 VDD VSS FILLER4
XFILLER_96_115 VDD VSS FILLER4
XFILLER_97_649 VSS VDD FILLER2
XFILLER_96_126 VSS VDD FILLER2
X_19722_ _19722_/CK _19722_/D _19722_/Q VDD VSS DFFQX1
X_16934_ _16937_/A _16937_/B _17081_/C VDD VSS _16935_/C OAI21X1
X_12057_ _19235_/Q _12108_/C _12101_/C VDD VSS _12234_/B XNOR3X1
XFILLER_77_60 VSS VDD FILLER2
X_11008_ _11009_/A _11009_/B VDD VSS _11033_/C NOR2X1
X_19653_ _19696_/CK _19653_/D _19653_/Q VDD VSS DFFQX1
XFILLER_65_513 VSS VDD FILLER2
X_16865_ _16865_/A _16865_/B VDD VSS _19703_/D NOR2X1
X_18604_ _18612_/CK _18604_/D _18604_/Q VDD VSS DFFQX1
X_15816_ _15816_/A _15816_/B VDD VSS _19432_/D NOR2X1
X_19584_ _19584_/CK _19584_/D _19584_/Q VDD VSS DFFQX1
X_16796_ _16843_/A _16796_/B VDD VSS _19641_/D AND2X1
XFILLER_65_579 VSS VDD FILLER2
XTAP_TAPCELL_ROW_164_1490 VDD VSS WELLTAP
XFILLER_80_516 VDD VSS FILLER1
X_18535_ _18543_/CK _18535_/D _18535_/Q VDD VSS DFFQX1
XFILLER_52_218 VDD VSS FILLER4
X_15747_ _15770_/A _15747_/B VDD VSS _19370_/D AND2X1
X_12959_ _20010_/Q _19274_/Q VDD VSS _13150_/B NAND2X1
XFILLER_46_793 VSS VDD FILLER2
XFILLER_18_484 VDD VSS FILLER4
XFILLER_33_432 VDD VSS FILLER1
X_18466_ _18469_/CK _18519_/Q _18466_/Q _20075_/RB VDD VSS DFFRQX1
X_15678_ _15817_/A VDD VSS _15693_/A BUFX3
XFILLER_61_774 VDD VSS FILLER4
XFILLER_60_251 VSS VDD FILLER2
X_17417_ _19841_/Q _19809_/Q _17417_/C VDD VSS _17420_/B MIN3X1
XTAP_TAPCELL_ROW_15_151 VDD VSS WELLTAP
X_14629_ _14658_/A _14658_/B VDD VSS _14671_/C XOR2X1
X_18397_ _18407_/CK _18514_/Q _20138_/A _18422_/RB VDD VSS DFFRQX1
XFILLER_14_690 VDD VSS FILLER4
X_17348_ _19826_/Q _19794_/Q _17348_/C VDD VSS _17353_/C AO21X2
XFILLER_20_159 VSS VDD FILLER2
XFILLER_146_345 VSS VDD FILLER2
X_17279_ _17281_/A _17281_/B _17279_/C VDD VSS _19812_/D AOI21X1
XFILLER_162_805 VSS VDD FILLER2
XFILLER_61_0 VSS VDD FILLER2
X_19018_ _19044_/CK _19018_/D _19018_/Q VDD VSS DFFQX1
XFILLER_161_315 VDD VSS FILLER4
XFILLER_115_721 VDD VSS FILLER4
XFILLER_161_326 VSS VDD FILLER2
XFILLER_115_754 VDD VSS DECAPHV8
XFILLER_114_242 VSS VDD FILLER2
XFILLER_88_616 VSS VDD FILLER2
XFILLER_88_627 VDD VSS FILLER1
XFILLER_114_275 VDD VSS FILLER1
XFILLER_115_798 VSS VDD FILLER2
XFILLER_142_584 VSS VDD FILLER2
XFILLER_142_595 VSS VDD FILLER2
XFILLER_130_746 VSS VDD FILLER2
Xclkbuf_leaf_2__000_ clkbuf_leaf_6__000_/A VDD VSS _19536_/CK BUFX12
XTAP_TAPCELL_ROW_130_1180 VDD VSS WELLTAP
XFILLER_130_768 VSS VDD FILLER2
XFILLER_68_351 VDD VSS FILLER4
XFILLER_68_384 VSS VDD FILLER2
XFILLER_28_226 VDD VSS FILLER4
X_09604_ _18442_/Q VDD VSS _20154_/A INVX1
XFILLER_113_47 VSS VDD FILLER2
XFILLER_113_69 VDD VSS FILLER4
XTAP_TAPCELL_ROW_94_861 VDD VSS WELLTAP
XFILLER_73_18 VDD VSS FILLER4
XFILLER_56_579 VSS VDD FILLER2
X_09535_ _20030_/Q _18199_/A VDD VSS _20031_/D NOR2BX1
XFILLER_37_782 VSS VDD FILLER2
XFILLER_24_421 VSS VDD FILLER2
X_09466_ _18447_/D _09468_/B _09466_/C VDD VSS _18250_/D AOI21X1
XFILLER_52_752 VSS VDD FILLER2
XFILLER_24_443 VSS VDD FILLER2
XFILLER_12_627 VDD VSS FILLER4
X_09397_ _11273_/A VDD VSS _11378_/A BUFX3
XFILLER_51_295 VDD VSS FILLER4
XFILLER_8_609 VDD VSS FILLER1
XFILLER_22_11 VSS VDD FILLER2
XFILLER_137_301 VSS VDD FILLER2
XFILLER_22_44 VSS VDD FILLER2
XFILLER_22_55 VSS VDD FILLER2
XFILLER_137_345 VDD VSS DECAPHV8
XFILLER_22_66 VDD VSS FILLER4
XFILLER_165_654 VSS VDD FILLER2
XFILLER_138_44 VSS VDD FILLER2
XTAP_TAPCELL_ROW_21_198 VDD VSS WELLTAP
XFILLER_164_142 VSS VDD FILLER2
XFILLER_153_816 VSS VDD FILLER2
XFILLER_118_4 VSS VDD FILLER2
X_10310_ _10312_/B _10310_/B _10310_/C VDD VSS _18552_/D AOI21X1
XTAP_TAPCELL_ROW_133_1209 VDD VSS WELLTAP
XFILLER_152_304 VSS VDD FILLER2
XFILLER_22_99 VSS VDD FILLER2
X_11290_ _11152_/Y _11363_/B _11370_/A VDD VSS _11291_/A MUXI2X1
XFILLER_98_26 VSS VDD FILLER2
XFILLER_4_837 VSS VDD FILLER2
XFILLER_118_592 VSS VDD FILLER2
X_10241_ _18624_/Q _11436_/C VDD VSS _10314_/C NOR2X1
XFILLER_105_231 VSS VDD FILLER2
XFILLER_105_242 VSS VDD FILLER2
XFILLER_154_21 VSS VDD FILLER2
XFILLER_106_787 VSS VDD FILLER2
XFILLER_154_32 VSS VDD FILLER2
X_10172_ _10172_/A _10172_/B _10172_/C _10172_/D VDD VSS _10173_/C AOAI211X1
XFILLER_78_104 VDD VSS DECAPHV8
XFILLER_160_381 VDD VSS DECAPHV8
XFILLER_78_137 VSS VDD FILLER2
XFILLER_78_148 VSS VDD FILLER2
XFILLER_154_87 VSS VDD FILLER2
X_14980_ _15026_/C _15026_/B VDD VSS _14981_/B NOR2BX1
XFILLER_59_340 VSS VDD FILLER2
XFILLER_120_267 VSS VDD FILLER2
X_13931_ _13977_/A _13931_/B _13981_/D VDD VSS _13941_/C XNOR3X1
Xfanout194 _18508_/Q VDD VSS _09729_/D BUFX3
XFILLER_59_384 VSS VDD FILLER2
XTAP_TAPCELL_ROW_144_1305 VDD VSS WELLTAP
XFILLER_47_63 VDD VSS FILLER4
X_16650_ _19607_/Q _16758_/B VDD VSS _16657_/A OR2X2
XTAP_TAPCELL_ROW_57_530 VDD VSS WELLTAP
X_13862_ _19032_/Q _13862_/B _13901_/D VDD VSS _13951_/C XOR3X1
XFILLER_47_96 VSS VDD FILLER2
X_15601_ _15576_/A _15601_/B _15601_/C VDD VSS _15824_/B AOI2B1X1
XFILLER_28_771 VSS VDD FILLER2
X_12813_ _12813_/A _12813_/B _12813_/C VDD VSS _12819_/B XNOR3X1
XFILLER_90_836 VSS VDD FILLER2
X_16581_ _19669_/Q _16828_/B VDD VSS _16595_/B XOR2X1
XTAP_TAPCELL_ROW_29_276 VDD VSS WELLTAP
XFILLER_28_793 VSS VDD FILLER2
X_13793_ _14392_/A _14392_/B _19114_/Q VDD VSS _13857_/C OAI21X1
X_18320_ _18325_/CK _18517_/Q _18320_/Q _18469_/RB VDD VSS DFFRQX1
XFILLER_103_91 VSS VDD FILLER2
X_15532_ _15532_/A _15535_/B VDD VSS _18153_/B XNOR2X1
X_12744_ _19187_/Q _12827_/A _12827_/B VDD VSS _12746_/D XNOR3X1
X_18251_ _18257_/CK _18251_/D _18266_/D _18469_/RB VDD VSS DFFRQX1
XFILLER_63_84 VDD VSS FILLER1
X_15463_ _19378_/Q _15755_/B VDD VSS _15492_/A NOR2BX1
X_12675_ _12759_/A _12763_/C _12675_/C VDD VSS _12832_/C XNOR3X1
X_17202_ _17204_/C _17202_/B _17202_/C VDD VSS _19795_/D AOI21X1
XFILLER_147_109 VSS VDD FILLER2
X_14414_ _14381_/Y _14414_/B _14414_/C VDD VSS _19134_/D AND3BX1
XTAP_TAPCELL_ROW_12_121 VDD VSS WELLTAP
X_18182_ _18185_/C _18185_/B VDD VSS _18183_/B NAND2BX1
X_11626_ _18768_/Q _11635_/B VDD VSS _18795_/D AND2X1
XFILLER_129_835 VSS VDD FILLER2
X_15394_ _15394_/A _15848_/B _15394_/C VDD VSS _15430_/B OAI21X1
XFILLER_30_479 VSS VDD FILLER2
XFILLER_128_312 VDD VSS FILLER4
XTAP_TAPCELL_ROW_155_1412 VDD VSS WELLTAP
XFILLER_128_323 VSS VDD FILLER2
XFILLER_156_632 VSS VDD FILLER2
X_17133_ _19781_/Q _19749_/Q VDD VSS _17140_/C NOR2X1
XFILLER_8_79 VDD VSS FILLER1
X_14345_ _14352_/A _14345_/B _14345_/C VDD VSS _19072_/D NOR3X1
X_11557_ _11648_/A VDD VSS _11567_/B BUFX3
XFILLER_143_304 VSS VDD FILLER2
X_17064_ _17064_/A _17064_/B VDD VSS _17066_/B _17064_/C _17064_/D NAND4X2
X_10508_ _10544_/C _10544_/B VDD VSS _10509_/B NAND2BX1
X_14276_ _14285_/A _14276_/B VDD VSS _19012_/D NOR2X1
X_11488_ _18643_/Q _11496_/B VDD VSS _18670_/D AND2X1
X_16015_ _16015_/A _16015_/B VDD VSS _16871_/B XNOR2X1
X_13227_ _13316_/A _13316_/B _13316_/D _13316_/C VDD VSS _14416_/B OAOI211X1
X_10439_ _18634_/Q _18796_/Q VDD VSS _10441_/C AND2X1
XFILLER_40_5 VSS VDD FILLER2
XTAP_TAPCELL_ROW_110_1006 VDD VSS WELLTAP
X_13158_ _19108_/Q _13219_/B _13231_/C VDD VSS _13364_/B XNOR3X1
XFILLER_88_81 VDD VSS FILLER1
XFILLER_112_735 VDD VSS FILLER4
XFILLER_111_223 VSS VDD FILLER2
XFILLER_112_746 VSS VDD FILLER2
X_12109_ _20000_/Q _19264_/Q VDD VSS _12233_/C XOR2X1
X_17966_ _17966_/A _17966_/B _17966_/C _17966_/D VDD VSS _17967_/C OAI211X1
X_13089_ _18995_/Q _14257_/B VDD VSS _13192_/C _14257_/C AND3X2
XFILLER_97_468 VSS VDD FILLER2
XFILLER_78_660 VDD VSS FILLER4
X_16917_ _17047_/B VDD VSS _17073_/B BUFX3
X_19705_ _19705_/CK _19705_/D _19705_/Q VDD VSS DFFQX1
XFILLER_84_129 VDD VSS FILLER4
X_17897_ _17898_/B _17898_/C _17901_/C _18087_/D VDD VSS _17898_/D AOAI211X1
XFILLER_19_2 VDD VSS FILLER1
X_16848_ _16859_/A _16848_/B VDD VSS _19687_/D AND2X1
X_19636_ _19636_/CK _19636_/D _19636_/Q VDD VSS DFFQX1
XFILLER_19_771 VSS VDD FILLER2
XFILLER_93_696 VDD VSS FILLER4
XFILLER_81_836 VDD VSS FILLER1
X_19567_ _19584_/CK _19567_/D _19567_/Q VDD VSS DFFQX1
XFILLER_65_398 VSS VDD FILLER2
X_16779_ _16793_/A _16779_/B VDD VSS _19625_/D AND2X1
XTAP_TAPCELL_ROW_91_831 VDD VSS WELLTAP
X_09320_ _18290_/Q _18497_/D _09299_/Y VDD VSS _09320_/Y MUXI2X1
XTAP_TAPCELL_ROW_121_1102 VDD VSS WELLTAP
X_18518_ _18518_/CK _18518_/D _18518_/Q _09322_/Y VDD VSS DFFRQX1
X_19498_ _19531_/CK _19498_/D _19498_/Q VDD VSS DFFQX1
XTAP_TAPCELL_ROW_103_943 VDD VSS WELLTAP
XTAP_TAPCELL_ROW_63_577 VDD VSS WELLTAP
XFILLER_34_785 VDD VSS FILLER4
X_09251_ _18278_/Q _18277_/Q VDD VSS _09408_/C _18276_/Q AND3X2
X_18449_ _18455_/CK _18449_/D _18449_/Q _18450_/RB VDD VSS DFFRQX1
XFILLER_61_593 VDD VSS FILLER4
XFILLER_33_284 VDD VSS FILLER1
XFILLER_21_468 VSS VDD FILLER2
XFILLER_119_301 VSS VDD FILLER2
XFILLER_119_312 VSS VDD FILLER2
XFILLER_147_643 VDD VSS FILLER1
XFILLER_147_654 VSS VDD FILLER2
XFILLER_146_142 VSS VDD FILLER2
XFILLER_162_602 VSS VDD FILLER2
XFILLER_146_164 VDD VSS FILLER1
XFILLER_147_698 VDD VSS FILLER4
XTAP_TAPCELL_ROW_119_1086 VDD VSS WELLTAP
XFILLER_162_646 VSS VDD FILLER2
XFILLER_162_668 VSS VDD FILLER2
XFILLER_150_819 VSS VDD FILLER2
XFILLER_161_167 VSS VDD FILLER2
XFILLER_68_18 VSS VDD FILLER2
XFILLER_103_713 VDD VSS FILLER4
XFILLER_161_189 VSS VDD FILLER2
XFILLER_103_735 VDD VSS FILLER1
XFILLER_115_595 VDD VSS FILLER1
XFILLER_102_223 VDD VSS FILLER1
XFILLER_103_779 VSS VDD FILLER2
XFILLER_69_660 VSS VDD FILLER2
XFILLER_57_800 VSS VDD FILLER2
XFILLER_57_855 VSS VDD FILLER2
XFILLER_29_579 VSS VDD FILLER2
XFILLER_17_22 VDD VSS FILLER4
XFILLER_56_376 VSS VDD FILLER2
XTAP_TAPCELL_ROW_54_500 VDD VSS WELLTAP
XFILLER_84_696 VDD VSS FILLER1
XFILLER_44_527 VSS VDD FILLER2
XFILLER_140_34 VSS VDD FILLER2
XFILLER_83_184 VSS VDD FILLER2
XFILLER_17_66 VDD VSS FILLER4
X_09518_ _20018_/Q _20017_/Q _09520_/D VDD VSS _09519_/C OAI21X1
XTAP_TAPCELL_ROW_26_246 VDD VSS WELLTAP
X_10790_ _10790_/A _10790_/B _10790_/C _10790_/D VDD VSS _10856_/B OAI211X1
XFILLER_40_700 VSS VDD FILLER2
XFILLER_24_273 VSS VDD FILLER2
X_09449_ _09482_/C VDD VSS _09483_/B BUFX3
X_12460_ _12460_/A _14345_/B _14345_/C VDD VSS _12461_/D NOR3X1
XTAP_TAPCELL_ROW_4_47 VDD VSS WELLTAP
X_11411_ _11422_/A _17990_/B _11411_/C VDD VSS _18605_/D NOR3X1
XFILLER_123_2 VDD VSS FILLER1
X_12391_ _12391_/A _12391_/B _12391_/C _12391_/D VDD VSS _12571_/B AOAI211X1
XFILLER_137_142 VSS VDD FILLER2
XFILLER_126_827 VDD VSS FILLER1
X_14130_ _14158_/A _14130_/B VDD VSS _18889_/D AND2X1
X_11342_ _11343_/B _11342_/B VDD VSS _11345_/B NAND2X1
XFILLER_4_634 VDD VSS FILLER4
XFILLER_4_645 VSS VDD FILLER2
X_14061_ _14086_/A _14061_/B VDD VSS _14171_/B XOR2X1
X_11273_ _11273_/A VDD VSS _11383_/A BUFX3
XFILLER_141_819 VSS VDD FILLER2
X_13012_ _13021_/A _13021_/B _13091_/C VDD VSS _14320_/C NOR3X1
X_10224_ _10224_/A _10224_/B _10224_/C _18621_/Q VDD VSS _10229_/B AOI211X1
XTAP_TAPCELL_ROW_150_1364 VDD VSS WELLTAP
XFILLER_4_689 VSS VDD FILLER2
XFILLER_106_595 VSS VDD FILLER2
XFILLER_121_521 VDD VSS FILLER1
X_17820_ _17823_/A _17823_/B _17828_/C VDD VSS _17821_/C OAI21X1
X_10155_ _10155_/A _10190_/C _10155_/C _10166_/D VDD VSS _10156_/C AOI211X1
XFILLER_79_468 VSS VDD FILLER2
XFILLER_79_479 VSS VDD FILLER2
XFILLER_121_576 VSS VDD FILLER2
XFILLER_94_416 VSS VDD FILLER2
XFILLER_58_73 VDD VSS DECAPHV8
X_17751_ _17754_/C _17752_/B _17828_/C VDD VSS _17752_/C OAI21X1
X_14963_ _14966_/A _14966_/B _14966_/C VDD VSS _14963_/Y AOI21X1
X_10086_ _10097_/A _10086_/B VDD VSS _10087_/B XNOR2X1
XFILLER_66_129 VSS VDD FILLER2
XFILLER_58_95 VSS VDD FILLER2
X_16702_ _19908_/Q _16702_/B VDD VSS _19556_/D AND2X1
XFILLER_75_641 VSS VDD FILLER2
X_13914_ _13967_/C _13965_/B _13914_/C VDD VSS _13958_/B XNOR3X1
X_17682_ _19898_/Q _19866_/Q _17746_/C VDD VSS _17683_/C OAI21X1
X_14894_ _19309_/Q _15680_/B VDD VSS _14897_/A XNOR2X1
X_19421_ _19466_/CK _19421_/D _19421_/Q VDD VSS DFFQX1
X_16633_ _19639_/Q _16793_/B VDD VSS _16634_/B XNOR2X1
XFILLER_90_622 VSS VDD FILLER2
XFILLER_74_173 VSS VDD FILLER2
X_13845_ _13845_/A _14229_/B _13845_/C _13845_/D VDD VSS _13955_/A OAOI211X1
XTAP_TAPCELL_ROW_161_1460 VDD VSS WELLTAP
XFILLER_90_655 VSS VDD FILLER2
X_19352_ _19385_/CK _19352_/D _19352_/Q VDD VSS DFFQX1
XFILLER_90_666 VSS VDD FILLER2
XFILLER_62_357 VSS VDD FILLER2
X_16564_ _16566_/B _16564_/B VDD VSS _16565_/B XOR2X1
XFILLER_50_508 VSS VDD FILLER2
X_13776_ _13783_/A _14297_/B _13783_/C VDD VSS _14298_/C NOR3X1
XFILLER_16_774 VSS VDD FILLER2
X_10988_ _11364_/A _11235_/B _10988_/C VDD VSS _11026_/B OA21X2
X_18303_ _18311_/CK _18495_/D _18303_/Q _18471_/RB VDD VSS DFFRQX1
XFILLER_43_571 VSS VDD FILLER2
XFILLER_31_711 VSS VDD FILLER2
X_15515_ _15515_/A _15515_/B _15515_/C VDD VSS _15885_/B AOI21X1
X_19283_ _19314_/CK _19283_/D _19283_/Q VDD VSS DFFQX1
X_12727_ _12809_/A _12819_/A _12910_/B VDD VSS _12729_/C XNOR3X1
XFILLER_15_284 VDD VSS FILLER1
X_16495_ _19633_/Q _16495_/B _16787_/B VDD VSS _16521_/B MIN3X1
XTAP_TAPCELL_ROW_100_913 VDD VSS WELLTAP
Xclkbuf_2_1__f__001_ clkbuf_0__001_/Y VDD VSS clkbuf_2_1__f__001_/Y BUFX12
X_18234_ _18234_/CK _18234_/E _18234_/ECK VDD VSS CGX3
XFILLER_129_610 VSS VDD FILLER2
X_15446_ _15469_/B _15446_/B VDD VSS _15819_/B XNOR2X1
Xclkbuf_leaf_1__001_ clkbuf_leaf_4__001_/A VDD VSS _20013_/CK BUFX12
X_12658_ _12840_/A _12840_/B _12658_/C VDD VSS _14473_/B NOR3X1
XFILLER_31_799 VSS VDD FILLER2
XFILLER_129_643 VDD VSS FILLER1
XFILLER_129_654 VSS VDD FILLER2
X_18165_ _19299_/Q _18169_/B VDD VSS _18167_/C XOR2X1
X_11609_ _11609_/A _11641_/B VDD VSS _18780_/D NOR2X1
XFILLER_117_805 VSS VDD FILLER2
X_15377_ _15425_/B _15377_/B VDD VSS _15722_/B NOR2BX1
XFILLER_11_490 VSS VDD FILLER2
XFILLER_128_142 VDD VSS FILLER4
X_12589_ _19186_/Q _12649_/B _12658_/C VDD VSS _12655_/C XNOR3X1
XFILLER_156_451 VDD VSS FILLER1
XFILLER_129_676 VDD VSS FILLER1
XFILLER_144_602 VSS VDD FILLER2
XFILLER_156_462 VSS VDD FILLER2
XFILLER_117_827 VDD VSS DECAPHV8
XFILLER_144_613 VDD VSS DECAPHV8
X_17116_ _17118_/C _17117_/B _17164_/C VDD VSS _17117_/C OAI21X1
X_14328_ _14339_/A _14328_/B VDD VSS _19057_/D NOR2X1
XFILLER_117_849 VSS VDD FILLER2
X_18096_ _18096_/A _18096_/B VDD VSS _18100_/C NAND2X1
XFILLER_143_112 VSS VDD FILLER2
XFILLER_144_646 VDD VSS FILLER1
X_17047_ _19763_/Q _17047_/B VDD VSS _17064_/B XOR2X1
Xmax_cap158 _14319_/B VDD VSS _13021_/B BUFX4
X_14259_ _14294_/A _14259_/B _14259_/C VDD VSS _18997_/D NOR3X1
XFILLER_99_91 VSS VDD FILLER2
XFILLER_98_700 VSS VDD FILLER2
XFILLER_143_167 VDD VSS FILLER1
Xmax_cap169 _09426_/A VDD VSS _09446_/A BUFX3
XFILLER_143_189 VSS VDD FILLER2
XFILLER_112_510 VDD VSS FILLER1
XFILLER_112_521 VSS VDD FILLER2
XFILLER_140_852 VDD VSS FILLER4
XFILLER_98_766 VSS VDD FILLER2
XFILLER_58_619 VSS VDD FILLER2
X_18998_ _18999_/CK _18998_/D _18998_/Q VDD VSS DFFQX1
XFILLER_97_276 VSS VDD FILLER2
XFILLER_85_416 VDD VSS FILLER1
XFILLER_24_0 VDD VSS FILLER1
XTAP_TAPCELL_ROW_68_625 VDD VSS WELLTAP
X_17949_ _18866_/Q _17949_/B VDD VSS _17958_/A NOR2BX1
XFILLER_38_332 VDD VSS FILLER1
XFILLER_38_354 VSS VDD FILLER2
XFILLER_54_814 VSS VDD FILLER2
XFILLER_65_162 VDD VSS FILLER1
XFILLER_38_376 VSS VDD FILLER2
X_19619_ _19667_/CK _19619_/D _19619_/Q VDD VSS DFFQX1
XFILLER_53_324 VSS VDD FILLER2
XFILLER_38_398 VDD VSS FILLER4
XFILLER_41_519 VSS VDD FILLER2
XFILLER_22_700 VSS VDD FILLER2
X_09303_ _18456_/D _09300_/Y _09302_/Y VDD VSS _18525_/D MUXI2X1
XTAP_TAPCELL_ROW_23_216 VDD VSS WELLTAP
XFILLER_34_593 VSS VDD FILLER2
XFILLER_22_733 VDD VSS FILLER1
XFILLER_139_418 VDD VSS FILLER4
XFILLER_22_766 VDD VSS FILLER1
Xclkbuf_leaf_20__000_ clkload72/A VDD VSS _19602_/CK BUFX12
X_09234_ _18495_/D VDD VSS _18351_/D INVX1
XFILLER_21_254 VSS VDD FILLER2
XFILLER_22_788 VSS VDD FILLER2
XFILLER_108_816 VSS VDD FILLER2
XFILLER_119_24 VDD VSS FILLER1
XTAP_TAPCELL_ROW_31_293 VDD VSS WELLTAP
XFILLER_107_304 VSS VDD FILLER2
XFILLER_134_101 VSS VDD FILLER2
XFILLER_162_421 VSS VDD FILLER2
XFILLER_135_646 VDD VSS FILLER4
XFILLER_135_668 VSS VDD FILLER2
Xclkbuf_leaf_35__000_ clkbuf_leaf_6__000_/A VDD VSS _19478_/CK BUFX12
XFILLER_162_443 VSS VDD FILLER2
XFILLER_123_819 VSS VDD FILLER2
XFILLER_122_307 VDD VSS FILLER4
XFILLER_115_370 VSS VDD FILLER2
XFILLER_89_733 VSS VDD FILLER2
XFILLER_1_626 VDD VSS FILLER1
XFILLER_115_381 VSS VDD FILLER2
Xclkbuf_1_1__f_clk clkbuf_0_clk/Y VDD VSS _232_/CK BUFX12
XFILLER_103_532 VDD VSS FILLER4
XFILLER_89_777 VSS VDD FILLER2
X_20187_ _20187_/A VDD VSS _20187_/Y BUFX3
X_09998_ _18600_/Q _09998_/B _09998_/C VDD VSS _10011_/B AOI21X1
XFILLER_76_405 VDD VSS FILLER4
XFILLER_76_416 VSS VDD FILLER2
XFILLER_130_384 VDD VSS FILLER4
XFILLER_76_438 VDD VSS FILLER1
X_11960_ _19065_/Q _11960_/B _12014_/B VDD VSS _12080_/B MIN3X1
XFILLER_45_803 VSS VDD FILLER2
XFILLER_29_365 VSS VDD FILLER2
XFILLER_28_76 VSS VDD FILLER2
XFILLER_72_611 VSS VDD FILLER2
XFILLER_44_302 VSS VDD FILLER2
XFILLER_84_471 VDD VSS FILLER4
X_10911_ _10876_/Y _10910_/Y _10945_/A VDD VSS _10911_/Y MUXI2X1
XTAP_TAPCELL_ROW_39_360 VDD VSS WELLTAP
X_11891_ _19176_/Q _11891_/B _11918_/C VDD VSS _12035_/C XNOR3X1
XFILLER_72_666 VDD VSS FILLER4
X_13630_ _13640_/A _13640_/B _13630_/C VDD VSS _14422_/C OAI21X1
X_10842_ _10699_/Y _10841_/Y _10843_/A VDD VSS _10845_/B MUXI2X1
XFILLER_44_31 VDD VSS FILLER4
XFILLER_44_379 VDD VSS FILLER4
X_13561_ _19168_/Q _13637_/D _13561_/C VDD VSS _13630_/C XNOR3X1
X_10773_ _11116_/A _10773_/B VDD VSS _10774_/B NOR2X1
XFILLER_44_86 VSS VDD FILLER2
XFILLER_13_755 VDD VSS FILLER4
XFILLER_52_390 VSS VDD FILLER2
X_15300_ _19346_/Q _15720_/B _15300_/C VDD VSS _15341_/B AOI21X1
XFILLER_40_541 VDD VSS FILLER1
XFILLER_13_766 VSS VDD FILLER2
X_12512_ _12512_/A _12512_/B _14343_/B VDD VSS _14310_/B XNOR3X1
X_16280_ _19625_/Q _16779_/B VDD VSS _16292_/A NAND2BX1
XFILLER_9_726 VSS VDD FILLER2
X_13492_ _13492_/A _13502_/D VDD VSS _14128_/B XNOR2X1
XFILLER_9_759 VSS VDD FILLER2
X_15231_ _15275_/A _15275_/C _15193_/B VDD VSS _15232_/C AOI21BX1
X_12443_ _19044_/Q VDD VSS _12515_/C INVX1
XFILLER_60_41 VDD VSS FILLER4
XFILLER_138_451 VSS VDD FILLER2
XFILLER_126_602 VSS VDD FILLER2
X_15162_ _19399_/Q _15778_/B VDD VSS _15178_/B XNOR2X1
XFILLER_166_793 VSS VDD FILLER2
X_12374_ _19154_/Q _14437_/B _14437_/C VDD VSS _12378_/D OR3BX1
X_14113_ _14158_/A _14113_/B VDD VSS _18873_/D AND2X1
X_11325_ _11364_/B _11325_/B _11325_/C _11325_/D VDD VSS _11333_/B OAOI211X1
XFILLER_126_679 VSS VDD FILLER2
X_15093_ _15139_/A _15139_/B VDD VSS _15116_/A NAND2X1
X_19970_ _19985_/CK _19970_/D _19970_/Q VDD VSS DFFQX1
XFILLER_113_307 VDD VSS FILLER4
XFILLER_4_475 VSS VDD FILLER2
XFILLER_113_329 VSS VDD FILLER2
XFILLER_125_189 VSS VDD FILLER2
X_18921_ _18973_/CK _18921_/D _18921_/Q VDD VSS DFFQX1
X_14044_ _18979_/Q _14235_/B VDD VSS _14068_/A NOR2X1
X_11256_ _11181_/Y _11298_/B _11298_/A VDD VSS _11341_/B MUXI2X1
XFILLER_79_221 VDD VSS FILLER1
XFILLER_140_137 VSS VDD FILLER2
XFILLER_69_72 VSS VDD FILLER2
XFILLER_122_852 VSS VDD FILLER2
X_10207_ _18619_/Q _10207_/B VDD VSS _10217_/B NAND2X1
XFILLER_121_340 VSS VDD FILLER2
X_18852_ _18889_/CK _18852_/D _18852_/Q VDD VSS DFFQX1
X_11187_ _11217_/B _11217_/C VDD VSS _11188_/B NAND2BX1
XFILLER_95_714 VSS VDD FILLER2
XFILLER_121_362 VDD VSS FILLER1
XFILLER_79_276 VSS VDD FILLER2
XFILLER_39_107 VSS VDD FILLER2
XFILLER_67_427 VDD VSS FILLER4
X_17803_ _17803_/A _17803_/B _17803_/C VDD VSS _17807_/C MIN3X1
X_10138_ _18588_/Q _10138_/B VDD VSS _10163_/C NOR2BX1
XFILLER_79_287 VSS VDD FILLER2
X_18783_ _18810_/CK _18783_/D _18783_/Q VDD VSS DFFQX1
XFILLER_95_747 VSS VDD FILLER2
X_15995_ _15965_/A _15995_/B _15995_/C VDD VSS _16038_/C AOI2B1X1
XFILLER_94_235 VSS VDD FILLER2
X_17734_ _17738_/A _17735_/B _17746_/C VDD VSS _17735_/C OAI21X1
X_14946_ _14952_/B _14946_/B VDD VSS _15681_/B XNOR2X1
X_10069_ _10055_/Y _10068_/Y _10127_/A VDD VSS _10069_/Y MUX2X1
XFILLER_85_71 VDD VSS FILLER4
X_17665_ _17667_/A _17667_/B _17665_/C VDD VSS _19894_/D AOI21X1
XFILLER_47_184 VSS VDD FILLER2
X_14877_ _19529_/Q _19530_/Q _14877_/C _19531_/Q VDD VSS _14921_/C AOI31X1
X_16616_ _16616_/A _16616_/B _16616_/C VDD VSS _16643_/B OA21X2
X_19404_ _19406_/CK _19404_/D _19404_/Q VDD VSS DFFQX1
X_13828_ _13845_/A _14229_/B _13845_/C VDD VSS _14230_/B OAI21X1
X_17596_ _19879_/Q _19847_/Q _17596_/C VDD VSS _17600_/C MIN3X1
XFILLER_50_305 VSS VDD FILLER2
XTAP_TAPCELL_ROW_73_672 VDD VSS WELLTAP
XFILLER_62_187 VSS VDD FILLER2
X_16547_ _19603_/Q _16754_/B VDD VSS _16548_/C NOR2X1
X_19335_ _19349_/CK _19335_/D _19335_/Q VDD VSS DFFQX1
X_13759_ _18974_/Q VDD VSS _13770_/A INVX1
XFILLER_43_390 VDD VSS FILLER4
XFILLER_149_727 VSS VDD FILLER2
XFILLER_148_215 VDD VSS FILLER4
X_19266_ _19269_/CK _19266_/D _19266_/Q VDD VSS DFFQX1
X_16478_ _16498_/C _16478_/B VDD VSS _16501_/A XNOR2X1
X_18217_ _18217_/CK _18217_/E _18217_/ECK VDD VSS CGX3
X_15429_ _15429_/A _15429_/B VDD VSS _15449_/B AND2X1
X_19197_ _19200_/CK _19197_/D _19197_/Q VDD VSS DFFQX1
XFILLER_157_771 VDD VSS FILLER1
X_18148_ _19295_/Q _18149_/B VDD VSS _18150_/B NOR2X1
XFILLER_8_770 VSS VDD FILLER2
XFILLER_117_635 VDD VSS FILLER4
XFILLER_144_421 VSS VDD FILLER2
XFILLER_7_291 VSS VDD FILLER2
X_18079_ _19282_/Q _18079_/B VDD VSS _18083_/A NAND2X1
XTAP_TAPCELL_ROW_116_1056 VDD VSS WELLTAP
XFILLER_116_167 VDD VSS DECAPHV8
XFILLER_116_178 VSS VDD FILLER2
XFILLER_131_104 VDD VSS FILLER1
X_20110_ _20110_/A VDD VSS _20110_/Y BUFX3
X_09921_ _18563_/Q _10927_/C VDD VSS _09922_/B XNOR2X1
XFILLER_113_830 VDD VSS FILLER1
XFILLER_98_541 VSS VDD FILLER2
X_20041_ _20045_/CK _20041_/D _20041_/Q _20045_/RB VDD VSS DFFRQX1
X_09852_ _10268_/B VDD VSS _10927_/C BUFX3
Xclkbuf_1_1__f__09175_ clkbuf_0__09175_/Y VDD VSS _18275_/CK BUFX12
XFILLER_58_416 VSS VDD FILLER2
XFILLER_105_26 VDD VSS FILLER4
XFILLER_105_37 VSS VDD FILLER2
XFILLER_112_395 VSS VDD FILLER2
X_09783_ _18405_/Q _09783_/B _09783_/C VDD VSS _09784_/E OAI21X1
XFILLER_85_235 VSS VDD FILLER2
XFILLER_86_769 VSS VDD FILLER2
XFILLER_100_557 VDD VSS FILLER1
XFILLER_73_419 VSS VDD FILLER2
XTAP_TAPCELL_ROW_127_1152 VDD VSS WELLTAP
XFILLER_26_313 VSS VDD FILLER2
XFILLER_53_121 VDD VSS FILLER4
XFILLER_54_666 VSS VDD FILLER2
XFILLER_53_143 VSS VDD FILLER2
XTAP_TAPCELL_ROW_36_341 VDD VSS WELLTAP
XFILLER_42_817 VSS VDD FILLER2
XFILLER_53_176 VDD VSS FILLER1
XFILLER_53_198 VSS VDD FILLER2
XFILLER_22_541 VSS VDD FILLER2
XFILLER_22_563 VDD VSS FILLER1
XFILLER_22_585 VDD VSS FILLER4
X_09217_ _18521_/Q VDD VSS _18404_/D INVX1
XFILLER_108_602 VSS VDD FILLER2
XFILLER_6_729 VDD VSS FILLER1
XFILLER_148_793 VDD VSS FILLER4
XFILLER_108_668 VSS VDD FILLER2
XTAP_TAPCELL_ROW_1_26 VDD VSS WELLTAP
XFILLER_107_167 VSS VDD FILLER2
XFILLER_135_476 VSS VDD FILLER2
XFILLER_146_44 VSS VDD FILLER2
XFILLER_30_77 VSS VDD FILLER2
XFILLER_146_55 VDD VSS FILLER1
X_11110_ _11132_/D _11132_/B VDD VSS _11111_/B NAND2BX1
XFILLER_107_189 VSS VDD FILLER2
X_12090_ _19178_/Q _14464_/B VDD VSS _12116_/A NAND2X1
XFILLER_122_126 VSS VDD FILLER2
XFILLER_123_649 VSS VDD FILLER2
XFILLER_146_77 VSS VDD FILLER2
XFILLER_122_137 VSS VDD FILLER2
X_11041_ _11067_/C _11041_/B _11041_/C _11041_/D VDD VSS _11047_/C OAOI211X1
XFILLER_77_703 VDD VSS DECAPHV8
XFILLER_162_21 VDD VSS FILLER4
XFILLER_49_427 VDD VSS FILLER4
XFILLER_77_747 VSS VDD FILLER2
XFILLER_76_235 VSS VDD FILLER2
X_14800_ _14800_/A _14800_/B _15737_/B VDD VSS _14810_/C MIN3X1
Xclkbuf_leaf_0__002_ clkload16/A VDD VSS _18818_/CK BUFX12
X_15780_ _15780_/A _15780_/B VDD VSS _19400_/D NOR2X1
X_12992_ _12992_/A _12992_/B _14186_/B VDD VSS _13086_/B MIN3X1
XFILLER_91_205 VSS VDD FILLER2
XFILLER_17_302 VSS VDD FILLER2
XTAP_TAPCELL_ROW_87_797 VDD VSS WELLTAP
X_14731_ _19446_/Q VDD VSS _14778_/A INVX1
XFILLER_18_847 VSS VDD FILLER2
X_11943_ _19091_/Q _11943_/B _14367_/B VDD VSS _14335_/B XNOR3X1
XFILLER_29_184 VSS VDD FILLER2
XFILLER_44_132 VSS VDD FILLER2
X_17450_ _17600_/B _17450_/B _17450_/C VDD VSS _17455_/C MIN3X1
XFILLER_55_74 VSS VDD FILLER2
XFILLER_33_817 VSS VDD FILLER2
X_14662_ _19415_/Q _14669_/B _15797_/B VDD VSS _15765_/B XNOR3X1
X_11874_ _11874_/A _11874_/B _11874_/C _11874_/D VDD VSS _12035_/B OAOI211X1
XFILLER_55_96 VSS VDD FILLER2
XFILLER_17_379 VDD VSS FILLER1
X_16401_ _16402_/A _16402_/B _16402_/C VDD VSS _16429_/B AOI21X1
X_13613_ _19029_/Q VDD VSS _13839_/A INVX1
X_17381_ _19834_/Q _19802_/Q _17452_/C VDD VSS _17382_/C OAI21X1
X_10825_ _18699_/Q _18753_/Q VDD VSS _10827_/B XNOR2X1
XFILLER_44_198 VSS VDD FILLER2
XFILLER_32_338 VSS VDD FILLER2
X_14593_ _19440_/Q _15825_/B VDD VSS _14639_/B NOR2X1
XTAP_TAPCELL_ROW_70_642 VDD VSS WELLTAP
XFILLER_60_669 VSS VDD FILLER2
X_19120_ _19139_/CK _19120_/D _19120_/Q VDD VSS DFFQX1
XFILLER_111_91 VSS VDD FILLER2
X_16332_ _16329_/B _16332_/B _16332_/C VDD VSS _16355_/A AOI2B1X1
X_13544_ _19167_/Q _13637_/A _13549_/B VDD VSS _13546_/C XNOR3X1
X_10756_ _10798_/A _10756_/B VDD VSS _10762_/B XNOR2X1
XFILLER_40_360 VDD VSS FILLER4
XTAP_TAPCELL_ROW_42_388 VDD VSS WELLTAP
XFILLER_13_596 VSS VDD FILLER2
X_19051_ _19094_/CK _19051_/D _19051_/Q VDD VSS DFFQX1
XFILLER_9_545 VSS VDD FILLER2
X_16263_ _19625_/Q _16779_/B VDD VSS _16281_/B XNOR2X1
X_13475_ _18999_/Q _13607_/A _13683_/B VDD VSS _13594_/D XNOR3X1
XFILLER_158_579 VSS VDD FILLER2
X_10687_ _18640_/Q _18802_/Q _10687_/C VDD VSS _10715_/A MIN3X1
XFILLER_139_771 VDD VSS FILLER1
X_18002_ _18546_/Q _18547_/Q VDD VSS _18055_/B _18052_/B NAND3X1
X_15214_ _15217_/B _15214_/B VDD VSS _18107_/B XNOR2X1
XFILLER_139_793 VDD VSS FILLER1
X_12426_ _12441_/A _12441_/B _14248_/B VDD VSS _14211_/B XNOR3X1
XFILLER_126_421 VDD VSS DECAPHV8
X_16194_ _16201_/B _16194_/B VDD VSS _16882_/B XNOR2X1
XFILLER_154_730 VSS VDD FILLER2
XFILLER_5_740 VDD VSS FILLER4
X_15145_ _15145_/A _15145_/B _15145_/C _15145_/D VDD VSS _15191_/B OAOI211X1
X_12357_ _12357_/A _12357_/B _14281_/B VDD VSS _12442_/B MIN3X1
XFILLER_114_627 VSS VDD FILLER2
XFILLER_141_413 VDD VSS FILLER1
XFILLER_5_784 VSS VDD FILLER2
XFILLER_126_498 VSS VDD FILLER2
X_11308_ _11308_/A _11308_/B VDD VSS _11319_/B _11308_/C AND3X2
X_15076_ _15126_/B _15076_/B VDD VSS _15684_/B XNOR2X1
X_19953_ _19956_/CK _19953_/D _19953_/Q VDD VSS DFFQX1
X_12288_ _12288_/A _14309_/B _12288_/C VDD VSS _14279_/A MIN3X1
XFILLER_141_468 VDD VSS FILLER4
X_18904_ _18905_/CK _18904_/D _18904_/Q VDD VSS DFFQX1
X_14027_ _18923_/Q VDD VSS _14054_/A INVX1
X_11239_ _11249_/C _11239_/B _11239_/C VDD VSS _18578_/D AOI21X1
XFILLER_110_800 VDD VSS DECAPHV8
X_19884_ clkload8/A _19884_/D _19884_/Q VDD VSS DFFQX1
XFILLER_95_522 VDD VSS DECAPHV16
X_18835_ _19954_/CK _18835_/D _18835_/Q VDD VSS DFFQX1
XFILLER_95_544 VDD VSS FILLER4
X_15978_ _19643_/Q _16800_/B VDD VSS _15979_/B XNOR2X1
X_18766_ _18767_/CK _18766_/D _18766_/Q VDD VSS DFFQX1
XFILLER_36_611 VDD VSS FILLER1
X_14929_ _19478_/Q _15869_/B VDD VSS _14957_/B XOR2X1
X_17717_ _19906_/Q _19874_/Q VDD VSS _17718_/B XOR2X1
X_18697_ _19947_/CK _18697_/D _18697_/Q VDD VSS DFFQX1
XFILLER_63_441 VDD VSS FILLER1
XFILLER_63_463 VSS VDD FILLER2
X_17648_ _19890_/Q _19858_/Q _17648_/C VDD VSS _17653_/C AO21X2
XFILLER_91_783 VSS VDD FILLER2
XFILLER_63_474 VDD VSS FILLER1
XFILLER_24_828 VSS VDD FILLER2
Xclkbuf_leaf_34__001_ clkbuf_2_1__f__001_/Y VDD VSS _19139_/CK BUFX12
XFILLER_90_282 VDD VSS FILLER4
XTAP_TAPCELL_ROW_33_311 VDD VSS WELLTAP
X_17579_ _17581_/A _17581_/B _17579_/C VDD VSS _19876_/D AOI21X1
XFILLER_51_669 VDD VSS FILLER1
XFILLER_16_390 VSS VDD FILLER2
XFILLER_91_0 VDD VSS FILLER1
XFILLER_149_513 VDD VSS DECAPHV8
X_19318_ _19333_/CK _19318_/D _19318_/Q VDD VSS DFFQX1
X_19249_ _19250_/CK _19249_/D _19249_/Q VDD VSS DFFQX1
XFILLER_136_207 VDD VSS FILLER4
XFILLER_164_538 VSS VDD FILLER2
XFILLER_117_421 VSS VDD FILLER2
XFILLER_117_454 VDD VSS DECAPHV8
XFILLER_160_700 VSS VDD FILLER2
XFILLER_144_262 VDD VSS FILLER1
XFILLER_105_627 VSS VDD FILLER2
XFILLER_104_137 VSS VDD FILLER2
XFILLER_116_14 VSS VDD FILLER2
X_09904_ _09899_/Y _10005_/B _09944_/A VDD VSS _09915_/B MUX2X1
XFILLER_120_619 VSS VDD FILLER2
XFILLER_113_671 VSS VDD FILLER2
XFILLER_86_500 VSS VDD FILLER2
XFILLER_160_799 VDD VSS FILLER4
XFILLER_76_18 VSS VDD FILLER2
X_20024_ _20033_/CK _20024_/D _20024_/Q _20030_/RB VDD VSS DFFRQX1
XFILLER_58_213 VDD VSS FILLER4
X_09835_ _10258_/D VDD VSS _10803_/A BUFX3
XFILLER_98_393 VSS VDD FILLER2
XFILLER_59_747 VDD VSS DECAPHV8
XFILLER_58_235 VDD VSS FILLER4
XFILLER_100_332 VDD VSS FILLER1
XFILLER_58_246 VSS VDD FILLER2
XFILLER_86_566 VDD VSS FILLER1
XFILLER_74_717 VDD VSS FILLER1
XFILLER_46_408 VDD VSS FILLER4
XFILLER_100_365 VDD VSS FILLER1
X_09766_ _18308_/Q _09782_/B _09766_/C _18468_/Q VDD VSS _09768_/C AOI22X1
XFILLER_86_599 VDD VSS FILLER4
XFILLER_39_460 VDD VSS FILLER4
XFILLER_100_387 VSS VDD FILLER2
XFILLER_132_35 VSS VDD FILLER2
XFILLER_73_227 VDD VSS FILLER1
XFILLER_39_482 VSS VDD FILLER2
X_09697_ _18463_/Q _09813_/B _09770_/C _20089_/A _09697_/E VDD VSS _09698_/B AOI221X1
XFILLER_92_28 VSS VDD FILLER2
XTAP_TAPCELL_ROW_84_767 VDD VSS WELLTAP
XFILLER_92_39 VDD VSS FILLER1
XFILLER_27_666 VSS VDD FILLER2
XFILLER_25_11 VSS VDD FILLER2
XFILLER_15_828 VSS VDD FILLER2
XFILLER_81_271 VSS VDD FILLER2
XFILLER_42_625 VSS VDD FILLER2
XFILLER_81_282 VDD VSS FILLER4
XFILLER_81_293 VSS VDD FILLER2
XFILLER_42_669 VSS VDD FILLER2
XFILLER_25_77 VSS VDD FILLER2
XFILLER_148_4 VDD VSS FILLER1
X_10610_ _18666_/Q _18774_/Q VDD VSS _10642_/C NAND2X1
X_11590_ _11648_/A VDD VSS _11600_/B BUFX3
XFILLER_128_719 VSS VDD FILLER2
X_10541_ _10548_/C _10541_/B VDD VSS _10542_/B XOR2X1
X_13260_ _13260_/A _13343_/A _13345_/C VDD VSS _13262_/B AOI21BX1
XFILLER_108_421 VSS VDD FILLER2
XFILLER_136_730 VSS VDD FILLER2
X_10472_ _10472_/A _10472_/B _10472_/C VDD VSS _10474_/C AOI21X1
XFILLER_157_65 VSS VDD FILLER2
X_12211_ _19098_/Q VDD VSS _12299_/A INVX1
X_13191_ _13192_/A _13192_/B _13192_/D _13192_/C VDD VSS _14219_/C AOI211X1
Xdelaybuf_4_clk delaybuf_4_clk/A VDD VSS _18228_/CK BUFX12
XFILLER_123_424 VSS VDD FILLER2
X_12142_ _12149_/A _12149_/B _12149_/C VDD VSS _14373_/C OR3X2
XFILLER_123_446 VSS VDD FILLER2
XFILLER_151_755 VSS VDD FILLER2
XFILLER_2_743 VSS VDD FILLER2
XFILLER_123_468 VSS VDD FILLER2
X_16950_ _16953_/C _16951_/B _17081_/C VDD VSS _16951_/C OAI21X1
X_12073_ _19038_/Q VDD VSS _12076_/A INVX1
XFILLER_89_371 VDD VSS FILLER1
X_15901_ _15906_/A _15901_/B VDD VSS _19507_/D NOR2X1
X_11024_ _11378_/A _11024_/B _11055_/B VDD VSS _18571_/D AND3BX1
XFILLER_49_224 VDD VSS FILLER1
XFILLER_1_286 VDD VSS FILLER1
X_16881_ _16891_/A _16881_/B VDD VSS _19717_/D NOR2X1
XFILLER_77_555 VSS VDD FILLER2
XFILLER_106_91 VDD VSS FILLER4
X_15832_ _15849_/A _15832_/B VDD VSS _19447_/D AND2X1
X_18620_ _18622_/CK _18620_/D _18620_/Q VDD VSS DFFQX1
XTAP_TAPCELL_ROW_147_1336 VDD VSS WELLTAP
XFILLER_49_268 VSS VDD FILLER2
XFILLER_92_514 VDD VSS FILLER4
XFILLER_66_73 VSS VDD FILLER2
X_15763_ _15780_/A _15763_/B VDD VSS _19385_/D NOR2X1
X_18551_ _18578_/CK _18551_/D _18551_/Q VDD VSS DFFQX1
XTAP_TAPCELL_ROW_47_436 VDD VSS WELLTAP
X_12975_ _13020_/A _12975_/B _13102_/D VDD VSS _13091_/C XNOR3X1
XFILLER_92_558 VSS VDD FILLER2
X_14714_ _14785_/B VDD VSS _14746_/B INVX1
X_17502_ _19860_/Q _19828_/Q VDD VSS _17505_/A XNOR2X1
X_18482_ _18487_/CK _18519_/Q _20127_/A _18486_/RB VDD VSS DFFRQX1
X_11926_ _11933_/A _14525_/B VDD VSS _14526_/A _11980_/C NAND3X1
X_15694_ _15817_/A VDD VSS _15710_/A BUFX3
XFILLER_60_411 VDD VSS FILLER4
XFILLER_32_102 VSS VDD FILLER2
X_17433_ _19845_/Q _19813_/Q VDD VSS _17439_/B NAND2X1
X_14645_ _14645_/A _14645_/B _14645_/C _14645_/D VDD VSS _14652_/A AOAI211X1
X_11857_ _11908_/A _11943_/B _14367_/B VDD VSS _11861_/C XNOR3X1
XFILLER_14_850 VSS VDD FILLER2
XFILLER_159_822 VDD VSS FILLER4
X_17364_ _17366_/A _17366_/B _17364_/C VDD VSS _19830_/D AOI21X1
X_10808_ _11255_/A _10808_/B _10808_/C VDD VSS _10808_/Y OA21X2
X_14576_ _19467_/Q VDD VSS _14594_/A INVX1
XFILLER_13_360 VSS VDD FILLER2
X_11788_ _19118_/Q VDD VSS _11865_/A INVX1
Xclkbuf_1_0__f__09178_ clkbuf_0__09178_/Y VDD VSS _20033_/CK BUFX12
XTAP_TAPCELL_ROW_158_1432 VDD VSS WELLTAP
XFILLER_119_708 VDD VSS FILLER1
X_16315_ _16340_/C _16315_/B VDD VSS _16745_/B XNOR2X1
X_19103_ _19157_/CK _19103_/D _19103_/Q VDD VSS DFFQX1
XFILLER_9_331 VSS VDD FILLER2
X_13527_ _19110_/Q _14388_/B _14388_/C VDD VSS _13528_/D OR3BX1
X_17295_ _19816_/Q _19784_/Q VDD VSS _17298_/A XNOR2X1
X_10739_ _10960_/A _11018_/B _10739_/C VDD VSS _10785_/B OAI21X1
X_19034_ _19115_/CK _19034_/D _19034_/Q VDD VSS DFFQX1
XFILLER_9_375 VSS VDD FILLER2
X_16246_ _19720_/Q _16884_/B VDD VSS _16247_/B XNOR2X1
X_13458_ _19194_/Q _14481_/B _14481_/C VDD VSS _13459_/D OR3BX1
X_12409_ _12577_/A _12577_/B _12577_/D VDD VSS _12413_/B AOI21X1
XFILLER_161_508 VDD VSS FILLER4
XFILLER_142_700 VDD VSS FILLER4
X_16177_ _16177_/A _16177_/B _16177_/C VDD VSS _16203_/B OA21X2
XFILLER_161_519 VDD VSS FILLER1
Xoutput105 _20180_/Y VDD VSS o_rst_ctrl_b[1] BUFX3
X_13389_ _13578_/A _13578_/B _13578_/C VDD VSS _13492_/A AOI21X1
XFILLER_154_560 VDD VSS FILLER4
Xoutput116 _20185_/Y VDD VSS o_tst_ctrl[4] BUFX3
XFILLER_154_571 VSS VDD FILLER2
Xoutput127 _20211_/Y VDD VSS o_uwb_tx_cfg[14] BUFX3
X_15128_ _19314_/Q _15685_/B VDD VSS _15129_/B XNOR2X1
Xoutput138 _20221_/Y VDD VSS o_uwb_tx_cfg[24] BUFX3
XTAP_TAPCELL_ROW_113_1026 VDD VSS WELLTAP
XFILLER_99_124 VSS VDD FILLER2
Xoutput149 _20204_/Y VDD VSS o_uwb_tx_cfg[7] BUFX3
XFILLER_141_243 VDD VSS FILLER4
X_15059_ _19535_/Q _15146_/C VDD VSS _15144_/B XOR2X1
X_19936_ clkload3/A _19936_/D _19936_/Q VDD VSS DFFQX1
XFILLER_99_168 VDD VSS FILLER1
XFILLER_101_107 VSS VDD FILLER2
XFILLER_141_276 VSS VDD FILLER2
X_19867_ _19895_/CK _19867_/D _19867_/Q VDD VSS DFFQX1
XFILLER_68_555 VDD VSS FILLER4
X_09620_ _18443_/Q VDD VSS _20155_/A INVX1
XFILLER_28_408 VSS VDD FILLER2
X_18818_ _18818_/CK _18818_/D _18818_/Q VDD VSS DFFQX1
X_19798_ clkload4/A _19798_/D _19798_/Q VDD VSS DFFQX1
XFILLER_83_525 VSS VDD FILLER2
XFILLER_83_536 VDD VSS FILLER4
X_09551_ _18440_/Q VDD VSS _20152_/A INVX1
X_18749_ _18831_/CK _18749_/D _18749_/Q VDD VSS DFFQX1
XFILLER_83_569 VDD VSS FILLER1
XFILLER_102_16 VSS VDD FILLER2
XFILLER_64_761 VDD VSS FILLER4
XTAP_TAPCELL_ROW_124_1133 VDD VSS WELLTAP
X_09482_ _19980_/Q _09490_/B _09482_/C VDD VSS _09483_/C AOI21X1
XFILLER_102_49 VSS VDD FILLER2
XFILLER_63_260 VDD VSS FILLER1
XFILLER_51_400 VSS VDD FILLER2
XFILLER_63_282 VDD VSS DECAPHV8
XTAP_TAPCELL_ROW_18_171 VDD VSS WELLTAP
XFILLER_51_444 VDD VSS FILLER4
XFILLER_51_455 VSS VDD FILLER2
XFILLER_51_477 VSS VDD FILLER2
XFILLER_149_332 VSS VDD FILLER2
XFILLER_165_847 VDD VSS DECAPHV8
XFILLER_164_324 VDD VSS FILLER1
XFILLER_164_346 VSS VDD FILLER2
XFILLER_117_273 VDD VSS FILLER4
XFILLER_133_722 VSS VDD FILLER2
XFILLER_3_529 VSS VDD FILLER2
XFILLER_105_424 VSS VDD FILLER2
XFILLER_127_68 VSS VDD FILLER2
XFILLER_105_468 VSS VDD FILLER2
XTAP_TAPCELL_ROW_89_815 VDD VSS WELLTAP
XFILLER_120_416 VSS VDD FILLER2
XFILLER_160_596 VDD VSS FILLER1
XFILLER_98_190 VSS VDD FILLER2
XFILLER_143_45 VDD VSS FILLER1
X_20007_ _20007_/CK _20007_/D _20007_/Q VDD VSS DFFQX1
X_09818_ _20081_/Q _09818_/B _09818_/C _18275_/Q _09818_/E VDD VSS _09819_/C AOI221X1
XFILLER_100_151 VDD VSS FILLER4
XFILLER_101_674 VDD VSS DECAPHV8
XFILLER_74_514 VDD VSS FILLER4
XFILLER_47_739 VDD VSS FILLER4
XFILLER_74_525 VSS VDD FILLER2
XFILLER_36_10 VSS VDD FILLER2
X_09749_ _20174_/A _09784_/C _09797_/C _20223_/A VDD VSS _09751_/C AOI22X1
XFILLER_74_558 VSS VDD FILLER2
XTAP_TAPCELL_ROW_109_993 VDD VSS WELLTAP
XFILLER_55_761 VSS VDD FILLER2
XFILLER_27_463 VSS VDD FILLER2
X_12760_ _12835_/A _14506_/B _12835_/D _12760_/D VDD VSS _12968_/A OAOI211X1
XTAP_TAPCELL_ROW_44_406 VDD VSS WELLTAP
XFILLER_61_219 VDD VSS FILLER1
XFILLER_54_260 VSS VDD FILLER2
XFILLER_70_720 VDD VSS FILLER1
XFILLER_42_411 VDD VSS FILLER4
XFILLER_14_113 VDD VSS FILLER4
X_11711_ _19198_/Q _11739_/B _11714_/C VDD VSS _14455_/B XNOR3X1
XFILLER_70_742 VDD VSS FILLER4
XFILLER_54_293 VSS VDD FILLER2
X_12691_ _12892_/A _12868_/A _12709_/C VDD VSS _12896_/D XNOR3X1
XTAP_TAPCELL_ROW_142_1288 VDD VSS WELLTAP
X_14430_ _14467_/A _14430_/B VDD VSS _19147_/D AND2X1
XFILLER_52_20 VDD VSS FILLER1
X_11642_ _18783_/Q _11647_/B VDD VSS _18810_/D AND2X1
XFILLER_70_797 VSS VDD FILLER2
XFILLER_52_53 VSS VDD FILLER2
XFILLER_30_639 VDD VSS FILLER4
XFILLER_23_680 VDD VSS DECAPHV8
XTAP_TAPCELL_ROW_52_483 VDD VSS WELLTAP
XFILLER_139_0 VSS VDD FILLER2
X_14361_ _14368_/A _14361_/B VDD VSS _19085_/D NOR2X1
X_11573_ _18720_/Q _11578_/B VDD VSS _18747_/D AND2X1
XFILLER_52_97 VDD VSS FILLER4
XFILLER_155_302 VDD VSS FILLER1
XFILLER_128_527 VSS VDD FILLER2
X_16100_ _16100_/A _16100_/B VDD VSS _19522_/D NOR2X1
X_13312_ _14324_/B _13416_/C _19053_/Q VDD VSS _13406_/C AND3BX1
X_17080_ _17095_/A _17080_/B VDD VSS _19769_/D NOR2X1
X_10524_ _18690_/Q _18744_/Q VDD VSS _10525_/D NAND2X1
X_14292_ _14311_/A _14292_/B VDD VSS _19025_/D NOR2X1
XFILLER_6_323 VSS VDD FILLER2
XFILLER_155_346 VSS VDD FILLER2
X_16031_ _19647_/Q _16031_/B _16804_/B VDD VSS _16057_/A MIN3X1
X_13243_ _14541_/B _14541_/C _13244_/A VDD VSS _13444_/B OAI21X1
XFILLER_124_700 VSS VDD FILLER2
X_10455_ _10521_/B _10455_/B _10721_/D VDD VSS _10462_/C OR3BX1
XFILLER_123_210 VSS VDD FILLER2
XFILLER_124_744 VSS VDD FILLER2
X_13174_ _13290_/A _13290_/B VDD VSS _14157_/B XNOR2X1
X_10386_ _10512_/A _10435_/A _10435_/B _10386_/D VDD VSS _10701_/C OAI31X1
XFILLER_163_390 VDD VSS FILLER4
X_12125_ _12132_/A _12132_/B _14242_/B VDD VSS _14207_/B XNOR3X1
XFILLER_124_788 VSS VDD FILLER2
X_17982_ _18872_/Q _17982_/B VDD VSS _17989_/A XOR2X1
XFILLER_123_298 VDD VSS DECAPHV8
X_19721_ _19722_/CK _19721_/D _19721_/Q VDD VSS DFFQX1
XFILLER_111_449 VDD VSS DECAPHV8
X_16933_ _19741_/Q wire164/Y _16933_/C VDD VSS _16937_/B MIN3X1
X_12056_ _12108_/A _12108_/B VDD VSS _12101_/C NOR2X1
XFILLER_77_83 VSS VDD FILLER2
XFILLER_77_352 VDD VSS FILLER1
XFILLER_38_706 VDD VSS FILLER4
X_11007_ _11007_/A _11007_/B _11007_/C VDD VSS _11009_/B AO21X2
XFILLER_38_717 VSS VDD FILLER2
X_19652_ _19696_/CK _19652_/D _19652_/Q VDD VSS DFFQX1
X_16864_ _16899_/A _16864_/B VDD VSS _19702_/D AND2X1
XFILLER_93_834 VSS VDD FILLER2
XFILLER_77_385 VDD VSS FILLER4
X_18603_ _18612_/CK _18603_/D _18603_/Q VDD VSS DFFQX1
XFILLER_92_322 VSS VDD FILLER2
X_15815_ _15816_/A _15815_/B VDD VSS _19431_/D NOR2X1
X_16795_ _16795_/A VDD VSS _16843_/A BUFX3
X_19583_ _19636_/CK _19583_/D _19583_/Q VDD VSS DFFQX1
XFILLER_92_344 VDD VSS FILLER1
X_15746_ _15770_/A _15746_/B VDD VSS _19369_/D AND2X1
X_18534_ _18543_/CK _18534_/D _18534_/Q VDD VSS DFFQX1
XTAP_TAPCELL_ROW_164_1491 VDD VSS WELLTAP
X_12958_ _20010_/Q _19274_/Q VDD VSS _13255_/A OR2X2
XFILLER_92_388 VDD VSS FILLER1
XFILLER_18_474 VDD VSS FILLER4
XFILLER_45_271 VSS VDD FILLER2
XFILLER_73_591 VSS VDD FILLER2
XFILLER_45_282 VDD VSS FILLER4
X_11909_ _19092_/Q _11909_/B _11958_/C VDD VSS _12023_/B MIN3X1
XFILLER_61_742 VSS VDD FILLER2
X_15677_ _15706_/A _15677_/B VDD VSS _19307_/D AND2X1
X_18465_ _18469_/CK _18497_/D _18465_/Q _20075_/RB VDD VSS DFFRQX1
XFILLER_60_230 VSS VDD FILLER2
X_12889_ _13004_/B _12890_/C _18965_/Q VDD VSS _12891_/B AOI21X1
XFILLER_21_606 VDD VSS FILLER4
XFILLER_21_617 VSS VDD FILLER2
X_17416_ _17417_/C _17416_/B _17416_/C VDD VSS _19841_/D AOI21X1
X_14628_ _14676_/A _14652_/B VDD VSS _14658_/B XNOR2X1
X_18396_ _18407_/CK _18513_/Q _20137_/A _09380_/B VDD VSS DFFRQX1
XTAP_TAPCELL_ROW_15_152 VDD VSS WELLTAP
XFILLER_21_639 VSS VDD FILLER2
X_17347_ _17348_/C _17469_/B _17347_/C VDD VSS _19826_/D AND3BX1
XFILLER_20_138 VDD VSS FILLER1
X_14559_ _16273_/A VDD VSS _14569_/B BUFX3
XFILLER_159_674 VSS VDD FILLER2
XFILLER_158_151 VSS VDD FILLER2
XFILLER_147_836 VDD VSS FILLER1
XFILLER_146_324 VDD VSS FILLER1
XFILLER_158_184 VDD VSS FILLER4
X_17278_ _17281_/A _17281_/B _17306_/C VDD VSS _17279_/C OAI21X1
XFILLER_9_194 VSS VDD FILLER2
XFILLER_134_508 VSS VDD FILLER2
X_16229_ _19655_/Q _16229_/B _16813_/B VDD VSS _16243_/A MIN3X1
X_19017_ _19044_/CK _19017_/D _19017_/Q VDD VSS DFFQX1
XFILLER_162_839 VDD VSS FILLER1
XFILLER_54_0 VDD VSS FILLER1
XFILLER_127_593 VSS VDD FILLER2
XFILLER_115_766 VSS VDD FILLER2
XFILLER_114_265 VDD VSS FILLER1
XFILLER_102_416 VSS VDD FILLER2
XFILLER_87_105 VSS VDD FILLER2
XFILLER_87_116 VDD VSS FILLER1
X_19919_ clkload8/A _19919_/D _19919_/Q VDD VSS DFFQX1
XFILLER_69_842 VDD VSS FILLER1
XTAP_TAPCELL_ROW_130_1181 VDD VSS WELLTAP
XFILLER_56_514 VDD VSS FILLER4
XFILLER_3_91 VSS VDD FILLER2
X_09603_ _18346_/Q VDD VSS _20214_/A INVX1
XFILLER_84_856 VDD VSS FILLER1
XTAP_TAPCELL_ROW_94_862 VDD VSS WELLTAP
X_09534_ _20029_/Q _18199_/A VDD VSS _20030_/D NOR2BX1
XFILLER_71_517 VDD VSS FILLER4
XFILLER_71_539 VDD VSS FILLER1
XFILLER_36_260 VDD VSS FILLER4
XTAP_TAPCELL_ROW_106_963 VDD VSS WELLTAP
X_09465_ _19972_/Q _09467_/B _09476_/C VDD VSS _09466_/C AOI21X1
XFILLER_52_775 VDD VSS FILLER4
XFILLER_51_252 VSS VDD FILLER2
XFILLER_12_617 VDD VSS FILLER4
X_09396_ _18623_/Q _11433_/B wire167/Y VDD VSS _11273_/A OAI21X1
XFILLER_138_803 VDD VSS FILLER4
XFILLER_11_149 VSS VDD FILLER2
XFILLER_22_23 VSS VDD FILLER2
XFILLER_149_184 VSS VDD FILLER2
XFILLER_20_683 VDD VSS DECAPHV8
XFILLER_138_34 VSS VDD FILLER2
XTAP_TAPCELL_ROW_21_199 VDD VSS WELLTAP
XFILLER_165_688 VDD VSS FILLER4
XFILLER_106_700 VSS VDD FILLER2
XFILLER_3_304 VSS VDD FILLER2
XFILLER_164_176 VDD VSS FILLER4
XFILLER_98_49 VSS VDD FILLER2
X_10240_ _18624_/Q _10247_/A _10240_/C _10240_/D VDD VSS _10358_/B AOI211X1
XFILLER_3_326 VDD VSS FILLER4
XFILLER_3_337 VDD VSS FILLER4
XFILLER_161_850 VDD VSS FILLER4
XFILLER_106_766 VSS VDD FILLER2
XFILLER_79_606 VSS VDD FILLER2
X_10171_ _18006_/C VDD VSS _16273_/A BUFX3
XFILLER_79_617 VSS VDD FILLER2
XFILLER_121_747 VDD VSS FILLER4
XFILLER_120_235 VSS VDD FILLER2
XFILLER_121_769 VDD VSS FILLER4
XFILLER_120_257 VSS VDD FILLER2
XFILLER_87_650 VDD VSS FILLER1
X_13930_ _18893_/Q VDD VSS _13977_/A INVX1
XFILLER_120_279 VDD VSS FILLER1
XFILLER_47_514 VDD VSS FILLER4
XFILLER_47_31 VSS VDD FILLER2
Xfanout195 _18508_/Q VDD VSS _09773_/D BUFX3
XFILLER_75_834 VSS VDD FILLER2
XFILLER_101_482 VSS VDD FILLER2
XTAP_TAPCELL_ROW_144_1306 VDD VSS WELLTAP
XFILLER_74_322 VSS VDD FILLER2
X_13861_ _19060_/Q _13910_/A _13910_/B VDD VSS _13901_/D XNOR3X1
XFILLER_19_249 VSS VDD FILLER2
X_15600_ _19466_/Q _15855_/B VDD VSS _15601_/C NOR2BX1
X_12812_ _12916_/A _12916_/B _12916_/D VDD VSS _12865_/B AOI21X1
X_16580_ _16597_/B _16580_/B VDD VSS _16828_/B XNOR2X1
XFILLER_74_388 VDD VSS FILLER4
X_13792_ _19114_/Q _14392_/A _14392_/B VDD VSS _13857_/B NOR3X1
XTAP_TAPCELL_ROW_29_277 VDD VSS WELLTAP
XFILLER_27_282 VDD VSS FILLER4
X_15531_ _19324_/Q _15696_/B VDD VSS _15535_/B XOR2X1
XFILLER_43_742 VSS VDD FILLER2
X_12743_ _12910_/A _12910_/B _12910_/C VDD VSS _12775_/B AOI21X1
XFILLER_42_230 VSS VDD FILLER2
X_18250_ _18257_/CK _18250_/D _18267_/D _18469_/RB VDD VSS DFFRQX1
X_15462_ _15457_/A _15462_/B _15462_/C VDD VSS _15495_/A AOI2B1X1
XFILLER_42_263 VSS VDD FILLER2
X_12674_ _12763_/A _12763_/B _12763_/D VDD VSS _12675_/C OAI21X1
XFILLER_63_96 VDD VSS DECAPHV8
XFILLER_43_797 VDD VSS FILLER4
XFILLER_42_285 VSS VDD FILLER2
XFILLER_30_425 VSS VDD FILLER2
X_17201_ _17204_/C _17202_/B _17229_/C VDD VSS _17202_/C OAI21X1
X_14413_ _14449_/A _14413_/B _14413_/C VDD VSS _19133_/D NOR3X1
X_18181_ _19302_/Q _18181_/B VDD VSS _18185_/B OR2X2
X_11625_ _11648_/A VDD VSS _11635_/B BUFX3
X_15393_ _15393_/A _15393_/B VDD VSS _15394_/C NAND2X1
XTAP_TAPCELL_ROW_12_122 VDD VSS WELLTAP
XFILLER_11_661 VDD VSS DECAPHV16
XFILLER_129_847 VDD VSS DECAPHV8
X_17132_ _17132_/A _17132_/B _17132_/C VDD VSS _17140_/A OA21X2
XFILLER_8_69 VSS VDD FILLER2
X_14344_ _14368_/A _14344_/B VDD VSS _19071_/D NOR2X1
X_11556_ _11556_/A _11641_/B VDD VSS _18732_/D NOR2X1
XFILLER_11_694 VSS VDD FILLER2
XFILLER_7_643 VDD VSS DECAPHV8
XFILLER_128_368 VDD VSS FILLER4
XFILLER_7_654 VSS VDD FILLER2
XFILLER_156_677 VSS VDD FILLER2
XFILLER_155_143 VSS VDD FILLER2
XFILLER_144_828 VSS VDD FILLER2
X_17063_ _19766_/Q _17073_/B VDD VSS _17066_/C XNOR2X1
X_10507_ _18557_/Q _10507_/B VDD VSS _10544_/B OR2X2
XFILLER_6_142 VDD VSS FILLER4
X_14275_ _14275_/A _14275_/B VDD VSS _14276_/B XNOR2X1
XFILLER_144_839 VDD VSS FILLER1
X_11487_ _18642_/Q _11496_/B VDD VSS _18669_/D AND2X1
X_16014_ _16872_/B VDD VSS _16024_/B INVX1
XFILLER_109_593 VSS VDD FILLER2
X_13226_ _13355_/A _13331_/A _13443_/B VDD VSS _13316_/C XNOR3X1
X_10438_ _10476_/A _10476_/B _10476_/D _10476_/C VDD VSS _10443_/B OAI211X1
XFILLER_6_197 VSS VDD FILLER2
XFILLER_124_552 VSS VDD FILLER2
XFILLER_97_403 VSS VDD FILLER2
X_13157_ _13230_/A _13157_/B _13315_/D VDD VSS _13231_/C XNOR3X1
XTAP_TAPCELL_ROW_110_1007 VDD VSS WELLTAP
XFILLER_151_360 VDD VSS FILLER1
X_10369_ _18633_/Q _18795_/Q VDD VSS _10402_/C XOR2X1
X_12108_ _12108_/A _12108_/B _12108_/C _12108_/D VDD VSS _12236_/A OAOI211X2
X_17965_ _17966_/A _17966_/B _17966_/D _17966_/C VDD VSS _17976_/B OAOI211X1
X_13088_ _13097_/A _13097_/B _13097_/C VDD VSS _14257_/C OR3X2
XFILLER_78_650 VDD VSS FILLER4
XTAP_TAPCELL_ROW_166_1520 VDD VSS WELLTAP
XFILLER_26_4 VSS VDD FILLER2
X_19704_ _19705_/CK _19704_/D _19704_/Q VDD VSS DFFQX1
X_16916_ _17011_/B VDD VSS _17047_/B BUFX3
X_12039_ _19178_/Q _12113_/A _12113_/B VDD VSS _12040_/D XNOR3X1
XFILLER_66_823 VSS VDD FILLER2
XFILLER_38_514 VSS VDD FILLER2
X_17896_ _18857_/Q _17901_/B VDD VSS _17898_/C OR2X2
XFILLER_65_311 VSS VDD FILLER2
XFILLER_93_631 VSS VDD FILLER2
XFILLER_77_182 VDD VSS FILLER4
XFILLER_66_856 VDD VSS FILLER1
X_19635_ _19636_/CK _19635_/D _19635_/Q VDD VSS DFFQX1
XFILLER_77_193 VDD VSS FILLER1
XFILLER_65_333 VDD VSS FILLER4
X_16847_ _16859_/A _16847_/B VDD VSS _19686_/D AND2X1
XFILLER_81_804 VDD VSS FILLER4
XFILLER_65_377 VDD VSS FILLER1
X_19566_ _19600_/CK _19566_/D _19566_/Q VDD VSS DFFQX1
XFILLER_80_314 VDD VSS FILLER4
XFILLER_25_219 VSS VDD FILLER2
X_16778_ _16793_/A _16778_/B VDD VSS _19624_/D AND2X1
XFILLER_92_185 VDD VSS FILLER4
XTAP_TAPCELL_ROW_91_832 VDD VSS WELLTAP
XFILLER_18_282 VSS VDD FILLER2
X_18517_ _18517_/CK _18517_/D _18517_/Q _09325_/Y VDD VSS DFFRQX1
XTAP_TAPCELL_ROW_121_1103 VDD VSS WELLTAP
X_15729_ _15743_/A _15729_/B VDD VSS _19354_/D AND2X1
X_19497_ _19531_/CK _19497_/D _19497_/Q VDD VSS DFFQX1
XFILLER_80_369 VDD VSS FILLER4
XTAP_TAPCELL_ROW_63_578 VDD VSS WELLTAP
XTAP_TAPCELL_ROW_103_944 VDD VSS WELLTAP
XFILLER_61_561 VSS VDD FILLER2
X_09250_ _20045_/RB _09362_/B VDD VSS _09250_/Y NOR2BX1
X_18448_ _18455_/CK _18448_/D _18448_/Q _18469_/RB VDD VSS DFFRQX1
XFILLER_33_274 VDD VSS FILLER4
XFILLER_166_408 VDD VSS DECAPHV8
X_18379_ _18389_/CK _18512_/Q _20184_/A _20065_/RB VDD VSS DFFRQX1
XFILLER_159_482 VDD VSS FILLER1
XFILLER_119_357 VDD VSS DECAPHV8
XFILLER_135_817 VSS VDD FILLER2
XFILLER_162_614 VDD VSS FILLER4
XTAP_TAPCELL_ROW_119_1087 VDD VSS WELLTAP
XFILLER_150_809 VSS VDD FILLER2
XFILLER_103_725 VDD VSS DECAPHV8
XFILLER_130_500 VSS VDD FILLER2
XFILLER_142_360 VSS VDD FILLER2
XFILLER_0_318 VSS VDD FILLER2
XFILLER_115_585 VSS VDD FILLER2
XFILLER_88_425 VDD VSS FILLER1
XFILLER_0_329 VSS VDD FILLER2
XFILLER_130_522 VSS VDD FILLER2
XFILLER_103_747 VSS VDD FILLER2
XFILLER_88_447 VDD VSS FILLER4
XFILLER_102_235 VSS VDD FILLER2
XFILLER_130_544 VSS VDD FILLER2
XFILLER_102_257 VSS VDD FILLER2
XFILLER_102_268 VDD VSS FILLER1
XFILLER_124_36 VDD VSS FILLER1
XFILLER_56_300 VSS VDD FILLER2
XFILLER_124_58 VSS VDD FILLER2
XFILLER_84_620 VSS VDD FILLER2
XFILLER_29_536 VDD VSS DECAPHV8
XFILLER_68_182 VSS VDD FILLER2
XFILLER_56_322 VSS VDD FILLER2
XFILLER_56_355 VSS VDD FILLER2
XFILLER_17_709 VSS VDD FILLER2
XFILLER_72_826 VDD VSS DECAPHV8
XFILLER_140_13 VDD VSS FILLER4
XTAP_TAPCELL_ROW_54_501 VDD VSS WELLTAP
XFILLER_71_336 VSS VDD FILLER2
XFILLER_37_591 VDD VSS FILLER4
X_09517_ _20017_/Q _18197_/D VDD VSS _20017_/D NOR2X1
XFILLER_25_742 VSS VDD FILLER2
XFILLER_140_68 VSS VDD FILLER2
XTAP_TAPCELL_ROW_26_247 VDD VSS WELLTAP
XFILLER_24_230 VSS VDD FILLER2
XFILLER_40_712 VSS VDD FILLER2
X_09448_ _18386_/Q VDD VSS _20191_/A INVX1
XFILLER_12_436 VDD VSS FILLER1
XFILLER_24_296 VDD VSS FILLER4
XFILLER_157_419 VSS VDD FILLER2
X_09379_ _18526_/Q _09818_/B VDD VSS _18224_/E AND2X1
XFILLER_40_778 VSS VDD FILLER2
XFILLER_130_4 VDD VSS FILLER4
XFILLER_40_789 VDD VSS FILLER1
XFILLER_33_88 VDD VSS FILLER4
X_11410_ _11422_/A _17990_/B _11410_/C VDD VSS _18604_/D NOR3X1
XTAP_TAPCELL_ROW_4_48 VDD VSS WELLTAP
XFILLER_149_66 VDD VSS FILLER4
XFILLER_137_121 VDD VSS FILLER4
X_12390_ _12391_/A _12391_/B _12391_/D _12391_/C VDD VSS _14503_/C AOI211X1
XFILLER_165_441 VSS VDD FILLER2
XFILLER_153_603 VDD VSS DECAPHV8
X_11341_ _11370_/A _11341_/B _11370_/C VDD VSS _11343_/B OAI21X1
XFILLER_4_602 VSS VDD FILLER2
XFILLER_165_10 VSS VDD FILLER2
XFILLER_125_338 VDD VSS FILLER4
X_14060_ _17959_/A _17959_/B _17960_/C _14060_/D VDD VSS _14093_/A OAOI211X1
XFILLER_118_390 VDD VSS FILLER4
X_11272_ _11272_/A _11272_/B VDD VSS _18581_/D NOR2X1
X_13011_ _13021_/A _13021_/B _13091_/C VDD VSS _14320_/B OA21X2
X_10223_ _10224_/A _10224_/B _10224_/C _18621_/Q VDD VSS _10229_/C AOAI211X1
XFILLER_165_76 VDD VSS FILLER4
XTAP_TAPCELL_ROW_150_1365 VDD VSS WELLTAP
XFILLER_121_511 VDD VSS DECAPHV8
XFILLER_133_371 VDD VSS FILLER1
XFILLER_3_178 VSS VDD FILLER2
XFILLER_3_189 VDD VSS FILLER4
XFILLER_133_393 VSS VDD FILLER2
XFILLER_79_447 VSS VDD FILLER2
XFILLER_121_544 VDD VSS FILLER1
X_10154_ _10155_/A _10154_/B _10154_/C VDD VSS _10155_/C NOR3X1
XFILLER_121_588 VSS VDD FILLER2
X_14962_ wire162/Y _15000_/B _15000_/D VDD VSS _14975_/B OAI21X1
X_17750_ _17838_/A VDD VSS _17828_/C BUFX3
XFILLER_58_85 VSS VDD FILLER2
XFILLER_121_599 VSS VDD FILLER2
X_10085_ _18607_/Q _10098_/B VDD VSS _10086_/B XNOR2X1
XFILLER_47_300 VSS VDD FILLER2
X_16701_ _16701_/A _16704_/B VDD VSS _19555_/D NOR2X1
XFILLER_47_333 VSS VDD FILLER2
X_13913_ _13965_/A _13965_/C VDD VSS _13914_/C NAND2X1
XFILLER_47_344 VDD VSS FILLER1
X_14893_ _14901_/B _14893_/B VDD VSS _15680_/B XNOR2X1
X_17681_ _17806_/A _17681_/B VDD VSS _19897_/D NOR2X1
XFILLER_63_804 VSS VDD FILLER2
XFILLER_114_80 VSS VDD FILLER2
XFILLER_90_601 VSS VDD FILLER2
XFILLER_74_152 VSS VDD FILLER2
X_19420_ _19466_/CK _19420_/D _19420_/Q VDD VSS DFFQX1
XFILLER_63_826 VSS VDD FILLER2
XFILLER_35_517 VSS VDD FILLER2
X_16632_ _16657_/B _16632_/B VDD VSS _16793_/B NOR2BX1
X_13844_ _13903_/B _14265_/C _19003_/Q VDD VSS _13845_/D AND3BX1
XFILLER_75_697 VDD VSS FILLER4
XFILLER_35_539 VDD VSS FILLER1
XFILLER_90_634 VDD VSS FILLER4
XFILLER_47_399 VSS VDD FILLER2
XTAP_TAPCELL_ROW_161_1461 VDD VSS WELLTAP
XFILLER_62_347 VSS VDD FILLER2
X_19351_ _19379_/CK _19351_/D _19351_/Q VDD VSS DFFQX1
X_16563_ _19732_/Q _16897_/B VDD VSS _16564_/B XOR2X1
X_13775_ _13783_/A _14297_/B _13783_/C VDD VSS _14298_/B OA21X2
X_10987_ _11364_/A _10987_/B VDD VSS _10988_/C NAND2X1
XFILLER_16_764 VDD VSS FILLER4
XFILLER_43_561 VSS VDD FILLER2
XFILLER_15_252 VDD VSS FILLER1
X_18302_ _18311_/CK _18494_/D _18302_/Q _18471_/RB VDD VSS DFFRQX1
X_15514_ _19518_/Q _15514_/B _15514_/C VDD VSS _15515_/C MIN3X1
X_12726_ _19103_/Q VDD VSS _12809_/A INVX1
X_16494_ _16494_/A _16494_/B _16494_/C VDD VSS _16518_/B AOI21X1
X_19282_ _19314_/CK _19282_/D _19282_/Q VDD VSS DFFQX1
Xclkbuf_2_1__f__000_ clkbuf_0__000_/Y VDD VSS clkload70/A BUFX12
XFILLER_148_408 VDD VSS FILLER1
XTAP_TAPCELL_ROW_100_914 VDD VSS WELLTAP
X_15445_ _15469_/A _15468_/A VDD VSS _15446_/B XNOR2X1
X_18233_ _18234_/CK _18233_/E _18233_/ECK VDD VSS CGX3
Xclkbuf_leaf_1__000_ clkbuf_leaf_6__000_/A VDD VSS _19508_/CK BUFX12
X_12657_ _12748_/A _14409_/B VDD VSS _12813_/B NOR2X1
XFILLER_88_6 VDD VSS FILLER1
XFILLER_31_778 VSS VDD FILLER2
XFILLER_129_622 VSS VDD FILLER2
XFILLER_90_94 VDD VSS FILLER1
X_11608_ _18752_/Q _11612_/B VDD VSS _18779_/D AND2X1
X_15376_ _15376_/A _15376_/B _15376_/C VDD VSS _15377_/B NOR3X1
X_18164_ _19298_/Q _18164_/B VDD VSS _18167_/A NOR2BX1
X_12588_ _19214_/Q _12648_/B _12837_/C VDD VSS _12658_/C XNOR3X1
XFILLER_156_441 VDD VSS FILLER1
XFILLER_129_666 VDD VSS FILLER1
XFILLER_128_154 VDD VSS FILLER4
X_17115_ _19777_/Q _19745_/Q VDD VSS _17117_/B XOR2X1
X_14327_ _14352_/A _14327_/B _14327_/C VDD VSS _19056_/D NOR3X1
XFILLER_116_305 VSS VDD FILLER2
X_18095_ _18095_/A _18095_/B VDD VSS _18096_/B NAND2X1
X_11539_ _18690_/Q _11542_/B VDD VSS _18717_/D AND2X1
XFILLER_144_625 VDD VSS FILLER1
XFILLER_156_496 VDD VSS FILLER1
X_17046_ _17536_/A _17046_/B _17064_/A VDD VSS _19762_/D NOR3X1
X_14258_ _14270_/A _14258_/B VDD VSS _18996_/D AND2X1
X_13209_ _19024_/Q _14291_/B VDD VSS _13373_/E _14291_/C NAND3X1
XFILLER_98_712 VSS VDD FILLER2
XFILLER_124_360 VSS VDD FILLER2
XFILLER_131_319 VDD VSS FILLER4
X_14189_ _14218_/A _14189_/B VDD VSS _18939_/D NOR2X1
XFILLER_124_382 VDD VSS FILLER1
XFILLER_97_222 VSS VDD FILLER2
XFILLER_112_544 VSS VDD FILLER2
X_18997_ _18997_/CK _18997_/D _18997_/Q VDD VSS DFFQX1
XFILLER_98_789 VDD VSS FILLER1
XFILLER_100_739 VSS VDD FILLER2
X_17948_ _17948_/A _17948_/B _17948_/C _17948_/D VDD VSS _19956_/D AOI31X1
XTAP_TAPCELL_ROW_68_626 VDD VSS WELLTAP
XFILLER_78_480 VSS VDD FILLER2
XFILLER_17_0 VSS VDD FILLER2
XFILLER_66_653 VSS VDD FILLER2
X_17879_ _17880_/C _17879_/B _17879_/C VDD VSS _19943_/D AOI21X1
XFILLER_65_152 VSS VDD FILLER2
X_19618_ _19667_/CK _19618_/D _19618_/Q VDD VSS DFFQX1
XFILLER_93_472 VSS VDD FILLER2
XFILLER_65_185 VDD VSS FILLER1
XFILLER_65_196 VSS VDD FILLER2
XFILLER_80_133 VDD VSS FILLER4
X_19549_ _19602_/CK _19549_/D _19549_/Q VDD VSS DFFQX1
X_09302_ _09302_/A VDD VSS _09302_/Y BUFX3
XTAP_TAPCELL_ROW_23_217 VDD VSS WELLTAP
XFILLER_110_49 VSS VDD FILLER2
XFILLER_21_222 VDD VSS FILLER1
X_09233_ _18496_/D VDD VSS _18352_/D INVX1
XFILLER_22_756 VDD VSS FILLER1
XFILLER_21_233 VDD VSS FILLER1
XFILLER_21_277 VSS VDD FILLER2
XFILLER_147_430 VSS VDD FILLER2
XFILLER_147_463 VSS VDD FILLER2
XTAP_TAPCELL_ROW_31_294 VDD VSS WELLTAP
XFILLER_119_176 VDD VSS FILLER4
XFILLER_162_411 VDD VSS FILLER1
XFILLER_79_18 VSS VDD FILLER2
XFILLER_102_8 VDD VSS FILLER1
XFILLER_89_723 VDD VSS FILLER4
XFILLER_103_511 VSS VDD FILLER2
XFILLER_135_35 VSS VDD FILLER2
XFILLER_1_649 VSS VDD FILLER2
XFILLER_142_190 VDD VSS FILLER1
X_20186_ _20186_/A VDD VSS _20186_/Y BUFX3
X_09997_ _17906_/C _09997_/B _09998_/C VDD VSS _18528_/D NOR3X1
XFILLER_95_17 VDD VSS FILLER1
XFILLER_130_352 VSS VDD FILLER2
XFILLER_88_266 VSS VDD FILLER2
XFILLER_130_363 VDD VSS FILLER1
XFILLER_103_588 VSS VDD FILLER2
XFILLER_103_599 VDD VSS FILLER1
XFILLER_88_288 VDD VSS FILLER4
XFILLER_76_428 VDD VSS DECAPHV8
XFILLER_28_11 VDD VSS FILLER4
XFILLER_69_491 VDD VSS FILLER1
XFILLER_28_44 VSS VDD FILLER2
XFILLER_151_56 VDD VSS FILLER4
XFILLER_72_601 VSS VDD FILLER2
XFILLER_56_152 VSS VDD FILLER2
X_10910_ _10965_/A _18728_/Q _10910_/C _10910_/D VDD VSS _10910_/Y AO211X2
XTAP_TAPCELL_ROW_39_361 VDD VSS WELLTAP
XFILLER_151_78 VDD VSS FILLER4
X_11890_ _19204_/Q _12048_/A _12048_/B VDD VSS _11918_/C XNOR3X1
XFILLER_72_634 VDD VSS FILLER4
XFILLER_17_539 VSS VDD FILLER2
X_10841_ _10774_/Y _10840_/Y _10947_/A VDD VSS _10841_/Y MUX2X1
XFILLER_60_818 VSS VDD FILLER2
XFILLER_71_155 VDD VSS FILLER4
XFILLER_25_561 VSS VDD FILLER2
XFILLER_71_177 VSS VDD FILLER2
XFILLER_13_723 VSS VDD FILLER2
X_13560_ _13637_/A _13637_/B _13637_/C VDD VSS _13561_/C AO21X2
X_10772_ _11039_/C _10772_/B _10772_/C _10772_/D VDD VSS _10773_/B AOI211X1
XFILLER_71_199 VSS VDD FILLER2
XFILLER_12_211 VDD VSS FILLER1
X_12511_ _19042_/Q VDD VSS _14278_/A INVX1
XFILLER_12_244 VSS VDD FILLER2
X_13491_ _18915_/Q _13656_/A _13656_/B VDD VSS _13502_/D XNOR3X1
XFILLER_40_575 VSS VDD FILLER2
X_15230_ _15193_/B _15275_/C _15275_/A VDD VSS _15232_/B AND3BX1
XFILLER_40_586 VDD VSS FILLER1
X_12442_ _19016_/Q _12442_/B _14282_/B VDD VSS _12894_/A MIN3X1
XFILLER_12_299 VSS VDD FILLER2
XFILLER_121_0 VSS VDD FILLER2
XFILLER_60_64 VDD VSS FILLER4
XFILLER_126_614 VSS VDD FILLER2
X_15161_ _15180_/B _15161_/B VDD VSS _15778_/B XOR2X1
XFILLER_138_474 VDD VSS FILLER4
XFILLER_153_400 VSS VDD FILLER2
X_12373_ _19154_/Q _12373_/B _12373_/C VDD VSS _12378_/B XNOR3X1
XFILLER_126_636 VSS VDD FILLER2
XFILLER_165_282 VSS VDD FILLER2
XFILLER_153_433 VSS VDD FILLER2
X_14112_ _14118_/A _17982_/B VDD VSS _18872_/D NOR2X1
X_11324_ _11364_/B _11325_/B _11325_/C _11325_/D VDD VSS _11333_/C OAI211X1
XFILLER_4_421 VSS VDD FILLER2
XFILLER_153_444 VSS VDD FILLER2
X_15092_ _15092_/A _15092_/B _15092_/C _15092_/D VDD VSS _15139_/B AOAI211X1
XFILLER_4_443 VSS VDD FILLER2
XFILLER_4_454 VSS VDD FILLER2
XFILLER_125_168 VSS VDD FILLER2
X_18920_ _18973_/CK _18920_/D _18920_/Q VDD VSS DFFQX1
X_14043_ _14043_/A _14043_/B VDD VSS _14235_/B XOR2X1
XFILLER_4_465 VSS VDD FILLER2
XFILLER_106_360 VSS VDD FILLER2
XFILLER_140_105 VDD VSS DECAPHV8
XFILLER_141_639 VDD VSS FILLER4
X_11255_ _11255_/A _11255_/B _11255_/C VDD VSS _11298_/B AOI21X1
XFILLER_79_211 VSS VDD FILLER2
X_10206_ _18619_/Q _10207_/B VDD VSS _10217_/C NOR2X1
X_18851_ _18889_/CK _18851_/D _18851_/Q VDD VSS DFFQX1
XFILLER_79_244 VSS VDD FILLER2
X_11186_ _11184_/Y _18576_/Q VDD VSS _11217_/C NAND2BX1
X_17802_ _17802_/A _17803_/C _17802_/C VDD VSS _19924_/D AOI21X1
X_10137_ _10180_/A _11417_/C VDD VSS _18539_/D NOR2X1
X_18782_ _18810_/CK _18782_/D _18782_/Q VDD VSS DFFQX1
X_15994_ _19902_/Q _19550_/Q VDD VSS _15995_/C NOR2BX1
XFILLER_94_247 VSS VDD FILLER2
XFILLER_48_642 VSS VDD FILLER2
X_17733_ _17738_/C _17738_/B VDD VSS _17735_/B NAND2BX1
X_14945_ _19338_/Q _15711_/B VDD VSS _14946_/B XOR2X1
X_10068_ _11302_/A _10068_/B VDD VSS _10068_/Y XNOR2X1
XFILLER_48_675 VDD VSS DECAPHV8
XFILLER_47_152 VDD VSS FILLER1
XFILLER_48_686 VSS VDD FILLER2
X_17664_ _17667_/A _17667_/B _17746_/C VDD VSS _17665_/C OAI21X1
X_14876_ _19529_/Q _19530_/Q _19531_/Q _14877_/C VDD VSS _15009_/C AND4X2
XFILLER_75_494 VSS VDD FILLER2
XFILLER_62_111 VDD VSS FILLER1
XFILLER_90_431 VDD VSS FILLER4
X_19403_ _19406_/CK _19403_/D _19403_/Q VDD VSS DFFQX1
X_16615_ _16616_/A _16616_/B _16616_/C VDD VSS _16617_/B NOR3X1
XFILLER_90_442 VSS VDD FILLER2
X_13827_ _13827_/A _13827_/B _13845_/C VDD VSS _13921_/B XNOR3X1
X_17595_ _19880_/Q _19848_/Q VDD VSS _17598_/A XNOR2X1
XFILLER_63_689 VSS VDD FILLER2
XTAP_TAPCELL_ROW_73_673 VDD VSS WELLTAP
X_19334_ _19349_/CK _19334_/D _19334_/Q VDD VSS DFFQX1
XFILLER_50_328 VSS VDD FILLER2
X_16546_ _19635_/Q _16546_/B _16789_/B VDD VSS _16571_/B MIN3X1
X_13758_ _18973_/Q _14228_/B VDD VSS _13816_/A NAND2X1
XFILLER_31_520 VSS VDD FILLER2
X_12709_ _19019_/Q _12868_/A _12709_/C VDD VSS _12717_/D XNOR3X1
XFILLER_148_205 VDD VSS FILLER4
X_19265_ _20007_/CK _19265_/D _19265_/Q VDD VSS DFFQX1
X_16477_ _19569_/Q _19921_/Q VDD VSS _16478_/B XNOR2X1
X_13689_ _13771_/A _14195_/B VDD VSS _13739_/B NOR2X1
XFILLER_31_586 VSS VDD FILLER2
X_18216_ _18223_/CK _18216_/E _18216_/ECK VDD VSS CGX3
X_15428_ _19433_/Q _15818_/B VDD VSS _15449_/A NOR2BX1
X_19196_ _19196_/CK _19196_/D _19196_/Q VDD VSS DFFQX1
XFILLER_163_208 VDD VSS FILLER1
X_15359_ _15359_/A _15359_/B _15359_/C _15359_/D VDD VSS _15398_/C OAOI211X1
X_18147_ _19296_/Q _18153_/B VDD VSS _18152_/A XOR2X1
XFILLER_8_782 VSS VDD FILLER2
XFILLER_129_496 VSS VDD FILLER2
XFILLER_117_647 VDD VSS FILLER4
XFILLER_8_793 VSS VDD FILLER2
XFILLER_7_270 VSS VDD FILLER2
XFILLER_117_658 VSS VDD FILLER2
XFILLER_144_455 VSS VDD FILLER2
X_18078_ _18076_/B _18078_/B _18078_/C VDD VSS _19990_/D AOI2B1X1
XTAP_TAPCELL_ROW_116_1057 VDD VSS WELLTAP
X_09920_ _09944_/A _09990_/B _09920_/C VDD VSS _10048_/B OAI21X1
X_17029_ _19760_/Q _17047_/B VDD VSS _17040_/A XOR2X1
Xhold259 hold262/Y VDD VSS hold263/A BUFX3
XFILLER_125_680 VDD VSS FILLER4
XFILLER_131_127 VDD VSS DECAPHV16
X_20040_ _20045_/CK _20040_/D _20040_/Q _20045_/RB VDD VSS DFFRQX1
X_09851_ _11435_/A _11435_/B _11438_/A VDD VSS _10268_/B OR3BX1
Xclkbuf_1_1__f__09174_ clkbuf_0__09174_/Y VDD VSS _18295_/CK BUFX12
XFILLER_112_363 VSS VDD FILLER2
XFILLER_100_514 VSS VDD FILLER2
X_09782_ _18309_/Q _09782_/B _09788_/B _20114_/A _09782_/E VDD VSS _09783_/C AOI221X1
XFILLER_66_450 VDD VSS FILLER1
XFILLER_27_804 VSS VDD FILLER2
XFILLER_39_675 VDD VSS FILLER4
XTAP_TAPCELL_ROW_127_1153 VDD VSS WELLTAP
XFILLER_38_174 VSS VDD FILLER2
XFILLER_54_645 VDD VSS FILLER4
XFILLER_38_196 VSS VDD FILLER2
XFILLER_121_26 VSS VDD FILLER2
XFILLER_93_291 VSS VDD FILLER2
XFILLER_81_431 VDD VSS FILLER1
XFILLER_81_442 VSS VDD FILLER2
XFILLER_14_509 VSS VDD FILLER2
XFILLER_81_464 VDD VSS FILLER1
XFILLER_53_155 VDD VSS FILLER1
XFILLER_121_59 VDD VSS FILLER4
XFILLER_157_9 VSS VDD FILLER2
XFILLER_139_227 VDD VSS FILLER4
XFILLER_139_238 VSS VDD FILLER2
X_09216_ _18522_/Q VDD VSS _18405_/D INVX1
XFILLER_10_748 VSS VDD FILLER2
XFILLER_6_708 VDD VSS FILLER4
XFILLER_5_218 VDD VSS FILLER1
XFILLER_107_102 VSS VDD FILLER2
XFILLER_135_411 VSS VDD FILLER2
XFILLER_30_23 VSS VDD FILLER2
XFILLER_147_282 VSS VDD FILLER2
XFILLER_108_647 VSS VDD FILLER2
XFILLER_135_433 VDD VSS DECAPHV16
XFILLER_30_45 VDD VSS FILLER1
XFILLER_162_230 VSS VDD FILLER2
XFILLER_163_797 VDD VSS FILLER4
XFILLER_150_425 VSS VDD FILLER2
XFILLER_146_89 VDD VSS FILLER1
XFILLER_150_447 VDD VSS DECAPHV8
X_11040_ _11070_/C _11040_/B _11040_/C VDD VSS _11041_/D AOI21X1
XFILLER_103_341 VSS VDD FILLER2
XFILLER_77_715 VSS VDD FILLER2
XFILLER_1_468 VSS VDD FILLER2
XFILLER_103_363 VSS VDD FILLER2
XFILLER_77_737 VDD VSS FILLER4
XFILLER_76_214 VSS VDD FILLER2
X_20169_ _20169_/A VDD VSS _20169_/Y BUFX3
XFILLER_162_44 VSS VDD FILLER2
Xclkbuf_leaf_0__001_ clkbuf_leaf_4__001_/A VDD VSS _20004_/CK BUFX12
XFILLER_130_193 VSS VDD FILLER2
XFILLER_76_247 VSS VDD FILLER2
XFILLER_39_98 VDD VSS FILLER1
X_12991_ _18966_/Q _13171_/A _14217_/B VDD VSS _14186_/B XOR3X1
XFILLER_18_804 VSS VDD FILLER2
XFILLER_57_461 VDD VSS FILLER4
XTAP_TAPCELL_ROW_87_798 VDD VSS WELLTAP
X_14730_ _14730_/A _14730_/B _15799_/B VDD VSS _14774_/B MIN3X1
X_11942_ _19063_/Q VDD VSS _11944_/A INVX1
XFILLER_85_792 VSS VDD FILLER2
XFILLER_55_53 VSS VDD FILLER2
XFILLER_29_196 VSS VDD FILLER2
X_14661_ _14701_/A _14701_/B _14673_/C VDD VSS _15797_/B XNOR3X1
XFILLER_72_453 VDD VSS FILLER1
X_11873_ _19175_/Q _14461_/B VDD VSS _12035_/A AND2X1
XFILLER_32_306 VSS VDD FILLER2
X_16400_ _19630_/Q _16784_/B VDD VSS _16402_/C XOR2X1
X_13612_ _13840_/A _13840_/B VDD VSS _13652_/B NOR2X1
XFILLER_60_626 VSS VDD FILLER2
X_10824_ _18698_/Q _18752_/Q _10804_/C VDD VSS _10861_/C AOI21BX1
XFILLER_72_497 VDD VSS FILLER4
XFILLER_32_328 VSS VDD FILLER2
X_17380_ _17390_/A _17380_/B VDD VSS _19833_/D NOR2X1
X_14592_ _19468_/Q _14616_/B _14595_/C VDD VSS _15825_/B XNOR3X1
XFILLER_13_531 VDD VSS FILLER4
XFILLER_41_840 VSS VDD FILLER2
XFILLER_25_391 VSS VDD FILLER2
XFILLER_13_542 VSS VDD FILLER2
XTAP_TAPCELL_ROW_70_643 VDD VSS WELLTAP
X_16331_ _19723_/Q _16887_/B VDD VSS _16332_/C NOR2X1
X_13543_ _19166_/Q _14451_/B _14451_/C VDD VSS _13546_/D OR3BX1
XFILLER_158_514 VSS VDD FILLER2
X_10755_ _10798_/D _10798_/B VDD VSS _10756_/B NAND2BX1
X_16262_ _16283_/B _16262_/B VDD VSS _16779_/B XNOR2X1
X_19050_ _19094_/CK _19050_/D _19050_/Q VDD VSS DFFQX1
XTAP_TAPCELL_ROW_42_389 VDD VSS WELLTAP
X_13474_ _19027_/Q _13599_/B _13599_/C VDD VSS _13683_/B XNOR3X1
X_10686_ _10722_/A _10686_/B _10686_/C _10686_/D VDD VSS _10696_/C OAI211X1
XFILLER_9_557 VDD VSS FILLER1
XFILLER_71_96 VSS VDD FILLER2
X_15213_ _19316_/Q _15687_/B VDD VSS _15214_/B XNOR2X1
X_18001_ _18544_/Q _18545_/Q VDD VSS _18052_/B _18048_/B AND3X2
X_12425_ _19016_/Q _12442_/B _14282_/B VDD VSS _14248_/B XNOR3X1
XFILLER_138_260 VDD VSS FILLER1
X_16193_ _19686_/Q _16847_/B VDD VSS _16194_/B XNOR2X1
X_15144_ _19508_/Q _15144_/B VDD VSS _15145_/D AND2X1
X_12356_ _18987_/Q _12356_/B _14247_/B VDD VSS _12441_/B MIN3X1
X_11307_ _11364_/A _11307_/B _11356_/C VDD VSS _11319_/A AOI21X1
X_15075_ _19341_/Q _15715_/B VDD VSS _15076_/B XNOR2X1
X_19952_ _19956_/CK _19952_/D _19952_/Q VDD VSS DFFQX1
XFILLER_141_425 VDD VSS DECAPHV8
X_12287_ _19040_/Q _14275_/A _12287_/C VDD VSS _12288_/C MIN3X1
X_18903_ _18905_/CK _18903_/D _18903_/Q VDD VSS DFFQX1
X_14026_ _18895_/Q _14138_/B VDD VSS _17959_/A AND2X1
X_11238_ _11249_/C _11239_/B _11386_/C VDD VSS _11239_/C OAI21X1
X_19883_ clkload9/A _19883_/D _19883_/Q VDD VSS DFFQX1
XFILLER_110_823 VDD VSS FILLER4
X_18834_ _19956_/CK _18834_/D _18834_/Q VDD VSS DFFQX1
XFILLER_68_737 VSS VDD FILLER2
XFILLER_67_214 VDD VSS FILLER4
XFILLER_110_834 VSS VDD FILLER2
X_11169_ _11195_/A _11169_/B _11169_/C _11169_/D VDD VSS _11179_/A AOI31X1
XFILLER_67_225 VSS VDD FILLER2
XFILLER_110_856 VDD VSS FILLER1
XFILLER_121_193 VSS VDD FILLER2
XFILLER_95_556 VSS VDD FILLER2
X_18765_ _18767_/CK _18765_/D _18765_/Q VDD VSS DFFQX1
X_15977_ _15977_/A _15977_/B VDD VSS _16835_/B XNOR2X1
XFILLER_36_601 VSS VDD FILLER2
XFILLER_48_472 VDD VSS FILLER4
X_17716_ _19905_/Q _19873_/Q _17716_/C VDD VSS _17719_/B MIN3X1
X_14928_ _15868_/B _14928_/B _14966_/C VDD VSS _15869_/B XNOR3X1
XFILLER_35_100 VSS VDD FILLER2
X_18696_ _19947_/CK _18696_/D _18696_/Q VDD VSS DFFQX1
XFILLER_35_122 VSS VDD FILLER2
X_17647_ _17648_/C _18127_/B _17647_/C VDD VSS _19890_/D AND3BX1
XFILLER_63_453 VSS VDD FILLER2
X_14859_ _19420_/Q VDD VSS _14861_/A INVX1
Xclkbuf_leaf_34__000_ clkbuf_leaf_6__000_/A VDD VSS _19466_/CK BUFX12
XFILLER_90_250 VSS VDD FILLER2
XFILLER_23_339 VSS VDD FILLER2
X_17578_ _17581_/A _17581_/B _17597_/C VDD VSS _17579_/C OAI21X1
XTAP_TAPCELL_ROW_33_312 VDD VSS WELLTAP
X_19317_ _19333_/CK _19317_/D _19317_/Q VDD VSS DFFQX1
XFILLER_32_851 VSS VDD FILLER2
X_16529_ _19603_/Q _16754_/B VDD VSS _16548_/B XOR2X1
X_19248_ _19250_/CK _19248_/D _19248_/Q VDD VSS DFFQX1
X_19179_ _19223_/CK _19179_/D _19179_/Q VDD VSS DFFQX1
XFILLER_129_282 VSS VDD FILLER2
XFILLER_117_433 VSS VDD FILLER2
XFILLER_117_444 VSS VDD FILLER2
XFILLER_144_230 VSS VDD FILLER2
XFILLER_132_414 VDD VSS FILLER4
XFILLER_104_127 VSS VDD FILLER2
XFILLER_99_840 VSS VDD FILLER2
XFILLER_132_447 VDD VSS DECAPHV8
XFILLER_104_149 VSS VDD FILLER2
X_09903_ _09940_/B _09902_/Y _09885_/A VDD VSS _10005_/B MUXI2X1
XFILLER_113_650 VDD VSS FILLER1
XFILLER_160_789 VDD VSS FILLER1
XFILLER_101_812 VDD VSS FILLER1
XFILLER_59_726 VDD VSS FILLER1
X_20023_ _20033_/CK _20023_/D _20023_/Q _20030_/RB VDD VSS DFFRQX1
X_09834_ _11435_/A _11435_/B _11196_/A VDD VSS _10258_/D NOR3BX1
XFILLER_86_534 VDD VSS FILLER1
XFILLER_59_759 VSS VDD FILLER2
XFILLER_101_856 VDD VSS FILLER1
X_09765_ _18404_/Q VDD VSS _20145_/A INVX1
XFILLER_100_377 VSS VDD FILLER2
XFILLER_39_472 VSS VDD FILLER2
XFILLER_26_100 VDD VSS FILLER1
X_09696_ _18431_/Q _09696_/B VDD VSS _09697_/E NOR2X1
XFILLER_73_239 VDD VSS FILLER1
XFILLER_27_645 VDD VSS FILLER4
XFILLER_82_740 VSS VDD FILLER2
XFILLER_54_431 VSS VDD FILLER2
XTAP_TAPCELL_ROW_84_768 VDD VSS WELLTAP
XFILLER_54_464 VDD VSS DECAPHV8
XFILLER_14_306 VSS VDD FILLER2
XFILLER_25_34 VSS VDD FILLER2
XFILLER_14_328 VDD VSS FILLER4
XFILLER_41_114 VSS VDD FILLER2
XFILLER_25_45 VSS VDD FILLER2
XFILLER_25_56 VSS VDD FILLER2
XFILLER_42_659 VSS VDD FILLER2
XFILLER_23_840 VSS VDD FILLER2
X_10540_ _10548_/A _10548_/B _10595_/A VDD VSS _10541_/B OAI21X1
XFILLER_41_11 VDD VSS FILLER4
XFILLER_10_556 VDD VSS FILLER1
XFILLER_41_55 VDD VSS DECAPHV8
XFILLER_157_22 VDD VSS FILLER4
X_10471_ _10472_/A _10472_/B _10472_/C _11378_/A VDD VSS _10471_/Y AOI31X1
XFILLER_157_33 VDD VSS FILLER4
XFILLER_6_538 VSS VDD FILLER2
X_12210_ _12210_/A _12210_/B _12210_/C _12210_/D VDD VSS _12300_/B OAOI211X1
XFILLER_108_455 VDD VSS FILLER4
X_13190_ _13290_/A _13290_/B _13290_/D VDD VSS _13280_/A OAI21X1
XFILLER_108_466 VDD VSS FILLER4
XFILLER_151_701 VDD VSS FILLER1
XFILLER_163_561 VDD VSS FILLER4
XFILLER_2_700 VSS VDD FILLER2
X_12141_ _12149_/A _12149_/B _12149_/C VDD VSS _14373_/B OAI21X1
XFILLER_163_583 VSS VDD FILLER2
XFILLER_123_436 VSS VDD FILLER2
XFILLER_135_296 VDD VSS DECAPHV8
XFILLER_150_244 VSS VDD FILLER2
XFILLER_111_609 VDD VSS FILLER4
X_12072_ _18983_/Q _12072_/B _12072_/C VDD VSS _12132_/B MIN3X1
XFILLER_150_255 VSS VDD FILLER2
XFILLER_150_266 VSS VDD FILLER2
XFILLER_77_501 VSS VDD FILLER2
XFILLER_104_672 VDD VSS FILLER4
XFILLER_89_361 VDD VSS DECAPHV8
XFILLER_2_788 VSS VDD FILLER2
X_15900_ _15906_/A _15900_/B VDD VSS _19506_/D NOR2X1
X_11023_ _11023_/A _11023_/B _11023_/C _11023_/D VDD VSS _11055_/B AO211X2
XFILLER_104_683 VDD VSS FILLER4
XFILLER_103_171 VSS VDD FILLER2
X_16880_ _16899_/A _16880_/B VDD VSS _19716_/D AND2X1
XFILLER_2_49 VSS VDD FILLER2
X_15831_ _17010_/A _15831_/B _15831_/C VDD VSS _19446_/D NOR3X1
XTAP_TAPCELL_ROW_147_1337 VDD VSS WELLTAP
XFILLER_65_707 VSS VDD FILLER2
X_18550_ _18550_/CK _18550_/D _18550_/Q VDD VSS DFFQX1
X_15762_ _15780_/A _15762_/B VDD VSS _19384_/D NOR2X1
X_12974_ _19106_/Q _13113_/A _13314_/B VDD VSS _13102_/D XNOR3X1
XTAP_TAPCELL_ROW_47_437 VDD VSS WELLTAP
XFILLER_66_96 VDD VSS FILLER1
XFILLER_17_111 VSS VDD FILLER2
XFILLER_17_122 VSS VDD FILLER2
X_17501_ _17503_/C _17501_/B _17501_/C VDD VSS _19859_/D AOI21X1
X_14713_ _19500_/Q _15893_/B VDD VSS _14785_/B XOR2X1
X_18481_ _18487_/CK _18497_/D _20126_/A _18486_/RB VDD VSS DFFRQX1
X_11925_ _11987_/A _14462_/B VDD VSS _11937_/B NOR2X1
XFILLER_45_464 VDD VSS FILLER1
X_15693_ _15693_/A _15693_/B VDD VSS _19322_/D NOR2X1
XFILLER_45_486 VSS VDD FILLER2
XFILLER_33_626 VDD VSS DECAPHV8
X_17432_ _19845_/Q _19813_/Q VDD VSS _17439_/C NOR2X1
X_14644_ _14644_/A _15889_/B VDD VSS _14645_/D OR2X2
X_11856_ _11899_/B _11866_/B VDD VSS _14367_/B XNOR2X1
X_10807_ _11255_/A _10807_/B _10807_/C VDD VSS _10808_/C OR3BX1
X_17363_ _17366_/A _17366_/B _17363_/C VDD VSS _17364_/C OAI21X1
X_14575_ _20013_/Q _16702_/B VDD VSS _19277_/D AND2X1
XFILLER_82_95 VSS VDD FILLER2
X_11787_ _19089_/Q _14365_/B VDD VSS _11864_/B NOR2X1
Xclkbuf_1_0__f__09177_ clkbuf_0__09177_/Y VDD VSS _18257_/CK BUFX12
XFILLER_60_489 VSS VDD FILLER2
XFILLER_158_322 VSS VDD FILLER2
X_19102_ _19157_/CK _19102_/D _19102_/Q VDD VSS DFFQX1
XTAP_TAPCELL_ROW_158_1433 VDD VSS WELLTAP
XFILLER_159_856 VDD VSS FILLER1
X_16314_ _19563_/Q _19915_/Q VDD VSS _16315_/B XOR2X1
XFILLER_9_321 VSS VDD FILLER2
X_13526_ _19082_/Q _14358_/B _14358_/C VDD VSS _13531_/D OR3BX1
X_10738_ _11267_/A _10738_/B _10738_/C _10960_/A VDD VSS _10739_/C OAI211X1
X_17294_ _17296_/C _17294_/B _17294_/C VDD VSS _19815_/D AOI21X1
XFILLER_158_355 VSS VDD FILLER2
XFILLER_9_354 VSS VDD FILLER2
X_19033_ _19115_/CK _19033_/D _19033_/Q VDD VSS DFFQX1
XFILLER_146_539 VSS VDD FILLER2
X_16245_ _16251_/B _16245_/B VDD VSS _16884_/B XNOR2X1
X_13457_ _13457_/A _13457_/B _13457_/C _13457_/D VDD VSS _14481_/C OAOI211X1
XFILLER_127_720 VSS VDD FILLER2
X_10669_ _10667_/Y _10671_/B _11431_/A VDD VSS _18561_/D AND3BX1
XFILLER_127_731 VSS VDD FILLER2
XFILLER_139_591 VDD VSS FILLER4
XFILLER_127_742 VSS VDD FILLER2
XFILLER_127_753 VDD VSS FILLER1
X_12408_ _20003_/Q _19267_/Q VDD VSS _12577_/D AND2X1
XFILLER_126_230 VSS VDD FILLER2
XFILLER_126_241 VDD VSS FILLER1
X_16176_ _19653_/Q _16810_/B VDD VSS _16177_/C OR2X2
X_13388_ _18914_/Q _14159_/B VDD VSS _13578_/C _14159_/C AND3X2
Xoutput106 _20181_/Y VDD VSS o_tst_ctrl[0] BUFX3
Xoutput117 _20186_/Y VDD VSS o_tst_ctrl[5] BUFX3
X_15127_ _15127_/A _15133_/C VDD VSS _15685_/B XNOR2X1
Xoutput128 _20212_/Y VDD VSS o_uwb_tx_cfg[15] BUFX3
X_12339_ _18987_/Q _12356_/B _14247_/B VDD VSS _14210_/B XNOR3X1
Xoutput139 _20222_/Y VDD VSS o_uwb_tx_cfg[25] BUFX3
XTAP_TAPCELL_ROW_113_1027 VDD VSS WELLTAP
X_15058_ _19534_/Q _15058_/B VDD VSS _15146_/C NOR2BX1
X_19935_ clkload3/A _19935_/D _19935_/Q VDD VSS DFFQX1
XFILLER_142_789 VDD VSS FILLER1
XFILLER_68_501 VDD VSS DECAPHV8
X_14009_ _19007_/Q _14269_/B VDD VSS _14043_/A XOR2X1
XFILLER_96_832 VSS VDD FILLER2
XFILLER_122_480 VSS VDD FILLER2
X_19866_ clkload2/A _19866_/D _19866_/Q VDD VSS DFFQX1
XFILLER_68_545 VDD VSS FILLER4
X_18817_ _18845_/CK _18817_/D _18817_/Q VDD VSS DFFQX1
XFILLER_56_718 VSS VDD FILLER2
XFILLER_110_675 VDD VSS DECAPHV8
X_19797_ clkload3/A _19797_/D _19797_/Q VDD VSS DFFQX1
XFILLER_95_375 VDD VSS FILLER4
XFILLER_95_386 VSS VDD FILLER2
XFILLER_49_781 VSS VDD FILLER2
X_09550_ _20044_/Q _18201_/A VDD VSS _20045_/D NOR2BX1
X_18748_ _19947_/CK _18748_/D _18748_/Q VDD VSS DFFQX1
Xdelaybuf_3_sclk delaybuf_3_sclk/A VDD VSS delaybuf_4_sclk/A BUFX12
X_09481_ _18454_/D _09483_/B _09481_/C VDD VSS _18243_/D AOI21X1
XFILLER_36_453 VDD VSS FILLER4
X_18679_ _19959_/CK _18679_/D _18679_/Q VDD VSS DFFQX1
XTAP_TAPCELL_ROW_81_738 VDD VSS WELLTAP
XTAP_TAPCELL_ROW_18_172 VDD VSS WELLTAP
XFILLER_24_659 VSS VDD FILLER2
XFILLER_149_366 VDD VSS FILLER4
XFILLER_149_399 VDD VSS FILLER1
XTAP_TAPCELL_ROW_135_1230 VDD VSS WELLTAP
XFILLER_118_764 VSS VDD FILLER2
XFILLER_152_509 VSS VDD FILLER2
XFILLER_3_508 VDD VSS FILLER4
XFILLER_145_561 VDD VSS DECAPHV8
XFILLER_127_47 VSS VDD FILLER2
XFILLER_132_222 VSS VDD FILLER2
XFILLER_133_756 VDD VSS DECAPHV16
XFILLER_87_18 VDD VSS FILLER4
XFILLER_87_29 VSS VDD FILLER2
XTAP_TAPCELL_ROW_89_816 VDD VSS WELLTAP
XFILLER_59_512 VDD VSS FILLER4
XFILLER_99_692 VSS VDD FILLER2
XFILLER_59_523 VDD VSS FILLER4
XFILLER_113_480 VSS VDD FILLER2
XFILLER_113_491 VDD VSS FILLER1
XFILLER_101_642 VSS VDD FILLER2
XFILLER_59_556 VSS VDD FILLER2
X_20006_ _20013_/CK _20006_/D _20006_/Q VDD VSS DFFQX1
XFILLER_47_707 VDD VSS FILLER4
X_09817_ _09817_/A _09817_/B _09817_/C _09817_/D VDD VSS _09818_/E AOI31X1
XFILLER_59_578 VSS VDD FILLER2
XTAP_TAPCELL_ROW_97_882 VDD VSS WELLTAP
X_09748_ _18339_/Q VDD VSS _20093_/A INVX1
XTAP_TAPCELL_ROW_109_994 VDD VSS WELLTAP
X_09679_ _20072_/Q _09770_/B _09769_/C _20088_/A _09679_/E VDD VSS _09680_/C AOI221X1
XTAP_TAPCELL_ROW_44_407 VDD VSS WELLTAP
XFILLER_55_784 VSS VDD FILLER2
XFILLER_160_4 VSS VDD FILLER2
X_11710_ _11745_/A _11768_/B VDD VSS _11714_/C XNOR2X1
XFILLER_36_88 VSS VDD FILLER2
XFILLER_82_592 VDD VSS FILLER4
XFILLER_27_497 VSS VDD FILLER2
X_12690_ _19047_/Q _12714_/B _12731_/C VDD VSS _12709_/C XNOR3X1
XTAP_TAPCELL_ROW_142_1289 VDD VSS WELLTAP
X_11641_ _11641_/A _11641_/B VDD VSS _18809_/D NOR2X1
XFILLER_30_607 VDD VSS DECAPHV8
XFILLER_42_489 VDD VSS DECAPHV8
X_14360_ _14316_/Y _14360_/B _14360_/C VDD VSS _19084_/D AND3BX1
XTAP_TAPCELL_ROW_52_484 VDD VSS WELLTAP
X_11572_ _18719_/Q _11578_/B VDD VSS _18746_/D AND2X1
XFILLER_156_804 VDD VSS FILLER1
X_13311_ _14323_/A _14323_/B _14323_/C VDD VSS _13416_/C AO21X2
X_10523_ _10576_/A _10576_/B _10721_/D VDD VSS _10528_/B AOI21X1
XFILLER_6_302 VDD VSS FILLER1
XFILLER_109_720 VDD VSS FILLER1
X_14291_ _14255_/Y _14291_/B _14291_/C VDD VSS _19024_/D AND3BX1
XFILLER_7_836 VDD VSS FILLER1
XFILLER_108_230 VSS VDD FILLER2
X_16030_ _16030_/A _16030_/B _16030_/C VDD VSS _16049_/A AOI21X1
X_13242_ _13255_/A _13255_/C _13150_/D VDD VSS _14541_/C AOI21BX1
X_10454_ _10454_/A _10454_/B _10454_/C _10454_/D VDD VSS _10455_/B AOI211X1
XFILLER_109_786 VDD VSS FILLER1
XFILLER_136_583 VDD VSS FILLER4
XFILLER_123_200 VSS VDD FILLER2
X_13173_ _18940_/Q _13295_/B _13173_/C VDD VSS _13290_/B XNOR3X1
XFILLER_108_285 VSS VDD FILLER2
X_10385_ _10581_/A _10385_/B _10385_/C _10512_/A VDD VSS _10386_/D OAI211X1
Xclkbuf_leaf_33__001_ clkbuf_2_1__f__001_/Y VDD VSS _19134_/CK BUFX12
X_12124_ _19012_/Q _12134_/B _12134_/C VDD VSS _14242_/B XNOR3X1
X_17981_ _17983_/B _17983_/C _18871_/Q VDD VSS _17987_/B OAI21X1
XFILLER_96_106 VSS VDD FILLER2
XFILLER_78_810 VSS VDD FILLER2
XFILLER_123_277 VSS VDD FILLER2
X_19720_ _19722_/CK _19720_/D _19720_/Q VDD VSS DFFQX1
XFILLER_117_91 VSS VDD FILLER2
X_16932_ _19742_/Q wire164/Y VDD VSS _16937_/A XNOR2X1
X_12055_ _12055_/A _12055_/B _12055_/C _12055_/D VDD VSS _12108_/B OAOI211X1
X_11006_ _18677_/Q _18785_/Q VDD VSS _11009_/A XNOR2X1
X_19651_ _19696_/CK _19651_/D _19651_/Q VDD VSS DFFQX1
X_16863_ _16899_/A _16863_/B VDD VSS _19701_/D AND2X1
XFILLER_77_375 VDD VSS FILLER4
X_18602_ _18612_/CK _18602_/D _18602_/Q VDD VSS DFFQX1
X_15814_ _15816_/A _15814_/B VDD VSS _19430_/D NOR2X1
XFILLER_65_537 VDD VSS FILLER4
X_19582_ _19636_/CK _19582_/D _19582_/Q VDD VSS DFFQX1
X_16794_ _16794_/A _16794_/B VDD VSS _19640_/D NOR2X1
X_18533_ _18543_/CK _18533_/D _18533_/Q VDD VSS DFFQX1
X_15745_ _16795_/A VDD VSS _15770_/A BUFX3
XTAP_TAPCELL_ROW_164_1492 VDD VSS WELLTAP
XFILLER_52_209 VSS VDD FILLER2
X_12957_ _13049_/A _13049_/B _13049_/C VDD VSS _13150_/A AOI21X1
XFILLER_61_710 VSS VDD FILLER2
XFILLER_46_795 VDD VSS FILLER1
XFILLER_61_732 VDD VSS FILLER4
X_18464_ _18471_/CK _18496_/D _18464_/Q _18464_/RB VDD VSS DFFRQX1
X_11908_ _11908_/A _11943_/B _14367_/B VDD VSS _11909_/B MIN3X1
X_15676_ _16795_/A VDD VSS _15706_/A BUFX3
X_12888_ _18937_/Q _14185_/B _12888_/C VDD VSS _12992_/B MIN3X1
XFILLER_61_765 VSS VDD FILLER2
X_17415_ _17417_/C _17416_/B _17452_/C VDD VSS _17416_/C OAI21X1
X_14627_ _19497_/Q _15890_/B VDD VSS _14652_/B XNOR2X1
X_18395_ _18407_/CK _18512_/Q _20136_/A _09380_/B VDD VSS DFFRQX1
X_11839_ _11839_/A _11839_/B _11839_/C _11839_/D VDD VSS _14490_/B OAOI211X1
XFILLER_159_642 VSS VDD FILLER2
XFILLER_60_297 VSS VDD FILLER2
X_17346_ _17346_/A _17346_/B _17346_/C _17346_/D VDD VSS _17347_/C AOAI211X1
X_14558_ _19998_/Q _14558_/B VDD VSS _19262_/D AND2X1
XFILLER_119_517 VSS VDD FILLER2
X_13509_ _13509_/A _13509_/B _13509_/C _13509_/D VDD VSS _13683_/A AO31X2
XFILLER_158_174 VDD VSS FILLER4
X_17277_ _19811_/Q _19779_/Q _17277_/C VDD VSS _17281_/B MIN3X1
X_14489_ _14493_/A _14489_/B VDD VSS _19201_/D NOR2X1
XFILLER_9_184 VSS VDD FILLER2
XFILLER_158_196 VSS VDD FILLER2
X_19016_ _19044_/CK _19016_/D _19016_/Q VDD VSS DFFQX1
XFILLER_162_807 VDD VSS FILLER1
X_16228_ _16228_/A VDD VSS _16229_/B INVX1
XFILLER_127_561 VSS VDD FILLER2
X_16159_ _16159_/A _19908_/Q _16159_/C VDD VSS _16185_/C MIN3X1
XFILLER_142_531 VDD VSS FILLER4
XFILLER_114_244 VDD VSS FILLER1
XFILLER_88_607 VSS VDD FILLER2
XFILLER_47_0 VSS VDD FILLER2
XFILLER_142_586 VDD VSS FILLER1
XFILLER_102_439 VSS VDD FILLER2
XFILLER_114_299 VSS VDD FILLER2
XFILLER_130_748 VDD VSS FILLER1
X_19918_ clkload9/A _19918_/D _19918_/Q VDD VSS DFFQX1
XTAP_TAPCELL_ROW_130_1182 VDD VSS WELLTAP
XFILLER_96_640 VSS VDD FILLER2
X_19849_ _19853_/CK _19849_/D _19849_/Q VDD VSS DFFQX1
XFILLER_96_673 VDD VSS FILLER1
XFILLER_95_150 VSS VDD FILLER2
XFILLER_29_729 VDD VSS FILLER4
XFILLER_110_461 VDD VSS FILLER1
XFILLER_68_375 VSS VDD FILLER2
XFILLER_96_695 VSS VDD FILLER2
XFILLER_28_217 VSS VDD FILLER2
X_09602_ _18490_/Q VDD VSS _20103_/A INVX1
XFILLER_110_494 VSS VDD FILLER2
XFILLER_95_183 VSS VDD FILLER2
XFILLER_83_345 VSS VDD FILLER2
X_09533_ _20028_/Q _18199_/A VDD VSS _20029_/D NOR2BX1
XTAP_TAPCELL_ROW_94_863 VDD VSS WELLTAP
XTAP_TAPCELL_ROW_106_964 VDD VSS WELLTAP
X_09464_ _18446_/D _09468_/B _09464_/C VDD VSS _18251_/D AOI21X1
XFILLER_12_607 VDD VSS FILLER4
X_09395_ _18624_/Q _11436_/C VDD VSS _11433_/B NAND2X1
XFILLER_24_489 VDD VSS FILLER4
XFILLER_51_286 VSS VDD FILLER2
XFILLER_132_8 VSS VDD FILLER2
XFILLER_138_826 VSS VDD FILLER2
XFILLER_22_35 VDD VSS FILLER4
XFILLER_165_634 VSS VDD FILLER2
XFILLER_137_336 VDD VSS FILLER4
XFILLER_20_695 VSS VDD FILLER2
XFILLER_153_807 VSS VDD FILLER2
XFILLER_153_818 VDD VSS FILLER1
XFILLER_4_806 VSS VDD FILLER2
XFILLER_118_6 VDD VSS FILLER1
XFILLER_4_828 VSS VDD FILLER2
XFILLER_138_79 VDD VSS FILLER4
XFILLER_152_328 VSS VDD FILLER2
X_09975__246 _20080_/CK VDD VSS _18522_/CK INVX1
XFILLER_164_199 VDD VSS FILLER4
XFILLER_161_840 VDD VSS FILLER4
XFILLER_0_6 VSS VDD FILLER2
XFILLER_105_244 VDD VSS FILLER1
X_10170_ _10172_/A _10172_/B _10172_/D _10172_/C VDD VSS _10174_/C AOI211X1
XFILLER_106_789 VDD VSS FILLER1
XFILLER_160_350 VSS VDD FILLER2
XFILLER_105_277 VSS VDD FILLER2
XFILLER_154_45 VDD VSS FILLER1
XFILLER_154_56 VSS VDD FILLER2
XFILLER_87_640 VSS VDD FILLER2
XFILLER_120_269 VDD VSS FILLER1
XFILLER_87_684 VSS VDD FILLER2
XFILLER_59_375 VSS VDD FILLER2
Xfanout196 _18504_/Q VDD VSS _09630_/C BUFX3
XFILLER_19_228 VSS VDD FILLER2
XTAP_TAPCELL_ROW_144_1307 VDD VSS WELLTAP
X_13860_ _13860_/A _14329_/B _13860_/C _13860_/D VDD VSS _13910_/B AOAI211X1
XFILLER_86_194 VSS VDD FILLER2
XFILLER_19_239 VSS VDD FILLER2
XFILLER_74_345 VSS VDD FILLER2
X_12811_ _19076_/Q _14349_/B VDD VSS _12916_/D _14349_/C AND3X2
XFILLER_28_762 VSS VDD FILLER2
XFILLER_90_827 VDD VSS FILLER4
X_13791_ _13791_/A _13791_/B _13791_/C VDD VSS _14392_/B NOR3X1
XTAP_TAPCELL_ROW_29_278 VDD VSS WELLTAP
XFILLER_15_412 VSS VDD FILLER2
X_15530_ _15539_/A _15539_/B VDD VSS _15696_/B XOR2X1
X_12742_ _12813_/A _14410_/B _14410_/C VDD VSS _12910_/C NOR3X1
XFILLER_15_434 VDD VSS FILLER4
XFILLER_15_456 VSS VDD FILLER2
XFILLER_151_0 VSS VDD FILLER2
X_15461_ _19350_/Q _15724_/B VDD VSS _15462_/C NOR2BX1
X_12673_ _12673_/A _12673_/B _12673_/C _12673_/D VDD VSS _12763_/A OAI31X1
X_17200_ _19795_/Q _19763_/Q VDD VSS _17202_/B XOR2X1
X_14412_ _17566_/A VDD VSS _14449_/A BUFX3
X_11624_ _18767_/Q _11624_/B VDD VSS _18794_/D AND2X1
X_18180_ _19302_/Q _18181_/B VDD VSS _18185_/C AND2X1
X_15392_ _19460_/Q VDD VSS _15394_/A INVX1
XTAP_TAPCELL_ROW_12_123 VDD VSS WELLTAP
XFILLER_30_459 VDD VSS DECAPHV16
XFILLER_11_640 VDD VSS FILLER4
X_17131_ _19780_/Q _19748_/Q VDD VSS _17132_/C NAND2X1
XFILLER_8_59 VSS VDD FILLER2
XFILLER_7_611 VSS VDD FILLER2
X_14343_ _14368_/A _14343_/B VDD VSS _19070_/D NOR2X1
X_11555_ _18704_/Q _11555_/B VDD VSS _18731_/D AND2X1
XFILLER_156_634 VDD VSS FILLER1
XFILLER_155_133 VDD VSS FILLER4
X_10506_ _18557_/Q _10507_/B VDD VSS _10544_/C AND2X1
XFILLER_116_509 VSS VDD FILLER2
X_17062_ _17208_/B _17062_/B _17062_/C _17062_/D VDD VSS _17062_/Y AOAI211X1
X_14274_ _14285_/A _14274_/B VDD VSS _19011_/D NOR2X1
XFILLER_143_306 VDD VSS FILLER1
X_11486_ _18641_/Q _11496_/B VDD VSS _18668_/D AND2X1
XFILLER_109_561 VSS VDD FILLER2
X_16013_ _16013_/A _16013_/B VDD VSS _16872_/B XNOR2X1
X_13225_ _19164_/Q VDD VSS _13355_/A INVX1
XFILLER_12_90 VSS VDD FILLER2
X_10437_ _18634_/Q _18796_/Q VDD VSS _10476_/C NAND2X1
X_13156_ _19164_/Q _13331_/A _13443_/B VDD VSS _13315_/D XNOR3X1
X_10368_ _18632_/Q _18794_/Q VDD VSS _10402_/A AND2X1
XFILLER_97_415 VDD VSS FILLER4
XFILLER_97_426 VSS VDD FILLER2
XFILLER_69_117 VSS VDD FILLER2
X_12107_ _19999_/Q _19263_/Q VDD VSS _12108_/D AND2X1
XFILLER_151_383 VSS VDD FILLER2
XFILLER_33_6 VSS VDD FILLER2
X_17964_ _18869_/Q _17964_/B _17964_/C VDD VSS _17966_/C XNOR3X1
X_13087_ _13097_/A _13097_/B _13097_/C VDD VSS _14257_/B OAI21X1
XFILLER_97_448 VDD VSS FILLER1
X_10299_ _10538_/A _10550_/A _10465_/B VDD VSS _10299_/Y NOR3X1
XTAP_TAPCELL_ROW_166_1510 VDD VSS WELLTAP
XFILLER_111_258 VSS VDD FILLER2
X_19703_ _19705_/CK _19703_/D _19703_/Q VDD VSS DFFQX1
X_16915_ _16978_/B VDD VSS _17011_/B BUFX3
X_12038_ _19206_/Q _12038_/B _12099_/C VDD VSS _12113_/B XOR3X1
XFILLER_66_802 VDD VSS FILLER4
X_17895_ _18857_/Q _17901_/B VDD VSS _17898_/B NAND2X1
XFILLER_120_781 VSS VDD FILLER2
XFILLER_65_301 VSS VDD FILLER2
XFILLER_78_695 VSS VDD FILLER2
X_19634_ _19667_/CK _19634_/D _19634_/Q VDD VSS DFFQX1
XFILLER_38_537 VSS VDD FILLER2
X_16846_ _16865_/A _16846_/B VDD VSS _19685_/D NOR2X1
XFILLER_93_654 VSS VDD FILLER2
XFILLER_92_142 VSS VDD FILLER2
XFILLER_53_507 VDD VSS FILLER4
X_19565_ _19600_/CK _19565_/D _19565_/Q VDD VSS DFFQX1
X_16777_ _16794_/A _16777_/B VDD VSS _19623_/D NOR2X1
X_13989_ _13989_/A _14198_/B _14198_/C VDD VSS _13990_/D NOR3X1
XFILLER_34_721 VSS VDD FILLER2
X_18516_ _18516_/CK _18516_/D _18516_/Q _09328_/Y VDD VSS DFFRQX1
XTAP_TAPCELL_ROW_91_833 VDD VSS WELLTAP
X_15728_ _15739_/A _15728_/B VDD VSS _19353_/D NOR2X1
XTAP_TAPCELL_ROW_121_1104 VDD VSS WELLTAP
X_19496_ _19531_/CK _19496_/D _19496_/Q VDD VSS DFFQX1
X_18447_ _18455_/CK _18447_/D _18447_/Q _18450_/RB VDD VSS DFFRQX1
XTAP_TAPCELL_ROW_63_579 VDD VSS WELLTAP
X_15659_ _19330_/Q _15702_/B VDD VSS _15660_/B XNOR2X1
XFILLER_33_297 VSS VDD FILLER2
X_18378_ _18391_/CK _18511_/Q _20183_/A _20065_/RB VDD VSS DFFRQX1
XFILLER_21_459 VDD VSS FILLER4
XFILLER_159_472 VDD VSS FILLER1
X_17329_ _17479_/B _17329_/B _17329_/C VDD VSS _17334_/C MIN3X1
XFILLER_146_122 VSS VDD FILLER2
XFILLER_134_317 VDD VSS FILLER1
XFILLER_134_328 VSS VDD FILLER2
XTAP_TAPCELL_ROW_119_1088 VDD VSS WELLTAP
XTAP_TAPCELL_ROW_132_1200 VDD VSS WELLTAP
XFILLER_146_199 VSS VDD FILLER2
XFILLER_127_391 VSS VDD FILLER2
XFILLER_143_840 VSS VDD FILLER2
XFILLER_108_49 VSS VDD FILLER2
XFILLER_161_147 VDD VSS DECAPHV8
XFILLER_1_809 VSS VDD FILLER2
XFILLER_115_553 VDD VSS FILLER4
XTAP_TAPCELL_ROW_99_900 VDD VSS WELLTAP
XFILLER_115_575 VSS VDD FILLER2
XFILLER_88_415 VSS VDD FILLER2
XFILLER_102_203 VSS VDD FILLER2
XFILLER_130_556 VSS VDD FILLER2
XFILLER_69_640 VSS VDD FILLER2
XFILLER_124_26 VSS VDD FILLER2
XFILLER_29_504 VDD VSS DECAPHV8
XFILLER_69_695 VDD VSS FILLER4
XFILLER_57_835 VSS VDD FILLER2
XFILLER_83_131 VDD VSS FILLER1
XFILLER_84_687 VSS VDD FILLER2
XFILLER_72_838 VSS VDD FILLER2
XTAP_TAPCELL_ROW_54_502 VDD VSS WELLTAP
XFILLER_83_175 VSS VDD FILLER2
XFILLER_25_710 VSS VDD FILLER2
X_09516_ _20014_/Q _09516_/B VDD VSS _18197_/D OR2X2
XFILLER_24_220 VSS VDD FILLER2
XFILLER_25_754 VDD VSS FILLER4
XTAP_TAPCELL_ROW_26_248 VDD VSS WELLTAP
XFILLER_25_765 VSS VDD FILLER2
X_09447_ _09624_/B _09447_/B VDD VSS _18222_/E NOR2X1
XFILLER_25_787 VSS VDD FILLER2
XFILLER_52_584 VDD VSS FILLER1
XFILLER_33_12 VDD VSS FILLER4
XFILLER_24_275 VDD VSS FILLER1
XFILLER_157_409 VDD VSS FILLER4
XFILLER_12_448 VSS VDD FILLER2
X_09378_ _09410_/B VDD VSS _09818_/B BUFX3
XFILLER_12_459 VDD VSS FILLER1
XFILLER_138_601 VSS VDD FILLER2
XFILLER_40_768 VSS VDD FILLER2
XTAP_TAPCELL_ROW_4_49 VDD VSS WELLTAP
XFILLER_137_133 VSS VDD FILLER2
XFILLER_149_89 VDD VSS FILLER4
XFILLER_137_144 VDD VSS FILLER1
X_11340_ _11340_/A _11342_/B _11364_/B VDD VSS _11357_/A OA21X2
XFILLER_137_155 VDD VSS DECAPHV8
XFILLER_165_464 VDD VSS FILLER1
XFILLER_138_689 VDD VSS DECAPHV8
XFILLER_137_177 VSS VDD FILLER2
XFILLER_165_497 VSS VDD FILLER2
XFILLER_118_380 VDD VSS FILLER4
XFILLER_152_125 VDD VSS FILLER4
X_11271_ _11271_/A _11275_/B VDD VSS _11272_/B XOR2X1
X_13010_ _19050_/Q VDD VSS _13091_/A INVX1
X_10222_ _10224_/A _10222_/B VDD VSS _10224_/C NOR2X1
XFILLER_121_501 VSS VDD FILLER2
XTAP_TAPCELL_ROW_150_1366 VDD VSS WELLTAP
XFILLER_79_415 VSS VDD FILLER2
XFILLER_106_586 VSS VDD FILLER2
XFILLER_79_437 VSS VDD FILLER2
XFILLER_161_692 VSS VDD FILLER2
X_10153_ _11229_/A _10153_/B VDD VSS _10154_/C NOR2X1
XFILLER_121_556 VSS VDD FILLER2
XFILLER_121_567 VSS VDD FILLER2
X_14961_ _19478_/Q _15869_/B VDD VSS _15000_/D NAND2X1
X_10084_ _09952_/B _10175_/D _10131_/A VDD VSS _10098_/B MUXI2X1
XFILLER_59_161 VSS VDD FILLER2
X_16700_ _19906_/Q _16702_/B VDD VSS _19554_/D AND2X1
X_13912_ _13912_/A _13912_/B _14332_/B _13912_/D _13912_/E VDD VSS _13965_/C OAI221X1
XFILLER_59_183 VSS VDD FILLER2
X_17680_ _17680_/A _17680_/B VDD VSS _17681_/B XNOR2X1
X_14892_ _19337_/Q _15710_/B VDD VSS _14893_/B XNOR2X1
XFILLER_75_654 VSS VDD FILLER2
XFILLER_74_142 VDD VSS FILLER4
X_16631_ _16631_/A _16631_/B _16631_/C VDD VSS _16632_/B NOR3X1
X_13843_ _13843_/A _13843_/B _13843_/C _13843_/D VDD VSS _14265_/C OAI211X1
XFILLER_62_304 VDD VSS FILLER4
XFILLER_74_186 VSS VDD FILLER2
X_19350_ _19379_/CK _19350_/D _19350_/Q VDD VSS DFFQX1
XFILLER_74_74 VSS VDD FILLER2
X_16562_ _16585_/B _16562_/B VDD VSS _16897_/B NAND2BX1
XTAP_TAPCELL_ROW_161_1462 VDD VSS WELLTAP
XFILLER_15_220 VDD VSS FILLER4
X_13774_ _13845_/A _14229_/B VDD VSS _13827_/B NOR2X1
X_10986_ _10841_/Y _11119_/B _11118_/A VDD VSS _11235_/B MUXI2X1
XFILLER_90_668 VDD VSS FILLER1
X_18301_ _18309_/CK _18514_/Q _18301_/Q _20081_/RB VDD VSS DFFRQX1
X_15513_ _15913_/B VDD VSS _15514_/C INVX1
X_19281_ _19314_/CK _19281_/D _19281_/Q VDD VSS DFFQX1
X_12725_ _19102_/Q _14379_/B _14379_/C VDD VSS _12729_/D OR3BX1
XFILLER_43_573 VDD VSS FILLER1
X_16493_ _19665_/Q _16823_/B VDD VSS _16494_/C NOR2X1
X_18232_ _18232_/CK _18232_/E _18232_/ECK VDD VSS CGX3
XTAP_TAPCELL_ROW_60_549 VDD VSS WELLTAP
XTAP_TAPCELL_ROW_100_915 VDD VSS WELLTAP
X_15444_ _15471_/B _15444_/B VDD VSS _15468_/A XNOR2X1
X_12656_ _12656_/A _12656_/B _12656_/C _12656_/D VDD VSS _14409_/B OAOI211X1
X_18163_ _18163_/A _18163_/B _18167_/B VDD VSS _20006_/D NOR3X1
X_11607_ _18751_/Q _11612_/B VDD VSS _18778_/D AND2X1
X_15375_ _15376_/A _15376_/B _15376_/C VDD VSS _15425_/B OAI21X1
X_12587_ _19242_/Q _12666_/A _12678_/C VDD VSS _12837_/C XNOR3X1
X_17114_ _17263_/B _17114_/B _17114_/C VDD VSS _17118_/C MIN3X1
X_14326_ _14316_/Y _14326_/B _14326_/C VDD VSS _19055_/D AND3BX1
X_18094_ _19285_/Q _18094_/B VDD VSS _18096_/A NAND2X1
X_11538_ _18689_/Q _11542_/B VDD VSS _18716_/D AND2X1
XFILLER_7_463 VSS VDD FILLER2
XFILLER_143_103 VSS VDD FILLER2
XFILLER_156_486 VSS VDD FILLER2
XFILLER_116_328 VDD VSS DECAPHV8
X_17045_ _17045_/A _17045_/B _17045_/C _17045_/D VDD VSS _17064_/A OAOI211X1
X_14257_ _14255_/Y _14257_/B _14257_/C VDD VSS _18995_/D AND3BX1
X_11469_ _11469_/A _11641_/B VDD VSS _18653_/D NOR2X1
XFILLER_109_391 VDD VSS DECAPHV8
XFILLER_125_840 VSS VDD FILLER2
XFILLER_143_147 VSS VDD FILLER2
X_13208_ _13415_/A _13415_/B _13208_/C VDD VSS _14291_/C OAI21X1
X_14188_ _14457_/A VDD VSS _14218_/A BUFX3
XFILLER_140_821 VDD VSS FILLER4
XFILLER_140_843 VSS VDD FILLER2
XFILLER_124_394 VSS VDD FILLER2
X_13139_ _13444_/A _13139_/B VDD VSS _14512_/B XNOR2X1
XFILLER_98_757 VSS VDD FILLER2
X_18996_ _19025_/CK _18996_/D _18996_/Q VDD VSS DFFQX1
XFILLER_98_768 VDD VSS FILLER1
XFILLER_112_567 VSS VDD FILLER2
XFILLER_100_718 VDD VSS FILLER4
X_17947_ _17958_/B _18087_/D VDD VSS _17948_/D NAND2BX1
XFILLER_97_278 VDD VSS FILLER1
XTAP_TAPCELL_ROW_68_627 VDD VSS WELLTAP
XFILLER_39_835 VSS VDD FILLER2
XFILLER_66_621 VSS VDD FILLER2
XFILLER_38_323 VSS VDD FILLER2
XFILLER_66_643 VDD VSS FILLER1
X_17878_ _17880_/C _17879_/B _17917_/C VDD VSS _17879_/C OAI21X1
XFILLER_54_805 VSS VDD FILLER2
XFILLER_93_462 VSS VDD FILLER2
X_16829_ _16838_/A _16829_/B VDD VSS _19670_/D NOR2X1
X_19617_ _19667_/CK _19617_/D _19617_/Q VDD VSS DFFQX1
XFILLER_53_304 VSS VDD FILLER2
XFILLER_54_849 VDD VSS FILLER4
XFILLER_81_635 VSS VDD FILLER2
XTAP_TAPCELL_ROW_76_693 VDD VSS WELLTAP
X_19548_ _19602_/CK _19548_/D _19548_/Q VDD VSS DFFQX1
XFILLER_0_93 VDD VSS FILLER4
X_09301_ _09301_/A _09301_/B VDD VSS _09302_/A NOR2X2
XFILLER_110_28 VSS VDD FILLER2
X_19479_ _19508_/CK _19479_/D _19479_/Q VDD VSS DFFQX1
XTAP_TAPCELL_ROW_23_218 VDD VSS WELLTAP
XFILLER_80_189 VSS VDD FILLER2
XFILLER_61_370 VSS VDD FILLER2
X_09232_ _18519_/Q VDD VSS _18354_/D INVX1
XFILLER_22_746 VDD VSS DECAPHV8
XFILLER_139_409 VSS VDD FILLER2
XFILLER_21_256 VDD VSS FILLER1
XFILLER_166_228 VDD VSS DECAPHV32
XFILLER_9_80 VSS VDD FILLER2
XFILLER_119_122 VSS VDD FILLER2
XFILLER_9_91 VSS VDD FILLER2
XFILLER_147_442 VSS VDD FILLER2
XTAP_TAPCELL_ROW_31_295 VDD VSS WELLTAP
XFILLER_135_615 VDD VSS FILLER4
XFILLER_147_475 VSS VDD FILLER2
XFILLER_135_637 VSS VDD FILLER2
XFILLER_162_434 VSS VDD FILLER2
XFILLER_134_136 VSS VDD FILLER2
XFILLER_150_607 VDD VSS FILLER4
XFILLER_115_361 VSS VDD FILLER2
XFILLER_143_670 VSS VDD FILLER2
XFILLER_1_639 VDD VSS FILLER4
XFILLER_0_127 VSS VDD FILLER2
XFILLER_89_757 VDD VSS FILLER4
XFILLER_0_138 VSS VDD FILLER2
X_20185_ _20185_/A VDD VSS _20185_/Y BUFX3
X_09996_ _09996_/A _09996_/B _09996_/C VDD VSS _09998_/C OA21X2
XFILLER_89_779 VDD VSS FILLER1
XFILLER_103_578 VSS VDD FILLER2
XFILLER_97_790 VDD VSS FILLER1
XFILLER_29_312 VSS VDD FILLER2
XFILLER_29_334 VSS VDD FILLER2
XFILLER_57_654 VSS VDD FILLER2
XFILLER_151_35 VDD VSS FILLER4
XFILLER_57_665 VDD VSS DECAPHV8
XFILLER_56_142 VDD VSS FILLER4
XFILLER_29_356 VSS VDD FILLER2
XFILLER_17_529 VSS VDD FILLER2
XTAP_TAPCELL_ROW_39_362 VDD VSS WELLTAP
XFILLER_84_484 VDD VSS DECAPHV8
X_10840_ _11116_/A _10840_/B _10840_/C VDD VSS _10840_/Y OAI21X1
XFILLER_44_22 VSS VDD FILLER2
XFILLER_25_551 VDD VSS FILLER4
XFILLER_44_44 VSS VDD FILLER2
X_10771_ _11229_/D _10771_/B _10771_/C VDD VSS _10772_/D OAI21X1
XFILLER_12_201 VDD VSS FILLER1
XFILLER_71_189 VDD VSS FILLER4
XFILLER_44_66 VDD VSS FILLER4
XFILLER_40_510 VDD VSS FILLER1
X_12510_ _12510_/A _12510_/B _12510_/C _12510_/D VDD VSS _12600_/B AOAI211X1
XFILLER_158_718 VSS VDD FILLER2
X_13490_ _18943_/Q _13490_/B _13516_/C VDD VSS _13656_/B XNOR3X1
XFILLER_9_717 VSS VDD FILLER2
XFILLER_8_205 VSS VDD FILLER2
X_12441_ _12441_/A _12441_/B _14248_/B VDD VSS _12537_/B MIN3X1
XFILLER_100_72 VDD VSS DECAPHV8
XFILLER_12_289 VSS VDD FILLER2
XFILLER_60_32 VSS VDD FILLER2
XFILLER_138_453 VDD VSS FILLER1
X_15160_ _19427_/Q _15811_/B VDD VSS _15161_/B XOR2X1
X_12372_ _12372_/A _12372_/B _12372_/C _12372_/D VDD VSS _12378_/A AOI31X1
XFILLER_165_250 VSS VDD FILLER2
XFILLER_114_0 VDD VSS DECAPHV32
X_14111_ _17977_/A _17977_/B _17978_/B _14111_/D VDD VSS _17982_/B OAOI211X1
X_11323_ _18586_/Q VDD VSS _11325_/D INVX1
X_15091_ _19453_/Q _15838_/B VDD VSS _15139_/A NAND2X1
XFILLER_107_840 VSS VDD FILLER2
XFILLER_109_81 VSS VDD FILLER2
X_14042_ _18980_/Q _14236_/B VDD VSS _14068_/B XNOR2X1
X_11254_ _11264_/A _11264_/B _11364_/B VDD VSS _11258_/A OA21X2
XFILLER_109_92 VDD VSS FILLER1
XFILLER_4_477 VDD VSS FILLER1
XFILLER_140_117 VDD VSS FILLER1
X_10205_ _10130_/Y _10204_/Y _10224_/A VDD VSS _10207_/B MUXI2X1
XFILLER_122_843 VSS VDD FILLER2
X_18850_ _18889_/CK _18850_/D _18850_/Q VDD VSS DFFQX1
X_11185_ _11184_/Y _18576_/Q VDD VSS _11217_/B NOR2BX1
XFILLER_69_96 VDD VSS FILLER4
X_17801_ _17802_/A _17803_/C _17828_/C VDD VSS _17802_/C OAI21X1
X_10136_ _10150_/A _10136_/B VDD VSS _11417_/C XNOR2X1
XFILLER_39_109 VDD VSS FILLER1
X_18781_ _18810_/CK _18781_/D _18781_/Q VDD VSS DFFQX1
XFILLER_94_204 VSS VDD FILLER2
XFILLER_79_278 VDD VSS FILLER1
XFILLER_121_375 VDD VSS FILLER4
X_15993_ _15993_/A _15993_/B _15993_/C VDD VSS _15999_/A AOI21X1
XFILLER_94_226 VDD VSS FILLER4
XFILLER_121_397 VSS VDD FILLER2
XFILLER_125_80 VDD VSS FILLER4
XFILLER_125_91 VSS VDD FILLER2
X_17732_ _19909_/Q _19877_/Q VDD VSS _17738_/B NAND2X1
XFILLER_85_40 VDD VSS FILLER1
X_14944_ _14954_/B _14944_/B VDD VSS _15711_/B XNOR2X1
X_10067_ _18583_/Q _10079_/C VDD VSS _10068_/B NAND2X1
XFILLER_75_440 VSS VDD FILLER2
XFILLER_85_84 VSS VDD FILLER2
X_17663_ _19893_/Q _19861_/Q _17663_/C VDD VSS _17667_/B MIN3X1
X_14875_ _15015_/C VDD VSS _14881_/C INVX1
XFILLER_90_410 VSS VDD FILLER2
X_19402_ _19460_/CK _19402_/D _19402_/Q VDD VSS DFFQX1
XFILLER_90_421 VSS VDD FILLER2
X_16614_ _19734_/Q _16899_/B VDD VSS _16616_/C XNOR2X1
X_13826_ _18975_/Q VDD VSS _13827_/A INVX1
XFILLER_62_134 VDD VSS FILLER4
X_17594_ _17596_/C _17594_/B _17594_/C VDD VSS _19879_/D AOI21X1
XFILLER_62_156 VSS VDD FILLER2
X_19333_ _19333_/CK _19333_/D _19333_/Q VDD VSS DFFQX1
X_16545_ _16545_/A _16545_/B _16825_/B VDD VSS _16558_/A MIN3X1
XTAP_TAPCELL_ROW_73_674 VDD VSS WELLTAP
XFILLER_62_178 VSS VDD FILLER2
X_13757_ _13771_/A _14195_/B _13771_/C VDD VSS _14196_/B OAI21X1
XFILLER_62_189 VDD VSS FILLER1
X_10969_ _18676_/Q _18784_/Q VDD VSS _11007_/B NAND2X1
XFILLER_31_510 VSS VDD FILLER2
XFILLER_149_718 VSS VDD FILLER2
X_19264_ _20004_/CK _19264_/D _19264_/Q VDD VSS DFFQX1
X_12708_ _18935_/Q _12708_/B _12708_/C VDD VSS _12877_/B MIN3X1
XFILLER_31_543 VDD VSS DECAPHV8
XFILLER_149_729 VDD VSS FILLER1
X_16476_ _16476_/A _19920_/Q _16476_/C VDD VSS _16498_/C MIN3X1
X_13688_ _13688_/A _13688_/B _13688_/C _13688_/D VDD VSS _14195_/B OAOI211X1
X_18215_ _18217_/CK _18215_/E _18215_/ECK VDD VSS CGX3
XFILLER_86_4 VSS VDD FILLER2
X_15427_ _15427_/A _15427_/B _15427_/C VDD VSS _15465_/A AOI21X1
X_19195_ _19223_/CK _19195_/D _19195_/Q VDD VSS DFFQX1
X_12639_ _12732_/A _12732_/C _12732_/B VDD VSS _14379_/C AOI21X1
XFILLER_31_598 VDD VSS FILLER1
XFILLER_129_442 VSS VDD FILLER2
X_18146_ _18150_/A _18146_/B _18146_/C VDD VSS _20003_/D AOI21X1
X_15358_ _19515_/Q _15910_/B VDD VSS _15360_/A XNOR2X1
XFILLER_157_784 VSS VDD FILLER2
XFILLER_144_412 VDD VSS FILLER4
XFILLER_116_114 VSS VDD FILLER2
X_14309_ _14311_/A _14309_/B VDD VSS _19041_/D NOR2X1
XFILLER_156_294 VDD VSS DECAPHV8
X_18077_ _18087_/D _18083_/B VDD VSS _18078_/C NAND2X1
XFILLER_7_282 VSS VDD FILLER2
XFILLER_116_136 VSS VDD FILLER2
X_15289_ _15289_/A _15305_/C VDD VSS _15751_/B XOR2X1
XTAP_TAPCELL_ROW_116_1058 VDD VSS WELLTAP
XFILLER_132_607 VSS VDD FILLER2
Xclkbuf_leaf_2_sclk delaybuf_0_sclk/A VDD VSS _18234_/CK BUFX12
XFILLER_132_618 VDD VSS FILLER1
X_17028_ _17028_/A _17030_/A _17030_/B _17028_/D VDD VSS _19759_/D AOI31X1
XFILLER_113_810 VDD VSS FILLER1
XFILLER_98_532 VSS VDD FILLER2
Xclkbuf_1_1__f__09173_ clkbuf_0__09173_/Y VDD VSS _18309_/CK BUFX12
X_09850_ _09855_/B _09850_/B VDD VSS _09850_/Y NOR2X1
XFILLER_105_17 VSS VDD FILLER2
XFILLER_140_673 VSS VDD FILLER2
X_09781_ _18373_/Q wire176/Y _09810_/B _18341_/Q VDD VSS _09782_/E OAI22X1
XFILLER_98_598 VDD VSS FILLER4
XFILLER_86_738 VSS VDD FILLER2
XFILLER_58_429 VSS VDD FILLER2
XFILLER_112_386 VSS VDD FILLER2
XFILLER_140_695 VSS VDD FILLER2
X_18979_ _19171_/CK _18979_/D _18979_/Q VDD VSS DFFQX1
XFILLER_85_226 VSS VDD FILLER2
XFILLER_39_643 VDD VSS DECAPHV8
XFILLER_39_654 VDD VSS FILLER4
XFILLER_66_440 VSS VDD FILLER2
XFILLER_38_142 VSS VDD FILLER2
XFILLER_94_771 VSS VDD FILLER2
XFILLER_66_462 VDD VSS FILLER1
XFILLER_54_602 VSS VDD FILLER2
XFILLER_39_687 VSS VDD FILLER2
XTAP_TAPCELL_ROW_127_1154 VDD VSS WELLTAP
XFILLER_94_793 VSS VDD FILLER2
XFILLER_66_495 VDD VSS FILLER1
XFILLER_53_112 VSS VDD FILLER2
XFILLER_26_337 VDD VSS FILLER4
XFILLER_53_145 VDD VSS FILLER1
XFILLER_53_189 VSS VDD FILLER2
XFILLER_41_329 VSS VDD FILLER2
XFILLER_50_830 VSS VDD FILLER2
XFILLER_22_532 VSS VDD FILLER2
XFILLER_22_543 VDD VSS FILLER1
X_09215_ _18470_/D VDD VSS _18406_/D INVX1
XFILLER_148_773 VDD VSS FILLER4
XFILLER_148_784 VDD VSS FILLER4
XFILLER_163_721 VDD VSS FILLER4
XFILLER_162_220 VDD VSS FILLER4
XFILLER_135_456 VSS VDD FILLER2
XFILLER_146_24 VDD VSS FILLER4
XFILLER_107_158 VDD VSS FILLER4
XFILLER_100_6 VDD VSS FILLER4
XFILLER_162_286 VDD VSS FILLER4
XFILLER_150_437 VSS VDD FILLER2
XFILLER_89_532 VSS VDD FILLER2
XFILLER_150_459 VDD VSS FILLER1
XFILLER_1_447 VSS VDD FILLER2
XFILLER_131_662 VSS VDD FILLER2
XFILLER_49_407 VSS VDD FILLER2
XFILLER_162_12 VSS VDD FILLER2
Xclkbuf_1_1__f__002_ clkbuf_0__002_/Y VDD VSS clkbuf_leaf_9__002_/A BUFX12
XFILLER_89_587 VSS VDD FILLER2
XFILLER_39_44 VSS VDD FILLER2
XFILLER_103_375 VDD VSS FILLER4
X_20168_ _20168_/A VDD VSS _20168_/Y BUFX3
XFILLER_130_161 VSS VDD FILLER2
Xclkbuf_leaf_0__000_ clkbuf_leaf_6__000_/A VDD VSS _19531_/CK BUFX12
XFILLER_103_397 VSS VDD FILLER2
XFILLER_162_67 VDD VSS FILLER4
XFILLER_92_708 VDD VSS FILLER4
X_20099_ _20099_/A VDD VSS _20099_/Y BUFX3
X_12990_ _18910_/Q _13076_/B _13076_/C VDD VSS _13178_/B MIN3X1
XFILLER_92_719 VSS VDD FILLER2
XFILLER_57_440 VDD VSS FILLER4
XFILLER_29_131 VDD VSS FILLER4
XFILLER_162_78 VDD VSS FILLER4
XFILLER_57_451 VSS VDD FILLER2
XFILLER_91_207 VDD VSS FILLER1
X_11941_ _19065_/Q _12023_/B _12018_/B VDD VSS _12014_/A XNOR3X1
XTAP_TAPCELL_ROW_87_799 VDD VSS WELLTAP
XFILLER_18_838 VSS VDD FILLER2
XFILLER_84_270 VDD VSS FILLER1
XFILLER_72_421 VSS VDD FILLER2
X_14660_ _19471_/Q _14700_/B _15862_/B VDD VSS _14673_/C XOR3X1
X_11872_ _11918_/A _11915_/C VDD VSS _14461_/B XNOR2X1
XFILLER_44_156 VSS VDD FILLER2
X_13611_ _19028_/Q _14295_/B VDD VSS _13840_/A AND2X1
X_10823_ _10823_/A _10823_/B VDD VSS _10838_/B XNOR2X1
X_14591_ _14615_/A _14615_/B _14615_/C VDD VSS _14595_/C XNOR3X1
XFILLER_25_381 VSS VDD FILLER2
X_16330_ _16512_/A _16330_/B VDD VSS _19531_/D NOR2X1
XTAP_TAPCELL_ROW_70_644 VDD VSS WELLTAP
X_13542_ _13542_/A _13542_/B _13542_/C VDD VSS _13546_/B XNOR3X1
X_10754_ _18643_/Q _18805_/Q VDD VSS _10798_/B NAND2X1
XFILLER_13_576 VDD VSS DECAPHV16
X_16261_ _19593_/Q _16743_/B VDD VSS _16262_/B XNOR2X1
XFILLER_139_740 VDD VSS FILLER4
XFILLER_13_598 VDD VSS FILLER1
X_13473_ _19055_/Q _13473_/B _13601_/D VDD VSS _13599_/C XNOR3X1
X_10685_ _10722_/A _10686_/B VDD VSS _10686_/C NAND2X1
XFILLER_158_559 VDD VSS FILLER1
XFILLER_139_751 VDD VSS FILLER1
X_18000_ _18543_/Q _18044_/B VDD VSS _18048_/B AND2X1
XFILLER_145_209 VSS VDD FILLER2
X_15212_ _15218_/B _15212_/B VDD VSS _15687_/B XNOR2X1
X_12424_ _19044_/Q _12510_/A _14313_/B VDD VSS _14282_/B XNOR3X1
X_16192_ _16203_/B _16192_/B VDD VSS _16847_/B XNOR2X1
XFILLER_166_581 VDD VSS FILLER4
XFILLER_154_732 VDD VSS FILLER1
XFILLER_138_294 VSS VDD FILLER2
X_15143_ _15183_/A _15183_/B VDD VSS _15157_/B NAND2X1
XFILLER_126_445 VDD VSS DECAPHV16
X_12355_ _18988_/Q VDD VSS _12441_/A INVX1
XFILLER_114_607 VDD VSS FILLER4
XFILLER_5_753 VDD VSS FILLER4
XFILLER_4_230 VSS VDD FILLER2
XFILLER_126_478 VDD VSS FILLER4
XFILLER_153_264 VDD VSS FILLER4
X_11306_ _11370_/A _11379_/B VDD VSS _11356_/C AND2X1
XFILLER_126_489 VSS VDD FILLER2
X_15074_ _15081_/B _15074_/B VDD VSS _15715_/B XOR2X1
X_19951_ _19956_/CK _19951_/D _19951_/Q VDD VSS DFFQX1
X_12286_ _12448_/B _12286_/B VDD VSS _12287_/C XNOR2X1
XFILLER_4_263 VSS VDD FILLER2
XFILLER_113_128 VSS VDD FILLER2
XFILLER_4_285 VSS VDD FILLER2
X_18902_ _18905_/CK _18902_/D _18902_/Q VDD VSS DFFQX1
X_14025_ _14058_/A _14085_/B VDD VSS _14138_/B XNOR2X1
X_11237_ _18578_/Q _11249_/B VDD VSS _11239_/B XOR2X1
X_19882_ clkload9/A _19882_/D _19882_/Q VDD VSS DFFQX1
XFILLER_68_716 VDD VSS FILLER4
X_18833_ _19949_/CK _18833_/D _18833_/Q VDD VSS DFFQX1
X_11168_ _11229_/D _11168_/B _11200_/C VDD VSS _11169_/D NOR3X1
XTAP_TAPCELL_ROW_78_711 VDD VSS WELLTAP
XFILLER_122_695 VSS VDD FILLER2
XFILLER_67_237 VSS VDD FILLER2
X_10119_ _18610_/Q _10126_/B VDD VSS _10123_/C XNOR2X1
X_18764_ _18818_/CK _18764_/D _18764_/Q VDD VSS DFFQX1
X_15976_ _16836_/B VDD VSS _15986_/B INVX1
X_11099_ _11497_/A _11677_/A _11099_/C VDD VSS _11136_/C MIN3X1
XFILLER_67_259 VSS VDD FILLER2
X_17715_ _17716_/C _17715_/B _17715_/C VDD VSS _19905_/D AOI21X1
X_14927_ _15016_/A _15017_/C VDD VSS _14966_/C NAND2X1
XFILLER_76_782 VDD VSS DECAPHV8
X_18695_ _18831_/CK _18695_/D _18695_/Q VDD VSS DFFQX1
XFILLER_76_793 VSS VDD FILLER2
XFILLER_91_741 VSS VDD FILLER2
XFILLER_63_432 VSS VDD FILLER2
X_17646_ _17646_/A _17646_/B _17646_/C _17646_/D VDD VSS _17647_/C AOAI211X1
X_14858_ _19392_/Q _14858_/B _15770_/B VDD VSS _14904_/B MIN3X1
X_13809_ _13873_/A _13809_/B _13918_/D VDD VSS _13876_/C XNOR3X1
X_17577_ _19875_/Q _19843_/Q _17577_/C VDD VSS _17581_/B MIN3X1
XFILLER_35_189 VSS VDD FILLER2
X_14789_ _19502_/Q _14789_/B VDD VSS _14872_/D NAND2X1
XTAP_TAPCELL_ROW_33_313 VDD VSS WELLTAP
XFILLER_51_649 VSS VDD FILLER2
X_19316_ _19349_/CK _19316_/D _19316_/Q VDD VSS DFFQX1
XFILLER_50_137 VSS VDD FILLER2
X_16528_ _16551_/C _16528_/B VDD VSS _16754_/B XNOR2X1
XFILLER_149_526 VSS VDD FILLER2
XFILLER_31_362 VDD VSS FILLER4
XFILLER_149_548 VSS VDD FILLER2
X_19247_ _20004_/CK _19247_/D _19247_/Q VDD VSS DFFQX1
X_16459_ _16459_/A _16459_/B VDD VSS _16460_/B _16459_/C NAND3X1
XFILLER_31_384 VDD VSS FILLER4
XFILLER_77_0 VSS VDD FILLER2
XFILLER_164_518 VSS VDD FILLER2
XFILLER_129_250 VDD VSS FILLER1
X_19178_ _19223_/CK _19178_/D _19178_/Q VDD VSS DFFQX1
XFILLER_164_529 VSS VDD FILLER2
XFILLER_117_412 VSS VDD FILLER2
X_18129_ _19292_/Q _18133_/B VDD VSS _18131_/C XNOR2X1
XFILLER_105_607 VDD VSS DECAPHV8
XFILLER_144_253 VSS VDD FILLER2
XFILLER_6_81 VSS VDD FILLER2
XFILLER_160_746 VSS VDD FILLER2
X_09902_ _11014_/A _09902_/B _09902_/C VDD VSS _09902_/Y OAI21X1
XFILLER_116_49 VDD VSS DECAPHV8
X_20022_ _20022_/CK _20022_/D _20022_/Q _20030_/RB VDD VSS DFFRQX1
X_09833_ _10383_/A VDD VSS _11195_/A BUFX3
XFILLER_58_204 VSS VDD FILLER2
XFILLER_101_835 VSS VDD FILLER2
X_09764_ _18372_/Q VDD VSS _20209_/A INVX1
XFILLER_74_708 VSS VDD FILLER2
XFILLER_132_26 VSS VDD FILLER2
XFILLER_67_782 VDD VSS FILLER1
X_09695_ _18303_/Q _09812_/B _09811_/C _20204_/A VDD VSS _09698_/A AOI22X1
XFILLER_54_421 VSS VDD FILLER2
XTAP_TAPCELL_ROW_84_769 VDD VSS WELLTAP
XFILLER_82_763 VSS VDD FILLER2
XFILLER_54_476 VSS VDD FILLER2
XFILLER_81_273 VDD VSS FILLER1
XFILLER_23_830 VSS VDD FILLER2
XFILLER_41_23 VSS VDD FILLER2
XFILLER_155_507 VDD VSS DECAPHV16
XFILLER_127_209 VSS VDD FILLER2
X_10470_ _18556_/Q _10474_/B VDD VSS _10472_/C XNOR2X1
XFILLER_41_89 VDD VSS FILLER4
XFILLER_135_231 VSS VDD FILLER2
XFILLER_157_89 VDD VSS FILLER4
XFILLER_136_787 VSS VDD FILLER2
X_12140_ _19068_/Q _12188_/A _12140_/C VDD VSS _12283_/B MIN3X1
XFILLER_108_489 VSS VDD FILLER2
XFILLER_123_426 VDD VSS FILLER1
XFILLER_123_448 VDD VSS FILLER1
XFILLER_1_211 VDD VSS FILLER4
X_12071_ _18984_/Q VDD VSS _12132_/A INVX1
X_11022_ _11023_/A _11023_/B _11023_/D _11023_/C VDD VSS _11024_/B AOAI211X1
XFILLER_150_278 VSS VDD FILLER2
XFILLER_1_277 VSS VDD FILLER2
XFILLER_104_695 VSS VDD FILLER2
XFILLER_89_395 VSS VDD FILLER2
XFILLER_49_237 VDD VSS FILLER4
X_15830_ _15830_/A _15830_/B VDD VSS _19445_/D NOR2X1
XFILLER_77_557 VDD VSS FILLER1
XFILLER_106_82 VSS VDD FILLER2
XFILLER_49_259 VDD VSS FILLER4
XTAP_TAPCELL_ROW_147_1338 VDD VSS WELLTAP
XFILLER_77_579 VSS VDD FILLER2
XFILLER_18_602 VSS VDD FILLER2
XFILLER_66_64 VDD VSS FILLER4
XFILLER_64_218 VSS VDD FILLER2
X_15761_ _15780_/A _15761_/B VDD VSS _19383_/D NOR2X1
XFILLER_64_229 VSS VDD FILLER2
XFILLER_58_782 VDD VSS FILLER1
X_12973_ _19134_/Q _12973_/B _13041_/C VDD VSS _13314_/B XNOR3X1
XFILLER_58_793 VSS VDD FILLER2
X_17500_ _17503_/C _17501_/B _17509_/C VDD VSS _17501_/C OAI21X1
XTAP_TAPCELL_ROW_47_438 VDD VSS WELLTAP
XFILLER_45_432 VSS VDD FILLER2
X_14712_ _19527_/Q _14712_/B VDD VSS _15893_/B XOR2X1
X_18480_ _18487_/CK _18496_/D _20125_/A _18498_/RB VDD VSS DFFRQX1
X_11924_ _19204_/Q _14493_/B VDD VSS _11987_/A NOR2BX1
X_15692_ _15706_/A _15692_/B VDD VSS _19321_/D AND2X1
XFILLER_73_763 VDD VSS DECAPHV8
X_17431_ _17431_/A _17431_/B _17431_/C VDD VSS _17439_/A OA21X2
XFILLER_72_262 VSS VDD FILLER2
X_14643_ _14671_/A _14671_/B _15861_/B VDD VSS _14700_/B MIN3X1
XFILLER_32_104 VDD VSS FILLER1
X_11855_ _19119_/Q _11966_/A _11966_/B VDD VSS _11866_/B XNOR3X1
XFILLER_45_498 VDD VSS FILLER1
XFILLER_32_115 VSS VDD FILLER2
XFILLER_17_189 VSS VDD FILLER2
XFILLER_33_649 VSS VDD FILLER2
XFILLER_32_137 VSS VDD FILLER2
X_17362_ _19829_/Q _19797_/Q _17362_/C VDD VSS _17366_/B MIN3X1
X_10806_ _10773_/B _10839_/B _10945_/A VDD VSS _10808_/B MUX2X1
XFILLER_32_148 VSS VDD FILLER2
XFILLER_13_340 VSS VDD FILLER2
X_14574_ _20012_/Q _16702_/B VDD VSS _19276_/D AND2X1
XFILLER_32_159 VSS VDD FILLER2
X_11786_ _19117_/Q _11819_/B _11790_/C VDD VSS _14365_/B XNOR3X1
XFILLER_159_835 VSS VDD FILLER2
X_19101_ _19157_/CK _19101_/D _19101_/Q VDD VSS DFFQX1
Xclkbuf_1_0__f__09176_ clkbuf_0__09176_/Y VDD VSS _18241_/CK BUFX12
X_16313_ _16313_/A _19914_/Q _16313_/C VDD VSS _16340_/C MIN3X1
XFILLER_9_311 VSS VDD FILLER2
X_13525_ _13683_/A _13683_/B _13683_/C VDD VSS _13567_/B AOI21X1
XTAP_TAPCELL_ROW_158_1434 VDD VSS WELLTAP
XFILLER_158_334 VSS VDD FILLER2
X_17293_ _17296_/C _17294_/B _17306_/C VDD VSS _17294_/C OAI21X1
X_10737_ _10843_/A _10737_/B _10737_/C _10737_/D VDD VSS _11018_/B OAI31X1
XFILLER_40_170 VSS VDD FILLER2
X_19032_ _19059_/CK _19032_/D _19032_/Q VDD VSS DFFQX1
XFILLER_40_192 VDD VSS FILLER4
X_16244_ _19688_/Q _16849_/B VDD VSS _16245_/B XNOR2X1
X_13456_ _19221_/Q _14514_/B VDD VSS _13457_/C _14514_/C NAND3X1
X_10668_ _10668_/A _10668_/B VDD VSS _10671_/B NAND2X1
XFILLER_139_581 VSS VDD FILLER2
X_12407_ _12407_/A _14531_/B _12407_/C _12407_/D VDD VSS _12577_/B AOI31X1
X_16175_ _19685_/Q _16175_/B _16846_/B VDD VSS _16201_/B MIN3X1
X_13387_ _13393_/A _13393_/B _13393_/C VDD VSS _14159_/C OR3X2
X_10599_ _18693_/Q _18747_/Q VDD VSS _10601_/C XNOR2X1
Xoutput107 _20191_/Y VDD VSS o_tst_ctrl[10] BUFX3
XFILLER_126_264 VSS VDD FILLER2
XFILLER_142_713 VSS VDD FILLER2
X_15126_ _15126_/A _15126_/B _15715_/B VDD VSS _15133_/C MIN3X1
Xoutput118 _20187_/Y VDD VSS o_tst_ctrl[6] BUFX3
XFILLER_114_415 VSS VDD FILLER2
Xoutput129 _20213_/Y VDD VSS o_uwb_tx_cfg[16] BUFX3
X_12338_ _12357_/A _12357_/B _14281_/B VDD VSS _14247_/B XNOR3X1
XFILLER_5_561 VSS VDD FILLER2
XTAP_TAPCELL_ROW_113_1028 VDD VSS WELLTAP
XFILLER_142_746 VSS VDD FILLER2
XFILLER_99_148 VDD VSS FILLER4
X_15057_ _15145_/A _15145_/B VDD VSS _15064_/B NOR2X1
X_19934_ _19934_/CK _19934_/D _19934_/Q VDD VSS DFFQX1
X_12269_ _13283_/A _17843_/B VDD VSS _18846_/D AND2X1
XFILLER_99_159 VSS VDD FILLER2
XFILLER_101_109 VDD VSS FILLER1
XFILLER_141_278 VDD VSS FILLER1
X_14008_ _19034_/Q _14302_/B _14268_/A VDD VSS _14269_/B AO21X2
X_19865_ clkload5/A _19865_/D _19865_/Q VDD VSS DFFQX1
XFILLER_68_524 VDD VSS DECAPHV8
XFILLER_110_632 VSS VDD FILLER2
XFILLER_96_855 VSS VDD FILLER2
XFILLER_110_643 VSS VDD FILLER2
X_18816_ _18845_/CK _18816_/D _18816_/Q VDD VSS DFFQX1
X_19796_ clkload4/A _19796_/D _19796_/Q VDD VSS DFFQX1
XFILLER_83_527 VDD VSS FILLER1
X_15959_ _19646_/Q VDD VSS _15988_/A INVX1
X_18747_ _18801_/CK _18747_/D _18747_/Q VDD VSS DFFQX1
XFILLER_36_421 VSS VDD FILLER2
XFILLER_36_443 VSS VDD FILLER2
X_18678_ _18788_/CK _18678_/D _18678_/Q VDD VSS DFFQX1
X_09480_ _19979_/Q _09490_/B _09482_/C VDD VSS _09481_/C AOI21X1
XFILLER_91_571 VSS VDD FILLER2
XTAP_TAPCELL_ROW_81_739 VDD VSS WELLTAP
XFILLER_91_582 VSS VDD FILLER2
X_17629_ _17776_/B _17629_/B _17629_/C VDD VSS _17634_/C MIN3X1
XFILLER_23_115 VDD VSS FILLER4
XTAP_TAPCELL_ROW_18_173 VDD VSS WELLTAP
XFILLER_23_148 VSS VDD FILLER2
XFILLER_51_468 VSS VDD FILLER2
XFILLER_51_479 VDD VSS FILLER1
XFILLER_149_334 VDD VSS FILLER1
XFILLER_32_693 VDD VSS FILLER4
XFILLER_20_844 VSS VDD FILLER2
XFILLER_137_518 VDD VSS DECAPHV8
XFILLER_118_732 VDD VSS FILLER4
XFILLER_117_220 VDD VSS FILLER4
XFILLER_117_231 VDD VSS FILLER4
XTAP_TAPCELL_ROW_135_1231 VDD VSS WELLTAP
XFILLER_133_724 VDD VSS FILLER1
XFILLER_105_426 VDD VSS FILLER1
XFILLER_145_595 VSS VDD FILLER2
XFILLER_160_521 VSS VDD FILLER2
XFILLER_105_448 VDD VSS DECAPHV16
XFILLER_132_245 VSS VDD FILLER2
XTAP_TAPCELL_ROW_89_817 VDD VSS WELLTAP
XFILLER_113_470 VDD VSS FILLER1
XFILLER_132_289 VSS VDD FILLER2
XFILLER_101_621 VDD VSS FILLER1
X_20005_ _20013_/CK _20005_/D _20005_/Q VDD VSS DFFQX1
XFILLER_100_120 VDD VSS FILLER1
X_09816_ _18455_/Q _09816_/B _09816_/C _09816_/D VDD VSS _09817_/D OA211X2
XFILLER_101_654 VSS VDD FILLER2
XFILLER_100_142 VSS VDD FILLER2
XFILLER_101_665 VSS VDD FILLER2
XFILLER_47_719 VDD VSS DECAPHV8
XFILLER_143_69 VDD VSS FILLER4
XTAP_TAPCELL_ROW_97_883 VDD VSS WELLTAP
X_09747_ _18403_/Q VDD VSS _20144_/A INVX1
XFILLER_55_730 VSS VDD FILLER2
XFILLER_55_741 VSS VDD FILLER2
XFILLER_36_34 VSS VDD FILLER2
XTAP_TAPCELL_ROW_109_995 VDD VSS WELLTAP
XFILLER_36_45 VDD VSS FILLER1
X_09678_ _18430_/Q _09696_/B VDD VSS _09679_/E NOR2X1
XTAP_TAPCELL_ROW_44_408 VDD VSS WELLTAP
XFILLER_70_700 VSS VDD FILLER2
XFILLER_55_774 VDD VSS FILLER4
XFILLER_36_67 VDD VSS FILLER1
XFILLER_42_402 VSS VDD FILLER2
XFILLER_15_627 VDD VSS DECAPHV8
XFILLER_15_649 VSS VDD FILLER2
XFILLER_14_137 VSS VDD FILLER2
XFILLER_153_4 VSS VDD FILLER2
X_11640_ _18781_/Q _11647_/B VDD VSS _18808_/D AND2X1
XFILLER_42_468 VSS VDD FILLER2
XFILLER_70_788 VSS VDD FILLER2
XFILLER_52_44 VSS VDD FILLER2
XTAP_TAPCELL_ROW_52_485 VDD VSS WELLTAP
XFILLER_11_833 VDD VSS FILLER4
X_11571_ _18718_/Q _11578_/B VDD VSS _18745_/D AND2X1
X_13310_ _14323_/A _14323_/B VDD VSS _14324_/B _14323_/C AND3X2
XFILLER_7_815 VSS VDD FILLER2
X_10522_ _10576_/A _10576_/B VDD VSS _10522_/Y NOR2X1
X_14290_ _14255_/Y _14290_/B _14290_/C VDD VSS _19023_/D AND3BX1
XFILLER_6_314 VSS VDD FILLER2
XFILLER_155_337 VSS VDD FILLER2
X_13241_ _13150_/D _13255_/C _13255_/A VDD VSS _14541_/B AND3BX1
X_10453_ _10454_/A _10454_/B _10454_/D _10454_/C VDD VSS _10521_/B AOAI211X1
XFILLER_155_359 VSS VDD FILLER2
XFILLER_109_754 VSS VDD FILLER2
XFILLER_136_573 VSS VDD FILLER2
XFILLER_124_724 VDD VSS FILLER4
X_13172_ _13295_/A _13295_/C VDD VSS _13173_/C AND2X1
X_10384_ _10579_/D _10395_/B _10395_/C _10395_/D VDD VSS _10435_/B AND4X2
XFILLER_163_370 VSS VDD FILLER2
XTAP_TAPCELL_ROW_153_1386 VDD VSS WELLTAP
XFILLER_151_532 VDD VSS FILLER4
Xclkbuf_leaf_33__000_ clkbuf_leaf_6__000_/A VDD VSS _19465_/CK BUFX12
X_12123_ _14239_/A _14240_/A _14274_/B VDD VSS _12134_/C MIN3X1
XFILLER_124_768 VSS VDD FILLER2
X_17980_ _17987_/A _17980_/B _17980_/C VDD VSS _19961_/D AOI21X1
XFILLER_123_256 VSS VDD FILLER2
XFILLER_151_576 VDD VSS FILLER4
XFILLER_111_418 VDD VSS FILLER4
XFILLER_117_81 VSS VDD FILLER2
X_16931_ _16933_/C _16931_/B _16931_/C VDD VSS _19741_/D AOI21X1
X_12054_ _19999_/Q _19263_/Q VDD VSS _12108_/C XOR2X1
XFILLER_2_575 VSS VDD FILLER2
XFILLER_123_289 VSS VDD FILLER2
XFILLER_104_481 VDD VSS FILLER4
XFILLER_77_321 VSS VDD FILLER2
XFILLER_78_855 VSS VDD FILLER2
X_11005_ _11037_/A _11037_/B _11095_/C VDD VSS _11011_/C AOI21X1
X_16862_ _16865_/A _16862_/B VDD VSS _19700_/D NOR2X1
X_19650_ _19696_/CK _19650_/D _19650_/Q VDD VSS DFFQX1
XFILLER_77_96 VSS VDD FILLER2
X_15813_ _15816_/A _15813_/B VDD VSS _19429_/D NOR2X1
X_18601_ _18612_/CK _18601_/D _18601_/Q VDD VSS DFFQX1
XFILLER_93_836 VDD VSS FILLER1
XFILLER_37_218 VSS VDD FILLER2
X_19581_ _19636_/CK _19581_/D _19581_/Q VDD VSS DFFQX1
X_16793_ _16793_/A _16793_/B VDD VSS _19639_/D AND2X1
XFILLER_92_324 VDD VSS FILLER1
XFILLER_92_335 VSS VDD FILLER2
XFILLER_46_730 VSS VDD FILLER2
XFILLER_18_421 VSS VDD FILLER2
XFILLER_133_91 VSS VDD FILLER2
X_18532_ _18543_/CK _18532_/D _18532_/Q VDD VSS DFFQX1
X_15744_ _15758_/A _15744_/B VDD VSS _19368_/D NOR2X1
XFILLER_93_51 VDD VSS FILLER1
XFILLER_18_443 VDD VSS FILLER4
X_12956_ _20009_/Q _19273_/Q VDD VSS _13049_/C AND2X1
XFILLER_46_763 VSS VDD FILLER2
XTAP_TAPCELL_ROW_164_1493 VDD VSS WELLTAP
X_18463_ _18471_/CK _18495_/D _18463_/Q _18463_/RB VDD VSS DFFRQX1
X_11907_ _19036_/Q _11907_/B _11907_/C VDD VSS _12015_/B MIN3X1
X_15675_ _18006_/C VDD VSS _16795_/A BUFX3
X_12887_ _18938_/Q VDD VSS _12992_/A INVX1
X_17414_ _19841_/Q _19809_/Q VDD VSS _17416_/B XOR2X1
X_14626_ _19524_/Q _14646_/B VDD VSS _15890_/B XOR2X1
X_18394_ _18407_/CK _18394_/D _18394_/Q _09380_/B VDD VSS DFFRQX1
X_11838_ _11876_/A wire166/Y _11838_/C VDD VSS _11839_/D XNOR3X1
XFILLER_33_468 VSS VDD FILLER2
XFILLER_60_265 VSS VDD FILLER2
XFILLER_21_619 VDD VSS FILLER1
XFILLER_20_107 VSS VDD FILLER2
X_17345_ _17346_/A _17346_/B _17346_/D _17346_/C VDD VSS _17348_/C AOI211X1
XFILLER_158_120 VSS VDD FILLER2
X_14557_ _19997_/Q _14558_/B VDD VSS _19261_/D AND2X1
XFILLER_159_654 VDD VSS FILLER4
X_11769_ _11769_/A _11769_/B _11769_/C _11769_/D VDD VSS _14521_/B AOAI211X1
XFILLER_159_665 VDD VSS FILLER4
XFILLER_158_142 VSS VDD FILLER2
XFILLER_147_827 VSS VDD FILLER2
X_13508_ _13656_/A _13656_/B _13656_/E VDD VSS _13580_/B OA21X2
X_17276_ _19812_/Q _19780_/Q VDD VSS _17281_/A XNOR2X1
X_14488_ _14493_/A _14488_/B VDD VSS _19200_/D NOR2X1
X_19015_ _19044_/CK _19015_/D _19015_/Q VDD VSS DFFQX1
X_16227_ _16219_/A _16227_/B _16227_/C VDD VSS _16251_/B AOI2B1X1
X_13439_ _19138_/Q _14419_/B VDD VSS _13548_/A AND2X1
XFILLER_127_584 VSS VDD FILLER2
X_16158_ _19556_/Q VDD VSS _16159_/A INVX1
XFILLER_142_521 VSS VDD FILLER2
XFILLER_142_543 VDD VSS FILLER4
X_15109_ _15191_/A _15155_/B VDD VSS _15183_/B XNOR2X1
XFILLER_115_768 VDD VSS FILLER1
X_16089_ _16089_/A _16112_/C VDD VSS _16735_/B XNOR2X1
XFILLER_69_811 VSS VDD FILLER2
XFILLER_130_738 VSS VDD FILLER2
X_19917_ clkload8/A _19917_/D _19917_/Q VDD VSS DFFQX1
XTAP_TAPCELL_ROW_130_1183 VDD VSS WELLTAP
X_19848_ _19853_/CK _19848_/D _19848_/Q VDD VSS DFFQX1
XFILLER_95_140 VDD VSS FILLER1
XFILLER_28_207 VSS VDD FILLER2
X_09601_ _09819_/A _09601_/B _09601_/C _09601_/D VDD VSS _18281_/D OAI211X1
XFILLER_110_484 VSS VDD FILLER2
X_19779_ _19825_/CK _19779_/D _19779_/Q VDD VSS DFFQX1
X_09532_ _20027_/Q _18199_/A VDD VSS _20028_/D NOR2BX1
XFILLER_37_752 VDD VSS FILLER4
XFILLER_37_774 VDD VSS FILLER4
XFILLER_36_240 VSS VDD FILLER2
XFILLER_64_560 VDD VSS FILLER1
XFILLER_52_700 VSS VDD FILLER2
XFILLER_36_251 VSS VDD FILLER2
XTAP_TAPCELL_ROW_106_965 VDD VSS WELLTAP
XFILLER_52_722 VSS VDD FILLER2
X_09463_ _19971_/Q _09467_/B _09476_/C VDD VSS _09464_/C AOI21X1
XFILLER_52_744 VDD VSS FILLER1
X_09394_ _18629_/Q wire167/Y VDD VSS _18231_/E NAND2BX1
XFILLER_52_788 VSS VDD FILLER2
XFILLER_52_799 VSS VDD FILLER2
XFILLER_149_153 VSS VDD FILLER2
XFILLER_20_652 VSS VDD FILLER2
XFILLER_165_613 VSS VDD FILLER2
XFILLER_138_838 VSS VDD FILLER2
XFILLER_149_175 VSS VDD FILLER2
XFILLER_165_624 VSS VDD FILLER2
XFILLER_164_101 VDD VSS FILLER1
XFILLER_20_674 VDD VSS FILLER4
XFILLER_138_25 VSS VDD FILLER2
XFILLER_138_36 VDD VSS FILLER1
XFILLER_137_359 VSS VDD FILLER2
XFILLER_145_370 VSS VDD FILLER2
XFILLER_106_735 VSS VDD FILLER2
XFILLER_79_608 VDD VSS FILLER1
XFILLER_133_565 VDD VSS FILLER1
XFILLER_121_727 VDD VSS DECAPHV16
XFILLER_78_118 VSS VDD FILLER2
XFILLER_160_373 VSS VDD FILLER2
XFILLER_120_215 VDD VSS FILLER4
XFILLER_154_79 VSS VDD FILLER2
XFILLER_47_22 VSS VDD FILLER2
XFILLER_59_365 VSS VDD FILLER2
Xfanout197 _09346_/B VDD VSS _09362_/B BUFX3
XFILLER_86_173 VDD VSS FILLER4
XFILLER_75_836 VDD VSS FILLER1
XFILLER_74_313 VSS VDD FILLER2
XTAP_TAPCELL_ROW_144_1308 VDD VSS WELLTAP
XFILLER_74_324 VDD VSS FILLER1
XTAP_TAPCELL_ROW_57_522 VDD VSS WELLTAP
X_12810_ _12913_/A _12821_/B _12821_/C VDD VSS _14349_/C OR3BX1
XFILLER_47_88 VDD VSS FILLER4
X_13790_ _13791_/A _13791_/C _13791_/B VDD VSS _14392_/A OA21X2
XFILLER_27_240 VSS VDD FILLER2
XFILLER_27_262 VSS VDD FILLER2
X_12741_ _12748_/A _14409_/B _12813_/C VDD VSS _14410_/C NOR3X1
XFILLER_63_43 VSS VDD FILLER2
X_15460_ _15674_/A _18143_/B VDD VSS _19294_/D AND2X1
XFILLER_15_468 VSS VDD FILLER2
X_12672_ _20005_/Q _19269_/Q VDD VSS _12673_/D NAND2X1
XFILLER_30_416 VSS VDD FILLER2
XFILLER_144_0 VDD VSS FILLER1
X_14411_ _14415_/A _14411_/B VDD VSS _19132_/D AND2X1
X_11623_ _18766_/Q _11624_/B VDD VSS _18793_/D AND2X1
X_15391_ _15391_/A _15391_/B _15816_/B VDD VSS _15429_/A MIN3X1
XTAP_TAPCELL_ROW_12_124 VDD VSS WELLTAP
XFILLER_156_602 VSS VDD FILLER2
X_17130_ _17132_/A _17132_/B _17130_/C VDD VSS _19780_/D AOI21X1
XFILLER_8_49 VDD VSS FILLER4
X_14342_ _14368_/A _14342_/B VDD VSS _19069_/D NOR2X1
XTAP_TAPCELL_ROW_155_1404 VDD VSS WELLTAP
X_11554_ _18703_/Q _11555_/B VDD VSS _18730_/D AND2X1
XFILLER_156_624 VDD VSS DECAPHV8
XFILLER_128_337 VSS VDD FILLER2
X_17061_ _17095_/A _17061_/B VDD VSS _19765_/D NOR2X1
X_10505_ _10548_/A _10505_/B VDD VSS _10507_/B XNOR2X1
X_14273_ _14334_/A _14273_/B VDD VSS _19010_/D AND2X1
X_11485_ _16860_/A VDD VSS _11496_/B BUFX3
XFILLER_143_318 VDD VSS FILLER1
X_16012_ _16012_/A _16836_/B VDD VSS _16013_/B XNOR2X1
X_13224_ _13365_/A _13365_/B _13365_/D VDD VSS _13268_/B OAI21X1
XTAP_TAPCELL_ROW_20_190 VDD VSS WELLTAP
X_10436_ _18635_/Q _18797_/Q VDD VSS _10476_/D XNOR2X1
XFILLER_155_189 VSS VDD FILLER2
XFILLER_124_521 VSS VDD FILLER2
XFILLER_124_543 VSS VDD FILLER2
XFILLER_3_840 VSS VDD FILLER2
X_13155_ _19192_/Q _13155_/B _13329_/C VDD VSS _13443_/B XNOR3X1
X_10367_ _10413_/A _10413_/B _10413_/C _10763_/A VDD VSS _10375_/B AOI31X1
XFILLER_88_62 VDD VSS FILLER1
XFILLER_69_107 VSS VDD FILLER2
XFILLER_2_350 VSS VDD FILLER2
X_12106_ _19236_/Q VDD VSS _12222_/A INVX1
XFILLER_111_215 VDD VSS DECAPHV8
X_17963_ _18868_/Q _17963_/B VDD VSS _17966_/D _17963_/C NAND3X1
X_13086_ _18939_/Q _13086_/B _13086_/C VDD VSS _13290_/A MIN3X1
X_10298_ _10550_/A _10465_/B VDD VSS _10298_/Y OR2X2
XFILLER_2_372 VSS VDD FILLER2
XFILLER_111_237 VSS VDD FILLER2
XFILLER_78_641 VSS VDD FILLER2
XFILLER_2_394 VSS VDD FILLER2
X_19702_ _19702_/CK _19702_/D _19702_/Q VDD VSS DFFQX1
XTAP_TAPCELL_ROW_166_1511 VDD VSS WELLTAP
X_16914_ wire164/Y VDD VSS _16978_/B BUFX3
X_12037_ _19177_/Q _14463_/B VDD VSS _12040_/C _14463_/C NAND3X1
XFILLER_26_6 VDD VSS FILLER1
X_17894_ _17894_/A _17894_/B _17894_/C VDD VSS _17901_/C MIN3X1
XFILLER_38_516 VDD VSS FILLER1
XFILLER_120_793 VSS VDD FILLER2
X_19633_ _19667_/CK _19633_/D _19633_/Q VDD VSS DFFQX1
X_16845_ _16859_/A _16845_/B VDD VSS _19684_/D AND2X1
XFILLER_65_324 VDD VSS FILLER4
XFILLER_65_346 VSS VDD FILLER2
X_16776_ _16776_/A VDD VSS _16794_/A BUFX3
X_19564_ _19600_/CK _19564_/D _19564_/Q VDD VSS DFFQX1
XFILLER_19_763 VSS VDD FILLER2
XFILLER_18_240 VSS VDD FILLER2
X_13988_ _14198_/B _14198_/C _13989_/A VDD VSS _13990_/C OAI21X1
XFILLER_53_519 VSS VDD FILLER2
XFILLER_34_700 VSS VDD FILLER2
X_15727_ _15743_/A _15727_/B VDD VSS _19352_/D AND2X1
X_18515_ _18515_/CK _18515_/D _18515_/Q _09331_/Y VDD VSS DFFRQX1
XTAP_TAPCELL_ROW_91_834 VDD VSS WELLTAP
X_12939_ _12939_/A _12939_/B _12939_/C _12939_/D VDD VSS _13113_/A OAOI211X1
X_19495_ _19508_/CK _19495_/D _19495_/Q VDD VSS DFFQX1
XTAP_TAPCELL_ROW_8_81 VDD VSS WELLTAP
XTAP_TAPCELL_ROW_121_1105 VDD VSS WELLTAP
XFILLER_61_552 VDD VSS FILLER4
X_15658_ _15658_/A _15662_/C VDD VSS _15702_/B XNOR2X1
X_18446_ _18455_/CK _18446_/D _18446_/Q _18469_/RB VDD VSS DFFRQX1
XFILLER_33_265 VSS VDD FILLER2
X_14609_ _19441_/Q _14639_/B _14613_/C VDD VSS _15795_/B XNOR3X1
X_18377_ _18391_/CK _18510_/Q _20182_/A _20065_/RB VDD VSS DFFRQX1
X_15589_ _15672_/A _18164_/B VDD VSS _19298_/D NOR2X1
X_17328_ _19822_/Q VDD VSS _17479_/B INVX1
X_17259_ _19808_/Q _19776_/Q VDD VSS _17261_/B XNOR2X1
XFILLER_134_307 VSS VDD FILLER2
XTAP_TAPCELL_ROW_132_1201 VDD VSS WELLTAP
XFILLER_162_638 VSS VDD FILLER2
XFILLER_161_115 VDD VSS FILLER4
XFILLER_108_28 VSS VDD FILLER2
XFILLER_161_126 VSS VDD FILLER2
XFILLER_115_543 VSS VDD FILLER2
XFILLER_161_159 VSS VDD FILLER2
XFILLER_103_705 VDD VSS DECAPHV8
XTAP_TAPCELL_ROW_99_901 VDD VSS WELLTAP
XFILLER_102_237 VDD VSS FILLER1
XFILLER_124_49 VSS VDD FILLER2
XFILLER_84_611 VDD VSS FILLER1
XFILLER_56_324 VDD VSS FILLER1
XFILLER_68_195 VSS VDD FILLER2
XFILLER_56_346 VDD VSS FILLER4
XFILLER_83_143 VDD VSS FILLER1
XFILLER_44_508 VSS VDD FILLER2
XTAP_TAPCELL_ROW_54_503 VDD VSS WELLTAP
X_09515_ output5/A _09515_/B _18201_/C VDD VSS _20069_/D NOR3BX1
XFILLER_83_198 VSS VDD FILLER2
XTAP_TAPCELL_ROW_26_249 VDD VSS WELLTAP
X_09446_ _09446_/A _09810_/B VDD VSS _18221_/E NOR2X1
Xclkbuf_leaf_32__001_ clkbuf_2_1__f__001_/Y VDD VSS _19157_/CK BUFX12
XFILLER_12_416 VSS VDD FILLER2
XFILLER_12_427 VSS VDD FILLER2
X_09377_ _09576_/B _09626_/B VDD VSS _09410_/B NOR2BX1
XFILLER_138_613 VDD VSS FILLER4
XFILLER_33_79 VSS VDD FILLER2
XFILLER_149_57 VDD VSS FILLER4
XFILLER_137_112 VSS VDD FILLER2
XFILLER_138_657 VSS VDD FILLER2
XFILLER_165_454 VSS VDD FILLER2
XFILLER_137_189 VSS VDD FILLER2
XFILLER_4_626 VSS VDD FILLER2
X_11270_ _18581_/Q _11274_/B VDD VSS _11275_/B XNOR2X1
XFILLER_3_103 VSS VDD FILLER2
XFILLER_153_649 VSS VDD FILLER2
XFILLER_152_137 VSS VDD FILLER2
XFILLER_3_125 VSS VDD FILLER2
XFILLER_165_45 VSS VDD FILLER2
XFILLER_152_159 VDD VSS FILLER1
X_10221_ _18594_/Q _10230_/B VDD VSS _10224_/B XNOR2X1
XFILLER_3_147 VDD VSS FILLER4
XFILLER_106_565 VSS VDD FILLER2
XTAP_TAPCELL_ROW_150_1367 VDD VSS WELLTAP
X_10152_ _18612_/Q _10152_/B _10152_/C VDD VSS _10172_/A AOI21X1
XFILLER_0_821 VDD VSS FILLER1
XFILLER_0_843 VSS VDD FILLER2
X_14960_ _14995_/A _14995_/B VDD VSS _14976_/B NOR2X1
X_10083_ _10033_/Y _10130_/B _10167_/A VDD VSS _10175_/D MUXI2X1
XFILLER_94_408 VSS VDD FILLER2
XFILLER_59_151 VSS VDD FILLER2
XFILLER_48_825 VDD VSS FILLER1
XFILLER_58_87 VDD VSS FILLER1
XFILLER_102_782 VSS VDD FILLER2
X_13911_ _13912_/D _14332_/B VDD VSS _13965_/A NAND2X1
XFILLER_87_482 VDD VSS FILLER1
XFILLER_102_793 VSS VDD FILLER2
X_14891_ _14902_/B _14891_/B VDD VSS _15710_/B XNOR2X1
XFILLER_114_60 VSS VDD FILLER2
X_16630_ _16631_/A _16631_/B _16631_/C VDD VSS _16657_/B OAI21X1
X_13842_ _13843_/A _13843_/B _13843_/D _13843_/C VDD VSS _13903_/B OAOI211X1
XFILLER_90_603 VDD VSS FILLER1
XFILLER_16_700 VDD VSS FILLER4
XFILLER_62_316 VSS VDD FILLER2
XFILLER_74_64 VDD VSS FILLER4
XFILLER_28_582 VDD VSS FILLER4
X_16561_ _16561_/A _16561_/B VDD VSS _16562_/B _16561_/C NAND3X1
XFILLER_90_647 VSS VDD FILLER2
XFILLER_62_338 VSS VDD FILLER2
X_13773_ _19002_/Q _14264_/B VDD VSS _13845_/A AND2X1
X_10985_ _10911_/Y _10984_/Y _10947_/Y VDD VSS _11119_/B MUX2X1
XTAP_TAPCELL_ROW_161_1463 VDD VSS WELLTAP
XFILLER_43_541 VDD VSS DECAPHV8
X_15512_ _19491_/Q _15512_/B _15884_/B VDD VSS _15547_/B MIN3X1
X_18300_ _18311_/CK _18513_/Q _18300_/Q _18471_/RB VDD VSS DFFRQX1
X_19280_ _19306_/CK _19280_/D _19280_/Q VDD VSS DFFQX1
X_12724_ _19102_/Q _12732_/B _12724_/C VDD VSS _12729_/B XNOR3X1
X_16492_ _16486_/B _16492_/B _16492_/C VDD VSS _16509_/A AOI2B1X1
XFILLER_16_788 VSS VDD FILLER2
XFILLER_70_360 VDD VSS FILLER4
XFILLER_43_585 VDD VSS FILLER4
X_18231_ _18232_/CK _18231_/E _18231_/ECK VDD VSS CGX3
XFILLER_43_596 VDD VSS FILLER1
X_15443_ _19490_/Q _15883_/B VDD VSS _15444_/B XNOR2X1
XFILLER_31_747 VSS VDD FILLER2
X_12655_ _12737_/A _12771_/A _12655_/C VDD VSS _12656_/D XNOR3X1
XTAP_TAPCELL_ROW_100_916 VDD VSS WELLTAP
XFILLER_30_235 VDD VSS FILLER4
XFILLER_31_769 VSS VDD FILLER2
X_18162_ _18162_/A _18162_/B _18162_/C VDD VSS _18167_/B OA21X2
X_11606_ _18750_/Q _11612_/B VDD VSS _18777_/D AND2X1
X_15374_ _19376_/Q _15753_/B VDD VSS _15376_/C XOR2X1
X_12586_ _12763_/D _12763_/B VDD VSS _12678_/C NOR2BX1
XFILLER_156_421 VSS VDD FILLER2
X_17113_ _19776_/Q VDD VSS _17263_/B INVX1
X_14325_ _14334_/A _14325_/B VDD VSS _19054_/D AND2X1
X_18093_ _18173_/A _18093_/B VDD VSS _19993_/D NOR2X1
X_11537_ _18688_/Q _11542_/B VDD VSS _18715_/D AND2X1
XFILLER_7_442 VDD VSS FILLER1
XFILLER_128_167 VDD VSS FILLER1
X_17044_ _17045_/A _17045_/B _17045_/C _17045_/D VDD VSS _17046_/B OA211X2
XFILLER_7_475 VSS VDD FILLER2
X_14256_ _14255_/Y _14256_/B _14256_/C VDD VSS _18994_/D AND3BX1
X_11468_ _17812_/A VDD VSS _11641_/B BUFX3
XFILLER_99_61 VSS VDD FILLER2
XFILLER_99_83 VSS VDD FILLER2
X_13207_ _13274_/A _13415_/B _13208_/C VDD VSS _14291_/B OR3BX1
X_10419_ _10448_/A _10448_/B _10686_/D VDD VSS _10419_/Y OAI21X1
X_14187_ _17906_/C VDD VSS _14457_/A BUFX3
X_11399_ _11398_/Y wire167/A _11399_/C VDD VSS _18598_/D AND3BX1
XFILLER_97_213 VSS VDD FILLER2
X_13138_ _13138_/A _13138_/B _13138_/C _13138_/D VDD VSS _13331_/A OAOI211X1
XFILLER_112_546 VDD VSS FILLER1
X_18995_ _19025_/CK _18995_/D _18995_/Q VDD VSS DFFQX1
XFILLER_31_4 VSS VDD FILLER2
X_17946_ _17946_/A _17946_/B _17948_/A _17948_/C VDD VSS _17958_/B OAOI211X1
X_13069_ _19023_/Q _13069_/B _13270_/D VDD VSS _13097_/C XNOR3X1
XTAP_TAPCELL_ROW_68_628 VDD VSS WELLTAP
XFILLER_78_482 VDD VSS FILLER1
X_17877_ _18853_/Q _17880_/B VDD VSS _17879_/B XOR2X1
XFILLER_38_346 VDD VSS FILLER4
X_19616_ _19722_/CK _19616_/D _19616_/Q VDD VSS DFFQX1
XFILLER_66_677 VSS VDD FILLER2
X_16828_ _16838_/A _16828_/B VDD VSS _19669_/D NOR2X1
XFILLER_93_496 VSS VDD FILLER2
XFILLER_19_582 VSS VDD FILLER2
X_19547_ _19636_/CK _19547_/D _19547_/Q VDD VSS DFFQX1
XTAP_TAPCELL_ROW_76_694 VDD VSS WELLTAP
X_16759_ _16759_/A _16759_/B VDD VSS _19608_/D NOR2X1
X_09300_ _18280_/Q input2/Y _09299_/Y VDD VSS _09300_/Y MUXI2X1
XFILLER_62_850 VSS VDD FILLER2
X_19478_ _19478_/CK _19478_/D _19478_/Q VDD VSS DFFQX1
XTAP_TAPCELL_ROW_23_219 VDD VSS WELLTAP
X_09231_ _18521_/Q VDD VSS _18356_/D INVX1
X_18429_ _18437_/CK _18429_/D _18429_/Q _20078_/RB VDD VSS DFFRQX1
XFILLER_166_207 VSS VDD FILLER2
XFILLER_166_218 VDD VSS FILLER1
XFILLER_159_270 VSS VDD FILLER2
XTAP_TAPCELL_ROW_31_296 VDD VSS WELLTAP
XFILLER_119_189 VDD VSS FILLER4
XFILLER_134_115 VDD VSS FILLER4
Xclkbuf_leaf_3_clk_regs clkload1/A VDD VSS clkload2/A BUFX12
XFILLER_162_479 VSS VDD FILLER2
XFILLER_115_351 VDD VSS FILLER4
XFILLER_88_202 VDD VSS FILLER4
XFILLER_1_618 VSS VDD FILLER2
XFILLER_135_26 VSS VDD FILLER2
XFILLER_89_747 VSS VDD FILLER2
X_20184_ _20184_/A VDD VSS _20184_/Y BUFX3
XFILLER_88_224 VSS VDD FILLER2
XFILLER_135_48 VSS VDD FILLER2
X_09995_ _09996_/A _09996_/B _09996_/C VDD VSS _09997_/B NOR3X1
XFILLER_88_235 VSS VDD FILLER2
XFILLER_131_855 VSS VDD FILLER2
XFILLER_103_557 VDD VSS FILLER1
XFILLER_130_376 VDD VSS FILLER4
XFILLER_28_24 VSS VDD FILLER2
XFILLER_57_644 VDD VSS FILLER4
XFILLER_56_132 VDD VSS FILLER4
XFILLER_72_603 VDD VSS FILLER1
XFILLER_45_817 VDD VSS DECAPHV8
XFILLER_151_69 VSS VDD FILLER2
XTAP_TAPCELL_ROW_39_363 VDD VSS WELLTAP
XFILLER_57_699 VDD VSS FILLER4
XFILLER_44_316 VSS VDD FILLER2
XFILLER_56_176 VDD VSS FILLER4
XFILLER_71_113 VSS VDD FILLER2
XFILLER_56_187 VSS VDD FILLER2
XFILLER_72_658 VDD VSS DECAPHV8
XFILLER_13_714 VSS VDD FILLER2
X_10770_ _18628_/Q _18724_/Q VDD VSS _10771_/C NAND2X1
XFILLER_80_680 VSS VDD FILLER2
XFILLER_52_382 VSS VDD FILLER2
XFILLER_12_224 VSS VDD FILLER2
XFILLER_13_747 VDD VSS DECAPHV8
X_09429_ _09447_/B _09751_/B VDD VSS _18235_/E NOR2X1
XFILLER_158_708 VSS VDD FILLER2
XFILLER_12_235 VSS VDD FILLER2
XFILLER_157_207 VSS VDD FILLER2
XFILLER_12_257 VSS VDD FILLER2
X_12440_ _18960_/Q _12440_/B _14211_/B VDD VSS _12535_/B MIN3X1
XFILLER_8_217 VDD VSS FILLER1
XFILLER_40_577 VDD VSS FILLER1
XFILLER_157_229 VSS VDD FILLER2
XFILLER_12_279 VSS VDD FILLER2
XFILLER_100_84 VSS VDD FILLER2
XFILLER_138_421 VSS VDD FILLER2
XFILLER_166_730 VDD VSS DECAPHV8
XFILLER_8_239 VSS VDD FILLER2
XFILLER_21_780 VDD VSS FILLER4
XFILLER_166_752 VSS VDD FILLER2
XFILLER_60_55 VDD VSS FILLER4
XFILLER_166_763 VSS VDD FILLER2
X_12371_ _12544_/A _12544_/B _12544_/C VDD VSS _12419_/B AOI21X1
XFILLER_153_402 VDD VSS FILLER1
X_14110_ _18899_/Q _14142_/B VDD VSS _14111_/D NOR2BX1
XFILLER_126_638 VDD VSS FILLER1
X_11322_ _11325_/B _11322_/B _11331_/A VDD VSS _11325_/C OAI21X1
XFILLER_60_99 VDD VSS FILLER4
XFILLER_126_649 VSS VDD FILLER2
X_15090_ _15090_/A _15776_/B VDD VSS _15138_/B NOR2X1
XFILLER_153_446 VDD VSS FILLER1
XFILLER_107_0 VDD VSS FILLER4
XFILLER_109_71 VSS VDD FILLER2
XFILLER_153_468 VSS VDD FILLER2
X_14041_ _14041_/A _14043_/B _14041_/C VDD VSS _14236_/B OA21X2
X_11253_ _11253_/A _11253_/B _11253_/C _11253_/D VDD VSS _11262_/B AOAI211X1
XFILLER_4_456 VDD VSS FILLER1
XFILLER_106_362 VDD VSS FILLER1
XFILLER_122_811 VDD VSS FILLER1
XFILLER_134_682 VSS VDD FILLER2
X_10204_ _18592_/Q _10220_/C VDD VSS _10204_/Y XNOR2X1
X_11184_ _11184_/A _11221_/B VDD VSS _11184_/Y XOR2X1
X_17800_ _19923_/Q _19891_/Q _17800_/C VDD VSS _17803_/C MIN3X1
X_10135_ _10150_/D _10150_/B VDD VSS _10136_/B NOR2BX1
X_15992_ _19582_/Q _16731_/B VDD VSS _15993_/C NOR2X1
X_18780_ _19940_/CK _18780_/D _18780_/Q VDD VSS DFFQX1
XFILLER_0_673 VSS VDD FILLER2
XFILLER_48_611 VSS VDD FILLER2
XFILLER_0_684 VSS VDD FILLER2
XFILLER_85_30 VSS VDD FILLER2
X_14943_ _19366_/Q _15742_/B VDD VSS _14944_/B XNOR2X1
X_17731_ _19909_/Q _19877_/Q VDD VSS _17738_/C NOR2X1
X_10066_ _18584_/Q VDD VSS _11302_/A INVX1
XFILLER_47_110 VSS VDD FILLER2
XFILLER_75_463 VSS VDD FILLER2
XFILLER_63_603 VSS VDD FILLER2
X_14874_ _19503_/Q _14874_/B VDD VSS _15015_/C NAND2X1
X_17662_ _19894_/Q _19862_/Q VDD VSS _17667_/A XNOR2X1
XFILLER_63_614 VSS VDD FILLER2
XFILLER_85_96 VSS VDD FILLER2
XFILLER_63_625 VSS VDD FILLER2
X_19401_ _19406_/CK _19401_/D _19401_/Q VDD VSS DFFQX1
X_16613_ _16613_/A _16620_/C VDD VSS _16899_/B XNOR2X1
X_13825_ _18948_/Q VDD VSS _13989_/A INVX1
XFILLER_47_198 VSS VDD FILLER2
X_17593_ _17596_/C _17594_/B _17597_/C VDD VSS _17594_/C OAI21X1
XFILLER_90_455 VSS VDD FILLER2
XFILLER_141_91 VSS VDD FILLER2
X_16544_ _19699_/Q _16861_/B VDD VSS _16561_/A NAND2BX1
X_19332_ _19333_/CK _19332_/D _19332_/Q VDD VSS DFFQX1
X_13756_ _14132_/A _14132_/B VDD VSS _13802_/B NOR2X1
X_10968_ _18676_/Q _18784_/Q VDD VSS _11007_/C NOR2X1
XFILLER_43_371 VDD VSS FILLER1
XFILLER_149_708 VSS VDD FILLER2
X_12707_ _12789_/A _12789_/B _14151_/B VDD VSS _12883_/B MIN3X1
X_16475_ _19568_/Q VDD VSS _16476_/A INVX1
X_19263_ _20000_/CK _19263_/D _19263_/Q VDD VSS DFFQX1
X_13687_ _18973_/Q _13830_/A _13830_/B VDD VSS _13688_/D XNOR3X1
X_10899_ _18673_/Q _18781_/Q _10899_/C VDD VSS _10936_/C MIN3X1
X_15426_ _19405_/Q _15786_/B VDD VSS _15427_/C NOR2BX1
X_18214_ _18235_/CK _18214_/E _18214_/ECK VDD VSS CGX3
X_19194_ _19250_/CK _19194_/D _19194_/Q VDD VSS DFFQX1
X_12638_ _12732_/A _12732_/B VDD VSS _14379_/B _12732_/C AND3X2
XTAP_TAPCELL_ROW_5_60 VDD VSS WELLTAP
XFILLER_79_4 VDD VSS FILLER4
X_15357_ _19542_/Q _15357_/B VDD VSS _15910_/B XOR2X1
X_18145_ _18150_/A _18146_/B _18187_/C VDD VSS _18146_/C OAI21X1
X_12569_ _19240_/Q _14534_/A _14534_/B VDD VSS _12571_/C NOR3X1
XFILLER_129_476 VDD VSS FILLER4
XFILLER_129_487 VSS VDD FILLER2
X_14308_ _14311_/A _14308_/B VDD VSS _19040_/D NOR2X1
X_18076_ _18078_/B _18076_/B VDD VSS _18083_/B NAND2BX1
X_15288_ _15304_/A _15783_/B VDD VSS _15305_/C XNOR2X1
X_17027_ _17028_/A _17030_/A _17030_/B _18087_/D VDD VSS _17028_/D AOAI211X1
XTAP_TAPCELL_ROW_116_1059 VDD VSS WELLTAP
X_14239_ _14239_/A _14274_/B VDD VSS _14240_/B XNOR2X1
XFILLER_125_660 VDD VSS FILLER1
XFILLER_112_321 VDD VSS FILLER4
Xclkbuf_1_1__f__09172_ clkbuf_0__09172_/Y VDD VSS _18325_/CK BUFX12
XFILLER_124_181 VSS VDD FILLER2
XFILLER_112_354 VDD VSS FILLER4
XFILLER_58_408 VSS VDD FILLER2
XFILLER_100_505 VDD VSS FILLER4
X_09780_ _18373_/Q VDD VSS _20210_/A INVX1
X_18978_ _19115_/CK _18978_/D _18978_/Q VDD VSS DFFQX1
XFILLER_22_0 VDD VSS FILLER1
XFILLER_100_538 VDD VSS FILLER4
X_17929_ _18863_/Q _17929_/B VDD VSS _17941_/A AND2X1
XFILLER_81_400 VSS VDD FILLER2
XTAP_TAPCELL_ROW_127_1155 VDD VSS WELLTAP
XFILLER_93_282 VSS VDD FILLER2
XFILLER_93_293 VDD VSS FILLER1
XFILLER_19_390 VSS VDD FILLER2
XTAP_TAPCELL_ROW_36_333 VDD VSS WELLTAP
XFILLER_41_308 VSS VDD FILLER2
XFILLER_81_477 VDD VSS FILLER4
XFILLER_81_499 VSS VDD FILLER2
XFILLER_139_218 VSS VDD FILLER2
XFILLER_14_59 VSS VDD FILLER2
X_09214_ _18514_/Q VDD VSS _18413_/D INVX1
XFILLER_22_577 VSS VDD FILLER2
XTAP_TAPCELL_ROW_138_1251 VDD VSS WELLTAP
XFILLER_135_424 VSS VDD FILLER2
XFILLER_163_733 VSS VDD FILLER2
XFILLER_107_126 VSS VDD FILLER2
XFILLER_146_14 VDD VSS FILLER4
XTAP_TAPCELL_ROW_1_18 VDD VSS WELLTAP
XFILLER_30_58 VDD VSS FILLER4
XFILLER_135_468 VSS VDD FILLER2
XFILLER_123_619 VSS VDD FILLER2
XFILLER_163_788 VSS VDD FILLER2
XFILLER_122_107 VSS VDD FILLER2
XFILLER_150_416 VSS VDD FILLER2
XFILLER_162_298 VSS VDD FILLER2
XFILLER_143_490 VSS VDD FILLER2
XFILLER_103_332 VSS VDD FILLER2
XFILLER_104_855 VSS VDD FILLER2
XFILLER_1_459 VDD VSS FILLER4
X_20167_ _20167_/A VDD VSS _20167_/Y BUFX3
XFILLER_49_419 VSS VDD FILLER2
X_20098_ _20098_/A VDD VSS _20098_/Y BUFX3
XFILLER_76_249 VDD VSS FILLER1
X_11940_ _19093_/Q _11963_/A _12022_/B VDD VSS _12018_/B XNOR3X1
XFILLER_55_11 VSS VDD FILLER2
XFILLER_85_783 VSS VDD FILLER2
XFILLER_45_625 VSS VDD FILLER2
XFILLER_57_485 VSS VDD FILLER2
X_11871_ _19203_/Q _11871_/B _11979_/C VDD VSS _11915_/C XNOR3X1
X_13610_ _13733_/A _13610_/B VDD VSS _14295_/B XNOR2X1
X_10822_ _10856_/D _10856_/C VDD VSS _10823_/B NAND2BX1
X_14590_ _14601_/A _14601_/B _14601_/D VDD VSS _14615_/C AOI21X1
XFILLER_25_360 VSS VDD FILLER2
XFILLER_25_371 VDD VSS FILLER1
X_13541_ _13696_/A _13696_/B _13696_/C VDD VSS _13564_/B AOI21X1
X_10753_ _18643_/Q _18805_/Q VDD VSS _10798_/D NOR2X1
XTAP_TAPCELL_ROW_70_645 VDD VSS WELLTAP
XFILLER_71_43 VDD VSS FILLER4
XFILLER_158_527 VDD VSS FILLER1
X_16260_ _16285_/C _16260_/B VDD VSS _16743_/B XNOR2X1
XFILLER_71_65 VDD VSS DECAPHV8
X_13472_ _19083_/Q _13623_/A _13696_/B VDD VSS _13601_/D XNOR3X1
XFILLER_158_549 VDD VSS FILLER1
X_10684_ _10722_/B _10725_/A VDD VSS _10686_/B NAND2BX1
X_15211_ _15218_/A _15718_/B VDD VSS _15212_/B XNOR2X1
X_12423_ _12519_/B _12519_/C VDD VSS _14313_/B OR2X2
X_16191_ _19654_/Q _16202_/A VDD VSS _16192_/B XNOR2X1
XFILLER_154_700 VSS VDD FILLER2
XFILLER_139_785 VDD VSS DECAPHV8
Xdelaybuf_7_clk delaybuf_7_clk/A VDD VSS delaybuf_8_clk/A BUFX12
X_15142_ _15198_/A _15198_/B VDD VSS _15158_/B NOR2X1
XFILLER_5_710 VDD VSS FILLER1
X_12354_ _12354_/A _12354_/B _14210_/B VDD VSS _12440_/B MIN3X1
XFILLER_153_232 VSS VDD FILLER2
XFILLER_4_220 VSS VDD FILLER2
XFILLER_126_468 VSS VDD FILLER2
X_11305_ _11383_/A _11305_/B VDD VSS _18584_/D NOR2X1
X_15073_ _19369_/Q _15746_/B VDD VSS _15074_/B XNOR2X1
X_19950_ _19956_/CK _19950_/D _19950_/Q VDD VSS DFFQX1
XFILLER_5_765 VDD VSS FILLER4
XFILLER_154_788 VSS VDD FILLER2
X_12285_ _12285_/A _12285_/B _14307_/B VDD VSS _14275_/A MIN3X1
X_18901_ _18961_/CK _18901_/D _18901_/Q VDD VSS DFFQX1
X_14024_ _14163_/A _17957_/B _17957_/C VDD VSS _18867_/D NOR3X1
XFILLER_106_170 VSS VDD FILLER2
X_11236_ _11236_/A _11241_/B VDD VSS _11249_/B XNOR2X1
X_19881_ clkload9/A _19881_/D _19881_/Q VDD VSS DFFQX1
XFILLER_106_192 VSS VDD FILLER2
XFILLER_122_663 VSS VDD FILLER2
X_18832_ _19949_/CK _18832_/D _18832_/Q VDD VSS DFFQX1
XFILLER_110_814 VSS VDD FILLER2
X_11167_ _11167_/A _11167_/B _11167_/C _11167_/D VDD VSS _11200_/C OAOI211X1
XTAP_TAPCELL_ROW_78_712 VDD VSS WELLTAP
XFILLER_121_184 VSS VDD FILLER2
X_10118_ _10018_/Y _10117_/Y _10131_/A VDD VSS _10126_/B MUXI2X1
XFILLER_96_84 VSS VDD FILLER2
X_18763_ _18818_/CK _18763_/D _18763_/Q VDD VSS DFFQX1
X_15975_ _15975_/A _15975_/B VDD VSS _16836_/B XOR2X1
X_11098_ _18814_/Q VDD VSS _11677_/A INVX1
X_17714_ _17716_/C _17715_/B _17746_/C VDD VSS _17715_/C OAI21X1
XFILLER_76_772 VSS VDD FILLER2
XFILLER_48_463 VSS VDD FILLER2
XFILLER_36_603 VDD VSS FILLER1
X_14926_ _19505_/Q _15899_/B VDD VSS _15017_/C NAND2BX1
X_10049_ _10053_/A _10053_/B VDD VSS _10051_/A XNOR2X1
X_18694_ _19947_/CK _18694_/D _18694_/Q VDD VSS DFFQX1
XFILLER_91_720 VDD VSS FILLER1
XFILLER_48_485 VSS VDD FILLER2
XFILLER_75_282 VSS VDD FILLER2
XFILLER_63_422 VSS VDD FILLER2
XFILLER_36_636 VSS VDD FILLER2
X_17645_ _17646_/A _17646_/B _17646_/D _17646_/C VDD VSS _17648_/C AOI211X1
XFILLER_36_658 VSS VDD FILLER2
X_14857_ _14857_/A _14857_/B _15739_/B VDD VSS _14902_/B MIN3X1
XFILLER_91_764 VDD VSS FILLER4
XFILLER_35_146 VSS VDD FILLER2
XFILLER_91_775 VDD VSS DECAPHV8
X_13808_ _18919_/Q VDD VSS _13873_/A INVX1
X_14788_ _15895_/B VDD VSS _14789_/B INVX1
X_17576_ _19876_/Q _19844_/Q VDD VSS _17581_/A XNOR2X1
XFILLER_16_360 VDD VSS FILLER1
XFILLER_63_499 VSS VDD FILLER2
XTAP_TAPCELL_ROW_33_314 VDD VSS WELLTAP
XFILLER_50_127 VDD VSS FILLER4
X_19315_ _19349_/CK _19315_/D _19315_/Q VDD VSS DFFQX1
X_16527_ _19571_/Q _19923_/Q VDD VSS _16528_/B XNOR2X1
X_13739_ _18946_/Q _13739_/B _13771_/C VDD VSS _13918_/B XNOR3X1
XFILLER_31_341 VDD VSS FILLER1
XFILLER_149_538 VSS VDD FILLER2
X_19246_ _20004_/CK _19246_/D _19246_/Q VDD VSS DFFQX1
X_16458_ _16459_/A _16459_/B _16459_/C VDD VSS _16470_/C AO21X2
X_15409_ _15429_/A _15429_/B VDD VSS _15786_/B XNOR2X1
XTAP_TAPCELL_ROW_41_380 VDD VSS WELLTAP
X_16389_ _19661_/Q _16819_/B VDD VSS _16406_/A NOR2X1
X_19177_ _19223_/CK _19177_/D _19177_/Q VDD VSS DFFQX1
XFILLER_117_402 VSS VDD FILLER2
XFILLER_145_722 VSS VDD FILLER2
XFILLER_129_273 VDD VSS FILLER4
XFILLER_145_733 VSS VDD FILLER2
X_18128_ _19291_/Q _18128_/B VDD VSS _18131_/A NOR2BX1
XFILLER_117_435 VDD VSS FILLER1
XFILLER_129_295 VSS VDD FILLER2
XFILLER_8_592 VDD VSS FILLER4
XFILLER_145_766 VDD VSS FILLER4
XFILLER_117_468 VDD VSS DECAPHV8
XFILLER_105_619 VSS VDD FILLER2
XFILLER_145_788 VDD VSS FILLER4
X_18059_ _19278_/Q _18059_/B VDD VSS _18064_/A NOR2X1
X_09901_ _11014_/A _09901_/B VDD VSS _09902_/C NAND2X1
XFILLER_132_438 VSS VDD FILLER2
XFILLER_144_298 VSS VDD FILLER2
XFILLER_113_630 VDD VSS DECAPHV8
XFILLER_98_330 VDD VSS FILLER1
XFILLER_160_769 VSS VDD FILLER2
X_20021_ _20022_/CK _20021_/D _20021_/Q _20030_/RB VDD VSS DFFRQX1
XFILLER_113_663 VSS VDD FILLER2
X_09832_ _11435_/B _11196_/A _11435_/A VDD VSS _10304_/A NOR3BX1
XFILLER_112_151 VSS VDD FILLER2
XFILLER_86_514 VSS VDD FILLER2
XFILLER_112_173 VSS VDD FILLER2
XFILLER_140_493 VDD VSS FILLER4
Xclkbuf_0__09186_ _18235_/ECK VDD VSS clkbuf_0__09186_/Y BUFX12
X_09763_ _18356_/Q VDD VSS _20224_/A INVX1
XFILLER_39_430 VSS VDD FILLER2
XFILLER_67_761 VSS VDD FILLER2
X_09694_ _20140_/A _20188_/A _09626_/B VDD VSS _09699_/D MUX2X1
XFILLER_39_474 VDD VSS FILLER1
XFILLER_27_614 VSS VDD FILLER2
XFILLER_132_49 VSS VDD FILLER2
XFILLER_54_411 VDD VSS FILLER1
XFILLER_39_496 VDD VSS FILLER4
XFILLER_54_433 VDD VSS FILLER1
XFILLER_81_252 VDD VSS DECAPHV8
XFILLER_42_617 VSS VDD FILLER2
XFILLER_81_263 VDD VSS DECAPHV8
XFILLER_25_25 VSS VDD FILLER2
XFILLER_82_797 VSS VDD FILLER2
XFILLER_35_691 VDD VSS FILLER1
XFILLER_41_149 VSS VDD FILLER2
XFILLER_10_503 VDD VSS FILLER1
XFILLER_10_514 VSS VDD FILLER2
XFILLER_50_694 VSS VDD FILLER2
XFILLER_10_536 VDD VSS FILLER1
XFILLER_136_700 VSS VDD FILLER2
XFILLER_136_711 VSS VDD FILLER2
XFILLER_148_582 VSS VDD FILLER2
XFILLER_148_593 VSS VDD FILLER2
XFILLER_157_57 VDD VSS FILLER1
XFILLER_136_755 VSS VDD FILLER2
XFILLER_135_254 VDD VSS DECAPHV16
XFILLER_108_479 VSS VDD FILLER2
XFILLER_123_405 VSS VDD FILLER2
XFILLER_163_574 VSS VDD FILLER2
XFILLER_123_416 VDD VSS DECAPHV8
XFILLER_163_585 VDD VSS FILLER1
XFILLER_2_724 VSS VDD FILLER2
XFILLER_163_596 VSS VDD FILLER2
XFILLER_151_747 VSS VDD FILLER2
XFILLER_150_235 VDD VSS FILLER4
X_12070_ _12070_/A _12070_/B _14206_/B VDD VSS _12131_/B MIN3X1
XFILLER_104_630 VDD VSS FILLER1
XFILLER_116_490 VDD VSS FILLER4
XFILLER_151_769 VSS VDD FILLER2
XFILLER_2_757 VSS VDD FILLER2
XFILLER_150_257 VDD VSS FILLER1
XFILLER_1_245 VDD VSS FILLER1
XFILLER_150_268 VDD VSS FILLER1
X_11021_ _18571_/Q _11021_/B VDD VSS _11023_/C XOR2X1
XFILLER_2_779 VSS VDD FILLER2
XFILLER_103_140 VSS VDD FILLER2
X_20219_ _20219_/A VDD VSS _20219_/Y BUFX3
XFILLER_131_460 VDD VSS FILLER4
XFILLER_66_21 VSS VDD FILLER2
XTAP_TAPCELL_ROW_147_1339 VDD VSS WELLTAP
XFILLER_92_506 VDD VSS FILLER4
X_15760_ _15817_/A VDD VSS _15780_/A BUFX3
X_12972_ _19162_/Q _12972_/B _13108_/D VDD VSS _13041_/C XNOR3X1
XFILLER_57_260 VSS VDD FILLER2
XTAP_TAPCELL_ROW_47_439 VDD VSS WELLTAP
XFILLER_57_282 VDD VSS FILLER4
X_14711_ _19526_/Q _14742_/C VDD VSS _14712_/B NAND2X1
X_11923_ _12048_/A _12048_/B VDD VSS _14493_/B XNOR2X1
XFILLER_73_742 VSS VDD FILLER2
X_15691_ _15693_/A _15691_/B VDD VSS _19320_/D NOR2X1
XFILLER_72_241 VSS VDD FILLER2
XFILLER_73_775 VDD VSS FILLER1
X_17430_ _19844_/Q _19812_/Q VDD VSS _17431_/C NAND2X1
X_14642_ _14658_/A _14658_/B VDD VSS _15861_/B XNOR2X1
XFILLER_33_617 VSS VDD FILLER2
X_11854_ _11854_/A _11854_/B _14429_/B VDD VSS _11966_/B MIN3X1
XFILLER_45_488 VDD VSS FILLER1
XFILLER_82_53 VSS VDD FILLER2
X_10805_ _10805_/A _10805_/B _10805_/C VDD VSS _10839_/B OA21X2
X_17361_ _19830_/Q _19798_/Q VDD VSS _17366_/A XNOR2X1
X_14573_ _20011_/Q _16702_/B VDD VSS _19275_/D AND2X1
X_11785_ _19145_/Q _11818_/B _14427_/B VDD VSS _11790_/C XOR3X1
XFILLER_82_86 VSS VDD FILLER2
Xclkbuf_1_0__f__09175_ clkbuf_0__09175_/Y VDD VSS _18268_/CK BUFX12
XFILLER_158_302 VSS VDD FILLER2
XFILLER_13_352 VDD VSS FILLER4
X_19100_ _19126_/CK _19100_/D _19100_/Q VDD VSS DFFQX1
XFILLER_9_301 VSS VDD FILLER2
X_16312_ _19562_/Q VDD VSS _16313_/A INVX1
X_13524_ _13599_/A _14294_/B _14294_/C VDD VSS _13683_/C NOR3X1
XFILLER_41_672 VDD VSS FILLER4
XFILLER_158_324 VDD VSS FILLER1
X_17292_ _19815_/Q _19783_/Q VDD VSS _17294_/B XOR2X1
X_10736_ _10843_/A _10736_/B VDD VSS _10737_/D NAND2X1
XTAP_TAPCELL_ROW_158_1435 VDD VSS WELLTAP
XFILLER_9_323 VDD VSS FILLER1
XFILLER_15_91 VSS VDD FILLER2
XFILLER_41_694 VSS VDD FILLER2
X_16243_ _16243_/A _16253_/B VDD VSS _16849_/B XOR2X1
X_19031_ _19059_/CK _19031_/D _19031_/Q VDD VSS DFFQX1
X_13455_ _14514_/B _14514_/C _19221_/Q VDD VSS _13457_/B AOI21X1
X_10667_ _10668_/A _10668_/B VDD VSS _10667_/Y NOR2X1
XFILLER_139_571 VSS VDD FILLER2
XFILLER_127_722 VDD VSS FILLER1
X_12406_ _12497_/A _14503_/B VDD VSS _12486_/B NOR2X1
X_16174_ _19717_/Q _16174_/B _16881_/B VDD VSS _16196_/A MIN3X1
X_13386_ _13393_/A _13393_/B _13393_/C VDD VSS _14159_/B OAI21X1
X_10598_ _18692_/Q _18746_/Q VDD VSS _10649_/A NAND2X1
XFILLER_154_552 VDD VSS DECAPHV8
X_15125_ _19341_/Q VDD VSS _15126_/A INVX1
Xoutput108 _20192_/Y VDD VSS o_tst_ctrl[11] BUFX3
X_12337_ _12361_/A _12361_/B _12514_/C VDD VSS _14281_/B XNOR3X1
XFILLER_31_90 VSS VDD FILLER2
Xoutput119 _20188_/Y VDD VSS o_tst_ctrl[7] BUFX3
XFILLER_99_105 VSS VDD FILLER2
XFILLER_142_725 VSS VDD FILLER2
XFILLER_126_287 VSS VDD FILLER2
XTAP_TAPCELL_ROW_113_1029 VDD VSS WELLTAP
XFILLER_126_298 VDD VSS FILLER1
XFILLER_114_449 VDD VSS DECAPHV8
X_15056_ _15056_/A _15056_/B _15056_/C _15056_/D VDD VSS _15145_/B OAOI211X1
X_19933_ _19934_/CK _19933_/D _19933_/Q VDD VSS DFFQX1
X_12268_ _18874_/Q _12349_/B _12272_/C VDD VSS _17843_/B XNOR3X1
X_14007_ wire153/Y _14010_/B _14010_/D _14010_/C VDD VSS _14268_/A OA211X2
X_11219_ _11219_/A _11220_/C _11219_/C _11431_/A VDD VSS _18577_/D OA211X2
XFILLER_96_812 VDD VSS FILLER4
X_19864_ clkload5/A _19864_/D _19864_/Q VDD VSS DFFQX1
XFILLER_68_514 VSS VDD FILLER2
X_12199_ _12199_/A _12199_/B _14208_/B VDD VSS _12277_/B MIN3X1
Xoutput90 _20174_/Y VDD VSS o_lf_cfg[11] BUFX3
XFILLER_95_311 VSS VDD FILLER2
XFILLER_95_322 VSS VDD FILLER2
X_18815_ _19959_/CK _18815_/D _18815_/Q VDD VSS DFFQX1
X_19795_ _19934_/CK _19795_/D _19795_/Q VDD VSS DFFQX1
XFILLER_49_761 VDD VSS DECAPHV8
XFILLER_55_208 VSS VDD FILLER2
XFILLER_110_688 VSS VDD FILLER2
X_18746_ _18801_/CK _18746_/D _18746_/Q VDD VSS DFFQX1
X_15958_ _15975_/B _15975_/A _15958_/C VDD VSS _15989_/A AOI2B1X1
XFILLER_64_731 VSS VDD FILLER2
X_14909_ _14931_/A _14909_/B VDD VSS _15804_/B XNOR2X1
X_18677_ _19954_/CK _18677_/D _18677_/Q VDD VSS DFFQX1
X_15889_ _15895_/A _15889_/B VDD VSS _19496_/D NOR2X1
XTAP_TAPCELL_ROW_124_1125 VDD VSS WELLTAP
XFILLER_91_561 VDD VSS FILLER4
XFILLER_63_252 VDD VSS FILLER1
X_17628_ _19886_/Q VDD VSS _17776_/B INVX1
XTAP_TAPCELL_ROW_18_174 VDD VSS WELLTAP
XFILLER_51_436 VDD VSS DECAPHV8
XFILLER_23_127 VDD VSS FILLER1
XFILLER_17_691 VDD VSS FILLER4
X_17559_ _17562_/C _17560_/B _17597_/C VDD VSS _17560_/C OAI21X1
XFILLER_20_801 VSS VDD FILLER2
XFILLER_149_357 VSS VDD FILLER2
XFILLER_165_806 VSS VDD FILLER2
XFILLER_165_817 VSS VDD FILLER2
X_19229_ _19995_/CK _19229_/D _19229_/Q VDD VSS DFFQX1
XFILLER_118_700 VSS VDD FILLER2
XFILLER_118_755 VSS VDD FILLER2
XTAP_TAPCELL_ROW_135_1232 VDD VSS WELLTAP
XFILLER_11_38 VSS VDD FILLER2
XFILLER_127_16 VDD VSS FILLER4
XFILLER_117_254 VSS VDD FILLER2
XFILLER_105_405 VSS VDD FILLER2
XFILLER_118_788 VSS VDD FILLER2
XFILLER_133_714 VDD VSS DECAPHV8
XFILLER_127_38 VSS VDD FILLER2
XFILLER_145_585 VSS VDD FILLER2
XFILLER_133_747 VDD VSS FILLER4
XFILLER_117_298 VSS VDD FILLER2
XFILLER_132_235 VDD VSS FILLER4
XFILLER_99_661 VSS VDD FILLER2
XTAP_TAPCELL_ROW_89_818 VDD VSS WELLTAP
XFILLER_99_683 VDD VSS FILLER1
XFILLER_98_160 VSS VDD FILLER2
XFILLER_101_611 VDD VSS DECAPHV8
XFILLER_59_536 VSS VDD FILLER2
X_20004_ _20004_/CK _20004_/D _20004_/Q VDD VSS DFFQX1
X_09815_ _18359_/Q _09815_/B _09815_/C _18327_/Q _09815_/E VDD VSS _09816_/C AOI221X1
XFILLER_59_547 VSS VDD FILLER2
XFILLER_86_344 VDD VSS DECAPHV8
XFILLER_100_165 VSS VDD FILLER2
Xclkbuf_0__09169_ _18218_/ECK VDD VSS clkbuf_0__09169_/Y BUFX12
X_09746_ _18451_/Q VDD VSS _20149_/A INVX1
XTAP_TAPCELL_ROW_97_884 VDD VSS WELLTAP
XFILLER_101_699 VSS VDD FILLER2
XFILLER_86_388 VDD VSS DECAPHV16
XFILLER_39_282 VDD VSS FILLER4
XFILLER_39_293 VSS VDD FILLER2
X_09677_ _18302_/Q _09812_/B _09784_/B _18462_/Q VDD VSS _09680_/B AOI22X1
XTAP_TAPCELL_ROW_109_996 VDD VSS WELLTAP
XFILLER_54_230 VSS VDD FILLER2
XFILLER_27_444 VDD VSS FILLER4
XTAP_TAPCELL_ROW_44_409 VDD VSS WELLTAP
XFILLER_82_572 VDD VSS FILLER1
XFILLER_55_786 VDD VSS FILLER1
XFILLER_27_488 VSS VDD FILLER2
XFILLER_70_734 VDD VSS DECAPHV8
XFILLER_42_436 VSS VDD FILLER2
XFILLER_42_458 VSS VDD FILLER2
XFILLER_11_801 VSS VDD FILLER2
X_11570_ _18717_/Q _11578_/B VDD VSS _18744_/D AND2X1
XFILLER_128_508 VSS VDD FILLER2
XFILLER_50_491 VDD VSS FILLER1
X_10521_ _10521_/A _10521_/B _10521_/C _10521_/D VDD VSS _10576_/B AOAI211X1
XFILLER_156_839 VDD VSS FILLER1
X_13240_ _13240_/A _13240_/B _13240_/C _13240_/D VDD VSS _14513_/B OAOI211X1
XFILLER_136_530 VSS VDD FILLER2
X_10452_ _10452_/A VDD VSS _10454_/C INVX1
XFILLER_164_850 VSS VDD FILLER2
XFILLER_109_766 VSS VDD FILLER2
XFILLER_136_563 VSS VDD FILLER2
X_13171_ _13171_/A _13171_/B _14218_/B _13171_/D _13171_/E VDD VSS _13295_/C OAI221X1
X_10383_ _10383_/A _10383_/B _10383_/C _10383_/D VDD VSS _10395_/D AOI31X1
XFILLER_123_202 VDD VSS FILLER1
XTAP_TAPCELL_ROW_153_1387 VDD VSS WELLTAP
XFILLER_2_510 VDD VSS FILLER1
X_12122_ _12189_/B _14275_/B VDD VSS _12134_/B XNOR2X1
XFILLER_124_758 VSS VDD FILLER2
XFILLER_2_532 VSS VDD FILLER2
XFILLER_97_609 VDD VSS FILLER4
XFILLER_117_60 VDD VSS FILLER1
XFILLER_2_554 VDD VSS FILLER4
X_16930_ _16933_/C _16931_/B _17081_/C VDD VSS _16931_/C OAI21X1
X_12053_ _12053_/A _14494_/B _12053_/C _12053_/D VDD VSS _12234_/A AOAI211X1
XFILLER_151_599 VSS VDD FILLER2
XFILLER_96_119 VDD VSS FILLER1
XFILLER_78_834 VDD VSS FILLER4
XFILLER_2_598 VDD VSS FILLER4
X_11004_ _11004_/A _11004_/B _11004_/C VDD VSS _11037_/B AO21X2
X_16861_ _16899_/A _16861_/B VDD VSS _19699_/D AND2X1
XFILLER_77_75 VSS VDD FILLER2
X_18600_ _18612_/CK _18600_/D _18600_/Q VDD VSS DFFQX1
X_15812_ _17010_/A _15812_/B _15812_/C VDD VSS _19428_/D NOR3X1
X_19580_ _19636_/CK _19580_/D _19580_/Q VDD VSS DFFQX1
XFILLER_92_314 VDD VSS DECAPHV8
X_16792_ _16794_/A _16792_/B VDD VSS _19638_/D NOR2X1
X_18531_ _18543_/CK _18531_/D _18531_/Q VDD VSS DFFQX1
X_15743_ _15743_/A _15743_/B VDD VSS _19367_/D AND2X1
X_12955_ _12955_/A _12955_/B _12955_/C _12955_/D VDD VSS _13049_/B AOI31X1
XFILLER_93_41 VDD VSS DECAPHV8
XFILLER_46_753 VSS VDD FILLER2
XFILLER_92_369 VDD VSS FILLER1
XFILLER_80_509 VSS VDD FILLER2
XFILLER_45_230 VSS VDD FILLER2
XFILLER_73_561 VDD VSS FILLER4
X_11906_ _19035_/Q _14303_/B VDD VSS _11907_/B OR2X2
X_18462_ _18471_/CK _18494_/D _18462_/Q _18463_/RB VDD VSS DFFRQX1
X_15674_ _15674_/A _15674_/B VDD VSS _19306_/D AND2X1
X_12886_ _12886_/A _13180_/B _14153_/B VDD VSS _13076_/B MIN3X1
XFILLER_93_96 VSS VDD FILLER2
XFILLER_60_222 VSS VDD FILLER2
XFILLER_45_296 VSS VDD FILLER2
X_17413_ _17562_/B _17413_/B _17413_/C VDD VSS _17417_/C MIN3X1
X_14625_ _19523_/Q _14649_/C VDD VSS _14646_/B NAND2X1
X_11837_ _19229_/Q _14523_/B VDD VSS _11839_/C _14523_/C NAND3X1
X_18393_ _18407_/CK _18393_/D _18393_/Q _09380_/B VDD VSS DFFRQX1
XFILLER_61_778 VSS VDD FILLER2
XFILLER_14_650 VSS VDD FILLER2
XTAP_TAPCELL_ROW_15_144 VDD VSS WELLTAP
X_17344_ _19826_/Q _19794_/Q VDD VSS _17346_/D XNOR2X1
X_14556_ _19996_/Q _14558_/B VDD VSS _19260_/D AND2X1
XFILLER_14_683 VSS VDD FILLER2
X_11768_ _11768_/A _11768_/B _11768_/C _14486_/B VDD VSS _11776_/B AOAI211X1
XFILLER_14_694 VSS VDD FILLER2
XFILLER_60_299 VDD VSS FILLER1
XFILLER_41_491 VSS VDD FILLER2
XFILLER_119_508 VDD VSS FILLER4
X_13507_ _18943_/Q _14193_/B _14193_/C VDD VSS _13656_/E OR3BX1
X_10719_ _18669_/Q _18777_/Q VDD VSS _10721_/B XNOR2X1
X_17275_ _17277_/C _17275_/B _17275_/C VDD VSS _19811_/D AOI21X1
X_14487_ _14493_/A _14487_/B VDD VSS _19199_/D NOR2X1
XFILLER_146_316 VSS VDD FILLER2
X_11699_ _19224_/Q _14517_/B VDD VSS _11700_/B OR2X2
X_19014_ _19044_/CK _19014_/D _19014_/Q VDD VSS DFFQX1
X_16226_ _16848_/B _19687_/Q VDD VSS _16227_/C NOR2BX1
X_13438_ _13546_/A _13617_/B VDD VSS _14419_/B XNOR2X1
XFILLER_127_552 VDD VSS FILLER4
XFILLER_127_563 VDD VSS FILLER1
X_16157_ _16157_/A _16157_/B _16157_/C VDD VSS _16163_/A OA21X2
X_13369_ _19054_/Q _13601_/A _13531_/B VDD VSS _13406_/D XNOR3X1
XFILLER_115_725 VDD VSS FILLER1
XFILLER_154_382 VSS VDD FILLER2
XFILLER_115_747 VSS VDD FILLER2
XFILLER_5_370 VSS VDD FILLER2
X_15108_ _15108_/A _15108_/B _15108_/C _15108_/D VDD VSS _15155_/B AOAI211X1
XFILLER_114_235 VSS VDD FILLER2
X_16088_ _19553_/Q _16699_/A _16088_/C VDD VSS _16112_/C MIN3X1
X_15039_ _15039_/A _15039_/B _15744_/B VDD VSS _15081_/B MIN3X1
X_19916_ clkload8/A _19916_/D _19916_/Q VDD VSS DFFQX1
XTAP_TAPCELL_ROW_130_1184 VDD VSS WELLTAP
XFILLER_96_642 VDD VSS FILLER1
X_19847_ _19853_/CK _19847_/D _19847_/Q VDD VSS DFFQX1
X_09600_ _18261_/Q _09716_/B _09600_/C _09626_/B _09600_/E VDD VSS _09601_/D AOI221X1
X_19778_ _19785_/CK _19778_/D _19778_/Q VDD VSS DFFQX1
XFILLER_95_174 VSS VDD FILLER2
XFILLER_113_29 VSS VDD FILLER2
XFILLER_95_185 VDD VSS FILLER1
XFILLER_37_731 VDD VSS FILLER1
X_09531_ _20026_/Q _18199_/A VDD VSS _20027_/D NOR2BX1
XFILLER_37_742 VSS VDD FILLER2
X_18729_ _19939_/CK _18729_/D _18729_/Q VDD VSS DFFQX1
XFILLER_36_230 VSS VDD FILLER2
X_09462_ _18445_/D _09468_/B _09462_/C VDD VSS _18252_/D AOI21X1
XTAP_TAPCELL_ROW_106_966 VDD VSS WELLTAP
XFILLER_64_583 VDD VSS FILLER4
XFILLER_51_211 VSS VDD FILLER2
X_09393_ wire167/A VDD VSS _232_/E INVX1
XFILLER_24_469 VDD VSS FILLER4
XTAP_TAPCELL_ROW_141_1280 VDD VSS WELLTAP
XFILLER_51_277 VSS VDD FILLER2
XFILLER_11_119 VDD VSS FILLER4
XFILLER_51_299 VDD VSS FILLER1
XFILLER_138_828 VDD VSS FILLER1
XFILLER_20_642 VSS VDD FILLER2
XFILLER_165_647 VDD VSS FILLER4
XFILLER_118_541 VDD VSS FILLER1
XFILLER_118_574 VSS VDD FILLER2
XFILLER_145_393 VSS VDD FILLER2
XFILLER_154_14 VSS VDD FILLER2
XFILLER_105_257 VDD VSS DECAPHV16
XFILLER_120_227 VDD VSS FILLER4
XFILLER_101_452 VSS VDD FILLER2
XFILLER_87_675 VSS VDD FILLER2
XFILLER_101_463 VSS VDD FILLER2
XFILLER_86_152 VDD VSS DECAPHV8
Xfanout198 _09346_/B VDD VSS _09414_/D BUFX3
XTAP_TAPCELL_ROW_144_1309 VDD VSS WELLTAP
XTAP_TAPCELL_ROW_57_523 VDD VSS WELLTAP
XFILLER_47_67 VSS VDD FILLER2
XFILLER_28_731 VDD VSS FILLER4
X_09729_ _09729_/A _09729_/B _09729_/C _09729_/D VDD VSS _09730_/C AOI31X1
XFILLER_28_753 VSS VDD FILLER2
XFILLER_62_509 VSS VDD FILLER2
XFILLER_103_51 VDD VSS FILLER4
XFILLER_55_561 VDD VSS FILLER4
X_12740_ _12816_/A _12816_/B _12816_/C VDD VSS _14410_/B AOI21X1
XFILLER_55_583 VSS VDD FILLER2
XFILLER_103_73 VDD VSS FILLER4
XFILLER_103_84 VSS VDD FILLER2
XFILLER_43_756 VDD VSS DECAPHV8
X_12671_ _20007_/Q _19271_/Q VDD VSS _12763_/C XOR2X1
X_14410_ _14410_/A _14410_/B _14410_/C VDD VSS _19131_/D NOR3X1
XFILLER_70_575 VDD VSS FILLER4
X_11622_ _18765_/Q _11624_/B VDD VSS _18792_/D AND2X1
X_15390_ _19432_/Q VDD VSS _15391_/A INVX1
XFILLER_23_480 VDD VSS FILLER1
XFILLER_129_817 VSS VDD FILLER2
XFILLER_137_0 VDD VSS FILLER4
X_14341_ _14368_/A _14341_/B VDD VSS _19068_/D NOR2X1
XTAP_TAPCELL_ROW_12_125 VDD VSS WELLTAP
X_11553_ _18702_/Q _11555_/B VDD VSS _18729_/D AND2X1
XTAP_TAPCELL_ROW_155_1405 VDD VSS WELLTAP
XFILLER_128_316 VSS VDD FILLER2
XFILLER_11_686 VSS VDD FILLER2
X_17060_ _17064_/D _17060_/B VDD VSS _17061_/B XNOR2X1
X_10504_ _10595_/A _10548_/B VDD VSS _10505_/B NAND2X1
XFILLER_128_349 VSS VDD FILLER2
X_14272_ _15383_/A VDD VSS _14334_/A BUFX3
X_11484_ _18640_/Q _11484_/B VDD VSS _18667_/D AND2X1
XFILLER_156_669 VDD VSS FILLER4
XFILLER_137_850 VSS VDD FILLER2
X_16011_ _19709_/Q VDD VSS _16024_/A INVX1
X_13223_ _19108_/Q _14386_/B VDD VSS _13365_/D _14386_/C NAND3X1
XFILLER_7_679 VSS VDD FILLER2
X_10435_ _10435_/A _10435_/B _10512_/A VDD VSS _10624_/B OAI21X1
XFILLER_6_167 VSS VDD FILLER2
XTAP_TAPCELL_ROW_20_191 VDD VSS WELLTAP
XFILLER_136_371 VDD VSS DECAPHV8
XFILLER_6_178 VSS VDD FILLER2
XFILLER_6_189 VSS VDD FILLER2
XFILLER_136_393 VDD VSS DECAPHV16
X_13154_ _19220_/Q _13444_/D _13154_/C VDD VSS _13329_/C XNOR3X1
XFILLER_3_830 VDD VSS FILLER4
X_10366_ _10413_/A _10413_/B _10413_/C VDD VSS _10366_/Y AOI21X1
X_12105_ _12158_/A _12158_/B _12158_/D VDD VSS _12111_/B OAI21X1
XFILLER_124_588 VDD VSS FILLER4
XFILLER_112_739 VSS VDD FILLER2
X_17962_ _17966_/A _17966_/B _17962_/C VDD VSS _19958_/D OA21X2
X_13085_ _13178_/A _13178_/B _14156_/B VDD VSS _13286_/B MIN3X1
X_10297_ _10581_/A _10385_/B _10385_/C _10655_/A VDD VSS _10465_/B OAI211X1
X_19701_ _19702_/CK _19701_/D _19701_/Q VDD VSS DFFQX1
X_16913_ _20057_/Q input1/Y _16913_/C VDD VSS wire165/A OAI21X1
X_12036_ _14463_/B _14463_/C _19177_/Q VDD VSS _12040_/B AOI21X1
XTAP_TAPCELL_ROW_166_1512 VDD VSS WELLTAP
X_17893_ _18173_/A _17893_/B VDD VSS _19946_/D NOR2X1
X_19632_ _19664_/CK _19632_/D _19632_/Q VDD VSS DFFQX1
XFILLER_65_303 VDD VSS FILLER1
X_16844_ _16860_/A VDD VSS _16859_/A BUFX3
XFILLER_93_623 VSS VDD FILLER2
XFILLER_66_848 VSS VDD FILLER2
XFILLER_38_539 VDD VSS FILLER1
XFILLER_93_656 VDD VSS FILLER1
XFILLER_19_742 VSS VDD FILLER2
X_19563_ _19600_/CK _19563_/D _19563_/Q VDD VSS DFFQX1
XFILLER_92_144 VDD VSS FILLER1
X_16775_ _16775_/A _16775_/B VDD VSS _19622_/D NOR2X1
XFILLER_65_369 VSS VDD FILLER2
X_13987_ _13987_/A _13987_/B _13987_/C _13987_/D VDD VSS _14198_/C AOI211X1
XFILLER_93_689 VSS VDD FILLER2
X_18514_ _18514_/CK _18514_/D _18514_/Q _09334_/Y VDD VSS DFFRQX1
XFILLER_18_263 VSS VDD FILLER2
X_15726_ _16795_/A VDD VSS _15743_/A BUFX3
XFILLER_80_328 VDD VSS DECAPHV8
XFILLER_34_723 VDD VSS FILLER1
X_19494_ _19536_/CK _19494_/D _19494_/Q VDD VSS DFFQX1
X_12938_ _12938_/A _14413_/B _14413_/C VDD VSS _12939_/D NOR3X1
XTAP_TAPCELL_ROW_91_835 VDD VSS WELLTAP
XTAP_TAPCELL_ROW_121_1106 VDD VSS WELLTAP
XTAP_TAPCELL_ROW_8_82 VDD VSS WELLTAP
XFILLER_34_756 VDD VSS DECAPHV8
XFILLER_33_233 VSS VDD FILLER2
X_18445_ _18454_/CK _18445_/D _18445_/Q _18450_/RB VDD VSS DFFRQX1
X_15657_ _19357_/Q _15657_/B _15732_/B VDD VSS _15662_/C MIN3X1
XTAP_TAPCELL_ROW_103_936 VDD VSS WELLTAP
X_12869_ _13005_/A _13005_/C VDD VSS _12997_/C AND2X1
XFILLER_34_789 VDD VSS FILLER1
XFILLER_33_255 VSS VDD FILLER2
X_14608_ _19469_/Q _14608_/B _14638_/C VDD VSS _14613_/C XNOR3X1
X_18376_ _18389_/CK _18525_/Q _20181_/A _20065_/RB VDD VSS DFFRQX1
XFILLER_159_430 VDD VSS FILLER1
X_15588_ _15591_/A _15591_/B VDD VSS _18164_/B XNOR2X1
XFILLER_159_463 VSS VDD FILLER2
XFILLER_147_614 VDD VSS FILLER4
X_17327_ _17327_/A _17329_/C _17327_/C VDD VSS _19822_/D AOI21X1
X_14539_ _14539_/A _14539_/B VDD VSS _19245_/D NOR2X1
XFILLER_159_496 VSS VDD FILLER2
X_17258_ _19807_/Q _19775_/Q _17258_/C VDD VSS _17263_/C AOI21X1
XFILLER_146_157 VSS VDD FILLER2
X_16209_ _19558_/Q _16704_/A _16209_/C VDD VSS _16236_/C OAI21X1
XFILLER_162_628 VSS VDD FILLER2
XFILLER_161_105 VSS VDD FILLER2
XFILLER_108_18 VSS VDD FILLER2
XFILLER_127_371 VDD VSS FILLER1
X_17189_ _17189_/A _17189_/B _17189_/C VDD VSS _17197_/A OA21X2
XTAP_TAPCELL_ROW_132_1202 VDD VSS WELLTAP
XFILLER_52_0 VSS VDD FILLER2
XFILLER_127_393 VDD VSS FILLER1
XFILLER_142_341 VSS VDD FILLER2
XTAP_TAPCELL_ROW_99_902 VDD VSS WELLTAP
XFILLER_103_717 VSS VDD FILLER2
XFILLER_115_577 VDD VSS FILLER1
XFILLER_88_417 VDD VSS FILLER1
XFILLER_130_514 VDD VSS DECAPHV8
XFILLER_111_794 VSS VDD FILLER2
XFILLER_83_100 VSS VDD FILLER2
XFILLER_57_848 VSS VDD FILLER2
XFILLER_110_271 VSS VDD FILLER2
XFILLER_110_282 VSS VDD FILLER2
XFILLER_83_122 VSS VDD FILLER2
XFILLER_110_293 VSS VDD FILLER2
XFILLER_84_656 VSS VDD FILLER2
XFILLER_84_667 VDD VSS FILLER4
XFILLER_17_26 VDD VSS FILLER1
XFILLER_37_550 VDD VSS FILLER1
XFILLER_83_166 VSS VDD FILLER2
XFILLER_37_561 VSS VDD FILLER2
XFILLER_25_701 VSS VDD FILLER2
X_09514_ _20064_/Q _09516_/B _20065_/Q VDD VSS _18201_/C OR3BX1
XFILLER_37_583 VDD VSS DECAPHV8
XFILLER_140_49 VSS VDD FILLER2
XFILLER_25_734 VSS VDD FILLER2
X_09445_ _09447_/B _09810_/B VDD VSS _18220_/E NOR2X1
XFILLER_52_553 VSS VDD FILLER2
Xclkbuf_leaf_32__000_ clkbuf_leaf_6__000_/A VDD VSS _19463_/CK BUFX12
XFILLER_25_789 VDD VSS FILLER1
XFILLER_24_266 VSS VDD FILLER2
XFILLER_33_25 VSS VDD FILLER2
X_09376_ _09468_/B _09467_/B VDD VSS _18226_/E OR2X2
XTAP_TAPCELL_ROW_62_570 VDD VSS WELLTAP
XFILLER_52_597 VDD VSS FILLER4
XFILLER_138_603 VDD VSS FILLER1
XFILLER_149_25 VSS VDD FILLER2
XFILLER_165_411 VSS VDD FILLER2
XFILLER_138_636 VDD VSS FILLER4
XFILLER_165_433 VSS VDD FILLER2
XFILLER_20_494 VDD VSS FILLER4
XFILLER_165_477 VDD VSS FILLER4
XFILLER_125_319 VSS VDD FILLER2
XFILLER_106_500 VSS VDD FILLER2
XFILLER_146_680 VDD VSS FILLER4
XFILLER_146_691 VDD VSS FILLER4
XFILLER_109_4 VSS VDD FILLER2
X_10220_ _18592_/Q _18593_/Q VDD VSS _10230_/B _10220_/C NAND3X1
XFILLER_165_68 VSS VDD FILLER2
XFILLER_161_650 VDD VSS FILLER1
XFILLER_161_661 VSS VDD FILLER2
XFILLER_121_503 VDD VSS FILLER1
XFILLER_106_588 VDD VSS FILLER1
X_10151_ _17906_/C _10151_/B _10152_/C VDD VSS _18540_/D NOR3X1
XFILLER_161_694 VDD VSS FILLER1
XFILLER_58_33 VDD VSS FILLER4
XFILLER_160_182 VSS VDD FILLER2
XFILLER_58_44 VSS VDD FILLER2
XFILLER_0_855 VSS VDD FILLER2
X_10082_ _10056_/Y _10081_/Y _10155_/A VDD VSS _10130_/B MUXI2X1
XFILLER_59_130 VDD VSS FILLER4
XFILLER_48_804 VSS VDD FILLER2
XFILLER_75_612 VDD VSS FILLER4
X_13910_ _13910_/A _13910_/B VDD VSS _14332_/B XNOR2X1
XFILLER_87_472 VDD VSS FILLER1
XFILLER_47_314 VSS VDD FILLER2
X_14890_ _19365_/Q _15740_/B VDD VSS _14891_/B XOR2X1
XFILLER_59_185 VDD VSS FILLER1
XFILLER_101_282 VSS VDD FILLER2
XFILLER_114_72 VSS VDD FILLER2
X_13841_ _19030_/Q _14298_/B _14298_/C VDD VSS _13843_/D OR3BX1
XFILLER_35_509 VSS VDD FILLER2
XFILLER_90_615 VSS VDD FILLER2
XFILLER_75_689 VSS VDD FILLER2
XFILLER_74_43 VSS VDD FILLER2
X_16560_ _16561_/A _16561_/B _16561_/C VDD VSS _16585_/B AOI21X1
X_13772_ _13843_/A _13889_/B VDD VSS _14264_/B XNOR2X1
XFILLER_62_328 VSS VDD FILLER2
X_10984_ _10984_/A _10984_/B _10984_/C VDD VSS _10984_/Y OAI21X1
XTAP_TAPCELL_ROW_161_1464 VDD VSS WELLTAP
XFILLER_71_840 VDD VSS FILLER4
X_15511_ _15511_/A _15511_/B VDD VSS _15520_/B AND2X1
X_12723_ _19048_/Q VDD VSS _12868_/D INVX1
X_16491_ _19697_/Q _16858_/B VDD VSS _16492_/C NOR2X1
XFILLER_31_704 VSS VDD FILLER2
X_18230_ _18232_/CK _18230_/E _18230_/ECK VDD VSS CGX3
XFILLER_15_277 VSS VDD FILLER2
XFILLER_130_82 VSS VDD FILLER2
X_15442_ _15472_/A _15472_/B VDD VSS _15883_/B XNOR2X1
X_12654_ _19157_/Q _12654_/B VDD VSS _12656_/C _12654_/C NAND3X1
XTAP_TAPCELL_ROW_100_917 VDD VSS WELLTAP
XFILLER_129_603 VSS VDD FILLER2
X_11605_ _18749_/Q _11612_/B VDD VSS _18776_/D AND2X1
X_18161_ _18162_/A _18162_/B _18162_/C VDD VSS _18163_/B NOR3X1
XFILLER_128_102 VSS VDD FILLER2
X_15373_ _15389_/A _15373_/B VDD VSS _15753_/B XNOR2X1
X_12585_ _20006_/Q _19270_/Q VDD VSS _12763_/B AND2X1
XFILLER_11_450 VDD VSS FILLER1
X_17112_ _17114_/C _17112_/B _17112_/C VDD VSS _19776_/D AOI21X1
XFILLER_128_135 VDD VSS FILLER4
X_14324_ _14352_/A _14324_/B _14324_/C VDD VSS _19053_/D NOR3X1
X_11536_ _18687_/Q _11542_/B VDD VSS _18714_/D AND2X1
XFILLER_128_146 VDD VSS FILLER1
X_18092_ _18095_/A _18095_/B VDD VSS _18093_/B XNOR2X1
XFILLER_23_91 VSS VDD FILLER2
XFILLER_139_91 VSS VDD FILLER2
X_17043_ _19762_/Q _17047_/B VDD VSS _17045_/D XNOR2X1
X_14255_ _18163_/A VDD VSS _14255_/Y BUFX3
X_11467_ _19959_/Q _11473_/B VDD VSS _18652_/D AND2X1
XFILLER_109_371 VDD VSS FILLER1
XFILLER_125_820 VSS VDD FILLER2
XFILLER_109_382 VDD VSS FILLER4
XFILLER_137_691 VSS VDD FILLER2
XFILLER_7_498 VSS VDD FILLER2
XFILLER_143_138 VSS VDD FILLER2
X_13206_ _14321_/B _19051_/Q VDD VSS _13274_/A NAND2BX1
X_10418_ _19941_/Q _18823_/Q VDD VSS _10448_/B XOR2X1
X_14186_ _14186_/A _14186_/B VDD VSS _18938_/D NOR2X1
X_11398_ _11398_/A _11398_/B _11398_/C VDD VSS _11398_/Y NOR3X1
XFILLER_112_514 VSS VDD FILLER2
XFILLER_124_374 VDD VSS DECAPHV8
X_13137_ _13137_/A _14478_/B _14478_/C VDD VSS _13138_/D NOR3X1
X_10349_ _10512_/A _10349_/B VDD VSS _10500_/C _10579_/D NAND3X1
XFILLER_140_834 VSS VDD FILLER2
X_18994_ _19025_/CK _18994_/D _18994_/Q VDD VSS DFFQX1
XFILLER_3_693 VSS VDD FILLER2
XFILLER_140_856 VDD VSS FILLER1
X_17945_ _18866_/Q _17945_/B _17945_/C VDD VSS _17948_/C XNOR3X1
X_13068_ _19051_/Q _13271_/A _13098_/B VDD VSS _13270_/D XNOR3X1
XFILLER_97_258 VSS VDD FILLER2
X_12019_ _12019_/A _14337_/B _12019_/C VDD VSS _12020_/B MIN3X1
XTAP_TAPCELL_ROW_68_629 VDD VSS WELLTAP
XFILLER_38_303 VDD VSS FILLER4
XFILLER_38_314 VDD VSS FILLER4
X_17876_ _17876_/A _17876_/B _17876_/C VDD VSS _17880_/C MIN3X1
X_19615_ _19636_/CK _19615_/D _19615_/Q VDD VSS DFFQX1
X_16827_ _17391_/A VDD VSS _16838_/A BUFX3
XFILLER_54_807 VDD VSS FILLER1
XFILLER_93_464 VDD VSS FILLER1
XFILLER_26_509 VSS VDD FILLER2
XFILLER_54_829 VDD VSS FILLER4
XFILLER_53_306 VDD VSS FILLER1
XFILLER_65_166 VSS VDD FILLER2
XFILLER_19_561 VSS VDD FILLER2
XFILLER_65_177 VDD VSS DECAPHV8
XFILLER_53_317 VSS VDD FILLER2
X_19546_ _19705_/CK _19546_/D _19546_/Q VDD VSS DFFQX1
X_16758_ _16759_/A _16758_/B VDD VSS _19607_/D NOR2X1
XTAP_TAPCELL_ROW_76_695 VDD VSS WELLTAP
XFILLER_80_125 VDD VSS DECAPHV8
X_09965__236 _20081_/CK VDD VSS _18512_/CK INVX1
X_15709_ _15725_/A _15709_/B VDD VSS _19336_/D AND2X1
X_19477_ _19528_/CK _19477_/D _19477_/Q VDD VSS DFFQX1
X_16689_ _16690_/A _16690_/B _18168_/C VDD VSS _16690_/C OAI21X1
XFILLER_22_715 VDD VSS DECAPHV16
X_09230_ _18501_/D VDD VSS _18357_/D INVX1
X_18428_ _18439_/CK _18428_/D _18428_/Q _18471_/RB VDD VSS DFFRQX1
XFILLER_61_383 VSS VDD FILLER2
X_18359_ _18359_/CK _18471_/D _18359_/Q _20067_/RB VDD VSS DFFRQX1
XFILLER_147_422 VSS VDD FILLER2
XFILLER_159_282 VSS VDD FILLER2
XFILLER_128_680 VSS VDD FILLER2
XFILLER_134_127 VSS VDD FILLER2
XFILLER_134_138 VDD VSS FILLER1
XFILLER_116_853 VDD VSS FILLER4
XFILLER_162_469 VSS VDD FILLER2
XFILLER_131_812 VDD VSS FILLER4
XFILLER_142_160 VSS VDD FILLER2
XFILLER_0_118 VDD VSS FILLER4
X_20183_ _20183_/A VDD VSS _20183_/Y BUFX3
X_09994_ _18600_/Q _09998_/B VDD VSS _09996_/C XOR2X1
XFILLER_103_536 VDD VSS FILLER1
XFILLER_130_322 VSS VDD FILLER2
XFILLER_88_258 VDD VSS DECAPHV8
XFILLER_69_472 VDD VSS FILLER1
XFILLER_57_612 VSS VDD FILLER2
XFILLER_130_388 VDD VSS FILLER1
XFILLER_56_100 VDD VSS FILLER4
XFILLER_111_591 VSS VDD FILLER2
XFILLER_151_26 VSS VDD FILLER2
XFILLER_28_58 VSS VDD FILLER2
XFILLER_84_464 VSS VDD FILLER2
XFILLER_45_829 VSS VDD FILLER2
XFILLER_84_475 VSS VDD FILLER2
XTAP_TAPCELL_ROW_39_364 VDD VSS WELLTAP
XFILLER_72_626 VDD VSS DECAPHV8
XFILLER_44_328 VDD VSS DECAPHV8
XFILLER_53_840 VSS VDD FILLER2
XFILLER_44_13 VSS VDD FILLER2
XFILLER_25_542 VSS VDD FILLER2
XFILLER_44_35 VSS VDD FILLER2
XFILLER_13_704 VDD VSS FILLER4
XFILLER_40_501 VSS VDD FILLER2
X_09428_ _09816_/B VDD VSS _09751_/B BUFX3
XFILLER_25_597 VSS VDD FILLER2
XFILLER_100_30 VDD VSS DECAPHV8
XFILLER_13_759 VSS VDD FILLER2
XFILLER_9_708 VSS VDD FILLER2
X_09359_ _18506_/Q _18505_/Q _09354_/Y VDD VSS _18506_/D MUX2X1
XFILLER_8_207 VDD VSS FILLER1
XFILLER_60_12 VDD VSS FILLER1
XFILLER_8_229 VSS VDD FILLER2
XFILLER_60_45 VDD VSS FILLER1
XFILLER_138_444 VSS VDD FILLER2
X_12370_ _19099_/Q _14376_/B VDD VSS _12544_/C _14376_/C AND3X2
XFILLER_138_466 VDD VSS DECAPHV8
XFILLER_166_786 VSS VDD FILLER2
X_11321_ _11364_/B _11339_/A VDD VSS _11331_/A AND2X1
XFILLER_153_425 VSS VDD FILLER2
XFILLER_125_127 VSS VDD FILLER2
X_14040_ _19007_/Q _14269_/B VDD VSS _14041_/C NAND2X1
X_11252_ _18579_/Q _11252_/B VDD VSS _11253_/D NAND2X1
XFILLER_69_10 VSS VDD FILLER2
X_10203_ _18591_/Q _10203_/B VDD VSS _10220_/C NOR2BX1
XFILLER_121_300 VSS VDD FILLER2
X_11183_ _10913_/Y _11182_/Y _11289_/A VDD VSS _11221_/B MUXI2X1
XFILLER_106_396 VSS VDD FILLER2
X_10134_ _18611_/Q _10134_/B VDD VSS _10150_/B AND2X1
XFILLER_95_707 VSS VDD FILLER2
X_15991_ _19614_/Q _16766_/B _15991_/C VDD VSS _16033_/A MIN3X1
XFILLER_125_71 VSS VDD FILLER2
X_17730_ _17730_/A _17730_/B _17730_/C VDD VSS _17738_/A OA21X2
XFILLER_121_399 VDD VSS FILLER1
X_14942_ _14955_/B _14942_/B VDD VSS _15742_/B XOR2X1
X_10065_ _10180_/A _11411_/C VDD VSS _18533_/D NOR2X1
XFILLER_0_696 VSS VDD FILLER2
XFILLER_102_591 VDD VSS FILLER4
XFILLER_85_53 VSS VDD FILLER2
XFILLER_87_291 VDD VSS DECAPHV8
X_17661_ _17663_/C _17661_/B _17661_/C VDD VSS _19893_/D AOI21X1
X_14873_ _15897_/B VDD VSS _14874_/B INVX1
XFILLER_85_86 VDD VSS FILLER1
XFILLER_75_475 VDD VSS FILLER4
XFILLER_36_829 VSS VDD FILLER2
X_19400_ _19406_/CK _19400_/D _19400_/Q VDD VSS DFFQX1
X_16612_ _19702_/Q _16864_/B VDD VSS _16620_/C XOR2X1
X_13824_ _13990_/A _14166_/B VDD VSS _13866_/B NOR2X1
XFILLER_90_423 VDD VSS FILLER1
X_17592_ _19879_/Q _19847_/Q VDD VSS _17594_/B XOR2X1
XFILLER_62_125 VDD VSS FILLER4
XFILLER_35_339 VSS VDD FILLER2
X_19331_ _19331_/CK _19331_/D _19331_/Q VDD VSS DFFQX1
X_16543_ _16540_/A _16543_/B _16543_/C VDD VSS _16566_/B AOI2B1X1
X_13755_ _18918_/Q _14164_/B VDD VSS _14132_/A AND2X1
X_10967_ _18675_/Q _18783_/Q _10967_/C VDD VSS _11007_/A MIN3X1
XFILLER_16_575 VDD VSS FILLER4
XFILLER_31_512 VDD VSS FILLER1
X_19262_ _20000_/CK _19262_/D _19262_/Q VDD VSS DFFQX1
X_12706_ _18935_/Q _12708_/B _12708_/C VDD VSS _14151_/B XNOR3X1
XFILLER_71_692 VDD VSS FILLER1
XFILLER_43_383 VSS VDD FILLER2
XFILLER_16_597 VDD VSS FILLER4
X_16474_ _16454_/A _16474_/B _16474_/C VDD VSS _16502_/B AOI2B1X1
XFILLER_43_394 VDD VSS FILLER1
X_13686_ _13686_/A _13686_/B _13686_/C _13686_/D VDD VSS _13830_/A AOAI211X1
X_10898_ _10925_/A _10898_/B VDD VSS _10909_/B XNOR2X1
X_18213_ _18223_/CK _18213_/E _18213_/ECK VDD VSS CGX3
XFILLER_31_556 VSS VDD FILLER2
X_15425_ _15425_/A _15425_/B _15425_/C _15425_/D VDD VSS _15464_/A AOAI211X1
X_19193_ _19223_/CK _19193_/D _19193_/Q VDD VSS DFFQX1
X_12637_ _12731_/A _12731_/B VDD VSS _12714_/B NOR2X1
XFILLER_31_578 VSS VDD FILLER2
XTAP_TAPCELL_ROW_5_61 VDD VSS WELLTAP
XFILLER_12_770 VSS VDD FILLER2
XFILLER_157_742 VSS VDD FILLER2
XFILLER_129_444 VDD VSS FILLER1
X_18144_ _19295_/Q _18149_/B VDD VSS _18146_/B XNOR2X1
XFILLER_156_230 VSS VDD FILLER2
X_15356_ _19541_/Q _15399_/C VDD VSS _15357_/B NAND2X1
X_12568_ _14440_/A _14440_/B _14440_/C _12568_/D VDD VSS _12771_/A OAOI211X2
XFILLER_144_403 VSS VDD FILLER2
XFILLER_116_105 VSS VDD FILLER2
Xwire160 wire160/A VDD VSS wire160/Y BUFX4
X_14307_ _14311_/A _14307_/B VDD VSS _19039_/D NOR2X1
X_11519_ _18672_/Q _11519_/B VDD VSS _18699_/D AND2X1
XFILLER_117_639 VDD VSS FILLER1
X_18075_ _19282_/Q _18079_/B VDD VSS _18078_/B XNOR2X1
XFILLER_7_262 VDD VSS FILLER4
X_15287_ _15347_/A _15287_/B VDD VSS _15783_/B XNOR2X1
X_12499_ _12499_/A _12499_/B _12499_/C _12673_/A VDD VSS _12583_/B OAOI211X1
XFILLER_156_285 VSS VDD FILLER2
XFILLER_7_284 VDD VSS FILLER1
XFILLER_116_138 VDD VSS FILLER1
XFILLER_144_447 VSS VDD FILLER2
XFILLER_116_149 VSS VDD FILLER2
X_17026_ _19759_/Q _17047_/B VDD VSS _17030_/B XNOR2X1
X_14238_ _14251_/A _14238_/B VDD VSS _18982_/D NOR2X1
Xclkbuf_1_1__f__09171_ clkbuf_0__09171_/Y VDD VSS _18341_/CK BUFX12
X_14169_ _14219_/A _14169_/B _14169_/C VDD VSS _18922_/D NOR3X1
XFILLER_98_523 VSS VDD FILLER2
XFILLER_113_856 VDD VSS FILLER1
Xclkbuf_leaf_31__001_ clkbuf_2_1__f__001_/Y VDD VSS _19126_/CK BUFX12
XFILLER_140_653 VSS VDD FILLER2
X_18977_ _19115_/CK _18977_/D _18977_/Q VDD VSS DFFQX1
XFILLER_98_578 VDD VSS FILLER4
XFILLER_98_589 VSS VDD FILLER2
XFILLER_85_217 VSS VDD FILLER2
X_17928_ _18132_/A _17928_/B _17941_/B VDD VSS _19953_/D NOR3X1
XFILLER_79_792 VDD VSS FILLER4
XFILLER_94_740 VDD VSS FILLER1
XFILLER_94_762 VSS VDD FILLER2
XFILLER_38_144 VDD VSS FILLER1
X_17859_ _17863_/C _17860_/B _17917_/C VDD VSS _17860_/C OAI21X1
XFILLER_27_818 VDD VSS FILLER4
XFILLER_93_261 VSS VDD FILLER2
XTAP_TAPCELL_ROW_127_1156 VDD VSS WELLTAP
XFILLER_26_328 VSS VDD FILLER2
XFILLER_121_18 VDD VSS FILLER4
XFILLER_53_136 VSS VDD FILLER2
XFILLER_35_840 VSS VDD FILLER2
XTAP_TAPCELL_ROW_36_334 VDD VSS WELLTAP
X_19529_ _19536_/CK _19529_/D _19529_/Q VDD VSS DFFQX1
XFILLER_62_670 VDD VSS FILLER1
XFILLER_34_372 VSS VDD FILLER2
XFILLER_34_394 VSS VDD FILLER2
X_09213_ _18515_/Q VDD VSS _18414_/D INVX1
XFILLER_10_707 VSS VDD FILLER2
XFILLER_14_49 VDD VSS FILLER4
XFILLER_22_589 VSS VDD FILLER2
XFILLER_147_230 VDD VSS FILLER4
XFILLER_147_241 VSS VDD FILLER2
XFILLER_148_764 VSS VDD FILLER2
XTAP_TAPCELL_ROW_138_1252 VDD VSS WELLTAP
XFILLER_135_403 VSS VDD FILLER2
XFILLER_108_628 VSS VDD FILLER2
XFILLER_163_756 VDD VSS FILLER4
XFILLER_135_458 VDD VSS FILLER1
XTAP_TAPCELL_ROW_1_19 VDD VSS WELLTAP
XFILLER_162_244 VSS VDD FILLER2
XFILLER_150_439 VDD VSS FILLER1
XFILLER_103_322 VDD VSS FILLER4
XFILLER_115_193 VDD VSS FILLER1
XFILLER_89_556 VSS VDD FILLER2
XFILLER_39_24 VDD VSS FILLER4
XFILLER_130_130 VSS VDD FILLER2
X_20166_ _20166_/A VDD VSS _20166_/Y BUFX3
XFILLER_130_152 VDD VSS FILLER4
XFILLER_162_25 VSS VDD FILLER2
X_20097_ _20097_/A VDD VSS _20097_/Y BUFX3
XFILLER_57_453 VDD VSS FILLER1
XFILLER_84_250 VDD VSS FILLER4
XFILLER_18_829 VDD VSS FILLER4
XFILLER_55_34 VSS VDD FILLER2
X_11870_ _19147_/Q _14430_/B _11966_/B VDD VSS _11973_/A MIN3X1
XFILLER_44_114 VSS VDD FILLER2
XFILLER_55_67 VSS VDD FILLER2
X_10821_ _19952_/Q _18834_/Q VDD VSS _10856_/C NAND2X1
XFILLER_60_607 VDD VSS FILLER4
XFILLER_72_489 VSS VDD FILLER2
XFILLER_111_51 VDD VSS FILLER1
XFILLER_13_512 VDD VSS FILLER4
XFILLER_41_821 VSS VDD FILLER2
XFILLER_13_523 VSS VDD FILLER2
X_13540_ _19111_/Q _14389_/B VDD VSS _13696_/C _14389_/C AND3X2
X_10752_ _18642_/Q _18804_/Q _10717_/C VDD VSS _10798_/A AOI21BX1
XFILLER_111_73 VSS VDD FILLER2
XTAP_TAPCELL_ROW_70_646 VDD VSS WELLTAP
XFILLER_13_556 VSS VDD FILLER2
XFILLER_52_191 VSS VDD FILLER2
X_13471_ _19111_/Q _13614_/B _13614_/C VDD VSS _13696_/B XNOR3X1
X_10683_ _19948_/Q _18830_/Q VDD VSS _10725_/A NAND2X1
XFILLER_9_527 VSS VDD FILLER2
XFILLER_40_364 VDD VSS FILLER1
XFILLER_139_731 VSS VDD FILLER2
XFILLER_40_375 VDD VSS FILLER4
X_15210_ _15220_/A _15220_/B VDD VSS _15718_/B XNOR2X1
X_12422_ _12461_/A _12517_/B _12517_/C VDD VSS _12519_/C AND3BX1
XFILLER_138_241 VDD VSS FILLER1
X_16190_ _16205_/B _16190_/B VDD VSS _16202_/A XNOR2X1
XFILLER_126_403 VSS VDD FILLER2
XFILLER_5_700 VSS VDD FILLER2
X_15141_ _19482_/Q _15874_/B VDD VSS _15198_/A AND2X1
Xclkbuf_1_1__f_clk_regs clkbuf_0_clk_regs/Y VDD VSS clkbuf_leaf_9_clk_regs/A BUFX12
X_12353_ _18931_/Q _14179_/B _12353_/C VDD VSS _12438_/B MIN3X1
XFILLER_138_285 VSS VDD FILLER2
XFILLER_5_722 VDD VSS FILLER4
X_11304_ _11304_/A _11304_/B VDD VSS _11305_/B XOR2X1
X_15072_ _15072_/A _15083_/B VDD VSS _15746_/B XNOR2X1
XFILLER_154_767 VDD VSS FILLER4
X_12284_ _12284_/A _12284_/B _12284_/C VDD VSS _14307_/B XNOR3X1
XFILLER_99_309 VSS VDD FILLER2
XFILLER_153_277 VSS VDD FILLER2
X_18900_ _18961_/CK _18900_/D _18900_/Q VDD VSS DFFQX1
X_14023_ _17945_/B _17945_/C _14098_/D _14098_/C VDD VSS _17957_/C AOI211X1
XFILLER_113_119 VSS VDD FILLER2
X_11235_ _11364_/A _11235_/B _11235_/C VDD VSS _11241_/B AOI21X1
XFILLER_153_299 VDD VSS DECAPHV8
X_19880_ _19880_/CK _19880_/D _19880_/Q VDD VSS DFFQX1
XFILLER_4_287 VDD VSS FILLER1
XFILLER_20_92 VSS VDD FILLER2
XFILLER_136_81 VSS VDD FILLER2
X_18831_ _18831_/CK _18831_/D _18831_/Q VDD VSS DFFQX1
X_11166_ _11167_/A _11167_/B _11167_/D _11167_/C VDD VSS _11168_/B OA211X2
XFILLER_95_515 VSS VDD FILLER2
XTAP_TAPCELL_ROW_78_713 VDD VSS WELLTAP
X_10117_ _10070_/Y _10167_/B _10167_/A VDD VSS _10117_/Y MUX2X1
XFILLER_0_471 VSS VDD FILLER2
X_18762_ _18785_/CK _18762_/D _18762_/Q VDD VSS DFFQX1
X_15974_ _19677_/Q VDD VSS _16012_/A INVX1
X_11097_ _18652_/Q VDD VSS _11497_/A INVX1
XFILLER_95_548 VSS VDD FILLER2
XFILLER_0_493 VSS VDD FILLER2
X_17713_ _19905_/Q _19873_/Q VDD VSS _17715_/B XOR2X1
X_14925_ _19505_/Q _14925_/B VDD VSS _15016_/A NAND2X1
X_10048_ _10131_/A _10048_/B _10048_/C VDD VSS _10053_/B OAI21X1
X_18693_ _18801_/CK _18693_/D _18693_/Q VDD VSS DFFQX1
XFILLER_29_90 VSS VDD FILLER2
XFILLER_75_272 VDD VSS FILLER4
X_17644_ _19890_/Q _19858_/Q VDD VSS _17646_/D XNOR2X1
X_14856_ _19364_/Q VDD VSS _14857_/A INVX1
XTAP_TAPCELL_ROW_86_790 VDD VSS WELLTAP
XFILLER_91_743 VDD VSS FILLER1
XFILLER_90_220 VDD VSS FILLER1
XFILLER_63_434 VDD VSS FILLER1
XFILLER_17_840 VSS VDD FILLER2
XFILLER_90_231 VDD VSS FILLER1
X_13807_ _13807_/A _13807_/B _13807_/C _13807_/D VDD VSS _14131_/B AOAI211X1
X_17575_ _17577_/C _17575_/B _17575_/C VDD VSS _19875_/D AOI21X1
XFILLER_23_309 VDD VSS FILLER4
X_14787_ _19529_/Q _14877_/C VDD VSS _15895_/B XNOR2X1
X_11999_ _19150_/Q _11999_/B _12029_/D VDD VSS _12031_/C XNOR3X1
X_19314_ _19314_/CK _19314_/D _19314_/Q VDD VSS DFFQX1
XFILLER_90_286 VSS VDD FILLER2
XFILLER_44_681 VSS VDD FILLER2
XFILLER_32_821 VSS VDD FILLER2
X_16526_ _19570_/Q _16718_/A _16526_/C VDD VSS _16551_/C OAI21X1
X_13738_ _18974_/Q _13760_/B _13830_/D VDD VSS _13771_/C XNOR3X1
XFILLER_149_506 VSS VDD FILLER2
X_19245_ _20004_/CK _19245_/D _19245_/Q VDD VSS DFFQX1
X_16457_ _19664_/Q _16822_/B VDD VSS _16459_/C XNOR2X1
X_13669_ _18889_/Q _14130_/B VDD VSS _17920_/A AND2X1
XFILLER_31_375 VSS VDD FILLER2
X_15408_ _19433_/Q _15818_/B VDD VSS _15429_/B XNOR2X1
XFILLER_31_397 VSS VDD FILLER2
X_19176_ _19200_/CK _19176_/D _19176_/Q VDD VSS DFFQX1
XTAP_TAPCELL_ROW_41_381 VDD VSS WELLTAP
XFILLER_164_509 VSS VDD FILLER2
X_16388_ _16388_/A _16388_/B _16388_/C _16388_/D VDD VSS _16409_/A AOAI211X1
XFILLER_77_2 VDD VSS FILLER1
XFILLER_145_701 VDD VSS FILLER4
XFILLER_157_561 VDD VSS DECAPHV8
X_18127_ _18131_/B _18127_/B _18127_/C VDD VSS _19999_/D AND3BX1
X_15339_ _15672_/A _18128_/B VDD VSS _19291_/D NOR2X1
XFILLER_157_594 VDD VSS DECAPHV16
XFILLER_8_582 VSS VDD FILLER2
XFILLER_144_222 VSS VDD FILLER2
X_18058_ _18057_/Y _18058_/B VDD VSS _19986_/D NOR2BX1
XFILLER_144_288 VSS VDD FILLER2
X_17009_ _17019_/B _17009_/B _17019_/A VDD VSS _17012_/C OA21X2
X_09900_ _09850_/Y _09884_/B _10966_/A VDD VSS _09940_/B MUXI2X1
XFILLER_160_748 VDD VSS FILLER1
X_20020_ _20022_/CK _20020_/D _20020_/Q _20030_/RB VDD VSS DFFRQX1
XFILLER_98_342 VDD VSS FILLER4
X_09831_ _09928_/C VDD VSS _10190_/B BUFX3
XFILLER_59_718 VDD VSS DECAPHV8
XFILLER_58_217 VSS VDD FILLER2
XFILLER_113_697 VSS VDD FILLER2
Xclkbuf_0__09185_ _18234_/ECK VDD VSS clkbuf_0__09185_/Y BUFX12
X_09762_ _18340_/Q VDD VSS _20094_/A INVX1
XFILLER_58_239 VSS VDD FILLER2
XFILLER_100_347 VDD VSS FILLER4
XFILLER_39_442 VSS VDD FILLER2
XFILLER_132_17 VDD VSS FILLER4
X_09693_ _18267_/Q _09818_/C _09693_/C _09773_/D _09693_/E VDD VSS _09700_/A AOI221X1
XFILLER_39_464 VDD VSS FILLER1
XFILLER_94_592 VSS VDD FILLER2
XFILLER_82_732 VDD VSS FILLER4
XFILLER_26_114 VSS VDD FILLER2
XFILLER_81_220 VSS VDD FILLER2
XFILLER_82_765 VDD VSS FILLER1
XFILLER_42_607 VDD VSS FILLER4
XFILLER_50_640 VSS VDD FILLER2
XFILLER_50_673 VSS VDD FILLER2
XFILLER_22_364 VSS VDD FILLER2
XFILLER_22_386 VDD VSS FILLER4
XFILLER_148_550 VDD VSS FILLER4
XFILLER_148_572 VSS VDD FILLER2
XFILLER_108_414 VDD VSS FILLER4
XFILLER_135_222 VSS VDD FILLER2
XFILLER_108_447 VDD VSS FILLER4
XFILLER_136_789 VDD VSS FILLER1
XFILLER_151_726 VDD VSS FILLER4
XFILLER_151_737 VDD VSS FILLER4
XFILLER_89_320 VSS VDD FILLER2
X_11020_ _11020_/A _11026_/C VDD VSS _11021_/B XNOR2X1
X_20218_ _20218_/A VDD VSS _20218_/Y BUFX3
XFILLER_89_375 VDD VSS FILLER4
XFILLER_49_206 VSS VDD FILLER2
XFILLER_106_51 VDD VSS FILLER1
XFILLER_103_185 VDD VSS FILLER1
X_20149_ _20149_/A VDD VSS _20149_/Y BUFX3
XFILLER_106_95 VSS VDD FILLER2
XFILLER_66_44 VSS VDD FILLER2
XFILLER_66_55 VSS VDD FILLER2
XFILLER_64_209 VSS VDD FILLER2
X_12971_ _19190_/Q _13131_/A _13042_/B VDD VSS _13108_/D XNOR3X1
XFILLER_85_570 VSS VDD FILLER2
XFILLER_45_401 VDD VSS FILLER1
XFILLER_17_103 VSS VDD FILLER2
X_14710_ _14710_/A _14710_/B _14710_/C _14710_/D VDD VSS _14785_/A OAOI211X1
X_11922_ _11922_/A _11922_/B _11922_/C _11922_/D VDD VSS _12029_/A AOAI211X1
X_15690_ _15693_/A _15690_/B VDD VSS _19319_/D NOR2X1
XFILLER_18_659 VDD VSS FILLER4
XFILLER_72_231 VDD VSS FILLER1
XFILLER_17_158 VSS VDD FILLER2
X_14641_ _19470_/Q VDD VSS _14671_/A INVX1
X_11853_ _11916_/A _11916_/B VDD VSS _14429_/B XNOR2X1
XTAP_TAPCELL_ROW_83_760 VDD VSS WELLTAP
XFILLER_72_264 VDD VSS FILLER1
XFILLER_60_404 VSS VDD FILLER2
XFILLER_60_415 VSS VDD FILLER2
XFILLER_14_821 VSS VDD FILLER2
XFILLER_26_681 VDD VSS FILLER4
XFILLER_14_832 VSS VDD FILLER2
X_17360_ _17362_/C _17360_/B _17360_/C VDD VSS _19829_/D AOI21X1
X_10804_ _10965_/A _18725_/Q _10804_/C _10804_/D _10804_/E VDD VSS _10805_/C AOI221X1
XFILLER_72_297 VSS VDD FILLER2
XFILLER_26_692 VDD VSS FILLER4
X_14572_ _20010_/Q _16702_/B VDD VSS _19274_/D AND2X1
X_11784_ _19173_/Q _11852_/B _11794_/C VDD VSS _14427_/B XNOR3X1
XFILLER_60_459 VSS VDD FILLER2
XFILLER_159_815 VSS VDD FILLER2
Xclkbuf_1_0__f__09174_ clkbuf_0__09174_/Y VDD VSS _18288_/CK BUFX12
XFILLER_159_826 VDD VSS FILLER1
X_16311_ _16289_/A _16311_/B _16311_/C VDD VSS _16317_/A AOI2B1X1
X_13523_ _13533_/A _14293_/B _13599_/C VDD VSS _14294_/C NOR3X1
XFILLER_159_848 VSS VDD FILLER2
X_17291_ _19814_/Q _19782_/Q _17291_/C VDD VSS _17296_/C AO21X2
X_10735_ _10807_/B _10807_/C _10947_/A _10735_/D VDD VSS _10736_/B OAOI211X1
XFILLER_13_375 VDD VSS FILLER4
XTAP_TAPCELL_ROW_158_1436 VDD VSS WELLTAP
X_19030_ _19086_/CK _19030_/D _19030_/Q VDD VSS DFFQX1
XFILLER_146_509 VSS VDD FILLER2
X_16242_ _19656_/Q _16814_/B VDD VSS _16253_/B XNOR2X1
X_13454_ _13466_/A _13466_/B _13454_/C _13466_/E VDD VSS _14481_/B AOI211X1
X_10666_ _10666_/A _10666_/B _10666_/C VDD VSS _10668_/B AOI21X1
XFILLER_139_561 VSS VDD FILLER2
X_12405_ _12405_/A _12405_/B _12405_/C _12405_/D VDD VSS _14503_/B OAOI211X1
X_16173_ _16174_/B _16173_/B _16173_/C VDD VSS _19525_/D AOI21X1
X_13385_ _13494_/B _13385_/B _13385_/C VDD VSS _13578_/A OAI21X1
XFILLER_154_520 VSS VDD FILLER2
X_10597_ _11127_/A _10630_/A VDD VSS _10627_/A NAND2X1
X_15124_ _19342_/Q _15716_/B VDD VSS _15127_/A XOR2X1
XFILLER_126_255 VDD VSS FILLER4
Xoutput109 _20193_/Y VDD VSS o_tst_ctrl[12] BUFX3
X_12336_ _12360_/A _12366_/D VDD VSS _12514_/C XNOR2X1
XFILLER_154_564 VSS VDD FILLER2
XFILLER_127_789 VSS VDD FILLER2
XFILLER_114_417 VDD VSS FILLER1
XFILLER_154_586 VDD VSS FILLER4
XFILLER_142_737 VDD VSS FILLER4
XFILLER_147_91 VSS VDD FILLER2
XFILLER_114_439 VSS VDD FILLER2
XFILLER_141_225 VSS VDD FILLER2
X_15055_ _19507_/Q _15901_/B VDD VSS _15145_/A NOR2BX1
X_19932_ _19934_/CK _19932_/D _19932_/Q VDD VSS DFFQX1
X_12267_ _18902_/Q _12348_/B _14146_/B VDD VSS _12272_/C XNOR3X1
XFILLER_5_596 VDD VSS FILLER4
XFILLER_141_247 VDD VSS FILLER1
X_14006_ _14045_/A _14045_/B _14045_/E VDD VSS _14015_/B AOI21X1
X_11218_ _11219_/A _11220_/C VDD VSS _11219_/C NAND2X1
X_19863_ _19895_/CK _19863_/D _19863_/Q VDD VSS DFFQX1
X_12198_ _18929_/Q _12198_/B _14177_/B VDD VSS _12341_/B MIN3X1
XFILLER_110_601 VSS VDD FILLER2
XFILLER_150_770 VSS VDD FILLER2
Xoutput80 _20154_/Y VDD VSS o_en_ctrl[2] BUFX3
XFILLER_96_824 VDD VSS DECAPHV8
Xoutput91 _20175_/Y VDD VSS o_lf_cfg[12] BUFX3
XFILLER_110_623 VSS VDD FILLER2
XFILLER_68_537 VDD VSS DECAPHV8
XFILLER_122_494 VDD VSS FILLER1
X_18814_ _19959_/CK _18814_/D _18814_/Q VDD VSS DFFQX1
X_11149_ _11149_/A _11149_/B VDD VSS _11149_/Y _11149_/C NAND3X1
XFILLER_110_645 VDD VSS FILLER1
X_19794_ _19934_/CK _19794_/D _19794_/Q VDD VSS DFFQX1
XFILLER_68_559 VDD VSS FILLER1
XFILLER_95_356 VSS VDD FILLER2
XFILLER_0_290 VDD VSS FILLER4
XFILLER_83_507 VDD VSS FILLER4
X_18745_ _18773_/CK _18745_/D _18745_/Q VDD VSS DFFQX1
X_15957_ _19645_/Q _16802_/B VDD VSS _15958_/C NOR2X1
XFILLER_83_518 VSS VDD FILLER2
XFILLER_49_773 VSS VDD FILLER2
XFILLER_36_412 VDD VSS FILLER4
X_14908_ _14908_/A _14908_/B _14908_/C _14908_/D VDD VSS _14931_/A AOAI211X1
X_18676_ _19954_/CK _18676_/D _18676_/Q VDD VSS DFFQX1
X_15888_ _16768_/A _15888_/B VDD VSS _19495_/D AND2X1
XFILLER_36_445 VDD VSS FILLER1
XTAP_TAPCELL_ROW_124_1126 VDD VSS WELLTAP
XFILLER_64_765 VDD VSS FILLER1
XFILLER_63_242 VSS VDD FILLER2
XFILLER_24_607 VDD VSS FILLER4
X_17627_ _17627_/A _17629_/C _17627_/C VDD VSS _19886_/D AOI21X1
X_14839_ _19446_/Q _14839_/B VDD VSS _14840_/C _14839_/C NAND3X1
XFILLER_91_584 VDD VSS FILLER1
XTAP_TAPCELL_ROW_18_175 VDD VSS WELLTAP
X_17558_ _19872_/Q _19840_/Q VDD VSS _17560_/B XNOR2X1
XFILLER_51_448 VDD VSS FILLER1
X_16509_ _16509_/A _16517_/B VDD VSS _16895_/B XOR2X1
X_17489_ _19857_/Q _19825_/Q VDD VSS _17496_/C NOR2X1
XFILLER_82_0 VDD VSS FILLER1
X_19228_ _19995_/CK _19228_/D _19228_/Q VDD VSS DFFQX1
XFILLER_164_328 VSS VDD FILLER2
X_19159_ _19185_/CK _19159_/D _19159_/Q VDD VSS DFFQX1
XFILLER_117_244 VSS VDD FILLER2
XFILLER_145_553 VDD VSS FILLER4
XFILLER_117_277 VSS VDD FILLER2
XFILLER_133_737 VDD VSS FILLER4
XFILLER_87_802 VDD VSS FILLER1
XFILLER_59_504 VDD VSS DECAPHV8
XFILLER_87_835 VSS VDD FILLER2
X_20003_ _20007_/CK _20003_/D _20003_/Q VDD VSS DFFQX1
X_09814_ _20178_/A _09814_/B _09814_/C _20196_/A VDD VSS _09815_/E AO22X2
XFILLER_86_323 VSS VDD FILLER2
Xclkbuf_0__09168_ _18217_/ECK VDD VSS clkbuf_0__09168_/Y BUFX12
XFILLER_100_155 VSS VDD FILLER2
X_09745_ _09753_/A _09745_/B _09745_/C _09745_/D VDD VSS _18290_/D OAI211X1
XTAP_TAPCELL_ROW_97_885 VDD VSS WELLTAP
XFILLER_100_188 VDD VSS FILLER4
XFILLER_67_592 VSS VDD FILLER2
XFILLER_55_743 VDD VSS FILLER1
X_09676_ _20203_/A _09797_/C _09729_/D VDD VSS _09680_/A AOI21X1
XTAP_TAPCELL_ROW_109_997 VDD VSS WELLTAP
XFILLER_54_242 VSS VDD FILLER2
XFILLER_36_58 VSS VDD FILLER2
XFILLER_15_618 VSS VDD FILLER2
XFILLER_14_106 VSS VDD FILLER2
XFILLER_42_415 VSS VDD FILLER2
XFILLER_42_426 VSS VDD FILLER2
XTAP_TAPCELL_ROW_80_730 VDD VSS WELLTAP
XFILLER_23_662 VSS VDD FILLER2
XFILLER_146_5 VSS VDD FILLER2
XFILLER_11_824 VSS VDD FILLER2
XFILLER_50_481 VDD VSS DECAPHV8
XFILLER_23_695 VDD VSS DECAPHV8
XFILLER_10_323 VSS VDD FILLER2
X_10520_ _18663_/Q _18771_/Q VDD VSS _10521_/D NAND2X1
XFILLER_52_79 VSS VDD FILLER2
XFILLER_155_328 VSS VDD FILLER2
X_10451_ _18662_/Q _18770_/Q VDD VSS _10452_/A XNOR2X1
XFILLER_6_338 VSS VDD FILLER2
XFILLER_136_553 VSS VDD FILLER2
X_13170_ _13171_/D _14218_/B VDD VSS _13295_/A NAND2X1
XFILLER_108_255 VDD VSS FILLER4
X_10382_ _10965_/A _18714_/Q VDD VSS _10383_/D AND2X1
XFILLER_108_277 VSS VDD FILLER2
X_12121_ _19040_/Q _12448_/B _12286_/B VDD VSS _14275_/B XNOR3X1
XTAP_TAPCELL_ROW_153_1388 VDD VSS WELLTAP
XFILLER_123_247 VSS VDD FILLER2
XFILLER_151_556 VSS VDD FILLER2
XFILLER_151_567 VDD VSS FILLER4
X_12052_ _14528_/A _14528_/B _19234_/Q VDD VSS _12053_/D OAI21X1
XFILLER_117_72 VSS VDD FILLER2
XFILLER_132_770 VSS VDD FILLER2
XFILLER_89_150 VSS VDD FILLER2
X_11003_ _19957_/Q _18839_/Q VDD VSS _11037_/A XNOR2X1
XFILLER_77_54 VSS VDD FILLER2
X_16860_ _16860_/A VDD VSS _16899_/A BUFX3
XFILLER_131_291 VDD VSS FILLER4
X_15811_ _15816_/A _15811_/B VDD VSS _19427_/D NOR2X1
X_16791_ _16794_/A _16791_/B VDD VSS _19637_/D NOR2X1
XFILLER_77_389 VDD VSS FILLER1
X_18530_ _18543_/CK _18530_/D _18530_/Q VDD VSS DFFQX1
XFILLER_133_82 VSS VDD FILLER2
X_15742_ _15758_/A _15742_/B VDD VSS _19366_/D NOR2X1
X_12954_ _19218_/Q VDD VSS _13135_/A INVX1
XFILLER_45_220 VSS VDD FILLER2
XFILLER_45_242 VSS VDD FILLER2
XFILLER_18_456 VDD VSS FILLER4
XFILLER_61_702 VDD VSS DECAPHV8
XFILLER_18_467 VSS VDD FILLER2
X_18461_ _18469_/CK _18514_/Q _18461_/Q _20081_/RB VDD VSS DFFRQX1
X_11905_ _19037_/Q VDD VSS _12015_/A INVX1
XFILLER_18_478 VDD VSS FILLER1
X_15673_ _15674_/A _15673_/B VDD VSS _19305_/D AND2X1
XFILLER_33_404 VSS VDD FILLER2
X_12885_ _18881_/Q _12885_/B _12885_/C VDD VSS _13077_/B MIN3X1
XFILLER_60_201 VDD VSS FILLER1
XFILLER_33_426 VDD VSS FILLER4
X_17412_ _19840_/Q VDD VSS _17562_/B INVX1
X_14624_ _14624_/A _14624_/B _14624_/C _14624_/D VDD VSS _14676_/A OAOI211X1
XFILLER_26_80 VDD VSS FILLER1
X_18392_ _18407_/CK _18392_/D _18392_/Q _18422_/RB VDD VSS DFFRQX1
X_11836_ _14523_/B _14523_/C _19229_/Q VDD VSS _11839_/B AOI21X1
XTAP_TAPCELL_ROW_15_145 VDD VSS WELLTAP
X_17343_ _17346_/A _17343_/B _17343_/C VDD VSS _19825_/D AOI21X1
XFILLER_14_673 VSS VDD FILLER2
X_14555_ _19995_/Q _14558_/B VDD VSS _19259_/D AND2X1
X_11767_ _19227_/Q _11778_/A _11769_/B VDD VSS _14486_/B XNOR3X1
XFILLER_60_289 VDD VSS DECAPHV8
XFILLER_158_122 VDD VSS FILLER1
X_13506_ _13586_/A _14192_/B _13586_/C VDD VSS _14193_/C NOR3X1
X_17274_ _17277_/C _17275_/B _17306_/C VDD VSS _17275_/C OAI21X1
X_10718_ _10718_/A _10718_/B _10718_/C _10718_/D VDD VSS _10721_/C AOAI211X1
X_14486_ _14486_/A _14486_/B VDD VSS _14487_/B XNOR2X1
X_11698_ _19197_/Q _14484_/B VDD VSS _11739_/B NOR2X1
XFILLER_146_328 VDD VSS FILLER4
X_19013_ _19044_/CK _19013_/D _19013_/Q VDD VSS DFFQX1
X_16225_ _16225_/A _16225_/B VDD VSS _16250_/B NAND2X1
XFILLER_158_188 VSS VDD FILLER2
XFILLER_127_520 VDD VSS FILLER4
XFILLER_146_339 VSS VDD FILLER2
X_13437_ _13437_/A _13437_/B _13437_/C _13437_/D VDD VSS _13623_/A OAOI211X1
X_10649_ _10649_/A _10649_/B _10649_/C _10649_/D VDD VSS _10729_/D AOAI211X1
XFILLER_155_840 VSS VDD FILLER2
XFILLER_127_542 VSS VDD FILLER2
XFILLER_115_704 VSS VDD FILLER2
X_16156_ _19588_/Q _16738_/B VDD VSS _16157_/C OR2X2
XFILLER_115_715 VSS VDD FILLER2
X_13368_ _14323_/A _13422_/B _13422_/C _13422_/D VDD VSS _13531_/B AO31X2
X_15107_ _19508_/Q _15144_/B VDD VSS _15108_/C NOR2X1
X_12319_ _12407_/D _12407_/C VDD VSS _12396_/C NAND2BX1
X_16087_ _19905_/Q VDD VSS _16699_/A INVX1
X_13299_ _18996_/Q _14258_/B VDD VSS _13395_/A NAND2X1
XFILLER_5_393 VSS VDD FILLER2
XFILLER_102_409 VSS VDD FILLER2
XFILLER_130_718 VDD VSS FILLER4
X_15038_ _19368_/Q VDD VSS _15039_/A INVX1
X_19915_ clkload8/A _19915_/D _19915_/Q VDD VSS DFFQX1
XFILLER_69_835 VSS VDD FILLER2
XTAP_TAPCELL_ROW_130_1185 VDD VSS WELLTAP
X_19846_ _19880_/CK _19846_/D _19846_/Q VDD VSS DFFQX1
XFILLER_3_62 VDD VSS FILLER1
XFILLER_96_665 VDD VSS DECAPHV8
XFILLER_110_453 VSS VDD FILLER2
XFILLER_84_816 VSS VDD FILLER2
XFILLER_56_518 VDD VSS FILLER1
XFILLER_96_687 VSS VDD FILLER2
XFILLER_110_475 VDD VSS FILLER4
XFILLER_113_19 VDD VSS FILLER4
X_16989_ _17391_/A VDD VSS _17095_/A BUFX3
X_19777_ _19825_/CK _19777_/D _19777_/Q VDD VSS DFFQX1
XFILLER_84_838 VSS VDD FILLER2
X_09530_ _20025_/Q _18199_/A VDD VSS _20026_/D NOR2BX1
XFILLER_49_592 VDD VSS FILLER4
X_18728_ _19939_/CK _18728_/D _18728_/Q VDD VSS DFFQX1
XTAP_TAPCELL_ROW_94_855 VDD VSS WELLTAP
XFILLER_37_765 VSS VDD FILLER2
XFILLER_36_242 VDD VSS FILLER1
X_09461_ _19970_/Q _09467_/B _09476_/C VDD VSS _09462_/C AOI21X1
XFILLER_36_253 VDD VSS FILLER1
X_18659_ _18799_/CK _18659_/D _18659_/Q VDD VSS DFFQX1
XFILLER_36_264 VSS VDD FILLER2
XTAP_TAPCELL_ROW_106_967 VDD VSS WELLTAP
XFILLER_52_724 VDD VSS FILLER1
XFILLER_37_798 VSS VDD FILLER2
XFILLER_24_415 VSS VDD FILLER2
XFILLER_91_370 VSS VDD FILLER2
XFILLER_64_595 VSS VDD FILLER2
X_09392_ _18010_/A _11429_/B VDD VSS wire167/A NOR2X1
XFILLER_51_245 VSS VDD FILLER2
XFILLER_52_779 VSS VDD FILLER2
XTAP_TAPCELL_ROW_141_1281 VDD VSS WELLTAP
XFILLER_138_807 VDD VSS FILLER1
XFILLER_20_621 VSS VDD FILLER2
XFILLER_149_155 VDD VSS FILLER1
XFILLER_137_328 VDD VSS DECAPHV8
XFILLER_138_16 VSS VDD FILLER2
XFILLER_22_49 VSS VDD FILLER2
XFILLER_118_520 VDD VSS FILLER1
XFILLER_164_136 VSS VDD FILLER2
XFILLER_138_49 VDD VSS FILLER4
XFILLER_146_851 VSS VDD FILLER2
XFILLER_164_158 VSS VDD FILLER2
XFILLER_133_501 VDD VSS FILLER1
XFILLER_161_821 VDD VSS FILLER4
XFILLER_145_383 VDD VSS FILLER4
XFILLER_161_854 VSS VDD FILLER2
XFILLER_133_556 VSS VDD FILLER2
XFILLER_133_589 VSS VDD FILLER2
XFILLER_160_397 VSS VDD FILLER2
XFILLER_59_334 VSS VDD FILLER2
XFILLER_87_654 VDD VSS FILLER4
XFILLER_101_442 VDD VSS FILLER4
XFILLER_86_142 VSS VDD FILLER2
Xfanout177 _18628_/Q VDD VSS _11196_/A BUFX3
XFILLER_75_816 VSS VDD FILLER2
XFILLER_47_507 VSS VDD FILLER2
XFILLER_101_475 VSS VDD FILLER2
Xfanout199 _09322_/B VDD VSS _09346_/B BUFX3
XFILLER_47_57 VSS VDD FILLER2
XFILLER_86_186 VDD VSS FILLER4
XTAP_TAPCELL_ROW_57_524 VDD VSS WELLTAP
X_09728_ _18465_/Q _09784_/B _09770_/C _20091_/A VDD VSS _09729_/C AOI22X1
XFILLER_43_702 VSS VDD FILLER2
X_09659_ _20122_/A _09788_/B _09659_/C _09729_/D VDD VSS _09666_/A AOAI211X1
XFILLER_43_724 VSS VDD FILLER2
XFILLER_103_96 VSS VDD FILLER2
X_12670_ _19243_/Q VDD VSS _12759_/A INVX1
XFILLER_63_78 VDD VSS FILLER4
X_11621_ _18764_/Q _11624_/B VDD VSS _18791_/D AND2X1
XFILLER_70_598 VDD VSS FILLER4
XFILLER_11_632 VDD VSS DECAPHV8
XFILLER_129_807 VDD VSS FILLER4
X_14340_ _14457_/A VDD VSS _14368_/A BUFX3
X_11552_ _18701_/Q _11555_/B VDD VSS _18728_/D AND2X1
XFILLER_11_654 VSS VDD FILLER2
XTAP_TAPCELL_ROW_155_1406 VDD VSS WELLTAP
XFILLER_156_615 VSS VDD FILLER2
XFILLER_10_142 VDD VSS FILLER4
XFILLER_128_328 VDD VSS FILLER4
XFILLER_155_114 VSS VDD FILLER2
X_10503_ _10503_/A _10503_/B _10503_/C VDD VSS _10548_/B OR3X2
X_14271_ _14285_/A _14271_/B VDD VSS _19009_/D NOR2X1
X_11483_ _18639_/Q _11484_/B VDD VSS _18666_/D AND2X1
XFILLER_10_175 VDD VSS FILLER4
XFILLER_137_840 VSS VDD FILLER2
X_16010_ _16010_/A _16010_/B VDD VSS _16873_/B XNOR2X1
X_13222_ _13319_/A _14385_/B _13231_/C VDD VSS _14386_/C OR3BX1
X_10434_ _18555_/Q _10434_/B VDD VSS _10472_/A NAND2X1
XTAP_TAPCELL_ROW_20_192 VDD VSS WELLTAP
XFILLER_88_20 VDD VSS FILLER4
X_13153_ _13240_/A _13240_/B _13240_/C VDD VSS _13154_/C OAI21X1
X_10365_ _18687_/Q _18741_/Q VDD VSS _10413_/C XNOR2X1
XFILLER_124_545 VDD VSS FILLER1
XFILLER_112_707 VDD VSS FILLER4
X_12104_ _19235_/Q _14529_/B VDD VSS _12158_/D _14529_/C NAND3X1
X_17961_ _17966_/A _17966_/B _18163_/A VDD VSS _17962_/C AOI21X1
X_13084_ _18939_/Q _13086_/B _13086_/C VDD VSS _14156_/B XNOR3X1
XFILLER_151_375 VDD VSS DECAPHV8
X_10296_ _10346_/A _10346_/B _10349_/B VDD VSS _10385_/C AO21X2
X_16912_ _20069_/Q _16912_/B _16912_/C _20057_/Q VDD VSS _16913_/C OAI211X1
X_19700_ _19702_/CK _19700_/D _19700_/Q VDD VSS DFFQX1
X_12035_ _12035_/A _12035_/B _12035_/C _12035_/D VDD VSS _12040_/A OAOI211X1
XFILLER_78_632 VSS VDD FILLER2
XFILLER_120_740 VSS VDD FILLER2
X_17892_ _17892_/A _17894_/C VDD VSS _17893_/B XNOR2X1
XTAP_TAPCELL_ROW_166_1513 VDD VSS WELLTAP
XFILLER_77_120 VDD VSS FILLER1
XFILLER_78_654 VDD VSS FILLER1
XFILLER_120_762 VSS VDD FILLER2
XFILLER_93_602 VDD VSS FILLER4
X_16843_ _16843_/A _16843_/B VDD VSS _19683_/D AND2X1
X_19631_ _19664_/CK _19631_/D _19631_/Q VDD VSS DFFQX1
XFILLER_77_164 VSS VDD FILLER2
XFILLER_38_529 VDD VSS DECAPHV8
XFILLER_92_101 VSS VDD FILLER2
XFILLER_19_7 VSS VDD FILLER2
XFILLER_65_337 VSS VDD FILLER2
X_19562_ _19584_/CK _19562_/D _19562_/Q VDD VSS DFFQX1
X_16774_ _16793_/A _16774_/B VDD VSS _19621_/D AND2X1
XFILLER_18_220 VSS VDD FILLER2
X_13986_ _18894_/Q _14137_/B VDD VSS _14018_/C _14137_/C NAND3X1
X_18513_ _18513_/CK _18513_/D _18513_/Q _09337_/Y VDD VSS DFFRQX1
XFILLER_92_167 VSS VDD FILLER2
XFILLER_80_307 VSS VDD FILLER2
X_15725_ _15725_/A _15725_/B VDD VSS _19351_/D AND2X1
X_19493_ _19536_/CK _19493_/D _19493_/Q VDD VSS DFFQX1
X_12937_ _13107_/A _13107_/B _13107_/D _13107_/C VDD VSS _14413_/C AOI211X1
XFILLER_73_370 VSS VDD FILLER2
XFILLER_19_798 VDD VSS FILLER4
XTAP_TAPCELL_ROW_91_836 VDD VSS WELLTAP
XTAP_TAPCELL_ROW_8_83 VDD VSS WELLTAP
XFILLER_73_381 VDD VSS FILLER1
XFILLER_160_91 VSS VDD FILLER2
X_18444_ _18454_/CK _18444_/D _18444_/Q _20073_/RB VDD VSS DFFRQX1
XFILLER_33_223 VSS VDD FILLER2
X_15656_ _19358_/Q _15733_/B VDD VSS _15658_/A XNOR2X1
XFILLER_61_543 VSS VDD FILLER2
X_12868_ _12868_/A _12868_/B _14318_/B _12868_/D _12868_/E VDD VSS _13005_/C OAI221X1
XTAP_TAPCELL_ROW_103_937 VDD VSS WELLTAP
XFILLER_34_768 VDD VSS FILLER4
XFILLER_61_576 VSS VDD FILLER2
X_14607_ _15859_/A _14607_/B _14645_/C VDD VSS _14638_/C XNOR3X1
XFILLER_21_418 VSS VDD FILLER2
X_18375_ _18375_/CK _18471_/D _18375_/Q _18464_/RB VDD VSS DFFRQX1
X_11819_ _11819_/A _11819_/B _14396_/B VDD VSS _11821_/B MIN3X1
XFILLER_33_278 VDD VSS FILLER1
X_15587_ _19326_/Q _15698_/B VDD VSS _15591_/B XNOR2X1
X_12799_ _12868_/A _12868_/B _12868_/E _12799_/D VDD VSS _14286_/C OAOI211X1
X_17326_ _17327_/A _17329_/C _17363_/C VDD VSS _17327_/C OAI21X1
XFILLER_159_453 VDD VSS FILLER4
XFILLER_147_604 VSS VDD FILLER2
X_14538_ _14538_/A _14538_/B _17827_/B VDD VSS _19244_/D AOI21X1
XFILLER_147_637 VDD VSS FILLER4
XFILLER_119_339 VDD VSS FILLER4
X_17257_ _17255_/B _17257_/B VDD VSS _17258_/C NOR2BX1
X_14469_ _14421_/Y _14469_/B _14469_/C VDD VSS _19183_/D AND3BX1
XFILLER_146_147 VSS VDD FILLER2
Xclkbuf_leaf_5_sclk delaybuf_1_sclk/A VDD VSS _18235_/CK BUFX12
XFILLER_162_607 VSS VDD FILLER2
X_16208_ _16208_/A _16208_/B VDD VSS _16209_/C NAND2X1
XFILLER_134_309 VDD VSS FILLER1
XFILLER_162_618 VSS VDD FILLER2
X_17188_ _19792_/Q _19760_/Q VDD VSS _17189_/C NAND2X1
XTAP_TAPCELL_ROW_132_1203 VDD VSS WELLTAP
XFILLER_155_670 VSS VDD FILLER2
XFILLER_115_512 VDD VSS FILLER4
XFILLER_155_681 VDD VSS FILLER4
XFILLER_115_523 VSS VDD FILLER2
XFILLER_6_680 VSS VDD FILLER2
X_16139_ _19588_/Q _16738_/B VDD VSS _16157_/B XNOR2X1
XTAP_TAPCELL_ROW_99_903 VDD VSS WELLTAP
XFILLER_88_407 VDD VSS DECAPHV8
XFILLER_45_0 VDD VSS FILLER1
XFILLER_142_375 VDD VSS FILLER1
XFILLER_102_217 VDD VSS FILLER4
XFILLER_69_621 VDD VSS FILLER4
XFILLER_124_18 VDD VSS FILLER4
XFILLER_68_120 VSS VDD FILLER2
XFILLER_69_654 VSS VDD FILLER2
XFILLER_68_142 VDD VSS FILLER4
XFILLER_96_462 VSS VDD FILLER2
XFILLER_84_602 VSS VDD FILLER2
X_19829_ clkload4/A _19829_/D _19829_/Q VDD VSS DFFQX1
XFILLER_68_164 VSS VDD FILLER2
XFILLER_84_635 VDD VSS FILLER4
XFILLER_56_337 VSS VDD FILLER2
XFILLER_68_197 VDD VSS FILLER1
XFILLER_72_819 VSS VDD FILLER2
XFILLER_140_17 VDD VSS FILLER1
X_09513_ _09421_/A _09527_/B _20014_/Q VDD VSS _09515_/B AOI2B1X1
XFILLER_71_318 VSS VDD FILLER2
XFILLER_83_189 VSS VDD FILLER2
XFILLER_37_595 VDD VSS FILLER1
XFILLER_64_392 VDD VSS DECAPHV8
X_09444_ _09630_/C _09578_/B VDD VSS _09810_/B OR2X2
XFILLER_80_852 VSS VDD FILLER2
XFILLER_52_576 VDD VSS DECAPHV8
X_09375_ _09496_/B VDD VSS _09467_/B BUFX3
XTAP_TAPCELL_ROW_62_571 VDD VSS WELLTAP
XFILLER_40_738 VDD VSS FILLER4
XFILLER_33_59 VDD VSS DECAPHV8
XFILLER_149_37 VDD VSS DECAPHV8
XFILLER_130_8 VSS VDD FILLER2
XFILLER_165_423 VSS VDD FILLER2
XFILLER_137_125 VDD VSS FILLER1
XFILLER_123_7 VSS VDD FILLER2
XFILLER_20_473 VDD VSS FILLER4
XFILLER_119_840 VSS VDD FILLER2
XFILLER_4_617 VSS VDD FILLER2
XFILLER_118_372 VDD VSS DECAPHV8
XFILLER_165_36 VSS VDD FILLER2
XFILLER_79_407 VSS VDD FILLER2
X_10150_ _10150_/A _10150_/B _10150_/C _10150_/D VDD VSS _10152_/C OA211X2
XFILLER_160_150 VDD VSS FILLER4
XFILLER_133_375 VSS VDD FILLER2
XFILLER_58_12 VDD VSS FILLER4
X_10081_ _10068_/Y _10080_/Y _10127_/A VDD VSS _10081_/Y MUX2X1
XFILLER_102_740 VDD VSS FILLER1
XFILLER_58_67 VSS VDD FILLER2
XFILLER_87_462 VSS VDD FILLER2
XFILLER_59_153 VDD VSS FILLER1
XFILLER_101_261 VSS VDD FILLER2
XFILLER_75_624 VSS VDD FILLER2
X_13840_ _13840_/A _13840_/B _13840_/C _13840_/D VDD VSS _13843_/B OAOI211X1
XFILLER_28_562 VDD VSS FILLER4
XFILLER_74_55 VDD VSS FILLER4
X_13771_ _13771_/A _14195_/B _13771_/C _13771_/D VDD VSS _13921_/A OAOI211X1
XFILLER_90_638 VSS VDD FILLER2
X_10983_ _10984_/A _10983_/B VDD VSS _10984_/C NAND2X1
XFILLER_90_649 VDD VSS FILLER1
X_15510_ _19463_/Q _15851_/B VDD VSS _15520_/A NOR2BX1
XTAP_TAPCELL_ROW_161_1465 VDD VSS WELLTAP
XFILLER_16_746 VDD VSS FILLER4
X_12722_ _12868_/A _12868_/B _12868_/E VDD VSS _12778_/B OA21X2
XFILLER_16_757 VSS VDD FILLER2
X_16490_ _19729_/Q _16490_/B _16894_/B VDD VSS _16515_/B MIN3X1
XFILLER_16_768 VDD VSS FILLER1
XFILLER_15_245 VSS VDD FILLER2
XFILLER_130_61 VDD VSS FILLER1
XTAP_TAPCELL_ROW_25_240 VDD VSS WELLTAP
X_15441_ _15474_/A _15474_/B VDD VSS _15472_/B XNOR2X1
X_12653_ _12654_/B _12654_/C _19157_/Q VDD VSS _12656_/B AOI21X1
XFILLER_70_373 VSS VDD FILLER2
X_18160_ _19298_/Q _18164_/B VDD VSS _18162_/C XNOR2X1
X_11604_ _18748_/Q _11612_/B VDD VSS _18775_/D AND2X1
XFILLER_30_248 VDD VSS FILLER4
X_15372_ _15389_/C _15389_/B VDD VSS _15373_/B NOR2BX1
X_12584_ _20006_/Q _19270_/Q VDD VSS _12763_/D OR2X2
XFILLER_156_412 VDD VSS FILLER4
XFILLER_129_637 VDD VSS FILLER4
X_17111_ _17114_/C _17112_/B _17164_/C VDD VSS _17112_/C OAI21X1
XFILLER_156_423 VDD VSS FILLER1
X_14323_ _14323_/A _14323_/B _14323_/C VDD VSS _14324_/C AOI21X1
X_18091_ _19285_/Q _18094_/B VDD VSS _18095_/B XOR2X1
X_11535_ _18686_/Q _11542_/B VDD VSS _18713_/D AND2X1
XFILLER_11_484 VSS VDD FILLER2
XFILLER_7_433 VSS VDD FILLER2
XFILLER_156_456 VSS VDD FILLER2
XFILLER_144_607 VSS VDD FILLER2
X_17042_ _19760_/Q _19761_/Q _17047_/B _17042_/D VDD VSS _17045_/C OAOI211X1
XFILLER_7_455 VSS VDD FILLER2
X_14254_ _14270_/A _14254_/B VDD VSS _18993_/D AND2X1
XFILLER_109_361 VDD VSS FILLER1
X_11466_ _19958_/Q _11473_/B VDD VSS _18651_/D AND2X1
XFILLER_99_41 VSS VDD FILLER2
XFILLER_7_477 VDD VSS FILLER1
X_13205_ _18997_/Q VDD VSS _13308_/A INVX1
X_10417_ _10417_/A _10417_/B _10417_/C _10417_/D VDD VSS _10448_/A AOAI211X1
X_14185_ _14197_/A _14185_/B VDD VSS _18937_/D AND2X1
X_11397_ _11398_/C _11397_/B VDD VSS _18597_/D NOR2X1
XFILLER_99_85 VDD VSS FILLER1
XFILLER_152_651 VSS VDD FILLER2
XFILLER_99_96 VSS VDD FILLER2
XFILLER_124_353 VSS VDD FILLER2
X_13136_ _13141_/A _13141_/B _13141_/D _13141_/C VDD VSS _14478_/C AOI211X1
XFILLER_97_204 VDD VSS FILLER4
X_10348_ _10385_/B _10359_/B _10579_/D VDD VSS _10500_/B MUXI2X1
XFILLER_98_738 VSS VDD FILLER2
XFILLER_152_695 VSS VDD FILLER2
X_18993_ _19025_/CK _18993_/D _18993_/Q VDD VSS DFFQX1
XFILLER_151_172 VDD VSS FILLER4
XFILLER_31_6 VDD VSS FILLER1
X_17944_ _17942_/B _17946_/A _17944_/C VDD VSS _19955_/D AOI2B1X1
X_13067_ _19079_/Q _13067_/B _13212_/C VDD VSS _13098_/B XNOR3X1
X_10279_ _18684_/Q _18738_/Q VDD VSS _10329_/A AND2X1
XFILLER_66_602 VSS VDD FILLER2
XFILLER_24_5 VSS VDD FILLER2
X_12018_ _12018_/A _12018_/B VDD VSS _14337_/B XNOR2X1
X_17875_ _18852_/Q VDD VSS _17876_/A INVX1
XFILLER_93_410 VSS VDD FILLER2
X_19614_ _19667_/CK _19614_/D _19614_/Q VDD VSS DFFQX1
X_16826_ _16826_/A _16826_/B VDD VSS _19668_/D NOR2X1
XFILLER_65_145 VSS VDD FILLER2
XFILLER_19_540 VSS VDD FILLER2
XFILLER_81_616 VSS VDD FILLER2
XFILLER_93_487 VSS VDD FILLER2
X_16757_ _16759_/A _16757_/B VDD VSS _19606_/D NOR2X1
X_19545_ _19737_/CK _19545_/D _19545_/Q VDD VSS DFFQX1
X_13969_ _19006_/Q _14010_/D _13969_/C VDD VSS _14004_/C XOR3X1
XFILLER_93_498 VDD VSS FILLER1
XFILLER_65_189 VSS VDD FILLER2
XFILLER_46_370 VDD VSS FILLER1
XFILLER_34_510 VDD VSS FILLER1
XTAP_TAPCELL_ROW_76_696 VDD VSS WELLTAP
XFILLER_81_649 VSS VDD FILLER2
XFILLER_80_137 VSS VDD FILLER2
X_15708_ _16795_/A VDD VSS _15725_/A BUFX3
XFILLER_46_392 VSS VDD FILLER2
X_16688_ _19737_/Q _16902_/B VDD VSS _16690_/B XNOR2X1
X_19476_ _19528_/CK _19476_/D _19476_/Q VDD VSS DFFQX1
X_15639_ _15639_/A VDD VSS _15641_/B INVX1
X_18427_ _18439_/CK _18427_/D _18427_/Q _18463_/RB VDD VSS DFFRQX1
X_18358_ _18359_/CK _18470_/D _20226_/A _18471_/RB VDD VSS DFFRQX1
XFILLER_119_114 VDD VSS FILLER4
X_17309_ _17309_/A _17309_/B _17309_/C VDD VSS _17318_/A OA21X2
XFILLER_119_18 VDD VSS FILLER4
X_18289_ _18295_/CK _18289_/D _18289_/Q VDD VSS DFFQX1
XFILLER_30_793 VSS VDD FILLER2
XFILLER_119_158 VSS VDD FILLER2
XFILLER_89_727 VSS VDD FILLER2
XFILLER_115_375 VSS VDD FILLER2
XFILLER_131_824 VDD VSS FILLER4
X_20182_ _20182_/A VDD VSS _20182_/Y BUFX3
XFILLER_103_526 VSS VDD FILLER2
XFILLER_131_835 VSS VDD FILLER2
X_09993_ _11226_/D _09993_/B _09993_/C VDD VSS _09998_/B OA21X2
XFILLER_88_215 VDD VSS FILLER4
XFILLER_143_695 VDD VSS FILLER4
XFILLER_88_226 VDD VSS FILLER1
XFILLER_130_345 VSS VDD FILLER2
XFILLER_69_462 VSS VDD FILLER2
XFILLER_28_15 VDD VSS FILLER1
XFILLER_111_570 VSS VDD FILLER2
XFILLER_96_270 VSS VDD FILLER2
XFILLER_84_421 VSS VDD FILLER2
XTAP_TAPCELL_ROW_39_365 VDD VSS WELLTAP
XFILLER_25_510 VSS VDD FILLER2
XFILLER_72_649 VDD VSS FILLER4
XFILLER_37_370 VSS VDD FILLER2
XFILLER_71_137 VSS VDD FILLER2
XFILLER_71_159 VSS VDD FILLER2
XFILLER_80_660 VSS VDD FILLER2
XFILLER_52_362 VSS VDD FILLER2
X_09427_ _18505_/Q _09630_/C _18506_/Q VDD VSS _09816_/B OR3BX1
XFILLER_52_384 VDD VSS FILLER1
XFILLER_40_535 VDD VSS FILLER4
XFILLER_12_237 VDD VSS FILLER1
XTAP_TAPCELL_ROW_22_210 VDD VSS WELLTAP
X_09358_ _20065_/RB _09362_/B VDD VSS _09358_/Y NOR2BX1
Xclkbuf_1_0__f_clk_regs clkbuf_0_clk_regs/Y VDD VSS clkload1/A BUFX12
X_09289_ _09414_/D _20048_/Q _09289_/C VDD VSS _20046_/D AOI2B1X1
XFILLER_60_68 VDD VSS FILLER1
XFILLER_20_281 VSS VDD FILLER2
XFILLER_126_607 VSS VDD FILLER2
X_11320_ _11318_/B _11322_/B VDD VSS _11339_/A NAND2BX1
XFILLER_5_19 VDD VSS FILLER4
X_11251_ _11253_/A _11253_/C _11253_/B _11251_/D VDD VSS _18579_/D AOI31X1
XFILLER_109_62 VSS VDD FILLER2
XFILLER_109_73 VDD VSS FILLER1
XFILLER_106_342 VSS VDD FILLER2
XFILLER_122_802 VSS VDD FILLER2
X_10202_ _18618_/Q _10202_/B _10201_/B VDD VSS _10217_/A AOI21BX1
XFILLER_133_150 VSS VDD FILLER2
X_11182_ _11049_/Y _11181_/Y _11298_/A VDD VSS _11182_/Y MUXI2X1
XFILLER_69_55 VDD VSS FILLER4
XFILLER_69_66 VSS VDD FILLER2
XFILLER_106_386 VDD VSS FILLER4
XFILLER_134_695 VSS VDD FILLER2
X_10133_ _18611_/Q _10134_/B VDD VSS _10150_/D OR2X2
X_15990_ _15990_/A VDD VSS _15991_/C INVX1
XFILLER_48_602 VSS VDD FILLER2
X_14941_ _19394_/Q _15773_/B VDD VSS _14942_/B XNOR2X1
X_10064_ _10075_/A _10064_/B VDD VSS _11411_/C XNOR2X1
XFILLER_88_782 VSS VDD FILLER2
XFILLER_85_21 VSS VDD FILLER2
XFILLER_48_613 VDD VSS FILLER1
XFILLER_102_570 VDD VSS FILLER4
XFILLER_121_389 VDD VSS DECAPHV8
XFILLER_88_793 VSS VDD FILLER2
XFILLER_75_410 VDD VSS FILLER1
XFILLER_47_101 VDD VSS FILLER4
X_17660_ _17663_/C _17661_/B _17746_/C VDD VSS _17661_/C OAI21X1
XFILLER_47_134 VSS VDD FILLER2
X_14872_ _14872_/A _14872_/B _14872_/C _14872_/D VDD VSS _14881_/A AOAI211X1
XFILLER_75_454 VDD VSS FILLER4
X_16611_ _16621_/B _16611_/B VDD VSS _16864_/B XNOR2X1
XFILLER_63_616 VDD VSS FILLER1
X_13823_ _18947_/Q _14197_/B VDD VSS _13990_/A AND2X1
X_17591_ _19878_/Q _19846_/Q _17591_/C VDD VSS _17596_/C AO21X2
XFILLER_47_189 VSS VDD FILLER2
XFILLER_90_435 VSS VDD FILLER2
XFILLER_16_532 VSS VDD FILLER2
X_16542_ _16896_/B _19731_/Q VDD VSS _16543_/C NOR2BX1
X_19330_ _19385_/CK _19330_/D _19330_/Q VDD VSS DFFQX1
XFILLER_44_852 VSS VDD FILLER2
X_13754_ _13818_/A _13918_/B VDD VSS _14164_/B XNOR2X1
X_10966_ _10966_/A _10966_/B _10966_/C VDD VSS _10982_/A OAI21X1
XTAP_TAPCELL_ROW_73_666 VDD VSS WELLTAP
XFILLER_43_340 VDD VSS FILLER1
XFILLER_43_351 VSS VDD FILLER2
X_19261_ _20000_/CK _19261_/D _19261_/Q VDD VSS DFFQX1
X_12705_ _18963_/Q _12712_/B _12705_/C VDD VSS _12708_/C XNOR3X1
X_16473_ _19600_/Q _16751_/B VDD VSS _16474_/C NOR2X1
X_13685_ _19000_/Q _14262_/B VDD VSS _13686_/D _14262_/C NAND3X1
XFILLER_70_170 VDD VSS FILLER1
X_10897_ _18647_/Q _18809_/Q VDD VSS _10898_/B XNOR2X1
XFILLER_148_209 VDD VSS FILLER1
X_15424_ _19377_/Q _15424_/B VDD VSS _15425_/D NAND2X1
X_19192_ _19223_/CK _19192_/D _19192_/Q VDD VSS DFFQX1
X_12636_ _12719_/A _14347_/B VDD VSS _12731_/A NOR2X1
XTAP_TAPCELL_ROW_5_62 VDD VSS WELLTAP
X_18143_ _19294_/Q _18143_/B _18143_/C VDD VSS _18150_/A MIN3X1
X_15355_ _15355_/A _15355_/B _15878_/B VDD VSS _15396_/A AOI21X1
XFILLER_11_270 VSS VDD FILLER2
XFILLER_12_793 VSS VDD FILLER2
X_12567_ _12840_/B _14472_/C _19185_/Q VDD VSS _12568_/D AND3BX1
XFILLER_8_742 VDD VSS FILLER1
XFILLER_157_765 VDD VSS FILLER4
XFILLER_156_253 VDD VSS FILLER4
XFILLER_11_292 VDD VSS FILLER4
X_14306_ _14311_/A _14306_/B VDD VSS _19038_/D NOR2X1
XFILLER_117_629 VSS VDD FILLER2
X_18074_ _18074_/A _18074_/B _18074_/C VDD VSS _18076_/B AO21X2
Xwire161 wire161/A VDD VSS wire161/Y BUFX6
X_11518_ _18671_/Q _11519_/B VDD VSS _18698_/D AND2X1
XFILLER_8_775 VSS VDD FILLER2
X_15286_ _19430_/Q _15814_/B VDD VSS _15287_/B XNOR2X1
XFILLER_157_798 VDD VSS FILLER4
XFILLER_156_275 VDD VSS FILLER4
X_12498_ _20005_/Q _19269_/Q VDD VSS _12677_/B XOR2X1
X_17025_ _19758_/Q _17049_/B VDD VSS _17028_/A NAND2X1
X_14237_ _14270_/A _14237_/B VDD VSS _18981_/D AND2X1
XFILLER_7_296 VSS VDD FILLER2
X_11449_ _18006_/C VDD VSS _16860_/A BUFX3
XFILLER_125_673 VSS VDD FILLER2
Xclkbuf_leaf_11_clk_regs clkbuf_leaf_9_clk_regs/A VDD VSS _19934_/CK BUFX12
XFILLER_125_684 VDD VSS FILLER1
XFILLER_152_470 VSS VDD FILLER2
Xclkbuf_1_1__f__09170_ clkbuf_0__09170_/Y VDD VSS _18357_/CK BUFX12
X_14168_ _14197_/A _14168_/B VDD VSS _18921_/D AND2X1
XFILLER_112_312 VSS VDD FILLER2
XFILLER_113_835 VSS VDD FILLER2
XFILLER_140_621 VDD VSS FILLER1
XFILLER_140_632 VSS VDD FILLER2
Xclkbuf_leaf_31__000_ clkload70/A VDD VSS _19460_/CK BUFX12
XFILLER_140_643 VSS VDD FILLER2
X_13119_ _13231_/A _14385_/B VDD VSS _13219_/B NOR2X1
X_18976_ _19059_/CK _18976_/D _18976_/Q VDD VSS DFFQX1
X_14099_ _14139_/B _14139_/C _18896_/Q VDD VSS _14101_/C AOI21X1
X_17927_ _17927_/A _17927_/B _17927_/C _17927_/D VDD VSS _17941_/B OAOI211X1
XFILLER_79_782 VDD VSS FILLER4
XFILLER_66_421 VSS VDD FILLER2
XFILLER_38_134 VDD VSS FILLER4
X_17858_ _18850_/Q _17869_/B VDD VSS _17860_/B XNOR2X1
XFILLER_39_679 VSS VDD FILLER2
XFILLER_81_402 VDD VSS FILLER1
XTAP_TAPCELL_ROW_127_1157 VDD VSS WELLTAP
XFILLER_66_487 VDD VSS DECAPHV8
X_16809_ _16843_/A _16809_/B VDD VSS _19652_/D AND2X1
XFILLER_54_638 VSS VDD FILLER2
XFILLER_53_104 VDD VSS FILLER1
X_17789_ _17793_/A _17790_/B _17828_/C VDD VSS _17790_/C OAI21X1
XFILLER_54_649 VDD VSS FILLER1
XFILLER_35_830 VDD VSS FILLER1
XFILLER_19_381 VSS VDD FILLER2
XTAP_TAPCELL_ROW_36_335 VDD VSS WELLTAP
X_19528_ _19528_/CK _19528_/D _19528_/Q VDD VSS DFFQX1
XFILLER_81_468 VSS VDD FILLER2
XFILLER_34_340 VSS VDD FILLER2
XFILLER_34_351 VDD VSS FILLER1
X_19459_ _19460_/CK _19459_/D _19459_/Q VDD VSS DFFQX1
XFILLER_22_524 VSS VDD FILLER2
XFILLER_139_209 VSS VDD FILLER2
X_09212_ _18516_/Q VDD VSS _18415_/D INVX1
XFILLER_148_710 VSS VDD FILLER2
XFILLER_22_579 VDD VSS FILLER1
XFILLER_108_607 VDD VSS FILLER4
XTAP_TAPCELL_ROW_138_1253 VDD VSS WELLTAP
XFILLER_107_128 VDD VSS FILLER1
XFILLER_30_49 VSS VDD FILLER2
XFILLER_146_49 VDD VSS FILLER4
XFILLER_150_407 VDD VSS FILLER4
XFILLER_104_802 VSS VDD FILLER2
XFILLER_116_673 VDD VSS FILLER4
XFILLER_122_109 VDD VSS FILLER1
XFILLER_116_695 VSS VDD FILLER2
XFILLER_143_481 VSS VDD FILLER2
XFILLER_131_632 VDD VSS FILLER1
XFILLER_143_492 VDD VSS FILLER1
XFILLER_131_654 VSS VDD FILLER2
X_20165_ _20165_/A VDD VSS _20165_/Y BUFX3
XFILLER_130_142 VSS VDD FILLER2
XFILLER_89_579 VSS VDD FILLER2
XFILLER_131_698 VSS VDD FILLER2
X_20096_ _20096_/A VDD VSS _20096_/Y BUFX3
XFILLER_162_59 VSS VDD FILLER2
XFILLER_85_741 VSS VDD FILLER2
XFILLER_29_156 VDD VSS FILLER4
XFILLER_29_167 VSS VDD FILLER2
XFILLER_72_413 VDD VSS FILLER4
XFILLER_44_104 VSS VDD FILLER2
XFILLER_29_189 VSS VDD FILLER2
XFILLER_45_649 VSS VDD FILLER2
XFILLER_44_137 VSS VDD FILLER2
X_10820_ _19952_/Q _18834_/Q VDD VSS _10856_/D NOR2X1
XFILLER_53_660 VDD VSS FILLER1
XFILLER_25_351 VSS VDD FILLER2
X_10751_ _10790_/A _10751_/B VDD VSS _10772_/B XNOR2X1
XFILLER_52_170 VSS VDD FILLER2
XTAP_TAPCELL_ROW_70_647 VDD VSS WELLTAP
XFILLER_80_490 VSS VDD FILLER2
XFILLER_40_332 VDD VSS FILLER1
XFILLER_111_96 VSS VDD FILLER2
X_13470_ _19139_/Q _13470_/B _13617_/D VDD VSS _13614_/C XNOR3X1
XFILLER_71_56 VSS VDD FILLER2
X_10682_ _19948_/Q _18830_/Q VDD VSS _10722_/B NOR2X1
X_12421_ _12421_/A _14344_/B VDD VSS _12461_/A NOR2X1
XFILLER_40_398 VSS VDD FILLER2
XFILLER_139_765 VDD VSS FILLER4
XFILLER_154_702 VDD VSS FILLER1
X_15140_ _15183_/A _15183_/B VDD VSS _15874_/B XOR2X1
XFILLER_154_713 VDD VSS FILLER4
XFILLER_126_415 VSS VDD FILLER2
X_12352_ _18875_/Q _12352_/B _12352_/C VDD VSS _12528_/B MIN3X1
XFILLER_138_275 VDD VSS FILLER4
XFILLER_112_0 VSS VDD FILLER2
XFILLER_5_734 VSS VDD FILLER2
XFILLER_154_746 VDD VSS FILLER4
X_11303_ _11312_/B _11312_/C VDD VSS _11304_/B NOR2BX1
X_15071_ _15082_/A _15071_/B VDD VSS _15083_/B XNOR2X1
X_12283_ _12283_/A _12283_/B _12449_/C VDD VSS _14309_/B XNOR3X1
XFILLER_154_779 VSS VDD FILLER2
X_14022_ _18894_/Q _14137_/B VDD VSS _14098_/C _14137_/C AND3X2
XTAP_TAPCELL_ROW_115_1050 VDD VSS WELLTAP
X_11234_ _11364_/A _11317_/B VDD VSS _11235_/C NOR2X1
XFILLER_107_684 VDD VSS DECAPHV8
XFILLER_106_183 VSS VDD FILLER2
XFILLER_122_643 VDD VSS FILLER4
X_18830_ _18831_/CK _18830_/D _18830_/Q VDD VSS DFFQX1
X_11165_ _18708_/Q _18762_/Q VDD VSS _11167_/C NAND2X1
XFILLER_96_53 VDD VSS FILLER1
XFILLER_121_153 VDD VSS FILLER4
XFILLER_67_207 VSS VDD FILLER2
X_10116_ _10091_/Y _10145_/B _10155_/A VDD VSS _10167_/B MUXI2X1
XTAP_TAPCELL_ROW_78_714 VDD VSS WELLTAP
XFILLER_67_218 VSS VDD FILLER2
XFILLER_121_175 VSS VDD FILLER2
X_15973_ _15989_/A _15989_/B VDD VSS _16837_/B XNOR2X1
X_18761_ _18785_/CK _18761_/D _18761_/Q VDD VSS DFFQX1
X_11096_ _11142_/C _11096_/B _11096_/C VDD VSS _11096_/Y OAI21X1
XFILLER_95_538 VDD VSS FILLER1
X_18204__251 _20052_/CK VDD VSS _20046_/CK INVX1
XFILLER_0_483 VSS VDD FILLER2
XFILLER_48_421 VSS VDD FILLER2
XFILLER_48_432 VSS VDD FILLER2
X_14924_ _15899_/B VDD VSS _14925_/B INVX1
X_17712_ _17712_/A _17712_/B _17712_/C VDD VSS _17716_/C MIN3X1
X_10047_ _11208_/A _10047_/B VDD VSS _10048_/C NAND2X1
X_18692_ _18773_/CK _18692_/D _18692_/Q VDD VSS DFFQX1
XFILLER_76_774 VDD VSS FILLER1
XFILLER_91_711 VSS VDD FILLER2
XFILLER_48_476 VSS VDD FILLER2
XFILLER_63_413 VSS VDD FILLER2
X_14855_ _19336_/Q _15709_/B _14855_/C VDD VSS _14901_/B MIN3X1
X_17643_ _17646_/A _17643_/B _17643_/C VDD VSS _19889_/D AOI21X1
XTAP_TAPCELL_ROW_86_791 VDD VSS WELLTAP
XFILLER_29_690 VSS VDD FILLER2
XFILLER_17_830 VDD VSS FILLER1
XFILLER_63_446 VSS VDD FILLER2
X_13806_ _18918_/Q _14164_/B VDD VSS _13876_/A NAND2X1
XFILLER_35_148 VDD VSS FILLER1
X_17574_ _17577_/C _17575_/B _17597_/C VDD VSS _17575_/C OAI21X1
XFILLER_63_468 VDD VSS FILLER4
XFILLER_51_608 VDD VSS DECAPHV16
X_14786_ _14826_/A _14826_/B VDD VSS _14792_/B NOR2X1
X_11998_ _19178_/Q _12113_/A _12032_/B VDD VSS _12029_/D XNOR3X1
XFILLER_32_811 VDD VSS FILLER4
X_16525_ _16525_/A _16525_/B VDD VSS _16526_/C NAND2X1
X_19313_ _19349_/CK _19313_/D _19313_/Q VDD VSS DFFQX1
X_13737_ _19002_/Q _13843_/A _13889_/B VDD VSS _13830_/D XNOR3X1
X_10949_ _10808_/Y _10948_/Y _11118_/A VDD VSS _11213_/B MUX2X1
XFILLER_32_833 VSS VDD FILLER2
XFILLER_31_321 VDD VSS FILLER1
XFILLER_16_395 VSS VDD FILLER2
XFILLER_91_5 VSS VDD FILLER2
X_16456_ _16472_/B _16456_/B VDD VSS _16822_/B XOR2X1
X_19244_ _20004_/CK _19244_/D _19244_/Q VDD VSS DFFQX1
X_13668_ _13751_/A _13807_/B VDD VSS _14130_/B XNOR2X1
XFILLER_84_4 VSS VDD FILLER2
X_15407_ _15430_/B _15407_/B VDD VSS _15818_/B XNOR2X1
X_19175_ _19200_/CK _19175_/D _19175_/Q VDD VSS DFFQX1
X_12619_ _18962_/Q _12619_/B _14213_/B VDD VSS _12712_/B MIN3X1
X_16387_ _19693_/Q _16854_/B VDD VSS _16388_/D NAND2BX1
X_13599_ _13599_/A _13599_/B _13599_/C VDD VSS _13607_/B XNOR3X1
XTAP_TAPCELL_ROW_41_382 VDD VSS WELLTAP
XFILLER_145_713 VSS VDD FILLER2
X_18126_ _18126_/A _18126_/B VDD VSS _18127_/C NAND2X1
X_15338_ _15338_/A _15340_/C VDD VSS _18128_/B XNOR2X1
XFILLER_129_297 VDD VSS FILLER1
XFILLER_145_757 VSS VDD FILLER2
X_18057_ _18549_/Q _18550_/Q _18057_/C _18163_/A VDD VSS _18057_/Y AOI31X1
X_15269_ _19512_/Q _15276_/B VDD VSS _15274_/C AND2X1
XFILLER_132_407 VSS VDD FILLER2
X_17008_ _17019_/A _17019_/B _17009_/B VDD VSS _17010_/B NOR3X1
XFILLER_132_429 VDD VSS FILLER4
XFILLER_113_621 VSS VDD FILLER2
XFILLER_153_790 VDD VSS DECAPHV8
X_09830_ _10313_/B VDD VSS _09928_/C BUFX3
XFILLER_113_654 VDD VSS FILLER4
XFILLER_59_708 VDD VSS FILLER4
XFILLER_112_142 VSS VDD FILLER2
Xclkbuf_0__09184_ _18233_/ECK VDD VSS clkbuf_0__09184_/Y BUFX12
XFILLER_98_387 VSS VDD FILLER2
X_09761_ _09761_/A _09761_/B VDD VSS _18291_/D NAND2X1
XFILLER_101_849 VSS VDD FILLER2
X_18959_ _18961_/CK _18959_/D _18959_/Q VDD VSS DFFQX1
XFILLER_39_410 VSS VDD FILLER2
XFILLER_39_432 VDD VSS FILLER1
XFILLER_100_359 VDD VSS FILLER4
X_09692_ _09819_/A _09692_/B VDD VSS _09693_/E NOR2X1
XFILLER_39_454 VSS VDD FILLER2
XFILLER_82_700 VSS VDD FILLER2
XFILLER_81_210 VDD VSS FILLER4
XFILLER_27_649 VSS VDD FILLER2
XFILLER_26_137 VSS VDD FILLER2
XFILLER_54_457 VSS VDD FILLER2
XFILLER_42_619 VDD VSS FILLER1
XFILLER_35_660 VSS VDD FILLER2
XFILLER_23_855 VSS VDD FILLER2
XFILLER_50_696 VDD VSS FILLER1
XFILLER_41_15 VSS VDD FILLER2
XFILLER_148_540 VDD VSS FILLER4
XFILLER_22_398 VSS VDD FILLER2
XFILLER_6_509 VSS VDD FILLER2
XFILLER_136_713 VDD VSS FILLER1
XFILLER_148_595 VDD VSS FILLER1
XFILLER_108_437 VSS VDD FILLER2
XFILLER_135_212 VSS VDD FILLER2
XFILLER_108_459 VSS VDD FILLER2
XFILLER_135_245 VSS VDD FILLER2
XFILLER_135_278 VDD VSS FILLER1
XFILLER_135_289 VSS VDD FILLER2
XFILLER_2_726 VDD VSS FILLER1
XFILLER_150_226 VDD VSS FILLER4
X_20217_ _20217_/A VDD VSS _20217_/Y BUFX3
XFILLER_103_131 VSS VDD FILLER2
XFILLER_89_354 VSS VDD FILLER2
XFILLER_104_676 VSS VDD FILLER2
XFILLER_104_687 VSS VDD FILLER2
X_20148_ _20148_/A VDD VSS _20148_/Y BUFX3
XFILLER_66_12 VSS VDD FILLER2
X_20079_ _20080_/CK _20079_/D _20079_/Q _20080_/RB VDD VSS DFFRQX1
X_12970_ _13135_/A _13133_/C _12970_/C VDD VSS _13042_/B XNOR3X1
X_11921_ _19176_/Q _14462_/B _14462_/C VDD VSS _11922_/D OR3BX1
XFILLER_72_210 VSS VDD FILLER2
X_14640_ _19442_/Q _14640_/B _14640_/C VDD VSS _14701_/B MIN3X1
XFILLER_72_243 VDD VSS FILLER1
X_11852_ _11852_/A _11852_/B _14459_/B VDD VSS _11916_/A MIN3X1
XFILLER_72_254 VDD VSS DECAPHV8
XFILLER_45_468 VSS VDD FILLER2
XTAP_TAPCELL_ROW_83_761 VDD VSS WELLTAP
XFILLER_33_619 VDD VSS FILLER1
XFILLER_122_84 VSS VDD FILLER2
XFILLER_82_44 VSS VDD FILLER2
X_10803_ _10803_/A _10803_/B _10866_/B _10803_/D VDD VSS _10804_/E AO31X2
XFILLER_82_55 VDD VSS FILLER1
X_14571_ _20009_/Q _16702_/B VDD VSS _19273_/D AND2X1
X_11783_ _11851_/A _11851_/B VDD VSS _11794_/C XOR2X1
Xclkbuf_1_0__f__09173_ clkbuf_0__09173_/Y VDD VSS _18311_/CK BUFX12
XFILLER_53_490 VSS VDD FILLER2
X_16310_ _19594_/Q _16744_/B VDD VSS _16311_/C NOR2X1
X_13522_ _13604_/A _13604_/B _13599_/C VDD VSS _14294_/B AOI21BX1
X_17290_ _17291_/C _17469_/B _17290_/C VDD VSS _19814_/D AND3BX1
X_10734_ _10947_/A _10734_/B VDD VSS _10735_/D NOR2X1
Xclkbuf_leaf_30__001_ clkbuf_2_1__f__001_/Y VDD VSS _19072_/CK BUFX12
XFILLER_13_365 VSS VDD FILLER2
XTAP_TAPCELL_ROW_158_1437 VDD VSS WELLTAP
X_16241_ _16255_/B _16241_/B VDD VSS _16814_/B XNOR2X1
XFILLER_158_348 VSS VDD FILLER2
X_13453_ _13617_/A _13617_/B _13617_/C VDD VSS _13470_/B AOI21X1
X_10665_ _18560_/Q _10665_/B VDD VSS _10666_/C NOR2X1
XFILLER_127_702 VDD VSS FILLER4
X_12404_ _19239_/Q _12499_/A _12499_/B VDD VSS _12405_/D XNOR3X1
X_16172_ _16174_/B _16173_/B _18168_/C VDD VSS _16173_/C OAI21X1
X_13384_ _18887_/Q VDD VSS _13497_/A INVX1
XFILLER_154_510 VDD VSS FILLER1
XFILLER_139_595 VSS VDD FILLER2
X_10596_ _10596_/A _10596_/B VDD VSS _10630_/A NAND2X1
XFILLER_166_381 VDD VSS DECAPHV16
X_15123_ _15134_/A _15123_/B VDD VSS _15716_/B XNOR2X1
X_12335_ _19071_/Q _12457_/A _12544_/B VDD VSS _12366_/D XNOR3X1
XTAP_TAPCELL_ROW_2_30 VDD VSS WELLTAP
XFILLER_31_92 VDD VSS FILLER1
XFILLER_99_107 VDD VSS FILLER1
X_15054_ _15054_/A _15054_/B _15054_/C _15054_/D VDD VSS _15112_/A OAOI211X1
X_19931_ _19934_/CK _19931_/D _19931_/Q VDD VSS DFFQX1
X_12266_ _18930_/Q _12341_/B _14178_/B VDD VSS _14146_/B XNOR3X1
XFILLER_107_481 VDD VSS FILLER4
X_14005_ _18978_/Q _14233_/B VDD VSS _14045_/E _14233_/C AND3X2
X_11217_ _11217_/A _11217_/B _11217_/C VDD VSS _11220_/C OA21X2
X_19862_ _19895_/CK _19862_/D _19862_/Q VDD VSS DFFQX1
Xoutput70 _20136_/Y VDD VSS o_clk_cfg[3] BUFX3
X_12197_ _12197_/A _12197_/B _14145_/B VDD VSS _12348_/B MIN3X1
XFILLER_68_516 VDD VSS FILLER1
Xoutput81 _20155_/Y VDD VSS o_en_ctrl[3] BUFX3
XFILLER_122_473 VSS VDD FILLER2
X_18813_ _19959_/CK _18813_/D _18813_/Q VDD VSS DFFQX1
Xoutput92 _20176_/Y VDD VSS o_lf_cfg[13] BUFX3
XFILLER_95_313 VDD VSS FILLER1
XFILLER_150_793 VSS VDD FILLER2
X_11148_ _11167_/A _11167_/B _11148_/C VDD VSS _11149_/C OAI21X1
X_19793_ _19934_/CK _19793_/D _19793_/Q VDD VSS DFFQX1
XFILLER_68_549 VDD VSS FILLER1
XFILLER_163_80 VDD VSS FILLER4
XFILLER_163_91 VSS VDD FILLER2
XFILLER_110_668 VSS VDD FILLER2
X_18744_ _18773_/CK _18744_/D _18744_/Q VDD VSS DFFQX1
X_15956_ _19644_/Q _16801_/B _15956_/C VDD VSS _15975_/A OAI21X1
X_11079_ _11047_/Y _11115_/B _10984_/A VDD VSS _11079_/Y MUX2X1
XFILLER_95_379 VSS VDD FILLER2
XFILLER_64_700 VDD VSS DECAPHV16
X_14907_ _19448_/Q _14907_/B _15833_/C VDD VSS _14908_/D OR3BX1
X_15887_ _11641_/B _15887_/B _15887_/C VDD VSS _19494_/D AND3BX1
X_18675_ _18810_/CK _18675_/D _18675_/Q VDD VSS DFFQX1
XFILLER_63_210 VDD VSS FILLER4
XFILLER_91_541 VDD VSS FILLER1
XTAP_TAPCELL_ROW_46_430 VDD VSS WELLTAP
XTAP_TAPCELL_ROW_124_1127 VDD VSS WELLTAP
X_17626_ _17627_/A _17629_/C _17654_/C VDD VSS _17627_/C OAI21X1
X_14838_ _14839_/B _14839_/C _19446_/Q VDD VSS _14840_/B AOI21X1
XFILLER_64_788 VSS VDD FILLER2
XFILLER_24_619 VDD VSS FILLER4
XFILLER_63_276 VSS VDD FILLER2
XFILLER_51_416 VDD VSS FILLER4
XFILLER_17_671 VDD VSS FILLER4
XTAP_TAPCELL_ROW_18_176 VDD VSS WELLTAP
X_14769_ _19306_/Q _14769_/B _15674_/B VDD VSS _14809_/A MIN3X1
X_17557_ _19871_/Q _19839_/Q _17557_/C VDD VSS _17562_/C AOI21X1
XFILLER_16_170 VSS VDD FILLER2
XFILLER_16_181 VSS VDD FILLER2
XFILLER_149_315 VDD VSS FILLER1
X_16508_ _19698_/Q _16859_/B VDD VSS _16517_/B XNOR2X1
X_17488_ _17488_/A _17488_/B _17488_/C VDD VSS _17496_/A OA21X2
XFILLER_31_140 VSS VDD FILLER2
XFILLER_31_162 VSS VDD FILLER2
X_19227_ _19988_/CK _19227_/D _19227_/Q VDD VSS DFFQX1
X_16439_ _19727_/Q _16891_/B VDD VSS _16441_/B XNOR2X1
XFILLER_31_184 VSS VDD FILLER2
XFILLER_118_702 VDD VSS FILLER1
XFILLER_75_0 VDD VSS FILLER4
XFILLER_164_318 VDD VSS FILLER4
X_19158_ _19185_/CK _19158_/D _19158_/Q VDD VSS DFFQX1
XFILLER_157_370 VSS VDD FILLER2
XFILLER_145_543 VSS VDD FILLER2
X_18109_ _18105_/A _18109_/B _18109_/C VDD VSS _18112_/B AOI2B1X1
XFILLER_117_256 VDD VSS FILLER1
X_19089_ _19119_/CK _19089_/D _19089_/Q VDD VSS DFFQX1
XFILLER_105_407 VDD VSS FILLER1
XFILLER_132_215 VSS VDD FILLER2
XFILLER_99_641 VDD VSS FILLER1
XFILLER_141_771 VSS VDD FILLER2
X_20002_ _20007_/CK _20002_/D _20002_/Q VDD VSS DFFQX1
XFILLER_59_516 VSS VDD FILLER2
X_09813_ _18471_/Q _09813_/B _09813_/C _20148_/A VDD VSS _09817_/C AOI22X1
XFILLER_86_313 VSS VDD FILLER2
XFILLER_59_527 VSS VDD FILLER2
XFILLER_141_793 VDD VSS FILLER1
XFILLER_101_635 VSS VDD FILLER2
XFILLER_98_184 VSS VDD FILLER2
XFILLER_59_549 VDD VSS FILLER1
Xclkbuf_0__09167_ _18216_/ECK VDD VSS clkbuf_0__09167_/Y BUFX12
X_09744_ _09744_/A _09744_/B _09753_/A VDD VSS _09745_/D OAI21X1
XFILLER_86_368 VDD VSS FILLER4
XFILLER_55_700 VDD VSS FILLER1
XTAP_TAPCELL_ROW_97_886 VDD VSS WELLTAP
XTAP_TAPCELL_ROW_146_1330 VDD VSS WELLTAP
XFILLER_67_582 VSS VDD FILLER2
X_09675_ _18350_/Q _09772_/B _09675_/C _09729_/D VDD VSS _09681_/A OAI211X1
XFILLER_36_26 VSS VDD FILLER2
XTAP_TAPCELL_ROW_109_998 VDD VSS WELLTAP
XFILLER_94_390 VSS VDD FILLER2
XFILLER_82_541 VSS VDD FILLER2
XFILLER_82_552 VDD VSS DECAPHV16
XFILLER_27_468 VDD VSS FILLER4
XFILLER_54_287 VSS VDD FILLER2
XTAP_TAPCELL_ROW_80_731 VDD VSS WELLTAP
XFILLER_11_803 VDD VSS FILLER1
XTAP_TAPCELL_ROW_52_477 VDD VSS WELLTAP
XFILLER_156_819 VDD VSS DECAPHV8
XFILLER_155_318 VSS VDD FILLER2
X_10450_ _18661_/Q _18769_/Q VDD VSS _10454_/D AND2X1
XFILLER_108_212 VSS VDD FILLER2
XFILLER_6_328 VSS VDD FILLER2
XFILLER_164_841 VSS VDD FILLER2
XFILLER_136_543 VSS VDD FILLER2
X_10381_ _18659_/Q _18767_/Q _10381_/C _10381_/D VDD VSS _10383_/C AOAI211X1
XFILLER_136_587 VSS VDD FILLER2
X_12120_ _19068_/Q _12210_/A _12447_/B VDD VSS _12286_/B XNOR3X1
XFILLER_136_598 VDD VSS FILLER4
XFILLER_151_524 VSS VDD FILLER2
XTAP_TAPCELL_ROW_153_1389 VDD VSS WELLTAP
XFILLER_163_384 VSS VDD FILLER2
XFILLER_151_546 VDD VSS FILLER4
XTAP_TAPCELL_ROW_112_1020 VDD VSS WELLTAP
X_12051_ _19234_/Q _14528_/A _14528_/B VDD VSS _12053_/C NOR3X1
XFILLER_78_803 VDD VSS FILLER4
XFILLER_77_33 VDD VSS FILLER4
XFILLER_104_473 VSS VDD FILLER2
X_11002_ _11043_/B _11002_/B VDD VSS _11013_/B XOR2X1
XFILLER_2_589 VSS VDD FILLER2
XFILLER_132_793 VDD VSS FILLER4
XFILLER_77_313 VDD VSS FILLER4
XFILLER_89_184 VSS VDD FILLER2
X_15810_ _15816_/A _15810_/B VDD VSS _19426_/D NOR2X1
X_16790_ _16793_/A _16790_/B VDD VSS _19636_/D AND2X1
XFILLER_93_817 VSS VDD FILLER2
XFILLER_46_700 VSS VDD FILLER2
XFILLER_133_50 VDD VSS FILLER4
XFILLER_58_571 VDD VSS FILLER1
XFILLER_133_72 VSS VDD FILLER2
X_15741_ _15817_/A VDD VSS _15758_/A BUFX3
X_12953_ _12953_/A _14475_/B _13032_/C _12953_/D VDD VSS _13131_/A OAOI211X1
X_11904_ _19008_/Q _14270_/B VDD VSS _11950_/B NOR2X1
XTAP_TAPCELL_ROW_164_1485 VDD VSS WELLTAP
XFILLER_93_65 VDD VSS FILLER4
X_15672_ _15672_/A _18194_/A VDD VSS _19304_/D NOR2X1
X_18460_ _18471_/CK _18513_/Q _18460_/Q _18471_/RB VDD VSS DFFRQX1
X_12884_ _12884_/A _12884_/B _14121_/B VDD VSS _12885_/B MIN3X1
XFILLER_46_788 VSS VDD FILLER2
XFILLER_45_265 VSS VDD FILLER2
XFILLER_93_87 VDD VSS FILLER4
X_17411_ _17413_/C _17411_/B _17411_/C VDD VSS _19840_/D AOI21X1
X_14623_ _14644_/A _15889_/B VDD VSS _14624_/D NOR2X1
XTAP_TAPCELL_ROW_43_400 VDD VSS WELLTAP
XFILLER_61_736 VSS VDD FILLER2
X_18391_ _18391_/CK _18471_/D _20196_/A _20065_/RB VDD VSS DFFRQX1
X_11835_ _11835_/A _11835_/B _11835_/C _11835_/D VDD VSS _11839_/A OAOI211X1
XFILLER_61_747 VSS VDD FILLER2
XFILLER_60_224 VDD VSS FILLER1
XFILLER_33_449 VDD VSS FILLER4
XFILLER_60_235 VDD VSS DECAPHV16
XFILLER_26_92 VDD VSS DECAPHV8
XFILLER_14_652 VDD VSS FILLER1
X_17342_ _17346_/A _17343_/B _17363_/C VDD VSS _17343_/C OAI21X1
X_14554_ _19994_/Q _14558_/B VDD VSS _19258_/D AND2X1
XTAP_TAPCELL_ROW_15_146 VDD VSS WELLTAP
XFILLER_159_624 VSS VDD FILLER2
XFILLER_158_101 VSS VDD FILLER2
X_11766_ _19226_/Q _14519_/B VDD VSS _11768_/C _14519_/C AND3X2
XFILLER_9_100 VDD VSS FILLER1
XFILLER_13_162 VSS VDD FILLER2
XFILLER_9_111 VSS VDD FILLER2
XFILLER_14_696 VDD VSS FILLER1
X_13505_ _13516_/A _13516_/B _13516_/C VDD VSS _14193_/B AOI21X1
X_17273_ _19811_/Q _19779_/Q VDD VSS _17275_/B XOR2X1
X_10717_ _10803_/A _10717_/B _10717_/C _10717_/D VDD VSS _10747_/A AOI31X1
XFILLER_13_184 VSS VDD FILLER2
XFILLER_147_819 VSS VDD FILLER2
X_14485_ _14493_/A _14485_/B VDD VSS _19198_/D NOR2X1
XFILLER_9_133 VSS VDD FILLER2
XFILLER_41_493 VDD VSS FILLER1
X_11697_ _19225_/Q _11737_/B _11700_/C VDD VSS _14484_/B XNOR3X1
XFILLER_146_307 VSS VDD FILLER2
XFILLER_9_155 VSS VDD FILLER2
XFILLER_158_167 VSS VDD FILLER2
X_16224_ _19719_/Q _16883_/B VDD VSS _16225_/A NAND2BX1
X_19012_ _19068_/CK _19012_/D _19012_/Q VDD VSS DFFQX1
XFILLER_158_178 VSS VDD FILLER2
X_13436_ _13436_/A _14388_/B _14388_/C VDD VSS _13437_/D NOR3X1
X_10648_ _18693_/Q _18747_/Q VDD VSS _10649_/D NAND2X1
XFILLER_9_177 VSS VDD FILLER2
XFILLER_9_199 VDD VSS FILLER4
X_16155_ _19620_/Q _16155_/B _16773_/B VDD VSS _16179_/B MIN3X1
X_13367_ _14355_/A _14355_/B _19081_/Q VDD VSS _13422_/D AOI21X1
X_10579_ _10579_/A _10579_/B _10579_/C _10579_/D VDD VSS _10656_/C AOI31X1
XFILLER_127_576 VSS VDD FILLER2
X_15106_ _15191_/D _15155_/A VDD VSS _15191_/A NAND2X1
XFILLER_114_215 VDD VSS DECAPHV8
X_12318_ _20002_/Q _19266_/Q VDD VSS _12407_/C NAND2X1
X_16086_ _19554_/Q _19906_/Q VDD VSS _16089_/A XNOR2X1
X_13298_ _13393_/A _13393_/B VDD VSS _13378_/B NOR2X1
XFILLER_142_557 VDD VSS FILLER4
XFILLER_114_259 VDD VSS FILLER4
X_15037_ _19340_/Q _15037_/B _15714_/B VDD VSS _15126_/B MIN3X1
X_19914_ clkload8/A _19914_/D _19914_/Q VDD VSS DFFQX1
X_12249_ _19125_/Q _14404_/B VDD VSS _12298_/D _14404_/C NAND3X1
XFILLER_69_825 VSS VDD FILLER2
XFILLER_3_30 VSS VDD FILLER2
X_19845_ _19853_/CK _19845_/D _19845_/Q VDD VSS DFFQX1
XFILLER_110_421 VSS VDD FILLER2
XTAP_TAPCELL_ROW_130_1186 VDD VSS WELLTAP
XFILLER_3_52 VSS VDD FILLER2
XFILLER_68_346 VSS VDD FILLER2
XFILLER_3_85 VSS VDD FILLER2
X_19776_ _19825_/CK _19776_/D _19776_/Q VDD VSS DFFQX1
XFILLER_3_96 VSS VDD FILLER2
X_16988_ _16994_/A _16991_/C _16988_/C VDD VSS _19752_/D AOI21X1
XFILLER_95_165 VDD VSS FILLER4
XFILLER_83_327 VSS VDD FILLER2
X_18727_ _19940_/CK _18727_/D _18727_/Q VDD VSS DFFQX1
X_15939_ _15939_/A _15939_/B VDD VSS _15940_/C NAND2X1
XTAP_TAPCELL_ROW_94_856 VDD VSS WELLTAP
X_09460_ _18444_/D _09468_/B _09460_/C VDD VSS _18253_/D AOI21X1
X_18658_ _18823_/CK _18658_/D _18658_/Q VDD VSS DFFQX1
XTAP_TAPCELL_ROW_106_968 VDD VSS WELLTAP
XFILLER_36_287 VSS VDD FILLER2
X_17609_ _19882_/Q _19850_/Q VDD VSS _17610_/C NAND2X1
XFILLER_36_298 VSS VDD FILLER2
X_09391_ _19936_/Q _09405_/B VDD VSS _11429_/B NOR2BX2
XFILLER_91_393 VSS VDD FILLER2
XFILLER_52_758 VSS VDD FILLER2
X_18589_ _18589_/CK _18589_/D _18589_/Q VDD VSS DFFQX1
XTAP_TAPCELL_ROW_141_1282 VDD VSS WELLTAP
XFILLER_149_123 VDD VSS FILLER4
XFILLER_22_17 VSS VDD FILLER2
XFILLER_20_644 VDD VSS FILLER1
XFILLER_20_666 VDD VSS DECAPHV8
XFILLER_149_189 VSS VDD FILLER2
XFILLER_133_535 VDD VSS FILLER4
XFILLER_161_844 VDD VSS FILLER1
XFILLER_160_332 VSS VDD FILLER2
XFILLER_154_27 VSS VDD FILLER2
XFILLER_160_365 VSS VDD FILLER2
XFILLER_120_207 VDD VSS DECAPHV8
XFILLER_154_49 VSS VDD FILLER2
XFILLER_59_302 VDD VSS FILLER4
XFILLER_114_793 VSS VDD FILLER2
XFILLER_99_482 VSS VDD FILLER2
XFILLER_101_421 VSS VDD FILLER2
XFILLER_141_590 VSS VDD FILLER2
XFILLER_59_346 VSS VDD FILLER2
Xfanout178 _18628_/Q VDD VSS _11438_/A BUFX3
XFILLER_28_700 VDD VSS FILLER4
XFILLER_87_699 VSS VDD FILLER2
XFILLER_28_722 VSS VDD FILLER2
XFILLER_101_498 VDD VSS FILLER4
X_09727_ _18305_/Q _09812_/B _09797_/C _20206_/A VDD VSS _09729_/B AOI22X1
XTAP_TAPCELL_ROW_57_525 VDD VSS WELLTAP
XFILLER_55_552 VDD VSS FILLER4
X_09658_ _18445_/Q _09751_/B _09696_/B _18413_/Q _09658_/E VDD VSS _09659_/C OAI221X1
XFILLER_28_788 VSS VDD FILLER2
XFILLER_42_202 VSS VDD FILLER2
XFILLER_82_371 VDD VSS FILLER1
XFILLER_103_86 VDD VSS FILLER1
XFILLER_63_35 VDD VSS FILLER4
XFILLER_43_747 VSS VDD FILLER2
XFILLER_42_224 VSS VDD FILLER2
XFILLER_15_438 VSS VDD FILLER2
X_09589_ _18297_/Q _09812_/B _09769_/C _20083_/A VDD VSS _09593_/C AOI22X1
XFILLER_70_544 VDD VSS FILLER4
XFILLER_42_235 VSS VDD FILLER2
X_11620_ _18763_/Q _11624_/B VDD VSS _18790_/D AND2X1
XFILLER_70_566 VSS VDD FILLER2
X_11551_ _18700_/Q _11555_/B VDD VSS _18727_/D AND2X1
XTAP_TAPCELL_ROW_155_1407 VDD VSS WELLTAP
XFILLER_50_290 VDD VSS FILLER4
XFILLER_128_318 VDD VSS FILLER1
XFILLER_7_604 VSS VDD FILLER2
X_10502_ _10625_/A _10502_/B VDD VSS _10548_/A AND2X1
XFILLER_11_677 VDD VSS FILLER4
X_14270_ _14270_/A _14270_/B VDD VSS _19008_/D AND2X1
XFILLER_7_626 VSS VDD FILLER2
X_11482_ _18638_/Q _11484_/B VDD VSS _18665_/D AND2X1
XFILLER_155_137 VDD VSS FILLER1
X_13221_ _19135_/Q _14415_/B VDD VSS _13319_/A NAND2X1
XFILLER_109_554 VDD VSS FILLER4
X_10433_ _10503_/A _10433_/B VDD VSS _10434_/B XNOR2X1
XFILLER_124_502 VSS VDD FILLER2
XTAP_TAPCELL_ROW_20_193 VDD VSS WELLTAP
XFILLER_164_671 VSS VDD FILLER2
XFILLER_109_587 VSS VDD FILLER2
XFILLER_3_810 VSS VDD FILLER2
XFILLER_152_833 VDD VSS FILLER4
X_13152_ _19247_/Q _13152_/B VDD VSS _13240_/C _13152_/C NAND3X1
XFILLER_151_310 VSS VDD FILLER2
X_10364_ _18686_/Q _18740_/Q VDD VSS _10413_/A NAND2X1
XFILLER_151_343 VDD VSS FILLER4
X_12103_ _12108_/A _12108_/C _12108_/B VDD VSS _14529_/C OR3X2
XFILLER_151_354 VDD VSS FILLER4
XFILLER_124_579 VSS VDD FILLER2
X_17960_ _18868_/Q _17960_/B _17960_/C VDD VSS _17966_/B XOR3X1
X_13083_ _13083_/A _13083_/B VDD VSS _13086_/C XNOR2X1
XFILLER_105_760 VDD VSS FILLER1
X_10295_ _10283_/Y _10295_/B _10295_/C VDD VSS _10385_/B OR3BX1
XFILLER_88_98 VSS VDD FILLER2
XFILLER_105_793 VDD VSS FILLER4
X_16911_ _20068_/D _20069_/Q VDD VSS _16912_/C NAND2X1
X_12034_ _12034_/A _14462_/B _14462_/C VDD VSS _12035_/D NOR3X1
XFILLER_132_590 VSS VDD FILLER2
X_17891_ _18855_/Q _17891_/B _17891_/C VDD VSS _17894_/C MIN3X1
XTAP_TAPCELL_ROW_166_1503 VDD VSS WELLTAP
XFILLER_104_292 VSS VDD FILLER2
XTAP_TAPCELL_ROW_166_1514 VDD VSS WELLTAP
XFILLER_66_806 VDD VSS FILLER1
X_19630_ _19664_/CK _19630_/D _19630_/Q VDD VSS DFFQX1
XFILLER_38_508 VSS VDD FILLER2
X_16842_ _16865_/A _16842_/B VDD VSS _19682_/D NOR2X1
XFILLER_77_154 VSS VDD FILLER2
XFILLER_144_93 VSS VDD FILLER2
XFILLER_93_614 VSS VDD FILLER2
XFILLER_19_722 VDD VSS FILLER4
X_19561_ _19600_/CK _19561_/D _19561_/Q VDD VSS DFFQX1
XFILLER_92_124 VDD VSS FILLER4
X_16773_ _16775_/A _16773_/B VDD VSS _19620_/D NOR2X1
X_13985_ _14137_/B _14137_/C _18894_/Q VDD VSS _14018_/B AOI21X1
XFILLER_92_135 VDD VSS FILLER4
XFILLER_19_755 VSS VDD FILLER2
X_18512_ _18512_/CK _18512_/D _18512_/Q _09340_/Y VDD VSS DFFRQX1
X_15724_ _15739_/A _15724_/B VDD VSS _19350_/D NOR2X1
X_12936_ _12936_/A _14444_/B _14444_/C VDD VSS _13107_/C NOR3X1
XFILLER_19_777 VDD VSS FILLER4
X_19492_ _19737_/CK _19492_/D _19492_/Q VDD VSS DFFQX1
XFILLER_37_91 VSS VDD FILLER2
XFILLER_46_585 VSS VDD FILLER2
XFILLER_160_81 VDD VSS FILLER4
X_18443_ _18454_/CK _18443_/D _18443_/Q _20073_/RB VDD VSS DFFRQX1
XTAP_TAPCELL_ROW_8_84 VDD VSS WELLTAP
X_15655_ _15655_/A _15763_/B _15655_/C VDD VSS _15733_/B OAI21X1
X_12867_ _12868_/D _14318_/B VDD VSS _13005_/A NAND2X1
XTAP_TAPCELL_ROW_103_938 VDD VSS WELLTAP
XFILLER_33_257 VDD VSS FILLER1
X_14606_ _14644_/A _15889_/B VDD VSS _14645_/C XNOR2X1
X_11818_ _19145_/Q _11818_/B _14427_/B VDD VSS _14396_/B XNOR3X1
X_15586_ _15592_/A _15592_/B VDD VSS _15698_/B XNOR2X1
X_18374_ _18374_/CK _18470_/D _20211_/A _18374_/RB VDD VSS DFFRQX1
X_12798_ _12868_/A _12868_/B _12799_/D _12868_/E VDD VSS _14286_/B OA211X2
X_17325_ _19821_/Q _19789_/Q _17325_/C VDD VSS _17329_/C MIN3X1
X_14537_ _15806_/A _14537_/B _14537_/C VDD VSS _19243_/D NOR3X1
X_11749_ _19228_/Q _11749_/B _11769_/D VDD VSS _11835_/C XNOR3X1
XFILLER_146_104 VSS VDD FILLER2
XFILLER_159_487 VSS VDD FILLER2
XFILLER_147_649 VSS VDD FILLER2
X_17256_ _17390_/A _17256_/B VDD VSS _19807_/D NOR2X1
X_14468_ _14490_/A _14468_/B _14468_/C VDD VSS _19182_/D NOR3X1
XFILLER_146_137 VSS VDD FILLER2
X_16207_ _19910_/Q VDD VSS _16704_/A INVX1
X_13419_ _19054_/Q _13531_/A _13531_/B VDD VSS _13420_/D XNOR3X1
X_17187_ _17189_/A _17189_/B _17187_/C VDD VSS _19792_/D AOI21X1
XFILLER_127_351 VSS VDD FILLER2
X_14399_ _14426_/A _14399_/B VDD VSS _19120_/D NOR2X1
XFILLER_161_107 VDD VSS FILLER1
XTAP_TAPCELL_ROW_132_1204 VDD VSS WELLTAP
X_16138_ _16138_/A _16159_/C VDD VSS _16738_/B XNOR2X1
XFILLER_155_693 VDD VSS DECAPHV8
XFILLER_115_535 VSS VDD FILLER2
XFILLER_115_557 VDD VSS FILLER1
XFILLER_142_343 VDD VSS FILLER1
XFILLER_115_568 VSS VDD FILLER2
XTAP_TAPCELL_ROW_99_904 VDD VSS WELLTAP
X_16069_ _19649_/Q _16806_/B VDD VSS _16070_/B XNOR2X1
XFILLER_69_600 VSS VDD FILLER2
XFILLER_38_0 VSS VDD FILLER2
XFILLER_130_549 VSS VDD FILLER2
XFILLER_96_430 VSS VDD FILLER2
X_19828_ clkload4/A _19828_/D _19828_/Q VDD VSS DFFQX1
XFILLER_29_519 VSS VDD FILLER2
XFILLER_69_699 VSS VDD FILLER2
XFILLER_83_102 VDD VSS FILLER1
XFILLER_96_496 VSS VDD FILLER2
XFILLER_84_647 VDD VSS FILLER4
X_19759_ _19791_/CK _19759_/D _19759_/Q VDD VSS DFFQX1
XFILLER_84_658 VDD VSS FILLER1
XTAP_TAPCELL_ROW_143_1300 VDD VSS WELLTAP
X_09512_ _20021_/Q _20022_/Q VDD VSS _09527_/B _09526_/B AND3X2
XFILLER_71_308 VSS VDD FILLER2
XFILLER_37_563 VDD VSS FILLER1
XFILLER_52_500 VSS VDD FILLER2
XFILLER_80_831 VDD VSS FILLER4
X_09443_ _18506_/Q _18505_/Q VDD VSS _09578_/B NAND2X1
XFILLER_25_747 VSS VDD FILLER2
XFILLER_52_533 VDD VSS FILLER4
XFILLER_24_235 VDD VSS FILLER4
XFILLER_40_706 VSS VDD FILLER2
XFILLER_24_257 VSS VDD FILLER2
X_09374_ _20054_/Q output5/A _18386_/Q VDD VSS _09496_/B MUX2X1
XFILLER_33_16 VDD VSS FILLER1
XFILLER_33_27 VDD VSS FILLER1
XTAP_TAPCELL_ROW_62_572 VDD VSS WELLTAP
XFILLER_149_16 VSS VDD FILLER2
XFILLER_33_49 VSS VDD FILLER2
XFILLER_165_402 VSS VDD FILLER2
XFILLER_165_413 VDD VSS FILLER1
XFILLER_137_148 VSS VDD FILLER2
XFILLER_165_468 VSS VDD FILLER2
XFILLER_4_607 VDD VSS FILLER4
XFILLER_134_811 VSS VDD FILLER2
XFILLER_165_26 VSS VDD FILLER2
XFILLER_118_384 VDD VSS FILLER1
XFILLER_152_129 VDD VSS FILLER1
XFILLER_109_6 VDD VSS FILLER1
XFILLER_133_321 VSS VDD FILLER2
XFILLER_165_59 VSS VDD FILLER2
XTAP_TAPCELL_ROW_150_1359 VDD VSS WELLTAP
XFILLER_133_365 VDD VSS FILLER4
XFILLER_161_674 VSS VDD FILLER2
XFILLER_0_813 VSS VDD FILLER2
XFILLER_121_538 VDD VSS FILLER4
X_10080_ _18585_/Q _10089_/B VDD VSS _10080_/Y XOR2X1
XFILLER_47_316 VDD VSS FILLER1
XFILLER_87_496 VDD VSS FILLER4
XFILLER_114_74 VDD VSS FILLER1
XFILLER_74_146 VDD VSS FILLER1
XFILLER_74_45 VDD VSS FILLER1
XFILLER_62_308 VSS VDD FILLER2
X_13770_ _13770_/A _14229_/B _14229_/C VDD VSS _13771_/D NOR3X1
X_10982_ _10982_/A _10982_/B _10982_/C VDD VSS _10983_/B NOR3X1
XFILLER_90_628 VSS VDD FILLER2
XFILLER_43_511 VDD VSS DECAPHV16
XFILLER_55_371 VDD VSS FILLER1
XFILLER_28_596 VSS VDD FILLER2
X_12721_ _19047_/Q _14317_/B VDD VSS _12868_/E _14317_/C NAND3X1
XTAP_TAPCELL_ROW_161_1466 VDD VSS WELLTAP
XFILLER_55_382 VDD VSS FILLER4
XFILLER_15_224 VDD VSS FILLER1
X_15440_ _19516_/Q _15440_/B _15440_/C VDD VSS _15474_/B MIN3X1
X_12652_ _14440_/A _14440_/B _14440_/C VDD VSS _12654_/B OAI21X1
XTAP_TAPCELL_ROW_25_241 VDD VSS WELLTAP
XFILLER_130_73 VSS VDD FILLER2
XFILLER_90_33 VDD VSS FILLER4
XFILLER_43_599 VDD VSS FILLER4
XFILLER_31_739 VDD VSS FILLER4
XFILLER_90_44 VSS VDD FILLER2
XFILLER_70_385 VDD VSS FILLER4
X_11603_ _18747_/Q _11612_/B VDD VSS _18774_/D AND2X1
XFILLER_70_396 VSS VDD FILLER2
XFILLER_30_227 VDD VSS FILLER4
X_15371_ _19404_/Q _15785_/B VDD VSS _15389_/B NOR2X1
X_12583_ _12583_/A _12583_/B _12677_/B _12583_/D VDD VSS _12666_/A OAOI211X1
XFILLER_90_66 VDD VSS FILLER4
XFILLER_11_441 VSS VDD FILLER2
XFILLER_90_88 VDD VSS FILLER4
XFILLER_128_104 VDD VSS FILLER1
X_17110_ _17172_/A VDD VSS _17164_/C BUFX3
X_14322_ _14316_/Y _14323_/B _14322_/C VDD VSS _19052_/D AND3BX1
XFILLER_11_463 VSS VDD FILLER2
X_18090_ _18090_/A _18090_/B _18090_/C _18090_/D VDD VSS _18095_/A AOAI211X1
X_11534_ _18685_/Q _11542_/B VDD VSS _18712_/D AND2X1
XFILLER_129_649 VSS VDD FILLER2
X_17041_ _17041_/A VDD VSS _17042_/D INVX1
X_14253_ _14285_/A _14253_/B VDD VSS _18992_/D NOR2X1
XFILLER_156_468 VDD VSS FILLER4
X_11465_ _19957_/Q _11473_/B VDD VSS _18650_/D AND2X1
XFILLER_156_479 VSS VDD FILLER2
X_13204_ _14221_/A _14221_/B VDD VSS _13278_/B NOR2X1
X_10416_ _19940_/Q _18822_/Q VDD VSS _10417_/D NAND2X1
X_14184_ _14186_/A _14184_/B VDD VSS _18936_/D NOR2X1
X_11396_ _11396_/A _11396_/B wire167/A VDD VSS _11397_/B OAI21X1
XFILLER_164_490 VSS VDD FILLER2
X_13135_ _13135_/A _14511_/B _14511_/C VDD VSS _13141_/C NOR3X1
XFILLER_140_814 VSS VDD FILLER2
XFILLER_151_140 VSS VDD FILLER2
X_10347_ _10347_/A VDD VSS _10579_/D BUFX3
X_18992_ _19025_/CK _18992_/D _18992_/Q VDD VSS DFFQX1
XFILLER_140_825 VSS VDD FILLER2
XFILLER_3_684 VSS VDD FILLER2
XFILLER_151_184 VSS VDD FILLER2
X_17943_ _18087_/D _17948_/B VDD VSS _17944_/C NAND2X1
X_13066_ _19107_/Q _13104_/B _13314_/D VDD VSS _13212_/C XNOR3X1
XFILLER_105_590 VDD VSS FILLER4
X_10278_ _10346_/A _10346_/B VDD VSS _10581_/A NAND2X1P5
XFILLER_2_183 VDD VSS FILLER4
X_12017_ _19065_/Q VDD VSS _12019_/A INVX1
XFILLER_39_817 VSS VDD FILLER2
X_17874_ _18132_/A _17874_/B _17874_/C VDD VSS _19942_/D NOR3X1
X_19613_ _19702_/CK _19613_/D _19613_/Q VDD VSS DFFQX1
XFILLER_78_496 VDD VSS DECAPHV8
X_16825_ _16843_/A _16825_/B VDD VSS _19667_/D AND2X1
XFILLER_38_338 VDD VSS DECAPHV8
XFILLER_65_135 VSS VDD FILLER2
X_19544_ _19736_/CK _19544_/D _19544_/Q VDD VSS DFFQX1
X_16756_ _16759_/A _16756_/B VDD VSS _19605_/D NOR2X1
XFILLER_80_105 VDD VSS FILLER4
XFILLER_0_53 VSS VDD FILLER2
X_13968_ wire153/Y _14010_/B _14010_/C VDD VSS _13969_/C OAI21X1
XTAP_TAPCELL_ROW_76_697 VDD VSS WELLTAP
X_15707_ _15710_/A _15707_/B VDD VSS _19335_/D NOR2X1
X_19475_ _19478_/CK _19475_/D _19475_/Q VDD VSS DFFQX1
X_12919_ _13017_/A _13102_/B VDD VSS _14351_/B XNOR2X1
XFILLER_0_97 VDD VSS FILLER1
X_16687_ _16687_/A _16687_/B VDD VSS _16902_/B XNOR2X1
X_13899_ _13998_/A _13998_/B _13998_/C VDD VSS _13916_/B AOI21X1
XFILLER_61_341 VDD VSS FILLER1
X_18426_ _18439_/CK _18426_/D _18426_/Q _18464_/RB VDD VSS DFFRQX1
XFILLER_61_363 VSS VDD FILLER2
X_15638_ _19385_/Q VDD VSS _15655_/A INVX1
XFILLER_34_588 VSS VDD FILLER2
XFILLER_22_739 VSS VDD FILLER2
X_18357_ _18357_/CK _18357_/D _18357_/Q _18491_/RB VDD VSS DFFRQX1
X_15569_ _15569_/A _15569_/B VDD VSS _15570_/C NOR2X1
XFILLER_147_413 VSS VDD FILLER2
XFILLER_9_73 VSS VDD FILLER2
X_17308_ _19818_/Q _19786_/Q VDD VSS _17309_/C NAND2X1
X_18288_ _18288_/CK _18288_/D _18288_/Q VDD VSS DFFQX1
XTAP_TAPCELL_ROW_31_288 VDD VSS WELLTAP
XFILLER_135_608 VSS VDD FILLER2
XFILLER_147_468 VSS VDD FILLER2
XFILLER_135_619 VSS VDD FILLER2
X_17239_ _19804_/Q _19772_/Q VDD VSS _17240_/B XOR2X1
XFILLER_162_416 VSS VDD FILLER2
XFILLER_127_170 VSS VDD FILLER2
XFILLER_128_693 VDD VSS FILLER4
XFILLER_162_449 VDD VSS FILLER4
XFILLER_127_181 VDD VSS FILLER4
XFILLER_155_490 VSS VDD FILLER2
XFILLER_131_803 VSS VDD FILLER2
XFILLER_143_663 VSS VDD FILLER2
X_20181_ _20181_/A VDD VSS _20181_/Y BUFX3
XFILLER_89_717 VSS VDD FILLER2
XFILLER_103_505 VSS VDD FILLER2
XFILLER_135_18 VSS VDD FILLER2
XFILLER_142_151 VSS VDD FILLER2
X_09992_ _11226_/D _09992_/B VDD VSS _09993_/C NAND2X1
XFILLER_130_302 VSS VDD FILLER2
XFILLER_130_324 VDD VSS FILLER1
XFILLER_142_184 VDD VSS FILLER4
XFILLER_130_368 VDD VSS DECAPHV8
XFILLER_29_305 VSS VDD FILLER2
XTAP_TAPCELL_ROW_67_620 VDD VSS WELLTAP
XFILLER_28_49 VDD VSS FILLER4
XFILLER_151_39 VDD VSS FILLER1
XFILLER_84_455 VDD VSS FILLER4
XFILLER_56_168 VDD VSS DECAPHV8
XTAP_TAPCELL_ROW_39_366 VDD VSS WELLTAP
XFILLER_71_127 VDD VSS FILLER4
XFILLER_25_522 VDD VSS FILLER4
XFILLER_25_555 VSS VDD FILLER2
X_09426_ _09426_/A _09819_/A VDD VSS _18234_/E NOR2X1
XFILLER_40_514 VDD VSS FILLER4
XFILLER_12_216 VSS VDD FILLER2
XFILLER_13_739 VDD VSS FILLER4
XFILLER_100_43 VSS VDD FILLER2
X_09357_ _18507_/Q _18506_/Q _09354_/Y VDD VSS _18507_/D MUX2X1
XTAP_TAPCELL_ROW_22_211 VDD VSS WELLTAP
XFILLER_40_558 VSS VDD FILLER2
XFILLER_100_65 VSS VDD FILLER2
XFILLER_60_25 VSS VDD FILLER2
XFILLER_138_435 VDD VSS FILLER4
X_09288_ _20046_/Q _09414_/B VDD VSS _09289_/C NOR2X1
XFILLER_20_271 VSS VDD FILLER2
XFILLER_166_777 VSS VDD FILLER2
XFILLER_166_799 VDD VSS DECAPHV8
XFILLER_125_118 VSS VDD FILLER2
XFILLER_4_415 VSS VDD FILLER2
X_11250_ _11253_/A _11253_/B _11253_/C _11386_/C VDD VSS _11251_/D AOAI211X1
XFILLER_134_630 VSS VDD FILLER2
X_10201_ _10199_/Y _10201_/B _17172_/A VDD VSS _18546_/D AND3BX1
XFILLER_106_354 VSS VDD FILLER2
XFILLER_133_140 VSS VDD FILLER2
XFILLER_109_96 VDD VSS DECAPHV8
XFILLER_134_674 VDD VSS FILLER4
X_11181_ _11116_/Y _11180_/Y _10947_/Y VDD VSS _11181_/Y MUXI2X1
XFILLER_122_825 VSS VDD FILLER2
XFILLER_69_78 VDD VSS DECAPHV8
XFILLER_133_184 VSS VDD FILLER2
X_10132_ _10035_/Y _10130_/Y _10224_/A VDD VSS _10134_/B MUXI2X1
XFILLER_79_238 VSS VDD FILLER2
XFILLER_121_379 VSS VDD FILLER2
XFILLER_125_62 VSS VDD FILLER2
X_14940_ _14940_/A _14940_/B VDD VSS _15773_/B XNOR2X1
X_10063_ _10075_/D _10075_/B VDD VSS _10064_/B NOR2BX1
XFILLER_94_219 VSS VDD FILLER2
XFILLER_125_84 VSS VDD FILLER2
XFILLER_75_422 VSS VDD FILLER2
XFILLER_87_282 VSS VDD FILLER2
X_14871_ _14918_/A _14918_/B VDD VSS _14884_/B NAND2X1
X_16610_ _19670_/Q _16829_/B VDD VSS _16611_/B XOR2X1
X_13822_ _13921_/A _13987_/B VDD VSS _14197_/B XNOR2X1
X_17590_ _17591_/C _18127_/B _17590_/C VDD VSS _19878_/D AND3BX1
XFILLER_62_105 VDD VSS FILLER4
XFILLER_47_179 VSS VDD FILLER2
X_16541_ _16735_/A _16541_/B VDD VSS _19539_/D NOR2X1
X_13753_ _17920_/A _17920_/B _17921_/C _13753_/D VDD VSS _13868_/A OAOI211X1
XFILLER_62_138 VDD VSS FILLER1
X_10965_ _10965_/A _18730_/Q VDD VSS _10966_/C NAND2X1
XTAP_TAPCELL_ROW_73_667 VDD VSS WELLTAP
XFILLER_71_650 VDD VSS FILLER1
X_12704_ _18907_/Q VDD VSS _12789_/A INVX1
X_19260_ _19996_/CK _19260_/D _19260_/Q VDD VSS DFFQX1
XFILLER_31_503 VSS VDD FILLER2
X_16472_ _16456_/B _16472_/B _16472_/C VDD VSS _16495_/B AOI2B1X1
X_13684_ _14262_/B _14262_/C _19000_/Q VDD VSS _13686_/C AOI21X1
X_10896_ _18646_/Q _18808_/Q _10896_/C VDD VSS _10925_/A MIN3X1
XFILLER_31_536 VSS VDD FILLER2
X_15423_ _15754_/B VDD VSS _15424_/B INVX1
X_12635_ _12804_/A _12804_/B VDD VSS _14347_/B XNOR2X1
X_19191_ _19191_/CK _19191_/D _19191_/Q VDD VSS DFFQX1
XFILLER_157_700 VDD VSS FILLER1
XFILLER_129_424 VSS VDD FILLER2
X_15354_ _15359_/A _15359_/B _15354_/C VDD VSS _15355_/B OR3X2
X_18142_ _18173_/A _18142_/B VDD VSS _20002_/D NOR2X1
X_12566_ _12566_/A _12566_/B _12566_/C _12566_/D VDD VSS _14472_/C OAI211X1
XFILLER_11_260 VSS VDD FILLER2
XFILLER_11_282 VSS VDD FILLER2
XFILLER_7_231 VSS VDD FILLER2
XFILLER_129_468 VDD VSS DECAPHV8
X_14305_ _14311_/A _14305_/B VDD VSS _19037_/D NOR2X1
X_11517_ _18670_/Q _11519_/B VDD VSS _18697_/D AND2X1
XFILLER_157_777 VSS VDD FILLER2
X_15285_ _15285_/A _15306_/C VDD VSS _15814_/B XOR2X1
X_18073_ _19281_/Q _18073_/B VDD VSS _18074_/C AND2X1
XFILLER_144_416 VSS VDD FILLER2
Xwire162 wire162/A VDD VSS wire162/Y BUFX4
X_12497_ _12497_/A _14503_/B _12497_/C _12497_/D VDD VSS _12755_/A OAOI211X1
XFILLER_7_253 VSS VDD FILLER2
XFILLER_144_438 VSS VDD FILLER2
X_17024_ _17022_/B _17024_/B _17024_/C VDD VSS _19758_/D AOI2B1X1
X_14236_ _14251_/A _14236_/B VDD VSS _18980_/D NOR2X1
X_11448_ _19943_/Q _17990_/A VDD VSS _18636_/D AND2X1
XFILLER_125_630 VSS VDD FILLER2
X_14167_ _14136_/Y _14167_/B _14167_/C VDD VSS _18920_/D AND3BX1
X_11379_ _11379_/A _11379_/B _11379_/C VDD VSS _11390_/B AOI21X1
XFILLER_98_514 VDD VSS FILLER4
XFILLER_112_302 VSS VDD FILLER2
X_13118_ _19135_/Q _14415_/B VDD VSS _13231_/A AND2X1
XFILLER_3_481 VDD VSS FILLER1
X_18975_ _19059_/CK _18975_/D _18975_/Q VDD VSS DFFQX1
X_14098_ _17945_/B _17945_/C _14098_/C _14098_/D VDD VSS _14101_/B AOAI211X1
X_09971__242 _20054_/CK VDD VSS _18518_/CK INVX1
XFILLER_98_558 VDD VSS DECAPHV8
XFILLER_86_709 VDD VSS FILLER4
XFILLER_140_666 VSS VDD FILLER2
X_17926_ _17927_/A _17927_/B _17927_/D _17927_/C VDD VSS _17928_/B OA211X2
X_13049_ _13049_/A _13049_/B _13049_/C _13049_/D VDD VSS _14540_/B AOAI211X1
XFILLER_39_625 VSS VDD FILLER2
X_17857_ _18849_/Q _17868_/B _17857_/C VDD VSS _17863_/C AO21X2
XFILLER_39_658 VSS VDD FILLER2
XFILLER_94_764 VDD VSS FILLER1
XFILLER_27_809 VSS VDD FILLER2
X_16808_ _16811_/A _16808_/B VDD VSS _19651_/D NOR2X1
XFILLER_93_263 VDD VSS FILLER1
XFILLER_54_617 VDD VSS FILLER4
XTAP_TAPCELL_ROW_127_1158 VDD VSS WELLTAP
X_17788_ _17793_/C _17793_/B VDD VSS _17790_/B NAND2BX1
XFILLER_47_680 VSS VDD FILLER2
XFILLER_35_820 VDD VSS FILLER1
XFILLER_19_371 VDD VSS FILLER1
XFILLER_81_436 VSS VDD FILLER2
X_19527_ _19730_/CK _19527_/D _19527_/Q VDD VSS DFFQX1
X_16739_ _16768_/A _16739_/B VDD VSS _19589_/D AND2X1
XTAP_TAPCELL_ROW_36_336 VDD VSS WELLTAP
X_19458_ _19484_/CK _19458_/D _19458_/Q VDD VSS DFFQX1
XFILLER_22_514 VDD VSS FILLER4
XFILLER_61_171 VDD VSS FILLER1
X_09211_ _18471_/D VDD VSS _18423_/D INVX1
X_18409_ _18423_/CK _18510_/Q _20164_/A _20067_/RB VDD VSS DFFRQX1
XFILLER_50_856 VDD VSS FILLER1
XFILLER_148_700 VDD VSS FILLER4
X_19389_ _19465_/CK _19389_/D _19389_/Q VDD VSS DFFQX1
XFILLER_22_569 VDD VSS DECAPHV8
XFILLER_147_243 VDD VSS FILLER1
XFILLER_148_777 VSS VDD FILLER2
XTAP_TAPCELL_ROW_138_1254 VDD VSS WELLTAP
XFILLER_148_788 VSS VDD FILLER2
XFILLER_163_714 VSS VDD FILLER2
XFILLER_147_265 VDD VSS FILLER4
XFILLER_147_276 VSS VDD FILLER2
XFILLER_163_725 VDD VSS FILLER1
XFILLER_162_202 VDD VSS FILLER4
XFILLER_163_747 VSS VDD FILLER2
XFILLER_162_224 VSS VDD FILLER2
XFILLER_135_449 VSS VDD FILLER2
XFILLER_162_235 VSS VDD FILLER2
XFILLER_162_268 VSS VDD FILLER2
XFILLER_115_140 VDD VSS FILLER4
XFILLER_89_514 VSS VDD FILLER2
XFILLER_115_184 VSS VDD FILLER2
X_20164_ _20164_/A VDD VSS _20164_/Y BUFX3
XFILLER_130_132 VDD VSS FILLER1
XFILLER_103_357 VSS VDD FILLER2
XFILLER_162_27 VDD VSS FILLER1
XFILLER_103_379 VSS VDD FILLER2
X_20095_ _20095_/A VDD VSS _20095_/Y BUFX3
XFILLER_69_260 VSS VDD FILLER2
XFILLER_162_49 VDD VSS FILLER4
XFILLER_130_187 VSS VDD FILLER2
XTAP_TAPCELL_ROW_149_1350 VDD VSS WELLTAP
XFILLER_57_411 VDD VSS FILLER4
XFILLER_69_282 VSS VDD FILLER2
XFILLER_57_422 VSS VDD FILLER2
XFILLER_29_113 VSS VDD FILLER2
XFILLER_57_444 VSS VDD FILLER2
XFILLER_29_135 VDD VSS FILLER1
XFILLER_85_764 VDD VSS FILLER4
XFILLER_84_241 VSS VDD FILLER2
XFILLER_45_617 VSS VDD FILLER2
XFILLER_55_36 VDD VSS FILLER1
XFILLER_44_116 VDD VSS FILLER1
XFILLER_55_69 VDD VSS FILLER1
XFILLER_25_330 VDD VSS FILLER4
XFILLER_53_650 VDD VSS FILLER1
X_10750_ _19950_/Q _18832_/Q VDD VSS _10751_/B XNOR2X1
XFILLER_53_683 VSS VDD FILLER2
XFILLER_71_24 VSS VDD FILLER2
X_09409_ _09409_/A _09414_/B _09409_/C VDD VSS _20048_/D OAI21X1
X_10681_ _10634_/B _10681_/B _10681_/C VDD VSS _10722_/A AOI2B1X1
XFILLER_13_569 VSS VDD FILLER2
XFILLER_139_722 VSS VDD FILLER2
X_12420_ _12517_/A _12517_/B _12517_/C VDD VSS _12519_/B AOI21X1
XFILLER_71_79 VSS VDD FILLER2
XFILLER_21_591 VDD VSS FILLER1
X_12351_ _12429_/A _12429_/B _14147_/B VDD VSS _12352_/C XNOR3X1
XFILLER_126_405 VDD VSS FILLER1
X_11302_ _11302_/A _11302_/B VDD VSS _11312_/C NOR2X1
X_15070_ _15776_/B _15776_/C VDD VSS _15071_/B NOR2X1
X_12282_ _19041_/Q VDD VSS _12288_/A INVX1
XFILLER_5_757 VSS VDD FILLER2
XFILLER_105_0 VDD VSS FILLER4
X_14021_ _18895_/Q _14058_/A _14085_/B VDD VSS _14098_/D XNOR3X1
XFILLER_153_268 VSS VDD FILLER2
X_11233_ _11118_/B _11278_/B _11298_/A VDD VSS _11317_/B MUXI2X1
XTAP_TAPCELL_ROW_115_1051 VDD VSS WELLTAP
XFILLER_122_622 VSS VDD FILLER2
XFILLER_134_493 VSS VDD FILLER2
XFILLER_136_72 VSS VDD FILLER2
X_11164_ _18709_/Q _18763_/Q VDD VSS _11167_/D XNOR2X1
XFILLER_68_709 VSS VDD FILLER2
X_10115_ _10103_/Y _10127_/B _10127_/A VDD VSS _10145_/B MUX2X1
XFILLER_121_165 VSS VDD FILLER2
X_18760_ _18785_/CK _18760_/D _18760_/Q VDD VSS DFFQX1
XTAP_TAPCELL_ROW_78_715 VDD VSS WELLTAP
X_15972_ _15988_/A _16803_/B VDD VSS _15989_/B XNOR2X1
X_11095_ _11142_/C _11096_/B _11095_/C VDD VSS _11096_/C AOI21X1
XFILLER_48_400 VSS VDD FILLER2
XFILLER_76_731 VDD VSS DECAPHV8
X_17711_ _17712_/C _17711_/B _17711_/C VDD VSS _19904_/D AOI21X1
X_14923_ _19532_/Q _15009_/C VDD VSS _15899_/B XNOR2X1
X_10046_ _09989_/B _10045_/Y _10167_/A VDD VSS _10047_/B MUXI2X1
X_18691_ _18773_/CK _18691_/D _18691_/Q VDD VSS DFFQX1
XFILLER_29_92 VDD VSS FILLER1
X_17642_ _17646_/A _17643_/B _17654_/C VDD VSS _17643_/C OAI21X1
XFILLER_75_263 VSS VDD FILLER2
X_14854_ _15297_/A _18068_/B VDD VSS _19280_/D AND2X1
XFILLER_29_680 VSS VDD FILLER2
XFILLER_91_756 VDD VSS DECAPHV8
X_13805_ _14132_/A _14132_/B _14132_/C VDD VSS _13812_/B OAI21X1
X_17573_ _19875_/Q _19843_/Q VDD VSS _17575_/B XOR2X1
XFILLER_90_244 VSS VDD FILLER2
X_14785_ _14785_/A _14785_/B _14785_/C _14785_/D VDD VSS _14826_/B OAOI211X1
X_11997_ _19206_/Q _12038_/B _12099_/C VDD VSS _12032_/B XNOR3X1
X_19312_ _19314_/CK _19312_/D _19312_/Q VDD VSS DFFQX1
XFILLER_90_266 VDD VSS DECAPHV16
X_16524_ _19922_/Q VDD VSS _16718_/A INVX1
X_13736_ _13736_/A _14262_/B _13736_/C _13736_/D VDD VSS _13889_/B AOAI211X1
X_10948_ _10877_/Y _10946_/Y _10947_/Y VDD VSS _10948_/Y MUX2X1
XTAP_TAPCELL_ROW_33_306 VDD VSS WELLTAP
XFILLER_90_288 VDD VSS FILLER1
X_19243_ _19269_/CK _19243_/D _19243_/Q VDD VSS DFFQX1
X_16455_ _19632_/Q _16786_/B VDD VSS _16456_/B XNOR2X1
X_13667_ _14522_/A VDD VSS _18196_/A BUFX3
X_10879_ _10736_/B _10878_/Y _11118_/A VDD VSS _10881_/B MUXI2X1
X_15406_ _19461_/Q _15849_/B VDD VSS _15407_/B XOR2X1
XFILLER_129_221 VSS VDD FILLER2
X_19174_ _19200_/CK _19174_/D _19174_/Q VDD VSS DFFQX1
X_12618_ _18963_/Q VDD VSS _12712_/A INVX1
XFILLER_31_388 VDD VSS FILLER1
XFILLER_157_530 VSS VDD FILLER2
X_16386_ _16383_/A _16386_/B _16386_/C VDD VSS _16411_/A AOI2B1X1
X_13598_ _13675_/A _13675_/B _13675_/C VDD VSS _13654_/B AOI21X1
XTAP_TAPCELL_ROW_41_383 VDD VSS WELLTAP
X_18125_ _18126_/A _18126_/B VDD VSS _18131_/B NOR2X1
X_15337_ _19318_/Q _15337_/B _15337_/C VDD VSS _15340_/C MIN3X1
X_12549_ _12625_/A _14346_/B _14346_/C VDD VSS _12803_/C NOR3X1
XFILLER_8_573 VDD VSS FILLER4
XFILLER_144_224 VDD VSS FILLER1
XFILLER_145_747 VSS VDD FILLER2
XANTENNA_1 _09573_/C VDD VSS ANTENNA2
XFILLER_144_235 VSS VDD FILLER2
X_18056_ _18056_/A _18056_/B _18056_/C VDD VSS _19985_/D OAI21X1
X_15268_ _15307_/A _15307_/B VDD VSS _15308_/A AND2X1
X_17007_ _19754_/Q _19755_/Q _17011_/B VDD VSS _17009_/B OA21X2
XFILLER_144_279 VSS VDD FILLER2
X_14219_ _14219_/A _14221_/B _14219_/C VDD VSS _18968_/D NOR3X1
X_15199_ _19455_/Q _15841_/B _15841_/C VDD VSS _15200_/C NOR3BX1
XFILLER_113_611 VSS VDD FILLER2
XFILLER_98_311 VDD VSS DECAPHV8
Xclkbuf_0_sclk_regs clkbuf_regs_1_sclk/Y VDD VSS clkbuf_0_sclk_regs/Y BUFX12
XFILLER_113_644 VDD VSS FILLER4
XFILLER_113_677 VDD VSS FILLER4
Xclkbuf_0__09183_ _18232_/ECK VDD VSS clkbuf_0__09183_/Y BUFX12
X_09760_ _18271_/Q _09818_/C _09760_/C _09788_/B _09760_/E VDD VSS _09761_/B AOI221X1
X_18958_ _18997_/CK _18958_/D _18958_/Q VDD VSS DFFQX1
XFILLER_112_198 VDD VSS FILLER4
XFILLER_67_731 VDD VSS FILLER4
XFILLER_39_422 VDD VSS DECAPHV8
X_17909_ _18860_/Q VDD VSS _17914_/A INVX1
XFILLER_67_742 VSS VDD FILLER2
X_09691_ _20108_/A _20124_/A _09773_/D VDD VSS _09692_/B MUXI2X1
X_18889_ _18889_/CK _18889_/D _18889_/Q VDD VSS DFFQX1
XFILLER_66_230 VSS VDD FILLER2
XTAP_TAPCELL_ROW_49_450 VDD VSS WELLTAP
XFILLER_82_723 VSS VDD FILLER2
XFILLER_27_639 VDD VSS FILLER1
XFILLER_26_116 VDD VSS FILLER1
XFILLER_66_296 VSS VDD FILLER2
XFILLER_82_756 VSS VDD FILLER2
XFILLER_25_17 VSS VDD FILLER2
XFILLER_81_277 VSS VDD FILLER2
XFILLER_157_16 VSS VDD FILLER2
XFILLER_108_405 VSS VDD FILLER2
XFILLER_108_427 VSS VDD FILLER2
XFILLER_163_533 VDD VSS FILLER4
XFILLER_163_544 VSS VDD FILLER2
XFILLER_151_717 VSS VDD FILLER2
X_20216_ _20216_/A VDD VSS _20216_/Y BUFX3
XFILLER_104_655 VSS VDD FILLER2
X_20147_ _20147_/A VDD VSS _20147_/Y BUFX3
XFILLER_131_496 VSS VDD FILLER2
XFILLER_106_75 VSS VDD FILLER2
XFILLER_103_198 VSS VDD FILLER2
XFILLER_58_742 VSS VDD FILLER2
XFILLER_106_97 VDD VSS FILLER1
X_20078_ _20081_/CK _20078_/D _20078_/Q _20078_/RB VDD VSS DFFRQX1
X_09889_ _10803_/A VDD VSS _11014_/A BUFX3
XFILLER_85_561 VSS VDD FILLER2
XFILLER_73_712 VDD VSS FILLER4
XFILLER_18_617 VDD VSS FILLER4
X_11920_ _14462_/B _14462_/C _12034_/A VDD VSS _11922_/C OA21X2
XFILLER_85_583 VSS VDD FILLER2
XFILLER_57_274 VDD VSS FILLER4
XFILLER_18_639 VDD VSS FILLER4
XFILLER_57_296 VSS VDD FILLER2
XFILLER_17_127 VSS VDD FILLER2
XFILLER_73_756 VSS VDD FILLER2
X_11851_ _11851_/A _11851_/B VDD VSS _14459_/B XNOR2X1
XFILLER_17_149 VDD VSS FILLER4
Xclkbuf_1_1__f_sclk clkbuf_0_sclk/Y VDD VSS delaybuf_0_sclk/A BUFX12
XFILLER_26_650 VDD VSS DECAPHV16
XFILLER_14_801 VDD VSS FILLER1
XTAP_TAPCELL_ROW_83_762 VDD VSS WELLTAP
XFILLER_82_34 VSS VDD FILLER2
X_10802_ _10800_/Y _11195_/A _10871_/B VDD VSS _10803_/D AND3BX1
XFILLER_60_417 VDD VSS FILLER1
XFILLER_32_108 VSS VDD FILLER2
X_14570_ _16273_/A VDD VSS _16702_/B BUFX3
XFILLER_26_672 VDD VSS FILLER4
XFILLER_14_823 VDD VSS FILLER1
X_11782_ _19201_/Q _11828_/A _11828_/B VDD VSS _11851_/B XNOR3X1
XFILLER_72_288 VSS VDD FILLER2
XFILLER_25_160 VSS VDD FILLER2
Xclkbuf_1_0__f__09172_ clkbuf_0__09172_/Y VDD VSS _18327_/CK BUFX12
XFILLER_25_171 VSS VDD FILLER2
XFILLER_82_78 VSS VDD FILLER2
XFILLER_159_806 VSS VDD FILLER2
XFILLER_14_856 VDD VSS FILLER1
X_13521_ _19054_/Q _14325_/B VDD VSS _13604_/A NAND2X1
X_10733_ _10945_/A _10733_/B VDD VSS _10807_/C NOR2X1
Xclkbuf_leaf_30__000_ clkload70/A VDD VSS _19406_/CK BUFX12
XTAP_TAPCELL_ROW_158_1438 VDD VSS WELLTAP
X_16240_ _19624_/Q _16778_/B VDD VSS _16241_/B XNOR2X1
X_13452_ _13542_/A _14451_/B _14451_/C VDD VSS _13617_/C NOR3X1
XFILLER_13_388 VDD VSS FILLER4
X_10664_ _18560_/Q _10665_/B VDD VSS _10666_/B NAND2X1
XFILLER_9_348 VSS VDD FILLER2
X_12403_ _20003_/Q _19267_/Q VDD VSS _12499_/A XNOR2X1
X_16171_ _17172_/A VDD VSS _18168_/C BUFX3
X_13383_ _15383_/A VDD VSS _14158_/A BUFX3
X_10595_ _10595_/A VDD VSS _11127_/A BUFX3
XFILLER_166_371 VDD VSS FILLER4
XFILLER_154_522 VDD VSS FILLER1
XFILLER_127_747 VDD VSS FILLER4
XFILLER_126_224 VSS VDD FILLER2
X_15122_ _15134_/C _15134_/B VDD VSS _15123_/B NOR2BX1
X_12334_ _19099_/Q _12334_/B _12380_/C VDD VSS _12544_/B XNOR3X1
XFILLER_126_235 VDD VSS FILLER4
XTAP_TAPCELL_ROW_2_31 VDD VSS WELLTAP
XFILLER_154_544 VSS VDD FILLER2
XFILLER_126_246 VSS VDD FILLER2
XFILLER_154_566 VDD VSS FILLER1
X_15053_ _19480_/Q _15872_/B VDD VSS _15054_/D _15872_/C AND3X2
X_19930_ clkload3/A _19930_/D _19930_/Q VDD VSS DFFQX1
X_12265_ _18958_/Q _12277_/B _14209_/B VDD VSS _14178_/B XNOR3X1
X_14004_ _14004_/A _14004_/B _14004_/C VDD VSS _14233_/C OAI21X1
X_11216_ _11220_/A _11220_/B VDD VSS _11219_/A XNOR2X1
X_19861_ _19895_/CK _19861_/D _19861_/Q VDD VSS DFFQX1
X_12196_ _18873_/Q _14113_/B VDD VSS _12349_/B NOR2X1
XFILLER_122_441 VSS VDD FILLER2
XFILLER_150_750 VDD VSS DECAPHV8
Xoutput60 _20144_/Y VDD VSS o_clk_cfg[11] BUFX3
Xoutput71 _20137_/Y VDD VSS o_clk_cfg[4] BUFX3
XFILLER_110_603 VDD VSS FILLER1
X_18812_ _19954_/CK _18812_/D _18812_/Q VDD VSS DFFQX1
Xoutput82 _20156_/Y VDD VSS o_en_ctrl[4] BUFX3
Xoutput93 _20177_/Y VDD VSS o_lf_cfg[14] BUFX3
X_11147_ _11167_/A _11167_/B _11229_/D VDD VSS _11148_/C AOI21X1
X_19792_ _19934_/CK _19792_/D _19792_/Q VDD VSS DFFQX1
XFILLER_1_782 VDD VSS FILLER4
XFILLER_163_70 VSS VDD FILLER2
X_18743_ _18773_/CK _18743_/D _18743_/Q VDD VSS DFFQX1
XFILLER_49_742 VSS VDD FILLER2
X_15955_ _15977_/A _15977_/B VDD VSS _15956_/C NAND2X1
X_11078_ _11196_/A _18733_/Q _11078_/C _11078_/D VDD VSS _11115_/B AOI211X1
X_14906_ _14907_/B _15833_/C _14906_/C VDD VSS _14908_/C OA21X2
X_10029_ _18581_/Q _10029_/B VDD VSS _10029_/Y XOR2X1
X_18674_ _18810_/CK _18674_/D _18674_/Q VDD VSS DFFQX1
X_15886_ _16768_/A _15886_/B VDD VSS _19493_/D AND2X1
XFILLER_76_594 VSS VDD FILLER2
XFILLER_64_745 VDD VSS DECAPHV16
XFILLER_48_296 VDD VSS FILLER4
X_17625_ _19885_/Q _19853_/Q _17625_/C VDD VSS _17629_/C MIN3X1
XFILLER_63_233 VSS VDD FILLER2
X_14837_ _14837_/A _14837_/B _14837_/C VDD VSS _14839_/C OR3X2
XTAP_TAPCELL_ROW_46_431 VDD VSS WELLTAP
XTAP_TAPCELL_ROW_124_1128 VDD VSS WELLTAP
XFILLER_23_108 VSS VDD FILLER2
X_17556_ _17554_/B _17556_/B VDD VSS _17557_/C NOR2BX1
XFILLER_16_160 VSS VDD FILLER2
X_14768_ _14768_/A VDD VSS _14769_/B INVX1
XTAP_TAPCELL_ROW_18_177 VDD VSS WELLTAP
X_16507_ _16518_/B _16507_/B VDD VSS _16859_/B XNOR2X1
X_13719_ _13719_/A _13719_/B VDD VSS _14423_/B XNOR2X1
X_17487_ _19856_/Q _19824_/Q VDD VSS _17488_/C NAND2X1
X_14699_ _19445_/Q VDD VSS _14776_/A INVX1
X_19226_ _19988_/CK _19226_/D _19226_/Q VDD VSS DFFQX1
XFILLER_20_826 VSS VDD FILLER2
XFILLER_149_349 VSS VDD FILLER2
X_16438_ _16469_/B _16438_/B VDD VSS _16891_/B NAND2X1
Xclkbuf_2_0__f_sclk_regs clkbuf_0_sclk_regs/Y VDD VSS _20052_/CK BUFX12
X_19157_ _19157_/CK _19157_/D _19157_/Q VDD VSS DFFQX1
XFILLER_118_725 VSS VDD FILLER2
X_16369_ _19564_/Q _16711_/A _16369_/C VDD VSS _16395_/C OAI21X1
XFILLER_118_736 VSS VDD FILLER2
XFILLER_145_533 VSS VDD FILLER2
X_18108_ _18112_/C _18112_/A VDD VSS _18110_/A NOR2BX1
XTAP_TAPCELL_ROW_135_1224 VDD VSS WELLTAP
XFILLER_117_235 VSS VDD FILLER2
X_19088_ _19115_/CK _19088_/D _19088_/Q VDD VSS DFFQX1
XFILLER_145_577 VDD VSS DECAPHV8
X_18039_ _18042_/B _18045_/B _18039_/C _18049_/D VDD VSS _19977_/D OAI31X1
XFILLER_160_514 VSS VDD FILLER2
X_20001_ _20007_/CK _20001_/D _20001_/Q VDD VSS DFFQX1
X_09812_ _18311_/Q _09812_/B _09816_/D VDD VSS _09817_/B AOI21X1
XFILLER_143_18 VDD VSS FILLER4
XFILLER_100_102 VDD VSS FILLER4
XFILLER_140_293 VDD VSS FILLER4
Xclkbuf_0__09166_ _18215_/ECK VDD VSS clkbuf_0__09166_/Y BUFX12
X_09743_ _20173_/A _09784_/C _09769_/C _18322_/Q VDD VSS _09744_/B AO22X2
XFILLER_74_509 VSS VDD FILLER2
XFILLER_100_157 VDD VSS FILLER1
XTAP_TAPCELL_ROW_97_887 VDD VSS WELLTAP
XTAP_TAPCELL_ROW_146_1331 VDD VSS WELLTAP
XFILLER_67_561 VDD VSS FILLER4
X_09674_ _18266_/Q _09770_/B _09770_/C _18318_/Q _09674_/E VDD VSS _09675_/C AOI221X1
XFILLER_55_723 VSS VDD FILLER2
XFILLER_67_594 VDD VSS FILLER1
XFILLER_36_49 VSS VDD FILLER2
XFILLER_82_586 VSS VDD FILLER2
XFILLER_42_417 VDD VSS FILLER1
XFILLER_70_759 VDD VSS FILLER4
XTAP_TAPCELL_ROW_80_732 VDD VSS WELLTAP
XFILLER_23_631 VDD VSS FILLER1
XFILLER_52_26 VSS VDD FILLER2
XFILLER_22_152 VDD VSS FILLER4
XTAP_TAPCELL_ROW_52_478 VDD VSS WELLTAP
XFILLER_10_369 VDD VSS FILLER4
XFILLER_109_736 VDD VSS DECAPHV8
XFILLER_109_747 VSS VDD FILLER2
XFILLER_108_235 VDD VSS FILLER4
X_10380_ _10406_/A _10381_/C _10381_/D VDD VSS _10383_/B OR3BX1
XFILLER_108_246 VSS VDD FILLER2
XFILLER_124_706 VSS VDD FILLER2
XFILLER_163_363 VSS VDD FILLER2
XFILLER_151_514 VSS VDD FILLER2
XFILLER_151_536 VSS VDD FILLER2
X_12050_ _12055_/A _12055_/B _12055_/C _12050_/D VDD VSS _14528_/B OAOI211X1
XTAP_TAPCELL_ROW_112_1021 VDD VSS WELLTAP
XFILLER_7_4 VSS VDD FILLER2
XFILLER_116_290 VDD VSS FILLER1
XFILLER_104_441 VSS VDD FILLER2
XFILLER_132_761 VDD VSS FILLER1
XFILLER_89_141 VSS VDD FILLER2
X_11001_ _18703_/Q _18757_/Q _11001_/C VDD VSS _11002_/B MIN3X1
XFILLER_117_96 VSS VDD FILLER2
XFILLER_89_174 VSS VDD FILLER2
XFILLER_104_485 VDD VSS FILLER1
XFILLER_131_271 VDD VSS DECAPHV8
XFILLER_77_67 VSS VDD FILLER2
XFILLER_131_282 VSS VDD FILLER2
XFILLER_77_369 VSS VDD FILLER2
XFILLER_65_509 VDD VSS FILLER4
XFILLER_58_561 VSS VDD FILLER2
XFILLER_46_712 VSS VDD FILLER2
X_15740_ _15743_/A _15740_/B VDD VSS _19365_/D AND2X1
XFILLER_92_328 VSS VDD FILLER2
X_12952_ _19217_/Q _14510_/B VDD VSS _12953_/D _14510_/C AND3X2
XFILLER_58_594 VSS VDD FILLER2
XFILLER_46_745 VSS VDD FILLER2
XFILLER_18_447 VSS VDD FILLER2
X_11903_ _19036_/Q _11954_/B _11907_/C VDD VSS _14270_/B XNOR3X1
XTAP_TAPCELL_ROW_164_1486 VDD VSS WELLTAP
X_15671_ _19331_/Q _15671_/B _15671_/C VDD VSS _18194_/A MIN3X1
X_12883_ _18908_/Q _12883_/B _12883_/C VDD VSS _14121_/B XNOR3X1
XFILLER_61_715 VSS VDD FILLER2
X_17410_ _17413_/C _17411_/B _17452_/C VDD VSS _17411_/C OAI21X1
XFILLER_73_586 VSS VDD FILLER2
XFILLER_45_277 VSS VDD FILLER2
X_14622_ _14644_/A _15889_/B VDD VSS _14624_/C NAND2X1
XFILLER_26_60 VDD VSS FILLER1
X_18390_ _18391_/CK _18470_/D _20195_/A _20065_/RB VDD VSS DFFRQX1
X_11834_ _11804_/B _14521_/C _19228_/Q VDD VSS _11835_/D AND3BX1
XTAP_TAPCELL_ROW_43_401 VDD VSS WELLTAP
XFILLER_26_71 VSS VDD FILLER2
X_17341_ _17346_/C _17346_/B VDD VSS _17343_/B NAND2BX1
X_14553_ _19993_/Q _14558_/B VDD VSS _19257_/D AND2X1
X_11765_ _11797_/A _11797_/B _11797_/C VDD VSS _11851_/A OA21X2
XFILLER_60_258 VSS VDD FILLER2
XTAP_TAPCELL_ROW_15_147 VDD VSS WELLTAP
XFILLER_14_675 VDD VSS FILLER1
X_13504_ _14224_/B _18970_/Q VDD VSS _13516_/A NAND2BX1
X_10716_ _10965_/A _18723_/Q VDD VSS _10717_/D AND2X1
XFILLER_159_658 VDD VSS FILLER1
XFILLER_147_809 VSS VDD FILLER2
X_17272_ _19810_/Q _19778_/Q _17272_/C VDD VSS _17277_/C AO21X2
X_14484_ _14766_/A _14484_/B VDD VSS _19197_/D AND2X1
X_11696_ _11736_/A _11716_/D VDD VSS _11700_/C XNOR2X1
XFILLER_159_669 VDD VSS FILLER1
X_19011_ _19068_/CK _19011_/D _19011_/Q VDD VSS DFFQX1
X_16223_ _16221_/Y _16225_/B _17986_/C VDD VSS _19527_/D AND3BX1
XFILLER_42_70 VSS VDD FILLER2
XFILLER_139_360 VSS VDD FILLER2
X_13435_ _13616_/A _13616_/B _13616_/D _13616_/C VDD VSS _14388_/C AOI211X1
X_10647_ _18693_/Q _18747_/Q VDD VSS _10649_/C NOR2X1
XFILLER_127_511 VSS VDD FILLER2
XFILLER_139_371 VDD VSS FILLER1
XFILLER_155_820 VSS VDD FILLER2
XFILLER_9_189 VSS VDD FILLER2
X_16154_ _16144_/A _16154_/B _16154_/C VDD VSS _16177_/A AOI2B1X1
X_13366_ _19081_/Q _14355_/A VDD VSS _13422_/C _14355_/B NAND3X1
XFILLER_61_7 VSS VDD FILLER2
X_10578_ _10578_/A _10578_/B VDD VSS _10656_/B _10578_/C _10578_/D NAND4X2
XFILLER_115_706 VDD VSS FILLER1
X_15105_ _19509_/Q _15903_/B VDD VSS _15155_/A NAND2BX1
XFILLER_142_514 VSS VDD FILLER2
X_12317_ _20002_/Q _19266_/Q VDD VSS _12407_/D NOR2X1
X_16085_ _16085_/A _16085_/B _16734_/B VDD VSS _16109_/B MIN3X1
X_13297_ _18941_/Q _14191_/B VDD VSS _13393_/A AND2X1
XFILLER_5_384 VSS VDD FILLER2
XFILLER_142_547 VSS VDD FILLER2
XFILLER_5_395 VDD VSS FILLER1
X_15036_ _15036_/A _15036_/B _15683_/B VDD VSS _15080_/B MIN3X1
X_19913_ clkload8/A _19913_/D _19913_/Q VDD VSS DFFQX1
X_12248_ _14404_/B _14404_/C _19125_/Q VDD VSS _12298_/B AOI21X1
XFILLER_69_804 VSS VDD FILLER2
XFILLER_110_400 VDD VSS DECAPHV8
XFILLER_123_783 VSS VDD FILLER2
X_19844_ _19880_/CK _19844_/D _19844_/Q VDD VSS DFFQX1
X_12179_ _12214_/A wire161/Y VDD VSS _14435_/B XNOR2X1
XTAP_TAPCELL_ROW_130_1187 VDD VSS WELLTAP
XFILLER_122_282 VSS VDD FILLER2
X_19775_ _19841_/CK _19775_/D _19775_/Q VDD VSS DFFQX1
XFILLER_56_509 VSS VDD FILLER2
X_16987_ _16994_/A _16991_/C _17081_/C VDD VSS _16988_/C OAI21X1
XFILLER_96_678 VDD VSS FILLER4
XFILLER_49_561 VDD VSS DECAPHV8
X_18726_ _19940_/CK _18726_/D _18726_/Q VDD VSS DFFQX1
X_15938_ _19900_/Q VDD VSS _16693_/A INVX1
XFILLER_49_583 VSS VDD FILLER2
XFILLER_37_723 VDD VSS DECAPHV8
XTAP_TAPCELL_ROW_94_857 VDD VSS WELLTAP
XFILLER_37_756 VSS VDD FILLER2
X_18657_ _18823_/CK _18657_/D _18657_/Q VDD VSS DFFQX1
X_15869_ _15879_/A _15869_/B VDD VSS _19478_/D AND2X1
XFILLER_37_778 VDD VSS FILLER1
XFILLER_36_266 VDD VSS FILLER1
XFILLER_24_417 VDD VSS FILLER1
X_17608_ _17610_/A _17610_/B _17608_/C VDD VSS _19882_/D AOI21X1
XTAP_TAPCELL_ROW_106_969 VDD VSS WELLTAP
X_09390_ _19935_/Q _09390_/B VDD VSS _09405_/B NAND2X1
X_18588_ _18595_/CK _18588_/D _18588_/Q VDD VSS DFFQX1
X_17539_ _17541_/B _17539_/B VDD VSS _17540_/B XOR2X1
XTAP_TAPCELL_ROW_141_1283 VDD VSS WELLTAP
XFILLER_149_113 VSS VDD FILLER2
XFILLER_20_601 VSS VDD FILLER2
XFILLER_149_135 VSS VDD FILLER2
X_19209_ _19269_/CK _19209_/D _19209_/Q VDD VSS DFFQX1
XFILLER_22_29 VSS VDD FILLER2
XFILLER_137_319 VSS VDD FILLER2
XFILLER_146_820 VSS VDD FILLER2
XFILLER_146_842 VSS VDD FILLER2
XFILLER_164_138 VDD VSS FILLER1
XFILLER_164_149 VSS VDD FILLER2
XFILLER_145_352 VSS VDD FILLER2
XFILLER_106_717 VSS VDD FILLER2
XFILLER_105_238 VDD VSS FILLER4
XFILLER_161_856 VDD VSS FILLER1
Xclkbuf_leaf_6_clk_regs clkbuf_leaf_9_clk_regs/A VDD VSS _19880_/CK BUFX12
XFILLER_87_601 VSS VDD FILLER2
XFILLER_120_219 VSS VDD FILLER2
XFILLER_114_783 VDD VSS FILLER4
XFILLER_87_623 VDD VSS FILLER1
XFILLER_141_580 VDD VSS FILLER1
XFILLER_59_325 VSS VDD FILLER2
XFILLER_113_282 VSS VDD FILLER2
XFILLER_86_144 VDD VSS FILLER1
XFILLER_47_15 VSS VDD FILLER2
Xfanout179 _18628_/Q VDD VSS _10965_/A BUFX3
XFILLER_86_177 VSS VDD FILLER2
X_09726_ _20075_/Q _09770_/B _09784_/C _18433_/Q VDD VSS _09729_/A AOI22X1
XFILLER_74_328 VDD VSS FILLER4
XTAP_TAPCELL_ROW_57_526 VDD VSS WELLTAP
XFILLER_74_339 VSS VDD FILLER2
XFILLER_83_840 VSS VDD FILLER2
XFILLER_55_542 VSS VDD FILLER2
XFILLER_28_767 VDD VSS FILLER4
X_09657_ _20186_/A _09813_/C _09770_/C _18317_/Q _09657_/E VDD VSS _09658_/E AOI221X1
XFILLER_27_277 VSS VDD FILLER2
X_09588_ _09815_/C VDD VSS _09769_/C BUFX3
XFILLER_82_394 VSS VDD FILLER2
X_11550_ _11550_/A _11641_/B VDD VSS _18726_/D NOR2X1
XTAP_TAPCELL_ROW_12_117 VDD VSS WELLTAP
XFILLER_10_111 VDD VSS FILLER4
X_10501_ _10511_/A _10659_/B _10659_/C _10501_/D VDD VSS _10502_/B AO31X2
XTAP_TAPCELL_ROW_155_1408 VDD VSS WELLTAP
XFILLER_155_105 VDD VSS FILLER4
XFILLER_109_500 VDD VSS DECAPHV8
X_11481_ _18637_/Q _11484_/B VDD VSS _18664_/D AND2X1
XFILLER_155_116 VDD VSS FILLER1
XFILLER_137_842 VDD VSS FILLER1
X_13220_ _13231_/A _14385_/B _13231_/C VDD VSS _14386_/B OAI21X1
X_10432_ _10472_/B _10432_/B VDD VSS _18555_/D AND2X1
XFILLER_136_330 VDD VSS FILLER1
XFILLER_6_137 VSS VDD FILLER2
XTAP_TAPCELL_ROW_20_194 VDD VSS WELLTAP
X_13151_ _13152_/B _13152_/C _19247_/Q VDD VSS _13240_/B AOI21X1
XFILLER_124_514 VSS VDD FILLER2
XFILLER_151_300 VDD VSS FILLER4
X_10363_ _10417_/A _10417_/B _10417_/C _10363_/D VDD VSS _10395_/B AOAI211X1
XFILLER_128_84 VSS VDD FILLER2
XFILLER_152_856 VDD VSS FILLER1
X_12102_ _12108_/A _12108_/B _12108_/C VDD VSS _14529_/B OAI21X1
XFILLER_163_182 VDD VSS FILLER4
XFILLER_88_44 VSS VDD FILLER2
X_13082_ _18911_/Q VDD VSS _13178_/A INVX1
XFILLER_3_855 VSS VDD FILLER2
XFILLER_124_569 VSS VDD FILLER2
X_10294_ _10721_/D _10294_/B _10294_/C _10362_/D VDD VSS _10295_/C OAI22X1
XFILLER_97_409 VSS VDD FILLER2
XFILLER_111_208 VSS VDD FILLER2
X_16910_ _20068_/Q VDD VSS _20068_/D INVX1
X_12033_ _19178_/Q _14464_/B VDD VSS _12155_/A AND2X1
XFILLER_151_399 VSS VDD FILLER2
X_17890_ _17894_/A _17894_/B VDD VSS _17892_/A XNOR2X1
XFILLER_120_731 VDD VSS FILLER4
XTAP_TAPCELL_ROW_166_1504 VDD VSS WELLTAP
XTAP_TAPCELL_ROW_166_1515 VDD VSS WELLTAP
X_16841_ _16865_/A _16841_/B VDD VSS _19681_/D NOR2X1
XFILLER_120_764 VDD VSS FILLER1
XFILLER_78_678 VSS VDD FILLER2
XFILLER_66_829 VDD VSS FILLER4
X_19560_ _19584_/CK _19560_/D _19560_/Q VDD VSS DFFQX1
X_16772_ _16793_/A _16772_/B VDD VSS _19619_/D AND2X1
X_13984_ _13995_/A _13995_/B VDD VSS _14137_/C _13995_/C NAND3X1
XFILLER_18_211 VSS VDD FILLER2
XFILLER_46_531 VSS VDD FILLER2
XFILLER_18_222 VDD VSS FILLER1
X_18511_ _18511_/CK _18511_/D _18511_/Q _09343_/Y VDD VSS DFFRQX1
X_15723_ _15725_/A _15723_/B VDD VSS _19349_/D AND2X1
X_19491_ _19737_/CK _19491_/D _19491_/Q VDD VSS DFFQX1
X_12935_ _14444_/B _14444_/C _12936_/A VDD VSS _13107_/B OAI21X1
XFILLER_37_70 VSS VDD FILLER2
XFILLER_18_255 VSS VDD FILLER2
XFILLER_34_715 VSS VDD FILLER2
XFILLER_18_277 VSS VDD FILLER2
X_18442_ _18454_/CK _18442_/D _18442_/Q _18442_/RB VDD VSS DFFRQX1
X_15654_ _15654_/A _15654_/B VDD VSS _15655_/C NAND2X1
XTAP_TAPCELL_ROW_28_261 VDD VSS WELLTAP
X_12866_ _12916_/A _12916_/B VDD VSS _14318_/B XNOR2X1
XTAP_TAPCELL_ROW_8_85 VDD VSS WELLTAP
XTAP_TAPCELL_ROW_103_939 VDD VSS WELLTAP
XFILLER_61_556 VSS VDD FILLER2
X_14605_ _19523_/Q _14649_/C VDD VSS _15889_/B XNOR2X1
XFILLER_61_567 VSS VDD FILLER2
X_18373_ _18375_/CK _18373_/D _18373_/Q _18373_/RB VDD VSS DFFRQX1
X_11817_ _19117_/Q VDD VSS _11819_/A INVX1
X_15585_ _19354_/Q _15729_/B VDD VSS _15592_/B XNOR2X1
X_12797_ _12779_/Y _12872_/B _18992_/Q VDD VSS _12903_/B NAND3BX1
X_17324_ _19822_/Q _19790_/Q VDD VSS _17327_/A XNOR2X1
X_14536_ _14766_/A _14536_/B VDD VSS _19242_/D AND2X1
X_11748_ _19992_/Q _19256_/Q VDD VSS _11769_/D XOR2X1
XFILLER_119_308 VDD VSS FILLER4
X_17255_ _17257_/B _17255_/B VDD VSS _17256_/B XOR2X1
X_14467_ _14467_/A _14467_/B VDD VSS _19181_/D AND2X1
X_11679_ _18816_/Q _14547_/B VDD VSS _18843_/D AND2X1
X_16206_ _19590_/Q _16206_/B _16740_/B VDD VSS _16233_/A MIN3X1
XFILLER_146_149 VDD VSS FILLER1
X_13418_ _13427_/A _13418_/B _13437_/C VDD VSS _13531_/A XNOR3X1
XFILLER_127_341 VSS VDD FILLER2
X_17186_ _17189_/A _17189_/B _17229_/C VDD VSS _17187_/C OAI21X1
X_14398_ _14426_/A _14398_/B VDD VSS _19119_/D NOR2X1
XFILLER_155_672 VDD VSS FILLER1
X_16137_ _19555_/Q _16701_/A _16137_/C VDD VSS _16159_/C MIN3X1
XTAP_TAPCELL_ROW_132_1205 VDD VSS WELLTAP
XFILLER_115_525 VDD VSS FILLER1
XFILLER_142_311 VSS VDD FILLER2
X_13349_ _19250_/Q _14545_/B VDD VSS _13464_/B XNOR2X1
XFILLER_6_682 VDD VSS FILLER1
XFILLER_142_322 VSS VDD FILLER2
XFILLER_143_856 VDD VSS FILLER1
X_16068_ _16083_/A _16083_/B VDD VSS _16806_/B XNOR2X1
XTAP_TAPCELL_ROW_99_905 VDD VSS WELLTAP
XFILLER_102_208 VSS VDD FILLER2
X_15019_ _15056_/A _15056_/B _15056_/D _15056_/C VDD VSS _15052_/D OAI211X1
XFILLER_68_122 VDD VSS FILLER1
XFILLER_69_656 VDD VSS FILLER1
XFILLER_110_230 VSS VDD FILLER2
X_19827_ _19841_/CK _19827_/D _19827_/Q VDD VSS DFFQX1
XFILLER_57_818 VSS VDD FILLER2
XFILLER_69_678 VSS VDD FILLER2
XFILLER_110_252 VSS VDD FILLER2
XFILLER_110_263 VSS VDD FILLER2
XFILLER_111_786 VSS VDD FILLER2
XFILLER_56_328 VSS VDD FILLER2
XFILLER_83_114 VSS VDD FILLER2
X_19758_ _19791_/CK _19758_/D _19758_/Q VDD VSS DFFQX1
XFILLER_65_840 VSS VDD FILLER2
XFILLER_37_531 VSS VDD FILLER2
XTAP_TAPCELL_ROW_143_1301 VDD VSS WELLTAP
X_09511_ _20018_/Q _20017_/Q _20019_/Q _20020_/Q VDD VSS _09526_/B AND4X2
XFILLER_37_542 VDD VSS FILLER1
X_18709_ _18818_/CK _18709_/D _18709_/Q VDD VSS DFFQX1
X_19689_ _19695_/CK _19689_/D _19689_/Q VDD VSS DFFQX1
XFILLER_64_350 VDD VSS FILLER4
X_09442_ _09446_/A _09772_/B VDD VSS _18219_/E NOR2X1
XFILLER_24_214 VSS VDD FILLER2
XFILLER_52_545 VSS VDD FILLER2
XFILLER_24_247 VSS VDD FILLER2
X_09373_ _09482_/C VDD VSS _09468_/B BUFX3
XFILLER_33_770 VDD VSS FILLER1
XTAP_TAPCELL_ROW_62_573 VDD VSS WELLTAP
XFILLER_138_617 VSS VDD FILLER2
XFILLER_137_105 VSS VDD FILLER2
XFILLER_165_425 VDD VSS FILLER1
XFILLER_20_464 VSS VDD FILLER2
XFILLER_118_363 VDD VSS FILLER4
XFILLER_152_108 VDD VSS FILLER4
XFILLER_106_514 VDD VSS DECAPHV8
XFILLER_152_119 VSS VDD FILLER2
XFILLER_145_171 VDD VSS FILLER4
XFILLER_161_620 VSS VDD FILLER2
XFILLER_106_547 VSS VDD FILLER2
XFILLER_134_856 VDD VSS FILLER1
XFILLER_133_344 VDD VSS FILLER4
XFILLER_59_100 VSS VDD FILLER2
XFILLER_87_420 VDD VSS DECAPHV8
XFILLER_99_291 VSS VDD FILLER2
XFILLER_87_464 VDD VSS FILLER1
XFILLER_28_542 VDD VSS FILLER4
X_09709_ _18320_/Q _09769_/C VDD VSS _09711_/C NAND2X1
XFILLER_90_607 VDD VSS DECAPHV8
XFILLER_28_553 VDD VSS FILLER4
X_10981_ _11095_/C _10981_/B _10981_/C _11229_/D VDD VSS _10982_/C OAI22X1
XFILLER_74_169 VDD VSS FILLER4
XFILLER_28_586 VSS VDD FILLER2
X_12720_ _12807_/A _12731_/B _12731_/C VDD VSS _14317_/C OR3BX1
XFILLER_74_79 VDD VSS DECAPHV8
XFILLER_55_394 VSS VDD FILLER2
XFILLER_82_191 VSS VDD FILLER2
XFILLER_43_556 VSS VDD FILLER2
XFILLER_43_567 VDD VSS FILLER4
X_12651_ _12737_/A _14442_/B VDD VSS _12748_/A NOR2X1
XFILLER_43_578 VSS VDD FILLER2
XFILLER_31_718 VDD VSS DECAPHV8
XTAP_TAPCELL_ROW_25_242 VDD VSS WELLTAP
XFILLER_70_364 VSS VDD FILLER2
XTAP_TAPCELL_ROW_100_909 VDD VSS WELLTAP
XFILLER_30_217 VSS VDD FILLER2
X_11602_ _18746_/Q _11612_/B VDD VSS _18773_/D AND2X1
X_15370_ _19404_/Q _15785_/B VDD VSS _15389_/C NAND2X1
X_12582_ _20005_/Q _19269_/Q VDD VSS _12583_/D AND2X1
XFILLER_30_239 VSS VDD FILLER2
XFILLER_11_420 VDD VSS FILLER4
XFILLER_129_617 VSS VDD FILLER2
XFILLER_135_0 VSS VDD FILLER2
X_14321_ _14339_/A _14321_/B VDD VSS _19051_/D NOR2X1
X_11533_ _18684_/Q _11542_/B VDD VSS _18711_/D AND2X1
XFILLER_7_402 VSS VDD FILLER2
XFILLER_23_61 VDD VSS FILLER4
XFILLER_128_127 VSS VDD FILLER2
XFILLER_7_424 VSS VDD FILLER2
XFILLER_156_447 VDD VSS FILLER4
XFILLER_11_497 VSS VDD FILLER2
XFILLER_139_61 VSS VDD FILLER2
X_17040_ _17040_/A _17040_/B VDD VSS _17045_/B NAND2X1
XFILLER_99_10 VSS VDD FILLER2
X_14252_ _14457_/A VDD VSS _14285_/A BUFX3
X_11464_ _19956_/Q _11473_/B VDD VSS _18649_/D AND2X1
XFILLER_7_468 VSS VDD FILLER2
X_13203_ _13203_/A _13203_/B _13203_/C _13203_/D VDD VSS _14221_/B OAOI211X1
X_10415_ _10460_/A _10460_/B VDD VSS _10421_/B NAND2X1
XFILLER_99_54 VSS VDD FILLER2
XTAP_TAPCELL_ROW_118_1071 VDD VSS WELLTAP
X_14183_ _14186_/A _14183_/B VDD VSS _18935_/D NOR2X1
X_11395_ _232_/E _11396_/A _11395_/C VDD VSS _18596_/D NOR3X1
XFILLER_124_344 VDD VSS FILLER4
X_13134_ _14511_/B _14511_/C _13135_/A VDD VSS _13141_/B OAI21X1
X_10346_ _10346_/A _10346_/B VDD VSS _10347_/A AND2X1
XFILLER_98_707 VSS VDD FILLER2
X_18991_ _19025_/CK _18991_/D _18991_/Q VDD VSS DFFQX1
XFILLER_112_506 VDD VSS FILLER4
XFILLER_98_729 VSS VDD FILLER2
XFILLER_155_60 VSS VDD FILLER2
XFILLER_151_163 VSS VDD FILLER2
XFILLER_124_388 VSS VDD FILLER2
X_17942_ _17946_/A _17942_/B VDD VSS _17948_/B NAND2BX1
X_13065_ _19135_/Q _13316_/A _13315_/B VDD VSS _13314_/D XNOR3X1
X_10277_ _18552_/Q VDD VSS _10312_/A INVX1
X_12016_ _19038_/Q _12016_/B _12016_/C VDD VSS _12285_/B MIN3X1
XFILLER_78_442 VSS VDD FILLER2
XFILLER_78_453 VDD VSS FILLER1
XFILLER_39_807 VSS VDD FILLER2
X_17873_ _17872_/B _17876_/C VDD VSS _17874_/C NOR2BX1
XFILLER_66_615 VSS VDD FILLER2
X_16824_ _16826_/A _16824_/B VDD VSS _19666_/D NOR2X1
X_19612_ _19636_/CK _19612_/D _19612_/Q VDD VSS DFFQX1
XFILLER_65_114 VDD VSS FILLER4
XFILLER_38_328 VDD VSS FILLER4
XFILLER_47_840 VSS VDD FILLER2
X_19543_ _19736_/CK _19543_/D _19543_/Q VDD VSS DFFQX1
XFILLER_81_607 VSS VDD FILLER2
XFILLER_65_158 VDD VSS FILLER4
XFILLER_0_32 VSS VDD FILLER2
X_16755_ _16759_/A _16755_/B VDD VSS _19604_/D NOR2X1
XFILLER_81_618 VDD VSS FILLER1
XFILLER_0_43 VSS VDD FILLER2
X_13967_ _14301_/A _14301_/B _13967_/C VDD VSS _14010_/C AO21X2
X_15706_ _15706_/A _15706_/B VDD VSS _19334_/D AND2X1
XTAP_TAPCELL_ROW_76_698 VDD VSS WELLTAP
X_19474_ _19528_/CK _19474_/D _19474_/Q VDD VSS DFFQX1
X_12918_ _13005_/A _13005_/B _13005_/C _13005_/D VDD VSS _13095_/A AOI31X1
XFILLER_62_832 VSS VDD FILLER2
X_16686_ _19705_/Q _16868_/B VDD VSS _16687_/B XNOR2X1
XFILLER_73_180 VDD VSS FILLER4
XFILLER_61_320 VDD VSS FILLER4
XFILLER_46_394 VDD VSS FILLER1
X_13898_ _13951_/A _14266_/B _14266_/C VDD VSS _13998_/C NOR3X1
XFILLER_61_331 VSS VDD FILLER2
XFILLER_34_545 VDD VSS FILLER4
XFILLER_34_556 VDD VSS DECAPHV8
X_18425_ _18437_/CK _18425_/D _18425_/Q _18463_/RB VDD VSS DFFRQX1
XFILLER_22_707 VSS VDD FILLER2
X_15637_ _15637_/A _15637_/B _15637_/C VDD VSS _15657_/B AO21X2
X_12849_ _20009_/Q _19273_/Q VDD VSS _13049_/A XOR2X1
XFILLER_61_375 VSS VDD FILLER2
X_18356_ _18357_/CK _18356_/D _18356_/Q _18498_/RB VDD VSS DFFRQX1
XFILLER_14_280 VSS VDD FILLER2
X_15568_ _15568_/A _15568_/B _15568_/C VDD VSS _15584_/A AOI21X1
XFILLER_147_403 VDD VSS FILLER4
X_17307_ _17309_/A _17309_/B _17307_/C VDD VSS _19818_/D AOI21X1
X_14519_ _14491_/Y _14519_/B _14519_/C VDD VSS _19226_/D AND3BX1
X_18287_ _18288_/CK _18287_/D _18287_/Q VDD VSS DFFQX1
XFILLER_147_436 VSS VDD FILLER2
X_15499_ _15499_/A _15502_/C VDD VSS _18149_/B XNOR2X1
XFILLER_9_96 VDD VSS FILLER4
XTAP_TAPCELL_ROW_31_289 VDD VSS WELLTAP
X_17238_ _19803_/Q _19771_/Q _17238_/C VDD VSS _17242_/B AOI21X1
XFILLER_128_661 VSS VDD FILLER2
XFILLER_116_812 VSS VDD FILLER2
XFILLER_134_119 VDD VSS FILLER1
X_17169_ _17170_/C _17469_/B _17169_/C VDD VSS _19788_/D AND3BX1
XFILLER_115_333 VSS VDD FILLER2
XFILLER_143_642 VSS VDD FILLER2
X_20180_ _20180_/A VDD VSS _20180_/Y BUFX3
X_09991_ _09930_/B _09919_/B _10034_/A VDD VSS _09992_/B MUXI2X1
XFILLER_88_206 VDD VSS FILLER1
XFILLER_142_196 VSS VDD FILLER2
XFILLER_97_751 VSS VDD FILLER2
XFILLER_69_464 VDD VSS FILLER1
XFILLER_111_561 VSS VDD FILLER2
XFILLER_28_39 VSS VDD FILLER2
XFILLER_151_18 VSS VDD FILLER2
XFILLER_56_114 VSS VDD FILLER2
XFILLER_57_648 VSS VDD FILLER2
XFILLER_56_136 VSS VDD FILLER2
XFILLER_72_607 VDD VSS FILLER4
XFILLER_72_618 VDD VSS FILLER4
XFILLER_44_309 VSS VDD FILLER2
XTAP_TAPCELL_ROW_39_367 VDD VSS WELLTAP
XFILLER_65_670 VSS VDD FILLER2
XFILLER_65_681 VDD VSS FILLER1
XFILLER_37_383 VSS VDD FILLER2
XFILLER_52_320 VDD VSS FILLER4
XFILLER_64_191 VSS VDD FILLER2
XFILLER_52_342 VSS VDD FILLER2
XFILLER_44_49 VSS VDD FILLER2
X_09425_ _09447_/B _09819_/A VDD VSS _18233_/E NOR2X1
XFILLER_80_673 VSS VDD FILLER2
XFILLER_80_695 VSS VDD FILLER2
XFILLER_40_526 VSS VDD FILLER2
X_09356_ _09380_/B _09362_/B VDD VSS _09356_/Y NOR2BX1
XTAP_TAPCELL_ROW_22_212 VDD VSS WELLTAP
XFILLER_166_723 VSS VDD FILLER2
X_09287_ _09296_/A _09301_/B _09414_/D _09351_/B VDD VSS _09414_/B AOI211X1
XFILLER_166_745 VSS VDD FILLER2
XFILLER_21_784 VDD VSS FILLER1
XFILLER_20_261 VSS VDD FILLER2
XFILLER_119_650 VDD VSS FILLER1
XFILLER_107_801 VSS VDD FILLER2
XFILLER_119_672 VSS VDD FILLER2
XFILLER_125_108 VDD VSS FILLER4
XFILLER_165_277 VSS VDD FILLER2
XFILLER_109_31 VSS VDD FILLER2
XFILLER_109_53 VSS VDD FILLER2
XFILLER_134_642 VDD VSS FILLER1
X_10200_ _10200_/A _10200_/B _10200_/C _10200_/D VDD VSS _10201_/B OAI211X1
XFILLER_4_449 VSS VDD FILLER2
X_11180_ _11149_/Y _11179_/Y _10984_/A VDD VSS _11180_/Y MUXI2X1
XFILLER_79_217 VDD VSS FILLER4
X_10131_ _10131_/A VDD VSS _10224_/A BUFX3
XFILLER_0_611 VSS VDD FILLER2
XFILLER_121_325 VDD VSS FILLER4
XFILLER_161_494 VSS VDD FILLER2
XFILLER_0_633 VSS VDD FILLER2
XFILLER_121_336 VDD VSS FILLER4
XFILLER_125_30 VSS VDD FILLER2
XFILLER_121_358 VDD VSS FILLER4
X_10062_ _18605_/Q _10062_/B VDD VSS _10075_/B NOR2BX1
XFILLER_87_250 VSS VDD FILLER2
XFILLER_125_96 VDD VSS FILLER4
X_14870_ _14920_/A _15833_/B VDD VSS _14885_/B NOR2X1
XFILLER_48_659 VDD VSS DECAPHV16
XFILLER_29_840 VSS VDD FILLER2
X_13821_ _13876_/A _14131_/B _13876_/C _13821_/D VDD VSS _13981_/A AOAI211X1
XFILLER_47_169 VSS VDD FILLER2
XFILLER_28_350 VSS VDD FILLER2
XFILLER_62_117 VDD VSS DECAPHV8
XFILLER_44_821 VDD VSS FILLER1
XFILLER_141_62 VDD VSS FILLER1
X_16540_ _16540_/A _16543_/B VDD VSS _16541_/B XOR2X1
XFILLER_56_692 VDD VSS FILLER4
XFILLER_18_94 VDD VSS FILLER4
X_13752_ _14132_/B _14131_/C _18890_/Q VDD VSS _13753_/D AND3BX1
XFILLER_44_843 VSS VDD FILLER2
X_10964_ _10998_/C _10964_/B VDD VSS _10966_/B XNOR2X1
XFILLER_55_191 VDD VSS FILLER1
XFILLER_16_556 VDD VSS FILLER4
X_12703_ _18879_/Q _12703_/B _12703_/C VDD VSS _12884_/B MIN3X1
XTAP_TAPCELL_ROW_73_668 VDD VSS WELLTAP
XFILLER_71_662 VDD VSS FILLER4
X_16471_ _19632_/Q _16786_/B VDD VSS _16472_/C NOR2X1
X_13683_ _13683_/A _13683_/B _13683_/C _13683_/D VDD VSS _14262_/B AOAI211X1
XFILLER_71_673 VDD VSS FILLER4
X_10895_ _10931_/A _10895_/B _10895_/C _11095_/C VDD VSS _10910_/C AOI211X1
XFILLER_71_684 VDD VSS DECAPHV8
XFILLER_43_375 VSS VDD FILLER2
X_15422_ _15419_/A _15422_/B _15422_/C VDD VSS _15498_/B AOI2B1X1
XFILLER_34_60 VDD VSS DECAPHV8
X_19190_ _19191_/CK _19190_/D _19190_/Q VDD VSS DFFQX1
X_12634_ _12634_/A _12634_/B _12634_/C _12634_/D VDD VSS _12804_/A AOAI211X1
XFILLER_8_700 VSS VDD FILLER2
X_18141_ _18143_/C _18141_/B VDD VSS _18142_/B XNOR2X1
X_15353_ _15359_/A _15359_/B _15354_/C VDD VSS _15355_/A OAI21X1
X_12565_ _12566_/A _12566_/B _12566_/D _12566_/C VDD VSS _12840_/B OAOI211X1
XFILLER_157_756 VSS VDD FILLER2
X_14304_ _14311_/A _14304_/B VDD VSS _19036_/D NOR2X1
X_18072_ _18173_/A _18072_/B VDD VSS _19989_/D NOR2X1
X_11516_ _18669_/Q _11519_/B VDD VSS _18696_/D AND2X1
X_15284_ _15284_/A _15284_/B _15284_/C _15284_/D VDD VSS _15306_/C AOAI211X1
XFILLER_8_766 VDD VSS FILLER4
X_12496_ _14534_/A _14534_/B _19240_/Q VDD VSS _12497_/D OA21X2
XFILLER_8_788 VSS VDD FILLER2
XFILLER_144_428 VSS VDD FILLER2
X_17023_ _18187_/C _17030_/A VDD VSS _17024_/C NAND2X1
XFILLER_8_799 VSS VDD FILLER2
X_14235_ _14270_/A _14235_/B VDD VSS _18979_/D AND2X1
X_11447_ _19942_/Q _17990_/A VDD VSS _18635_/D AND2X1
XFILLER_137_491 VSS VDD FILLER2
X_14166_ _14219_/A _14166_/B _14166_/C VDD VSS _18919_/D NOR3X1
X_11378_ _11378_/A _11378_/B _11378_/C VDD VSS _18592_/D NOR3X1
XFILLER_113_826 VDD VSS FILLER4
XFILLER_124_163 VSS VDD FILLER2
X_13117_ _13316_/A _13315_/B VDD VSS _14415_/B XNOR2X1
X_10329_ _10329_/A _10329_/B _10329_/C _10329_/D VDD VSS _10413_/B AOAI211X1
XFILLER_112_336 VSS VDD FILLER2
X_18974_ _19059_/CK _18974_/D _18974_/Q VDD VSS DFFQX1
X_14097_ _18898_/Q _14141_/B VDD VSS _17977_/A NOR2X1
XFILLER_100_509 VSS VDD FILLER2
X_17925_ _18862_/Q _17925_/B VDD VSS _17927_/C _17925_/C NAND3X1
X_13048_ _13255_/A _13150_/B VDD VSS _13049_/D NAND2X1
XFILLER_79_773 VSS VDD FILLER2
XFILLER_39_615 VDD VSS FILLER4
X_17856_ _18132_/A _17856_/B _17857_/C VDD VSS _19939_/D NOR3X1
XFILLER_78_294 VSS VDD FILLER2
XFILLER_66_434 VSS VDD FILLER2
X_16807_ _16811_/A _16807_/B VDD VSS _19650_/D NOR2X1
XFILLER_54_607 VSS VDD FILLER2
X_17787_ _19921_/Q _19889_/Q VDD VSS _17793_/B NAND2X1
X_14999_ wire162/Y _15000_/B _15000_/D _15000_/C VDD VSS _15054_/B OAOI211X1
XTAP_TAPCELL_ROW_127_1159 VDD VSS WELLTAP
XFILLER_94_798 VDD VSS FILLER4
XFILLER_81_415 VDD VSS DECAPHV16
XFILLER_47_670 VDD VSS FILLER4
X_16738_ _16748_/A _16738_/B VDD VSS _19588_/D NOR2X1
X_19526_ _19528_/CK _19526_/D _19526_/Q VDD VSS DFFQX1
XTAP_TAPCELL_ROW_36_337 VDD VSS WELLTAP
X_19457_ _19484_/CK _19457_/D _19457_/Q VDD VSS DFFQX1
XFILLER_62_662 VSS VDD FILLER2
X_16669_ _16669_/A VDD VSS _16867_/B INVX1
XFILLER_62_695 VSS VDD FILLER2
X_09210_ _18525_/Q VDD VSS _18424_/D INVX1
X_18408_ _18422_/CK _18525_/Q _20163_/A _18422_/RB VDD VSS DFFRQX1
XFILLER_98_0 VDD VSS FILLER4
X_19388_ _19465_/CK _19388_/D _19388_/Q VDD VSS DFFQX1
XFILLER_22_559 VDD VSS FILLER4
XFILLER_147_200 VDD VSS FILLER4
X_18339_ _18341_/CK _18339_/D _18339_/Q _18374_/RB VDD VSS DFFRQX1
XFILLER_147_222 VDD VSS DECAPHV8
XTAP_TAPCELL_ROW_138_1255 VDD VSS WELLTAP
XFILLER_162_214 VSS VDD FILLER2
XFILLER_128_480 VSS VDD FILLER2
XFILLER_146_18 VDD VSS FILLER1
XFILLER_116_642 VSS VDD FILLER2
XFILLER_89_504 VSS VDD FILLER2
XFILLER_131_601 VSS VDD FILLER2
XFILLER_143_472 VSS VDD FILLER2
XFILLER_1_419 VSS VDD FILLER2
XFILLER_103_314 VDD VSS DECAPHV8
XFILLER_89_537 VSS VDD FILLER2
X_20163_ _20163_/A VDD VSS _20163_/Y BUFX3
XFILLER_131_656 VDD VSS FILLER1
XFILLER_130_144 VDD VSS FILLER1
X_20094_ _20094_/A VDD VSS _20094_/Y BUFX3
XTAP_TAPCELL_ROW_149_1351 VDD VSS WELLTAP
XFILLER_97_592 VSS VDD FILLER2
XFILLER_85_743 VDD VSS FILLER1
XFILLER_84_220 VSS VDD FILLER2
XFILLER_85_776 VSS VDD FILLER2
XFILLER_84_264 VDD VSS FILLER4
XFILLER_72_404 VSS VDD FILLER2
XFILLER_55_26 VDD VSS DECAPHV8
XFILLER_26_832 VSS VDD FILLER2
XFILLER_25_375 VSS VDD FILLER2
XFILLER_111_65 VDD VSS FILLER4
XFILLER_41_835 VSS VDD FILLER2
XFILLER_40_312 VDD VSS FILLER4
X_09408_ _09414_/D _20047_/Q _09408_/C _18279_/Q VDD VSS _09409_/C NAND4BX1
XFILLER_40_323 VSS VDD FILLER2
X_10680_ _19947_/Q _18829_/Q VDD VSS _10681_/C AND2X1
XFILLER_158_509 VSS VDD FILLER2
XFILLER_111_98 VDD VSS FILLER1
XFILLER_9_508 VDD VSS FILLER4
XFILLER_71_47 VSS VDD FILLER2
XFILLER_138_200 VDD VSS FILLER1
X_09339_ _18444_/D _09338_/Y _09302_/A VDD VSS _18513_/D MUXI2X1
XFILLER_166_520 VSS VDD FILLER2
XFILLER_139_778 VSS VDD FILLER2
X_12350_ _18903_/Q VDD VSS _12429_/A INVX1
XFILLER_138_266 VSS VDD FILLER2
XFILLER_126_417 VDD VSS FILLER1
XFILLER_154_726 VDD VSS FILLER4
X_11301_ _11302_/A _11302_/B VDD VSS _11312_/B NAND2X1
XFILLER_126_439 VSS VDD FILLER2
X_12281_ _19043_/Q VDD VSS _12361_/A INVX1
XFILLER_119_480 VDD VSS FILLER1
XFILLER_107_631 VSS VDD FILLER2
XFILLER_5_747 VSS VDD FILLER2
XFILLER_4_235 VDD VSS FILLER4
XFILLER_153_258 VSS VDD FILLER2
X_14020_ _14020_/A _14135_/B _14020_/C _14020_/D VDD VSS _14058_/A OAOI211X1
X_11232_ _11180_/Y _11255_/B _10947_/Y VDD VSS _11278_/B MUXI2X1
XFILLER_20_51 VDD VSS FILLER1
XTAP_TAPCELL_ROW_115_1052 VDD VSS WELLTAP
XFILLER_20_62 VDD VSS FILLER4
X_11163_ _18681_/Q _18789_/Q _11163_/C _11163_/D VDD VSS _11169_/C AO211X2
XFILLER_161_291 VDD VSS FILLER4
X_10114_ _18588_/Q _10138_/B VDD VSS _10127_/B XOR2X1
XFILLER_96_44 VSS VDD FILLER2
XFILLER_121_144 VSS VDD FILLER2
X_15971_ _15971_/A _15990_/A VDD VSS _16803_/B XNOR2X1
X_11094_ _19960_/Q _18842_/Q VDD VSS _11096_/B XNOR2X1
XTAP_TAPCELL_ROW_78_716 VDD VSS WELLTAP
XFILLER_96_77 VSS VDD FILLER2
X_17710_ _17712_/C _17711_/B _17746_/C VDD VSS _17711_/C OAI21X1
X_14922_ _14966_/A _14966_/B VDD VSS _14928_/B NAND2X1
X_10045_ _10015_/Y _10044_/Y _10155_/A VDD VSS _10045_/Y MUXI2X1
XFILLER_96_99 VSS VDD FILLER2
X_18690_ _18773_/CK _18690_/D _18690_/Q VDD VSS DFFQX1
XFILLER_48_445 VSS VDD FILLER2
XFILLER_76_765 VSS VDD FILLER2
X_17641_ _17646_/C _17646_/B VDD VSS _17643_/B NAND2BX1
XFILLER_91_702 VSS VDD FILLER2
XFILLER_36_607 VDD VSS FILLER4
X_14853_ _14896_/B _14853_/B VDD VSS _18068_/B XNOR2X1
XFILLER_63_404 VSS VDD FILLER2
XFILLER_48_478 VDD VSS FILLER1
XFILLER_36_618 VSS VDD FILLER2
XFILLER_63_415 VDD VSS FILLER1
X_13804_ _14158_/A _17929_/B VDD VSS _18863_/D AND2X1
X_17572_ _19874_/Q _19842_/Q _17572_/C VDD VSS _17577_/C AO21X2
XFILLER_63_448 VDD VSS FILLER1
XFILLER_35_139 VSS VDD FILLER2
X_14784_ _19501_/Q _15894_/B VDD VSS _14826_/A NOR2BX1
XFILLER_91_768 VDD VSS FILLER1
XFILLER_63_459 VDD VSS FILLER4
X_11996_ _19234_/Q _11996_/B _12050_/D VDD VSS _12099_/C XOR3X1
XFILLER_44_640 VSS VDD FILLER2
X_19311_ _19314_/CK _19311_/D _19311_/Q VDD VSS DFFQX1
XFILLER_90_256 VDD VSS FILLER4
X_16523_ _19602_/Q _16753_/B _16523_/C VDD VSS _16548_/A OAI21X1
X_13735_ _19029_/Q _13735_/B VDD VSS _13736_/D _13735_/C NAND3X1
X_10947_ _10947_/A VDD VSS _10947_/Y BUFX3
XTAP_TAPCELL_ROW_33_307 VDD VSS WELLTAP
XFILLER_45_92 VDD VSS FILLER1
XFILLER_44_695 VSS VDD FILLER2
X_19242_ _19269_/CK _19242_/D _19242_/Q VDD VSS DFFQX1
X_16454_ _16454_/A _16474_/B VDD VSS _16786_/B XOR2X1
X_13666_ _14163_/A _17920_/B _17915_/B VDD VSS _18861_/D NOR3X1
X_10878_ _10808_/B _10877_/Y _10947_/A VDD VSS _10878_/Y MUXI2X1
X_15405_ _15405_/A _15433_/B VDD VSS _15849_/B XNOR2X1
XFILLER_129_200 VSS VDD FILLER2
X_19173_ _19200_/CK _19173_/D _19173_/Q VDD VSS DFFQX1
X_12617_ _12617_/A _12617_/B _14182_/B VDD VSS _12708_/B MIN3X1
X_16385_ wire155/Y _19725_/Q VDD VSS _16386_/C NOR2BX1
X_13597_ _14227_/B _13682_/C _18972_/Q VDD VSS _13675_/C AND3BX1
X_18124_ _19291_/Q _18128_/B VDD VSS _18126_/B XOR2X1
XTAP_TAPCELL_ROW_41_384 VDD VSS WELLTAP
X_15336_ _15689_/B VDD VSS _15337_/C INVX1
X_18211__257 _20052_/CK VDD VSS _18278_/CK INVX1
X_12548_ _12558_/A _14345_/B _12625_/C VDD VSS _14346_/C NOR3X1
XFILLER_61_91 VSS VDD FILLER2
XFILLER_129_266 VSS VDD FILLER2
XFILLER_8_563 VDD VSS FILLER4
XFILLER_129_277 VSS VDD FILLER2
X_18055_ _18548_/Q _18055_/B VDD VSS _18056_/B XOR2X1
XFILLER_6_31 VSS VDD FILLER2
X_15267_ _19485_/Q _15877_/B VDD VSS _15281_/A AND2X1
XANTENNA_2 _09575_/C VDD VSS ANTENNA2
X_12479_ _19156_/Q _14439_/B VDD VSS _12480_/D _14439_/C NAND3X1
X_17006_ _17006_/A _17006_/B VDD VSS _17019_/B AND2X1
X_14218_ _14218_/A _14218_/B VDD VSS _18967_/D NOR2X1
XFILLER_160_718 VDD VSS DECAPHV8
X_15198_ _15198_/A _15198_/B _15198_/C VDD VSS _15841_/C NOR3X1
XFILLER_99_835 VSS VDD FILLER2
XFILLER_98_323 VSS VDD FILLER2
XFILLER_112_111 VDD VSS FILLER4
XFILLER_125_494 VSS VDD FILLER2
X_14149_ _14154_/A _14149_/B VDD VSS _18905_/D NOR2X1
Xclkbuf_0__09182_ _18231_/ECK VDD VSS clkbuf_0__09182_/Y BUFX12
XFILLER_101_829 VSS VDD FILLER2
XFILLER_112_166 VSS VDD FILLER2
X_18957_ _18997_/CK _18957_/D _18957_/Q VDD VSS DFFQX1
XFILLER_100_317 VDD VSS DECAPHV8
XFILLER_100_328 VDD VSS FILLER4
XFILLER_67_721 VSS VDD FILLER2
XFILLER_140_497 VSS VDD FILLER2
X_17908_ _17906_/B _17911_/C _17908_/C VDD VSS _19949_/D AOI2B1X1
X_09690_ _18319_/Q _09769_/C _09690_/C _09690_/D VDD VSS _09693_/C AO211X2
X_18888_ _18915_/CK _18888_/D _18888_/Q VDD VSS DFFQX1
XFILLER_94_551 VDD VSS FILLER1
XFILLER_66_242 VSS VDD FILLER2
X_17839_ _19935_/Q _17842_/C _17917_/C VDD VSS _17840_/C OAI21X1
XTAP_TAPCELL_ROW_49_451 VDD VSS WELLTAP
XFILLER_94_573 VDD VSS FILLER4
XFILLER_66_264 VDD VSS FILLER4
XFILLER_39_489 VSS VDD FILLER2
XFILLER_35_640 VSS VDD FILLER2
X_19509_ _19536_/CK _19509_/D _19509_/Q VDD VSS DFFQX1
XFILLER_23_813 VSS VDD FILLER2
XFILLER_22_301 VSS VDD FILLER2
XFILLER_23_835 VSS VDD FILLER2
XFILLER_22_323 VSS VDD FILLER2
XFILLER_22_334 VSS VDD FILLER2
XFILLER_22_356 VSS VDD FILLER2
XFILLER_148_520 VDD VSS FILLER1
XFILLER_41_39 VDD VSS DECAPHV16
X_09978__249 _20054_/CK VDD VSS _18525_/CK INVX1
XFILLER_136_748 VSS VDD FILLER2
XFILLER_163_556 VSS VDD FILLER2
XFILLER_151_707 VSS VDD FILLER2
XFILLER_116_450 VDD VSS FILLER1
XFILLER_150_206 VDD VSS FILLER4
XFILLER_2_717 VSS VDD FILLER2
XFILLER_144_770 VSS VDD FILLER2
X_20215_ _20215_/A VDD VSS _20215_/Y BUFX3
XFILLER_116_494 VSS VDD FILLER2
XFILLER_103_122 VSS VDD FILLER2
XFILLER_89_345 VDD VSS FILLER4
XFILLER_104_678 VDD VSS FILLER1
XFILLER_131_464 VDD VSS FILLER1
X_20146_ _20146_/A VDD VSS _20146_/Y BUFX3
XFILLER_104_689 VDD VSS FILLER1
XFILLER_131_475 VDD VSS FILLER4
XFILLER_103_177 VDD VSS DECAPHV8
X_20077_ _20081_/CK _20077_/D _20077_/Q _20080_/RB VDD VSS DFFRQX1
X_09888_ _11435_/B _11196_/A VDD VSS _09928_/A NOR2X1
XFILLER_18_607 VSS VDD FILLER2
XFILLER_57_286 VSS VDD FILLER2
X_11850_ _19173_/Q VDD VSS _11852_/A INVX1
XFILLER_122_64 VDD VSS DECAPHV8
XFILLER_122_75 VSS VDD FILLER2
XFILLER_122_86 VDD VSS FILLER1
X_10801_ _10801_/A _10801_/B _10801_/C _10801_/D VDD VSS _10871_/B OAI211X1
XTAP_TAPCELL_ROW_83_763 VDD VSS WELLTAP
X_11781_ _19229_/Q _11781_/B _11804_/C VDD VSS _11828_/B XNOR3X1
XFILLER_13_301 VSS VDD FILLER2
Xclkbuf_1_0__f__09171_ clkbuf_0__09171_/Y VDD VSS _18343_/CK BUFX12
XFILLER_41_610 VSS VDD FILLER2
X_13520_ _19027_/Q VDD VSS _13599_/A INVX1
X_10732_ _10945_/A _10747_/A _10747_/B _10747_/C VDD VSS _10807_/B AND4X2
XFILLER_41_654 VSS VDD FILLER2
XFILLER_13_356 VDD VSS FILLER1
XFILLER_40_142 VSS VDD FILLER2
XFILLER_41_676 VSS VDD FILLER2
XFILLER_158_328 VSS VDD FILLER2
X_13451_ _13451_/A _14449_/B _13542_/C VDD VSS _14451_/C NOR3X1
XTAP_TAPCELL_ROW_158_1439 VDD VSS WELLTAP
X_10663_ _18561_/Q _10670_/B VDD VSS _10668_/A XOR2X1
X_12402_ _12402_/A _12402_/B _19238_/Q VDD VSS _12405_/C OAI21X1
X_16170_ _19717_/Q _16881_/B VDD VSS _16173_/B XNOR2X1
X_13382_ _18006_/C VDD VSS _15383_/A BUFX3
X_10594_ _10594_/A _10594_/B VDD VSS _10666_/A NOR2X1
X_15121_ _19370_/Q _15747_/B VDD VSS _15134_/B NOR2X1
X_12333_ _19127_/Q _12333_/B _12471_/D VDD VSS _12380_/C XNOR3X1
XFILLER_127_759 VDD VSS FILLER4
XTAP_TAPCELL_ROW_2_32 VDD VSS WELLTAP
X_15052_ _15052_/A _15052_/B _15108_/B _15052_/D VDD VSS _15872_/C AO22X2
X_12264_ _12278_/A _12278_/B _14246_/B VDD VSS _14209_/B XNOR3X1
XFILLER_107_461 VDD VSS FILLER4
XFILLER_135_792 VDD VSS FILLER4
X_14003_ _14013_/A _14004_/B _14004_/C VDD VSS _14233_/B OR3BX1
X_11215_ _11215_/A _11222_/B VDD VSS _11220_/B XNOR2X1
X_19860_ _19895_/CK _19860_/D _19860_/Q VDD VSS DFFQX1
X_12195_ _12197_/A _12197_/B _14145_/B VDD VSS _14113_/B XNOR3X1
Xoutput50 _20132_/Y VDD VSS o_bias_cfg[34] BUFX3
Xoutput61 _20145_/Y VDD VSS o_clk_cfg[12] BUFX3
XFILLER_150_762 VDD VSS FILLER1
XFILLER_96_816 VDD VSS FILLER1
X_18811_ _19954_/CK _18811_/D _18811_/Q VDD VSS DFFQX1
Xoutput72 _20138_/Y VDD VSS o_clk_cfg[5] BUFX3
XFILLER_122_464 VDD VSS FILLER4
Xoutput83 _20157_/Y VDD VSS o_en_ctrl[5] BUFX3
X_11146_ _18707_/Q _18761_/Q _11146_/C VDD VSS _11167_/B MIN3X1
XFILLER_110_615 VDD VSS FILLER4
Xoutput94 _20178_/Y VDD VSS o_lf_cfg[15] BUFX3
X_19791_ _19791_/CK _19791_/D _19791_/Q VDD VSS DFFQX1
XFILLER_96_838 VSS VDD FILLER2
XFILLER_122_486 VDD VSS DECAPHV8
XFILLER_49_721 VDD VSS FILLER4
XFILLER_0_282 VSS VDD FILLER2
X_15954_ _19644_/Q _16801_/B VDD VSS _15977_/B XOR2X1
X_18742_ _18795_/CK _18742_/D _18742_/Q VDD VSS DFFQX1
X_11077_ _11226_/A _11077_/B _11077_/C VDD VSS _11078_/D OAI21X1
XFILLER_95_348 VSS VDD FILLER2
XFILLER_48_220 VSS VDD FILLER2
XFILLER_48_231 VDD VSS FILLER1
X_14905_ _19421_/Q VDD VSS _14910_/A INVX1
X_10028_ _18580_/Q _10042_/C VDD VSS _10029_/B NAND2X1
XFILLER_48_253 VDD VSS FILLER4
X_18673_ _18810_/CK _18673_/D _18673_/Q VDD VSS DFFQX1
X_15885_ _16768_/A _15885_/B VDD VSS _19492_/D AND2X1
XFILLER_63_201 VSS VDD FILLER2
XFILLER_48_275 VDD VSS FILLER4
XFILLER_63_223 VSS VDD FILLER2
X_14836_ _14837_/A _14837_/B _14837_/C VDD VSS _14839_/B OAI21X1
X_17624_ _19886_/Q _19854_/Q VDD VSS _17627_/A XNOR2X1
XTAP_TAPCELL_ROW_124_1129 VDD VSS WELLTAP
XFILLER_91_554 VDD VSS FILLER4
XFILLER_91_565 VDD VSS FILLER1
X_17555_ _17675_/A _17555_/B VDD VSS _19871_/D NOR2X1
XFILLER_63_278 VDD VSS FILLER1
X_14767_ _15383_/A VDD VSS _15297_/A BUFX3
XFILLER_51_429 VSS VDD FILLER2
X_11979_ _11979_/A _14490_/B _11979_/C _11979_/D VDD VSS _11985_/A OAOI211X1
XTAP_TAPCELL_ROW_18_178 VDD VSS WELLTAP
XFILLER_17_695 VDD VSS FILLER1
XFILLER_16_172 VDD VSS FILLER1
X_16506_ _19666_/Q _16824_/B VDD VSS _16507_/B XOR2X1
XFILLER_32_632 VDD VSS FILLER1
X_13718_ _19142_/Q _14424_/B VDD VSS _13791_/B XNOR2X1
X_17486_ _17488_/A _17488_/B _17486_/C VDD VSS _19856_/D AOI21X1
XFILLER_31_120 VDD VSS FILLER1
X_14698_ _19416_/Q _14698_/B _14698_/C VDD VSS _14730_/B MIN3X1
XFILLER_32_676 VSS VDD FILLER2
X_16437_ _16437_/A _16437_/B _16437_/C VDD VSS _16438_/B OR3X2
X_19225_ _19988_/CK _19225_/D _19225_/Q VDD VSS DFFQX1
X_13649_ _19056_/Q _13649_/B VDD VSS _13733_/D _13649_/C NAND3X1
X_19156_ _19185_/CK _19156_/D _19156_/Q VDD VSS DFFQX1
X_16368_ _16368_/A _16368_/B VDD VSS _16369_/C NAND2X1
XFILLER_118_715 VSS VDD FILLER2
X_18107_ _19288_/Q _18107_/B VDD VSS _18112_/A NOR2X1
XFILLER_8_360 VSS VDD FILLER2
X_15319_ _19487_/Q _15879_/B VDD VSS _15364_/B XNOR2X1
XTAP_TAPCELL_ROW_135_1225 VDD VSS WELLTAP
XFILLER_157_383 VDD VSS FILLER4
X_19087_ _19115_/CK _19087_/D _19087_/Q VDD VSS DFFQX1
XFILLER_157_394 VSS VDD FILLER2
X_16299_ _16299_/A _16307_/B VDD VSS _16886_/B XNOR2X1
XFILLER_133_707 VSS VDD FILLER2
X_18038_ _18540_/Q _18038_/B VDD VSS _18039_/C NOR2X1
XFILLER_126_770 VSS VDD FILLER2
XFILLER_132_206 VDD VSS FILLER4
XFILLER_99_621 VSS VDD FILLER2
XFILLER_132_239 VDD VSS FILLER1
XFILLER_160_548 VDD VSS DECAPHV8
XFILLER_125_291 VDD VSS FILLER4
XFILLER_99_654 VSS VDD FILLER2
X_20000_ _20000_/CK _20000_/D _20000_/Q VDD VSS DFFQX1
XFILLER_98_142 VSS VDD FILLER2
X_09811_ _18439_/Q _09811_/B _09811_/C _18375_/Q _09811_/E VDD VSS _09817_/A AOI221X1
XFILLER_101_604 VSS VDD FILLER2
XFILLER_59_529 VDD VSS FILLER1
XFILLER_140_261 VDD VSS FILLER1
X_19989_ _19996_/CK _19989_/D _19989_/Q VDD VSS DFFQX1
XFILLER_100_114 VDD VSS FILLER4
Xclkbuf_0__09165_ _18214_/ECK VDD VSS clkbuf_0__09165_/Y BUFX12
XFILLER_101_648 VSS VDD FILLER2
X_09742_ _18450_/Q _09751_/B _09772_/B _18354_/Q VDD VSS _09744_/A OAI22X1
XFILLER_86_359 VDD VSS FILLER4
XFILLER_67_551 VDD VSS FILLER4
XTAP_TAPCELL_ROW_97_888 VDD VSS WELLTAP
X_09673_ _18446_/Q _09816_/B _09673_/C _18414_/Q VDD VSS _09674_/E OAI22X1
XFILLER_82_510 VDD VSS FILLER1
XFILLER_39_286 VSS VDD FILLER2
XFILLER_94_392 VDD VSS FILLER1
XFILLER_55_768 VSS VDD FILLER2
XFILLER_70_716 VDD VSS FILLER4
XFILLER_70_727 VSS VDD FILLER2
XFILLER_23_610 VDD VSS FILLER1
XTAP_TAPCELL_ROW_80_733 VDD VSS WELLTAP
XFILLER_63_790 VDD VSS DECAPHV8
XFILLER_22_120 VSS VDD FILLER2
XFILLER_23_654 VSS VDD FILLER2
XFILLER_22_142 VSS VDD FILLER2
XTAP_TAPCELL_ROW_52_479 VDD VSS WELLTAP
XFILLER_52_49 VDD VSS FILLER4
XFILLER_10_315 VSS VDD FILLER2
XFILLER_149_840 VSS VDD FILLER2
XFILLER_10_337 VSS VDD FILLER2
XFILLER_155_309 VSS VDD FILLER2
XFILLER_10_359 VSS VDD FILLER2
XFILLER_148_361 VDD VSS DECAPHV8
XFILLER_148_394 VDD VSS FILLER4
XFILLER_163_342 VSS VDD FILLER2
XFILLER_163_375 VSS VDD FILLER2
XFILLER_2_514 VSS VDD FILLER2
XFILLER_117_31 VDD VSS FILLER1
XFILLER_117_792 VSS VDD FILLER2
XFILLER_123_228 VSS VDD FILLER2
XTAP_TAPCELL_ROW_112_1022 VDD VSS WELLTAP
XFILLER_89_120 VDD VSS FILLER1
XFILLER_132_751 VDD VSS FILLER1
XFILLER_77_13 VSS VDD FILLER2
XFILLER_2_558 VSS VDD FILLER2
X_11000_ _18704_/Q _18758_/Q VDD VSS _11043_/B XOR2X1
XFILLER_104_464 VSS VDD FILLER2
XFILLER_77_304 VSS VDD FILLER2
XFILLER_78_838 VDD VSS FILLER1
X_20129_ _20129_/A VDD VSS _20129_/Y BUFX3
XFILLER_77_348 VDD VSS FILLER4
X_12951_ _12951_/A _12951_/B _12951_/C _12951_/D VDD VSS _14510_/C AOAI211X1
XFILLER_133_63 VSS VDD FILLER2
XFILLER_133_74 VDD VSS FILLER1
XFILLER_73_521 VDD VSS FILLER1
XFILLER_133_96 VDD VSS FILLER4
X_11902_ _19064_/Q _11959_/B _11953_/C VDD VSS _11907_/C XNOR3X1
XFILLER_85_392 VSS VDD FILLER2
X_15670_ _15703_/B VDD VSS _15671_/B INVX1
XFILLER_93_56 VSS VDD FILLER2
XFILLER_73_543 VDD VSS FILLER4
X_12882_ _18882_/Q VDD VSS _13077_/A INVX1
XTAP_TAPCELL_ROW_164_1487 VDD VSS WELLTAP
X_14621_ _15859_/A _15858_/A _15858_/B VDD VSS _14658_/A NOR3X1
XFILLER_165_0 VDD VSS FILLER4
X_11833_ _11876_/A _14524_/B VDD VSS _11979_/A NOR2X1
XTAP_TAPCELL_ROW_43_402 VDD VSS WELLTAP
XFILLER_73_598 VSS VDD FILLER2
XFILLER_45_289 VDD VSS FILLER4
X_17340_ _19825_/Q _19793_/Q VDD VSS _17346_/B NAND2X1
XFILLER_14_643 VSS VDD FILLER2
X_14552_ _19992_/Q _14558_/B VDD VSS _19256_/D AND2X1
X_11764_ _19200_/Q _11764_/B VDD VSS _11797_/C _11764_/C NAND3X1
XTAP_TAPCELL_ROW_15_148 VDD VSS WELLTAP
XFILLER_41_451 VSS VDD FILLER2
XFILLER_158_103 VDD VSS FILLER1
X_13503_ _13662_/A _13662_/B VDD VSS _13572_/B NOR2X1
XFILLER_41_462 VSS VDD FILLER2
X_17271_ _17536_/A _17271_/B _17272_/C VDD VSS _19810_/D NOR3X1
X_10715_ _10715_/A _10715_/B _10715_/C _10715_/D VDD VSS _10717_/C AO211X2
X_14483_ _14493_/A _14483_/B VDD VSS _19196_/D NOR2X1
X_11695_ _19989_/Q _19253_/Q VDD VSS _11716_/D XOR2X1
X_19010_ _19037_/CK _19010_/D _19010_/Q VDD VSS DFFQX1
X_16222_ _16222_/A _16222_/B _16222_/C VDD VSS _16225_/B OAI21X1
XFILLER_158_158 VSS VDD FILLER2
X_13434_ _19137_/Q _14417_/B VDD VSS _13616_/C _14417_/C AND3X2
X_10646_ _18694_/Q _18748_/Q VDD VSS _10729_/C XOR2X1
X_16153_ _16809_/B _19652_/Q VDD VSS _16154_/C NOR2BX1
X_13365_ _13365_/A _13365_/B _13365_/C _13365_/D VDD VSS _14355_/B OAI211X1
X_10577_ _10642_/B _10577_/B _10721_/D VDD VSS _10578_/D OR3BX1
XFILLER_6_842 VSS VDD FILLER2
XFILLER_166_191 VDD VSS FILLER1
XFILLER_127_556 VSS VDD FILLER2
X_15104_ _19509_/Q _15104_/B VDD VSS _15191_/D NAND2X1
XFILLER_127_578 VDD VSS FILLER1
X_12316_ _12407_/A _14531_/B VDD VSS _14532_/A _12397_/C NAND3X1
XFILLER_154_364 VSS VDD FILLER2
X_16084_ _19585_/Q VDD VSS _16085_/A INVX1
X_13296_ _13402_/A _13391_/B VDD VSS _14191_/B XNOR2X1
XFILLER_154_397 VSS VDD FILLER2
X_15035_ _19312_/Q VDD VSS _15036_/A INVX1
X_19912_ clkload8/A _19912_/D _19912_/Q VDD VSS DFFQX1
X_12247_ _12372_/A _12372_/C _12372_/B VDD VSS _14404_/C AO21X2
XFILLER_47_6 VSS VDD FILLER2
XFILLER_96_602 VSS VDD FILLER2
XFILLER_122_250 VSS VDD FILLER2
XFILLER_123_773 VDD VSS FILLER4
X_19843_ _19880_/CK _19843_/D _19843_/Q VDD VSS DFFQX1
XFILLER_69_827 VDD VSS FILLER1
X_12178_ _19152_/Q VDD VSS _12181_/D INVX1
X_11129_ _11364_/B _11159_/A VDD VSS _11154_/A NAND2X1
X_19774_ _19841_/CK _19774_/D _19774_/Q VDD VSS DFFQX1
XFILLER_95_145 VSS VDD FILLER2
X_16986_ _16996_/A _16996_/D VDD VSS _16991_/C NAND2X1
XFILLER_110_467 VDD VSS DECAPHV8
XFILLER_3_98 VDD VSS FILLER1
X_18725_ _19943_/CK _18725_/D _18725_/Q VDD VSS DFFQX1
X_15937_ _19580_/Q _16729_/B _15937_/C VDD VSS _15960_/A OAI21X1
XFILLER_95_189 VDD VSS FILLER4
XFILLER_64_521 VDD VSS DECAPHV8
XTAP_TAPCELL_ROW_94_858 VDD VSS WELLTAP
X_15868_ _17010_/A _15868_/B _15868_/C VDD VSS _19477_/D NOR3X1
X_18656_ _18845_/CK _18656_/D _18656_/Q VDD VSS DFFQX1
XFILLER_64_554 VDD VSS FILLER4
XFILLER_91_351 VDD VSS FILLER4
XFILLER_64_565 VDD VSS FILLER4
XFILLER_64_576 VSS VDD FILLER2
X_14819_ _19475_/Q _15866_/B VDD VSS _14865_/D NAND2X1
X_17607_ _17610_/A _17610_/B _17654_/C VDD VSS _17608_/C OAI21X1
XFILLER_64_587 VDD VSS FILLER1
X_15799_ _15800_/A _15799_/B VDD VSS _19417_/D NOR2X1
X_18587_ _18595_/CK _18587_/D _18587_/Q VDD VSS DFFQX1
X_17538_ _19868_/Q _19836_/Q VDD VSS _17539_/B XOR2X1
XFILLER_51_259 VSS VDD FILLER2
XTAP_TAPCELL_ROW_141_1284 VDD VSS WELLTAP
XFILLER_32_462 VSS VDD FILLER2
X_17469_ _17470_/C _17469_/B _17469_/C VDD VSS _19852_/D AND3BX1
XFILLER_60_793 VSS VDD FILLER2
XFILLER_80_0 VSS VDD FILLER2
XFILLER_149_169 VSS VDD FILLER2
X_19208_ _20004_/CK _19208_/D _19208_/Q VDD VSS DFFQX1
X_19139_ _19139_/CK _19139_/D _19139_/Q VDD VSS DFFQX1
XFILLER_118_556 VSS VDD FILLER2
XFILLER_145_342 VDD VSS FILLER4
XFILLER_145_375 VDD VSS DECAPHV8
XFILLER_161_835 VSS VDD FILLER2
XFILLER_160_323 VSS VDD FILLER2
XTAP_TAPCELL_ROW_152_1380 VDD VSS WELLTAP
XFILLER_160_356 VSS VDD FILLER2
XFILLER_160_389 VSS VDD FILLER2
XFILLER_101_412 VSS VDD FILLER2
XFILLER_59_348 VDD VSS FILLER1
XFILLER_86_167 VSS VDD FILLER2
X_09725_ _18449_/Q _09751_/B _09725_/C _09725_/D VDD VSS _09730_/B OAI211X1
XTAP_TAPCELL_ROW_57_527 VDD VSS WELLTAP
XFILLER_67_370 VSS VDD FILLER2
XFILLER_55_510 VDD VSS FILLER4
XFILLER_27_201 VDD VSS FILLER1
XFILLER_55_521 VDD VSS DECAPHV8
XFILLER_28_735 VSS VDD FILLER2
XFILLER_27_223 VSS VDD FILLER2
XFILLER_67_392 VSS VDD FILLER2
X_09656_ _18349_/Q wire176/A VDD VSS _09657_/E NOR2X1
XFILLER_103_44 VSS VDD FILLER2
XFILLER_55_565 VSS VDD FILLER2
XFILLER_15_407 VSS VDD FILLER2
XFILLER_103_77 VSS VDD FILLER2
X_09587_ _20102_/A _20118_/A _09729_/D VDD VSS _09601_/B MUXI2X1
XFILLER_70_535 VSS VDD FILLER2
XFILLER_70_579 VSS VDD FILLER2
XFILLER_23_451 VDD VSS FILLER4
XFILLER_51_771 VDD VSS FILLER1
XTAP_TAPCELL_ROW_12_118 VDD VSS WELLTAP
XFILLER_50_281 VSS VDD FILLER2
XFILLER_156_607 VDD VSS DECAPHV8
X_10500_ _10512_/A _10500_/B _10500_/C _10511_/A VDD VSS _10501_/D OAOI211X1
XTAP_TAPCELL_ROW_155_1409 VDD VSS WELLTAP
XFILLER_7_606 VDD VSS FILLER1
XFILLER_137_810 VSS VDD FILLER2
X_11480_ _18636_/Q _11484_/B VDD VSS _18663_/D AND2X1
X_10431_ _10431_/A _10431_/B _10431_/C _11273_/A VDD VSS _10432_/B AOI31X1
XFILLER_136_342 VDD VSS FILLER4
X_13150_ _13150_/A _13150_/B _13150_/C _13150_/D VDD VSS _13152_/C AOAI211X1
XTAP_TAPCELL_ROW_20_195 VDD VSS WELLTAP
X_10362_ _10417_/A _10417_/B _10417_/C _10362_/D VDD VSS _10363_/D AOI31X1
XFILLER_88_12 VSS VDD FILLER2
XFILLER_136_386 VSS VDD FILLER2
XFILLER_3_823 VDD VSS FILLER1
XFILLER_164_695 VSS VDD FILLER2
X_12101_ _12101_/A _12108_/C _12101_/C VDD VSS _12158_/B XNOR3X1
XFILLER_88_34 VSS VDD FILLER2
XFILLER_3_834 VSS VDD FILLER2
X_13081_ _18883_/Q _13081_/B _13081_/C VDD VSS _13287_/B MIN3X1
X_10293_ _10343_/A _10343_/B VDD VSS _10294_/C XNOR2X1
XFILLER_78_602 VSS VDD FILLER2
X_12032_ _12113_/A _12032_/B VDD VSS _14464_/B XNOR2X1
XFILLER_151_389 VDD VSS FILLER4
XFILLER_144_51 VDD VSS FILLER1
XTAP_TAPCELL_ROW_166_1505 VDD VSS WELLTAP
XTAP_TAPCELL_ROW_166_1516 VDD VSS WELLTAP
XFILLER_120_754 VDD VSS DECAPHV8
X_16840_ _16865_/A _16840_/B VDD VSS _19680_/D NOR2X1
XFILLER_77_134 VDD VSS FILLER4
XFILLER_144_84 VSS VDD FILLER2
XFILLER_77_156 VDD VSS FILLER1
X_16771_ _16795_/A VDD VSS _16793_/A BUFX3
XFILLER_65_318 VSS VDD FILLER2
X_13983_ _14019_/A _13983_/B _13983_/C VDD VSS _13995_/C XNOR3X1
XFILLER_77_189 VDD VSS FILLER4
XFILLER_93_649 VSS VDD FILLER2
XFILLER_58_381 VDD VSS FILLER4
X_15722_ _15725_/A _15722_/B VDD VSS _19348_/D AND2X1
X_18510_ _18510_/CK _18510_/D _18510_/Q _09346_/Y VDD VSS DFFRQX1
XFILLER_58_392 VDD VSS FILLER4
X_12934_ _12940_/A _12940_/C _12940_/B VDD VSS _14444_/C AOI21X1
XFILLER_74_852 VSS VDD FILLER2
XFILLER_46_543 VDD VSS FILLER1
X_19490_ _19736_/CK _19490_/D _19490_/Q VDD VSS DFFQX1
XTAP_TAPCELL_ROW_91_828 VDD VSS WELLTAP
X_15653_ _15653_/A VDD VSS _15763_/B INVX1
X_18441_ _18454_/CK _18441_/D _18441_/Q _18442_/RB VDD VSS DFFRQX1
X_12865_ _19049_/Q _12865_/B _12916_/C VDD VSS _13005_/B XNOR3X1
XTAP_TAPCELL_ROW_28_262 VDD VSS WELLTAP
XTAP_TAPCELL_ROW_8_86 VDD VSS WELLTAP
X_14604_ _19520_/Q _19519_/Q _19521_/Q _19522_/Q VDD VSS _14649_/C AND4X2
X_18372_ _18375_/CK _18372_/D _18372_/Q _18491_/RB VDD VSS DFFRQX1
X_11816_ _19090_/Q _11816_/B _11816_/C VDD VSS _11943_/B MIN3X1
X_15584_ _15584_/A _15595_/B VDD VSS _15729_/B XNOR2X1
XFILLER_159_401 VSS VDD FILLER2
X_12796_ _18964_/Q _12796_/B _14215_/B VDD VSS _12891_/A MIN3X1
X_17323_ _17325_/C _17323_/B _17323_/C VDD VSS _19821_/D AOI21X1
XFILLER_14_473 VDD VSS FILLER4
X_14535_ _15806_/A _14535_/B _14535_/C VDD VSS _19241_/D NOR3X1
XFILLER_42_782 VSS VDD FILLER2
X_11747_ _11769_/A _11769_/B _11769_/C VDD VSS _11749_/B AOI21X1
XFILLER_53_81 VSS VDD FILLER2
XFILLER_159_445 VSS VDD FILLER2
XFILLER_53_92 VDD VSS FILLER1
XFILLER_42_793 VDD VSS DECAPHV8
XFILLER_147_618 VSS VDD FILLER2
X_17254_ _19807_/Q _19775_/Q VDD VSS _17255_/B XOR2X1
XFILLER_159_478 VDD VSS FILLER4
X_14466_ _14421_/Y _14466_/B _14466_/C VDD VSS _19180_/D AND3BX1
X_11678_ _18815_/Q _14547_/B VDD VSS _18842_/D AND2X1
XFILLER_128_832 VSS VDD FILLER2
XFILLER_146_128 VSS VDD FILLER2
X_16205_ _19622_/Q _16205_/B _16775_/B VDD VSS _16230_/A MIN3X1
X_13417_ _19082_/Q VDD VSS _13427_/A INVX1
X_17185_ _19791_/Q _19759_/Q _17185_/C VDD VSS _17189_/B MIN3X1
X_10629_ _11431_/A _10629_/B VDD VSS _18560_/D AND2X1
X_14397_ _14426_/A _14397_/B VDD VSS _19118_/D NOR2X1
X_16136_ _19907_/Q VDD VSS _16701_/A INVX1
XFILLER_6_650 VDD VSS FILLER1
X_13348_ _20013_/Q _19277_/Q _14544_/A VDD VSS _14545_/B AOI21X1
XFILLER_127_375 VDD VSS DECAPHV16
XFILLER_143_835 VSS VDD FILLER2
X_16067_ _19617_/Q _16769_/B VDD VSS _16083_/B XNOR2X1
X_13279_ _18941_/Q _13391_/A _13391_/B VDD VSS _13290_/C XNOR3X1
XTAP_TAPCELL_ROW_99_906 VDD VSS WELLTAP
XFILLER_130_507 VDD VSS FILLER4
XFILLER_142_367 VDD VSS DECAPHV8
X_15018_ _19506_/Q _15018_/B VDD VSS _15056_/B NOR2X1
XFILLER_69_613 VSS VDD FILLER2
XFILLER_111_710 VDD VSS FILLER4
XFILLER_142_389 VDD VSS FILLER4
XFILLER_111_721 VSS VDD FILLER2
XFILLER_96_421 VSS VDD FILLER2
X_19826_ _19841_/CK _19826_/D _19826_/Q VDD VSS DFFQX1
XFILLER_110_242 VDD VSS FILLER4
XFILLER_96_487 VSS VDD FILLER2
XFILLER_56_318 VDD VSS FILLER4
X_19757_ _19791_/CK _19757_/D _19757_/Q VDD VSS DFFQX1
X_16969_ _16971_/B _16969_/B VDD VSS _16970_/B XOR2X1
XFILLER_49_370 VSS VDD FILLER2
X_09510_ _20071_/Q _20070_/Q _09510_/C VDD VSS _20071_/D AOI21X1
XTAP_TAPCELL_ROW_143_1302 VDD VSS WELLTAP
X_18708_ _18818_/CK _18708_/D _18708_/Q VDD VSS DFFQX1
X_19688_ _19695_/CK _19688_/D _19688_/Q VDD VSS DFFQX1
X_09441_ _09447_/B _09772_/B VDD VSS _18218_/E NOR2X1
XFILLER_25_727 VSS VDD FILLER2
X_18639_ _19946_/CK _18639_/D _18639_/Q VDD VSS DFFQX1
XFILLER_64_384 VDD VSS FILLER4
X_09372_ _09770_/B _09426_/A VDD VSS _09482_/C NOR2BX1
XTAP_TAPCELL_ROW_62_574 VDD VSS WELLTAP
XFILLER_20_421 VSS VDD FILLER2
XFILLER_138_607 VSS VDD FILLER2
XFILLER_20_443 VDD VSS FILLER4
XFILLER_119_810 VDD VSS FILLER1
XFILLER_165_448 VSS VDD FILLER2
XFILLER_118_320 VDD VSS FILLER4
XFILLER_20_498 VSS VDD FILLER2
XFILLER_146_662 VSS VDD FILLER2
XFILLER_134_824 VDD VSS FILLER4
XFILLER_165_28 VDD VSS FILLER1
XFILLER_134_835 VDD VSS FILLER4
XFILLER_146_695 VSS VDD FILLER2
XFILLER_133_323 VDD VSS FILLER1
XFILLER_161_654 VSS VDD FILLER2
XFILLER_160_131 VSS VDD FILLER2
XFILLER_160_142 VSS VDD FILLER2
XFILLER_0_804 VDD VSS FILLER4
XFILLER_160_164 VSS VDD FILLER2
XFILLER_0_826 VSS VDD FILLER2
XFILLER_114_570 VDD VSS FILLER1
XFILLER_58_37 VSS VDD FILLER2
XFILLER_102_732 VDD VSS DECAPHV8
XFILLER_114_592 VSS VDD FILLER2
XFILLER_87_432 VDD VSS FILLER1
XFILLER_59_134 VDD VSS FILLER1
XFILLER_102_765 VDD VSS FILLER1
XFILLER_101_242 VSS VDD FILLER2
XFILLER_75_616 VDD VSS FILLER1
XFILLER_74_115 VDD VSS FILLER4
XFILLER_59_189 VSS VDD FILLER2
XFILLER_28_510 VDD VSS FILLER1
XFILLER_75_649 VSS VDD FILLER2
XFILLER_28_521 VDD VSS DECAPHV8
XFILLER_74_137 VSS VDD FILLER2
X_09708_ _18464_/Q _09784_/B _09769_/C _20090_/A _09708_/E VDD VSS _09717_/B AOI221X1
XFILLER_74_25 VSS VDD FILLER2
XFILLER_114_98 VDD VSS FILLER4
X_10980_ _11001_/C _10980_/B VDD VSS _10981_/C XNOR2X1
XFILLER_71_800 VDD VSS FILLER1
XFILLER_83_671 VSS VDD FILLER2
X_09639_ _20086_/A _09815_/C VDD VSS _09641_/C NAND2X1
XFILLER_15_215 VSS VDD FILLER2
XFILLER_71_844 VDD VSS FILLER1
XFILLER_43_535 VDD VSS FILLER1
XFILLER_130_42 VDD VSS FILLER4
X_12650_ _12771_/A _12771_/B VDD VSS _14442_/B XNOR2X1
XFILLER_70_354 VSS VDD FILLER2
XFILLER_90_24 VSS VDD FILLER2
X_11601_ _11648_/A VDD VSS _11612_/B BUFX3
XFILLER_130_97 VDD VSS FILLER1
XFILLER_11_410 VSS VDD FILLER2
X_12581_ _12837_/A _12837_/B _12837_/D VDD VSS _12648_/B AOI21X1
XFILLER_24_793 VDD VSS FILLER4
XFILLER_90_57 VSS VDD FILLER2
X_14320_ _14352_/A _14320_/B _14320_/C VDD VSS _19050_/D NOR3X1
XFILLER_90_79 VSS VDD FILLER2
X_11532_ _16860_/A VDD VSS _11542_/B BUFX3
XFILLER_156_404 VDD VSS DECAPHV8
XFILLER_156_437 VDD VSS FILLER4
XFILLER_11_476 VDD VSS FILLER1
XFILLER_128_0 VSS VDD FILLER2
X_14251_ _14251_/A _14251_/B VDD VSS _18991_/D NOR2X1
X_11463_ _19955_/Q _11473_/B VDD VSS _18648_/D AND2X1
XFILLER_139_84 VSS VDD FILLER2
XFILLER_109_353 VSS VDD FILLER2
X_13202_ _18996_/Q _13373_/A _13373_/B VDD VSS _13203_/D XNOR3X1
X_10414_ _10460_/A _10460_/B _10875_/C VDD VSS _10414_/Y OAI21X1
XFILLER_109_375 VSS VDD FILLER2
XFILLER_124_301 VSS VDD FILLER2
XFILLER_137_684 VSS VDD FILLER2
X_14182_ _14186_/A _14182_/B VDD VSS _18934_/D NOR2X1
XFILLER_125_835 VSS VDD FILLER2
X_11394_ _09932_/B _18596_/Q VDD VSS _11395_/C NOR2BX1
XTAP_TAPCELL_ROW_118_1072 VDD VSS WELLTAP
XFILLER_152_621 VDD VSS DECAPHV8
XFILLER_124_323 VSS VDD FILLER2
XFILLER_164_492 VDD VSS FILLER1
X_13133_ _13133_/A _13133_/B _13133_/C VDD VSS _14511_/C AOI21X1
X_10345_ _10345_/A _10345_/B VDD VSS _10359_/B _10345_/C _10345_/D OR4X1
X_18990_ _19025_/CK _18990_/D _18990_/Q VDD VSS DFFQX1
XFILLER_3_675 VSS VDD FILLER2
X_17941_ _17941_/A _17941_/B _17941_/C _17941_/D VDD VSS _17946_/A OAOI211X1
X_13064_ _19163_/Q _13122_/B _13138_/C VDD VSS _13315_/B XNOR3X1
X_10276_ _10272_/Y _10312_/B _11431_/A VDD VSS _18551_/D AND3BX1
XFILLER_78_410 VSS VDD FILLER2
XFILLER_78_421 VDD VSS FILLER4
X_12015_ _12015_/A _12015_/B _14305_/B VDD VSS _12016_/B MIN3X1
X_17872_ _17876_/C _17872_/B VDD VSS _17874_/B NOR2BX1
XFILLER_78_476 VDD VSS FILLER4
XFILLER_38_307 VSS VDD FILLER2
X_19611_ _19702_/CK _19611_/D _19611_/Q VDD VSS DFFQX1
XFILLER_38_318 VDD VSS FILLER1
X_16823_ _16826_/A _16823_/B VDD VSS _19665_/D NOR2X1
XFILLER_48_70 VSS VDD FILLER2
XFILLER_66_649 VDD VSS FILLER4
XFILLER_65_126 VSS VDD FILLER2
X_19542_ _19736_/CK _19542_/D _19542_/Q VDD VSS DFFQX1
XFILLER_93_457 VSS VDD FILLER2
X_16754_ _16759_/A _16754_/B VDD VSS _19603_/D NOR2X1
X_13966_ _19033_/Q _14301_/A _14301_/B VDD VSS _14010_/B AND3BX1
XFILLER_93_468 VDD VSS FILLER4
XFILLER_0_66 VSS VDD FILLER2
X_15705_ _15710_/A _15705_/B VDD VSS _19333_/D NOR2X1
X_12917_ _19049_/Q _14319_/B _14319_/C VDD VSS _13005_/D NOR3BX1
X_16685_ _16685_/A _16685_/B VDD VSS _16868_/B XNOR2X1
X_19473_ _19528_/CK _19473_/D _19473_/Q VDD VSS DFFQX1
XTAP_TAPCELL_ROW_76_699 VDD VSS WELLTAP
X_13897_ _13903_/A _13903_/B _13951_/C VDD VSS _14266_/C NOR3X1
XFILLER_73_170 VDD VSS FILLER4
XFILLER_61_310 VSS VDD FILLER2
XFILLER_0_88 VSS VDD FILLER2
X_18424_ _18437_/CK _18424_/D _18424_/Q _20078_/RB VDD VSS DFFRQX1
X_15636_ _19356_/Q _15731_/B VDD VSS _15637_/C NOR2BX1
X_12848_ _12951_/A _12951_/B _12951_/C VDD VSS _12854_/B AOI21X1
XFILLER_34_579 VSS VDD FILLER2
XFILLER_21_207 VDD VSS FILLER4
XFILLER_21_218 VDD VSS FILLER4
XFILLER_159_220 VDD VSS DECAPHV8
X_15567_ _19381_/Q _15758_/B VDD VSS _15568_/C NOR2BX1
X_18355_ _18357_/CK _18499_/D _20223_/A _18498_/RB VDD VSS DFFRQX1
X_12779_ _12801_/A _12801_/B _12801_/C VDD VSS _12779_/Y AOI21X1
X_17306_ _17309_/A _17309_/B _17306_/C VDD VSS _17307_/C OAI21X1
X_14518_ _14539_/A _14518_/B VDD VSS _19225_/D NOR2X1
XFILLER_30_752 VSS VDD FILLER2
X_15498_ _15498_/A _15498_/B _15693_/B VDD VSS _15502_/C MIN3X1
X_18286_ _18288_/CK _18286_/D _18286_/Q VDD VSS DFFQX1
XFILLER_30_785 VDD VSS FILLER4
XFILLER_147_459 VDD VSS FILLER4
X_17237_ _17536_/A _17237_/B _17238_/C VDD VSS _19803_/D NOR3X1
X_14449_ _14449_/A _14449_/B _14449_/C VDD VSS _19165_/D NOR3X1
XFILLER_116_802 VSS VDD FILLER2
XFILLER_162_407 VDD VSS FILLER4
X_17168_ _17168_/A _17168_/B _17168_/C _17168_/D VDD VSS _17169_/C AOAI211X1
XFILLER_143_610 VDD VSS FILLER1
XFILLER_143_621 VDD VSS FILLER4
XFILLER_143_632 VSS VDD FILLER2
X_16119_ _19651_/Q _16808_/B VDD VSS _16131_/B XOR2X1
XFILLER_142_120 VDD VSS FILLER1
XFILLER_143_654 VSS VDD FILLER2
X_17099_ _19774_/Q _19742_/Q VDD VSS _17100_/B XOR2X1
X_09990_ _10034_/A _09990_/B _09990_/C VDD VSS _09993_/B OAI21X1
XFILLER_131_805 VDD VSS FILLER1
XFILLER_142_142 VSS VDD FILLER2
XFILLER_131_816 VSS VDD FILLER2
XFILLER_43_0 VSS VDD FILLER2
XFILLER_103_518 VDD VSS DECAPHV8
XFILLER_131_849 VSS VDD FILLER2
XFILLER_142_175 VSS VDD FILLER2
XFILLER_130_337 VDD VSS DECAPHV8
XFILLER_69_454 VDD VSS DECAPHV8
XFILLER_96_262 VDD VSS FILLER1
XFILLER_84_402 VDD VSS FILLER4
X_19809_ _19841_/CK _19809_/D _19809_/Q VDD VSS DFFQX1
XFILLER_56_104 VSS VDD FILLER2
XFILLER_28_29 VDD VSS FILLER4
XFILLER_111_584 VSS VDD FILLER2
XFILLER_38_852 VSS VDD FILLER2
XFILLER_56_159 VDD VSS FILLER4
XTAP_TAPCELL_ROW_39_368 VDD VSS WELLTAP
XFILLER_53_800 VSS VDD FILLER2
XFILLER_52_332 VSS VDD FILLER2
X_09424_ _09626_/C VDD VSS _09819_/A BUFX3
XFILLER_25_557 VDD VSS FILLER1
XFILLER_13_708 VDD VSS FILLER1
XFILLER_80_652 VSS VDD FILLER2
XFILLER_25_579 VSS VDD FILLER2
XFILLER_100_23 VDD VSS FILLER4
X_09355_ _09753_/A input2/Y _09354_/Y VDD VSS _18508_/D MUX2X1
XTAP_TAPCELL_ROW_22_213 VDD VSS WELLTAP
XFILLER_33_590 VDD VSS DECAPHV8
XFILLER_100_45 VDD VSS FILLER1
XFILLER_21_741 VSS VDD FILLER2
XFILLER_166_713 VDD VSS FILLER4
X_09286_ _09256_/C _20046_/Q _18258_/Q VDD VSS _09301_/B NOR3BX1
XFILLER_60_27 VDD VSS FILLER1
XFILLER_21_763 VSS VDD FILLER2
XFILLER_138_426 VSS VDD FILLER2
XFILLER_60_49 VSS VDD FILLER2
XFILLER_138_459 VSS VDD FILLER2
XFILLER_166_768 VDD VSS FILLER4
XFILLER_153_407 VSS VDD FILLER2
XFILLER_107_824 VDD VSS FILLER4
XFILLER_4_417 VDD VSS FILLER1
XFILLER_107_835 VSS VDD FILLER2
XFILLER_106_323 VSS VDD FILLER2
XFILLER_146_492 VSS VDD FILLER2
XFILLER_122_816 VSS VDD FILLER2
XFILLER_133_142 VDD VSS FILLER1
XFILLER_161_462 VSS VDD FILLER2
X_10130_ _10166_/D _10130_/B _10130_/C VDD VSS _10130_/Y AOI21X1
XFILLER_0_623 VDD VSS FILLER4
XFILLER_0_645 VDD VSS FILLER4
X_10061_ _18605_/Q _10062_/B VDD VSS _10075_/D NAND2BX1
XFILLER_0_656 VSS VDD FILLER2
XFILLER_85_13 VSS VDD FILLER2
XFILLER_0_678 VSS VDD FILLER2
XFILLER_48_638 VDD VSS FILLER4
XFILLER_85_46 VSS VDD FILLER2
XFILLER_47_126 VSS VDD FILLER2
XFILLER_75_446 VDD VSS DECAPHV8
X_13820_ _18919_/Q _14166_/B _14166_/C VDD VSS _13821_/D OR3BX1
XFILLER_47_148 VDD VSS FILLER4
XFILLER_75_468 VSS VDD FILLER2
XFILLER_18_62 VSS VDD FILLER2
XFILLER_90_416 VSS VDD FILLER2
XFILLER_141_52 VSS VDD FILLER2
X_13751_ _13751_/A _13751_/B _13751_/C _13751_/D VDD VSS _14131_/C OAI211X1
XFILLER_18_84 VSS VDD FILLER2
X_10963_ _18649_/Q _18811_/Q VDD VSS _10964_/B XOR2X1
XFILLER_62_129 VDD VSS FILLER1
XFILLER_141_85 VSS VDD FILLER2
XFILLER_141_96 VSS VDD FILLER2
X_12702_ _17861_/A _17862_/A _14118_/B VDD VSS _12703_/B MIN3X1
X_16470_ _19664_/Q _16822_/B _16470_/C VDD VSS _16494_/A OAI21X1
XTAP_TAPCELL_ROW_73_669 VDD VSS WELLTAP
X_13682_ _18972_/Q _13682_/B VDD VSS _13688_/C _13682_/C NAND3X1
X_10894_ _10931_/A _10895_/B VDD VSS _10895_/C NOR2X1
XFILLER_16_579 VSS VDD FILLER2
XFILLER_70_151 VSS VDD FILLER2
X_15421_ _19321_/Q _15692_/B VDD VSS _15422_/C AND2X1
X_12633_ _19101_/Q _14378_/B _14378_/C VDD VSS _12634_/D OR3BX1
XFILLER_12_752 VSS VDD FILLER2
X_15352_ _19487_/Q _15879_/B VDD VSS _15364_/D NAND2X1
X_18140_ _19294_/Q _18143_/B VDD VSS _18141_/B XOR2X1
XTAP_TAPCELL_ROW_5_54 VDD VSS WELLTAP
X_12564_ _12643_/A _12643_/B _12643_/C VDD VSS _12591_/B AOI21X1
XFILLER_157_724 VSS VDD FILLER2
XFILLER_11_251 VDD VSS FILLER4
X_14303_ _14334_/A _14303_/B VDD VSS _19035_/D AND2X1
XFILLER_156_223 VSS VDD FILLER2
X_18071_ _18074_/A _18074_/B VDD VSS _18072_/B XNOR2X1
X_11515_ _18668_/Q _11519_/B VDD VSS _18695_/D AND2X1
XFILLER_11_284 VDD VSS FILLER1
X_15283_ _19458_/Q _15306_/B VDD VSS _15285_/A XNOR2X1
X_12495_ _12499_/A _12499_/B _12499_/C _12495_/D VDD VSS _14534_/B OAOI211X1
Xwire153 wire153/A VDD VSS wire153/Y BUFX4
X_17022_ _17024_/B _17022_/B VDD VSS _17030_/A NAND2BX1
Xwire164 wire165/Y VDD VSS wire164/Y BUFX6
X_14234_ _15383_/A VDD VSS _14270_/A BUFX3
X_11446_ _19941_/Q _17990_/A VDD VSS _18634_/D AND2X1
XFILLER_7_277 VSS VDD FILLER2
XFILLER_166_60 VSS VDD FILLER2
XFILLER_124_120 VDD VSS FILLER1
XFILLER_125_654 VDD VSS FILLER4
X_14165_ _17812_/A VDD VSS _14219_/A BUFX3
XFILLER_166_82 VDD VSS DECAPHV8
X_11377_ _11381_/B _11377_/B VDD VSS _11378_/C NOR2BX1
XFILLER_166_93 VDD VSS DECAPHV16
XFILLER_124_142 VDD VSS FILLER4
XFILLER_152_462 VSS VDD FILLER2
X_13116_ _13161_/A _13161_/B _13161_/C _13116_/D VDD VSS _13364_/A AOAI211X1
X_10328_ _10329_/A _10329_/B _10329_/D _10329_/C VDD VSS _10328_/Y AOI211X1
XFILLER_113_849 VSS VDD FILLER2
X_18973_ _18973_/CK _18973_/D _18973_/Q VDD VSS DFFQX1
X_14096_ _14096_/A _14104_/B VDD VSS _14141_/B XOR2X1
X_17924_ _18863_/Q _17924_/B _17924_/C VDD VSS _17927_/D XNOR3X1
X_13047_ _13054_/A _13054_/B _13047_/C _13054_/D VDD VSS _14540_/A OAI211X1
X_10259_ _11438_/A _11435_/B _11435_/A VDD VSS _10330_/B AND3BX1
XFILLER_94_700 VSS VDD FILLER2
XFILLER_59_91 VSS VDD FILLER2
XFILLER_22_5 VSS VDD FILLER2
XFILLER_39_627 VDD VSS FILLER1
XFILLER_79_796 VSS VDD FILLER2
X_17855_ _17868_/C _17855_/B VDD VSS _17857_/C NOR2BX1
XFILLER_93_221 VDD VSS FILLER4
XFILLER_66_446 VDD VSS FILLER4
XFILLER_15_4 VSS VDD FILLER2
X_16806_ _16811_/A _16806_/B VDD VSS _19649_/D NOR2X1
XFILLER_93_243 VSS VDD FILLER2
X_17786_ _19921_/Q _19889_/Q VDD VSS _17793_/C NOR2X1
XFILLER_94_788 VSS VDD FILLER2
X_14998_ _19424_/Q VDD VSS _15044_/A INVX1
X_19525_ _19536_/CK _19525_/D _19525_/Q VDD VSS DFFQX1
XFILLER_75_90 VSS VDD FILLER2
X_16737_ _16776_/A VDD VSS _16748_/A BUFX3
X_13949_ _13949_/A _13949_/B _13993_/D VDD VSS _13983_/B AOI21BX1
XTAP_TAPCELL_ROW_36_338 VDD VSS WELLTAP
XFILLER_62_652 VSS VDD FILLER2
X_19456_ _19484_/CK _19456_/D _19456_/Q VDD VSS DFFQX1
X_16668_ _19736_/Q _16668_/B _16901_/B VDD VSS _16690_/A MIN3X1
XFILLER_61_140 VSS VDD FILLER2
XFILLER_22_505 VDD VSS FILLER4
XFILLER_50_825 VDD VSS FILLER1
X_18407_ _18407_/CK _18471_/D _20148_/A _18422_/RB VDD VSS DFFRQX1
XFILLER_50_836 VDD VSS FILLER4
X_15619_ _19383_/Q _15619_/B VDD VSS _15620_/D NAND2X1
X_19387_ _19465_/CK _19387_/D _19387_/Q VDD VSS DFFQX1
XFILLER_61_184 VSS VDD FILLER2
X_16599_ _16578_/A _16599_/B VDD VSS _16606_/B NOR2BX1
X_18338_ _18341_/CK _18338_/D _18338_/Q _18491_/RB VDD VSS DFFRQX1
XFILLER_148_746 VSS VDD FILLER2
X_18269_ _18275_/CK _18269_/D _18269_/Q _18486_/RB VDD VSS DFFRQX1
XTAP_TAPCELL_ROW_138_1256 VDD VSS WELLTAP
XFILLER_30_19 VDD VSS FILLER4
XFILLER_135_418 VSS VDD FILLER2
XFILLER_147_278 VDD VSS FILLER1
XFILLER_162_259 VSS VDD FILLER2
XFILLER_104_827 VDD VSS DECAPHV8
XFILLER_115_164 VDD VSS FILLER4
X_20162_ _20162_/A VDD VSS _20162_/Y BUFX3
XFILLER_115_175 VSS VDD FILLER2
XFILLER_103_326 VDD VSS FILLER1
X_20093_ _20093_/A VDD VSS output9/A BUFX3
XFILLER_97_571 VDD VSS FILLER1
XFILLER_69_262 VDD VSS FILLER1
XFILLER_57_402 VSS VDD FILLER2
XFILLER_111_370 VSS VDD FILLER2
XTAP_TAPCELL_ROW_149_1352 VDD VSS WELLTAP
XFILLER_85_733 VDD VSS DECAPHV8
XFILLER_69_284 VDD VSS FILLER1
XFILLER_57_468 VSS VDD FILLER2
XFILLER_84_254 VSS VDD FILLER2
XFILLER_45_619 VDD VSS FILLER1
XFILLER_26_811 VDD VSS FILLER4
XFILLER_84_287 VSS VDD FILLER2
XFILLER_72_449 VDD VSS FILLER4
XFILLER_65_490 VSS VDD FILLER2
X_09407_ _20048_/Q VDD VSS _09409_/A INVX1
XTAP_TAPCELL_ROW_70_639 VDD VSS WELLTAP
XFILLER_80_482 VSS VDD FILLER2
XFILLER_71_26 VDD VSS FILLER1
XFILLER_52_184 VSS VDD FILLER2
XFILLER_13_549 VSS VDD FILLER2
XFILLER_139_713 VSS VDD FILLER2
X_09338_ _18284_/Q _18512_/Q _09354_/B VDD VSS _09338_/Y MUXI2X1
XFILLER_40_379 VSS VDD FILLER2
XFILLER_166_532 VDD VSS DECAPHV8
XFILLER_139_757 VSS VDD FILLER2
XFILLER_166_543 VSS VDD FILLER2
X_09269_ _09408_/C _09273_/A _09269_/C _09269_/D VDD VSS _18278_/D OAI31X1
XFILLER_138_256 VDD VSS FILLER4
X_11300_ _11300_/A _11308_/C VDD VSS _11302_/B XOR2X1
XFILLER_126_429 VSS VDD FILLER2
XFILLER_5_715 VSS VDD FILLER2
XFILLER_154_738 VDD VSS DECAPHV8
XFILLER_107_610 VDD VSS FILLER4
X_12280_ _19014_/Q _12280_/B _12280_/C VDD VSS _12357_/B MIN3X1
XFILLER_5_726 VSS VDD FILLER2
XFILLER_4_214 VSS VDD FILLER2
XFILLER_5_759 VDD VSS FILLER1
X_11231_ _11209_/Y _11379_/B _10984_/A VDD VSS _11255_/B MUXI2X1
XFILLER_107_654 VDD VSS FILLER4
XFILLER_106_142 VSS VDD FILLER2
XFILLER_122_602 VSS VDD FILLER2
XFILLER_134_462 VSS VDD FILLER2
XFILLER_106_164 VSS VDD FILLER2
X_11162_ _18681_/Q _18789_/Q _11163_/C _11163_/D VDD VSS _11169_/B AOAI211X1
XFILLER_162_793 VSS VDD FILLER2
XFILLER_96_23 VSS VDD FILLER2
XFILLER_0_420 VSS VDD FILLER2
XFILLER_121_123 VSS VDD FILLER2
X_10113_ _18586_/Q _18587_/Q VDD VSS _10138_/B _10113_/C NAND3X1
XFILLER_110_808 VSS VDD FILLER2
X_15970_ _19613_/Q _15970_/B _16765_/B VDD VSS _15990_/A MIN3X1
X_11093_ _19959_/Q _18841_/Q _11093_/C VDD VSS _11142_/C AOI21X1
XFILLER_0_453 VSS VDD FILLER2
XTAP_TAPCELL_ROW_78_717 VDD VSS WELLTAP
XFILLER_76_700 VSS VDD FILLER2
XFILLER_121_167 VDD VSS FILLER1
XFILLER_121_189 VDD VSS FILLER4
X_14921_ _19504_/Q _15009_/C _14921_/C VDD VSS _14966_/A OR3BX1
X_10044_ _10029_/Y _10043_/Y _10127_/A VDD VSS _10044_/Y MUX2X1
XFILLER_88_582 VDD VSS FILLER4
XFILLER_29_50 VSS VDD FILLER2
XFILLER_88_593 VDD VSS FILLER4
XFILLER_29_61 VSS VDD FILLER2
X_17640_ _19889_/Q _19857_/Q VDD VSS _17646_/B NAND2X1
X_14852_ _19308_/Q _15679_/B VDD VSS _14853_/B XNOR2X1
XFILLER_75_254 VSS VDD FILLER2
XFILLER_152_95 VDD VSS FILLER4
XFILLER_75_276 VSS VDD FILLER2
XTAP_TAPCELL_ROW_86_783 VDD VSS WELLTAP
XFILLER_35_118 VDD VSS FILLER4
X_13803_ _13868_/A _17924_/C VDD VSS _17929_/B XNOR2X1
X_14783_ _14837_/A _14837_/B _14837_/C _14783_/D VDD VSS _14865_/A OAOI211X1
X_17571_ _18132_/A _17571_/B _17572_/C VDD VSS _19874_/D NOR3X1
XFILLER_91_747 VSS VDD FILLER2
X_11995_ _12055_/D _12108_/A VDD VSS _12050_/D NOR2X1
XFILLER_90_235 VSS VDD FILLER2
XFILLER_44_630 VDD VSS FILLER4
X_19310_ _19314_/CK _19310_/D _19310_/Q VDD VSS DFFQX1
X_16522_ _16503_/A _16522_/B VDD VSS _16523_/C NAND2BX1
X_13734_ _13735_/B _13735_/C _19029_/Q VDD VSS _13736_/C AOI21X1
X_10946_ _10910_/Y _10984_/B _10984_/A VDD VSS _10946_/Y MUXI2X1
XFILLER_45_71 VSS VDD FILLER2
XTAP_TAPCELL_ROW_33_308 VDD VSS WELLTAP
X_19241_ _19269_/CK _19241_/D _19241_/Q VDD VSS DFFQX1
XFILLER_43_173 VDD VSS FILLER4
X_16453_ _19599_/Q _16453_/B _16750_/B VDD VSS _16474_/B MIN3X1
X_13665_ _13869_/A _13869_/B _13869_/D _13869_/C VDD VSS _17915_/B AOI211X1
XFILLER_43_184 VSS VDD FILLER2
X_10877_ _10840_/B _10876_/Y _10945_/A VDD VSS _10877_/Y MUXI2X1
X_15404_ _19489_/Q _15882_/B VDD VSS _15433_/B XNOR2X1
X_12616_ _18906_/Q _12701_/B _12701_/C VDD VSS _12789_/B MIN3X1
X_16384_ _16512_/A _16384_/B VDD VSS _19533_/D NOR2X1
X_19172_ _19200_/CK _19172_/D _19172_/Q VDD VSS DFFQX1
X_13596_ _13686_/A wire154/Y _14226_/C VDD VSS _13682_/C OR3BX1
X_15335_ _15335_/A VDD VSS _15337_/B INVX1
X_18123_ _19290_/Q _18123_/B _18123_/C VDD VSS _18126_/A AOI21X1
X_12547_ _12634_/A _12634_/B _12634_/C VDD VSS _14346_/B AOI21X1
XTAP_TAPCELL_ROW_41_385 VDD VSS WELLTAP
XFILLER_129_256 VSS VDD FILLER2
XFILLER_145_705 VSS VDD FILLER2
XFILLER_157_587 VSS VDD FILLER2
XFILLER_117_429 VDD VSS FILLER4
XFILLER_144_215 VSS VDD FILLER2
X_15266_ _15307_/A _15307_/B VDD VSS _15877_/B XOR2X1
X_18054_ _18054_/A _18054_/B _18056_/A VDD VSS _19984_/D AOI21X1
XFILLER_6_21 VSS VDD FILLER2
X_12478_ _14439_/B _14439_/C _19156_/Q VDD VSS _12480_/C AOI21X1
XANTENNA_3 _09582_/C VDD VSS ANTENNA2
X_17005_ _19756_/Q _17011_/B VDD VSS _17019_/A XOR2X1
X_14217_ _14231_/A _14217_/B VDD VSS _18966_/D AND2X1
X_11429_ _14163_/A _11429_/B _11429_/C VDD VSS _18622_/D NOR3X1
X_15197_ _15198_/A _15198_/B _15198_/C VDD VSS _15841_/B OA21X2
XFILLER_153_760 VDD VSS FILLER4
XFILLER_98_302 VSS VDD FILLER2
XFILLER_6_98 VSS VDD FILLER2
XFILLER_113_613 VDD VSS FILLER1
X_14148_ _14154_/A _14148_/B VDD VSS _18904_/D NOR2X1
XFILLER_4_770 VDD VSS FILLER1
XFILLER_140_421 VSS VDD FILLER2
XFILLER_98_335 VSS VDD FILLER2
XFILLER_112_123 VDD VSS FILLER4
XFILLER_98_346 VSS VDD FILLER2
XFILLER_140_443 VSS VDD FILLER2
Xclkbuf_0__09181_ _18230_/ECK VDD VSS clkbuf_0__09181_/Y BUFX12
X_18956_ _19025_/CK _18956_/D _18956_/Q VDD VSS DFFQX1
X_14079_ _14140_/B _14140_/C _18897_/Q VDD VSS _14093_/B AOI21X1
X_17907_ _17907_/A VDD VSS _17908_/C INVX1
XFILLER_79_582 VSS VDD FILLER2
X_18887_ _18915_/CK _18887_/D _18887_/Q VDD VSS DFFQX1
X_17838_ _17838_/A VDD VSS _17917_/C BUFX3
XFILLER_39_468 VDD VSS FILLER4
XTAP_TAPCELL_ROW_49_452 VDD VSS WELLTAP
XFILLER_67_799 VSS VDD FILLER2
XFILLER_54_416 VSS VDD FILLER2
XFILLER_81_202 VDD VSS FILLER1
XFILLER_66_276 VDD VSS FILLER4
XFILLER_54_427 VDD VSS FILLER4
XFILLER_82_747 VSS VDD FILLER2
X_17769_ _19917_/Q _19885_/Q VDD VSS _17770_/B XOR2X1
X_19508_ _19508_/CK _19508_/D _19508_/Q VDD VSS DFFQX1
XFILLER_23_803 VDD VSS FILLER1
XFILLER_50_622 VDD VSS FILLER4
X_19439_ _19466_/CK _19439_/D _19439_/Q VDD VSS DFFQX1
XFILLER_50_633 VSS VDD FILLER2
XFILLER_62_493 VDD VSS FILLER1
XFILLER_34_195 VSS VDD FILLER2
XFILLER_50_666 VSS VDD FILLER2
XFILLER_148_554 VSS VDD FILLER2
XFILLER_129_790 VSS VDD FILLER2
XFILLER_135_237 VSS VDD FILLER2
XFILLER_163_546 VDD VSS FILLER1
XFILLER_144_760 VDD VSS FILLER4
XFILLER_104_602 VSS VDD FILLER2
X_20214_ _20214_/A VDD VSS _20214_/Y BUFX3
XFILLER_104_624 VDD VSS FILLER4
XFILLER_144_793 VSS VDD FILLER2
XFILLER_104_646 VSS VDD FILLER2
X_20145_ _20145_/A VDD VSS _20145_/Y BUFX3
X_09956_ _10180_/A _11403_/C VDD VSS _18527_/D NOR2X1
XFILLER_77_519 VDD VSS DECAPHV16
XFILLER_103_167 VDD VSS FILLER4
XFILLER_106_44 VSS VDD FILLER2
XFILLER_58_700 VSS VDD FILLER2
XFILLER_103_189 VSS VDD FILLER2
XFILLER_106_77 VDD VSS FILLER1
X_20076_ _20081_/CK _20076_/D _20076_/Q _20080_/RB VDD VSS DFFRQX1
X_09887_ _09944_/A _09887_/B VDD VSS _09895_/C NOR2X1
XFILLER_57_221 VSS VDD FILLER2
XFILLER_100_852 VDD VSS FILLER4
XFILLER_58_788 VSS VDD FILLER2
XFILLER_73_725 VSS VDD FILLER2
XFILLER_72_202 VSS VDD FILLER2
XFILLER_122_32 VSS VDD FILLER2
XFILLER_73_747 VSS VDD FILLER2
XFILLER_122_43 VSS VDD FILLER2
XFILLER_72_235 VSS VDD FILLER2
X_10800_ _10801_/A _10801_/B _10801_/D _10801_/C VDD VSS _10800_/Y OAOI211X1
XTAP_TAPCELL_ROW_83_764 VDD VSS WELLTAP
X_11780_ _19993_/Q _19257_/Q VDD VSS _11804_/C XOR2X1
XFILLER_82_36 VDD VSS FILLER1
XFILLER_14_814 VSS VDD FILLER2
Xclkbuf_1_0__f__09170_ clkbuf_0__09170_/Y VDD VSS _18359_/CK BUFX12
XFILLER_25_162 VDD VSS FILLER1
XFILLER_26_696 VDD VSS FILLER1
X_10731_ _10765_/A _10765_/B _10765_/C _10731_/D VDD VSS _10747_/C OAI31X1
XFILLER_53_482 VDD VSS FILLER1
XFILLER_25_184 VSS VDD FILLER2
XFILLER_13_346 VSS VDD FILLER2
X_09961__232 _20054_/CK VDD VSS _18508_/CK INVX1
XFILLER_158_318 VDD VSS FILLER4
X_13450_ _13459_/A _13459_/B _13459_/C VDD VSS _14451_/B AOI21X1
X_10662_ _10662_/A _10709_/B VDD VSS _10670_/B XNOR2X1
XFILLER_13_379 VSS VDD FILLER2
XFILLER_15_96 VSS VDD FILLER2
XFILLER_139_543 VDD VSS FILLER4
X_12401_ _12401_/A _12401_/B _12401_/C _12401_/D VDD VSS _12405_/B OAOI211X1
X_13381_ _14118_/A _17905_/B VDD VSS _18858_/D NOR2X1
X_10593_ _11378_/A _10593_/B _10594_/B VDD VSS _18559_/D NOR3X1
XFILLER_127_716 VDD VSS FILLER4
XFILLER_21_390 VSS VDD FILLER2
XFILLER_127_727 VDD VSS FILLER4
X_15120_ _19370_/Q _15747_/B VDD VSS _15134_/C NAND2X1
XFILLER_127_738 VDD VSS FILLER4
X_12332_ _19155_/Q _12483_/A _12472_/B VDD VSS _12471_/D XNOR3X1
XFILLER_5_501 VDD VSS FILLER4
XFILLER_5_512 VDD VSS FILLER4
XFILLER_154_535 VSS VDD FILLER2
XFILLER_31_73 VDD VSS FILLER4
XFILLER_154_546 VDD VSS FILLER1
XTAP_TAPCELL_ROW_2_33 VDD VSS WELLTAP
X_15051_ _15052_/A _15052_/B VDD VSS _15872_/B _15108_/B _15052_/D NAND4X2
XFILLER_126_259 VDD VSS FILLER1
X_12263_ _19014_/Q _12280_/B _12280_/C VDD VSS _14246_/B XNOR3X1
XFILLER_5_556 VSS VDD FILLER2
XFILLER_142_719 VSS VDD FILLER2
XFILLER_154_579 VSS VDD FILLER2
XFILLER_141_207 VSS VDD FILLER2
XFILLER_147_84 VSS VDD FILLER2
X_14002_ _14267_/B _19005_/Q VDD VSS _14013_/A NAND2BX1
Xoutput5 output5/A VDD VSS adc_conv BUFX3
X_11214_ _11289_/A _11307_/B _11214_/C VDD VSS _11222_/B AOI21X1
XFILLER_122_421 VDD VSS DECAPHV8
XFILLER_150_730 VDD VSS FILLER1
X_12194_ _18929_/Q _12198_/B _14177_/B VDD VSS _14145_/B XNOR3X1
Xoutput40 _20123_/Y VDD VSS o_bias_cfg[25] BUFX3
Xoutput51 _20101_/Y VDD VSS o_bias_cfg[3] BUFX3
X_18810_ _18810_/CK _18810_/D _18810_/Q VDD VSS DFFQX1
Xoutput62 _20146_/Y VDD VSS o_clk_cfg[13] BUFX3
Xoutput73 _20139_/Y VDD VSS o_clk_cfg[6] BUFX3
X_11145_ _18708_/Q _18762_/Q VDD VSS _11167_/A XNOR2X1
Xoutput84 _20158_/Y VDD VSS o_en_ctrl[6] BUFX3
X_19790_ _19791_/CK _19790_/D _19790_/Q VDD VSS DFFQX1
XFILLER_1_751 VSS VDD FILLER2
XFILLER_49_700 VDD VSS DECAPHV16
XFILLER_0_250 VSS VDD FILLER2
Xoutput95 _20164_/Y VDD VSS o_lf_cfg[1] BUFX3
XFILLER_163_61 VSS VDD FILLER2
X_18741_ _18795_/CK _18741_/D _18741_/Q VDD VSS DFFQX1
XFILLER_163_72 VDD VSS FILLER1
X_15953_ _19643_/Q _16800_/B _15979_/A VDD VSS _15977_/A MIN3X1
X_11076_ _11093_/C _11076_/B _11076_/C _11178_/C VDD VSS _11077_/C AOI2B2X1
XFILLER_0_294 VDD VSS FILLER1
XFILLER_49_755 VDD VSS FILLER1
X_14904_ _14904_/A _14904_/B _15771_/B VDD VSS _14955_/B MIN3X1
X_10027_ _09946_/Y _09953_/B _10166_/D VDD VSS _10027_/Y MUXI2X1
X_18672_ _19940_/CK _18672_/D _18672_/Q VDD VSS DFFQX1
X_15884_ _16768_/A _15884_/B VDD VSS _19491_/D AND2X1
XFILLER_49_788 VSS VDD FILLER2
XFILLER_48_265 VSS VDD FILLER2
XFILLER_36_416 VSS VDD FILLER2
XFILLER_48_287 VSS VDD FILLER2
X_17623_ _17625_/C _17623_/B _17623_/C VDD VSS _19885_/D AOI21X1
X_14835_ _19447_/Q _15832_/B VDD VSS _14867_/A AND2X1
XFILLER_91_533 VSS VDD FILLER2
XFILLER_17_630 VSS VDD FILLER2
X_17554_ _17556_/B _17554_/B VDD VSS _17555_/B XOR2X1
XFILLER_63_268 VDD VSS DECAPHV8
X_14766_ _14766_/A _18059_/B VDD VSS _19278_/D AND2X1
X_11978_ _19231_/Q _14525_/B VDD VSS _11979_/D _14525_/C AND3X2
XTAP_TAPCELL_ROW_18_179 VDD VSS WELLTAP
X_16505_ _16521_/B _16505_/B VDD VSS _16824_/B XOR2X1
X_13717_ _19169_/Q _14454_/B _13719_/B VDD VSS _14424_/B MIN3X1
X_10929_ _19955_/Q _18837_/Q VDD VSS _10931_/C XNOR2X1
X_14697_ _19444_/Q _14733_/B _14702_/C VDD VSS _14698_/C XNOR3X1
X_17485_ _17488_/A _17488_/B _17509_/C VDD VSS _17486_/C OAI21X1
XFILLER_71_290 VSS VDD FILLER2
XFILLER_31_132 VDD VSS FILLER4
X_19224_ _19988_/CK _19224_/D _19224_/Q VDD VSS DFFQX1
X_16436_ _16437_/A _16437_/B _16437_/C VDD VSS _16469_/B OAI21X1
XFILLER_20_817 VSS VDD FILLER2
X_13648_ _13649_/B _13649_/C _19056_/Q VDD VSS _13733_/B AOI21X1
XFILLER_72_91 VDD VSS FILLER1
XFILLER_9_840 VSS VDD FILLER2
X_19155_ _19185_/CK _19155_/D _19155_/Q VDD VSS DFFQX1
X_16367_ _19916_/Q VDD VSS _16711_/A INVX1
X_13579_ _18916_/Q VDD VSS _13661_/A INVX1
XFILLER_157_362 VSS VDD FILLER2
XFILLER_145_513 VSS VDD FILLER2
X_18106_ _19288_/Q _18107_/B VDD VSS _18112_/C NAND2X1
XFILLER_118_738 VDD VSS FILLER1
X_15318_ _15878_/B _15318_/B _15354_/C VDD VSS _15879_/B XNOR3X1
X_16298_ _19690_/Q _16851_/B VDD VSS _16307_/B XNOR2X1
X_19086_ _19086_/CK _19086_/D _19086_/Q VDD VSS DFFQX1
XTAP_TAPCELL_ROW_135_1226 VDD VSS WELLTAP
XFILLER_145_557 VDD VSS FILLER1
X_18037_ _18038_/B _18045_/B _18037_/C _18049_/D VDD VSS _19976_/D OAI31X1
X_15249_ _19401_/Q _15781_/B VDD VSS _15262_/B XOR2X1
XFILLER_160_505 VDD VSS FILLER4
XFILLER_160_527 VDD VSS DECAPHV16
XFILLER_126_793 VSS VDD FILLER2
XFILLER_141_741 VSS VDD FILLER2
X_09810_ _18343_/Q _09810_/B VDD VSS _09811_/E NOR2X1
X_19988_ _19988_/CK _19988_/D _19988_/Q VDD VSS DFFQX1
XFILLER_113_487 VDD VSS FILLER4
Xclkbuf_0__09164_ _18213_/ECK VDD VSS clkbuf_0__09164_/Y BUFX12
X_09741_ _20076_/Q _09818_/B _09818_/C _18270_/Q _09741_/E VDD VSS _09745_/C AOI221X1
X_18939_ _18939_/CK _18939_/D _18939_/Q VDD VSS DFFQX1
XFILLER_100_137 VSS VDD FILLER2
X_09672_ _20107_/A _20123_/A _09729_/D VDD VSS _09682_/C MUXI2X1
XTAP_TAPCELL_ROW_97_889 VDD VSS WELLTAP
XFILLER_54_213 VSS VDD FILLER2
XFILLER_55_747 VDD VSS DECAPHV8
XFILLER_54_224 VSS VDD FILLER2
XFILLER_54_235 VSS VDD FILLER2
XFILLER_82_577 VSS VDD FILLER2
XTAP_TAPCELL_ROW_80_734 VDD VSS WELLTAP
XFILLER_35_493 VDD VSS FILLER1
XFILLER_52_28 VDD VSS FILLER1
XFILLER_10_305 VSS VDD FILLER2
XFILLER_50_474 VSS VDD FILLER2
XFILLER_148_351 VDD VSS FILLER4
XFILLER_109_716 VDD VSS FILLER4
XFILLER_136_502 VSS VDD FILLER2
XFILLER_6_309 VSS VDD FILLER2
XFILLER_148_373 VDD VSS FILLER1
XFILLER_163_321 VDD VSS FILLER4
XFILLER_108_259 VSS VDD FILLER2
XFILLER_117_10 VDD VSS FILLER1
XFILLER_151_516 VDD VSS FILLER1
XFILLER_104_421 VDD VSS FILLER4
XFILLER_144_590 VSS VDD FILLER2
XFILLER_2_537 VSS VDD FILLER2
XTAP_TAPCELL_ROW_112_1023 VDD VSS WELLTAP
XFILLER_117_65 VSS VDD FILLER2
XFILLER_89_132 VSS VDD FILLER2
XFILLER_104_454 VDD VSS FILLER4
XFILLER_131_240 VSS VDD FILLER2
XFILLER_78_817 VSS VDD FILLER2
XFILLER_77_25 VDD VSS DECAPHV8
XFILLER_117_87 VDD VSS FILLER4
XTAP_TAPCELL_ROW_88_801 VDD VSS WELLTAP
XFILLER_131_262 VSS VDD FILLER2
Xdelaybuf_0_clk _18232_/CK VDD VSS _18229_/CK BUFX12
XFILLER_89_176 VDD VSS FILLER1
X_20128_ _20128_/A VDD VSS _20128_/Y BUFX3
XFILLER_131_295 VDD VSS FILLER1
X_09939_ _10190_/B _09939_/B VDD VSS _09940_/C NAND2X1
X_12950_ _12951_/A _12951_/B _12951_/D _12951_/C VDD VSS _14510_/B AO211X2
XFILLER_58_563 VDD VSS FILLER1
XFILLER_100_660 VSS VDD FILLER2
X_20059_ clkload6/A _20059_/D _20060_/D _20071_/RB VDD VSS DFFRQX1
XFILLER_85_371 VDD VSS FILLER1
XFILLER_45_202 VSS VDD FILLER2
XFILLER_18_416 VSS VDD FILLER2
X_11901_ _19092_/Q _11962_/B _11958_/C VDD VSS _11953_/C XNOR3X1
XFILLER_46_736 VSS VDD FILLER2
XFILLER_45_213 VDD VSS FILLER4
XFILLER_93_35 VSS VDD FILLER2
X_12881_ _13283_/A _17880_/B VDD VSS _18853_/D AND2X1
XFILLER_18_449 VDD VSS FILLER1
XTAP_TAPCELL_ROW_164_1488 VDD VSS WELLTAP
XFILLER_45_235 VSS VDD FILLER2
X_14620_ _14624_/A _14645_/B _14645_/C VDD VSS _15858_/B AND3BX1
X_11832_ wire166/Y _11838_/C VDD VSS _14524_/B XOR2X1
XFILLER_26_40 VDD VSS FILLER4
XTAP_TAPCELL_ROW_43_403 VDD VSS WELLTAP
X_14551_ _19991_/Q _14558_/B VDD VSS _19255_/D AND2X1
XFILLER_26_84 VSS VDD FILLER2
X_11763_ _11764_/B _11764_/C _19200_/Q VDD VSS _11797_/B AOI21X1
XTAP_TAPCELL_ROW_15_149 VDD VSS WELLTAP
X_13502_ _13502_/A _13502_/B _13502_/C _13502_/D VDD VSS _13662_/B OAOI211X1
X_10714_ _10715_/A _10715_/B _10715_/D _10715_/C VDD VSS _10717_/B AOAI211X1
X_17270_ _17269_/B _17270_/B VDD VSS _17272_/C NOR2BX1
X_14482_ _14482_/A _14482_/B _17827_/B VDD VSS _19195_/D AOI21X1
XFILLER_159_649 VSS VDD FILLER2
X_11694_ _11716_/A _11716_/B _11716_/C VDD VSS _11736_/A AOI21X1
XFILLER_158_137 VSS VDD FILLER2
X_16221_ _16222_/A _16222_/B _16222_/C VDD VSS _16221_/Y NOR3X1
X_13433_ _14417_/B _14417_/C _19137_/Q VDD VSS _13616_/B AO21X2
X_10645_ _10639_/Y _10645_/B _10675_/B _10645_/D VDD VSS _10653_/C OAI2B2BX1
XFILLER_42_61 VSS VDD FILLER2
XFILLER_139_351 VDD VSS FILLER4
XFILLER_127_502 VSS VDD FILLER2
X_16152_ _16146_/A _16152_/B _16152_/C VDD VSS _16175_/B AOI2B1X1
XFILLER_127_524 VSS VDD FILLER2
X_13364_ _13364_/A _13364_/B _13364_/C _13364_/D VDD VSS _14355_/A AOAI211X1
XFILLER_6_821 VDD VSS FILLER1
XFILLER_166_170 VDD VSS FILLER4
X_10576_ _10576_/A _10576_/B _10576_/C _10576_/D VDD VSS _10577_/B AOI211X1
XFILLER_6_832 VSS VDD FILLER2
XFILLER_158_83 VSS VDD FILLER2
X_15103_ _15903_/B VDD VSS _15104_/B INVX1
X_12315_ _20001_/Q _19265_/Q VDD VSS _12407_/A NAND2X1
X_16083_ _16083_/A _16083_/B _16083_/C VDD VSS _16108_/B OA21X2
XFILLER_154_354 VSS VDD FILLER2
XFILLER_142_505 VDD VSS FILLER4
X_13295_ _13295_/A _13295_/B _13295_/C _13295_/D VDD VSS _13402_/A AOI31X1
XFILLER_54_8 VSS VDD FILLER2
X_15034_ _15297_/A _18089_/B VDD VSS _19284_/D AND2X1
X_19911_ clkload8/A _19911_/D _19911_/Q VDD VSS DFFQX1
XFILLER_5_375 VDD VSS FILLER4
XFILLER_108_793 VSS VDD FILLER2
X_12246_ _12372_/A _12372_/B VDD VSS _14404_/B _12372_/C NAND3X1
XFILLER_135_590 VSS VDD FILLER2
X_19842_ _19880_/CK _19842_/D _19842_/Q VDD VSS DFFQX1
X_12177_ _19153_/Q _12177_/B VDD VSS _12183_/B XNOR2X1
XFILLER_96_636 VDD VSS FILLER4
XFILLER_1_570 VDD VSS FILLER1
X_11128_ _11128_/A _11128_/B VDD VSS _11159_/A NAND2X1
X_19773_ _19841_/CK _19773_/D _19773_/Q VDD VSS DFFQX1
X_16985_ _19750_/Q _19751_/Q _17011_/B VDD VSS _16996_/D OAI21X1
XFILLER_1_592 VSS VDD FILLER2
XFILLER_95_157 VDD VSS DECAPHV8
X_18724_ _19943_/CK _18724_/D _18724_/Q VDD VSS DFFQX1
X_15936_ _15936_/A _15936_/B VDD VSS _15937_/C NAND2X1
X_11059_ _18706_/Q _18760_/Q VDD VSS _11064_/A XOR2X1
XFILLER_37_703 VDD VSS FILLER4
XFILLER_76_360 VSS VDD FILLER2
XFILLER_67_91 VSS VDD FILLER2
XFILLER_49_574 VSS VDD FILLER2
XFILLER_37_736 VSS VDD FILLER2
XFILLER_37_747 VSS VDD FILLER2
X_18655_ _18845_/CK _18655_/D _18655_/Q VDD VSS DFFQX1
XTAP_TAPCELL_ROW_94_859 VDD VSS WELLTAP
X_15867_ _15867_/A _15867_/B VDD VSS _19476_/D NOR2X1
XFILLER_36_235 VSS VDD FILLER2
X_17606_ _19881_/Q _19849_/Q _17606_/C VDD VSS _17610_/B MIN3X1
X_14818_ _14818_/A _14818_/B _14818_/C _14818_/D VDD VSS _14908_/B AOAI211X1
XFILLER_91_363 VSS VDD FILLER2
X_18586_ _18595_/CK _18586_/D _18586_/Q VDD VSS DFFQX1
XFILLER_51_205 VSS VDD FILLER2
X_15798_ _15800_/A _15798_/B VDD VSS _19416_/D NOR2X1
XFILLER_51_227 VSS VDD FILLER2
X_17537_ _19867_/Q _19835_/Q _17537_/C VDD VSS _17541_/B AOI21X1
X_14749_ _14785_/A _14785_/B _14785_/D _14785_/C VDD VSS _14781_/D OAI211X1
XTAP_TAPCELL_ROW_141_1285 VDD VSS WELLTAP
XFILLER_32_452 VSS VDD FILLER2
XFILLER_149_115 VDD VSS FILLER1
XFILLER_60_772 VDD VSS FILLER1
XFILLER_20_603 VDD VSS FILLER1
X_17468_ _17468_/A _17468_/B _17468_/C _17468_/D VDD VSS _17469_/C AOAI211X1
XFILLER_20_614 VDD VSS FILLER4
X_19207_ _19250_/CK _19207_/D _19207_/Q VDD VSS DFFQX1
X_16419_ _19598_/Q _16748_/B VDD VSS _16420_/C NOR2X1
X_17399_ _19838_/Q _19806_/Q VDD VSS _17400_/B XOR2X1
XFILLER_146_811 VSS VDD FILLER2
XFILLER_158_671 VSS VDD FILLER2
XFILLER_73_0 VSS VDD FILLER2
XFILLER_164_118 VSS VDD FILLER2
X_19138_ _19166_/CK _19138_/D _19138_/Q VDD VSS DFFQX1
XFILLER_9_681 VSS VDD FILLER2
XFILLER_157_170 VSS VDD FILLER2
XFILLER_161_803 VSS VDD FILLER2
X_19069_ _19072_/CK _19069_/D _19069_/Q VDD VSS DFFQX1
XFILLER_105_207 VDD VSS DECAPHV8
XFILLER_161_825 VSS VDD FILLER2
XFILLER_133_527 VSS VDD FILLER2
XFILLER_145_387 VSS VDD FILLER2
XFILLER_145_398 VDD VSS DECAPHV8
XTAP_TAPCELL_ROW_152_1381 VDD VSS WELLTAP
XFILLER_99_463 VSS VDD FILLER2
XFILLER_113_273 VDD VSS FILLER4
XFILLER_101_435 VSS VDD FILLER2
XFILLER_87_658 VSS VDD FILLER2
XFILLER_101_446 VDD VSS FILLER1
XFILLER_101_468 VSS VDD FILLER2
X_09724_ _20221_/A _09811_/C _09770_/C _18321_/Q VDD VSS _09725_/D AOI22X1
XTAP_TAPCELL_ROW_57_528 VDD VSS WELLTAP
X_09655_ _18365_/Q VDD VSS _20202_/A INVX1
XFILLER_55_533 VDD VSS FILLER1
XFILLER_55_544 VDD VSS FILLER1
XFILLER_103_67 VSS VDD FILLER2
XFILLER_27_268 VSS VDD FILLER2
X_09586_ _18393_/Q VDD VSS _20134_/A INVX1
XFILLER_70_514 VDD VSS FILLER4
XTAP_TAPCELL_ROW_65_594 VDD VSS WELLTAP
XTAP_TAPCELL_ROW_105_960 VDD VSS WELLTAP
XFILLER_23_463 VSS VDD FILLER2
XFILLER_144_6 VSS VDD FILLER2
XFILLER_23_474 VDD VSS FILLER4
XFILLER_10_102 VDD VSS FILLER4
XTAP_TAPCELL_ROW_12_119 VDD VSS WELLTAP
XFILLER_10_146 VSS VDD FILLER2
XFILLER_7_618 VSS VDD FILLER2
XFILLER_6_106 VSS VDD FILLER2
XFILLER_10_168 VSS VDD FILLER2
X_10430_ _10431_/A _10431_/B _10431_/C VDD VSS _10472_/B AO21X2
XFILLER_148_170 VDD VSS DECAPHV8
XFILLER_10_179 VSS VDD FILLER2
XFILLER_128_31 VDD VSS FILLER1
XFILLER_12_64 VSS VDD FILLER2
XFILLER_109_579 VDD VSS DECAPHV8
X_10361_ _19940_/Q _18822_/Q VDD VSS _10417_/C XNOR2X1
XFILLER_12_86 VDD VSS FILLER4
XFILLER_136_365 VSS VDD FILLER2
XTAP_TAPCELL_ROW_20_196 VDD VSS WELLTAP
X_12100_ _19235_/Q VDD VSS _12101_/A INVX1
XFILLER_128_75 VSS VDD FILLER2
XFILLER_88_24 VSS VDD FILLER2
XFILLER_2_301 VSS VDD FILLER2
X_13080_ _18884_/Q VDD VSS _13287_/A INVX1
X_10292_ _19938_/Q _18820_/Q VDD VSS _10343_/B XOR2X1
XFILLER_2_323 VSS VDD FILLER2
XFILLER_151_368 VDD VSS FILLER4
X_12031_ _12031_/A _12031_/B _12031_/C _12031_/D VDD VSS wire160/A OAOI211X1
XFILLER_88_79 VSS VDD FILLER2
XFILLER_104_251 VDD VSS FILLER1
XFILLER_120_700 VDD VSS FILLER4
XFILLER_144_41 VDD VSS FILLER4
XTAP_TAPCELL_ROW_166_1506 VDD VSS WELLTAP
XTAP_TAPCELL_ROW_166_1517 VDD VSS WELLTAP
XFILLER_78_669 VSS VDD FILLER2
XFILLER_93_606 VSS VDD FILLER2
XFILLER_120_788 VSS VDD FILLER2
X_16770_ _16775_/A _16770_/B VDD VSS _19618_/D NOR2X1
X_13982_ _18922_/Q VDD VSS _14019_/A INVX1
X_15721_ _15739_/A _15721_/B VDD VSS _19347_/D NOR2X1
XFILLER_19_747 VSS VDD FILLER2
X_12933_ _12940_/A _12940_/B VDD VSS _14444_/B _12940_/C AND3X2
XFILLER_92_149 VSS VDD FILLER2
XFILLER_18_235 VSS VDD FILLER2
XFILLER_46_566 VSS VDD FILLER2
X_18440_ _18454_/CK _18440_/D _18440_/Q _18442_/RB VDD VSS DFFRQX1
X_15652_ _15652_/A _15652_/B _15652_/C VDD VSS _15660_/A AOI21X1
XTAP_TAPCELL_ROW_91_829 VDD VSS WELLTAP
X_12864_ _19077_/Q _13017_/A _13102_/B VDD VSS _12916_/C XNOR3X1
XFILLER_34_739 VSS VDD FILLER2
XTAP_TAPCELL_ROW_28_263 VDD VSS WELLTAP
XTAP_TAPCELL_ROW_8_87 VDD VSS WELLTAP
XFILLER_61_536 VSS VDD FILLER2
X_14603_ _19496_/Q VDD VSS _14644_/A INVX1
X_18371_ _18375_/CK _18499_/D _20208_/A _18373_/RB VDD VSS DFFRQX1
X_11815_ _19089_/Q _14365_/B VDD VSS _11816_/B OR2X2
X_15583_ _19382_/Q _15759_/B VDD VSS _15595_/B XOR2X1
X_12795_ _18908_/Q _12883_/B _12883_/C VDD VSS _13180_/B MIN3X1
XFILLER_26_290 VSS VDD FILLER2
X_17322_ _17325_/C _17323_/B _17363_/C VDD VSS _17323_/C OAI21X1
X_14534_ _14534_/A _14534_/B _15836_/C VDD VSS _19240_/D OA21X2
X_11746_ _19991_/Q _19255_/Q VDD VSS _11769_/C AND2X1
XFILLER_159_457 VDD VSS FILLER1
XFILLER_41_282 VSS VDD FILLER2
XFILLER_159_468 VDD VSS FILLER4
X_17253_ _19806_/Q _19774_/Q _17253_/C VDD VSS _17257_/B AOI21X1
X_14465_ _14490_/A _14465_/B _14465_/C VDD VSS _19179_/D NOR3X1
X_11677_ _11677_/A _16704_/B VDD VSS _18841_/D NOR2X1
X_16204_ _16204_/A VDD VSS _16775_/B INVX1
X_13416_ _19053_/Q _13416_/B VDD VSS _13420_/C _13416_/C NAND3X1
X_10628_ _18560_/Q _10666_/A _10665_/B VDD VSS _10629_/B XNOR3X1
X_17184_ _19792_/Q _19760_/Q VDD VSS _17189_/A XNOR2X1
X_14396_ _14426_/A _14396_/B VDD VSS _19117_/D NOR2X1
XFILLER_127_332 VSS VDD FILLER2
XFILLER_155_641 VSS VDD FILLER2
X_16135_ _19556_/Q _19908_/Q VDD VSS _16138_/A XNOR2X1
X_13347_ _13347_/A _14513_/B _13347_/C _13347_/D VDD VSS _13464_/A OAOI211X1
X_10559_ _18691_/Q _18745_/Q VDD VSS _10563_/D AND2X1
XFILLER_154_151 VSS VDD FILLER2
XFILLER_115_516 VSS VDD FILLER2
XFILLER_155_685 VSS VDD FILLER2
XFILLER_6_673 VSS VDD FILLER2
XFILLER_142_324 VDD VSS FILLER1
X_16066_ _16085_/B _16066_/B VDD VSS _16769_/B XNOR2X1
X_13278_ _18969_/Q _13278_/B _14221_/C VDD VSS _13391_/B XNOR3X1
XFILLER_154_195 VSS VDD FILLER2
XTAP_TAPCELL_ROW_99_907 VDD VSS WELLTAP
XFILLER_5_194 VSS VDD FILLER2
X_15017_ _15017_/A _15017_/B _15017_/C _15017_/D VDD VSS _15056_/A OAOI211X1
X_12229_ _12396_/A _12396_/B VDD VSS _12231_/B NOR2X1
Xclkbuf_leaf_14_clk_regs clkload1/A VDD VSS clkload5/A BUFX12
X_19825_ _19825_/CK _19825_/D _19825_/Q VDD VSS DFFQX1
XFILLER_96_444 VSS VDD FILLER2
XFILLER_68_146 VSS VDD FILLER2
XFILLER_111_777 VSS VDD FILLER2
XFILLER_110_265 VDD VSS FILLER1
X_19756_ _19791_/CK _19756_/D _19756_/Q VDD VSS DFFQX1
XFILLER_84_628 VSS VDD FILLER2
X_16968_ _19748_/Q _17078_/B _16968_/C VDD VSS _16969_/B MIN3X1
XFILLER_84_639 VDD VSS FILLER1
X_18707_ _18788_/CK _18707_/D _18707_/Q VDD VSS DFFQX1
X_15919_ _19579_/Q _16728_/B VDD VSS _15929_/B XOR2X1
XTAP_TAPCELL_ROW_143_1303 VDD VSS WELLTAP
X_19687_ _19695_/CK _19687_/D _19687_/Q VDD VSS DFFQX1
XFILLER_64_330 VDD VSS FILLER1
X_16899_ _16899_/A _16899_/B VDD VSS _19734_/D AND2X1
XFILLER_64_341 VSS VDD FILLER2
X_09440_ wire176/Y VDD VSS _09772_/B BUFX3
X_18638_ _18801_/CK _18638_/D _18638_/Q VDD VSS DFFQX1
XFILLER_52_514 VSS VDD FILLER2
XFILLER_37_599 VSS VDD FILLER2
X_09371_ _09626_/B _09422_/B VDD VSS _09426_/A _09624_/B NAND3X1
X_18569_ _18589_/CK _18569_/D _18569_/Q VDD VSS DFFQX1
XTAP_TAPCELL_ROW_102_930 VDD VSS WELLTAP
XTAP_TAPCELL_ROW_62_575 VDD VSS WELLTAP
XFILLER_138_619 VDD VSS FILLER1
XFILLER_20_477 VDD VSS FILLER1
XFILLER_158_490 VDD VSS FILLER4
XFILLER_145_140 VSS VDD FILLER2
XFILLER_161_611 VSS VDD FILLER2
XFILLER_145_184 VSS VDD FILLER2
XFILLER_161_644 VDD VSS FILLER4
XFILLER_160_154 VSS VDD FILLER2
XFILLER_121_519 VSS VDD FILLER2
XFILLER_102_700 VSS VDD FILLER2
XFILLER_99_260 VDD VSS FILLER4
XFILLER_58_16 VDD VSS FILLER1
XFILLER_99_271 VSS VDD FILLER2
XFILLER_99_282 VDD VSS FILLER4
XFILLER_59_113 VSS VDD FILLER2
XFILLER_58_49 VSS VDD FILLER2
XFILLER_87_455 VSS VDD FILLER2
XFILLER_102_788 VSS VDD FILLER2
XFILLER_87_488 VSS VDD FILLER2
XFILLER_59_179 VDD VSS FILLER4
XFILLER_114_44 VSS VDD FILLER2
X_09707_ _09707_/A _09707_/B VDD VSS _09708_/E NAND2X1
XFILLER_55_341 VSS VDD FILLER2
XFILLER_28_566 VDD VSS FILLER1
XFILLER_43_503 VSS VDD FILLER2
X_09638_ _18444_/Q VDD VSS _20156_/A INVX1
XFILLER_28_588 VDD VSS FILLER1
XFILLER_15_205 VSS VDD FILLER2
XTAP_TAPCELL_ROW_161_1458 VDD VSS WELLTAP
XFILLER_70_300 VDD VSS FILLER4
X_09569_ _09569_/A _09569_/B VDD VSS _09581_/A _09569_/C NAND3X1
X_11600_ _18745_/Q _11600_/B VDD VSS _18772_/D AND2X1
X_12580_ _12677_/A _14535_/B _14535_/C VDD VSS _12837_/D NOR3X1
XFILLER_23_282 VSS VDD FILLER2
X_11531_ _18683_/Q _11531_/B VDD VSS _18710_/D AND2X1
XFILLER_11_455 VSS VDD FILLER2
XFILLER_156_416 VSS VDD FILLER2
XFILLER_128_118 VSS VDD FILLER2
XFILLER_128_129 VDD VSS FILLER1
X_14250_ _14251_/A _14250_/B VDD VSS _18990_/D NOR2X1
XFILLER_109_310 VSS VDD FILLER2
X_11462_ _19954_/Q _11473_/B VDD VSS _18647_/D AND2X1
XFILLER_23_96 VDD VSS FILLER4
XFILLER_7_448 VSS VDD FILLER2
X_13201_ _19024_/Q _13201_/B _13208_/C VDD VSS _13373_/B XOR3X1
X_10413_ _10413_/A _10413_/B _10413_/C _10413_/D VDD VSS _10460_/B AOAI211X1
XFILLER_99_34 VSS VDD FILLER2
XFILLER_139_96 VDD VSS FILLER4
X_14181_ _14197_/A _14181_/B VDD VSS _18933_/D AND2X1
XFILLER_136_151 VSS VDD FILLER2
X_11393_ _11391_/Y _11393_/B _11431_/A VDD VSS _18595_/D AND3BX1
XTAP_TAPCELL_ROW_118_1073 VDD VSS WELLTAP
X_13132_ _13133_/A _13133_/C VDD VSS _14511_/B _13133_/B AND3X2
X_10344_ _10342_/Y _10417_/B _10686_/D VDD VSS _10345_/D AND3BX1
XFILLER_3_643 VSS VDD FILLER2
XFILLER_124_368 VSS VDD FILLER2
XFILLER_3_654 VDD VSS FILLER4
XFILLER_3_0 VDD VSS FILLER1
XFILLER_151_154 VSS VDD FILLER2
X_17940_ _17940_/A _17940_/B _17940_/C VDD VSS _17941_/D NOR3X1
X_13063_ _13137_/A _13141_/D _13125_/C VDD VSS _13138_/C XNOR3X1
XFILLER_2_142 VSS VDD FILLER2
X_10275_ _11386_/C VDD VSS _11431_/A BUFX3
XFILLER_151_176 VSS VDD FILLER2
X_12014_ _12014_/A _12014_/B VDD VSS _14305_/B XNOR2X1
XFILLER_151_198 VDD VSS FILLER4
XFILLER_78_433 VSS VDD FILLER2
X_17871_ _18852_/Q _17876_/B VDD VSS _17872_/B XNOR2X1
XFILLER_120_541 VDD VSS DECAPHV16
XFILLER_39_809 VDD VSS FILLER1
X_19610_ _19702_/CK _19610_/D _19610_/Q VDD VSS DFFQX1
X_16822_ _16826_/A _16822_/B VDD VSS _19664_/D NOR2X1
XFILLER_66_639 VDD VSS FILLER4
XFILLER_120_596 VDD VSS DECAPHV8
XFILLER_47_820 VSS VDD FILLER2
X_19541_ _19734_/CK _19541_/D _19541_/Q VDD VSS DFFQX1
X_16753_ _16759_/A _16753_/B VDD VSS _19602_/D NOR2X1
XFILLER_0_23 VDD VSS FILLER4
X_13965_ _13965_/A _13965_/B VDD VSS _14301_/B _13965_/C NAND3X1
XFILLER_58_190 VSS VDD FILLER2
X_15704_ _15706_/A _15704_/B VDD VSS _19332_/D AND2X1
X_19472_ _19528_/CK _19472_/D _19472_/Q VDD VSS DFFQX1
X_12916_ _12916_/A _12916_/B _12916_/C _12916_/D VDD VSS _14319_/C AOI211X1
X_16684_ _19673_/Q _16832_/B VDD VSS _16685_/B XOR2X1
XFILLER_61_300 VSS VDD FILLER2
XFILLER_34_514 VDD VSS FILLER4
X_13896_ _13903_/A _13903_/B _13951_/C VDD VSS _14266_/B OA21X2
XFILLER_74_694 VSS VDD FILLER2
XFILLER_46_385 VSS VDD FILLER2
XFILLER_34_525 VDD VSS FILLER4
XFILLER_19_599 VDD VSS FILLER4
X_18423_ _18423_/CK _18423_/D _18423_/Q _20067_/RB VDD VSS DFFRQX1
X_15635_ _15635_/A _15635_/B _15700_/B VDD VSS _15652_/A MIN3X1
XFILLER_61_333 VDD VSS FILLER1
X_12847_ _14538_/A _14538_/B _12967_/C VDD VSS _12951_/C AOI21X1
XFILLER_22_709 VDD VSS FILLER1
X_18354_ _18357_/CK _18354_/D _18354_/Q _18498_/RB VDD VSS DFFRQX1
XFILLER_9_21 VDD VSS FILLER4
X_15566_ _15566_/A _15566_/B _15566_/C VDD VSS _15592_/A AOI21X1
X_12778_ _19020_/Q _12778_/B _12799_/D VDD VSS _12801_/C XNOR3X1
X_17305_ _19817_/Q _19785_/Q _17305_/C VDD VSS _17309_/B MIN3X1
XFILLER_30_731 VDD VSS FILLER4
X_14517_ _14766_/A _14517_/B VDD VSS _19224_/D AND2X1
X_18285_ _18288_/CK _18285_/D _18285_/Q VDD VSS DFFQX1
X_11729_ _19171_/Q _11761_/B _11733_/C VDD VSS _14425_/B XNOR3X1
XFILLER_159_265 VSS VDD FILLER2
X_15497_ _19322_/Q VDD VSS _15498_/A INVX1
XFILLER_9_87 VDD VSS FILLER4
XFILLER_30_775 VSS VDD FILLER2
X_17236_ _19802_/Q _19770_/Q VDD VSS _17238_/C _17236_/C AND3X2
X_14448_ _14456_/A _14448_/B VDD VSS _19164_/D NOR2X1
XFILLER_128_652 VSS VDD FILLER2
XFILLER_128_663 VDD VSS FILLER1
X_17167_ _17168_/A _17168_/B _17168_/D _17168_/C VDD VSS _17170_/C AOI211X1
X_14379_ _14410_/A _14379_/B _14379_/C VDD VSS _19102_/D NOR3X1
XFILLER_115_324 VDD VSS FILLER4
X_16118_ _16133_/B _16118_/B VDD VSS _16808_/B XNOR2X1
X_17098_ _19773_/Q _19741_/Q _17098_/C VDD VSS _17102_/B AOI21X1
XFILLER_6_492 VSS VDD FILLER2
XFILLER_143_677 VSS VDD FILLER2
XFILLER_142_165 VDD VSS FILLER4
X_16049_ _16049_/A _16049_/B VDD VSS _16875_/B XNOR2X1
XFILLER_88_219 VDD VSS FILLER1
XFILLER_143_699 VSS VDD FILLER2
XFILLER_69_411 VSS VDD FILLER2
XFILLER_97_731 VDD VSS FILLER4
XFILLER_97_742 VSS VDD FILLER2
XFILLER_96_230 VSS VDD FILLER2
XFILLER_111_541 VSS VDD FILLER2
XFILLER_97_786 VDD VSS FILLER4
XFILLER_28_19 VSS VDD FILLER2
X_19808_ _19841_/CK _19808_/D _19808_/Q VDD VSS DFFQX1
XTAP_TAPCELL_ROW_67_612 VDD VSS WELLTAP
XFILLER_56_138 VDD VSS FILLER1
X_19739_ clkload3/A _19739_/D _19739_/Q VDD VSS DFFQX1
XFILLER_65_661 VSS VDD FILLER2
XFILLER_71_119 VSS VDD FILLER2
XFILLER_64_160 VSS VDD FILLER2
XFILLER_65_694 VSS VDD FILLER2
X_09423_ _09630_/C _18505_/Q _18506_/Q VDD VSS _09626_/C OR3BX1
XFILLER_64_182 VSS VDD FILLER2
XFILLER_52_355 VSS VDD FILLER2
X_09354_ _09354_/A _09354_/B VDD VSS _09354_/Y NOR2X2
XFILLER_40_539 VSS VDD FILLER2
XTAP_TAPCELL_ROW_22_214 VDD VSS WELLTAP
X_09285_ _20054_/RB _09414_/D VDD VSS _09285_/Y NOR2BX1
XFILLER_138_416 VSS VDD FILLER2
XFILLER_165_246 VDD VSS FILLER4
XFILLER_109_11 VDD VSS DECAPHV16
XTAP_TAPCELL_ROW_30_280 VDD VSS WELLTAP
XFILLER_165_268 VDD VSS FILLER4
XFILLER_106_302 VDD VSS FILLER4
XFILLER_119_696 VSS VDD FILLER2
XFILLER_134_622 VSS VDD FILLER2
XFILLER_106_335 VSS VDD FILLER2
XFILLER_109_88 VDD VSS FILLER4
XFILLER_69_37 VSS VDD FILLER2
XFILLER_106_379 VSS VDD FILLER2
XFILLER_134_688 VSS VDD FILLER2
XFILLER_69_59 VSS VDD FILLER2
XFILLER_125_32 VDD VSS FILLER1
X_10060_ _09915_/B _10159_/B _10131_/A VDD VSS _10062_/B MUXI2X1
XFILLER_102_541 VDD VSS FILLER4
XFILLER_87_241 VSS VDD FILLER2
XFILLER_102_563 VSS VDD FILLER2
XFILLER_102_574 VDD VSS FILLER1
XFILLER_75_458 VSS VDD FILLER2
XFILLER_44_801 VSS VDD FILLER2
X_13750_ _13751_/A _13751_/B _13751_/D _13751_/C VDD VSS _14132_/B OAOI211X1
X_10962_ _10962_/A _10962_/B _10962_/C VDD VSS _10998_/C OAI21X1
XFILLER_16_514 VDD VSS FILLER4
XFILLER_16_525 VSS VDD FILLER2
XFILLER_43_322 VSS VDD FILLER2
X_12701_ _18906_/Q _12701_/B _12701_/C VDD VSS _14118_/B XNOR3X1
X_13681_ _13682_/B _13682_/C _18972_/Q VDD VSS _13688_/B AOI21X1
X_10893_ _10931_/D _10931_/B VDD VSS _10895_/B NAND2BX1
X_15420_ _15674_/A _18138_/B VDD VSS _19293_/D AND2X1
XFILLER_34_40 VDD VSS FILLER4
X_12632_ _12632_/A _12632_/B _12632_/C _12632_/D VDD VSS _12868_/A OAOI211X2
XFILLER_31_528 VSS VDD FILLER2
XFILLER_12_742 VDD VSS FILLER4
X_15351_ _15351_/A _15351_/B _15351_/C VDD VSS _15393_/A OAI21X1
X_12563_ _14441_/B _12654_/C _19157_/Q VDD VSS _12643_/C AND3BX1
XTAP_TAPCELL_ROW_5_55 VDD VSS WELLTAP
XFILLER_129_416 VSS VDD FILLER2
XFILLER_156_202 VDD VSS FILLER4
X_14302_ _14334_/A _14302_/B VDD VSS _19034_/D AND2X1
X_11514_ _18667_/Q _11519_/B VDD VSS _18694_/D AND2X1
XFILLER_7_201 VDD VSS FILLER4
XFILLER_157_747 VSS VDD FILLER2
X_18070_ _19281_/Q _18073_/B VDD VSS _18074_/B XOR2X1
XFILLER_7_212 VSS VDD FILLER2
X_15282_ _15844_/B _15844_/C VDD VSS _15306_/B NOR2X1
X_12494_ _12499_/A _12499_/B _12495_/D _12499_/C VDD VSS _14534_/A OA211X2
XFILLER_157_769 VSS VDD FILLER2
XFILLER_156_235 VSS VDD FILLER2
XFILLER_11_296 VSS VDD FILLER2
XFILLER_156_257 VSS VDD FILLER2
X_17021_ _17838_/A VDD VSS _18187_/C BUFX3
Xwire154 wire154/A VDD VSS wire154/Y BUFX4
Xwire165 wire165/A VDD VSS wire165/Y BUFX6
X_14233_ _14136_/Y _14233_/B _14233_/C VDD VSS _18978_/D AND3BX1
X_11445_ _19940_/Q _17990_/A VDD VSS _18633_/D AND2X1
XFILLER_156_279 VDD VSS FILLER1
Xwire176 wire176/A VDD VSS wire176/Y BUFX6
XFILLER_137_482 VSS VDD FILLER2
XFILLER_50_83 VSS VDD FILLER2
XFILLER_109_184 VSS VDD FILLER2
X_14164_ _14197_/A _14164_/B VDD VSS _18918_/D AND2X1
X_11376_ _11377_/B _11381_/B VDD VSS _11378_/B NOR2BX1
XFILLER_152_441 VSS VDD FILLER2
XFILLER_125_666 VSS VDD FILLER2
XFILLER_140_603 VDD VSS FILLER1
X_13115_ _19107_/Q _14385_/B _14385_/C VDD VSS _13116_/D OR3BX1
X_10327_ _18685_/Q _18739_/Q VDD VSS _10329_/C AND2X1
X_18972_ _18999_/CK _18972_/D _18972_/Q VDD VSS DFFQX1
X_14095_ _14118_/A _17969_/B VDD VSS _18870_/D NOR2X1
XFILLER_152_485 VSS VDD FILLER2
XFILLER_3_473 VSS VDD FILLER2
X_17923_ _17990_/A _17923_/B VDD VSS _19952_/D AND2X1
X_13046_ _20009_/Q _19273_/Q VDD VSS _13054_/D NAND2X1
XFILLER_79_742 VSS VDD FILLER2
XFILLER_105_390 VDD VSS FILLER1
X_10258_ _10266_/C _10258_/B _10258_/C _10258_/D VDD VSS _10264_/A AOI22X1
XFILLER_78_230 VSS VDD FILLER2
XFILLER_59_81 VDD VSS FILLER4
XFILLER_79_764 VDD VSS FILLER4
XFILLER_79_786 VDD VSS FILLER1
X_17854_ _17855_/B _17868_/C VDD VSS _17856_/B NOR2BX1
X_10189_ _10189_/A _10189_/B _10189_/C VDD VSS _10200_/A OAI21X1
XFILLER_78_285 VSS VDD FILLER2
XFILLER_38_116 VSS VDD FILLER2
XFILLER_78_296 VDD VSS FILLER1
X_16805_ _16811_/A _16805_/B VDD VSS _19648_/D NOR2X1
XFILLER_38_138 VDD VSS FILLER1
XFILLER_66_458 VDD VSS FILLER4
X_17785_ _17785_/A _17785_/B _17785_/C VDD VSS _17793_/A OA21X2
XFILLER_54_609 VDD VSS FILLER1
XFILLER_19_330 VSS VDD FILLER2
X_14997_ _15045_/A _15045_/B _15045_/C VDD VSS _15024_/A AOI21X1
XFILLER_81_406 VSS VDD FILLER2
XFILLER_35_801 VSS VDD FILLER2
X_19524_ _19531_/CK _19524_/D _19524_/Q VDD VSS DFFQX1
XFILLER_93_277 VSS VDD FILLER2
X_16736_ _16768_/A _16736_/B VDD VSS _19587_/D AND2X1
XFILLER_75_80 VDD VSS FILLER4
X_13948_ _18949_/Q _14199_/B _14199_/C VDD VSS _13993_/D OR3BX1
XFILLER_93_299 VSS VDD FILLER2
XTAP_TAPCELL_ROW_36_339 VDD VSS WELLTAP
XFILLER_74_491 VSS VDD FILLER2
X_19455_ _19484_/CK _19455_/D _19455_/Q VDD VSS DFFQX1
XFILLER_62_642 VSS VDD FILLER2
X_16667_ _16668_/B _16667_/B _16667_/C VDD VSS _19544_/D AOI21X1
X_13879_ _14163_/A _17940_/B _17940_/C VDD VSS _18864_/D NOR3X1
X_18406_ _18406_/CK _18406_/D _18406_/Q _18450_/RB VDD VSS DFFRQX1
XFILLER_62_686 VSS VDD FILLER2
X_15618_ _15761_/B VDD VSS _15619_/B INVX1
X_19386_ _19465_/CK _19386_/D _19386_/Q VDD VSS DFFQX1
X_16598_ _19605_/Q _16756_/B VDD VSS _16606_/A NOR2X1
XFILLER_61_196 VDD VSS DECAPHV8
XFILLER_15_591 VSS VDD FILLER2
X_18337_ _18341_/CK _18337_/D _18337_/Q _18491_/RB VDD VSS DFFRQX1
XFILLER_91_90 VSS VDD FILLER2
X_15549_ _15574_/B _15549_/B VDD VSS _15822_/B XNOR2X1
X_18268_ _18268_/CK _18268_/D _18268_/Q _18469_/RB VDD VSS DFFRQX1
XTAP_TAPCELL_ROW_138_1257 VDD VSS WELLTAP
X_17219_ _17221_/B _17219_/B VDD VSS _17220_/B XOR2X1
X_18199_ _18199_/A _18199_/B VDD VSS _20015_/D NOR2X1
XFILLER_128_471 VSS VDD FILLER2
XFILLER_115_110 VDD VSS FILLER4
XFILLER_115_132 VDD VSS DECAPHV8
XFILLER_89_506 VDD VSS FILLER1
XFILLER_116_677 VSS VDD FILLER2
XFILLER_143_463 VSS VDD FILLER2
XFILLER_103_305 VSS VDD FILLER2
X_20161_ _20161_/A VDD VSS _20161_/Y BUFX3
XFILLER_89_539 VDD VSS FILLER1
XFILLER_130_102 VDD VSS FILLER4
XFILLER_39_18 VSS VDD FILLER2
XFILLER_103_349 VSS VDD FILLER2
X_20092_ _20092_/A VDD VSS output8/A BUFX3
XFILLER_97_561 VDD VSS DECAPHV8
XFILLER_130_179 VSS VDD FILLER2
XTAP_TAPCELL_ROW_149_1353 VDD VSS WELLTAP
XFILLER_85_723 VSS VDD FILLER2
XFILLER_84_211 VSS VDD FILLER2
XFILLER_72_417 VDD VSS FILLER1
XFILLER_72_428 VDD VSS DECAPHV16
XFILLER_38_694 VSS VDD FILLER2
XFILLER_41_804 VSS VDD FILLER2
XFILLER_111_56 VSS VDD FILLER2
XFILLER_52_152 VSS VDD FILLER2
X_09406_ _09390_/B _13283_/A VDD VSS _230_/E NAND2BX1
XFILLER_53_697 VDD VSS FILLER4
X_09337_ _20073_/RB _09346_/B VDD VSS _09337_/Y NOR2BX1
XFILLER_21_561 VSS VDD FILLER2
XFILLER_138_224 VDD VSS DECAPHV8
XFILLER_139_747 VDD VSS FILLER4
XFILLER_138_235 VDD VSS FILLER4
X_09268_ _18278_/Q _09354_/A VDD VSS _09269_/D NAND2X1
XFILLER_139_769 VSS VDD FILLER2
XFILLER_154_717 VSS VDD FILLER2
XFILLER_138_279 VDD VSS FILLER1
XFILLER_153_205 VDD VSS FILLER4
XFILLER_166_588 VDD VSS DECAPHV16
X_09199_ _18512_/Q VDD VSS _18443_/D INVX1
XFILLER_107_622 VDD VSS FILLER4
XFILLER_147_791 VSS VDD FILLER2
XFILLER_107_633 VDD VSS FILLER1
XFILLER_119_493 VDD VSS FILLER4
X_11230_ _11230_/A _11230_/B VDD VSS _11379_/B OR2X2
XFILLER_4_226 VDD VSS FILLER4
XFILLER_106_132 VDD VSS FILLER4
XFILLER_107_666 VSS VDD FILLER2
XFILLER_4_259 VDD VSS FILLER4
X_11161_ _18682_/Q _18790_/Q VDD VSS _11163_/D XOR2X1
XFILLER_107_699 VSS VDD FILLER2
XFILLER_20_86 VSS VDD FILLER2
XFILLER_122_636 VSS VDD FILLER2
XFILLER_161_282 VSS VDD FILLER2
X_10112_ _10180_/A _11415_/C VDD VSS _18537_/D NOR2X1
XFILLER_96_35 VSS VDD FILLER2
X_11092_ _11118_/A VDD VSS _11298_/A BUFX3
XFILLER_0_443 VDD VSS FILLER1
XFILLER_103_850 VSS VDD FILLER2
XFILLER_121_157 VDD VSS FILLER1
XFILLER_88_550 VSS VDD FILLER2
XTAP_TAPCELL_ROW_78_718 VDD VSS WELLTAP
XFILLER_96_68 VSS VDD FILLER2
XFILLER_0_465 VSS VDD FILLER2
X_14920_ _14920_/A _15833_/B _14920_/C _14920_/D VDD VSS wire162/A OAOI211X1
X_10043_ _18582_/Q _10054_/B VDD VSS _10043_/Y XOR2X1
XFILLER_0_498 VSS VDD FILLER2
XFILLER_102_393 VSS VDD FILLER2
X_14851_ _14851_/A _14855_/C VDD VSS _15679_/B XNOR2X1
X_13802_ _18891_/Q _13802_/B _14132_/C VDD VSS _17924_/C XNOR3X1
X_17570_ _17569_/B _17570_/B VDD VSS _17572_/C NOR2BX1
XTAP_TAPCELL_ROW_86_784 VDD VSS WELLTAP
XFILLER_91_737 VDD VSS FILLER4
XFILLER_63_428 VDD VSS FILLER4
X_14782_ _19474_/Q _15865_/B VDD VSS _14783_/D _15865_/C AND3X2
XFILLER_63_439 VSS VDD FILLER2
X_11994_ _19998_/Q _19262_/Q VDD VSS _12108_/A AND2X1
XTAP_TAPCELL_ROW_126_1150 VDD VSS WELLTAP
XFILLER_90_225 VDD VSS FILLER4
X_16521_ _16505_/B _16521_/B _16521_/C VDD VSS _16546_/B AOI2B1X1
X_13733_ _13733_/A _13733_/B _13733_/C _13733_/D VDD VSS _13735_/C OAI211X1
X_10945_ _10945_/A VDD VSS _10984_/A BUFX3
XTAP_TAPCELL_ROW_33_309 VDD VSS WELLTAP
XFILLER_44_675 VSS VDD FILLER2
XFILLER_32_815 VDD VSS FILLER1
X_19240_ _19269_/CK _19240_/D _19240_/Q VDD VSS DFFQX1
X_16452_ _19600_/Q _16751_/B VDD VSS _16454_/A XNOR2X1
X_13664_ _18888_/Q _14129_/B VDD VSS _13869_/C _14129_/C AND3X2
X_10876_ _11095_/C _10876_/B _10876_/C VDD VSS _10876_/Y OAI21X1
X_15403_ _15434_/A _15434_/B VDD VSS _15882_/B XNOR2X1
X_19171_ _19171_/CK _19171_/D _19171_/Q VDD VSS DFFQX1
X_12615_ _12617_/A _12617_/B _14182_/B VDD VSS _12701_/C XNOR3X1
X_16383_ _16383_/A _16386_/B VDD VSS _16384_/B XOR2X1
X_13595_ _13686_/A _13686_/B _14226_/C VDD VSS _14227_/B AOI21BX1
XFILLER_12_561 VSS VDD FILLER2
XFILLER_157_522 VSS VDD FILLER2
X_18122_ _18132_/A _18122_/B _18123_/C VDD VSS _19998_/D NOR3X1
X_15334_ _15340_/A _15690_/B VDD VSS _15338_/A XNOR2X1
X_12546_ _12557_/A _12546_/B _12546_/C VDD VSS _12634_/C XNOR3X1
XFILLER_12_594 VDD VSS FILLER4
XTAP_TAPCELL_ROW_41_386 VDD VSS WELLTAP
XFILLER_77_7 VSS VDD FILLER2
XFILLER_157_555 VSS VDD FILLER2
XFILLER_8_554 VDD VSS FILLER4
X_18053_ _18547_/Q _18053_/B VDD VSS _18054_/B XOR2X1
X_15265_ _15265_/A _15265_/B _15813_/B VDD VSS _15347_/A MIN3X1
X_12477_ _12483_/A _12483_/B _12483_/D _12483_/C VDD VSS _14439_/C OAI211X1
XANTENNA_4 _18196_/A VDD VSS ANTENNA2
X_17004_ _17002_/Y _17004_/B _17986_/C VDD VSS _19755_/D AND3BX1
XFILLER_6_44 VSS VDD FILLER2
X_14216_ _14218_/A _14216_/B VDD VSS _18965_/D NOR2X1
X_11428_ _18549_/D _11428_/B VDD VSS _18621_/D NOR2BX1
XFILLER_125_441 VDD VSS DECAPHV8
X_15196_ _19456_/Q _15842_/B VDD VSS _15227_/B XOR2X1
XFILLER_99_815 VDD VSS FILLER4
XFILLER_6_77 VDD VSS FILLER4
XFILLER_125_463 VSS VDD FILLER2
XFILLER_140_400 VDD VSS FILLER4
X_14147_ _14154_/A _14147_/B VDD VSS _18903_/D NOR2X1
X_11359_ _11359_/A _11364_/D VDD VSS _11367_/C XOR2X1
XFILLER_153_783 VSS VDD FILLER2
XFILLER_4_793 VSS VDD FILLER2
XFILLER_152_293 VDD VSS FILLER4
Xclkbuf_0__09180_ _18229_/ECK VDD VSS clkbuf_0__09180_/Y BUFX12
X_18955_ _19025_/CK _18955_/D _18955_/Q VDD VSS DFFQX1
X_14078_ _14078_/A _14078_/B _14078_/C VDD VSS _14140_/C OAI21X1
XFILLER_98_369 VSS VDD FILLER2
XFILLER_86_509 VSS VDD FILLER2
XFILLER_112_157 VSS VDD FILLER2
XFILLER_140_477 VDD VSS DECAPHV16
XFILLER_79_561 VSS VDD FILLER2
XFILLER_39_403 VSS VDD FILLER2
XFILLER_112_179 VDD VSS DECAPHV16
X_17906_ _17911_/C _17906_/B _17906_/C VDD VSS _17907_/A AOI2B1X1
X_13029_ _13111_/A _14413_/B _13041_/C VDD VSS _14414_/C OR3BX1
XFILLER_67_723 VDD VSS FILLER1
X_18886_ _18934_/CK _18886_/D _18886_/Q VDD VSS DFFQX1
XFILLER_121_680 VSS VDD FILLER2
XFILLER_94_531 VDD VSS FILLER4
XFILLER_94_542 VSS VDD FILLER2
XFILLER_67_756 VSS VDD FILLER2
X_17837_ _17842_/C _17837_/B VDD VSS _19934_/D NOR2X1
XFILLER_67_778 VDD VSS FILLER4
XFILLER_66_244 VDD VSS FILLER1
XFILLER_66_255 VSS VDD FILLER2
XTAP_TAPCELL_ROW_49_453 VDD VSS WELLTAP
XFILLER_82_715 VDD VSS DECAPHV8
XFILLER_26_108 VSS VDD FILLER2
X_17768_ _19916_/Q _19884_/Q _17768_/C VDD VSS _17773_/C AO21X2
XFILLER_81_214 VSS VDD FILLER2
XFILLER_19_171 VSS VDD FILLER2
XFILLER_81_247 VSS VDD FILLER2
X_16719_ _19923_/Q _16726_/B VDD VSS _19571_/D AND2X1
X_19507_ _19508_/CK _19507_/D _19507_/Q VDD VSS DFFQX1
X_17699_ _19902_/Q _19870_/Q VDD VSS _17700_/B XOR2X1
XFILLER_35_675 VDD VSS DECAPHV16
X_19438_ _19466_/CK _19438_/D _19438_/Q VDD VSS DFFQX1
XFILLER_62_472 VSS VDD FILLER2
X_19369_ _19406_/CK _19369_/D _19369_/Q VDD VSS DFFQX1
XFILLER_22_358 VDD VSS FILLER1
XFILLER_10_509 VSS VDD FILLER2
XFILLER_148_544 VDD VSS FILLER1
XFILLER_148_566 VSS VDD FILLER2
XFILLER_30_391 VDD VSS FILLER1
XFILLER_135_205 VSS VDD FILLER2
XFILLER_151_709 VDD VSS FILLER1
X_20213_ _20213_/A VDD VSS _20213_/Y BUFX3
XFILLER_103_113 VSS VDD FILLER2
XFILLER_116_496 VDD VSS FILLER1
XFILLER_143_282 VSS VDD FILLER2
XFILLER_103_124 VDD VSS FILLER1
XFILLER_131_433 VDD VSS FILLER4
X_20144_ _20144_/A VDD VSS _20144_/Y BUFX3
X_09955_ _09955_/A _09981_/C VDD VSS _11403_/C XOR2X1
XFILLER_106_34 VSS VDD FILLER2
XFILLER_89_369 VSS VDD FILLER2
X_20075_ _20081_/CK _20075_/D _20075_/Q _20075_/RB VDD VSS DFFRQX1
X_09886_ _09925_/B _09884_/Y _10032_/A VDD VSS _09887_/B MUXI2X1
XFILLER_66_49 VSS VDD FILLER2
XFILLER_58_778 VDD VSS FILLER4
XFILLER_45_406 VDD VSS FILLER4
XFILLER_45_417 VDD VSS DECAPHV8
XFILLER_122_22 VSS VDD FILLER2
XFILLER_57_288 VDD VSS FILLER1
XFILLER_26_642 VSS VDD FILLER2
XFILLER_82_26 VDD VSS DECAPHV8
XFILLER_81_770 VSS VDD FILLER2
X_10730_ _10765_/A _10765_/C _10765_/B _10763_/A VDD VSS _10731_/D OAOI211X1
X_10661_ _10960_/A _10661_/B _10661_/C VDD VSS _10709_/B OAI21X1
XFILLER_40_166 VDD VSS FILLER4
X_12400_ _12396_/B _14531_/C _19237_/Q VDD VSS _12401_/D AND3BX1
X_13380_ _13486_/A _13486_/B _13496_/C VDD VSS _17905_/B XNOR3X1
XFILLER_166_330 VSS VDD FILLER2
X_10592_ _10592_/A _10592_/B _10594_/A _10592_/D VDD VSS _10594_/B AOI211X1
XFILLER_127_706 VSS VDD FILLER2
XFILLER_166_363 VDD VSS DECAPHV8
XFILLER_126_205 VSS VDD FILLER2
X_12331_ _12331_/A _12474_/B _12473_/C VDD VSS _12472_/B XNOR3X1
XFILLER_154_514 VSS VDD FILLER2
XFILLER_5_524 VSS VDD FILLER2
XTAP_TAPCELL_ROW_2_34 VDD VSS WELLTAP
XFILLER_147_52 VDD VSS DECAPHV8
X_15050_ _15092_/A _15092_/B _15092_/C VDD VSS _15088_/A AOI21X1
X_12262_ _19042_/Q _12513_/B _14278_/B VDD VSS _12280_/C XNOR3X1
XFILLER_142_709 VDD VSS FILLER4
XFILLER_31_96 VSS VDD FILLER2
XFILLER_147_74 VDD VSS FILLER4
XFILLER_103_0 VSS VDD FILLER2
X_14001_ _14001_/A _14001_/B _14001_/C _14001_/D VDD VSS _14045_/A AOAI211X1
X_11213_ _11289_/A _11213_/B VDD VSS _11214_/C NOR2X1
XFILLER_5_579 VSS VDD FILLER2
XFILLER_147_96 VDD VSS FILLER4
Xoutput6 output6/A VDD VSS miso BUFX3
XFILLER_122_400 VSS VDD FILLER2
XFILLER_134_260 VSS VDD FILLER2
X_12193_ _12199_/A _12199_/B _14208_/B VDD VSS _14177_/B XNOR3X1
XFILLER_107_485 VSS VDD FILLER2
XFILLER_134_271 VDD VSS FILLER1
Xoutput30 _20114_/Y VDD VSS o_bias_cfg[16] BUFX3
Xoutput41 _20124_/Y VDD VSS o_bias_cfg[26] BUFX3
Xoutput52 _20102_/Y VDD VSS o_bias_cfg[4] BUFX3
X_11144_ _11171_/C _11144_/B _11144_/C _11208_/A VDD VSS _11149_/B AOI2B2X1
Xoutput63 _20147_/Y VDD VSS o_clk_cfg[14] BUFX3
Xoutput74 _20140_/Y VDD VSS o_clk_cfg[7] BUFX3
XFILLER_68_509 VSS VDD FILLER2
Xoutput85 _20159_/Y VDD VSS o_en_ctrl[7] BUFX3
Xoutput96 _20165_/Y VDD VSS o_lf_cfg[2] BUFX3
X_18740_ _18767_/CK _18740_/D _18740_/Q VDD VSS DFFQX1
XFILLER_0_262 VSS VDD FILLER2
XFILLER_110_639 VDD VSS FILLER4
X_15952_ _19642_/Q _16797_/B VDD VSS _15979_/A NOR2BX1
X_11075_ _11075_/A _11099_/C VDD VSS _11076_/C XNOR2X1
XFILLER_95_328 VDD VSS FILLER4
XFILLER_0_273 VSS VDD FILLER2
XFILLER_122_499 VSS VDD FILLER2
XFILLER_95_339 VSS VDD FILLER2
XFILLER_103_691 VSS VDD FILLER2
XFILLER_76_531 VDD VSS FILLER4
X_14903_ _19393_/Q VDD VSS _14904_/A INVX1
X_10026_ _10026_/A _10026_/B _10026_/C VDD VSS _10050_/B OAI21X1
XFILLER_76_542 VSS VDD FILLER2
X_18671_ _19940_/CK _18671_/D _18671_/Q VDD VSS DFFQX1
X_15883_ _15895_/A _15883_/B VDD VSS _19490_/D NOR2X1
X_17622_ _17625_/C _17623_/B _17654_/C VDD VSS _17623_/C OAI21X1
X_14834_ _14908_/A _14908_/B _14867_/C VDD VSS _14861_/B AOI21BX1
XFILLER_64_737 VSS VDD FILLER2
XFILLER_63_225 VDD VSS FILLER1
XTAP_TAPCELL_ROW_46_423 VDD VSS WELLTAP
XFILLER_56_82 VSS VDD FILLER2
X_17553_ _19871_/Q _19839_/Q VDD VSS _17554_/B XOR2X1
XFILLER_63_258 VSS VDD FILLER2
X_14765_ _14768_/A _14765_/B VDD VSS _18059_/B XNOR2X1
XFILLER_91_578 VDD VSS FILLER4
XFILLER_51_409 VSS VDD FILLER2
X_11977_ _12029_/A _12029_/B _12029_/C VDD VSS _11999_/B AOI21X1
XFILLER_32_601 VSS VDD FILLER2
XFILLER_17_675 VDD VSS FILLER1
XFILLER_16_152 VSS VDD FILLER2
X_16504_ _19634_/Q _16788_/B VDD VSS _16505_/B XNOR2X1
X_13716_ _13716_/A _13716_/B _13716_/C _13716_/D VDD VSS _13857_/A OAOI211X1
X_17484_ _19855_/Q _19823_/Q _17484_/C VDD VSS _17488_/B MIN3X1
X_10928_ _10962_/A _10962_/B _10928_/C VDD VSS _10944_/A OAI21X1
X_14696_ _19388_/Q _14696_/B _15766_/B VDD VSS _14758_/B MIN3X1
X_19223_ _19223_/CK _19223_/D _19223_/Q VDD VSS DFFQX1
XFILLER_32_656 VDD VSS FILLER4
X_16435_ _19695_/Q _16856_/B VDD VSS _16437_/C XNOR2X1
XFILLER_20_807 VSS VDD FILLER2
X_13647_ _13727_/A _13728_/B _13728_/C VDD VSS _13649_/C OR3BX1
X_10859_ _18699_/Q VDD VSS _11550_/A INVX1
X_19154_ _19185_/CK _19154_/D _19154_/Q VDD VSS DFFQX1
X_16366_ _19596_/Q _16366_/B _16746_/B VDD VSS _16398_/A MIN3X1
X_13578_ _13578_/A _13578_/B _13578_/C _13578_/D VDD VSS _13591_/B AOAI211X1
XFILLER_118_717 VDD VSS FILLER1
X_18105_ _18105_/A _18105_/B _18105_/C VDD VSS _19995_/D AOI21X1
XFILLER_75_4 VDD VSS FILLER1
X_15317_ _15359_/D _15359_/C VDD VSS _15354_/C NAND2BX1
X_19085_ _19086_/CK _19085_/D _19085_/Q VDD VSS DFFQX1
X_12529_ _12612_/A _12532_/B _12532_/C VDD VSS _17868_/B XNOR3X1
XFILLER_145_525 VDD VSS DECAPHV8
X_16297_ _16308_/C _16297_/B VDD VSS _16851_/B AND2X1
XTAP_TAPCELL_ROW_135_1227 VDD VSS WELLTAP
X_18036_ _18538_/Q _18036_/B _18539_/Q VDD VSS _18037_/C AOI21X1
X_15248_ _15265_/A _15265_/B _15813_/B VDD VSS _15781_/B XNOR3X1
XFILLER_113_411 VSS VDD FILLER2
X_15179_ _19427_/Q _15811_/B VDD VSS _15180_/C NOR2BX1
XFILLER_113_422 VDD VSS FILLER4
XFILLER_125_282 VSS VDD FILLER2
XFILLER_98_133 VDD VSS FILLER4
XFILLER_140_230 VSS VDD FILLER2
XFILLER_87_818 VSS VDD FILLER2
X_19987_ _19996_/CK _19987_/D _19987_/Q VDD VSS DFFQX1
XFILLER_98_166 VSS VDD FILLER2
XFILLER_101_628 VSS VDD FILLER2
X_09740_ _09753_/D _09740_/B _09740_/C _09819_/A VDD VSS _09741_/E OAI22X1
XFILLER_86_328 VDD VSS DECAPHV8
XFILLER_140_285 VSS VDD FILLER2
X_18938_ _18939_/CK _18938_/D _18938_/Q VDD VSS DFFQX1
.ends
