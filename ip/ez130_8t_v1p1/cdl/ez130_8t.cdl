************************************************************************
*
* Copyright 2026 ETH Zurich
*
* Licensed under the Apache License, Version 2.0 (the "License");
* you may not use this file except in compliance with the License.
* You may obtain a copy of the License at
*
*     http://www.apache.org/licenses/LICENSE-2.0
*
* Unless required by applicable law or agreed to in writing, software
* distributed under the License is distributed on an "AS IS" BASIS,
* WITHOUT WARRANTIES OR CONDITIONS OF ANY KIND, either express or implied.
* See the License for the specific language governing permissions and
* limitations under the License.
*
************************************************************************

************************************************************************
*
* If you use the EZ130 8T library (or parts of it),
* then please cite this reference:
*
* @article{castaneda2026ez130t8,
*   author = {Casta\~neda, Oscar and Recchioni, Lavinia and
*     Senti, Tobias and Cahenzli, Flurin and Ferroni, Marco and
*     Heekenjann, Thorben and Kenter, Robert and Odermatt, Stefan and
*     Richner, Daniel and Altendorfer, Gabriel and Cannone, Davide and
*     Correa, Miguel and Herger, Ivan and Kr\"oger, Lars and
*     Nanzer, Nicolas and Nonaca, Darja and Reinwardt, Christopher and
*     Winklhofer, Lukas and Zelioli, Enrico and Zhang, Yiheng and
*     Zhang, Yingxue and Keller, Domenic and Mirfarshbafan, Seyed Hadi
*     and Jiang, Zerun and Muheim, Beat and Rubino, Arianna and
*     Guichemerre, J\'er\'emy and G\"urkaynak, Frank K. and
*     Studer, Christoph},
*   title = {An Open-Source Standard-Cell Library for {IHP} 130\,nm
*     Developed by Students},
*   journal = {arXiv preprint arXiv:XXXX.XXXXX},
*   month = {September},
*   year = {2026},
*   url = {https://arxiv.org/abs/????}
* }
*
************************************************************************

************************************************************************
* auCdl Netlist:
*
* Library Name:  ez130_8t
************************************************************************

*.BIPOLAR
*.RESI = 2000
*.RESVAL
*.CAPVAL
*.DIOPERI
*.DIOAREA
*.EQUATION
*.SCALE METER
*.MEGA
.PARAM

************************************************************************
* Library Name: ez130_8t
* Cell Name:    WELLTAP
* View Name:    schematic
************************************************************************

.SUBCKT WELLTAP VDD VNW VPW VSS
*.PININFO VDD:B VNW:B VPW:B VSS:B
*.CONNECT VPW VSS
*.CONNECT VNW VDD
.ENDS

************************************************************************
* Library Name: ez130_8t
* Cell Name:    AND2X1
* View Name:    schematic
************************************************************************

.SUBCKT AND2X1 A B VDD VNW VPW VSS Y
*.PININFO A:I B:I Y:O VDD:B VNW:B VPW:B VSS:B
MN3 Y net6 VSS VPW sg13_lv_nmos m=1 w=300.0n l=130.00n ng=1
MN0 net6 A net7 VPW sg13_lv_nmos m=1 w=300.0n l=130.00n ng=1
MN1 net7 B VSS VPW sg13_lv_nmos m=1 w=300.0n l=130.00n ng=1
MP2 Y net6 VDD VNW sg13_lv_pmos m=1 w=480.00n l=130.00n ng=1
MP1 net6 B VDD VNW sg13_lv_pmos m=1 w=480.00n l=130.00n ng=1
MP0 net6 A VDD VNW sg13_lv_pmos m=1 w=480.00n l=130.00n ng=1
.ENDS

************************************************************************
* Library Name: ez130_8t
* Cell Name:    AND2X1P5
* View Name:    schematic
************************************************************************

.SUBCKT AND2X1P5 A B VDD VNW VPW VSS Y
*.PININFO A:I B:I Y:O VDD:B VNW:B VPW:B VSS:B
MN3 Y net6 VSS VPW sg13_lv_nmos m=1 w=480.00n l=130.00n ng=1
MN0 net6 A net7 VPW sg13_lv_nmos m=1 w=300.0n l=130.00n ng=1
MN1 net7 B VSS VPW sg13_lv_nmos m=1 w=300.0n l=130.00n ng=1
MP2 Y net6 VDD VNW sg13_lv_pmos m=1 w=720.00n l=130.00n ng=1
MP1 net6 B VDD VNW sg13_lv_pmos m=1 w=480.00n l=130.00n ng=1
MP0 net6 A VDD VNW sg13_lv_pmos m=1 w=480.00n l=130.00n ng=1
.ENDS

************************************************************************
* Library Name: ez130_8t
* Cell Name:    AND2X2
* View Name:    schematic
************************************************************************

.SUBCKT AND2X2 A B VDD VNW VPW VSS Y
*.PININFO A:I B:I Y:O VDD:B VNW:B VPW:B VSS:B
MN3 Y net6 VSS VPW sg13_lv_nmos m=1 w=640.00n l=130.00n ng=1
MN0 net6 A net7 VPW sg13_lv_nmos m=1 w=300.0n l=130.00n ng=1
MN1 net7 B VSS VPW sg13_lv_nmos m=1 w=300.0n l=130.00n ng=1
MP2 Y net6 VDD VNW sg13_lv_pmos m=1 w=980.00n l=130.00n ng=1
MP1 net6 B VDD VNW sg13_lv_pmos m=1 w=480.00n l=130.00n ng=1
MP0 net6 A VDD VNW sg13_lv_pmos m=1 w=480.00n l=130.00n ng=1
.ENDS

************************************************************************
* Library Name: ez130_8t
* Cell Name:    AND2X3
* View Name:    schematic
************************************************************************

.SUBCKT AND2X3 A B VDD VNW VPW VSS Y
*.PININFO A:I B:I Y:O VDD:B VNW:B VPW:B VSS:B
MN3 Y net6 VSS VPW sg13_lv_nmos m=1 w=860.00n l=130.00n ng=1
MN0 net6 A net7 VPW sg13_lv_nmos m=1 w=300.0n l=130.00n ng=1
MN1 net7 B VSS VPW sg13_lv_nmos m=1 w=300.0n l=130.00n ng=1
MP2 Y net6 VDD VNW sg13_lv_pmos m=1 w=1.32u l=130.00n ng=1
MP1 net6 B VDD VNW sg13_lv_pmos m=1 w=480.00n l=130.00n ng=1
MP0 net6 A VDD VNW sg13_lv_pmos m=1 w=480.00n l=130.00n ng=1
.ENDS

************************************************************************
* Library Name: ez130_8t
* Cell Name:    AND3X1
* View Name:    schematic
************************************************************************

.SUBCKT AND3X1 A B VDD VNW VPW VSS Y C
*.PININFO A:I B:I C:I Y:O VDD:B VNW:B VPW:B VSS:B
MN4 net1 C VSS VPW sg13_lv_nmos m=1 w=300.0n l=130.00n ng=1
MN3 Y net6 VSS VPW sg13_lv_nmos m=1 w=300.0n l=130.00n ng=1
MN0 net6 A net7 VPW sg13_lv_nmos m=1 w=300.0n l=130.00n ng=1
MN1 net7 B net1 VPW sg13_lv_nmos m=1 w=300.0n l=130.00n ng=1
MP2 Y net6 VDD VNW sg13_lv_pmos m=1 w=480.00n l=130.00n ng=1
MP1 net6 B VDD VNW sg13_lv_pmos m=1 w=480.00n l=130.00n ng=1
MP0 net6 A VDD VNW sg13_lv_pmos m=1 w=480.00n l=130.00n ng=1
MP3 net6 C VDD VNW sg13_lv_pmos m=1 w=480.00n l=130.00n ng=1
.ENDS

************************************************************************
* Library Name: ez130_8t
* Cell Name:    AND3X2
* View Name:    schematic
************************************************************************

.SUBCKT AND3X2 A B VDD VNW VPW VSS Y C
*.PININFO A:I B:I C:I Y:O VDD:B VNW:B VPW:B VSS:B
MN4 net1 C VSS VPW sg13_lv_nmos m=1 w=300.0n l=130.00n ng=1
MN3 Y net6 VSS VPW sg13_lv_nmos m=1 w=640.00n l=130.00n ng=1
MN0 net6 A net7 VPW sg13_lv_nmos m=1 w=300.0n l=130.00n ng=1
MN1 net7 B net1 VPW sg13_lv_nmos m=1 w=300.0n l=130.00n ng=1
MP2 Y net6 VDD VNW sg13_lv_pmos m=1 w=980.00n l=130.00n ng=1
MP1 net6 B VDD VNW sg13_lv_pmos m=1 w=480.00n l=130.00n ng=1
MP0 net6 A VDD VNW sg13_lv_pmos m=1 w=480.00n l=130.00n ng=1
MP3 net6 C VDD VNW sg13_lv_pmos m=1 w=480.00n l=130.00n ng=1
.ENDS

************************************************************************
* Library Name: ez130_8t
* Cell Name:    AND3BX1
* View Name:    schematic
************************************************************************

.SUBCKT AND3BX1 AB B C VDD VNW VPW VSS Y
*.PININFO AB:I B:I C:I Y:O VDD:B VNW:B VPW:B VSS:B
MP3 net9 C VDD VNW sg13_lv_pmos m=1 w=480.00n l=130.00n ng=1
MP2 net9 B VDD VNW sg13_lv_pmos m=1 w=480.00n l=130.00n ng=1
MP1 Y AB net1 VNW sg13_lv_pmos m=1 w=480.00n l=130.00n ng=1
MP0 net1 net9 VDD VNW sg13_lv_pmos m=1 w=480.00n l=130.00n ng=1
MN2 net10 C VSS VPW sg13_lv_nmos m=1 w=300.0n l=130.00n ng=1
MN1 net9 B net10 VPW sg13_lv_nmos m=1 w=300.0n l=130.00n ng=1
MN0 Y net9 VSS VPW sg13_lv_nmos m=1 w=300.0n l=130.00n ng=1
MN3 Y AB VSS VPW sg13_lv_nmos m=1 w=300.0n l=130.00n ng=1
.ENDS

************************************************************************
* Library Name: ez130_8t
* Cell Name:    AND3BX2
* View Name:    schematic
************************************************************************

.SUBCKT AND3BX2 AB B C VDD VNW VPW VSS Y
*.PININFO AB:I B:I C:I Y:O VDD:B VNW:B VPW:B VSS:B
MP3 net9 C VDD VNW sg13_lv_pmos m=1 w=480.00n l=130.00n ng=1
MP2 net9 B VDD VNW sg13_lv_pmos m=1 w=480.00n l=130.00n ng=1
MP1 Y AB net1 VNW sg13_lv_pmos m=1 w=980.00n l=130.00n ng=1
MP0 net1 net9 VDD VNW sg13_lv_pmos m=1 w=980.00n l=130.00n ng=1
MN2 net10 C VSS VPW sg13_lv_nmos m=1 w=300.0n l=130.00n ng=1
MN1 net9 B net10 VPW sg13_lv_nmos m=1 w=300.0n l=130.00n ng=1
MN0 Y net9 VSS VPW sg13_lv_nmos m=1 w=640.00n l=130.00n ng=1
MN3 Y AB VSS VPW sg13_lv_nmos m=1 w=640.00n l=130.00n ng=1
.ENDS

************************************************************************
* Library Name: ez130_8t
* Cell Name:    AND4X1
* View Name:    schematic
************************************************************************

.SUBCKT AND4X1 A B C D VDD VNW VPW VSS Y
*.PININFO A:I B:I C:I D:I Y:O VDD:B VNW:B VPW:B VSS:B
MN4 Y net4 VSS VPW sg13_lv_nmos m=1 w=300.0n l=130.00n ng=1
MN3 net3 D VSS VPW sg13_lv_nmos m=1 w=300.0n l=130.00n ng=1
MN2 net1 C net3 VPW sg13_lv_nmos m=1 w=300.0n l=130.00n ng=1
MN1 net4 A net2 VPW sg13_lv_nmos m=1 w=300.0n l=130.00n ng=1
MN0 net2 B net1 VPW sg13_lv_nmos m=1 w=300.0n l=130.00n ng=1
MP4 Y net4 VDD VNW sg13_lv_pmos m=1 w=480.00n l=130.00n ng=1
MP3 net4 B VDD VNW sg13_lv_pmos m=1 w=480.00n l=130.00n ng=1
MP2 net4 A VDD VNW sg13_lv_pmos m=1 w=480.00n l=130.00n ng=1
MP1 net4 C VDD VNW sg13_lv_pmos m=1 w=480.00n l=130.00n ng=1
MP0 net4 D VDD VNW sg13_lv_pmos m=1 w=480.00n l=130.00n ng=1
.ENDS

************************************************************************
* Library Name: ez130_8t
* Cell Name:    AND4X2
* View Name:    schematic
************************************************************************

.SUBCKT AND4X2 A B C D VDD VNW VPW VSS Y
*.PININFO A:I B:I C:I D:I Y:O VDD:B VNW:B VPW:B VSS:B
MN4 Y net4 VSS VPW sg13_lv_nmos m=1 w=640.00n l=130.00n ng=1
MN3 net3 D VSS VPW sg13_lv_nmos m=1 w=300.0n l=130.00n ng=1
MN2 net1 C net3 VPW sg13_lv_nmos m=1 w=300.0n l=130.00n ng=1
MN1 net4 A net2 VPW sg13_lv_nmos m=1 w=300.0n l=130.00n ng=1
MN0 net2 B net1 VPW sg13_lv_nmos m=1 w=300.0n l=130.00n ng=1
MP4 Y net4 VDD VNW sg13_lv_pmos m=1 w=980.00n l=130.00n ng=1
MP3 net4 B VDD VNW sg13_lv_pmos m=1 w=480.00n l=130.00n ng=1
MP2 net4 A VDD VNW sg13_lv_pmos m=1 w=480.00n l=130.00n ng=1
MP1 net4 C VDD VNW sg13_lv_pmos m=1 w=480.00n l=130.00n ng=1
MP0 net4 D VDD VNW sg13_lv_pmos m=1 w=480.00n l=130.00n ng=1
.ENDS

************************************************************************
* Library Name: ez130_8t
* Cell Name:    ANTENNA2
* View Name:    schematic
************************************************************************

.SUBCKT ANTENNA2 A VDD VNW VPW VSS
*.PININFO A:I VDD:B VNW:B VPW:B VSS:B
DD0 VPW A dantenna m=1 w=630n l=840n a=529.2f p=2.94u
.ENDS

************************************************************************
* Library Name: ez130_8t
* Cell Name:    ANTENNA4
* View Name:    schematic
************************************************************************

.SUBCKT ANTENNA4 A VDD VNW VPW VSS
*.PININFO A:I VDD:B VNW:B VPW:B VSS:B
DD0 VPW A dantenna m=1 w=1.47u l=900n a=1.323p p=4.74u
.ENDS

************************************************************************
* Library Name: ez130_8t
* Cell Name:    ANTENNA8
* View Name:    schematic
************************************************************************

.SUBCKT ANTENNA8 A VDD VNW VPW VSS
*.PININFO A:I VDD:B VNW:B VPW:B VSS:B
DD0 VPW A dantenna m=1 w=1.9u l=2.34u a=4.446p p=8.48u
.ENDS

************************************************************************
* Library Name: ez130_8t
* Cell Name:    AO22X1
* View Name:    schematic
************************************************************************

.SUBCKT AO22X1 A B C D VDD VNW VPW VSS Y
*.PININFO A:I B:I C:I D:I Y:O VDD:B VNW:B VPW:B VSS:B
MN3 net1 C VSS VPW sg13_lv_nmos m=1 w=300.0n l=130.00n ng=1
MN2 net2 D net1 VPW sg13_lv_nmos m=1 w=300.0n l=130.00n ng=1
MN1 net9 A VSS VPW sg13_lv_nmos m=1 w=300.0n l=130.00n ng=1
MN0 net2 B net9 VPW sg13_lv_nmos m=1 w=300.0n l=130.00n ng=1
MN4 Y net2 VSS VPW sg13_lv_nmos m=1 w=300.0n l=130.00n ng=1
MP4 Y net2 VDD VNW sg13_lv_pmos m=1 w=480.00n l=130.00n ng=1
MP3 net3 B VDD VNW sg13_lv_pmos m=1 w=480.00n l=130.00n ng=1
MP2 net2 D net3 VNW sg13_lv_pmos m=1 w=480.00n l=130.00n ng=1
MP1 net3 A VDD VNW sg13_lv_pmos m=1 w=480.00n l=130.00n ng=1
MP0 net2 C net3 VNW sg13_lv_pmos m=1 w=480.00n l=130.00n ng=1
.ENDS

************************************************************************
* Library Name: ez130_8t
* Cell Name:    AO22X2
* View Name:    schematic
************************************************************************

.SUBCKT AO22X2 A B C D VDD VNW VPW VSS Y
*.PININFO A:I B:I C:I D:I Y:O VDD:B VNW:B VPW:B VSS:B
MN3 net1 C VSS VPW sg13_lv_nmos m=1 w=300.0n l=130.00n ng=1
MN2 net2 D net1 VPW sg13_lv_nmos m=1 w=300.0n l=130.00n ng=1
MN1 net9 A VSS VPW sg13_lv_nmos m=1 w=300.0n l=130.00n ng=1
MN0 net2 B net9 VPW sg13_lv_nmos m=1 w=300.0n l=130.00n ng=1
MN4 Y net2 VSS VPW sg13_lv_nmos m=1 w=640.00n l=130.00n ng=1
MP4 Y net2 VDD VNW sg13_lv_pmos m=1 w=980.00n l=130.00n ng=1
MP3 net3 B VDD VNW sg13_lv_pmos m=1 w=480.00n l=130.00n ng=1
MP2 net2 D net3 VNW sg13_lv_pmos m=1 w=480.00n l=130.00n ng=1
MP1 net3 A VDD VNW sg13_lv_pmos m=1 w=480.00n l=130.00n ng=1
MP0 net2 C net3 VNW sg13_lv_pmos m=1 w=480.00n l=130.00n ng=1
.ENDS

************************************************************************
* Library Name: ez130_8t
* Cell Name:    AO21X2
* View Name:    schematic
************************************************************************

.SUBCKT AO21X2 A B C VDD VNW VPW VSS Y
*.PININFO A:I B:I C:I Y:O VDD:B VNW:B VPW:B VSS:B
MN3 net3 C VSS VPW sg13_lv_nmos m=1 w=300.0n l=130.00n ng=1
MN1 net9 A VSS VPW sg13_lv_nmos m=1 w=300.0n l=130.00n ng=1
MN0 net3 B net9 VPW sg13_lv_nmos m=1 w=300.0n l=130.00n ng=1
MN4 Y net3 VSS VPW sg13_lv_nmos m=1 w=640.00n l=130.00n ng=1
MP4 Y net3 VDD VNW sg13_lv_pmos m=1 w=980.00n l=130.00n ng=1
MP3 net3 B net2 VNW sg13_lv_pmos m=1 w=480.00n l=130.00n ng=1
MP1 net3 A net2 VNW sg13_lv_pmos m=1 w=480.00n l=130.00n ng=1
MP0 net2 C VDD VNW sg13_lv_pmos m=1 w=480.00n l=130.00n ng=1
.ENDS

************************************************************************
* Library Name: ez130_8t
* Cell Name:    AO211X1
* View Name:    schematic
************************************************************************

.SUBCKT AO211X1 A B C D VDD VNW VPW VSS Y
*.PININFO A:I B:I C:I D:I Y:O VDD:B VNW:B VPW:B VSS:B
MN3 net4 C VSS VPW sg13_lv_nmos m=1 w=300.0n l=130.00n ng=1
MN2 net4 D VSS VPW sg13_lv_nmos m=1 w=300.0n l=130.00n ng=1
MN1 net9 B VSS VPW sg13_lv_nmos m=1 w=300.0n l=130.00n ng=1
MN0 net4 A net9 VPW sg13_lv_nmos m=1 w=300.0n l=130.00n ng=1
MN4 Y net4 VSS VPW sg13_lv_nmos m=1 w=300.0n l=130.00n ng=1
MP4 Y net4 VDD VNW sg13_lv_pmos m=1 w=480.00n l=130.00n ng=1
MP3 net4 B net5 VNW sg13_lv_pmos m=1 w=480.00n l=130.00n ng=1
MP2 net3 D VDD VNW sg13_lv_pmos m=1 w=480.00n l=130.00n ng=1
MP1 net4 A net5 VNW sg13_lv_pmos m=1 w=480.00n l=130.00n ng=1
MP0 net5 C net3 VNW sg13_lv_pmos m=1 w=480.00n l=130.00n ng=1
.ENDS

************************************************************************
* Library Name: ez130_8t
* Cell Name:    AO211X2
* View Name:    schematic
************************************************************************

.SUBCKT AO211X2 A B C D VDD VNW VPW VSS Y
*.PININFO A:I B:I C:I D:I Y:O VDD:B VNW:B VPW:B VSS:B
MN3 net4 C VSS VPW sg13_lv_nmos m=1 w=300.0n l=130.00n ng=1
MN2 net4 D VSS VPW sg13_lv_nmos m=1 w=300.0n l=130.00n ng=1
MN1 net9 B VSS VPW sg13_lv_nmos m=1 w=300.0n l=130.00n ng=1
MN0 net4 A net9 VPW sg13_lv_nmos m=1 w=300.0n l=130.00n ng=1
MN4 Y net4 VSS VPW sg13_lv_nmos m=1 w=640.00n l=130.00n ng=1
MP4 Y net4 VDD VNW sg13_lv_pmos m=1 w=980.00n l=130.00n ng=1
MP3 net4 B net5 VNW sg13_lv_pmos m=1 w=480.00n l=130.00n ng=1
MP2 net3 D VDD VNW sg13_lv_pmos m=1 w=480.00n l=130.00n ng=1
MP1 net4 A net5 VNW sg13_lv_pmos m=1 w=480.00n l=130.00n ng=1
MP0 net5 C net3 VNW sg13_lv_pmos m=1 w=480.00n l=130.00n ng=1
.ENDS

************************************************************************
* Library Name: ez130_8t
* Cell Name:    AO31X1
* View Name:    schematic
************************************************************************

.SUBCKT AO31X1 A B C D VDD VNW VPW VSS Y
*.PININFO A:I B:I C:I D:I Y:O VDD:B VNW:B VPW:B VSS:B
MP4 Y net2 VDD VNW sg13_lv_pmos m=1 w=480.00n l=130.00n ng=1
MP3 net2 D net1 VNW sg13_lv_pmos m=1 w=480.00n l=130.00n ng=1
MP2 net1 C VDD VNW sg13_lv_pmos m=1 w=480.00n l=130.00n ng=1
MP1 net1 B VDD VNW sg13_lv_pmos m=1 w=480.00n l=130.00n ng=1
MP0 net1 A VDD VNW sg13_lv_pmos m=1 w=480.00n l=130.00n ng=1
MN4 Y net2 VSS VPW sg13_lv_nmos m=1 w=300.0n l=130.00n ng=1
MN3 net2 D VSS VPW sg13_lv_nmos m=1 w=300.0n l=130.00n ng=1
MN2 net4 C VSS VPW sg13_lv_nmos m=1 w=300.0n l=130.00n ng=1
MN1 net3 B net4 VPW sg13_lv_nmos m=1 w=300.0n l=130.00n ng=1
MN0 net2 A net3 VPW sg13_lv_nmos m=1 w=300.0n l=130.00n ng=1
.ENDS

************************************************************************
* Library Name: ez130_8t
* Cell Name:    AO31X2
* View Name:    schematic
************************************************************************

.SUBCKT AO31X2 A B C D VDD VNW VPW VSS Y
*.PININFO A:I B:I C:I D:I Y:O VDD:B VNW:B VPW:B VSS:B
MP4 Y net2 VDD VNW sg13_lv_pmos m=1 w=980.00n l=130.00n ng=1
MP3 net2 D net1 VNW sg13_lv_pmos m=1 w=480.00n l=130.00n ng=1
MP2 net1 C VDD VNW sg13_lv_pmos m=1 w=480.00n l=130.00n ng=1
MP1 net1 B VDD VNW sg13_lv_pmos m=1 w=480.00n l=130.00n ng=1
MP0 net1 A VDD VNW sg13_lv_pmos m=1 w=480.00n l=130.00n ng=1
MN4 Y net2 VSS VPW sg13_lv_nmos m=1 w=640.00n l=130.00n ng=1
MN3 net2 D VSS VPW sg13_lv_nmos m=1 w=300.0n l=130.00n ng=1
MN2 net4 C VSS VPW sg13_lv_nmos m=1 w=300.0n l=130.00n ng=1
MN1 net3 B net4 VPW sg13_lv_nmos m=1 w=300.0n l=130.00n ng=1
MN0 net2 A net3 VPW sg13_lv_nmos m=1 w=300.0n l=130.00n ng=1
.ENDS

************************************************************************
* Library Name: ez130_8t
* Cell Name:    AOI2B1X1
* View Name:    schematic
************************************************************************

.SUBCKT AOI2B1X1 AB B C VDD VNW VPW VSS Y
*.PININFO AB:I B:I C:I Y:O VDD:B VNW:B VPW:B VSS:B
MN3 Y A net10 VPW sg13_lv_nmos m=1 w=300.0n l=130.00n ng=1
MN0 A AB VSS VPW sg13_lv_nmos m=1 w=300.0n l=130.00n ng=1
MN2 net10 B VSS VPW sg13_lv_nmos m=1 w=300.0n l=130.00n ng=1
MN1 Y C VSS VPW sg13_lv_nmos m=1 w=300.0n l=130.00n ng=1
MP3 net9 C VDD VNW sg13_lv_pmos m=1 w=480.00n l=130.00n ng=1
MP2 Y B net9 VNW sg13_lv_pmos m=1 w=480.00n l=130.00n ng=1
MP1 Y A net9 VNW sg13_lv_pmos m=1 w=480.00n l=130.00n ng=1
MP0 A AB VDD VNW sg13_lv_pmos m=1 w=480.00n l=130.00n ng=1
.ENDS

************************************************************************
* Library Name: ez130_8t
* Cell Name:    AOI2B1X2
* View Name:    schematic
************************************************************************

.SUBCKT AOI2B1X2 AB B C VDD VNW VPW VSS Y
*.PININFO AB:I B:I C:I Y:O VDD:B VNW:B VPW:B VSS:B
MN3 Y A net10 VPW sg13_lv_nmos m=1 w=640.00n l=130.00n ng=1
MN0 A AB VSS VPW sg13_lv_nmos m=1 w=300.0n l=130.00n ng=1
MN2 net10 B VSS VPW sg13_lv_nmos m=1 w=640.00n l=130.00n ng=1
MN1 Y C VSS VPW sg13_lv_nmos m=1 w=640.00n l=130.00n ng=1
MP3 net9 C VDD VNW sg13_lv_pmos m=1 w=980.00n l=130.00n ng=1
MP2 Y B net9 VNW sg13_lv_pmos m=1 w=980.00n l=130.00n ng=1
MP1 Y A net9 VNW sg13_lv_pmos m=1 w=980.00n l=130.00n ng=1
MP0 A AB VDD VNW sg13_lv_pmos m=1 w=480.00n l=130.00n ng=1
.ENDS

************************************************************************
* Library Name: ez130_8t
* Cell Name:    AOI21BX1
* View Name:    schematic
************************************************************************

.SUBCKT AOI21BX1 A B CB VDD VNW VPW VSS Y
*.PININFO A:I B:I CB:I Y:O VDD:B VNW:B VPW:B VSS:B
MN0 C CB VSS VPW sg13_lv_nmos m=1 w=300.0n l=130.00n ng=1
MN3 Y A net10 VPW sg13_lv_nmos m=1 w=300.0n l=130.00n ng=1
MN2 net10 B VSS VPW sg13_lv_nmos m=1 w=300.0n l=130.00n ng=1
MN1 Y C VSS VPW sg13_lv_nmos m=1 w=300.0n l=130.00n ng=1
MP0 C CB VDD VNW sg13_lv_pmos m=1 w=480.00n l=130.00n ng=1
MP3 net9 C VDD VNW sg13_lv_pmos m=1 w=480.00n l=130.00n ng=1
MP2 Y B net9 VNW sg13_lv_pmos m=1 w=480.00n l=130.00n ng=1
MP1 Y A net9 VNW sg13_lv_pmos m=1 w=480.00n l=130.00n ng=1
.ENDS

************************************************************************
* Library Name: ez130_8t
* Cell Name:    AOI21BX2
* View Name:    schematic
************************************************************************

.SUBCKT AOI21BX2 A B CB VDD VNW VPW VSS Y
*.PININFO A:I B:I CB:I Y:O VDD:B VNW:B VPW:B VSS:B
MN3 Y A net1 VPW sg13_lv_nmos m=1 w=640.00n l=130.00n ng=1
MN2 net1 B VSS VPW sg13_lv_nmos m=1 w=640.00n l=130.00n ng=1
MN1 Y C VSS VPW sg13_lv_nmos m=1 w=640.00n l=130.00n ng=1
MN0 C CB VSS VPW sg13_lv_nmos m=1 w=300.0n l=130.00n ng=1
MP3 net2 C VDD VNW sg13_lv_pmos m=1 w=980.00n l=130.00n ng=1
MP2 Y B net2 VNW sg13_lv_pmos m=1 w=980.00n l=130.00n ng=1
MP1 Y A net2 VNW sg13_lv_pmos m=1 w=980.00n l=130.00n ng=1
MP0 C CB VDD VNW sg13_lv_pmos m=1 w=480.00n l=130.00n ng=1
.ENDS

************************************************************************
* Library Name: ez130_8t
* Cell Name:    AOI21X1
* View Name:    schematic
************************************************************************

.SUBCKT AOI21X1 A B C VDD VNW VPW VSS Y
*.PININFO A:I B:I C:I Y:O VDD:B VNW:B VPW:B VSS:B
MN3 Y C VSS VPW sg13_lv_nmos m=1 w=300.0n l=130.00n ng=1
MN1 net2 A VSS VPW sg13_lv_nmos m=1 w=300.0n l=130.00n ng=1
MN0 Y B net2 VPW sg13_lv_nmos m=1 w=300.0n l=130.00n ng=1
MP3 net1 B VDD VNW sg13_lv_pmos m=1 w=480.00n l=130.00n ng=1
MP1 Y C net1 VNW sg13_lv_pmos m=1 w=480.00n l=130.00n ng=1
MP0 net1 A VDD VNW sg13_lv_pmos m=1 w=480.00n l=130.00n ng=1
.ENDS

************************************************************************
* Library Name: ez130_8t
* Cell Name:    AOI21X2
* View Name:    schematic
************************************************************************

.SUBCKT AOI21X2 A B C VDD VNW VPW VSS Y
*.PININFO A:I B:I C:I Y:O VDD:B VNW:B VPW:B VSS:B
MN3 Y C VSS VPW sg13_lv_nmos m=1 w=640.00n l=130.00n ng=1
MN1 net2 A VSS VPW sg13_lv_nmos m=1 w=640.00n l=130.00n ng=1
MN0 Y B net2 VPW sg13_lv_nmos m=1 w=640.00n l=130.00n ng=1
MP3 net1 B VDD VNW sg13_lv_pmos m=1 w=980.00n l=130.00n ng=1
MP1 Y C net1 VNW sg13_lv_pmos m=1 w=980.00n l=130.00n ng=1
MP0 net1 A VDD VNW sg13_lv_pmos m=1 w=980.00n l=130.00n ng=1
.ENDS

************************************************************************
* Library Name: ez130_8t
* Cell Name:    AOI211X1
* View Name:    schematic
************************************************************************

.SUBCKT AOI211X1 A B C D VDD VNW VPW VSS Y
*.PININFO A:I B:I C:I D:I Y:O VDD:B VNW:B VPW:B VSS:B
MN3 Y D VSS VPW sg13_lv_nmos m=1 w=300.0n l=130.00n ng=1
MN2 Y C VSS VPW sg13_lv_nmos m=1 w=300.0n l=130.00n ng=1
MN1 Y B net1 VPW sg13_lv_nmos m=1 w=300.0n l=130.00n ng=1
MN0 net1 A VSS VPW sg13_lv_nmos m=1 w=300.0n l=130.00n ng=1
MP3 net3 B VDD VNW sg13_lv_pmos m=1 w=480.00n l=130.00n ng=1
MP2 net3 A VDD VNW sg13_lv_pmos m=1 w=480.00n l=130.00n ng=1
MP1 net2 C net3 VNW sg13_lv_pmos m=1 w=480.00n l=130.00n ng=1
MP0 Y D net2 VNW sg13_lv_pmos m=1 w=480.00n l=130.00n ng=1
.ENDS

************************************************************************
* Library Name: ez130_8t
* Cell Name:    AOI211X2
* View Name:    schematic
************************************************************************

.SUBCKT AOI211X2 A B C D VDD VNW VPW VSS Y
*.PININFO A:I B:I C:I D:I Y:O VDD:B VNW:B VPW:B VSS:B
MN3 Y D VSS VPW sg13_lv_nmos m=1 w=640.00n l=130.00n ng=1
MN2 Y C VSS VPW sg13_lv_nmos m=1 w=640.00n l=130.00n ng=1
MN1 Y B net1 VPW sg13_lv_nmos m=1 w=640.00n l=130.00n ng=1
MN0 net1 A VSS VPW sg13_lv_nmos m=1 w=640.00n l=130.00n ng=1
MP3 net3 B VDD VNW sg13_lv_pmos m=1 w=980.00n l=130.00n ng=1
MP2 net3 A VDD VNW sg13_lv_pmos m=1 w=980.00n l=130.00n ng=1
MP1 net2 C net3 VNW sg13_lv_pmos m=1 w=980.00n l=130.00n ng=1
MP0 Y D net2 VNW sg13_lv_pmos m=1 w=980.00n l=130.00n ng=1
.ENDS

************************************************************************
* Library Name: ez130_8t
* Cell Name:    AOI221X1
* View Name:    schematic
************************************************************************

.SUBCKT AOI221X1 A B C D E VDD VNW VPW VSS Y
*.PININFO A:I B:I C:I D:I E:I Y:O VDD:B VNW:B VPW:B VSS:B
MN7 Y E VSS VPW sg13_lv_nmos m=1 w=300.0n l=130.00n ng=1
MN4 Y C net2 VPW sg13_lv_nmos m=1 w=300.0n l=130.00n ng=1
MN6 Y A net1 VPW sg13_lv_nmos m=1 w=300.0n l=130.00n ng=1
MN2 net2 D VSS VPW sg13_lv_nmos m=1 w=300.0n l=130.00n ng=1
MN5 net1 B VSS VPW sg13_lv_nmos m=1 w=300.0n l=130.00n ng=1
MP3 Y C net3 VNW sg13_lv_pmos m=1 w=480.00n l=130.00n ng=1
MP5 Y D net3 VNW sg13_lv_pmos m=1 w=480.00n l=130.00n ng=1
MP8 net3 E net6 VNW sg13_lv_pmos m=1 w=480.00n l=130.00n ng=1
MP7 net6 A VDD VNW sg13_lv_pmos m=1 w=480.00n l=130.00n ng=1
MP6 net6 B VDD VNW sg13_lv_pmos m=1 w=480.00n l=130.00n ng=1
.ENDS

************************************************************************
* Library Name: ez130_8t
* Cell Name:    AOI221X2
* View Name:    schematic
************************************************************************

.SUBCKT AOI221X2 A B C D E VDD VNW VPW VSS Y
*.PININFO A:I B:I C:I D:I E:I Y:O VDD:B VNW:B VPW:B VSS:B
MN7 Y E VSS VPW sg13_lv_nmos m=1 w=640.00n l=130.00n ng=1
MN4 Y C net2 VPW sg13_lv_nmos m=1 w=640.00n l=130.00n ng=1
MN6 Y A net1 VPW sg13_lv_nmos m=1 w=640.00n l=130.00n ng=1
MN2 net2 D VSS VPW sg13_lv_nmos m=1 w=640.00n l=130.00n ng=1
MN5 net1 B VSS VPW sg13_lv_nmos m=1 w=640.00n l=130.00n ng=1
MP3 net6 A VDD VNW sg13_lv_pmos m=1 w=980.00n l=130.00n ng=1
MP5 net6 B VDD VNW sg13_lv_pmos m=1 w=980.00n l=130.00n ng=1
MP8 net3 E net6 VNW sg13_lv_pmos m=1 w=980.00n l=130.00n ng=1
MP7 Y C net3 VNW sg13_lv_pmos m=1 w=980.00n l=130.00n ng=1
MP6 Y D net3 VNW sg13_lv_pmos m=1 w=980.00n l=130.00n ng=1
.ENDS

************************************************************************
* Library Name: ez130_8t
* Cell Name:    AOI221X3
* View Name:    schematic
************************************************************************

.SUBCKT AOI221X3 A B C D E VDD VNW VPW VSS Y
*.PININFO A:I B:I C:I D:I E:I Y:O VDD:B VNW:B VPW:B VSS:B
MN7 Y E VSS VPW sg13_lv_nmos m=1 w=860.00n l=130.00n ng=1
MN4 Y C net2 VPW sg13_lv_nmos m=1 w=860.00n l=130.00n ng=1
MN6 Y A net1 VPW sg13_lv_nmos m=1 w=860.00n l=130.00n ng=1
MN2 net2 D VSS VPW sg13_lv_nmos m=1 w=860.00n l=130.00n ng=1
MN5 net1 B VSS VPW sg13_lv_nmos m=1 w=860.00n l=130.00n ng=1
MP3 net6 A VDD VNW sg13_lv_pmos m=1 w=1.32u l=130.00n ng=1
MP5 net6 B VDD VNW sg13_lv_pmos m=1 w=1.32u l=130.00n ng=1
MP8 net3 E net6 VNW sg13_lv_pmos m=1 w=1.32u l=130.00n ng=1
MP7 Y C net3 VNW sg13_lv_pmos m=1 w=1.32u l=130.00n ng=1
MP6 Y D net3 VNW sg13_lv_pmos m=1 w=1.32u l=130.00n ng=1
.ENDS

************************************************************************
* Library Name: ez130_8t
* Cell Name:    AOI22X1
* View Name:    schematic
************************************************************************

.SUBCKT AOI22X1 A B C D VDD VNW VPW VSS Y
*.PININFO A:I B:I C:I D:I Y:O VDD:B VNW:B VPW:B VSS:B
MN3 net1 C VSS VPW sg13_lv_nmos m=1 w=300.0n l=130.00n ng=1
MN2 Y D net1 VPW sg13_lv_nmos m=1 w=300.0n l=130.00n ng=1
MN1 net9 A VSS VPW sg13_lv_nmos m=1 w=300.0n l=130.00n ng=1
MN0 Y B net9 VPW sg13_lv_nmos m=1 w=300.0n l=130.00n ng=1
MP3 net3 B VDD VNW sg13_lv_pmos m=1 w=480.00n l=130.00n ng=1
MP2 Y D net3 VNW sg13_lv_pmos m=1 w=480.00n l=130.00n ng=1
MP1 net3 A VDD VNW sg13_lv_pmos m=1 w=480.00n l=130.00n ng=1
MP0 Y C net3 VNW sg13_lv_pmos m=1 w=480.00n l=130.00n ng=1
.ENDS

************************************************************************
* Library Name: ez130_8t
* Cell Name:    AOI22X1P5
* View Name:    schematic
************************************************************************

.SUBCKT AOI22X1P5 A B C D VDD VNW VPW VSS Y
*.PININFO A:I B:I C:I D:I Y:O VDD:B VNW:B VPW:B VSS:B
MN3 net1 D VSS VPW sg13_lv_nmos m=1 w=480.00n l=130.00n ng=1
MN2 Y C net1 VPW sg13_lv_nmos m=1 w=480.00n l=130.00n ng=1
MN1 net9 A VSS VPW sg13_lv_nmos m=1 w=480.00n l=130.00n ng=1
MN0 Y B net9 VPW sg13_lv_nmos m=1 w=480.00n l=130.00n ng=1
MP3 net3 B VDD VNW sg13_lv_pmos m=1 w=720.00n l=130.00n ng=1
MP2 Y D net3 VNW sg13_lv_pmos m=1 w=720.00n l=130.00n ng=1
MP1 net3 A VDD VNW sg13_lv_pmos m=1 w=720.00n l=130.00n ng=1
MP0 Y C net3 VNW sg13_lv_pmos m=1 w=720.00n l=130.00n ng=1
.ENDS

************************************************************************
* Library Name: ez130_8t
* Cell Name:    AOI22X2
* View Name:    schematic
************************************************************************

.SUBCKT AOI22X2 A B C D VDD VNW VPW VSS Y
*.PININFO A:I B:I C:I D:I Y:O VDD:B VNW:B VPW:B VSS:B
MN3 net1 C VSS VPW sg13_lv_nmos m=1 w=640.00n l=130.00n ng=1
MN2 Y D net1 VPW sg13_lv_nmos m=1 w=640.00n l=130.00n ng=1
MN1 net9 A VSS VPW sg13_lv_nmos m=1 w=640.00n l=130.00n ng=1
MN0 Y B net9 VPW sg13_lv_nmos m=1 w=640.00n l=130.00n ng=1
MP3 net3 B VDD VNW sg13_lv_pmos m=1 w=980.00n l=130.00n ng=1
MP2 Y D net3 VNW sg13_lv_pmos m=1 w=980.00n l=130.00n ng=1
MP1 net3 A VDD VNW sg13_lv_pmos m=1 w=980.00n l=130.00n ng=1
MP0 Y C net3 VNW sg13_lv_pmos m=1 w=980.00n l=130.00n ng=1
.ENDS

************************************************************************
* Library Name: ez130_8t
* Cell Name:    AOI2B2X1
* View Name:    schematic
************************************************************************

.SUBCKT AOI2B2X1 AB B C D VDD VNW VPW VSS Y
*.PININFO AB:I B:I C:I D:I Y:O VDD:B VNW:B VPW:B VSS:B
MN4 A AB VSS VPW sg13_lv_nmos m=1 w=300.0n l=130.00n ng=1
MN2 Y D net32 VPW sg13_lv_nmos m=1 w=300.0n l=130.00n ng=1
MN0 Y B net31 VPW sg13_lv_nmos m=1 w=300.0n l=130.00n ng=1
MN3 net32 C VSS VPW sg13_lv_nmos m=1 w=300.0n l=130.00n ng=1
MN1 net31 A VSS VPW sg13_lv_nmos m=1 w=300.0n l=130.00n ng=1
MP3 net30 B VDD VNW sg13_lv_pmos m=1 w=480.00n l=130.00n ng=1
MP1 net30 A VDD VNW sg13_lv_pmos m=1 w=480.00n l=130.00n ng=1
MP4 A AB VDD VNW sg13_lv_pmos m=1 w=480.00n l=130.00n ng=1
MP2 Y D net30 VNW sg13_lv_pmos m=1 w=480.00n l=130.00n ng=1
MP0 Y C net30 VNW sg13_lv_pmos m=1 w=480.00n l=130.00n ng=1
.ENDS

************************************************************************
* Library Name: ez130_8t
* Cell Name:    AOI2B2X2
* View Name:    schematic
************************************************************************

.SUBCKT AOI2B2X2 AB B C D VDD VNW VPW VSS Y
*.PININFO AB:I B:I C:I D:I Y:O VDD:B VNW:B VPW:B VSS:B
MN4 A AB VSS VPW sg13_lv_nmos m=1 w=300.0n l=130.00n ng=1
MN2 Y C net8 VPW sg13_lv_nmos m=1 w=640.00n l=130.00n ng=1
MN0 Y A net9 VPW sg13_lv_nmos m=1 w=640.00n l=130.00n ng=1
MN3 net8 D VSS VPW sg13_lv_nmos m=1 w=640.00n l=130.00n ng=1
MN1 net9 B VSS VPW sg13_lv_nmos m=1 w=640.00n l=130.00n ng=1
MP3 net7 D VDD VNW sg13_lv_pmos m=1 w=980.00n l=130.00n ng=1
MP1 net7 C VDD VNW sg13_lv_pmos m=1 w=980.00n l=130.00n ng=1
MP4 A AB VDD VNW sg13_lv_pmos m=1 w=480.00n l=130.00n ng=1
MP2 Y B net7 VNW sg13_lv_pmos m=1 w=980.00n l=130.00n ng=1
MP0 Y A net7 VNW sg13_lv_pmos m=1 w=980.00n l=130.00n ng=1
.ENDS

************************************************************************
* Library Name: ez130_8t
* Cell Name:    AOI2BB2X1
* View Name:    schematic
************************************************************************

.SUBCKT AOI2BB2X1 AB BB C D VDD VNW VPW VSS Y
*.PININFO AB:I BB:I C:I D:I Y:O VDD:B VNW:B VPW:B VSS:B
MP9 net3 D VDD VNW sg13_lv_pmos m=1 w=480.00n l=130.00n ng=1
MP8 Y net2 net3 VNW sg13_lv_pmos m=1 w=480.00n l=130.00n ng=1
MP7 net3 C VDD VNW sg13_lv_pmos m=1 w=480.00n l=130.00n ng=1
MP6 net2 BB net1 VNW sg13_lv_pmos m=1 w=480.00n l=130.00n ng=1
MP5 net1 AB VDD VNW sg13_lv_pmos m=1 w=480.00n l=130.00n ng=1
MN8 Y D net4 VPW sg13_lv_nmos m=1 w=300.0n l=130.00n ng=1
MN7 Y net2 VSS VPW sg13_lv_nmos m=1 w=300.0n l=130.00n ng=1
MN9 net4 C VSS VPW sg13_lv_nmos m=1 w=300.0n l=130.00n ng=1
MN5 net2 AB VSS VPW sg13_lv_nmos m=1 w=300.0n l=130.00n ng=1
MN6 net2 BB VSS VPW sg13_lv_nmos m=1 w=300.0n l=130.00n ng=1
.ENDS

************************************************************************
* Library Name: ez130_8t
* Cell Name:    AOI2BB2X2
* View Name:    schematic
************************************************************************

.SUBCKT AOI2BB2X2 AB BB C D VDD VNW VPW VSS Y
*.PININFO AB:I BB:I C:I D:I Y:O VDD:B VNW:B VPW:B VSS:B
MP9 net3 D VDD VNW sg13_lv_pmos m=1 w=980.00n l=130.00n ng=1
MP8 Y net2 net3 VNW sg13_lv_pmos m=1 w=980.00n l=130.00n ng=1
MP7 net3 C VDD VNW sg13_lv_pmos m=1 w=980.00n l=130.00n ng=1
MP6 net2 BB net1 VNW sg13_lv_pmos m=1 w=480.00n l=130.00n ng=1
MP5 net1 AB VDD VNW sg13_lv_pmos m=1 w=480.00n l=130.00n ng=1
MN8 Y D net4 VPW sg13_lv_nmos m=1 w=640.00n l=130.00n ng=1
MN7 Y net2 VSS VPW sg13_lv_nmos m=1 w=640.00n l=130.00n ng=1
MN9 net4 C VSS VPW sg13_lv_nmos m=1 w=640.00n l=130.00n ng=1
MN5 net2 AB VSS VPW sg13_lv_nmos m=1 w=300.0n l=130.00n ng=1
MN6 net2 BB VSS VPW sg13_lv_nmos m=1 w=300.0n l=130.00n ng=1
.ENDS

************************************************************************
* Library Name: ez130_8t
* Cell Name:    AOI2B2BX1
* View Name:    schematic
************************************************************************

.SUBCKT AOI2B2BX1 AB B CB D VDD VNW VPW VSS Y
*.PININFO AB:I B:I CB:I D:I Y:O VDD:B VNW:B VPW:B VSS:B
MP5 C CB VDD VNW sg13_lv_pmos m=1 w=480.00n l=130.00n ng=1
MP4 net2 C VDD VNW sg13_lv_pmos m=1 w=480.00n l=130.00n ng=1
MP3 net2 D VDD VNW sg13_lv_pmos m=1 w=480.00n l=130.00n ng=1
MP1 Y A net2 VNW sg13_lv_pmos m=1 w=480.00n l=130.00n ng=1
MP0 A AB VDD VNW sg13_lv_pmos m=1 w=480.00n l=130.00n ng=1
MP2 Y B net2 VNW sg13_lv_pmos m=1 w=480.00n l=130.00n ng=1
MN5 C CB VSS VPW sg13_lv_nmos m=1 w=300.0n l=130.00n ng=1
MN4 net15 B VSS VPW sg13_lv_nmos m=1 w=300.0n l=130.00n ng=1
MN3 Y A net15 VPW sg13_lv_nmos m=1 w=300.0n l=130.00n ng=1
MN2 Y C net6 VPW sg13_lv_nmos m=1 w=300.0n l=130.00n ng=1
MN1 A AB VSS VPW sg13_lv_nmos m=1 w=300.0n l=130.00n ng=1
MN0 net6 D VSS VPW sg13_lv_nmos m=1 w=300.0n l=130.00n ng=1
.ENDS

************************************************************************
* Library Name: ez130_8t
* Cell Name:    AOI2B2BX2
* View Name:    schematic
************************************************************************

.SUBCKT AOI2B2BX2 AB B CB D VDD VNW VPW VSS Y
*.PININFO AB:I B:I CB:I D:I Y:O VDD:B VNW:B VPW:B VSS:B
MP5 C CB VDD VNW sg13_lv_pmos m=1 w=480.00n l=130.00n ng=1
MP4 net2 C VDD VNW sg13_lv_pmos m=1 w=980.00n l=130.00n ng=1
MP3 net2 D VDD VNW sg13_lv_pmos m=1 w=980.00n l=130.00n ng=1
MP1 Y A net2 VNW sg13_lv_pmos m=1 w=980.00n l=130.00n ng=1
MP0 A AB VDD VNW sg13_lv_pmos m=1 w=480.00n l=130.00n ng=1
MP2 Y B net2 VNW sg13_lv_pmos m=1 w=980.00n l=130.00n ng=1
MN5 C CB VSS VPW sg13_lv_nmos m=1 w=300.0n l=130.00n ng=1
MN4 net15 B VSS VPW sg13_lv_nmos m=1 w=640.00n l=130.00n ng=1
MN3 Y A net15 VPW sg13_lv_nmos m=1 w=640.00n l=130.00n ng=1
MN2 Y C net6 VPW sg13_lv_nmos m=1 w=640.00n l=130.00n ng=1
MN1 A AB VSS VPW sg13_lv_nmos m=1 w=300.0n l=130.00n ng=1
MN0 net6 D VSS VPW sg13_lv_nmos m=1 w=640.00n l=130.00n ng=1
.ENDS

************************************************************************
* Library Name: ez130_8t
* Cell Name:    AOAI211X1
* View Name:    schematic
************************************************************************

.SUBCKT AOAI211X1 A B C D VDD VNW VPW VSS Y
*.PININFO A:I B:I C:I D:I Y:O VDD:B VNW:B VPW:B VSS:B
MN3 Y D net2 VPW sg13_lv_nmos m=1 w=300.0n l=130.00n ng=1
MN2 net2 C VSS VPW sg13_lv_nmos m=1 w=300.0n l=130.00n ng=1
MN1 net3 A VSS VPW sg13_lv_nmos m=1 w=300.0n l=130.00n ng=1
MN0 net2 B net3 VPW sg13_lv_nmos m=1 w=300.0n l=130.00n ng=1
MP3 Y D VDD VNW sg13_lv_pmos m=1 w=480.00n l=130.00n ng=1
MP2 Y C net1 VNW sg13_lv_pmos m=1 w=480.00n l=130.00n ng=1
MP1 net1 A VDD VNW sg13_lv_pmos m=1 w=480.00n l=130.00n ng=1
MP0 net1 B VDD VNW sg13_lv_pmos m=1 w=480.00n l=130.00n ng=1
.ENDS

************************************************************************
* Library Name: ez130_8t
* Cell Name:    AOAI211X2
* View Name:    schematic
************************************************************************

.SUBCKT AOAI211X2 A B C D VDD VNW VPW VSS Y
*.PININFO A:I B:I C:I D:I Y:O VDD:B VNW:B VPW:B VSS:B
MN3 Y D net2 VPW sg13_lv_nmos m=1 w=640.00n l=130.00n ng=1
MN2 net2 C VSS VPW sg13_lv_nmos m=1 w=640.00n l=130.00n ng=1
MN1 net3 A VSS VPW sg13_lv_nmos m=1 w=640.00n l=130.00n ng=1
MN0 net2 B net3 VPW sg13_lv_nmos m=1 w=640.00n l=130.00n ng=1
MP3 Y D VDD VNW sg13_lv_pmos m=1 w=980.00n l=130.00n ng=1
MP2 Y C net1 VNW sg13_lv_pmos m=1 w=980.00n l=130.00n ng=1
MP1 net1 A VDD VNW sg13_lv_pmos m=1 w=980.00n l=130.00n ng=1
MP0 net1 B VDD VNW sg13_lv_pmos m=1 w=980.00n l=130.00n ng=1
.ENDS

************************************************************************
* Library Name: ez130_8t
* Cell Name:    AOI31X1
* View Name:    schematic
************************************************************************

.SUBCKT AOI31X1 A B C D VDD VNW VPW VSS Y
*.PININFO A:I B:I C:I D:I Y:O VDD:B VNW:B VPW:B VSS:B
MP3 net1 C VDD VNW sg13_lv_pmos m=1 w=480.00n l=130.00n ng=1
MP2 net1 B VDD VNW sg13_lv_pmos m=1 w=480.00n l=130.00n ng=1
MP1 net1 A VDD VNW sg13_lv_pmos m=1 w=480.00n l=130.00n ng=1
MP0 Y D net1 VNW sg13_lv_pmos m=1 w=480.00n l=130.00n ng=1
MN3 net3 C VSS VPW sg13_lv_nmos m=1 w=300.0n l=130.00n ng=1
MN2 net2 B net3 VPW sg13_lv_nmos m=1 w=300.0n l=130.00n ng=1
MN1 Y A net2 VPW sg13_lv_nmos m=1 w=300.0n l=130.00n ng=1
MN0 Y D VSS VPW sg13_lv_nmos m=1 w=300.0n l=130.00n ng=1
.ENDS

************************************************************************
* Library Name: ez130_8t
* Cell Name:    AOI31X2
* View Name:    schematic
************************************************************************

.SUBCKT AOI31X2 A B C D VDD VNW VPW VSS Y
*.PININFO A:I B:I C:I D:I Y:O VDD:B VNW:B VPW:B VSS:B
MP3 net1 C VDD VNW sg13_lv_pmos m=1 w=980.00n l=130.00n ng=1
MP2 net1 B VDD VNW sg13_lv_pmos m=1 w=980.00n l=130.00n ng=1
MP1 net1 A VDD VNW sg13_lv_pmos m=1 w=980.00n l=130.00n ng=1
MP0 Y D net1 VNW sg13_lv_pmos m=1 w=980.00n l=130.00n ng=1
MN3 net3 C VSS VPW sg13_lv_nmos m=1 w=640.00n l=130.00n ng=1
MN2 net2 B net3 VPW sg13_lv_nmos m=1 w=640.00n l=130.00n ng=1
MN1 Y A net2 VPW sg13_lv_nmos m=1 w=640.00n l=130.00n ng=1
MN0 Y D VSS VPW sg13_lv_nmos m=1 w=640.00n l=130.00n ng=1
.ENDS

************************************************************************
* Library Name: ez130_8t
* Cell Name:    BUFX1
* View Name:    schematic
************************************************************************

.SUBCKT BUFX1 A VDD VNW VPW VSS Y
*.PININFO A:I Y:O VDD:B VNW:B VPW:B VSS:B
MP1 Y net8 VDD VNW sg13_lv_pmos m=1 w=480.00n l=130.00n ng=1
MP0 net8 A VDD VNW sg13_lv_pmos m=1 w=480.00n l=130.00n ng=1
MN1 Y net8 VSS VPW sg13_lv_nmos m=1 w=300.0n l=130.00n ng=1
MN0 net8 A VSS VPW sg13_lv_nmos m=1 w=300.0n l=130.00n ng=1
.ENDS

************************************************************************
* Library Name: ez130_8t
* Cell Name:    BUFX2
* View Name:    schematic
************************************************************************

.SUBCKT BUFX2 A VDD VNW VPW VSS Y
*.PININFO A:I Y:O VDD:B VNW:B VPW:B VSS:B
MN1 Y net21 VSS VPW sg13_lv_nmos m=1 w=640.00n l=130.00n ng=1
MN0 net21 A VSS VPW sg13_lv_nmos m=1 w=300.0n l=130.00n ng=1
MP1 Y net21 VDD VNW sg13_lv_pmos m=1 w=980.00n l=130.00n ng=1
MP0 net21 A VDD VNW sg13_lv_pmos m=1 w=480.00n l=130.00n ng=1
.ENDS

************************************************************************
* Library Name: ez130_8t
* Cell Name:    BUFX3
* View Name:    schematic
************************************************************************

.SUBCKT BUFX3 A VDD VNW VPW VSS Y
*.PININFO A:I Y:O VDD:B VNW:B VPW:B VSS:B
MP1 Y net1 VDD VNW sg13_lv_pmos m=1 w=1.32u l=130.00n ng=1
MP0 net1 A VDD VNW sg13_lv_pmos m=1 w=480.00n l=130.00n ng=1
MN1 Y net1 VSS VPW sg13_lv_nmos m=1 w=860.00n l=130.00n ng=1
MN0 net1 A VSS VPW sg13_lv_nmos m=1 w=300.0n l=130.00n ng=1
.ENDS

************************************************************************
* Library Name: ez130_8t
* Cell Name:    BUFX4
* View Name:    schematic
************************************************************************

.SUBCKT BUFX4 A VDD VNW VPW VSS Y
*.PININFO A:I Y:O VDD:B VNW:B VPW:B VSS:B
MN1 Y net5 VSS VPW sg13_lv_nmos m=2 w=640.00n l=130.00n ng=1
MN0 net5 A VSS VPW sg13_lv_nmos m=1 w=300.0n l=130.00n ng=1
MP1 Y net5 VDD VNW sg13_lv_pmos m=2 w=980.00n l=130.00n ng=1
MP0 net5 A VDD VNW sg13_lv_pmos m=1 w=480.00n l=130.00n ng=1
.ENDS

************************************************************************
* Library Name: ez130_8t
* Cell Name:    BUFX6
* View Name:    schematic
************************************************************************

.SUBCKT BUFX6 A VDD VNW VPW VSS Y
*.PININFO A:I Y:O VDD:B VNW:B VPW:B VSS:B
MN1 Y net21 VSS VPW sg13_lv_nmos m=2 w=860.00n l=130.00n ng=1
MN0 net21 A VSS VPW sg13_lv_nmos m=1 w=480.00n l=130.00n ng=1
MP1 Y net21 VDD VNW sg13_lv_pmos m=2 w=1.32u l=130.00n ng=1
MP0 net21 A VDD VNW sg13_lv_pmos m=1 w=720.00n l=130.00n ng=1
.ENDS

************************************************************************
* Library Name: ez130_8t
* Cell Name:    BUFX8
* View Name:    schematic
************************************************************************

.SUBCKT BUFX8 A VDD VNW VPW VSS Y
*.PININFO A:I Y:O VDD:B VNW:B VPW:B VSS:B
MN5 net9 A VSS VPW sg13_lv_nmos m=1 w=640.00n l=130.00n ng=1
MN0 Y net9 VSS VPW sg13_lv_nmos m=1 w=2.56u l=130.00n ng=4
MP5 net9 A VDD VNW sg13_lv_pmos m=1 w=980.00n l=130.00n ng=1
MP0 Y net9 VDD VNW sg13_lv_pmos m=1 w=3.92u l=130.00n ng=4
.ENDS

************************************************************************
* Library Name: ez130_8t
* Cell Name:    BUFX12
* View Name:    schematic
************************************************************************

.SUBCKT BUFX12 A VDD VNW VPW VSS Y
*.PININFO A:I Y:O VDD:B VNW:B VPW:B VSS:B
MN5 net9 A VSS VPW sg13_lv_nmos m=1 w=860.00n l=130.00n ng=1
MN0 Y net9 VSS VPW sg13_lv_nmos m=1 w=3.44u l=130.00n ng=4
MP5 net9 A VDD VNW sg13_lv_pmos m=1 w=1.32u l=130.00n ng=1
MP0 Y net9 VDD VNW sg13_lv_pmos m=1 w=5.28u l=130.00n ng=4
.ENDS

************************************************************************
* Library Name: ez130_8t
* Cell Name:    BUFX16
* View Name:    schematic
************************************************************************

.SUBCKT BUFX16 A VDD VNW VPW VSS Y
*.PININFO A:I Y:O VDD:B VNW:B VPW:B VSS:B
MN3 net5 A VSS VPW sg13_lv_nmos m=2 w=640.00n l=130.00n ng=1
MN1 Y net5 VSS VPW sg13_lv_nmos m=6 w=860.00n l=130.00n ng=1
MP1 Y net5 VDD VNW sg13_lv_pmos m=6 w=1.32u l=130.00n ng=1
MP3 net5 A VDD VNW sg13_lv_pmos m=2 w=980.00n l=130.00n ng=1
.ENDS

************************************************************************
* Library Name: ez130_8t
* Cell Name:    BUFX24
* View Name:    schematic
************************************************************************

.SUBCKT BUFX24 A VDD VNW VPW VSS Y
*.PININFO A:I Y:O VDD:B VNW:B VPW:B VSS:B
MN3 net5 A VSS VPW sg13_lv_nmos m=3 w=860.00n l=130.00n ng=1
MN1 Y net5 VSS VPW sg13_lv_nmos m=9 w=860.00n l=130.00n ng=1
MP1 Y net5 VDD VNW sg13_lv_pmos m=9 w=1.32u l=130.00n ng=1
MP3 net5 A VDD VNW sg13_lv_pmos m=3 w=1.32u l=130.00n ng=1
.ENDS

************************************************************************
* Library Name: ez130_8t
* Cell Name:    BUFX32
* View Name:    schematic
************************************************************************

.SUBCKT BUFX32 A VDD VNW VPW VSS Y
*.PININFO A:I Y:O VDD:B VNW:B VPW:B VSS:B
MN3 net5 A VSS VPW sg13_lv_nmos m=4 w=640.00n l=130.00n ng=1
MN1 Y net5 VSS VPW sg13_lv_nmos m=12 w=860.00n l=130.00n ng=1
MP1 Y net5 VDD VNW sg13_lv_pmos m=12 w=1.32u l=130.00n ng=1
MP3 net5 A VDD VNW sg13_lv_pmos m=4 w=980.00n l=130.00n ng=1
.ENDS

************************************************************************
* Library Name: ez130_8t
* Cell Name:    BUFX44
* View Name:    schematic
************************************************************************

.SUBCKT BUFX44 A VDD VNW VPW VSS Y
*.PININFO A:I Y:O VDD:B VNW:B VPW:B VSS:B
MN3 net5 A VSS VPW sg13_lv_nmos m=4 w=860.00n l=130.00n ng=1
MN1 Y net5 VSS VPW sg13_lv_nmos m=16 w=860.00n l=130.00n ng=1
MP1 Y net5 VDD VNW sg13_lv_pmos m=16 w=1.32u l=130.00n ng=1
MP3 net5 A VDD VNW sg13_lv_pmos m=4 w=1.32u l=130.00n ng=1
.ENDS

************************************************************************
* Library Name: ez130_8t
* Cell Name:    BUFX48
* View Name:    schematic
************************************************************************

.SUBCKT BUFX48 A VDD VNW VPW VSS Y
*.PININFO A:I Y:O VDD:B VNW:B VPW:B VSS:B
MN3 net5 A VSS VPW sg13_lv_nmos m=5 w=860.00n l=130.00n ng=1
MN1 Y net5 VSS VPW sg13_lv_nmos m=18 w=860.00n l=130.00n ng=1
MP1 Y net5 VDD VNW sg13_lv_pmos m=18 w=1.32u l=130.00n ng=1
MP3 net5 A VDD VNW sg13_lv_pmos m=5 w=1.32u l=130.00n ng=1
.ENDS

************************************************************************
* Library Name: ez130_8t
* Cell Name:    BUFX64
* View Name:    schematic
************************************************************************

.SUBCKT BUFX64 A VDD VNW VPW VSS Y
*.PININFO A:I Y:O VDD:B VNW:B VPW:B VSS:B
MN3 net5 A VSS VPW sg13_lv_nmos m=6 w=860.00n l=130.00n ng=1
MN1 Y net5 VSS VPW sg13_lv_nmos m=24 w=860.00n l=130.00n ng=1
MP1 Y net5 VDD VNW sg13_lv_pmos m=24 w=1.32u l=130.00n ng=1
MP3 net5 A VDD VNW sg13_lv_pmos m=6 w=1.32u l=130.00n ng=1
.ENDS

************************************************************************
* Library Name: ez130_8t
* Cell Name:    CGX1
* View Name:    schematic
************************************************************************

.SUBCKT CGX1 CK E ECK VDD VNW VPW VSS
*.PININFO CK:I E:I ECK:O VDD:B VNW:B VPW:B VSS:B
MN12 ECK net4 VSS VPW sg13_lv_nmos m=1 w=300.0n l=130.00n ng=1
MN8 net4 net2 net3 VPW sg13_lv_nmos m=1 w=300.0n l=130.00n ng=1
MN7 net2 net1 VSS VPW sg13_lv_nmos m=1 w=300.0n l=130.00n ng=1
MN5 net16 net2 VSS VPW sg13_lv_nmos m=1 w=300.0n l=130.00n ng=1
MN4 net1 CKPOS net16 VPW sg13_lv_nmos m=1 w=300.0n l=130.00n ng=1
MN3 net20 E VSS VPW sg13_lv_nmos m=1 w=300.0n l=130.00n ng=1
MN0 net1 CKNEG net20 VPW sg13_lv_nmos m=1 w=300.0n l=130.00n ng=1
MN11 net3 CKPOS VSS VPW sg13_lv_nmos m=1 w=300.0n l=130.00n ng=1
MN2 CKPOS CKNEG VSS VPW sg13_lv_nmos m=1 w=640.00n l=130.00n ng=1
MN1 CKNEG CK VSS VPW sg13_lv_nmos m=1 w=300.0n l=130.00n ng=1
MP13 net4 CKPOS VDD VNW sg13_lv_pmos m=1 w=480.00n l=130.00n ng=1
MP10 net4 net2 VDD VNW sg13_lv_pmos m=1 w=480.00n l=130.00n ng=1
MP9 net2 net1 VDD VNW sg13_lv_pmos m=1 w=480.00n l=130.00n ng=1
MP7 net1 CKNEG net15 VNW sg13_lv_pmos m=1 w=480.00n l=130.00n ng=1
MP6 net15 net2 VDD VNW sg13_lv_pmos m=1 w=480.00n l=130.00n ng=1
MP3 net1 CKPOS net19 VNW sg13_lv_pmos m=1 w=480.00n l=130.00n ng=1
MP0 net19 E VDD VNW sg13_lv_pmos m=1 w=480.00n l=130.00n ng=1
MP5 CKPOS CKNEG VDD VNW sg13_lv_pmos m=1 w=980.00n l=130.00n ng=1
MP4 CKNEG CK VDD VNW sg13_lv_pmos m=1 w=480.00n l=130.00n ng=1
MP14 ECK net4 VDD VNW sg13_lv_pmos m=1 w=480.00n l=130.00n ng=1
.ENDS

************************************************************************
* Library Name: ez130_8t
* Cell Name:    CGX2
* View Name:    schematic
************************************************************************

.SUBCKT CGX2 CK E ECK VDD VNW VPW VSS
*.PININFO CK:I E:I ECK:O VDD:B VNW:B VPW:B VSS:B
MN12 ECK net4 VSS VPW sg13_lv_nmos m=1 w=640.00n l=130.00n ng=1
MN8 net4 net2 net3 VPW sg13_lv_nmos m=1 w=300.0n l=130.00n ng=1
MN7 net2 net1 VSS VPW sg13_lv_nmos m=1 w=300.0n l=130.00n ng=1
MN5 net16 net2 VSS VPW sg13_lv_nmos m=1 w=300.0n l=130.00n ng=1
MN4 net1 CKPOS net16 VPW sg13_lv_nmos m=1 w=300.0n l=130.00n ng=1
MN3 net20 E VSS VPW sg13_lv_nmos m=1 w=300.0n l=130.00n ng=1
MN0 net1 CKNEG net20 VPW sg13_lv_nmos m=1 w=300.0n l=130.00n ng=1
MN11 net3 CKPOS VSS VPW sg13_lv_nmos m=1 w=300.0n l=130.00n ng=1
MN2 CKPOS CKNEG VSS VPW sg13_lv_nmos m=1 w=640.00n l=130.00n ng=1
MN1 CKNEG CK VSS VPW sg13_lv_nmos m=1 w=300.0n l=130.00n ng=1
MP13 net4 CKPOS VDD VNW sg13_lv_pmos m=1 w=480.00n l=130.00n ng=1
MP10 net4 net2 VDD VNW sg13_lv_pmos m=1 w=480.00n l=130.00n ng=1
MP9 net2 net1 VDD VNW sg13_lv_pmos m=1 w=480.00n l=130.00n ng=1
MP7 net1 CKNEG net15 VNW sg13_lv_pmos m=1 w=480.00n l=130.00n ng=1
MP6 net15 net2 VDD VNW sg13_lv_pmos m=1 w=480.00n l=130.00n ng=1
MP3 net1 CKPOS net19 VNW sg13_lv_pmos m=1 w=480.00n l=130.00n ng=1
MP0 net19 E VDD VNW sg13_lv_pmos m=1 w=480.00n l=130.00n ng=1
MP5 CKPOS CKNEG VDD VNW sg13_lv_pmos m=1 w=980.00n l=130.00n ng=1
MP4 CKNEG CK VDD VNW sg13_lv_pmos m=1 w=480.00n l=130.00n ng=1
MP14 ECK net4 VDD VNW sg13_lv_pmos m=1 w=980.00n l=130.00n ng=1
.ENDS

************************************************************************
* Library Name: ez130_8t
* Cell Name:    CGX3
* View Name:    schematic
************************************************************************

.SUBCKT CGX3 CK E ECK VDD VNW VPW VSS
*.PININFO CK:I E:I ECK:O VDD:B VNW:B VPW:B VSS:B
MN12 ECK net4 VSS VPW sg13_lv_nmos m=1 w=860.00n l=130.00n ng=1
MN8 net4 net2 net3 VPW sg13_lv_nmos m=1 w=300.0n l=130.00n ng=1
MN7 net2 net1 VSS VPW sg13_lv_nmos m=1 w=300.0n l=130.00n ng=1
MN5 net16 net2 VSS VPW sg13_lv_nmos m=1 w=300.0n l=130.00n ng=1
MN4 net1 CKPOS net16 VPW sg13_lv_nmos m=1 w=300.0n l=130.00n ng=1
MN3 net20 E VSS VPW sg13_lv_nmos m=1 w=300.0n l=130.00n ng=1
MN0 net1 CKNEG net20 VPW sg13_lv_nmos m=1 w=300.0n l=130.00n ng=1
MN11 net3 CKPOS VSS VPW sg13_lv_nmos m=1 w=300.0n l=130.00n ng=1
MN2 CKPOS CKNEG VSS VPW sg13_lv_nmos m=1 w=640.00n l=130.00n ng=1
MN1 CKNEG CK VSS VPW sg13_lv_nmos m=1 w=300.0n l=130.00n ng=1
MP13 net4 CKPOS VDD VNW sg13_lv_pmos m=1 w=480.00n l=130.00n ng=1
MP10 net4 net2 VDD VNW sg13_lv_pmos m=1 w=480.00n l=130.00n ng=1
MP9 net2 net1 VDD VNW sg13_lv_pmos m=1 w=480.00n l=130.00n ng=1
MP7 net1 CKNEG net15 VNW sg13_lv_pmos m=1 w=480.00n l=130.00n ng=1
MP6 net15 net2 VDD VNW sg13_lv_pmos m=1 w=480.00n l=130.00n ng=1
MP3 net1 CKPOS net19 VNW sg13_lv_pmos m=1 w=480.00n l=130.00n ng=1
MP0 net19 E VDD VNW sg13_lv_pmos m=1 w=480.00n l=130.00n ng=1
MP5 CKPOS CKNEG VDD VNW sg13_lv_pmos m=1 w=980.00n l=130.00n ng=1
MP4 CKNEG CK VDD VNW sg13_lv_pmos m=1 w=480.00n l=130.00n ng=1
MP14 ECK net4 VDD VNW sg13_lv_pmos m=1 w=1.32u l=130.00n ng=1
.ENDS

************************************************************************
* Library Name: ez130_8t
* Cell Name:    CGTSX1
* View Name:    schematic
************************************************************************

.SUBCKT CGTSX1 CK E ECK SE VDD VNW VPW VSS
*.PININFO CK:I E:I SE:I ECK:O VDD:B VNW:B VPW:B VSS:B
MN12 ECK net4 VSS VPW sg13_lv_nmos m=1 w=300.0n l=130.00n ng=1
MN8 net4 net1 net3 VPW sg13_lv_nmos m=1 w=300.0n l=130.00n ng=1
MN7 net2 net1 VSS VPW sg13_lv_nmos m=1 w=300.0n l=130.00n ng=1
MN13 net5 SE VSS VPW sg13_lv_nmos m=1 w=300.0n l=130.00n ng=1
MN5 net16 net2 VSS VPW sg13_lv_nmos m=1 w=300.0n l=130.00n ng=1
MN4 net1 CKPOS net16 VPW sg13_lv_nmos m=1 w=300.0n l=130.00n ng=1
MN3 net20 net5 VSS VPW sg13_lv_nmos m=1 w=300.0n l=130.00n ng=1
MN0 net1 CKNEG net20 VPW sg13_lv_nmos m=1 w=300.0n l=130.00n ng=1
MN11 net3 CKPOS VSS VPW sg13_lv_nmos m=1 w=300.0n l=130.00n ng=1
MN2 CKPOS CKNEG VSS VPW sg13_lv_nmos m=1 w=640.00n l=130.00n ng=1
MN1 CKNEG CK VSS VPW sg13_lv_nmos m=1 w=300.0n l=130.00n ng=1
MN14 net5 E VSS VPW sg13_lv_nmos m=1 w=300.0n l=130.00n ng=1
MP13 net4 CKPOS VDD VNW sg13_lv_pmos m=1 w=480.00n l=130.00n ng=1
MP15 net6 SE VDD VNW sg13_lv_pmos m=1 w=480.00n l=130.00n ng=1
MP10 net4 net1 VDD VNW sg13_lv_pmos m=1 w=480.00n l=130.00n ng=1
MP9 net2 net1 VDD VNW sg13_lv_pmos m=1 w=480.00n l=130.00n ng=1
MP16 net5 E net6 VNW sg13_lv_pmos m=1 w=480.00n l=130.00n ng=1
MP7 net1 CKNEG net15 VNW sg13_lv_pmos m=1 w=480.00n l=130.00n ng=1
MP6 net15 net2 VDD VNW sg13_lv_pmos m=1 w=480.00n l=130.00n ng=1
MP3 net1 CKPOS net19 VNW sg13_lv_pmos m=1 w=480.00n l=130.00n ng=1
MP0 net19 net5 VDD VNW sg13_lv_pmos m=1 w=480.00n l=130.00n ng=1
MP5 CKPOS CKNEG VDD VNW sg13_lv_pmos m=1 w=980.00n l=130.00n ng=1
MP4 CKNEG CK VDD VNW sg13_lv_pmos m=1 w=480.00n l=130.00n ng=1
MP14 ECK net4 VDD VNW sg13_lv_pmos m=1 w=480.00n l=130.00n ng=1
.ENDS

************************************************************************
* Library Name: ez130_8t
* Cell Name:    CGTSX1P5
* View Name:    schematic
************************************************************************

.SUBCKT CGTSX1P5 CK E ECK SE VDD VNW VPW VSS
*.PININFO CK:I E:I SE:I ECK:O VDD:B VNW:B VPW:B VSS:B
MN12 ECK net4 VSS VPW sg13_lv_nmos m=1 w=480.00n l=130.00n ng=1
MN8 net4 net1 net3 VPW sg13_lv_nmos m=1 w=300.0n l=130.00n ng=1
MN7 net2 net1 VSS VPW sg13_lv_nmos m=1 w=300.0n l=130.00n ng=1
MN13 net5 SE VSS VPW sg13_lv_nmos m=1 w=300.0n l=130.00n ng=1
MN5 net16 net2 VSS VPW sg13_lv_nmos m=1 w=300.0n l=130.00n ng=1
MN4 net1 CKPOS net16 VPW sg13_lv_nmos m=1 w=300.0n l=130.00n ng=1
MN3 net20 net5 VSS VPW sg13_lv_nmos m=1 w=300.0n l=130.00n ng=1
MN0 net1 CKNEG net20 VPW sg13_lv_nmos m=1 w=300.0n l=130.00n ng=1
MN11 net3 CKPOS VSS VPW sg13_lv_nmos m=1 w=300.0n l=130.00n ng=1
MN2 CKPOS CKNEG VSS VPW sg13_lv_nmos m=1 w=640.00n l=130.00n ng=1
MN1 CKNEG CK VSS VPW sg13_lv_nmos m=1 w=300.0n l=130.00n ng=1
MN14 net5 E VSS VPW sg13_lv_nmos m=1 w=300.0n l=130.00n ng=1
MP13 net4 CKPOS VDD VNW sg13_lv_pmos m=1 w=480.00n l=130.00n ng=1
MP15 net6 SE VDD VNW sg13_lv_pmos m=1 w=480.00n l=130.00n ng=1
MP10 net4 net1 VDD VNW sg13_lv_pmos m=1 w=480.00n l=130.00n ng=1
MP9 net2 net1 VDD VNW sg13_lv_pmos m=1 w=480.00n l=130.00n ng=1
MP16 net5 E net6 VNW sg13_lv_pmos m=1 w=480.00n l=130.00n ng=1
MP7 net1 CKNEG net15 VNW sg13_lv_pmos m=1 w=480.00n l=130.00n ng=1
MP6 net15 net2 VDD VNW sg13_lv_pmos m=1 w=480.00n l=130.00n ng=1
MP3 net1 CKPOS net19 VNW sg13_lv_pmos m=1 w=480.00n l=130.00n ng=1
MP0 net19 net5 VDD VNW sg13_lv_pmos m=1 w=480.00n l=130.00n ng=1
MP5 CKPOS CKNEG VDD VNW sg13_lv_pmos m=1 w=980.00n l=130.00n ng=1
MP4 CKNEG CK VDD VNW sg13_lv_pmos m=1 w=480.00n l=130.00n ng=1
MP14 ECK net4 VDD VNW sg13_lv_pmos m=1 w=720.00n l=130.00n ng=1
.ENDS

************************************************************************
* Library Name: ez130_8t
* Cell Name:    CGTSX2
* View Name:    schematic
************************************************************************

.SUBCKT CGTSX2 CK E ECK SE VDD VNW VPW VSS
*.PININFO CK:I E:I SE:I ECK:O VDD:B VNW:B VPW:B VSS:B
MN12 ECK net4 VSS VPW sg13_lv_nmos m=1 w=640.00n l=130.00n ng=1
MN8 net4 net1 net3 VPW sg13_lv_nmos m=1 w=300.0n l=130.00n ng=1
MN7 net2 net1 VSS VPW sg13_lv_nmos m=1 w=300.0n l=130.00n ng=1
MN13 net5 SE VSS VPW sg13_lv_nmos m=1 w=300.0n l=130.00n ng=1
MN5 net16 net2 VSS VPW sg13_lv_nmos m=1 w=300.0n l=130.00n ng=1
MN4 net1 CKPOS net16 VPW sg13_lv_nmos m=1 w=300.0n l=130.00n ng=1
MN3 net20 net5 VSS VPW sg13_lv_nmos m=1 w=300.0n l=130.00n ng=1
MN0 net1 CKNEG net20 VPW sg13_lv_nmos m=1 w=300.0n l=130.00n ng=1
MN11 net3 CKPOS VSS VPW sg13_lv_nmos m=1 w=300.0n l=130.00n ng=1
MN2 CKPOS CKNEG VSS VPW sg13_lv_nmos m=1 w=640.00n l=130.00n ng=1
MN1 CKNEG CK VSS VPW sg13_lv_nmos m=1 w=300.0n l=130.00n ng=1
MN14 net5 E VSS VPW sg13_lv_nmos m=1 w=300.0n l=130.00n ng=1
MP13 net4 CKPOS VDD VNW sg13_lv_pmos m=1 w=480.00n l=130.00n ng=1
MP15 net6 SE VDD VNW sg13_lv_pmos m=1 w=480.00n l=130.00n ng=1
MP10 net4 net1 VDD VNW sg13_lv_pmos m=1 w=480.00n l=130.00n ng=1
MP9 net2 net1 VDD VNW sg13_lv_pmos m=1 w=480.00n l=130.00n ng=1
MP16 net5 E net6 VNW sg13_lv_pmos m=1 w=480.00n l=130.00n ng=1
MP7 net1 CKNEG net15 VNW sg13_lv_pmos m=1 w=480.00n l=130.00n ng=1
MP6 net15 net2 VDD VNW sg13_lv_pmos m=1 w=480.00n l=130.00n ng=1
MP3 net1 CKPOS net19 VNW sg13_lv_pmos m=1 w=480.00n l=130.00n ng=1
MP0 net19 net5 VDD VNW sg13_lv_pmos m=1 w=480.00n l=130.00n ng=1
MP5 CKPOS CKNEG VDD VNW sg13_lv_pmos m=1 w=980.00n l=130.00n ng=1
MP4 CKNEG CK VDD VNW sg13_lv_pmos m=1 w=480.00n l=130.00n ng=1
MP14 ECK net4 VDD VNW sg13_lv_pmos m=1 w=980.00n l=130.00n ng=1
.ENDS

************************************************************************
* Library Name: ez130_8t
* Cell Name:    CGTSX3
* View Name:    schematic
************************************************************************

.SUBCKT CGTSX3 CK E ECK SE VDD VNW VPW VSS
*.PININFO CK:I E:I SE:I ECK:O VDD:B VNW:B VPW:B VSS:B
MN12 ECK net4 VSS VPW sg13_lv_nmos m=1 w=860.00n l=130.00n ng=1
MN8 net4 net1 net3 VPW sg13_lv_nmos m=1 w=300.0n l=130.00n ng=1
MN7 net2 net1 VSS VPW sg13_lv_nmos m=1 w=300.0n l=130.00n ng=1
MN13 net5 SE VSS VPW sg13_lv_nmos m=1 w=300.0n l=130.00n ng=1
MN5 net16 net2 VSS VPW sg13_lv_nmos m=1 w=300.0n l=130.00n ng=1
MN4 net1 CKPOS net16 VPW sg13_lv_nmos m=1 w=300.0n l=130.00n ng=1
MN3 net20 net5 VSS VPW sg13_lv_nmos m=1 w=300.0n l=130.00n ng=1
MN0 net1 CKNEG net20 VPW sg13_lv_nmos m=1 w=300.0n l=130.00n ng=1
MN11 net3 CKPOS VSS VPW sg13_lv_nmos m=1 w=300.0n l=130.00n ng=1
MN2 CKPOS CKNEG VSS VPW sg13_lv_nmos m=1 w=640.00n l=130.00n ng=1
MN1 CKNEG CK VSS VPW sg13_lv_nmos m=1 w=300.0n l=130.00n ng=1
MN14 net5 E VSS VPW sg13_lv_nmos m=1 w=300.0n l=130.00n ng=1
MP13 net4 CKPOS VDD VNW sg13_lv_pmos m=1 w=480.00n l=130.00n ng=1
MP15 net6 SE VDD VNW sg13_lv_pmos m=1 w=480.00n l=130.00n ng=1
MP10 net4 net1 VDD VNW sg13_lv_pmos m=1 w=480.00n l=130.00n ng=1
MP9 net2 net1 VDD VNW sg13_lv_pmos m=1 w=480.00n l=130.00n ng=1
MP16 net5 E net6 VNW sg13_lv_pmos m=1 w=480.00n l=130.00n ng=1
MP7 net1 CKNEG net15 VNW sg13_lv_pmos m=1 w=480.00n l=130.00n ng=1
MP6 net15 net2 VDD VNW sg13_lv_pmos m=1 w=480.00n l=130.00n ng=1
MP3 net1 CKPOS net19 VNW sg13_lv_pmos m=1 w=480.00n l=130.00n ng=1
MP0 net19 net5 VDD VNW sg13_lv_pmos m=1 w=480.00n l=130.00n ng=1
MP5 CKPOS CKNEG VDD VNW sg13_lv_pmos m=1 w=980.00n l=130.00n ng=1
MP4 CKNEG CK VDD VNW sg13_lv_pmos m=1 w=480.00n l=130.00n ng=1
MP14 ECK net4 VDD VNW sg13_lv_pmos m=1 w=1.32u l=130.00n ng=1
.ENDS

************************************************************************
* Library Name: ez130_8t
* Cell Name:    DECAP4
* View Name:    schematic
************************************************************************

.SUBCKT DECAP4 VDD VNW VPW VSS
*.PININFO VDD:B VNW:B VPW:B VSS:B
MX1 net2 net1 VSS VPW sg13_lv_nmos m=1 w=640.00n l=760.00n ng=1
MX0 net1 net2 VDD VNW sg13_lv_pmos m=1 w=980.00n l=760.00n ng=1
.ENDS

************************************************************************
* Library Name: ez130_8t
* Cell Name:    DECAP8
* View Name:    schematic
************************************************************************

.SUBCKT DECAP8 VDD VNW VPW VSS
*.PININFO VDD:B VNW:B VPW:B VSS:B
MN1 net1 net2 VSS VPW sg13_lv_nmos m=1 w=880.00n l=130.00n ng=1
MN0 VSS net2 VSS VPW sg13_lv_nmos m=1 w=880.00n l=1.945u ng=1
MP1 net2 net1 VDD VNW sg13_lv_pmos m=1 w=1.02u l=130.00n ng=1
MP0 VDD net1 VDD VNW sg13_lv_pmos m=1 w=1.02u l=1.945u ng=1
.ENDS

************************************************************************
* Library Name: ez130_8t
* Cell Name:    DECAP16
* View Name:    schematic
************************************************************************

.SUBCKT DECAP16 VDD VNW VPW VSS
*.PININFO VDD:B VNW:B VPW:B VSS:B
MN1 net1 net2 VSS VPW sg13_lv_nmos m=1 w=880.00n l=130.00n ng=1
MN0 VSS net2 VSS VPW sg13_lv_nmos m=1 w=880.00n l=5.305u ng=1
MP1 net2 net1 VDD VNW sg13_lv_pmos m=1 w=1.02u l=130.00n ng=1
MP0 VDD net1 VDD VNW sg13_lv_pmos m=1 w=1.02u l=5.305u ng=1
.ENDS

************************************************************************
* Library Name: ez130_8t
* Cell Name:    DECAP32
* View Name:    schematic
************************************************************************

.SUBCKT DECAP32 VDD VNW VPW VSS
*.PININFO VDD:B VNW:B VPW:B VSS:B
MN5 VSS net2 VSS VPW sg13_lv_nmos m=1 w=880.00n l=5.575u ng=1
MN1 net1 net2 VSS VPW sg13_lv_nmos m=1 w=880.00n l=130.00n ng=1
MN0 VSS net2 VSS VPW sg13_lv_nmos m=1 w=880.00n l=5.575u ng=1
MN4 net1 net2 VSS VPW sg13_lv_nmos m=1 w=880.00n l=130.00n ng=1
MP5 VDD net1 VDD VNW sg13_lv_pmos m=1 w=1.02u l=5.575u ng=1
MP1 net2 net1 VDD VNW sg13_lv_pmos m=1 w=1.02u l=130.00n ng=1
MP0 VDD net1 VDD VNW sg13_lv_pmos m=1 w=1.02u l=5.575u ng=1
MP4 net2 net1 VDD VNW sg13_lv_pmos m=1 w=1.02u l=130.00n ng=1
.ENDS

************************************************************************
* Library Name: ez130_8t
* Cell Name:    DFFQX1
* View Name:    schematic
************************************************************************

.SUBCKT DFFQX1 CK D Q VDD VNW VPW VSS
*.PININFO CK:I D:I Q:O VDD:B VNW:B VPW:B VSS:B
MP17 Q net2 VDD VNW sg13_lv_pmos m=1 w=480.00n l=130.00n ng=1
MP15 net2 net3 VDD VNW sg13_lv_pmos m=1 w=480.00n l=130.00n ng=1
MP13 net3 CKPOS net10 VNW sg13_lv_pmos m=1 w=480.00n l=130.00n ng=1
MP12 net10 net2 VDD VNW sg13_lv_pmos m=1 w=480.00n l=130.00n ng=1
MP11 net9 CKNEG net3 VNW sg13_lv_pmos m=1 w=480.00n l=130.00n ng=1
MP10 net9 EDB VDD VNW sg13_lv_pmos m=1 w=480.00n l=130.00n ng=1
MP8 EDB CKNEG net6 VNW sg13_lv_pmos m=1 w=480.00n l=130.00n ng=1
MP7 net6 net9 VDD VNW sg13_lv_pmos m=1 w=480.00n l=130.00n ng=1
MP5 CKPOS CKNEG VDD VNW sg13_lv_pmos m=1 w=980.00n l=130.00n ng=1
MP4 CKNEG CK VDD VNW sg13_lv_pmos m=1 w=480.00n l=130.00n ng=1
MP1 net12 CKPOS VDD VNW sg13_lv_pmos m=1 w=480.00n l=130.00n ng=1
MP18 EDB D net12 VNW sg13_lv_pmos m=1 w=480.00n l=130.00n ng=1
MN15 Q net2 VSS VPW sg13_lv_nmos m=1 w=300.0n l=130.00n ng=1
MN13 net2 net3 VSS VPW sg13_lv_nmos m=1 w=300.0n l=130.00n ng=1
MN10 net1 net2 VSS VPW sg13_lv_nmos m=1 w=300.0n l=130.00n ng=1
MN9 net3 CKNEG net1 VPW sg13_lv_nmos m=1 w=300.0n l=130.00n ng=1
MN8 net9 CKPOS net3 VPW sg13_lv_nmos m=1 w=300.0n l=130.00n ng=1
MN7 net9 EDB VSS VPW sg13_lv_nmos m=1 w=300.0n l=130.00n ng=1
MN5 net8 net9 VSS VPW sg13_lv_nmos m=1 w=300.0n l=130.00n ng=1
MN4 EDB CKPOS net8 VPW sg13_lv_nmos m=1 w=300.0n l=130.00n ng=1
MN2 CKPOS CKNEG VSS VPW sg13_lv_nmos m=1 w=640.00n l=130.00n ng=1
MN1 CKNEG CK VSS VPW sg13_lv_nmos m=1 w=300.0n l=130.00n ng=1
MN16 EDB CKNEG net21 VPW sg13_lv_nmos m=1 w=300.0n l=130.00n ng=1
MP2 net21 D VSS VPW sg13_lv_nmos m=1 w=300.0n l=130.00n ng=1
.ENDS

************************************************************************
* Library Name: ez130_8t
* Cell Name:    DFFQX1P5
* View Name:    schematic
************************************************************************

.SUBCKT DFFQX1P5 CK D Q VDD VNW VPW VSS
*.PININFO CK:I D:I Q:O VDD:B VNW:B VPW:B VSS:B
MP17 Q net2 VDD VNW sg13_lv_pmos m=1 w=720.00n l=130.00n ng=1
MP15 net2 net3 VDD VNW sg13_lv_pmos m=1 w=480.00n l=130.00n ng=1
MP13 net3 CKPOS net10 VNW sg13_lv_pmos m=1 w=480.00n l=130.00n ng=1
MP12 net10 net2 VDD VNW sg13_lv_pmos m=1 w=480.00n l=130.00n ng=1
MP11 net9 CKNEG net3 VNW sg13_lv_pmos m=1 w=480.00n l=130.00n ng=1
MP10 net9 EDB VDD VNW sg13_lv_pmos m=1 w=480.00n l=130.00n ng=1
MP8 EDB CKNEG net6 VNW sg13_lv_pmos m=1 w=480.00n l=130.00n ng=1
MP7 net6 net9 VDD VNW sg13_lv_pmos m=1 w=480.00n l=130.00n ng=1
MP5 CKPOS CKNEG VDD VNW sg13_lv_pmos m=1 w=980.00n l=130.00n ng=1
MP4 CKNEG CK VDD VNW sg13_lv_pmos m=1 w=480.00n l=130.00n ng=1
MP1 net12 CKPOS VDD VNW sg13_lv_pmos m=1 w=480.00n l=130.00n ng=1
MP18 EDB D net12 VNW sg13_lv_pmos m=1 w=480.00n l=130.00n ng=1
MN15 Q net2 VSS VPW sg13_lv_nmos m=1 w=480.00n l=130.00n ng=1
MN13 net2 net3 VSS VPW sg13_lv_nmos m=1 w=300.0n l=130.00n ng=1
MN10 net1 net2 VSS VPW sg13_lv_nmos m=1 w=300.0n l=130.00n ng=1
MN9 net3 CKNEG net1 VPW sg13_lv_nmos m=1 w=300.0n l=130.00n ng=1
MN8 net9 CKPOS net3 VPW sg13_lv_nmos m=1 w=300.0n l=130.00n ng=1
MN7 net9 EDB VSS VPW sg13_lv_nmos m=1 w=300.0n l=130.00n ng=1
MN5 net8 net9 VSS VPW sg13_lv_nmos m=1 w=300.0n l=130.00n ng=1
MN4 EDB CKPOS net8 VPW sg13_lv_nmos m=1 w=300.0n l=130.00n ng=1
MN2 CKPOS CKNEG VSS VPW sg13_lv_nmos m=1 w=640.00n l=130.00n ng=1
MN1 CKNEG CK VSS VPW sg13_lv_nmos m=1 w=300.0n l=130.00n ng=1
MN16 EDB CKNEG net21 VPW sg13_lv_nmos m=1 w=300.0n l=130.00n ng=1
MP2 net21 D VSS VPW sg13_lv_nmos m=1 w=300.0n l=130.00n ng=1
.ENDS

************************************************************************
* Library Name: ez130_8t
* Cell Name:    DFFQX2
* View Name:    schematic
************************************************************************

.SUBCKT DFFQX2 CK D Q VDD VNW VPW VSS
*.PININFO CK:I D:I Q:O VDD:B VNW:B VPW:B VSS:B
MP17 Q net2 VDD VNW sg13_lv_pmos m=1 w=980.00n l=130.00n ng=1
MP15 net2 net3 VDD VNW sg13_lv_pmos m=1 w=480.00n l=130.00n ng=1
MP13 net3 CKPOS net10 VNW sg13_lv_pmos m=1 w=480.00n l=130.00n ng=1
MP12 net10 net2 VDD VNW sg13_lv_pmos m=1 w=480.00n l=130.00n ng=1
MP11 net9 CKNEG net3 VNW sg13_lv_pmos m=1 w=480.00n l=130.00n ng=1
MP10 net9 EDB VDD VNW sg13_lv_pmos m=1 w=480.00n l=130.00n ng=1
MP8 EDB CKNEG net6 VNW sg13_lv_pmos m=1 w=480.00n l=130.00n ng=1
MP7 net6 net9 VDD VNW sg13_lv_pmos m=1 w=480.00n l=130.00n ng=1
MP5 CKPOS CKNEG VDD VNW sg13_lv_pmos m=1 w=980.00n l=130.00n ng=1
MP4 CKNEG CK VDD VNW sg13_lv_pmos m=1 w=480.00n l=130.00n ng=1
MP1 net12 CKPOS VDD VNW sg13_lv_pmos m=1 w=480.00n l=130.00n ng=1
MP18 EDB D net12 VNW sg13_lv_pmos m=1 w=480.00n l=130.00n ng=1
MN15 Q net2 VSS VPW sg13_lv_nmos m=1 w=640.00n l=130.00n ng=1
MN13 net2 net3 VSS VPW sg13_lv_nmos m=1 w=300.0n l=130.00n ng=1
MN10 net1 net2 VSS VPW sg13_lv_nmos m=1 w=300.0n l=130.00n ng=1
MN9 net3 CKNEG net1 VPW sg13_lv_nmos m=1 w=300.0n l=130.00n ng=1
MN8 net9 CKPOS net3 VPW sg13_lv_nmos m=1 w=300.0n l=130.00n ng=1
MN7 net9 EDB VSS VPW sg13_lv_nmos m=1 w=300.0n l=130.00n ng=1
MN5 net8 net9 VSS VPW sg13_lv_nmos m=1 w=300.0n l=130.00n ng=1
MN4 EDB CKPOS net8 VPW sg13_lv_nmos m=1 w=300.0n l=130.00n ng=1
MN2 CKPOS CKNEG VSS VPW sg13_lv_nmos m=1 w=640.00n l=130.00n ng=1
MN1 CKNEG CK VSS VPW sg13_lv_nmos m=1 w=300.0n l=130.00n ng=1
MN16 EDB CKNEG net21 VPW sg13_lv_nmos m=1 w=300.0n l=130.00n ng=1
MP2 net21 D VSS VPW sg13_lv_nmos m=1 w=300.0n l=130.00n ng=1
.ENDS

************************************************************************
* Library Name: ez130_8t
* Cell Name:    DFFQX3
* View Name:    schematic
************************************************************************

.SUBCKT DFFQX3 CK D Q VDD VNW VPW VSS
*.PININFO CK:I D:I Q:O VDD:B VNW:B VPW:B VSS:B
MP17 Q net2 VDD VNW sg13_lv_pmos m=1 w=1.32u l=130.00n ng=1
MP15 net2 net3 VDD VNW sg13_lv_pmos m=1 w=480.00n l=130.00n ng=1
MP13 net3 CKPOS net10 VNW sg13_lv_pmos m=1 w=480.00n l=130.00n ng=1
MP12 net10 net2 VDD VNW sg13_lv_pmos m=1 w=480.00n l=130.00n ng=1
MP11 net9 CKNEG net3 VNW sg13_lv_pmos m=1 w=480.00n l=130.00n ng=1
MP10 net9 EDB VDD VNW sg13_lv_pmos m=1 w=480.00n l=130.00n ng=1
MP8 EDB CKNEG net6 VNW sg13_lv_pmos m=1 w=480.00n l=130.00n ng=1
MP7 net6 net9 VDD VNW sg13_lv_pmos m=1 w=480.00n l=130.00n ng=1
MP5 CKPOS CKNEG VDD VNW sg13_lv_pmos m=1 w=980.00n l=130.00n ng=1
MP4 CKNEG CK VDD VNW sg13_lv_pmos m=1 w=480.00n l=130.00n ng=1
MP1 net12 CKPOS VDD VNW sg13_lv_pmos m=1 w=480.00n l=130.00n ng=1
MP18 EDB D net12 VNW sg13_lv_pmos m=1 w=480.00n l=130.00n ng=1
MN15 Q net2 VSS VPW sg13_lv_nmos m=1 w=860.00n l=130.00n ng=1
MN13 net2 net3 VSS VPW sg13_lv_nmos m=1 w=300.0n l=130.00n ng=1
MN10 net1 net2 VSS VPW sg13_lv_nmos m=1 w=300.0n l=130.00n ng=1
MN9 net3 CKNEG net1 VPW sg13_lv_nmos m=1 w=300.0n l=130.00n ng=1
MN8 net9 CKPOS net3 VPW sg13_lv_nmos m=1 w=300.0n l=130.00n ng=1
MN7 net9 EDB VSS VPW sg13_lv_nmos m=1 w=300.0n l=130.00n ng=1
MN5 net8 net9 VSS VPW sg13_lv_nmos m=1 w=300.0n l=130.00n ng=1
MN4 EDB CKPOS net8 VPW sg13_lv_nmos m=1 w=300.0n l=130.00n ng=1
MN2 CKPOS CKNEG VSS VPW sg13_lv_nmos m=1 w=640.00n l=130.00n ng=1
MN1 CKNEG CK VSS VPW sg13_lv_nmos m=1 w=300.0n l=130.00n ng=1
MN16 EDB CKNEG net21 VPW sg13_lv_nmos m=1 w=300.0n l=130.00n ng=1
MP2 net21 D VSS VPW sg13_lv_nmos m=1 w=300.0n l=130.00n ng=1
.ENDS

************************************************************************
* Library Name: ez130_8t
* Cell Name:    DFFQX4
* View Name:    schematic
************************************************************************

.SUBCKT DFFQX4 CK D Q VDD VNW VPW VSS
*.PININFO CK:I D:I Q:O VDD:B VNW:B VPW:B VSS:B
MP17 Q net2 VDD VNW sg13_lv_pmos m=1 w=1.96u l=130.00n ng=2
MP15 net2 net3 VDD VNW sg13_lv_pmos m=1 w=480.00n l=130.00n ng=1
MP13 net3 CKPOS net10 VNW sg13_lv_pmos m=1 w=480.00n l=130.00n ng=1
MP12 net10 net2 VDD VNW sg13_lv_pmos m=1 w=480.00n l=130.00n ng=1
MP11 net9 CKNEG net3 VNW sg13_lv_pmos m=1 w=480.00n l=130.00n ng=1
MP10 net9 EDB VDD VNW sg13_lv_pmos m=1 w=480.00n l=130.00n ng=1
MP8 EDB CKNEG net6 VNW sg13_lv_pmos m=1 w=480.00n l=130.00n ng=1
MP7 net6 net9 VDD VNW sg13_lv_pmos m=1 w=480.00n l=130.00n ng=1
MP5 CKPOS CKNEG VDD VNW sg13_lv_pmos m=1 w=980.00n l=130.00n ng=1
MP4 CKNEG CK VDD VNW sg13_lv_pmos m=1 w=480.00n l=130.00n ng=1
MP1 net12 CKPOS VDD VNW sg13_lv_pmos m=1 w=480.00n l=130.00n ng=1
MP18 EDB D net12 VNW sg13_lv_pmos m=1 w=480.00n l=130.00n ng=1
MN15 Q net2 VSS VPW sg13_lv_nmos m=1 w=1.28u l=130.00n ng=2
MN13 net2 net3 VSS VPW sg13_lv_nmos m=1 w=300.0n l=130.00n ng=1
MN10 net1 net2 VSS VPW sg13_lv_nmos m=1 w=300.0n l=130.00n ng=1
MN9 net3 CKNEG net1 VPW sg13_lv_nmos m=1 w=300.0n l=130.00n ng=1
MN8 net9 CKPOS net3 VPW sg13_lv_nmos m=1 w=300.0n l=130.00n ng=1
MN7 net9 EDB VSS VPW sg13_lv_nmos m=1 w=300.0n l=130.00n ng=1
MN5 net8 net9 VSS VPW sg13_lv_nmos m=1 w=300.0n l=130.00n ng=1
MN4 EDB CKPOS net8 VPW sg13_lv_nmos m=1 w=300.0n l=130.00n ng=1
MN2 CKPOS CKNEG VSS VPW sg13_lv_nmos m=1 w=640.00n l=130.00n ng=1
MN1 CKNEG CK VSS VPW sg13_lv_nmos m=1 w=300.0n l=130.00n ng=1
MN16 EDB CKNEG net21 VPW sg13_lv_nmos m=1 w=300.0n l=130.00n ng=1
MP2 net21 D VSS VPW sg13_lv_nmos m=1 w=300.0n l=130.00n ng=1
.ENDS

************************************************************************
* Library Name: ez130_8t
* Cell Name:    DFFQX6
* View Name:    schematic
************************************************************************

.SUBCKT DFFQX6 CK D Q VDD VNW VPW VSS
*.PININFO CK:I D:I Q:O VDD:B VNW:B VPW:B VSS:B
MP17 Q net2 VDD VNW sg13_lv_pmos m=1 w=2.64u l=130.00n ng=2
MP15 net2 net3 VDD VNW sg13_lv_pmos m=1 w=480.00n l=130.00n ng=1
MP13 net3 CKPOS net10 VNW sg13_lv_pmos m=1 w=480.00n l=130.00n ng=1
MP12 net10 net2 VDD VNW sg13_lv_pmos m=1 w=480.00n l=130.00n ng=1
MP11 net9 CKNEG net3 VNW sg13_lv_pmos m=1 w=480.00n l=130.00n ng=1
MP10 net9 EDB VDD VNW sg13_lv_pmos m=1 w=480.00n l=130.00n ng=1
MP8 EDB CKNEG net6 VNW sg13_lv_pmos m=1 w=480.00n l=130.00n ng=1
MP7 net6 net9 VDD VNW sg13_lv_pmos m=1 w=480.00n l=130.00n ng=1
MP5 CKPOS CKNEG VDD VNW sg13_lv_pmos m=1 w=980.00n l=130.00n ng=1
MP4 CKNEG CK VDD VNW sg13_lv_pmos m=1 w=480.00n l=130.00n ng=1
MP1 net12 CKPOS VDD VNW sg13_lv_pmos m=1 w=480.00n l=130.00n ng=1
MP18 EDB D net12 VNW sg13_lv_pmos m=1 w=480.00n l=130.00n ng=1
MN15 Q net2 VSS VPW sg13_lv_nmos m=1 w=1.72u l=130.00n ng=2
MN13 net2 net3 VSS VPW sg13_lv_nmos m=1 w=300.0n l=130.00n ng=1
MN10 net1 net2 VSS VPW sg13_lv_nmos m=1 w=300.0n l=130.00n ng=1
MN9 net3 CKNEG net1 VPW sg13_lv_nmos m=1 w=300.0n l=130.00n ng=1
MN8 net9 CKPOS net3 VPW sg13_lv_nmos m=1 w=300.0n l=130.00n ng=1
MN7 net9 EDB VSS VPW sg13_lv_nmos m=1 w=300.0n l=130.00n ng=1
MN5 net8 net9 VSS VPW sg13_lv_nmos m=1 w=300.0n l=130.00n ng=1
MN4 EDB CKPOS net8 VPW sg13_lv_nmos m=1 w=300.0n l=130.00n ng=1
MN2 CKPOS CKNEG VSS VPW sg13_lv_nmos m=1 w=640.00n l=130.00n ng=1
MN1 CKNEG CK VSS VPW sg13_lv_nmos m=1 w=300.0n l=130.00n ng=1
MN16 EDB CKNEG net21 VPW sg13_lv_nmos m=1 w=300.0n l=130.00n ng=1
MP2 net21 D VSS VPW sg13_lv_nmos m=1 w=300.0n l=130.00n ng=1
.ENDS

************************************************************************
* Library Name: ez130_8t
* Cell Name:    DFFMRQX2
* View Name:    schematic
************************************************************************

.SUBCKT DFFMRQX2 CK D Q RB SD SE VDD VNW VPW VSS
*.PININFO CK:I D:I RB:I SD:I SE:I Q:O VDD:B VNW:B VPW:B VSS:B
MP64 net12 SE VDD VNW sg13_lv_pmos m=1 w=480.00n l=130.00n ng=1
MP63 net11 SEI VDD VNW sg13_lv_pmos m=1 w=480.00n l=130.00n ng=1
MP0 net3 CKNEG net6 VNW sg13_lv_pmos m=1 w=480.00n l=130.00n ng=1
MP51 net3 EDB VDD VNW sg13_lv_pmos m=1 w=480.00n l=130.00n ng=1
MP50 EDB RB VDD VNW sg13_lv_pmos m=1 w=480.00n l=130.00n ng=1
MP49 net6 CKPOS net8 VNW sg13_lv_pmos m=1 w=480.00n l=130.00n ng=1
MP48 EDB CKNEG net7 VNW sg13_lv_pmos m=1 w=480.00n l=130.00n ng=1
MP62 SEI SE VDD VNW sg13_lv_pmos m=1 w=480.00n l=130.00n ng=1
MP61 CKPOS CKNEG VDD VNW sg13_lv_pmos m=1 w=980.00n l=130.00n ng=1
MP60 CKNEG CK VDD VNW sg13_lv_pmos m=1 w=480.00n l=130.00n ng=1
MP59 net9 D net12 VNW sg13_lv_pmos m=1 w=480.00n l=130.00n ng=1
MP58 net9 SD net11 VNW sg13_lv_pmos m=1 w=480.00n l=130.00n ng=1
MP57 net9 CKPOS EDB VNW sg13_lv_pmos m=1 w=480.00n l=130.00n ng=1
MP56 net8 net1 VDD VNW sg13_lv_pmos m=1 w=480.00n l=130.00n ng=1
MP55 net7 net3 VDD VNW sg13_lv_pmos m=1 w=480.00n l=130.00n ng=1
MP54 Q net1 VDD VNW sg13_lv_pmos m=1 w=980.00n l=130.00n ng=1
MP53 net1 net6 VDD VNW sg13_lv_pmos m=1 w=480.00n l=130.00n ng=1
MP52 net1 RB VDD VNW sg13_lv_pmos m=1 w=480.00n l=130.00n ng=1
MN53 net13 net6 VSS VPW sg13_lv_nmos m=1 w=300.0n l=130.00n ng=1
MN52 net4 RB VSS VPW sg13_lv_nmos m=1 w=305.000n l=130.00n ng=1
MN65 net9 SD net14 VPW sg13_lv_nmos m=1 w=300.0n l=130.00n ng=1
MN63 net14 SE net15 VPW sg13_lv_nmos m=1 w=300.0n l=130.00n ng=1
MN62 net10 SEI net15 VPW sg13_lv_nmos m=1 w=300.0n l=130.00n ng=1
MN58 net3 EDB VSS VPW sg13_lv_nmos m=1 w=305.000n l=130.00n ng=1
MN57 EDB CKPOS net5 VPW sg13_lv_nmos m=1 w=305.000n l=130.00n ng=1
MN59 net1 RB net13 VPW sg13_lv_nmos m=1 w=300.0n l=130.00n ng=1
MN68 SEI SE VSS VPW sg13_lv_nmos m=1 w=300.0n l=130.00n ng=1
MN67 CKPOS CKNEG VSS VPW sg13_lv_nmos m=1 w=640.00n l=130.00n ng=1
MN66 CKNEG CK VSS VPW sg13_lv_nmos m=1 w=300.0n l=130.00n ng=1
MN64 net9 D net10 VPW sg13_lv_nmos m=1 w=300.0n l=130.00n ng=1
MN69 net15 RB VSS VPW sg13_lv_nmos m=1 w=300.0n l=130.00n ng=1
MN61 net9 CKNEG EDB VPW sg13_lv_nmos m=1 w=300.0n l=130.00n ng=1
MN0 net3 CKPOS net6 VPW sg13_lv_nmos m=1 w=305.000n l=130.00n ng=1
MN60 Q net1 VSS VPW sg13_lv_nmos m=1 w=640.00n l=130.00n ng=1
MN56 net6 CKNEG net2 VPW sg13_lv_nmos m=1 w=300.0n l=130.00n ng=1
MN55 net5 net3 net4 VPW sg13_lv_nmos m=1 w=305.000n l=130.00n ng=1
MN54 net2 net1 VSS VPW sg13_lv_nmos m=1 w=300.0n l=130.00n ng=1
.ENDS

************************************************************************
* Library Name: ez130_8t
* Cell Name:    DFFRQX1
* View Name:    schematic
************************************************************************

.SUBCKT DFFRQX1 CK D Q RB VDD VNW VPW VSS
*.PININFO CK:I D:I RB:I Q:O VDD:B VNW:B VPW:B VSS:B
MP17 Q net2 VDD VNW sg13_lv_pmos m=1 w=480.00n l=130.00n ng=1
MP15 net2 net3 VDD VNW sg13_lv_pmos m=1 w=480.00n l=130.00n ng=1
MP14 net2 RB VDD VNW sg13_lv_pmos m=1 w=480.00n l=130.00n ng=1
MP13 net3 CKPOS net10 VNW sg13_lv_pmos m=1 w=480.00n l=130.00n ng=1
MP12 net10 net2 VDD VNW sg13_lv_pmos m=1 w=480.00n l=130.00n ng=1
MP11 net9 CKNEG net3 VNW sg13_lv_pmos m=1 w=480.00n l=130.00n ng=1
MP10 net9 EDB VDD VNW sg13_lv_pmos m=1 w=480.00n l=130.00n ng=1
MP9 EDB RB VDD VNW sg13_lv_pmos m=1 w=480.00n l=130.00n ng=1
MP8 EDB CKNEG net6 VNW sg13_lv_pmos m=1 w=480.00n l=130.00n ng=1
MP7 net6 net9 VDD VNW sg13_lv_pmos m=1 w=480.00n l=130.00n ng=1
MP5 CKPOS CKNEG VDD VNW sg13_lv_pmos m=1 w=980.00n l=130.00n ng=1
MP4 CKNEG CK VDD VNW sg13_lv_pmos m=1 w=480.00n l=130.00n ng=1
MP1 net12 CKPOS VDD VNW sg13_lv_pmos m=1 w=480.00n l=130.00n ng=1
MP18 EDB D net12 VNW sg13_lv_pmos m=1 w=480.00n l=130.00n ng=1
MN17 net20 RB VSS VPW sg13_lv_nmos m=1 w=300.0n l=130.00n ng=1
MN15 Q net2 VSS VPW sg13_lv_nmos m=1 w=300.0n l=130.00n ng=1
MN13 net5 net3 VSS VPW sg13_lv_nmos m=1 w=300.0n l=130.00n ng=1
MN12 net2 RB net5 VPW sg13_lv_nmos m=1 w=300.0n l=130.00n ng=1
MN10 net1 net2 VSS VPW sg13_lv_nmos m=1 w=300.0n l=130.00n ng=1
MN9 net3 CKNEG net1 VPW sg13_lv_nmos m=1 w=300.0n l=130.00n ng=1
MN8 net9 CKPOS net3 VPW sg13_lv_nmos m=1 w=300.0n l=130.00n ng=1
MN7 net9 EDB VSS VPW sg13_lv_nmos m=1 w=300.0n l=130.00n ng=1
MN6 net7 RB VSS VPW sg13_lv_nmos m=1 w=300.0n l=130.00n ng=1
MN5 net8 net9 net7 VPW sg13_lv_nmos m=1 w=300.0n l=130.00n ng=1
MN4 EDB CKPOS net8 VPW sg13_lv_nmos m=1 w=300.0n l=130.00n ng=1
MN2 CKPOS CKNEG VSS VPW sg13_lv_nmos m=1 w=640.00n l=130.00n ng=1
MN1 CKNEG CK VSS VPW sg13_lv_nmos m=1 w=300.0n l=130.00n ng=1
MN16 EDB CKNEG net21 VPW sg13_lv_nmos m=1 w=300.0n l=130.00n ng=1
MP2 net21 D net20 VPW sg13_lv_nmos m=1 w=300.0n l=130.00n ng=1
.ENDS

************************************************************************
* Library Name: ez130_8t
* Cell Name:    DFFRQX1P5
* View Name:    schematic
************************************************************************

.SUBCKT DFFRQX1P5 CK D Q RB VDD VNW VPW VSS
*.PININFO CK:I D:I RB:I Q:O VDD:B VNW:B VPW:B VSS:B
MP17 Q net2 VDD VNW sg13_lv_pmos m=1 w=720.00n l=130.00n ng=1
MP15 net2 net3 VDD VNW sg13_lv_pmos m=1 w=480.00n l=130.00n ng=1
MP14 net2 RB VDD VNW sg13_lv_pmos m=1 w=480.00n l=130.00n ng=1
MP13 net3 CKPOS net10 VNW sg13_lv_pmos m=1 w=480.00n l=130.00n ng=1
MP12 net10 net2 VDD VNW sg13_lv_pmos m=1 w=480.00n l=130.00n ng=1
MP11 net9 CKNEG net3 VNW sg13_lv_pmos m=1 w=480.00n l=130.00n ng=1
MP10 net9 EDB VDD VNW sg13_lv_pmos m=1 w=480.00n l=130.00n ng=1
MP9 EDB RB VDD VNW sg13_lv_pmos m=1 w=480.00n l=130.00n ng=1
MP8 EDB CKNEG net6 VNW sg13_lv_pmos m=1 w=480.00n l=130.00n ng=1
MP7 net6 net9 VDD VNW sg13_lv_pmos m=1 w=480.00n l=130.00n ng=1
MP5 CKPOS CKNEG VDD VNW sg13_lv_pmos m=1 w=980.00n l=130.00n ng=1
MP4 CKNEG CK VDD VNW sg13_lv_pmos m=1 w=480.00n l=130.00n ng=1
MP1 net12 CKPOS VDD VNW sg13_lv_pmos m=1 w=480.00n l=130.00n ng=1
MP18 EDB D net12 VNW sg13_lv_pmos m=1 w=480.00n l=130.00n ng=1
MN17 net20 RB VSS VPW sg13_lv_nmos m=1 w=300.0n l=130.00n ng=1
MN15 Q net2 VSS VPW sg13_lv_nmos m=1 w=480.00n l=130.00n ng=1
MN13 net5 net3 VSS VPW sg13_lv_nmos m=1 w=300.0n l=130.00n ng=1
MN12 net2 RB net5 VPW sg13_lv_nmos m=1 w=300.0n l=130.00n ng=1
MN10 net1 net2 VSS VPW sg13_lv_nmos m=1 w=300.0n l=130.00n ng=1
MN9 net3 CKNEG net1 VPW sg13_lv_nmos m=1 w=300.0n l=130.00n ng=1
MN8 net9 CKPOS net3 VPW sg13_lv_nmos m=1 w=300.0n l=130.00n ng=1
MN7 net9 EDB VSS VPW sg13_lv_nmos m=1 w=300.0n l=130.00n ng=1
MN6 net7 RB VSS VPW sg13_lv_nmos m=1 w=300.0n l=130.00n ng=1
MN5 net8 net9 net7 VPW sg13_lv_nmos m=1 w=300.0n l=130.00n ng=1
MN4 EDB CKPOS net8 VPW sg13_lv_nmos m=1 w=300.0n l=130.00n ng=1
MN2 CKPOS CKNEG VSS VPW sg13_lv_nmos m=1 w=640.00n l=130.00n ng=1
MN1 CKNEG CK VSS VPW sg13_lv_nmos m=1 w=300.0n l=130.00n ng=1
MN16 EDB CKNEG net21 VPW sg13_lv_nmos m=1 w=300.0n l=130.00n ng=1
MP2 net21 D net20 VPW sg13_lv_nmos m=1 w=300.0n l=130.00n ng=1
.ENDS

************************************************************************
* Library Name: ez130_8t
* Cell Name:    DFFRQX2
* View Name:    schematic
************************************************************************

.SUBCKT DFFRQX2 CK D Q RB VDD VNW VPW VSS
*.PININFO CK:I D:I RB:I Q:O VDD:B VNW:B VPW:B VSS:B
MP17 Q net2 VDD VNW sg13_lv_pmos m=1 w=980.00n l=130.00n ng=1
MP15 net2 net3 VDD VNW sg13_lv_pmos m=1 w=480.00n l=130.00n ng=1
MP14 net2 RB VDD VNW sg13_lv_pmos m=1 w=480.00n l=130.00n ng=1
MP13 net3 CKPOS net10 VNW sg13_lv_pmos m=1 w=480.00n l=130.00n ng=1
MP12 net10 net2 VDD VNW sg13_lv_pmos m=1 w=480.00n l=130.00n ng=1
MP11 net9 CKNEG net3 VNW sg13_lv_pmos m=1 w=480.00n l=130.00n ng=1
MP10 net9 EDB VDD VNW sg13_lv_pmos m=1 w=480.00n l=130.00n ng=1
MP9 EDB RB VDD VNW sg13_lv_pmos m=1 w=480.00n l=130.00n ng=1
MP8 EDB CKNEG net6 VNW sg13_lv_pmos m=1 w=480.00n l=130.00n ng=1
MP7 net6 net9 VDD VNW sg13_lv_pmos m=1 w=480.00n l=130.00n ng=1
MP5 CKPOS CKNEG VDD VNW sg13_lv_pmos m=1 w=980.00n l=130.00n ng=1
MP4 CKNEG CK VDD VNW sg13_lv_pmos m=1 w=480.00n l=130.00n ng=1
MP1 net12 CKPOS VDD VNW sg13_lv_pmos m=1 w=480.00n l=130.00n ng=1
MP18 EDB D net12 VNW sg13_lv_pmos m=1 w=480.00n l=130.00n ng=1
MN17 net20 RB VSS VPW sg13_lv_nmos m=1 w=300.0n l=130.00n ng=1
MN15 Q net2 VSS VPW sg13_lv_nmos m=1 w=640.00n l=130.00n ng=1
MN13 net5 net3 VSS VPW sg13_lv_nmos m=1 w=300.0n l=130.00n ng=1
MN12 net2 RB net5 VPW sg13_lv_nmos m=1 w=300.0n l=130.00n ng=1
MN10 net1 net2 VSS VPW sg13_lv_nmos m=1 w=300.0n l=130.00n ng=1
MN9 net3 CKNEG net1 VPW sg13_lv_nmos m=1 w=300.0n l=130.00n ng=1
MN8 net9 CKPOS net3 VPW sg13_lv_nmos m=1 w=300.0n l=130.00n ng=1
MN7 net9 EDB VSS VPW sg13_lv_nmos m=1 w=300.0n l=130.00n ng=1
MN6 net7 RB VSS VPW sg13_lv_nmos m=1 w=300.0n l=130.00n ng=1
MN5 net8 net9 net7 VPW sg13_lv_nmos m=1 w=300.0n l=130.00n ng=1
MN4 EDB CKPOS net8 VPW sg13_lv_nmos m=1 w=300.0n l=130.00n ng=1
MN2 CKPOS CKNEG VSS VPW sg13_lv_nmos m=1 w=640.00n l=130.00n ng=1
MN1 CKNEG CK VSS VPW sg13_lv_nmos m=1 w=300.0n l=130.00n ng=1
MN16 EDB CKNEG net21 VPW sg13_lv_nmos m=1 w=300.0n l=130.00n ng=1
MP2 net21 D net20 VPW sg13_lv_nmos m=1 w=300.0n l=130.00n ng=1
.ENDS

************************************************************************
* Library Name: ez130_8t
* Cell Name:    DFFRQX3
* View Name:    schematic
************************************************************************

.SUBCKT DFFRQX3 CK D Q RB VDD VNW VPW VSS
*.PININFO CK:I D:I RB:I Q:O VDD:B VNW:B VPW:B VSS:B
MP17 Q net2 VDD VNW sg13_lv_pmos m=1 w=1.32u l=130.00n ng=1
MP15 net2 net3 VDD VNW sg13_lv_pmos m=1 w=480.00n l=130.00n ng=1
MP14 net2 RB VDD VNW sg13_lv_pmos m=1 w=480.00n l=130.00n ng=1
MP13 net3 CKPOS net10 VNW sg13_lv_pmos m=1 w=480.00n l=130.00n ng=1
MP12 net10 net2 VDD VNW sg13_lv_pmos m=1 w=480.00n l=130.00n ng=1
MP11 net9 CKNEG net3 VNW sg13_lv_pmos m=1 w=480.00n l=130.00n ng=1
MP10 net9 EDB VDD VNW sg13_lv_pmos m=1 w=480.00n l=130.00n ng=1
MP9 EDB RB VDD VNW sg13_lv_pmos m=1 w=480.00n l=130.00n ng=1
MP8 EDB CKNEG net6 VNW sg13_lv_pmos m=1 w=480.00n l=130.00n ng=1
MP7 net6 net9 VDD VNW sg13_lv_pmos m=1 w=480.00n l=130.00n ng=1
MP5 CKPOS CKNEG VDD VNW sg13_lv_pmos m=1 w=980.00n l=130.00n ng=1
MP4 CKNEG CK VDD VNW sg13_lv_pmos m=1 w=480.00n l=130.00n ng=1
MP1 net12 CKPOS VDD VNW sg13_lv_pmos m=1 w=480.00n l=130.00n ng=1
MP18 EDB D net12 VNW sg13_lv_pmos m=1 w=480.00n l=130.00n ng=1
MN17 net20 RB VSS VPW sg13_lv_nmos m=1 w=300.0n l=130.00n ng=1
MN15 Q net2 VSS VPW sg13_lv_nmos m=1 w=860.00n l=130.00n ng=1
MN13 net5 net3 VSS VPW sg13_lv_nmos m=1 w=300.0n l=130.00n ng=1
MN12 net2 RB net5 VPW sg13_lv_nmos m=1 w=300.0n l=130.00n ng=1
MN10 net1 net2 VSS VPW sg13_lv_nmos m=1 w=300.0n l=130.00n ng=1
MN9 net3 CKNEG net1 VPW sg13_lv_nmos m=1 w=300.0n l=130.00n ng=1
MN8 net9 CKPOS net3 VPW sg13_lv_nmos m=1 w=300.0n l=130.00n ng=1
MN7 net9 EDB VSS VPW sg13_lv_nmos m=1 w=300.0n l=130.00n ng=1
MN6 net7 RB VSS VPW sg13_lv_nmos m=1 w=300.0n l=130.00n ng=1
MN5 net8 net9 net7 VPW sg13_lv_nmos m=1 w=300.0n l=130.00n ng=1
MN4 EDB CKPOS net8 VPW sg13_lv_nmos m=1 w=300.0n l=130.00n ng=1
MN2 CKPOS CKNEG VSS VPW sg13_lv_nmos m=1 w=640.00n l=130.00n ng=1
MN1 CKNEG CK VSS VPW sg13_lv_nmos m=1 w=300.0n l=130.00n ng=1
MN16 EDB CKNEG net21 VPW sg13_lv_nmos m=1 w=300.0n l=130.00n ng=1
MP2 net21 D net20 VPW sg13_lv_nmos m=1 w=300.0n l=130.00n ng=1
.ENDS

************************************************************************
* Library Name: ez130_8t
* Cell Name:    DFFRQX4
* View Name:    schematic
************************************************************************

.SUBCKT DFFRQX4 CK D Q RB VDD VNW VPW VSS
*.PININFO CK:I D:I RB:I Q:O VDD:B VNW:B VPW:B VSS:B
MP17 Q net2 VDD VNW sg13_lv_pmos m=1 w=1.96u l=130.00n ng=2
MP15 net2 net3 VDD VNW sg13_lv_pmos m=1 w=480.00n l=130.00n ng=1
MP14 net2 RB VDD VNW sg13_lv_pmos m=1 w=480.00n l=130.00n ng=1
MP13 net3 CKPOS net10 VNW sg13_lv_pmos m=1 w=480.00n l=130.00n ng=1
MP12 net10 net2 VDD VNW sg13_lv_pmos m=1 w=480.00n l=130.00n ng=1
MP11 net9 CKNEG net3 VNW sg13_lv_pmos m=1 w=480.00n l=130.00n ng=1
MP10 net9 EDB VDD VNW sg13_lv_pmos m=1 w=480.00n l=130.00n ng=1
MP9 EDB RB VDD VNW sg13_lv_pmos m=1 w=480.00n l=130.00n ng=1
MP8 EDB CKNEG net6 VNW sg13_lv_pmos m=1 w=480.00n l=130.00n ng=1
MP7 net6 net9 VDD VNW sg13_lv_pmos m=1 w=480.00n l=130.00n ng=1
MP5 CKPOS CKNEG VDD VNW sg13_lv_pmos m=1 w=980.00n l=130.00n ng=1
MP4 CKNEG CK VDD VNW sg13_lv_pmos m=1 w=480.00n l=130.00n ng=1
MP1 net12 CKPOS VDD VNW sg13_lv_pmos m=1 w=480.00n l=130.00n ng=1
MP18 EDB D net12 VNW sg13_lv_pmos m=1 w=480.00n l=130.00n ng=1
MN17 net20 RB VSS VPW sg13_lv_nmos m=1 w=300.0n l=130.00n ng=1
MN15 Q net2 VSS VPW sg13_lv_nmos m=1 w=1.28u l=130.00n ng=2
MN13 net5 net3 VSS VPW sg13_lv_nmos m=1 w=300.0n l=130.00n ng=1
MN12 net2 RB net5 VPW sg13_lv_nmos m=1 w=300.0n l=130.00n ng=1
MN10 net1 net2 VSS VPW sg13_lv_nmos m=1 w=300.0n l=130.00n ng=1
MN9 net3 CKNEG net1 VPW sg13_lv_nmos m=1 w=300.0n l=130.00n ng=1
MN8 net9 CKPOS net3 VPW sg13_lv_nmos m=1 w=300.0n l=130.00n ng=1
MN7 net9 EDB VSS VPW sg13_lv_nmos m=1 w=300.0n l=130.00n ng=1
MN6 net7 RB VSS VPW sg13_lv_nmos m=1 w=300.0n l=130.00n ng=1
MN5 net8 net9 net7 VPW sg13_lv_nmos m=1 w=300.0n l=130.00n ng=1
MN4 EDB CKPOS net8 VPW sg13_lv_nmos m=1 w=300.0n l=130.00n ng=1
MN2 CKPOS CKNEG VSS VPW sg13_lv_nmos m=1 w=640.00n l=130.00n ng=1
MN1 CKNEG CK VSS VPW sg13_lv_nmos m=1 w=300.0n l=130.00n ng=1
MN16 EDB CKNEG net21 VPW sg13_lv_nmos m=1 w=300.0n l=130.00n ng=1
MP2 net21 D net20 VPW sg13_lv_nmos m=1 w=300.0n l=130.00n ng=1
.ENDS

************************************************************************
* Library Name: ez130_8t
* Cell Name:    DFFRQX6
* View Name:    schematic
************************************************************************

.SUBCKT DFFRQX6 CK D Q RB VDD VNW VPW VSS
*.PININFO CK:I D:I RB:I Q:O VDD:B VNW:B VPW:B VSS:B
MP17 Q net2 VDD VNW sg13_lv_pmos m=1 w=2.64u l=130.00n ng=2
MP15 net2 net3 VDD VNW sg13_lv_pmos m=1 w=480.00n l=130.00n ng=1
MP14 net2 RB VDD VNW sg13_lv_pmos m=1 w=480.00n l=130.00n ng=1
MP13 net3 CKPOS net10 VNW sg13_lv_pmos m=1 w=480.00n l=130.00n ng=1
MP12 net10 net2 VDD VNW sg13_lv_pmos m=1 w=480.00n l=130.00n ng=1
MP11 net9 CKNEG net3 VNW sg13_lv_pmos m=1 w=480.00n l=130.00n ng=1
MP10 net9 EDB VDD VNW sg13_lv_pmos m=1 w=480.00n l=130.00n ng=1
MP9 EDB RB VDD VNW sg13_lv_pmos m=1 w=480.00n l=130.00n ng=1
MP8 EDB CKNEG net6 VNW sg13_lv_pmos m=1 w=480.00n l=130.00n ng=1
MP7 net6 net9 VDD VNW sg13_lv_pmos m=1 w=480.00n l=130.00n ng=1
MP5 CKPOS CKNEG VDD VNW sg13_lv_pmos m=1 w=980.00n l=130.00n ng=1
MP4 CKNEG CK VDD VNW sg13_lv_pmos m=1 w=480.00n l=130.00n ng=1
MP1 net12 CKPOS VDD VNW sg13_lv_pmos m=1 w=480.00n l=130.00n ng=1
MP18 EDB D net12 VNW sg13_lv_pmos m=1 w=480.00n l=130.00n ng=1
MN17 net20 RB VSS VPW sg13_lv_nmos m=1 w=300.0n l=130.00n ng=1
MN15 Q net2 VSS VPW sg13_lv_nmos m=1 w=1.72u l=130.00n ng=2
MN13 net5 net3 VSS VPW sg13_lv_nmos m=1 w=300.0n l=130.00n ng=1
MN12 net2 RB net5 VPW sg13_lv_nmos m=1 w=300.0n l=130.00n ng=1
MN10 net1 net2 VSS VPW sg13_lv_nmos m=1 w=300.0n l=130.00n ng=1
MN9 net3 CKNEG net1 VPW sg13_lv_nmos m=1 w=300.0n l=130.00n ng=1
MN8 net9 CKPOS net3 VPW sg13_lv_nmos m=1 w=300.0n l=130.00n ng=1
MN7 net9 EDB VSS VPW sg13_lv_nmos m=1 w=300.0n l=130.00n ng=1
MN6 net7 RB VSS VPW sg13_lv_nmos m=1 w=300.0n l=130.00n ng=1
MN5 net8 net9 net7 VPW sg13_lv_nmos m=1 w=300.0n l=130.00n ng=1
MN4 EDB CKPOS net8 VPW sg13_lv_nmos m=1 w=300.0n l=130.00n ng=1
MN2 CKPOS CKNEG VSS VPW sg13_lv_nmos m=1 w=640.00n l=130.00n ng=1
MN1 CKNEG CK VSS VPW sg13_lv_nmos m=1 w=300.0n l=130.00n ng=1
MN16 EDB CKNEG net21 VPW sg13_lv_nmos m=1 w=300.0n l=130.00n ng=1
MP2 net21 D net20 VPW sg13_lv_nmos m=1 w=300.0n l=130.00n ng=1
.ENDS

************************************************************************
* Library Name: ez130_8t
* Cell Name:    DFFRQ2X1
* View Name:    schematic
************************************************************************

.SUBCKT DFFRQ2X1 CK D0 D1 Q0 Q1 RB VDD VNW VPW VSS
*.PININFO CK:I D0:I D1:I RB:I Q0:O Q1:O VDD:B VNW:B VPW:B VSS:B
MP32 net37 CKPOS VDD VNW sg13_lv_pmos m=1 w=480.00n l=130.00n ng=1
MP31 net50 net36 VDD VNW sg13_lv_pmos m=1 w=480.00n l=130.00n ng=1
MP30 net51 net41 VDD VNW sg13_lv_pmos m=1 w=480.00n l=130.00n ng=1
MP29 net41 CKNEG net4 VNW sg13_lv_pmos m=1 w=480.00n l=130.00n ng=1
MP28 Q1 net36 VDD VNW sg13_lv_pmos m=1 w=480.00n l=130.00n ng=1
MP27 net36 net4 VDD VNW sg13_lv_pmos m=1 w=480.00n l=130.00n ng=1
MP26 net36 RB VDD VNW sg13_lv_pmos m=1 w=480.00n l=130.00n ng=1
MP25 net41 ED1B VDD VNW sg13_lv_pmos m=1 w=480.00n l=130.00n ng=1
MP24 ED1B RB VDD VNW sg13_lv_pmos m=1 w=480.00n l=130.00n ng=1
MP21 ED1B D1 net37 VNW sg13_lv_pmos m=1 w=480.00n l=130.00n ng=1
MP20 net4 CKPOS net50 VNW sg13_lv_pmos m=1 w=480.00n l=130.00n ng=1
MP19 ED1B CKNEG net51 VNW sg13_lv_pmos m=1 w=480.00n l=130.00n ng=1
MP17 Q0 net2 VDD VNW sg13_lv_pmos m=1 w=480.00n l=130.00n ng=1
MP15 net2 net3 VDD VNW sg13_lv_pmos m=1 w=480.00n l=130.00n ng=1
MP14 net2 RB VDD VNW sg13_lv_pmos m=1 w=480.00n l=130.00n ng=1
MP13 net3 CKPOS net10 VNW sg13_lv_pmos m=1 w=480.00n l=130.00n ng=1
MP12 net10 net2 VDD VNW sg13_lv_pmos m=1 w=480.00n l=130.00n ng=1
MP11 net9 CKNEG net3 VNW sg13_lv_pmos m=1 w=480.00n l=130.00n ng=1
MP10 net9 ED0B VDD VNW sg13_lv_pmos m=1 w=480.00n l=130.00n ng=1
MP9 ED0B RB VDD VNW sg13_lv_pmos m=1 w=480.00n l=130.00n ng=1
MP8 ED0B CKNEG net6 VNW sg13_lv_pmos m=1 w=480.00n l=130.00n ng=1
MP7 net6 net9 VDD VNW sg13_lv_pmos m=1 w=480.00n l=130.00n ng=1
MP5 CKPOS CKNEG VDD VNW sg13_lv_pmos m=1 w=980.00n l=130.00n ng=1
MP4 CKNEG CK VDD VNW sg13_lv_pmos m=1 w=480.00n l=130.00n ng=1
MP1 net12 CKPOS VDD VNW sg13_lv_pmos m=1 w=480.00n l=130.00n ng=1
MP18 ED0B D0 net12 VNW sg13_lv_pmos m=1 w=480.00n l=130.00n ng=1
MN32 net41 CKPOS net4 VPW sg13_lv_nmos m=1 w=300.0n l=130.00n ng=1
MN31 Q1 net36 VSS VPW sg13_lv_nmos m=1 w=300.0n l=130.00n ng=1
MN30 net36 RB net43 VPW sg13_lv_nmos m=1 w=300.0n l=130.00n ng=1
MN29 net41 ED1B VSS VPW sg13_lv_nmos m=1 w=300.0n l=130.00n ng=1
MN26 ED1B CKNEG net44 VPW sg13_lv_nmos m=1 w=300.0n l=130.00n ng=1
MN25 net4 CKNEG net11 VPW sg13_lv_nmos m=1 w=300.0n l=130.00n ng=1
MN24 ED1B CKPOS net52 VPW sg13_lv_nmos m=1 w=300.0n l=130.00n ng=1
MN23 net44 D1 net49 VPW sg13_lv_nmos m=1 w=300.0n l=130.00n ng=1
MN22 net11 net36 VSS VPW sg13_lv_nmos m=1 w=300.0n l=130.00n ng=1
MN21 net52 net41 net42 VPW sg13_lv_nmos m=1 w=300.0n l=130.00n ng=1
MN17 net20 RB VSS VPW sg13_lv_nmos m=1 w=300.0n l=130.00n ng=1
MN18 net42 RB VSS VPW sg13_lv_nmos m=1 w=300.0n l=130.00n ng=1
MN15 Q0 net2 VSS VPW sg13_lv_nmos m=1 w=300.0n l=130.00n ng=1
MN13 net5 net3 VSS VPW sg13_lv_nmos m=1 w=300.0n l=130.00n ng=1
MN12 net2 RB net5 VPW sg13_lv_nmos m=1 w=300.0n l=130.00n ng=1
MN10 net1 net2 VSS VPW sg13_lv_nmos m=1 w=300.0n l=130.00n ng=1
MN9 net3 CKNEG net1 VPW sg13_lv_nmos m=1 w=300.0n l=130.00n ng=1
MN8 net9 CKPOS net3 VPW sg13_lv_nmos m=1 w=300.0n l=130.00n ng=1
MN7 net9 ED0B VSS VPW sg13_lv_nmos m=1 w=300.0n l=130.00n ng=1
MN6 net7 RB VSS VPW sg13_lv_nmos m=1 w=300.0n l=130.00n ng=1
MN5 net8 net9 net7 VPW sg13_lv_nmos m=1 w=300.0n l=130.00n ng=1
MN4 ED0B CKPOS net8 VPW sg13_lv_nmos m=1 w=300.0n l=130.00n ng=1
MN19 net49 RB VSS VPW sg13_lv_nmos m=1 w=300.0n l=130.00n ng=1
MN20 net43 net4 VSS VPW sg13_lv_nmos m=1 w=300.0n l=130.00n ng=1
MN2 CKPOS CKNEG VSS VPW sg13_lv_nmos m=1 w=640.00n l=130.00n ng=1
MN1 CKNEG CK VSS VPW sg13_lv_nmos m=1 w=300.0n l=130.00n ng=1
MN16 ED0B CKNEG net21 VPW sg13_lv_nmos m=1 w=300.0n l=130.00n ng=1
MP2 net21 D0 net20 VPW sg13_lv_nmos m=1 w=300.0n l=130.00n ng=1
.ENDS

************************************************************************
* Library Name: ez130_8t
* Cell Name:    DFFRQ2X1P5
* View Name:    schematic
************************************************************************

.SUBCKT DFFRQ2X1P5 CK D0 D1 Q0 Q1 RB VDD VNW VPW VSS
*.PININFO CK:I D0:I D1:I RB:I Q0:O Q1:O VDD:B VNW:B VPW:B VSS:B
MP32 net37 CKPOS VDD VNW sg13_lv_pmos m=1 w=480.00n l=130.00n ng=1
MP31 net50 net36 VDD VNW sg13_lv_pmos m=1 w=480.00n l=130.00n ng=1
MP30 net51 net41 VDD VNW sg13_lv_pmos m=1 w=480.00n l=130.00n ng=1
MP29 net41 CKNEG net4 VNW sg13_lv_pmos m=1 w=480.00n l=130.00n ng=1
MP28 Q1 net36 VDD VNW sg13_lv_pmos m=1 w=720.00n l=130.00n ng=1
MP27 net36 net4 VDD VNW sg13_lv_pmos m=1 w=480.00n l=130.00n ng=1
MP26 net36 RB VDD VNW sg13_lv_pmos m=1 w=480.00n l=130.00n ng=1
MP25 net41 ED1B VDD VNW sg13_lv_pmos m=1 w=480.00n l=130.00n ng=1
MP24 ED1B RB VDD VNW sg13_lv_pmos m=1 w=480.00n l=130.00n ng=1
MP21 ED1B D1 net37 VNW sg13_lv_pmos m=1 w=480.00n l=130.00n ng=1
MP20 net4 CKPOS net50 VNW sg13_lv_pmos m=1 w=480.00n l=130.00n ng=1
MP19 ED1B CKNEG net51 VNW sg13_lv_pmos m=1 w=480.00n l=130.00n ng=1
MP17 Q0 net2 VDD VNW sg13_lv_pmos m=1 w=720.00n l=130.00n ng=1
MP15 net2 net3 VDD VNW sg13_lv_pmos m=1 w=480.00n l=130.00n ng=1
MP14 net2 RB VDD VNW sg13_lv_pmos m=1 w=480.00n l=130.00n ng=1
MP13 net3 CKPOS net10 VNW sg13_lv_pmos m=1 w=480.00n l=130.00n ng=1
MP12 net10 net2 VDD VNW sg13_lv_pmos m=1 w=480.00n l=130.00n ng=1
MP11 net9 CKNEG net3 VNW sg13_lv_pmos m=1 w=480.00n l=130.00n ng=1
MP10 net9 ED0B VDD VNW sg13_lv_pmos m=1 w=480.00n l=130.00n ng=1
MP9 ED0B RB VDD VNW sg13_lv_pmos m=1 w=480.00n l=130.00n ng=1
MP8 ED0B CKNEG net6 VNW sg13_lv_pmos m=1 w=480.00n l=130.00n ng=1
MP7 net6 net9 VDD VNW sg13_lv_pmos m=1 w=480.00n l=130.00n ng=1
MP5 CKPOS CKNEG VDD VNW sg13_lv_pmos m=1 w=980.00n l=130.00n ng=1
MP4 CKNEG CK VDD VNW sg13_lv_pmos m=1 w=480.00n l=130.00n ng=1
MP1 net12 CKPOS VDD VNW sg13_lv_pmos m=1 w=480.00n l=130.00n ng=1
MP18 ED0B D0 net12 VNW sg13_lv_pmos m=1 w=480.00n l=130.00n ng=1
MN32 net41 CKPOS net4 VPW sg13_lv_nmos m=1 w=300.0n l=130.00n ng=1
MN31 Q1 net36 VSS VPW sg13_lv_nmos m=1 w=480.00n l=130.00n ng=1
MN30 net36 RB net43 VPW sg13_lv_nmos m=1 w=300.0n l=130.00n ng=1
MN29 net41 ED1B VSS VPW sg13_lv_nmos m=1 w=300.0n l=130.00n ng=1
MN26 ED1B CKNEG net44 VPW sg13_lv_nmos m=1 w=300.0n l=130.00n ng=1
MN25 net4 CKNEG net11 VPW sg13_lv_nmos m=1 w=300.0n l=130.00n ng=1
MN24 ED1B CKPOS net52 VPW sg13_lv_nmos m=1 w=300.0n l=130.00n ng=1
MN23 net44 D1 net49 VPW sg13_lv_nmos m=1 w=300.0n l=130.00n ng=1
MN22 net11 net36 VSS VPW sg13_lv_nmos m=1 w=300.0n l=130.00n ng=1
MN21 net52 net41 net42 VPW sg13_lv_nmos m=1 w=300.0n l=130.00n ng=1
MN17 net20 RB VSS VPW sg13_lv_nmos m=1 w=300.0n l=130.00n ng=1
MN18 net42 RB VSS VPW sg13_lv_nmos m=1 w=300.0n l=130.00n ng=1
MN15 Q0 net2 VSS VPW sg13_lv_nmos m=1 w=480.00n l=130.00n ng=1
MN13 net5 net3 VSS VPW sg13_lv_nmos m=1 w=300.0n l=130.00n ng=1
MN12 net2 RB net5 VPW sg13_lv_nmos m=1 w=300.0n l=130.00n ng=1
MN10 net1 net2 VSS VPW sg13_lv_nmos m=1 w=300.0n l=130.00n ng=1
MN9 net3 CKNEG net1 VPW sg13_lv_nmos m=1 w=300.0n l=130.00n ng=1
MN8 net9 CKPOS net3 VPW sg13_lv_nmos m=1 w=300.0n l=130.00n ng=1
MN7 net9 ED0B VSS VPW sg13_lv_nmos m=1 w=300.0n l=130.00n ng=1
MN6 net7 RB VSS VPW sg13_lv_nmos m=1 w=300.0n l=130.00n ng=1
MN5 net8 net9 net7 VPW sg13_lv_nmos m=1 w=300.0n l=130.00n ng=1
MN4 ED0B CKPOS net8 VPW sg13_lv_nmos m=1 w=300.0n l=130.00n ng=1
MN19 net49 RB VSS VPW sg13_lv_nmos m=1 w=300.0n l=130.00n ng=1
MN20 net43 net4 VSS VPW sg13_lv_nmos m=1 w=300.0n l=130.00n ng=1
MN2 CKPOS CKNEG VSS VPW sg13_lv_nmos m=1 w=640.00n l=130.00n ng=1
MN1 CKNEG CK VSS VPW sg13_lv_nmos m=1 w=300.0n l=130.00n ng=1
MN16 ED0B CKNEG net21 VPW sg13_lv_nmos m=1 w=300.0n l=130.00n ng=1
MP2 net21 D0 net20 VPW sg13_lv_nmos m=1 w=300.0n l=130.00n ng=1
.ENDS

************************************************************************
* Library Name: ez130_8t
* Cell Name:    DFFRQ2X2
* View Name:    schematic
************************************************************************

.SUBCKT DFFRQ2X2 CK D0 D1 Q0 Q1 RB VDD VNW VPW VSS
*.PININFO CK:I D0:I D1:I RB:I Q0:O Q1:O VDD:B VNW:B VPW:B VSS:B
MP32 net37 CKPOS VDD VNW sg13_lv_pmos m=1 w=480.00n l=130.00n ng=1
MP31 net50 net36 VDD VNW sg13_lv_pmos m=1 w=480.00n l=130.00n ng=1
MP30 net51 net41 VDD VNW sg13_lv_pmos m=1 w=480.00n l=130.00n ng=1
MP29 net41 CKNEG net4 VNW sg13_lv_pmos m=1 w=480.00n l=130.00n ng=1
MP28 Q1 net36 VDD VNW sg13_lv_pmos m=1 w=980.00n l=130.00n ng=1
MP27 net36 net4 VDD VNW sg13_lv_pmos m=1 w=480.00n l=130.00n ng=1
MP26 net36 RB VDD VNW sg13_lv_pmos m=1 w=480.00n l=130.00n ng=1
MP25 net41 ED1B VDD VNW sg13_lv_pmos m=1 w=480.00n l=130.00n ng=1
MP24 ED1B RB VDD VNW sg13_lv_pmos m=1 w=480.00n l=130.00n ng=1
MP21 ED1B D1 net37 VNW sg13_lv_pmos m=1 w=480.00n l=130.00n ng=1
MP20 net4 CKPOS net50 VNW sg13_lv_pmos m=1 w=480.00n l=130.00n ng=1
MP19 ED1B CKNEG net51 VNW sg13_lv_pmos m=1 w=480.00n l=130.00n ng=1
MP17 Q0 net2 VDD VNW sg13_lv_pmos m=1 w=980.00n l=130.00n ng=1
MP15 net2 net3 VDD VNW sg13_lv_pmos m=1 w=480.00n l=130.00n ng=1
MP14 net2 RB VDD VNW sg13_lv_pmos m=1 w=480.00n l=130.00n ng=1
MP13 net3 CKPOS net10 VNW sg13_lv_pmos m=1 w=480.00n l=130.00n ng=1
MP12 net10 net2 VDD VNW sg13_lv_pmos m=1 w=480.00n l=130.00n ng=1
MP11 net9 CKNEG net3 VNW sg13_lv_pmos m=1 w=480.00n l=130.00n ng=1
MP10 net9 ED0B VDD VNW sg13_lv_pmos m=1 w=480.00n l=130.00n ng=1
MP9 ED0B RB VDD VNW sg13_lv_pmos m=1 w=480.00n l=130.00n ng=1
MP8 ED0B CKNEG net6 VNW sg13_lv_pmos m=1 w=480.00n l=130.00n ng=1
MP7 net6 net9 VDD VNW sg13_lv_pmos m=1 w=480.00n l=130.00n ng=1
MP5 CKPOS CKNEG VDD VNW sg13_lv_pmos m=1 w=980.00n l=130.00n ng=1
MP4 CKNEG CK VDD VNW sg13_lv_pmos m=1 w=480.00n l=130.00n ng=1
MP1 net12 CKPOS VDD VNW sg13_lv_pmos m=1 w=480.00n l=130.00n ng=1
MP18 ED0B D0 net12 VNW sg13_lv_pmos m=1 w=480.00n l=130.00n ng=1
MN32 net41 CKPOS net4 VPW sg13_lv_nmos m=1 w=300.0n l=130.00n ng=1
MN31 Q1 net36 VSS VPW sg13_lv_nmos m=1 w=640.00n l=130.00n ng=1
MN30 net36 RB net43 VPW sg13_lv_nmos m=1 w=300.0n l=130.00n ng=1
MN29 net41 ED1B VSS VPW sg13_lv_nmos m=1 w=300.0n l=130.00n ng=1
MN26 ED1B CKNEG net44 VPW sg13_lv_nmos m=1 w=300.0n l=130.00n ng=1
MN25 net4 CKNEG net11 VPW sg13_lv_nmos m=1 w=300.0n l=130.00n ng=1
MN24 ED1B CKPOS net52 VPW sg13_lv_nmos m=1 w=300.0n l=130.00n ng=1
MN23 net44 D1 net49 VPW sg13_lv_nmos m=1 w=300.0n l=130.00n ng=1
MN22 net11 net36 VSS VPW sg13_lv_nmos m=1 w=300.0n l=130.00n ng=1
MN21 net52 net41 net42 VPW sg13_lv_nmos m=1 w=300.0n l=130.00n ng=1
MN17 net20 RB VSS VPW sg13_lv_nmos m=1 w=300.0n l=130.00n ng=1
MN18 net42 RB VSS VPW sg13_lv_nmos m=1 w=300.0n l=130.00n ng=1
MN15 Q0 net2 VSS VPW sg13_lv_nmos m=1 w=640.00n l=130.00n ng=1
MN13 net5 net3 VSS VPW sg13_lv_nmos m=1 w=300.0n l=130.00n ng=1
MN12 net2 RB net5 VPW sg13_lv_nmos m=1 w=300.0n l=130.00n ng=1
MN10 net1 net2 VSS VPW sg13_lv_nmos m=1 w=300.0n l=130.00n ng=1
MN9 net3 CKNEG net1 VPW sg13_lv_nmos m=1 w=300.0n l=130.00n ng=1
MN8 net9 CKPOS net3 VPW sg13_lv_nmos m=1 w=300.0n l=130.00n ng=1
MN7 net9 ED0B VSS VPW sg13_lv_nmos m=1 w=300.0n l=130.00n ng=1
MN6 net7 RB VSS VPW sg13_lv_nmos m=1 w=300.0n l=130.00n ng=1
MN5 net8 net9 net7 VPW sg13_lv_nmos m=1 w=300.0n l=130.00n ng=1
MN4 ED0B CKPOS net8 VPW sg13_lv_nmos m=1 w=300.0n l=130.00n ng=1
MN19 net49 RB VSS VPW sg13_lv_nmos m=1 w=300.0n l=130.00n ng=1
MN20 net43 net4 VSS VPW sg13_lv_nmos m=1 w=300.0n l=130.00n ng=1
MN2 CKPOS CKNEG VSS VPW sg13_lv_nmos m=1 w=640.00n l=130.00n ng=1
MN1 CKNEG CK VSS VPW sg13_lv_nmos m=1 w=300.0n l=130.00n ng=1
MN16 ED0B CKNEG net21 VPW sg13_lv_nmos m=1 w=300.0n l=130.00n ng=1
MP2 net21 D0 net20 VPW sg13_lv_nmos m=1 w=300.0n l=130.00n ng=1
.ENDS

************************************************************************
* Library Name: ez130_8t
* Cell Name:    DFFRQ2X3
* View Name:    schematic
************************************************************************

.SUBCKT DFFRQ2X3 CK D0 D1 Q0 Q1 RB VDD VNW VPW VSS
*.PININFO CK:I D0:I D1:I RB:I Q0:O Q1:O VDD:B VNW:B VPW:B VSS:B
MP32 net37 CKPOS VDD VNW sg13_lv_pmos m=1 w=480.00n l=130.00n ng=1
MP31 net50 net36 VDD VNW sg13_lv_pmos m=1 w=480.00n l=130.00n ng=1
MP30 net51 net41 VDD VNW sg13_lv_pmos m=1 w=480.00n l=130.00n ng=1
MP29 net41 CKNEG net4 VNW sg13_lv_pmos m=1 w=480.00n l=130.00n ng=1
MP28 Q1 net36 VDD VNW sg13_lv_pmos m=1 w=1.32u l=130.00n ng=1
MP27 net36 net4 VDD VNW sg13_lv_pmos m=1 w=480.00n l=130.00n ng=1
MP26 net36 RB VDD VNW sg13_lv_pmos m=1 w=480.00n l=130.00n ng=1
MP25 net41 ED1B VDD VNW sg13_lv_pmos m=1 w=480.00n l=130.00n ng=1
MP24 ED1B RB VDD VNW sg13_lv_pmos m=1 w=480.00n l=130.00n ng=1
MP21 ED1B D1 net37 VNW sg13_lv_pmos m=1 w=480.00n l=130.00n ng=1
MP20 net4 CKPOS net50 VNW sg13_lv_pmos m=1 w=480.00n l=130.00n ng=1
MP19 ED1B CKNEG net51 VNW sg13_lv_pmos m=1 w=480.00n l=130.00n ng=1
MP17 Q0 net2 VDD VNW sg13_lv_pmos m=1 w=1.32u l=130.00n ng=1
MP15 net2 net3 VDD VNW sg13_lv_pmos m=1 w=480.00n l=130.00n ng=1
MP14 net2 RB VDD VNW sg13_lv_pmos m=1 w=480.00n l=130.00n ng=1
MP13 net3 CKPOS net10 VNW sg13_lv_pmos m=1 w=480.00n l=130.00n ng=1
MP12 net10 net2 VDD VNW sg13_lv_pmos m=1 w=480.00n l=130.00n ng=1
MP11 net9 CKNEG net3 VNW sg13_lv_pmos m=1 w=480.00n l=130.00n ng=1
MP10 net9 ED0B VDD VNW sg13_lv_pmos m=1 w=480.00n l=130.00n ng=1
MP9 ED0B RB VDD VNW sg13_lv_pmos m=1 w=480.00n l=130.00n ng=1
MP8 ED0B CKNEG net6 VNW sg13_lv_pmos m=1 w=480.00n l=130.00n ng=1
MP7 net6 net9 VDD VNW sg13_lv_pmos m=1 w=480.00n l=130.00n ng=1
MP5 CKPOS CKNEG VDD VNW sg13_lv_pmos m=1 w=980.00n l=130.00n ng=1
MP4 CKNEG CK VDD VNW sg13_lv_pmos m=1 w=480.00n l=130.00n ng=1
MP1 net12 CKPOS VDD VNW sg13_lv_pmos m=1 w=480.00n l=130.00n ng=1
MP18 ED0B D0 net12 VNW sg13_lv_pmos m=1 w=480.00n l=130.00n ng=1
MN32 net41 CKPOS net4 VPW sg13_lv_nmos m=1 w=300.0n l=130.00n ng=1
MN31 Q1 net36 VSS VPW sg13_lv_nmos m=1 w=860.00n l=130.00n ng=1
MN30 net36 RB net43 VPW sg13_lv_nmos m=1 w=300.0n l=130.00n ng=1
MN29 net41 ED1B VSS VPW sg13_lv_nmos m=1 w=300.0n l=130.00n ng=1
MN26 ED1B CKNEG net44 VPW sg13_lv_nmos m=1 w=300.0n l=130.00n ng=1
MN25 net4 CKNEG net11 VPW sg13_lv_nmos m=1 w=300.0n l=130.00n ng=1
MN24 ED1B CKPOS net52 VPW sg13_lv_nmos m=1 w=300.0n l=130.00n ng=1
MN23 net44 D1 net49 VPW sg13_lv_nmos m=1 w=300.0n l=130.00n ng=1
MN22 net11 net36 VSS VPW sg13_lv_nmos m=1 w=300.0n l=130.00n ng=1
MN21 net52 net41 net42 VPW sg13_lv_nmos m=1 w=300.0n l=130.00n ng=1
MN17 net20 RB VSS VPW sg13_lv_nmos m=1 w=300.0n l=130.00n ng=1
MN18 net42 RB VSS VPW sg13_lv_nmos m=1 w=300.0n l=130.00n ng=1
MN15 Q0 net2 VSS VPW sg13_lv_nmos m=1 w=860.00n l=130.00n ng=1
MN13 net5 net3 VSS VPW sg13_lv_nmos m=1 w=300.0n l=130.00n ng=1
MN12 net2 RB net5 VPW sg13_lv_nmos m=1 w=300.0n l=130.00n ng=1
MN10 net1 net2 VSS VPW sg13_lv_nmos m=1 w=300.0n l=130.00n ng=1
MN9 net3 CKNEG net1 VPW sg13_lv_nmos m=1 w=300.0n l=130.00n ng=1
MN8 net9 CKPOS net3 VPW sg13_lv_nmos m=1 w=300.0n l=130.00n ng=1
MN7 net9 ED0B VSS VPW sg13_lv_nmos m=1 w=300.0n l=130.00n ng=1
MN6 net7 RB VSS VPW sg13_lv_nmos m=1 w=300.0n l=130.00n ng=1
MN5 net8 net9 net7 VPW sg13_lv_nmos m=1 w=300.0n l=130.00n ng=1
MN4 ED0B CKPOS net8 VPW sg13_lv_nmos m=1 w=300.0n l=130.00n ng=1
MN19 net49 RB VSS VPW sg13_lv_nmos m=1 w=300.0n l=130.00n ng=1
MN20 net43 net4 VSS VPW sg13_lv_nmos m=1 w=300.0n l=130.00n ng=1
MN2 CKPOS CKNEG VSS VPW sg13_lv_nmos m=1 w=640.00n l=130.00n ng=1
MN1 CKNEG CK VSS VPW sg13_lv_nmos m=1 w=300.0n l=130.00n ng=1
MN16 ED0B CKNEG net21 VPW sg13_lv_nmos m=1 w=300.0n l=130.00n ng=1
MP2 net21 D0 net20 VPW sg13_lv_nmos m=1 w=300.0n l=130.00n ng=1
.ENDS

************************************************************************
* Library Name: ez130_8t
* Cell Name:    DFFRQ4X1
* View Name:    schematic
************************************************************************

.SUBCKT DFFRQ4X1 CK D0 D1 D2 D3 Q0 Q1 Q2 Q3 RB VDD VNW VPW VSS
*.PININFO CK:I D0:I D1:I D2:I D3:I RB:I Q0:O Q1:O Q2:O Q3:O VDD:B VNW:B VPW:B
*.PININFO VSS:B
MP57 CKNEG CK VDD VNW sg13_lv_pmos m=1 w=720.00n l=130.00n ng=1
MP56 net23 CKPOS VDD VNW sg13_lv_pmos m=1 w=480.00n l=130.00n ng=1
MP55 net17 net13 VDD VNW sg13_lv_pmos m=1 w=480.00n l=130.00n ng=1
MP54 net25 net14 VDD VNW sg13_lv_pmos m=1 w=480.00n l=130.00n ng=1
MP53 net14 CKNEG net15 VNW sg13_lv_pmos m=1 w=480.00n l=130.00n ng=1
MP52 Q3 net13 VDD VNW sg13_lv_pmos m=1 w=480.00n l=130.00n ng=1
MP51 net13 net15 VDD VNW sg13_lv_pmos m=1 w=480.00n l=130.00n ng=1
MP50 net13 RB VDD VNW sg13_lv_pmos m=1 w=480.00n l=130.00n ng=1
MP49 net14 ED3B VDD VNW sg13_lv_pmos m=1 w=480.00n l=130.00n ng=1
MP48 ED3B RB VDD VNW sg13_lv_pmos m=1 w=480.00n l=130.00n ng=1
MP47 ED3B D3 net23 VNW sg13_lv_pmos m=1 w=480.00n l=130.00n ng=1
MP46 net15 CKPOS net17 VNW sg13_lv_pmos m=1 w=480.00n l=130.00n ng=1
MP45 ED3B CKNEG net25 VNW sg13_lv_pmos m=1 w=480.00n l=130.00n ng=1
MP44 net27 CKPOS VDD VNW sg13_lv_pmos m=1 w=480.00n l=130.00n ng=1
MP43 net32 net29 VDD VNW sg13_lv_pmos m=1 w=480.00n l=130.00n ng=1
MP42 net40 net28 VDD VNW sg13_lv_pmos m=1 w=480.00n l=130.00n ng=1
MP41 net28 CKNEG net30 VNW sg13_lv_pmos m=1 w=480.00n l=130.00n ng=1
MP40 Q2 net29 VDD VNW sg13_lv_pmos m=1 w=480.00n l=130.00n ng=1
MP39 net29 net30 VDD VNW sg13_lv_pmos m=1 w=480.00n l=130.00n ng=1
MP38 net29 RB VDD VNW sg13_lv_pmos m=1 w=480.00n l=130.00n ng=1
MP37 net28 ED2B VDD VNW sg13_lv_pmos m=1 w=480.00n l=130.00n ng=1
MP36 ED2B RB VDD VNW sg13_lv_pmos m=1 w=480.00n l=130.00n ng=1
MP35 ED2B D2 net27 VNW sg13_lv_pmos m=1 w=480.00n l=130.00n ng=1
MP34 net30 CKPOS net32 VNW sg13_lv_pmos m=1 w=480.00n l=130.00n ng=1
MP33 ED2B CKNEG net40 VNW sg13_lv_pmos m=1 w=480.00n l=130.00n ng=1
MP32 net37 CKPOS VDD VNW sg13_lv_pmos m=1 w=480.00n l=130.00n ng=1
MP31 net50 net36 VDD VNW sg13_lv_pmos m=1 w=480.00n l=130.00n ng=1
MP30 net51 net41 VDD VNW sg13_lv_pmos m=1 w=480.00n l=130.00n ng=1
MP29 net41 CKNEG net4 VNW sg13_lv_pmos m=1 w=480.00n l=130.00n ng=1
MP28 Q1 net36 VDD VNW sg13_lv_pmos m=1 w=480.00n l=130.00n ng=1
MP27 net36 net4 VDD VNW sg13_lv_pmos m=1 w=480.00n l=130.00n ng=1
MP26 net36 RB VDD VNW sg13_lv_pmos m=1 w=480.00n l=130.00n ng=1
MP25 net41 ED1B VDD VNW sg13_lv_pmos m=1 w=480.00n l=130.00n ng=1
MP24 ED1B RB VDD VNW sg13_lv_pmos m=1 w=480.00n l=130.00n ng=1
MP21 ED1B D1 net37 VNW sg13_lv_pmos m=1 w=480.00n l=130.00n ng=1
MP20 net4 CKPOS net50 VNW sg13_lv_pmos m=1 w=480.00n l=130.00n ng=1
MP19 ED1B CKNEG net51 VNW sg13_lv_pmos m=1 w=480.00n l=130.00n ng=1
MP17 Q0 net2 VDD VNW sg13_lv_pmos m=1 w=480.00n l=130.00n ng=1
MP15 net2 net3 VDD VNW sg13_lv_pmos m=1 w=480.00n l=130.00n ng=1
MP14 net2 RB VDD VNW sg13_lv_pmos m=1 w=480.00n l=130.00n ng=1
MP13 net3 CKPOS net10 VNW sg13_lv_pmos m=1 w=480.00n l=130.00n ng=1
MP12 net10 net2 VDD VNW sg13_lv_pmos m=1 w=480.00n l=130.00n ng=1
MP11 net9 CKNEG net3 VNW sg13_lv_pmos m=1 w=480.00n l=130.00n ng=1
MP10 net9 ED0B VDD VNW sg13_lv_pmos m=1 w=480.00n l=130.00n ng=1
MP9 ED0B RB VDD VNW sg13_lv_pmos m=1 w=480.00n l=130.00n ng=1
MP8 ED0B CKNEG net6 VNW sg13_lv_pmos m=1 w=480.00n l=130.00n ng=1
MP7 net6 net9 VDD VNW sg13_lv_pmos m=1 w=480.00n l=130.00n ng=1
MP5 CKPOS CKNEG VDD VNW sg13_lv_pmos m=1 w=980.00n l=130.00n ng=1
MP1 net12 CKPOS VDD VNW sg13_lv_pmos m=1 w=480.00n l=130.00n ng=1
MP18 ED0B D0 net12 VNW sg13_lv_pmos m=1 w=480.00n l=130.00n ng=1
MN59 CKNEG CK VSS VPW sg13_lv_nmos m=1 w=480.00n l=130.00n ng=1
MN58 net14 CKPOS net15 VPW sg13_lv_nmos m=1 w=300.0n l=130.00n ng=1
MN57 Q3 net13 VSS VPW sg13_lv_nmos m=1 w=300.0n l=130.00n ng=1
MN56 net13 RB net18 VPW sg13_lv_nmos m=1 w=300.0n l=130.00n ng=1
MN55 net14 ED3B VSS VPW sg13_lv_nmos m=1 w=300.0n l=130.00n ng=1
MN54 ED3B CKNEG net22 VPW sg13_lv_nmos m=1 w=300.0n l=130.00n ng=1
MN53 net15 CKNEG net16 VPW sg13_lv_nmos m=1 w=300.0n l=130.00n ng=1
MN52 ED3B CKPOS net26 VPW sg13_lv_nmos m=1 w=300.0n l=130.00n ng=1
MN51 net22 D3 net19 VPW sg13_lv_nmos m=1 w=300.0n l=130.00n ng=1
MN50 net16 net13 VSS VPW sg13_lv_nmos m=1 w=300.0n l=130.00n ng=1
MN49 net26 net14 net24 VPW sg13_lv_nmos m=1 w=300.0n l=130.00n ng=1
MN48 net18 net15 VSS VPW sg13_lv_nmos m=1 w=300.0n l=130.00n ng=1
MN47 net24 RB VSS VPW sg13_lv_nmos m=1 w=300.0n l=130.00n ng=1
MN46 net19 RB VSS VPW sg13_lv_nmos m=1 w=300.0n l=130.00n ng=1
MN45 net28 CKPOS net30 VPW sg13_lv_nmos m=1 w=300.0n l=130.00n ng=1
MN44 Q2 net29 VSS VPW sg13_lv_nmos m=1 w=300.0n l=130.00n ng=1
MN43 net29 RB net33 VPW sg13_lv_nmos m=1 w=300.0n l=130.00n ng=1
MN42 net28 ED2B VSS VPW sg13_lv_nmos m=1 w=300.0n l=130.00n ng=1
MN41 ED2B CKNEG net38 VPW sg13_lv_nmos m=1 w=300.0n l=130.00n ng=1
MN33 net35 RB VSS VPW sg13_lv_nmos m=1 w=300.0n l=130.00n ng=1
MN34 net39 RB VSS VPW sg13_lv_nmos m=1 w=300.0n l=130.00n ng=1
MN35 net33 net30 VSS VPW sg13_lv_nmos m=1 w=300.0n l=130.00n ng=1
MN32 net41 CKPOS net4 VPW sg13_lv_nmos m=1 w=300.0n l=130.00n ng=1
MN31 Q1 net36 VSS VPW sg13_lv_nmos m=1 w=300.0n l=130.00n ng=1
MN30 net36 RB net43 VPW sg13_lv_nmos m=1 w=300.0n l=130.00n ng=1
MN29 net41 ED1B VSS VPW sg13_lv_nmos m=1 w=300.0n l=130.00n ng=1
MN36 net34 net28 net39 VPW sg13_lv_nmos m=1 w=300.0n l=130.00n ng=1
MN37 net31 net29 VSS VPW sg13_lv_nmos m=1 w=300.0n l=130.00n ng=1
MN26 ED1B CKNEG net44 VPW sg13_lv_nmos m=1 w=300.0n l=130.00n ng=1
MN25 net4 CKNEG net11 VPW sg13_lv_nmos m=1 w=300.0n l=130.00n ng=1
MN24 ED1B CKPOS net52 VPW sg13_lv_nmos m=1 w=300.0n l=130.00n ng=1
MN38 net38 D2 net35 VPW sg13_lv_nmos m=1 w=300.0n l=130.00n ng=1
MN23 net44 D1 net49 VPW sg13_lv_nmos m=1 w=300.0n l=130.00n ng=1
MN22 net11 net36 VSS VPW sg13_lv_nmos m=1 w=300.0n l=130.00n ng=1
MN21 net52 net41 net42 VPW sg13_lv_nmos m=1 w=300.0n l=130.00n ng=1
MN17 net20 RB VSS VPW sg13_lv_nmos m=1 w=300.0n l=130.00n ng=1
MN18 net42 RB VSS VPW sg13_lv_nmos m=1 w=300.0n l=130.00n ng=1
MN15 Q0 net2 VSS VPW sg13_lv_nmos m=1 w=300.0n l=130.00n ng=1
MN39 ED2B CKPOS net34 VPW sg13_lv_nmos m=1 w=300.0n l=130.00n ng=1
MN13 net5 net3 VSS VPW sg13_lv_nmos m=1 w=300.0n l=130.00n ng=1
MN12 net2 RB net5 VPW sg13_lv_nmos m=1 w=300.0n l=130.00n ng=1
MN40 net30 CKNEG net31 VPW sg13_lv_nmos m=1 w=300.0n l=130.00n ng=1
MN10 net1 net2 VSS VPW sg13_lv_nmos m=1 w=300.0n l=130.00n ng=1
MN9 net3 CKNEG net1 VPW sg13_lv_nmos m=1 w=300.0n l=130.00n ng=1
MN8 net9 CKPOS net3 VPW sg13_lv_nmos m=1 w=300.0n l=130.00n ng=1
MN7 net9 ED0B VSS VPW sg13_lv_nmos m=1 w=300.0n l=130.00n ng=1
MN6 net7 RB VSS VPW sg13_lv_nmos m=1 w=300.0n l=130.00n ng=1
MN5 net8 net9 net7 VPW sg13_lv_nmos m=1 w=300.0n l=130.00n ng=1
MN4 ED0B CKPOS net8 VPW sg13_lv_nmos m=1 w=300.0n l=130.00n ng=1
MN19 net49 RB VSS VPW sg13_lv_nmos m=1 w=300.0n l=130.00n ng=1
MN20 net43 net4 VSS VPW sg13_lv_nmos m=1 w=300.0n l=130.00n ng=1
MN2 CKPOS CKNEG VSS VPW sg13_lv_nmos m=1 w=640.00n l=130.00n ng=1
MN16 ED0B CKNEG net21 VPW sg13_lv_nmos m=1 w=300.0n l=130.00n ng=1
MP2 net21 D0 net20 VPW sg13_lv_nmos m=1 w=300.0n l=130.00n ng=1
.ENDS

************************************************************************
* Library Name: ez130_8t
* Cell Name:    DFFRQ4X1P5
* View Name:    schematic
************************************************************************

.SUBCKT DFFRQ4X1P5 CK D0 D1 D2 D3 Q0 Q1 Q2 Q3 RB VDD VNW VPW VSS
*.PININFO CK:I D0:I D1:I D2:I D3:I RB:I Q0:O Q1:O Q2:O Q3:O VDD:B VNW:B VPW:B
*.PININFO VSS:B
MP57 CKNEG CK VDD VNW sg13_lv_pmos m=1 w=720.00n l=130.00n ng=1
MP56 net23 CKPOS VDD VNW sg13_lv_pmos m=1 w=480.00n l=130.00n ng=1
MP55 net17 net13 VDD VNW sg13_lv_pmos m=1 w=480.00n l=130.00n ng=1
MP54 net25 net14 VDD VNW sg13_lv_pmos m=1 w=480.00n l=130.00n ng=1
MP53 net14 CKNEG net15 VNW sg13_lv_pmos m=1 w=480.00n l=130.00n ng=1
MP52 Q3 net13 VDD VNW sg13_lv_pmos m=1 w=720.00n l=130.00n ng=1
MP51 net13 net15 VDD VNW sg13_lv_pmos m=1 w=480.00n l=130.00n ng=1
MP50 net13 RB VDD VNW sg13_lv_pmos m=1 w=480.00n l=130.00n ng=1
MP49 net14 ED3B VDD VNW sg13_lv_pmos m=1 w=480.00n l=130.00n ng=1
MP48 ED3B RB VDD VNW sg13_lv_pmos m=1 w=480.00n l=130.00n ng=1
MP47 ED3B D3 net23 VNW sg13_lv_pmos m=1 w=480.00n l=130.00n ng=1
MP46 net15 CKPOS net17 VNW sg13_lv_pmos m=1 w=480.00n l=130.00n ng=1
MP45 ED3B CKNEG net25 VNW sg13_lv_pmos m=1 w=480.00n l=130.00n ng=1
MP44 net27 CKPOS VDD VNW sg13_lv_pmos m=1 w=480.00n l=130.00n ng=1
MP43 net32 net29 VDD VNW sg13_lv_pmos m=1 w=480.00n l=130.00n ng=1
MP42 net40 net28 VDD VNW sg13_lv_pmos m=1 w=480.00n l=130.00n ng=1
MP41 net28 CKNEG net30 VNW sg13_lv_pmos m=1 w=480.00n l=130.00n ng=1
MP40 Q2 net29 VDD VNW sg13_lv_pmos m=1 w=720.00n l=130.00n ng=1
MP39 net29 net30 VDD VNW sg13_lv_pmos m=1 w=480.00n l=130.00n ng=1
MP38 net29 RB VDD VNW sg13_lv_pmos m=1 w=480.00n l=130.00n ng=1
MP37 net28 ED2B VDD VNW sg13_lv_pmos m=1 w=480.00n l=130.00n ng=1
MP36 ED2B RB VDD VNW sg13_lv_pmos m=1 w=480.00n l=130.00n ng=1
MP35 ED2B D2 net27 VNW sg13_lv_pmos m=1 w=480.00n l=130.00n ng=1
MP34 net30 CKPOS net32 VNW sg13_lv_pmos m=1 w=480.00n l=130.00n ng=1
MP33 ED2B CKNEG net40 VNW sg13_lv_pmos m=1 w=480.00n l=130.00n ng=1
MP32 net37 CKPOS VDD VNW sg13_lv_pmos m=1 w=480.00n l=130.00n ng=1
MP31 net50 net36 VDD VNW sg13_lv_pmos m=1 w=480.00n l=130.00n ng=1
MP30 net51 net41 VDD VNW sg13_lv_pmos m=1 w=480.00n l=130.00n ng=1
MP29 net41 CKNEG net4 VNW sg13_lv_pmos m=1 w=480.00n l=130.00n ng=1
MP28 Q1 net36 VDD VNW sg13_lv_pmos m=1 w=720.00n l=130.00n ng=1
MP27 net36 net4 VDD VNW sg13_lv_pmos m=1 w=480.00n l=130.00n ng=1
MP26 net36 RB VDD VNW sg13_lv_pmos m=1 w=480.00n l=130.00n ng=1
MP25 net41 ED1B VDD VNW sg13_lv_pmos m=1 w=480.00n l=130.00n ng=1
MP24 ED1B RB VDD VNW sg13_lv_pmos m=1 w=480.00n l=130.00n ng=1
MP21 ED1B D1 net37 VNW sg13_lv_pmos m=1 w=480.00n l=130.00n ng=1
MP20 net4 CKPOS net50 VNW sg13_lv_pmos m=1 w=480.00n l=130.00n ng=1
MP19 ED1B CKNEG net51 VNW sg13_lv_pmos m=1 w=480.00n l=130.00n ng=1
MP17 Q0 net2 VDD VNW sg13_lv_pmos m=1 w=720.00n l=130.00n ng=1
MP15 net2 net3 VDD VNW sg13_lv_pmos m=1 w=480.00n l=130.00n ng=1
MP14 net2 RB VDD VNW sg13_lv_pmos m=1 w=480.00n l=130.00n ng=1
MP13 net3 CKPOS net10 VNW sg13_lv_pmos m=1 w=480.00n l=130.00n ng=1
MP12 net10 net2 VDD VNW sg13_lv_pmos m=1 w=480.00n l=130.00n ng=1
MP11 net9 CKNEG net3 VNW sg13_lv_pmos m=1 w=480.00n l=130.00n ng=1
MP10 net9 ED0B VDD VNW sg13_lv_pmos m=1 w=480.00n l=130.00n ng=1
MP9 ED0B RB VDD VNW sg13_lv_pmos m=1 w=480.00n l=130.00n ng=1
MP8 ED0B CKNEG net6 VNW sg13_lv_pmos m=1 w=480.00n l=130.00n ng=1
MP7 net6 net9 VDD VNW sg13_lv_pmos m=1 w=480.00n l=130.00n ng=1
MP5 CKPOS CKNEG VDD VNW sg13_lv_pmos m=1 w=980.00n l=130.00n ng=1
MP1 net12 CKPOS VDD VNW sg13_lv_pmos m=1 w=480.00n l=130.00n ng=1
MP18 ED0B D0 net12 VNW sg13_lv_pmos m=1 w=480.00n l=130.00n ng=1
MN59 CKNEG CK VSS VPW sg13_lv_nmos m=1 w=480.00n l=130.00n ng=1
MN58 net14 CKPOS net15 VPW sg13_lv_nmos m=1 w=300.0n l=130.00n ng=1
MN57 Q3 net13 VSS VPW sg13_lv_nmos m=1 w=480.00n l=130.00n ng=1
MN56 net13 RB net18 VPW sg13_lv_nmos m=1 w=300.0n l=130.00n ng=1
MN55 net14 ED3B VSS VPW sg13_lv_nmos m=1 w=300.0n l=130.00n ng=1
MN54 ED3B CKNEG net22 VPW sg13_lv_nmos m=1 w=300.0n l=130.00n ng=1
MN53 net15 CKNEG net16 VPW sg13_lv_nmos m=1 w=300.0n l=130.00n ng=1
MN52 ED3B CKPOS net26 VPW sg13_lv_nmos m=1 w=300.0n l=130.00n ng=1
MN51 net22 D3 net19 VPW sg13_lv_nmos m=1 w=300.0n l=130.00n ng=1
MN50 net16 net13 VSS VPW sg13_lv_nmos m=1 w=300.0n l=130.00n ng=1
MN49 net26 net14 net24 VPW sg13_lv_nmos m=1 w=300.0n l=130.00n ng=1
MN48 net18 net15 VSS VPW sg13_lv_nmos m=1 w=300.0n l=130.00n ng=1
MN47 net24 RB VSS VPW sg13_lv_nmos m=1 w=300.0n l=130.00n ng=1
MN46 net19 RB VSS VPW sg13_lv_nmos m=1 w=300.0n l=130.00n ng=1
MN45 net28 CKPOS net30 VPW sg13_lv_nmos m=1 w=300.0n l=130.00n ng=1
MN44 Q2 net29 VSS VPW sg13_lv_nmos m=1 w=480.00n l=130.00n ng=1
MN43 net29 RB net33 VPW sg13_lv_nmos m=1 w=300.0n l=130.00n ng=1
MN42 net28 ED2B VSS VPW sg13_lv_nmos m=1 w=300.0n l=130.00n ng=1
MN41 ED2B CKNEG net38 VPW sg13_lv_nmos m=1 w=300.0n l=130.00n ng=1
MN33 net35 RB VSS VPW sg13_lv_nmos m=1 w=300.0n l=130.00n ng=1
MN34 net39 RB VSS VPW sg13_lv_nmos m=1 w=300.0n l=130.00n ng=1
MN35 net33 net30 VSS VPW sg13_lv_nmos m=1 w=300.0n l=130.00n ng=1
MN32 net41 CKPOS net4 VPW sg13_lv_nmos m=1 w=300.0n l=130.00n ng=1
MN31 Q1 net36 VSS VPW sg13_lv_nmos m=1 w=480.00n l=130.00n ng=1
MN30 net36 RB net43 VPW sg13_lv_nmos m=1 w=300.0n l=130.00n ng=1
MN29 net41 ED1B VSS VPW sg13_lv_nmos m=1 w=300.0n l=130.00n ng=1
MN36 net34 net28 net39 VPW sg13_lv_nmos m=1 w=300.0n l=130.00n ng=1
MN37 net31 net29 VSS VPW sg13_lv_nmos m=1 w=300.0n l=130.00n ng=1
MN26 ED1B CKNEG net44 VPW sg13_lv_nmos m=1 w=300.0n l=130.00n ng=1
MN25 net4 CKNEG net11 VPW sg13_lv_nmos m=1 w=300.0n l=130.00n ng=1
MN24 ED1B CKPOS net52 VPW sg13_lv_nmos m=1 w=300.0n l=130.00n ng=1
MN38 net38 D2 net35 VPW sg13_lv_nmos m=1 w=300.0n l=130.00n ng=1
MN23 net44 D1 net49 VPW sg13_lv_nmos m=1 w=300.0n l=130.00n ng=1
MN22 net11 net36 VSS VPW sg13_lv_nmos m=1 w=300.0n l=130.00n ng=1
MN21 net52 net41 net42 VPW sg13_lv_nmos m=1 w=300.0n l=130.00n ng=1
MN17 net20 RB VSS VPW sg13_lv_nmos m=1 w=300.0n l=130.00n ng=1
MN18 net42 RB VSS VPW sg13_lv_nmos m=1 w=300.0n l=130.00n ng=1
MN15 Q0 net2 VSS VPW sg13_lv_nmos m=1 w=480.00n l=130.00n ng=1
MN39 ED2B CKPOS net34 VPW sg13_lv_nmos m=1 w=300.0n l=130.00n ng=1
MN13 net5 net3 VSS VPW sg13_lv_nmos m=1 w=300.0n l=130.00n ng=1
MN12 net2 RB net5 VPW sg13_lv_nmos m=1 w=300.0n l=130.00n ng=1
MN40 net30 CKNEG net31 VPW sg13_lv_nmos m=1 w=300.0n l=130.00n ng=1
MN10 net1 net2 VSS VPW sg13_lv_nmos m=1 w=300.0n l=130.00n ng=1
MN9 net3 CKNEG net1 VPW sg13_lv_nmos m=1 w=300.0n l=130.00n ng=1
MN8 net9 CKPOS net3 VPW sg13_lv_nmos m=1 w=300.0n l=130.00n ng=1
MN7 net9 ED0B VSS VPW sg13_lv_nmos m=1 w=300.0n l=130.00n ng=1
MN6 net7 RB VSS VPW sg13_lv_nmos m=1 w=300.0n l=130.00n ng=1
MN5 net8 net9 net7 VPW sg13_lv_nmos m=1 w=300.0n l=130.00n ng=1
MN4 ED0B CKPOS net8 VPW sg13_lv_nmos m=1 w=300.0n l=130.00n ng=1
MN19 net49 RB VSS VPW sg13_lv_nmos m=1 w=300.0n l=130.00n ng=1
MN20 net43 net4 VSS VPW sg13_lv_nmos m=1 w=300.0n l=130.00n ng=1
MN2 CKPOS CKNEG VSS VPW sg13_lv_nmos m=1 w=640.00n l=130.00n ng=1
MN16 ED0B CKNEG net21 VPW sg13_lv_nmos m=1 w=300.0n l=130.00n ng=1
MP2 net21 D0 net20 VPW sg13_lv_nmos m=1 w=300.0n l=130.00n ng=1
.ENDS

************************************************************************
* Library Name: ez130_8t
* Cell Name:    DFFRQ4X2
* View Name:    schematic
************************************************************************

.SUBCKT DFFRQ4X2 CK D0 D1 D2 D3 Q0 Q1 Q2 Q3 RB VDD VNW VPW VSS
*.PININFO CK:I D0:I D1:I D2:I D3:I RB:I Q0:O Q1:O Q2:O Q3:O VDD:B VNW:B VPW:B
*.PININFO VSS:B
MP57 CKNEG CK VDD VNW sg13_lv_pmos m=1 w=720.00n l=130.00n ng=1
MP56 net23 CKPOS VDD VNW sg13_lv_pmos m=1 w=480.00n l=130.00n ng=1
MP55 net17 net13 VDD VNW sg13_lv_pmos m=1 w=480.00n l=130.00n ng=1
MP54 net25 net14 VDD VNW sg13_lv_pmos m=1 w=480.00n l=130.00n ng=1
MP53 net14 CKNEG net15 VNW sg13_lv_pmos m=1 w=480.00n l=130.00n ng=1
MP52 Q3 net13 VDD VNW sg13_lv_pmos m=1 w=980.00n l=130.00n ng=1
MP51 net13 net15 VDD VNW sg13_lv_pmos m=1 w=480.00n l=130.00n ng=1
MP50 net13 RB VDD VNW sg13_lv_pmos m=1 w=480.00n l=130.00n ng=1
MP49 net14 ED3B VDD VNW sg13_lv_pmos m=1 w=480.00n l=130.00n ng=1
MP48 ED3B RB VDD VNW sg13_lv_pmos m=1 w=480.00n l=130.00n ng=1
MP47 ED3B D3 net23 VNW sg13_lv_pmos m=1 w=480.00n l=130.00n ng=1
MP46 net15 CKPOS net17 VNW sg13_lv_pmos m=1 w=480.00n l=130.00n ng=1
MP45 ED3B CKNEG net25 VNW sg13_lv_pmos m=1 w=480.00n l=130.00n ng=1
MP44 net27 CKPOS VDD VNW sg13_lv_pmos m=1 w=480.00n l=130.00n ng=1
MP43 net32 net29 VDD VNW sg13_lv_pmos m=1 w=480.00n l=130.00n ng=1
MP42 net40 net28 VDD VNW sg13_lv_pmos m=1 w=480.00n l=130.00n ng=1
MP41 net28 CKNEG net30 VNW sg13_lv_pmos m=1 w=480.00n l=130.00n ng=1
MP40 Q2 net29 VDD VNW sg13_lv_pmos m=1 w=980.00n l=130.00n ng=1
MP39 net29 net30 VDD VNW sg13_lv_pmos m=1 w=480.00n l=130.00n ng=1
MP38 net29 RB VDD VNW sg13_lv_pmos m=1 w=480.00n l=130.00n ng=1
MP37 net28 ED2B VDD VNW sg13_lv_pmos m=1 w=480.00n l=130.00n ng=1
MP36 ED2B RB VDD VNW sg13_lv_pmos m=1 w=480.00n l=130.00n ng=1
MP35 ED2B D2 net27 VNW sg13_lv_pmos m=1 w=480.00n l=130.00n ng=1
MP34 net30 CKPOS net32 VNW sg13_lv_pmos m=1 w=480.00n l=130.00n ng=1
MP33 ED2B CKNEG net40 VNW sg13_lv_pmos m=1 w=480.00n l=130.00n ng=1
MP32 net37 CKPOS VDD VNW sg13_lv_pmos m=1 w=480.00n l=130.00n ng=1
MP31 net50 net36 VDD VNW sg13_lv_pmos m=1 w=480.00n l=130.00n ng=1
MP30 net51 net41 VDD VNW sg13_lv_pmos m=1 w=480.00n l=130.00n ng=1
MP29 net41 CKNEG net4 VNW sg13_lv_pmos m=1 w=480.00n l=130.00n ng=1
MP28 Q1 net36 VDD VNW sg13_lv_pmos m=1 w=980.00n l=130.00n ng=1
MP27 net36 net4 VDD VNW sg13_lv_pmos m=1 w=480.00n l=130.00n ng=1
MP26 net36 RB VDD VNW sg13_lv_pmos m=1 w=480.00n l=130.00n ng=1
MP25 net41 ED1B VDD VNW sg13_lv_pmos m=1 w=480.00n l=130.00n ng=1
MP24 ED1B RB VDD VNW sg13_lv_pmos m=1 w=480.00n l=130.00n ng=1
MP21 ED1B D1 net37 VNW sg13_lv_pmos m=1 w=480.00n l=130.00n ng=1
MP20 net4 CKPOS net50 VNW sg13_lv_pmos m=1 w=480.00n l=130.00n ng=1
MP19 ED1B CKNEG net51 VNW sg13_lv_pmos m=1 w=480.00n l=130.00n ng=1
MP17 Q0 net2 VDD VNW sg13_lv_pmos m=1 w=980.00n l=130.00n ng=1
MP15 net2 net3 VDD VNW sg13_lv_pmos m=1 w=480.00n l=130.00n ng=1
MP14 net2 RB VDD VNW sg13_lv_pmos m=1 w=480.00n l=130.00n ng=1
MP13 net3 CKPOS net10 VNW sg13_lv_pmos m=1 w=480.00n l=130.00n ng=1
MP12 net10 net2 VDD VNW sg13_lv_pmos m=1 w=480.00n l=130.00n ng=1
MP11 net9 CKNEG net3 VNW sg13_lv_pmos m=1 w=480.00n l=130.00n ng=1
MP10 net9 ED0B VDD VNW sg13_lv_pmos m=1 w=480.00n l=130.00n ng=1
MP9 ED0B RB VDD VNW sg13_lv_pmos m=1 w=480.00n l=130.00n ng=1
MP8 ED0B CKNEG net6 VNW sg13_lv_pmos m=1 w=480.00n l=130.00n ng=1
MP7 net6 net9 VDD VNW sg13_lv_pmos m=1 w=480.00n l=130.00n ng=1
MP5 CKPOS CKNEG VDD VNW sg13_lv_pmos m=1 w=980.00n l=130.00n ng=1
MP1 net12 CKPOS VDD VNW sg13_lv_pmos m=1 w=480.00n l=130.00n ng=1
MP18 ED0B D0 net12 VNW sg13_lv_pmos m=1 w=480.00n l=130.00n ng=1
MN59 CKNEG CK VSS VPW sg13_lv_nmos m=1 w=480.00n l=130.00n ng=1
MN58 net14 CKPOS net15 VPW sg13_lv_nmos m=1 w=300.0n l=130.00n ng=1
MN57 Q3 net13 VSS VPW sg13_lv_nmos m=1 w=640.00n l=130.00n ng=1
MN56 net13 RB net18 VPW sg13_lv_nmos m=1 w=300.0n l=130.00n ng=1
MN55 net14 ED3B VSS VPW sg13_lv_nmos m=1 w=300.0n l=130.00n ng=1
MN54 ED3B CKNEG net22 VPW sg13_lv_nmos m=1 w=300.0n l=130.00n ng=1
MN53 net15 CKNEG net16 VPW sg13_lv_nmos m=1 w=300.0n l=130.00n ng=1
MN52 ED3B CKPOS net26 VPW sg13_lv_nmos m=1 w=300.0n l=130.00n ng=1
MN51 net22 D3 net19 VPW sg13_lv_nmos m=1 w=300.0n l=130.00n ng=1
MN50 net16 net13 VSS VPW sg13_lv_nmos m=1 w=300.0n l=130.00n ng=1
MN49 net26 net14 net24 VPW sg13_lv_nmos m=1 w=300.0n l=130.00n ng=1
MN48 net18 net15 VSS VPW sg13_lv_nmos m=1 w=300.0n l=130.00n ng=1
MN47 net24 RB VSS VPW sg13_lv_nmos m=1 w=300.0n l=130.00n ng=1
MN46 net19 RB VSS VPW sg13_lv_nmos m=1 w=300.0n l=130.00n ng=1
MN45 net28 CKPOS net30 VPW sg13_lv_nmos m=1 w=300.0n l=130.00n ng=1
MN44 Q2 net29 VSS VPW sg13_lv_nmos m=1 w=640.00n l=130.00n ng=1
MN43 net29 RB net33 VPW sg13_lv_nmos m=1 w=300.0n l=130.00n ng=1
MN42 net28 ED2B VSS VPW sg13_lv_nmos m=1 w=300.0n l=130.00n ng=1
MN41 ED2B CKNEG net38 VPW sg13_lv_nmos m=1 w=300.0n l=130.00n ng=1
MN33 net35 RB VSS VPW sg13_lv_nmos m=1 w=300.0n l=130.00n ng=1
MN34 net39 RB VSS VPW sg13_lv_nmos m=1 w=300.0n l=130.00n ng=1
MN35 net33 net30 VSS VPW sg13_lv_nmos m=1 w=300.0n l=130.00n ng=1
MN32 net41 CKPOS net4 VPW sg13_lv_nmos m=1 w=300.0n l=130.00n ng=1
MN31 Q1 net36 VSS VPW sg13_lv_nmos m=1 w=640.00n l=130.00n ng=1
MN30 net36 RB net43 VPW sg13_lv_nmos m=1 w=300.0n l=130.00n ng=1
MN29 net41 ED1B VSS VPW sg13_lv_nmos m=1 w=300.0n l=130.00n ng=1
MN36 net34 net28 net39 VPW sg13_lv_nmos m=1 w=300.0n l=130.00n ng=1
MN37 net31 net29 VSS VPW sg13_lv_nmos m=1 w=300.0n l=130.00n ng=1
MN26 ED1B CKNEG net44 VPW sg13_lv_nmos m=1 w=300.0n l=130.00n ng=1
MN25 net4 CKNEG net11 VPW sg13_lv_nmos m=1 w=300.0n l=130.00n ng=1
MN24 ED1B CKPOS net52 VPW sg13_lv_nmos m=1 w=300.0n l=130.00n ng=1
MN38 net38 D2 net35 VPW sg13_lv_nmos m=1 w=300.0n l=130.00n ng=1
MN23 net44 D1 net49 VPW sg13_lv_nmos m=1 w=300.0n l=130.00n ng=1
MN22 net11 net36 VSS VPW sg13_lv_nmos m=1 w=300.0n l=130.00n ng=1
MN21 net52 net41 net42 VPW sg13_lv_nmos m=1 w=300.0n l=130.00n ng=1
MN17 net20 RB VSS VPW sg13_lv_nmos m=1 w=300.0n l=130.00n ng=1
MN18 net42 RB VSS VPW sg13_lv_nmos m=1 w=300.0n l=130.00n ng=1
MN15 Q0 net2 VSS VPW sg13_lv_nmos m=1 w=640.00n l=130.00n ng=1
MN39 ED2B CKPOS net34 VPW sg13_lv_nmos m=1 w=300.0n l=130.00n ng=1
MN13 net5 net3 VSS VPW sg13_lv_nmos m=1 w=300.0n l=130.00n ng=1
MN12 net2 RB net5 VPW sg13_lv_nmos m=1 w=300.0n l=130.00n ng=1
MN40 net30 CKNEG net31 VPW sg13_lv_nmos m=1 w=300.0n l=130.00n ng=1
MN10 net1 net2 VSS VPW sg13_lv_nmos m=1 w=300.0n l=130.00n ng=1
MN9 net3 CKNEG net1 VPW sg13_lv_nmos m=1 w=300.0n l=130.00n ng=1
MN8 net9 CKPOS net3 VPW sg13_lv_nmos m=1 w=300.0n l=130.00n ng=1
MN7 net9 ED0B VSS VPW sg13_lv_nmos m=1 w=300.0n l=130.00n ng=1
MN6 net7 RB VSS VPW sg13_lv_nmos m=1 w=300.0n l=130.00n ng=1
MN5 net8 net9 net7 VPW sg13_lv_nmos m=1 w=300.0n l=130.00n ng=1
MN4 ED0B CKPOS net8 VPW sg13_lv_nmos m=1 w=300.0n l=130.00n ng=1
MN19 net49 RB VSS VPW sg13_lv_nmos m=1 w=300.0n l=130.00n ng=1
MN20 net43 net4 VSS VPW sg13_lv_nmos m=1 w=300.0n l=130.00n ng=1
MN2 CKPOS CKNEG VSS VPW sg13_lv_nmos m=1 w=640.00n l=130.00n ng=1
MN16 ED0B CKNEG net21 VPW sg13_lv_nmos m=1 w=300.0n l=130.00n ng=1
MP2 net21 D0 net20 VPW sg13_lv_nmos m=1 w=300.0n l=130.00n ng=1
.ENDS

************************************************************************
* Library Name: ez130_8t
* Cell Name:    DFFRQ4X3
* View Name:    schematic
************************************************************************

.SUBCKT DFFRQ4X3 CK D0 D1 D2 D3 Q0 Q1 Q2 Q3 RB VDD VNW VPW VSS
*.PININFO CK:I D0:I D1:I D2:I D3:I RB:I Q0:O Q1:O Q2:O Q3:O VDD:B VNW:B VPW:B
*.PININFO VSS:B
MP57 CKNEG CK VDD VNW sg13_lv_pmos m=1 w=720.00n l=130.00n ng=1
MP56 net23 CKPOS VDD VNW sg13_lv_pmos m=1 w=480.00n l=130.00n ng=1
MP55 net17 net13 VDD VNW sg13_lv_pmos m=1 w=480.00n l=130.00n ng=1
MP54 net25 net14 VDD VNW sg13_lv_pmos m=1 w=480.00n l=130.00n ng=1
MP53 net14 CKNEG net15 VNW sg13_lv_pmos m=1 w=480.00n l=130.00n ng=1
MP52 Q3 net13 VDD VNW sg13_lv_pmos m=1 w=1.32u l=130.00n ng=1
MP51 net13 net15 VDD VNW sg13_lv_pmos m=1 w=480.00n l=130.00n ng=1
MP50 net13 RB VDD VNW sg13_lv_pmos m=1 w=480.00n l=130.00n ng=1
MP49 net14 ED3B VDD VNW sg13_lv_pmos m=1 w=480.00n l=130.00n ng=1
MP48 ED3B RB VDD VNW sg13_lv_pmos m=1 w=480.00n l=130.00n ng=1
MP47 ED3B D3 net23 VNW sg13_lv_pmos m=1 w=480.00n l=130.00n ng=1
MP46 net15 CKPOS net17 VNW sg13_lv_pmos m=1 w=480.00n l=130.00n ng=1
MP45 ED3B CKNEG net25 VNW sg13_lv_pmos m=1 w=480.00n l=130.00n ng=1
MP44 net27 CKPOS VDD VNW sg13_lv_pmos m=1 w=480.00n l=130.00n ng=1
MP43 net32 net29 VDD VNW sg13_lv_pmos m=1 w=480.00n l=130.00n ng=1
MP42 net40 net28 VDD VNW sg13_lv_pmos m=1 w=480.00n l=130.00n ng=1
MP41 net28 CKNEG net30 VNW sg13_lv_pmos m=1 w=480.00n l=130.00n ng=1
MP40 Q2 net29 VDD VNW sg13_lv_pmos m=1 w=1.32u l=130.00n ng=1
MP39 net29 net30 VDD VNW sg13_lv_pmos m=1 w=480.00n l=130.00n ng=1
MP38 net29 RB VDD VNW sg13_lv_pmos m=1 w=480.00n l=130.00n ng=1
MP37 net28 ED2B VDD VNW sg13_lv_pmos m=1 w=480.00n l=130.00n ng=1
MP36 ED2B RB VDD VNW sg13_lv_pmos m=1 w=480.00n l=130.00n ng=1
MP35 ED2B D2 net27 VNW sg13_lv_pmos m=1 w=480.00n l=130.00n ng=1
MP34 net30 CKPOS net32 VNW sg13_lv_pmos m=1 w=480.00n l=130.00n ng=1
MP33 ED2B CKNEG net40 VNW sg13_lv_pmos m=1 w=480.00n l=130.00n ng=1
MP32 net37 CKPOS VDD VNW sg13_lv_pmos m=1 w=480.00n l=130.00n ng=1
MP31 net50 net36 VDD VNW sg13_lv_pmos m=1 w=480.00n l=130.00n ng=1
MP30 net51 net41 VDD VNW sg13_lv_pmos m=1 w=480.00n l=130.00n ng=1
MP29 net41 CKNEG net4 VNW sg13_lv_pmos m=1 w=480.00n l=130.00n ng=1
MP28 Q1 net36 VDD VNW sg13_lv_pmos m=1 w=1.32u l=130.00n ng=1
MP27 net36 net4 VDD VNW sg13_lv_pmos m=1 w=480.00n l=130.00n ng=1
MP26 net36 RB VDD VNW sg13_lv_pmos m=1 w=480.00n l=130.00n ng=1
MP25 net41 ED1B VDD VNW sg13_lv_pmos m=1 w=480.00n l=130.00n ng=1
MP24 ED1B RB VDD VNW sg13_lv_pmos m=1 w=480.00n l=130.00n ng=1
MP21 ED1B D1 net37 VNW sg13_lv_pmos m=1 w=480.00n l=130.00n ng=1
MP20 net4 CKPOS net50 VNW sg13_lv_pmos m=1 w=480.00n l=130.00n ng=1
MP19 ED1B CKNEG net51 VNW sg13_lv_pmos m=1 w=480.00n l=130.00n ng=1
MP17 Q0 net2 VDD VNW sg13_lv_pmos m=1 w=1.32u l=130.00n ng=1
MP15 net2 net3 VDD VNW sg13_lv_pmos m=1 w=480.00n l=130.00n ng=1
MP14 net2 RB VDD VNW sg13_lv_pmos m=1 w=480.00n l=130.00n ng=1
MP13 net3 CKPOS net10 VNW sg13_lv_pmos m=1 w=480.00n l=130.00n ng=1
MP12 net10 net2 VDD VNW sg13_lv_pmos m=1 w=480.00n l=130.00n ng=1
MP11 net9 CKNEG net3 VNW sg13_lv_pmos m=1 w=480.00n l=130.00n ng=1
MP10 net9 ED0B VDD VNW sg13_lv_pmos m=1 w=480.00n l=130.00n ng=1
MP9 ED0B RB VDD VNW sg13_lv_pmos m=1 w=480.00n l=130.00n ng=1
MP8 ED0B CKNEG net6 VNW sg13_lv_pmos m=1 w=480.00n l=130.00n ng=1
MP7 net6 net9 VDD VNW sg13_lv_pmos m=1 w=480.00n l=130.00n ng=1
MP5 CKPOS CKNEG VDD VNW sg13_lv_pmos m=1 w=980.00n l=130.00n ng=1
MP1 net12 CKPOS VDD VNW sg13_lv_pmos m=1 w=480.00n l=130.00n ng=1
MP18 ED0B D0 net12 VNW sg13_lv_pmos m=1 w=480.00n l=130.00n ng=1
MN59 CKNEG CK VSS VPW sg13_lv_nmos m=1 w=480.00n l=130.00n ng=1
MN58 net14 CKPOS net15 VPW sg13_lv_nmos m=1 w=300.0n l=130.00n ng=1
MN57 Q3 net13 VSS VPW sg13_lv_nmos m=1 w=860.00n l=130.00n ng=1
MN56 net13 RB net18 VPW sg13_lv_nmos m=1 w=300.0n l=130.00n ng=1
MN55 net14 ED3B VSS VPW sg13_lv_nmos m=1 w=300.0n l=130.00n ng=1
MN54 ED3B CKNEG net22 VPW sg13_lv_nmos m=1 w=300.0n l=130.00n ng=1
MN53 net15 CKNEG net16 VPW sg13_lv_nmos m=1 w=300.0n l=130.00n ng=1
MN52 ED3B CKPOS net26 VPW sg13_lv_nmos m=1 w=300.0n l=130.00n ng=1
MN51 net22 D3 net19 VPW sg13_lv_nmos m=1 w=300.0n l=130.00n ng=1
MN50 net16 net13 VSS VPW sg13_lv_nmos m=1 w=300.0n l=130.00n ng=1
MN49 net26 net14 net24 VPW sg13_lv_nmos m=1 w=300.0n l=130.00n ng=1
MN48 net18 net15 VSS VPW sg13_lv_nmos m=1 w=300.0n l=130.00n ng=1
MN47 net24 RB VSS VPW sg13_lv_nmos m=1 w=300.0n l=130.00n ng=1
MN46 net19 RB VSS VPW sg13_lv_nmos m=1 w=300.0n l=130.00n ng=1
MN45 net28 CKPOS net30 VPW sg13_lv_nmos m=1 w=300.0n l=130.00n ng=1
MN44 Q2 net29 VSS VPW sg13_lv_nmos m=1 w=860.00n l=130.00n ng=1
MN43 net29 RB net33 VPW sg13_lv_nmos m=1 w=300.0n l=130.00n ng=1
MN42 net28 ED2B VSS VPW sg13_lv_nmos m=1 w=300.0n l=130.00n ng=1
MN41 ED2B CKNEG net38 VPW sg13_lv_nmos m=1 w=300.0n l=130.00n ng=1
MN33 net35 RB VSS VPW sg13_lv_nmos m=1 w=300.0n l=130.00n ng=1
MN34 net39 RB VSS VPW sg13_lv_nmos m=1 w=300.0n l=130.00n ng=1
MN35 net33 net30 VSS VPW sg13_lv_nmos m=1 w=300.0n l=130.00n ng=1
MN32 net41 CKPOS net4 VPW sg13_lv_nmos m=1 w=300.0n l=130.00n ng=1
MN31 Q1 net36 VSS VPW sg13_lv_nmos m=1 w=860.00n l=130.00n ng=1
MN30 net36 RB net43 VPW sg13_lv_nmos m=1 w=300.0n l=130.00n ng=1
MN29 net41 ED1B VSS VPW sg13_lv_nmos m=1 w=300.0n l=130.00n ng=1
MN36 net34 net28 net39 VPW sg13_lv_nmos m=1 w=300.0n l=130.00n ng=1
MN37 net31 net29 VSS VPW sg13_lv_nmos m=1 w=300.0n l=130.00n ng=1
MN26 ED1B CKNEG net44 VPW sg13_lv_nmos m=1 w=300.0n l=130.00n ng=1
MN25 net4 CKNEG net11 VPW sg13_lv_nmos m=1 w=300.0n l=130.00n ng=1
MN24 ED1B CKPOS net52 VPW sg13_lv_nmos m=1 w=300.0n l=130.00n ng=1
MN38 net38 D2 net35 VPW sg13_lv_nmos m=1 w=300.0n l=130.00n ng=1
MN23 net44 D1 net49 VPW sg13_lv_nmos m=1 w=300.0n l=130.00n ng=1
MN22 net11 net36 VSS VPW sg13_lv_nmos m=1 w=300.0n l=130.00n ng=1
MN21 net52 net41 net42 VPW sg13_lv_nmos m=1 w=300.0n l=130.00n ng=1
MN17 net20 RB VSS VPW sg13_lv_nmos m=1 w=300.0n l=130.00n ng=1
MN18 net42 RB VSS VPW sg13_lv_nmos m=1 w=300.0n l=130.00n ng=1
MN15 Q0 net2 VSS VPW sg13_lv_nmos m=1 w=860.00n l=130.00n ng=1
MN39 ED2B CKPOS net34 VPW sg13_lv_nmos m=1 w=300.0n l=130.00n ng=1
MN13 net5 net3 VSS VPW sg13_lv_nmos m=1 w=300.0n l=130.00n ng=1
MN12 net2 RB net5 VPW sg13_lv_nmos m=1 w=300.0n l=130.00n ng=1
MN40 net30 CKNEG net31 VPW sg13_lv_nmos m=1 w=300.0n l=130.00n ng=1
MN10 net1 net2 VSS VPW sg13_lv_nmos m=1 w=300.0n l=130.00n ng=1
MN9 net3 CKNEG net1 VPW sg13_lv_nmos m=1 w=300.0n l=130.00n ng=1
MN8 net9 CKPOS net3 VPW sg13_lv_nmos m=1 w=300.0n l=130.00n ng=1
MN7 net9 ED0B VSS VPW sg13_lv_nmos m=1 w=300.0n l=130.00n ng=1
MN6 net7 RB VSS VPW sg13_lv_nmos m=1 w=300.0n l=130.00n ng=1
MN5 net8 net9 net7 VPW sg13_lv_nmos m=1 w=300.0n l=130.00n ng=1
MN4 ED0B CKPOS net8 VPW sg13_lv_nmos m=1 w=300.0n l=130.00n ng=1
MN19 net49 RB VSS VPW sg13_lv_nmos m=1 w=300.0n l=130.00n ng=1
MN20 net43 net4 VSS VPW sg13_lv_nmos m=1 w=300.0n l=130.00n ng=1
MN2 CKPOS CKNEG VSS VPW sg13_lv_nmos m=1 w=640.00n l=130.00n ng=1
MN16 ED0B CKNEG net21 VPW sg13_lv_nmos m=1 w=300.0n l=130.00n ng=1
MP2 net21 D0 net20 VPW sg13_lv_nmos m=1 w=300.0n l=130.00n ng=1
.ENDS

************************************************************************
* Library Name: ez130_8t
* Cell Name:    DFFRX1
* View Name:    schematic
************************************************************************

.SUBCKT DFFRX1 CK D Q RB VDD VNW VPW VSS QB
*.PININFO CK:I D:I RB:I Q:O QB:O VDD:B VNW:B VPW:B VSS:B
MP17 Q net2 VDD VNW sg13_lv_pmos m=1 w=480.00n l=130.00n ng=1
MP15 net2 net3 VDD VNW sg13_lv_pmos m=1 w=480.00n l=130.00n ng=1
MP14 net2 RB VDD VNW sg13_lv_pmos m=1 w=480.00n l=130.00n ng=1
MP16 QB net3 VDD VNW sg13_lv_pmos m=1 w=480.00n l=130.00n ng=1
MP13 net3 CKPOS net10 VNW sg13_lv_pmos m=1 w=480.00n l=130.00n ng=1
MP12 net10 net2 VDD VNW sg13_lv_pmos m=1 w=480.00n l=130.00n ng=1
MP11 net9 CKNEG net3 VNW sg13_lv_pmos m=1 w=480.00n l=130.00n ng=1
MP10 net9 EDB VDD VNW sg13_lv_pmos m=1 w=480.00n l=130.00n ng=1
MP9 EDB RB VDD VNW sg13_lv_pmos m=1 w=480.00n l=130.00n ng=1
MP8 EDB CKNEG net6 VNW sg13_lv_pmos m=1 w=480.00n l=130.00n ng=1
MP7 net6 net9 VDD VNW sg13_lv_pmos m=1 w=480.00n l=130.00n ng=1
MP5 CKPOS CKNEG VDD VNW sg13_lv_pmos m=1 w=980.00n l=130.00n ng=1
MP4 CKNEG CK VDD VNW sg13_lv_pmos m=1 w=480.00n l=130.00n ng=1
MP1 net12 CKPOS VDD VNW sg13_lv_pmos m=1 w=480.00n l=130.00n ng=1
MP18 EDB D net12 VNW sg13_lv_pmos m=1 w=480.00n l=130.00n ng=1
MN17 net20 RB VSS VPW sg13_lv_nmos m=1 w=300.0n l=130.00n ng=1
MN15 Q net2 VSS VPW sg13_lv_nmos m=1 w=300.0n l=130.00n ng=1
MN14 QB net3 VSS VPW sg13_lv_nmos m=1 w=300.0n l=130.00n ng=1
MN13 net5 RB VSS VPW sg13_lv_nmos m=1 w=300.0n l=130.00n ng=1
MN12 net2 net3 net5 VPW sg13_lv_nmos m=1 w=300.0n l=130.00n ng=1
MN10 net1 net2 VSS VPW sg13_lv_nmos m=1 w=300.0n l=130.00n ng=1
MN9 net3 CKNEG net1 VPW sg13_lv_nmos m=1 w=300.0n l=130.00n ng=1
MN8 net9 CKPOS net3 VPW sg13_lv_nmos m=1 w=300.0n l=130.00n ng=1
MN7 net9 EDB VSS VPW sg13_lv_nmos m=1 w=300.0n l=130.00n ng=1
MN6 net7 RB VSS VPW sg13_lv_nmos m=1 w=300.0n l=130.00n ng=1
MN5 net8 net9 net7 VPW sg13_lv_nmos m=1 w=300.0n l=130.00n ng=1
MN4 EDB CKPOS net8 VPW sg13_lv_nmos m=1 w=300.0n l=130.00n ng=1
MN2 CKPOS CKNEG VSS VPW sg13_lv_nmos m=1 w=640.00n l=130.00n ng=1
MN1 CKNEG CK VSS VPW sg13_lv_nmos m=1 w=300.0n l=130.00n ng=1
MN16 EDB CKNEG net21 VPW sg13_lv_nmos m=1 w=300.0n l=130.00n ng=1
MP2 net21 D net20 VPW sg13_lv_nmos m=1 w=300.0n l=130.00n ng=1
.ENDS

************************************************************************
* Library Name: ez130_8t
* Cell Name:    DFFRX1P5
* View Name:    schematic
************************************************************************

.SUBCKT DFFRX1P5 CK D Q RB VDD VNW VPW VSS QB
*.PININFO CK:I D:I RB:I Q:O QB:O VDD:B VNW:B VPW:B VSS:B
MP17 Q net2 VDD VNW sg13_lv_pmos m=1 w=720.00n l=130.00n ng=1
MP15 net2 net3 VDD VNW sg13_lv_pmos m=1 w=480.00n l=130.00n ng=1
MP14 net2 RB VDD VNW sg13_lv_pmos m=1 w=480.00n l=130.00n ng=1
MP16 QB net3 VDD VNW sg13_lv_pmos m=1 w=720.00n l=130.00n ng=1
MP13 net3 CKPOS net10 VNW sg13_lv_pmos m=1 w=480.00n l=130.00n ng=1
MP12 net10 net2 VDD VNW sg13_lv_pmos m=1 w=480.00n l=130.00n ng=1
MP11 net9 CKNEG net3 VNW sg13_lv_pmos m=1 w=480.00n l=130.00n ng=1
MP10 net9 EDB VDD VNW sg13_lv_pmos m=1 w=480.00n l=130.00n ng=1
MP9 EDB RB VDD VNW sg13_lv_pmos m=1 w=480.00n l=130.00n ng=1
MP8 EDB CKNEG net6 VNW sg13_lv_pmos m=1 w=480.00n l=130.00n ng=1
MP7 net6 net9 VDD VNW sg13_lv_pmos m=1 w=480.00n l=130.00n ng=1
MP5 CKPOS CKNEG VDD VNW sg13_lv_pmos m=1 w=980.00n l=130.00n ng=1
MP4 CKNEG CK VDD VNW sg13_lv_pmos m=1 w=480.00n l=130.00n ng=1
MP1 net12 CKPOS VDD VNW sg13_lv_pmos m=1 w=480.00n l=130.00n ng=1
MP18 EDB D net12 VNW sg13_lv_pmos m=1 w=480.00n l=130.00n ng=1
MN17 net20 RB VSS VPW sg13_lv_nmos m=1 w=300.0n l=130.00n ng=1
MN15 Q net2 VSS VPW sg13_lv_nmos m=1 w=480.00n l=130.00n ng=1
MN14 QB net3 VSS VPW sg13_lv_nmos m=1 w=480.00n l=130.00n ng=1
MN13 net5 RB VSS VPW sg13_lv_nmos m=1 w=300.0n l=130.00n ng=1
MN12 net2 net3 net5 VPW sg13_lv_nmos m=1 w=300.0n l=130.00n ng=1
MN10 net1 net2 VSS VPW sg13_lv_nmos m=1 w=300.0n l=130.00n ng=1
MN9 net3 CKNEG net1 VPW sg13_lv_nmos m=1 w=300.0n l=130.00n ng=1
MN8 net9 CKPOS net3 VPW sg13_lv_nmos m=1 w=300.0n l=130.00n ng=1
MN7 net9 EDB VSS VPW sg13_lv_nmos m=1 w=300.0n l=130.00n ng=1
MN6 net7 RB VSS VPW sg13_lv_nmos m=1 w=300.0n l=130.00n ng=1
MN5 net8 net9 net7 VPW sg13_lv_nmos m=1 w=300.0n l=130.00n ng=1
MN4 EDB CKPOS net8 VPW sg13_lv_nmos m=1 w=300.0n l=130.00n ng=1
MN2 CKPOS CKNEG VSS VPW sg13_lv_nmos m=1 w=640.00n l=130.00n ng=1
MN1 CKNEG CK VSS VPW sg13_lv_nmos m=1 w=300.0n l=130.00n ng=1
MN16 EDB CKNEG net21 VPW sg13_lv_nmos m=1 w=300.0n l=130.00n ng=1
MP2 net21 D net20 VPW sg13_lv_nmos m=1 w=300.0n l=130.00n ng=1
.ENDS

************************************************************************
* Library Name: ez130_8t
* Cell Name:    DFFRX2
* View Name:    schematic
************************************************************************

.SUBCKT DFFRX2 CK D Q RB VDD VNW VPW VSS QB
*.PININFO CK:I D:I RB:I Q:O QB:O VDD:B VNW:B VPW:B VSS:B
MP17 Q net2 VDD VNW sg13_lv_pmos m=1 w=980.00n l=130.00n ng=1
MP15 net2 net3 VDD VNW sg13_lv_pmos m=1 w=480.00n l=130.00n ng=1
MP14 net2 RB VDD VNW sg13_lv_pmos m=1 w=480.00n l=130.00n ng=1
MP16 QB net3 VDD VNW sg13_lv_pmos m=1 w=980.00n l=130.00n ng=1
MP13 net3 CKPOS net10 VNW sg13_lv_pmos m=1 w=480.00n l=130.00n ng=1
MP12 net10 net2 VDD VNW sg13_lv_pmos m=1 w=480.00n l=130.00n ng=1
MP11 net9 CKNEG net3 VNW sg13_lv_pmos m=1 w=480.00n l=130.00n ng=1
MP10 net9 EDB VDD VNW sg13_lv_pmos m=1 w=480.00n l=130.00n ng=1
MP9 EDB RB VDD VNW sg13_lv_pmos m=1 w=480.00n l=130.00n ng=1
MP8 EDB CKNEG net6 VNW sg13_lv_pmos m=1 w=480.00n l=130.00n ng=1
MP7 net6 net9 VDD VNW sg13_lv_pmos m=1 w=480.00n l=130.00n ng=1
MP5 CKPOS CKNEG VDD VNW sg13_lv_pmos m=1 w=980.00n l=130.00n ng=1
MP4 CKNEG CK VDD VNW sg13_lv_pmos m=1 w=480.00n l=130.00n ng=1
MP1 net12 CKPOS VDD VNW sg13_lv_pmos m=1 w=480.00n l=130.00n ng=1
MP18 EDB D net12 VNW sg13_lv_pmos m=1 w=480.00n l=130.00n ng=1
MN17 net20 RB VSS VPW sg13_lv_nmos m=1 w=300.0n l=130.00n ng=1
MN15 Q net2 VSS VPW sg13_lv_nmos m=1 w=640.00n l=130.00n ng=1
MN14 QB net3 VSS VPW sg13_lv_nmos m=1 w=640.00n l=130.00n ng=1
MN13 net5 RB VSS VPW sg13_lv_nmos m=1 w=300.0n l=130.00n ng=1
MN12 net2 net3 net5 VPW sg13_lv_nmos m=1 w=300.0n l=130.00n ng=1
MN10 net1 net2 VSS VPW sg13_lv_nmos m=1 w=300.0n l=130.00n ng=1
MN9 net3 CKNEG net1 VPW sg13_lv_nmos m=1 w=300.0n l=130.00n ng=1
MN8 net9 CKPOS net3 VPW sg13_lv_nmos m=1 w=300.0n l=130.00n ng=1
MN7 net9 EDB VSS VPW sg13_lv_nmos m=1 w=300.0n l=130.00n ng=1
MN6 net7 RB VSS VPW sg13_lv_nmos m=1 w=300.0n l=130.00n ng=1
MN5 net8 net9 net7 VPW sg13_lv_nmos m=1 w=300.0n l=130.00n ng=1
MN4 EDB CKPOS net8 VPW sg13_lv_nmos m=1 w=300.0n l=130.00n ng=1
MN2 CKPOS CKNEG VSS VPW sg13_lv_nmos m=1 w=640.00n l=130.00n ng=1
MN1 CKNEG CK VSS VPW sg13_lv_nmos m=1 w=300.0n l=130.00n ng=1
MN16 EDB CKNEG net21 VPW sg13_lv_nmos m=1 w=300.0n l=130.00n ng=1
MP2 net21 D net20 VPW sg13_lv_nmos m=1 w=300.0n l=130.00n ng=1
.ENDS

************************************************************************
* Library Name: ez130_8t
* Cell Name:    DFFRX3
* View Name:    schematic
************************************************************************

.SUBCKT DFFRX3 CK D Q RB VDD VNW VPW VSS QB
*.PININFO CK:I D:I RB:I Q:O QB:O VDD:B VNW:B VPW:B VSS:B
MP17 Q net2 VDD VNW sg13_lv_pmos m=1 w=1.32u l=130.00n ng=1
MP15 net2 net3 VDD VNW sg13_lv_pmos m=1 w=480.00n l=130.00n ng=1
MP14 net2 RB VDD VNW sg13_lv_pmos m=1 w=480.00n l=130.00n ng=1
MP16 QB net3 VDD VNW sg13_lv_pmos m=1 w=1.32u l=130.00n ng=1
MP13 net3 CKPOS net10 VNW sg13_lv_pmos m=1 w=480.00n l=130.00n ng=1
MP12 net10 net2 VDD VNW sg13_lv_pmos m=1 w=480.00n l=130.00n ng=1
MP11 net9 CKNEG net3 VNW sg13_lv_pmos m=1 w=480.00n l=130.00n ng=1
MP10 net9 EDB VDD VNW sg13_lv_pmos m=1 w=480.00n l=130.00n ng=1
MP9 EDB RB VDD VNW sg13_lv_pmos m=1 w=480.00n l=130.00n ng=1
MP8 EDB CKNEG net6 VNW sg13_lv_pmos m=1 w=480.00n l=130.00n ng=1
MP7 net6 net9 VDD VNW sg13_lv_pmos m=1 w=480.00n l=130.00n ng=1
MP5 CKPOS CKNEG VDD VNW sg13_lv_pmos m=1 w=980.00n l=130.00n ng=1
MP4 CKNEG CK VDD VNW sg13_lv_pmos m=1 w=480.00n l=130.00n ng=1
MP1 net12 CKPOS VDD VNW sg13_lv_pmos m=1 w=480.00n l=130.00n ng=1
MP18 EDB D net12 VNW sg13_lv_pmos m=1 w=480.00n l=130.00n ng=1
MN17 net20 RB VSS VPW sg13_lv_nmos m=1 w=300.0n l=130.00n ng=1
MN15 Q net2 VSS VPW sg13_lv_nmos m=1 w=860.00n l=130.00n ng=1
MN14 QB net3 VSS VPW sg13_lv_nmos m=1 w=860.00n l=130.00n ng=1
MN13 net5 RB VSS VPW sg13_lv_nmos m=1 w=300.0n l=130.00n ng=1
MN12 net2 net3 net5 VPW sg13_lv_nmos m=1 w=300.0n l=130.00n ng=1
MN10 net1 net2 VSS VPW sg13_lv_nmos m=1 w=300.0n l=130.00n ng=1
MN9 net3 CKNEG net1 VPW sg13_lv_nmos m=1 w=300.0n l=130.00n ng=1
MN8 net9 CKPOS net3 VPW sg13_lv_nmos m=1 w=300.0n l=130.00n ng=1
MN7 net9 EDB VSS VPW sg13_lv_nmos m=1 w=300.0n l=130.00n ng=1
MN6 net7 RB VSS VPW sg13_lv_nmos m=1 w=300.0n l=130.00n ng=1
MN5 net8 net9 net7 VPW sg13_lv_nmos m=1 w=300.0n l=130.00n ng=1
MN4 EDB CKPOS net8 VPW sg13_lv_nmos m=1 w=300.0n l=130.00n ng=1
MN2 CKPOS CKNEG VSS VPW sg13_lv_nmos m=1 w=640.00n l=130.00n ng=1
MN1 CKNEG CK VSS VPW sg13_lv_nmos m=1 w=300.0n l=130.00n ng=1
MN16 EDB CKNEG net21 VPW sg13_lv_nmos m=1 w=300.0n l=130.00n ng=1
MP2 net21 D net20 VPW sg13_lv_nmos m=1 w=300.0n l=130.00n ng=1
.ENDS

************************************************************************
* Library Name: ez130_8t
* Cell Name:    DFFRX4
* View Name:    schematic
************************************************************************

.SUBCKT DFFRX4 CK D Q RB VDD VNW VPW VSS QB
*.PININFO CK:I D:I RB:I Q:O QB:O VDD:B VNW:B VPW:B VSS:B
MP17 Q net2 VDD VNW sg13_lv_pmos m=1 w=1.96u l=130.00n ng=2
MP15 net2 net3 VDD VNW sg13_lv_pmos m=1 w=480.00n l=130.00n ng=1
MP14 net2 RB VDD VNW sg13_lv_pmos m=1 w=480.00n l=130.00n ng=1
MP16 QB net3 VDD VNW sg13_lv_pmos m=1 w=1.96u l=130.00n ng=2
MP13 net3 CKPOS net10 VNW sg13_lv_pmos m=1 w=480.00n l=130.00n ng=1
MP12 net10 net2 VDD VNW sg13_lv_pmos m=1 w=480.00n l=130.00n ng=1
MP11 net9 CKNEG net3 VNW sg13_lv_pmos m=1 w=480.00n l=130.00n ng=1
MP10 net9 EDB VDD VNW sg13_lv_pmos m=1 w=480.00n l=130.00n ng=1
MP9 EDB RB VDD VNW sg13_lv_pmos m=1 w=480.00n l=130.00n ng=1
MP8 EDB CKNEG net6 VNW sg13_lv_pmos m=1 w=480.00n l=130.00n ng=1
MP7 net6 net9 VDD VNW sg13_lv_pmos m=1 w=480.00n l=130.00n ng=1
MP5 CKPOS CKNEG VDD VNW sg13_lv_pmos m=1 w=980.00n l=130.00n ng=1
MP4 CKNEG CK VDD VNW sg13_lv_pmos m=1 w=480.00n l=130.00n ng=1
MP1 net12 CKPOS VDD VNW sg13_lv_pmos m=1 w=480.00n l=130.00n ng=1
MP18 EDB D net12 VNW sg13_lv_pmos m=1 w=480.00n l=130.00n ng=1
MN17 net20 RB VSS VPW sg13_lv_nmos m=1 w=300.0n l=130.00n ng=1
MN15 Q net2 VSS VPW sg13_lv_nmos m=1 w=1.28u l=130.00n ng=2
MN14 QB net3 VSS VPW sg13_lv_nmos m=1 w=1.28u l=130.00n ng=2
MN13 net5 RB VSS VPW sg13_lv_nmos m=1 w=300.0n l=130.00n ng=1
MN12 net2 net3 net5 VPW sg13_lv_nmos m=1 w=300.0n l=130.00n ng=1
MN10 net1 net2 VSS VPW sg13_lv_nmos m=1 w=300.0n l=130.00n ng=1
MN9 net3 CKNEG net1 VPW sg13_lv_nmos m=1 w=300.0n l=130.00n ng=1
MN8 net9 CKPOS net3 VPW sg13_lv_nmos m=1 w=300.0n l=130.00n ng=1
MN7 net9 EDB VSS VPW sg13_lv_nmos m=1 w=300.0n l=130.00n ng=1
MN6 net7 RB VSS VPW sg13_lv_nmos m=1 w=300.0n l=130.00n ng=1
MN5 net8 net9 net7 VPW sg13_lv_nmos m=1 w=300.0n l=130.00n ng=1
MN4 EDB CKPOS net8 VPW sg13_lv_nmos m=1 w=300.0n l=130.00n ng=1
MN2 CKPOS CKNEG VSS VPW sg13_lv_nmos m=1 w=640.00n l=130.00n ng=1
MN1 CKNEG CK VSS VPW sg13_lv_nmos m=1 w=300.0n l=130.00n ng=1
MN16 EDB CKNEG net21 VPW sg13_lv_nmos m=1 w=300.0n l=130.00n ng=1
MP2 net21 D net20 VPW sg13_lv_nmos m=1 w=300.0n l=130.00n ng=1
.ENDS

************************************************************************
* Library Name: ez130_8t
* Cell Name:    DFFRX6
* View Name:    schematic
************************************************************************

.SUBCKT DFFRX6 CK D Q RB VDD VNW VPW VSS QB
*.PININFO CK:I D:I RB:I Q:O QB:O VDD:B VNW:B VPW:B VSS:B
MP17 Q net2 VDD VNW sg13_lv_pmos m=1 w=2.6u l=130.00n ng=2
MP15 net2 net3 VDD VNW sg13_lv_pmos m=1 w=480.00n l=130.00n ng=1
MP14 net2 RB VDD VNW sg13_lv_pmos m=1 w=480.00n l=130.00n ng=1
MP16 QB net3 VDD VNW sg13_lv_pmos m=1 w=2.02u l=130.00n ng=2
MP13 net3 CKPOS net10 VNW sg13_lv_pmos m=1 w=480.00n l=130.00n ng=1
MP12 net10 net2 VDD VNW sg13_lv_pmos m=1 w=480.00n l=130.00n ng=1
MP11 net9 CKNEG net3 VNW sg13_lv_pmos m=1 w=480.00n l=130.00n ng=1
MP10 net9 EDB VDD VNW sg13_lv_pmos m=1 w=480.00n l=130.00n ng=1
MP9 EDB RB VDD VNW sg13_lv_pmos m=1 w=480.00n l=130.00n ng=1
MP8 EDB CKNEG net6 VNW sg13_lv_pmos m=1 w=480.00n l=130.00n ng=1
MP7 net6 net9 VDD VNW sg13_lv_pmos m=1 w=480.00n l=130.00n ng=1
MP5 CKPOS CKNEG VDD VNW sg13_lv_pmos m=1 w=980.00n l=130.00n ng=1
MP4 CKNEG CK VDD VNW sg13_lv_pmos m=1 w=480.00n l=130.00n ng=1
MP1 net12 CKPOS VDD VNW sg13_lv_pmos m=1 w=480.00n l=130.00n ng=1
MP18 EDB D net12 VNW sg13_lv_pmos m=1 w=480.00n l=130.00n ng=1
MN17 net20 RB VSS VPW sg13_lv_nmos m=1 w=300.0n l=130.00n ng=1
MN15 Q net2 VSS VPW sg13_lv_nmos m=1 w=1.72u l=130.00n ng=2
MN14 QB net3 VSS VPW sg13_lv_nmos m=1 w=1.72u l=130.00n ng=2
MN13 net5 RB VSS VPW sg13_lv_nmos m=1 w=300.0n l=130.00n ng=1
MN12 net2 net3 net5 VPW sg13_lv_nmos m=1 w=300.0n l=130.00n ng=1
MN10 net1 net2 VSS VPW sg13_lv_nmos m=1 w=300.0n l=130.00n ng=1
MN9 net3 CKNEG net1 VPW sg13_lv_nmos m=1 w=300.0n l=130.00n ng=1
MN8 net9 CKPOS net3 VPW sg13_lv_nmos m=1 w=300.0n l=130.00n ng=1
MN7 net9 EDB VSS VPW sg13_lv_nmos m=1 w=300.0n l=130.00n ng=1
MN6 net7 RB VSS VPW sg13_lv_nmos m=1 w=300.0n l=130.00n ng=1
MN5 net8 net9 net7 VPW sg13_lv_nmos m=1 w=300.0n l=130.00n ng=1
MN4 EDB CKPOS net8 VPW sg13_lv_nmos m=1 w=300.0n l=130.00n ng=1
MN2 CKPOS CKNEG VSS VPW sg13_lv_nmos m=1 w=640.00n l=130.00n ng=1
MN1 CKNEG CK VSS VPW sg13_lv_nmos m=1 w=300.0n l=130.00n ng=1
MN16 EDB CKNEG net21 VPW sg13_lv_nmos m=1 w=300.0n l=130.00n ng=1
MP2 net21 D net20 VPW sg13_lv_nmos m=1 w=300.0n l=130.00n ng=1
.ENDS

************************************************************************
* Library Name: ez130_8t
* Cell Name:    DLY1X2
* View Name:    schematic
************************************************************************

.SUBCKT DLY1X2 A VDD VNW VPW VSS Y
*.PININFO A:I Y:O VDD:B VNW:B VPW:B VSS:B
MN7 Y net4 VSS VPW sg13_lv_nmos m=1 w=640.00n l=130.00n ng=1
MN5 net1 net2 VSS VPW sg13_lv_nmos m=1 w=300.0n l=130.00n ng=1
MN0 net2 A VSS VPW sg13_lv_nmos m=1 w=300.0n l=130.00n ng=1
MN6 net4 net1 VSS VPW sg13_lv_nmos m=1 w=300.0n l=130.00n ng=1
MP7 Y net4 VDD VNW sg13_lv_pmos m=1 w=980.00n l=130.00n ng=1
MP6 net4 net1 VDD VNW sg13_lv_pmos m=1 w=480.00n l=130.00n ng=1
MP5 net1 net2 VDD VNW sg13_lv_pmos m=1 w=480.00n l=130.00n ng=1
MP1 net2 A VDD VNW sg13_lv_pmos m=1 w=480.00n l=130.00n ng=1
.ENDS

************************************************************************
* Library Name: ez130_8t
* Cell Name:    FAX1
* View Name:    schematic
************************************************************************

.SUBCKT FAX1 A B CI CO S VDD VNW VPW VSS
*.PININFO A:I B:I CI:I CO:O S:O VDD:B VNW:B VPW:B VSS:B
MN12 BUFCI NCI VSS VPW sg13_lv_nmos m=1 w=570.00n l=130.00n ng=1
MN4 BUFCI AXORB CO VPW sg13_lv_nmos m=1 w=570.00n l=130.00n ng=1
MN3 NAXORB CI S VPW sg13_lv_nmos m=1 w=300.0n l=130.00n ng=1
MN2 AXORB NCI S VPW sg13_lv_nmos m=1 w=300.0n l=130.00n ng=1
MN10 NAXORB AXORB VSS VPW sg13_lv_nmos m=1 w=300.0n l=130.00n ng=1
MN1 NA B AXORB VPW sg13_lv_nmos m=1 w=310.00n l=130.00n ng=1
MN0 BUFA NB AXORB VPW sg13_lv_nmos m=1 w=310.00n l=130.00n ng=1
MN9 NA A VSS VPW sg13_lv_nmos m=1 w=250.00n l=130.00n ng=1
MN8 BUFA NA VSS VPW sg13_lv_nmos m=1 w=310.00n l=130.00n ng=1
MN6 NB B VSS VPW sg13_lv_nmos m=1 w=300.0n l=130.00n ng=1
MN11 NCI CI VSS VPW sg13_lv_nmos m=1 w=570.00n l=130.00n ng=1
MN5 BUFA NAXORB CO VPW sg13_lv_nmos m=1 w=570.00n l=130.00n ng=1
MP9 BUFCI NCI VDD VNW sg13_lv_pmos m=1 w=480.00n l=130.00n ng=1
MP12 BUFCI NAXORB CO VNW sg13_lv_pmos m=1 w=980.00n l=130.00n ng=1
MP11 NAXORB NCI S VNW sg13_lv_pmos m=1 w=480.00n l=130.00n ng=1
MP10 AXORB CI S VNW sg13_lv_pmos m=1 w=480.00n l=130.00n ng=1
MP8 NAXORB AXORB VDD VNW sg13_lv_pmos m=1 w=480.00n l=130.00n ng=1
MP3 BUFA B AXORB VNW sg13_lv_pmos m=1 w=480.00n l=130.00n ng=1
MP2 NA NB AXORB VNW sg13_lv_pmos m=1 w=480.00n l=130.00n ng=1
MP1 BUFA NA VDD VNW sg13_lv_pmos m=1 w=480.00n l=130.00n ng=1
MP13 BUFA AXORB CO VNW sg13_lv_pmos m=1 w=980.00n l=130.00n ng=1
MP0 NB B VDD VNW sg13_lv_pmos m=1 w=480.00n l=130.00n ng=1
MP5 NCI CI VDD VNW sg13_lv_pmos m=1 w=480.00n l=130.00n ng=1
MP4 NA A VDD VNW sg13_lv_pmos m=1 w=480.00n l=130.00n ng=1
.ENDS

************************************************************************
* Library Name: ez130_8t
* Cell Name:    HAX2
* View Name:    schematic
************************************************************************

.SUBCKT HAX2 A B CO S VDD VNW VPW VSS
*.PININFO A:I B:I CO:O S:O VDD:B VNW:B VPW:B VSS:B
MN3 net1 A VSS VPW sg13_lv_nmos m=1 w=300.0n l=130.00n ng=1
MN5 S SB VSS VPW sg13_lv_nmos m=1 w=640.00n l=130.00n ng=1
MN4 CO COB VSS VPW sg13_lv_nmos m=1 w=640.00n l=130.00n ng=1
MN0 COB B net36 VPW sg13_lv_nmos m=1 w=300.0n l=130.00n ng=1
MN6 net1 B VSS VPW sg13_lv_nmos m=1 w=300.0n l=130.00n ng=1
MN2 SB COB net1 VPW sg13_lv_nmos m=1 w=300.0n l=130.00n ng=1
MN1 net36 A VSS VPW sg13_lv_nmos m=1 w=300.0n l=130.00n ng=1
MP6 SB B net2 VNW sg13_lv_pmos m=1 w=480.00n l=130.00n ng=1
MP1 COB B VDD VNW sg13_lv_pmos m=1 w=480.00n l=130.00n ng=1
MP5 S SB VDD VNW sg13_lv_pmos m=1 w=980.00n l=130.00n ng=1
MP4 CO COB VDD VNW sg13_lv_pmos m=1 w=980.00n l=130.00n ng=1
MP0 COB A VDD VNW sg13_lv_pmos m=1 w=480.00n l=130.00n ng=1
MP2 SB COB VDD VNW sg13_lv_pmos m=1 w=480.00n l=130.00n ng=1
MP3 net2 A VDD VNW sg13_lv_pmos m=1 w=480.00n l=130.00n ng=1
.ENDS

************************************************************************
* Library Name: ez130_8t
* Cell Name:    INVX1
* View Name:    schematic
************************************************************************

.SUBCKT INVX1 A VDD VNW VPW VSS Y
*.PININFO A:I Y:O VDD:B VNW:B VPW:B VSS:B
MN0 Y A VSS VPW sg13_lv_nmos m=1 w=300.0n l=130.00n ng=1
MP0 Y A VDD VNW sg13_lv_pmos m=1 w=480.00n l=130.00n ng=1
.ENDS

************************************************************************
* Library Name: ez130_8t
* Cell Name:    INVX2
* View Name:    schematic
************************************************************************

.SUBCKT INVX2 A VDD VNW VPW VSS Y
*.PININFO A:I Y:O VDD:B VNW:B VPW:B VSS:B
MN0 Y A VSS VPW sg13_lv_nmos m=1 w=640.00n l=130.00n ng=1
MP0 Y A VDD VNW sg13_lv_pmos m=1 w=980.00n l=130.00n ng=1
.ENDS

************************************************************************
* Library Name: ez130_8t
* Cell Name:    INVX3
* View Name:    schematic
************************************************************************

.SUBCKT INVX3 A VDD VNW VPW VSS Y
*.PININFO A:I Y:O VDD:B VNW:B VPW:B VSS:B
MN0 Y A VSS VPW sg13_lv_nmos m=1 w=860.00n l=130.00n ng=1
MP0 Y A VDD VNW sg13_lv_pmos m=1 w=1.32u l=130.00n ng=1
.ENDS

************************************************************************
* Library Name: ez130_8t
* Cell Name:    INVX4
* View Name:    schematic
************************************************************************

.SUBCKT INVX4 A VDD VNW VPW VSS Y
*.PININFO A:I Y:O VDD:B VNW:B VPW:B VSS:B
MN0 Y A VSS VPW sg13_lv_nmos m=2 w=640.00n l=130.00n ng=1
MP0 Y A VDD VNW sg13_lv_pmos m=2 w=980.00n l=130.00n ng=1
.ENDS

************************************************************************
* Library Name: ez130_8t
* Cell Name:    INVX6
* View Name:    schematic
************************************************************************

.SUBCKT INVX6 A VDD VNW VPW VSS Y
*.PININFO A:I Y:O VDD:B VNW:B VPW:B VSS:B
MN0 Y A VSS VPW sg13_lv_nmos m=2 w=860.00n l=130.00n ng=1
MP0 Y A VDD VNW sg13_lv_pmos m=2 w=1.32u l=130.00n ng=1
.ENDS

************************************************************************
* Library Name: ez130_8t
* Cell Name:    INVX8
* View Name:    schematic
************************************************************************

.SUBCKT INVX8 A VDD VNW VPW VSS Y
*.PININFO A:I Y:O VDD:B VNW:B VPW:B VSS:B
MN6 Y A VSS VPW sg13_lv_nmos m=1 w=2.58u l=130.00n ng=3
MP1 Y A VDD VNW sg13_lv_pmos m=1 w=3.96u l=130.00n ng=3
.ENDS

************************************************************************
* Library Name: ez130_8t
* Cell Name:    INVX14
* View Name:    schematic
************************************************************************

.SUBCKT INVX14 A VDD VNW VPW VSS Y
*.PININFO A:I Y:O VDD:B VNW:B VPW:B VSS:B
MN0 Y A VSS VPW sg13_lv_nmos m=5 w=860.00n l=130.00n ng=1
MP0 Y A VDD VNW sg13_lv_pmos m=5 w=1.32u l=130.00n ng=1
.ENDS

************************************************************************
* Library Name: ez130_8t
* Cell Name:    INVX16
* View Name:    schematic
************************************************************************

.SUBCKT INVX16 A VDD VNW VPW VSS Y
*.PININFO A:I Y:O VDD:B VNW:B VPW:B VSS:B
MN6 Y A VSS VPW sg13_lv_nmos m=1 w=5.16u l=130.00n ng=6
MP1 Y A VDD VNW sg13_lv_pmos m=1 w=7.92u l=130.00n ng=6
.ENDS

************************************************************************
* Library Name: ez130_8t
* Cell Name:    INVX32
* View Name:    schematic
************************************************************************

.SUBCKT INVX32 A VDD VNW VPW VSS Y
*.PININFO A:I Y:O VDD:B VNW:B VPW:B VSS:B
MN6 Y A VSS VPW sg13_lv_nmos m=1 w=10.32u l=130.00n ng=12
MP1 Y A VDD VNW sg13_lv_pmos m=1 w=15.84u l=130.00n ng=12
.ENDS

************************************************************************
* Library Name: ez130_8t
* Cell Name:    INVX64
* View Name:    schematic
************************************************************************

.SUBCKT INVX64 A VDD VNW VPW VSS Y
*.PININFO A:I Y:O VDD:B VNW:B VPW:B VSS:B
MN6 Y A VSS VPW sg13_lv_nmos m=1 w=20.64u l=130.00n ng=24
MP1 Y A VDD VNW sg13_lv_pmos m=1 w=31.68u l=130.00n ng=24
.ENDS

************************************************************************
* Library Name: ez130_8t
* Cell Name:    LATNRX1
* View Name:    schematic
************************************************************************

.SUBCKT LATNRX1 CK D Q RB VDD VNW VPW VSS QB
*.PININFO CK:I D:I RB:I Q:O QB:O VDD:B VNW:B VPW:B VSS:B
MP17 Q EDB VDD VNW sg13_lv_pmos m=1 w=480.00n l=130.00n ng=1
MP16 QB net9 VDD VNW sg13_lv_pmos m=1 w=480.00n l=130.00n ng=1
MP10 net9 EDB VDD VNW sg13_lv_pmos m=1 w=480.00n l=130.00n ng=1
MP9 EDB RB VDD VNW sg13_lv_pmos m=1 w=480.00n l=130.00n ng=1
MP8 EDB CKNEG net6 VNW sg13_lv_pmos m=1 w=480.00n l=130.00n ng=1
MP7 net6 net9 VDD VNW sg13_lv_pmos m=1 w=480.00n l=130.00n ng=1
MP5 CKPOS CKNEG VDD VNW sg13_lv_pmos m=1 w=980.00n l=130.00n ng=1
MP4 CKNEG CK VDD VNW sg13_lv_pmos m=1 w=480.00n l=130.00n ng=1
MP1 net12 CKPOS VDD VNW sg13_lv_pmos m=1 w=480.00n l=130.00n ng=1
MP18 EDB D net12 VNW sg13_lv_pmos m=1 w=480.00n l=130.00n ng=1
MN17 net20 RB VSS VPW sg13_lv_nmos m=1 w=300.0n l=130.00n ng=1
MN15 Q EDB VSS VPW sg13_lv_nmos m=1 w=300.0n l=130.00n ng=1
MN14 QB net9 VSS VPW sg13_lv_nmos m=1 w=300.0n l=130.00n ng=1
MN7 net9 EDB VSS VPW sg13_lv_nmos m=1 w=300.0n l=130.00n ng=1
MN6 net7 RB VSS VPW sg13_lv_nmos m=1 w=300.0n l=130.00n ng=1
MN5 net8 net9 net7 VPW sg13_lv_nmos m=1 w=300.0n l=130.00n ng=1
MN4 EDB CKPOS net8 VPW sg13_lv_nmos m=1 w=300.0n l=130.00n ng=1
MN2 CKPOS CKNEG VSS VPW sg13_lv_nmos m=1 w=640.00n l=130.00n ng=1
MN1 CKNEG CK VSS VPW sg13_lv_nmos m=1 w=300.0n l=130.00n ng=1
MN16 EDB CKNEG net21 VPW sg13_lv_nmos m=1 w=300.0n l=130.00n ng=1
MP2 net21 D net20 VPW sg13_lv_nmos m=1 w=300.0n l=130.00n ng=1
.ENDS

************************************************************************
* Library Name: ez130_8t
* Cell Name:    LATNRX1P5
* View Name:    schematic
************************************************************************

.SUBCKT LATNRX1P5 CK D Q RB VDD VNW VPW VSS QB
*.PININFO CK:I D:I RB:I Q:O QB:O VDD:B VNW:B VPW:B VSS:B
MP17 Q EDB VDD VNW sg13_lv_pmos m=1 w=720.00n l=130.00n ng=1
MP16 QB net9 VDD VNW sg13_lv_pmos m=1 w=720.00n l=130.00n ng=1
MP10 net9 EDB VDD VNW sg13_lv_pmos m=1 w=480.00n l=130.00n ng=1
MP9 EDB RB VDD VNW sg13_lv_pmos m=1 w=480.00n l=130.00n ng=1
MP8 EDB CKNEG net6 VNW sg13_lv_pmos m=1 w=480.00n l=130.00n ng=1
MP7 net6 net9 VDD VNW sg13_lv_pmos m=1 w=480.00n l=130.00n ng=1
MP5 CKPOS CKNEG VDD VNW sg13_lv_pmos m=1 w=980.00n l=130.00n ng=1
MP4 CKNEG CK VDD VNW sg13_lv_pmos m=1 w=480.00n l=130.00n ng=1
MP1 net12 CKPOS VDD VNW sg13_lv_pmos m=1 w=480.00n l=130.00n ng=1
MP18 EDB D net12 VNW sg13_lv_pmos m=1 w=480.00n l=130.00n ng=1
MN17 net20 RB VSS VPW sg13_lv_nmos m=1 w=300.0n l=130.00n ng=1
MN15 Q EDB VSS VPW sg13_lv_nmos m=1 w=480.00n l=130.00n ng=1
MN14 QB net9 VSS VPW sg13_lv_nmos m=1 w=480.00n l=130.00n ng=1
MN7 net9 EDB VSS VPW sg13_lv_nmos m=1 w=300.0n l=130.00n ng=1
MN6 net7 RB VSS VPW sg13_lv_nmos m=1 w=300.0n l=130.00n ng=1
MN5 net8 net9 net7 VPW sg13_lv_nmos m=1 w=300.0n l=130.00n ng=1
MN4 EDB CKPOS net8 VPW sg13_lv_nmos m=1 w=300.0n l=130.00n ng=1
MN2 CKPOS CKNEG VSS VPW sg13_lv_nmos m=1 w=640.00n l=130.00n ng=1
MN1 CKNEG CK VSS VPW sg13_lv_nmos m=1 w=300.0n l=130.00n ng=1
MN16 EDB CKNEG net21 VPW sg13_lv_nmos m=1 w=300.0n l=130.00n ng=1
MP2 net21 D net20 VPW sg13_lv_nmos m=1 w=300.0n l=130.00n ng=1
.ENDS

************************************************************************
* Library Name: ez130_8t
* Cell Name:    LATNRX2
* View Name:    schematic
************************************************************************

.SUBCKT LATNRX2 CK D Q RB VDD VNW VPW VSS QB
*.PININFO CK:I D:I RB:I Q:O QB:O VDD:B VNW:B VPW:B VSS:B
MP17 Q EDB VDD VNW sg13_lv_pmos m=1 w=980.00n l=130.00n ng=1
MP16 QB net9 VDD VNW sg13_lv_pmos m=1 w=980.00n l=130.00n ng=1
MP10 net9 EDB VDD VNW sg13_lv_pmos m=1 w=480.00n l=130.00n ng=1
MP9 EDB RB VDD VNW sg13_lv_pmos m=1 w=480.00n l=130.00n ng=1
MP8 EDB CKNEG net6 VNW sg13_lv_pmos m=1 w=480.00n l=130.00n ng=1
MP7 net6 net9 VDD VNW sg13_lv_pmos m=1 w=480.00n l=130.00n ng=1
MP5 CKPOS CKNEG VDD VNW sg13_lv_pmos m=1 w=980.00n l=130.00n ng=1
MP4 CKNEG CK VDD VNW sg13_lv_pmos m=1 w=480.00n l=130.00n ng=1
MP1 net12 CKPOS VDD VNW sg13_lv_pmos m=1 w=480.00n l=130.00n ng=1
MP18 EDB D net12 VNW sg13_lv_pmos m=1 w=480.00n l=130.00n ng=1
MN17 net20 RB VSS VPW sg13_lv_nmos m=1 w=300.0n l=130.00n ng=1
MN15 Q EDB VSS VPW sg13_lv_nmos m=1 w=640.00n l=130.00n ng=1
MN14 QB net9 VSS VPW sg13_lv_nmos m=1 w=640.00n l=130.00n ng=1
MN7 net9 EDB VSS VPW sg13_lv_nmos m=1 w=300.0n l=130.00n ng=1
MN6 net7 RB VSS VPW sg13_lv_nmos m=1 w=300.0n l=130.00n ng=1
MN5 net8 net9 net7 VPW sg13_lv_nmos m=1 w=300.0n l=130.00n ng=1
MN4 EDB CKPOS net8 VPW sg13_lv_nmos m=1 w=300.0n l=130.00n ng=1
MN2 CKPOS CKNEG VSS VPW sg13_lv_nmos m=1 w=640.00n l=130.00n ng=1
MN1 CKNEG CK VSS VPW sg13_lv_nmos m=1 w=300.0n l=130.00n ng=1
MN16 EDB CKNEG net21 VPW sg13_lv_nmos m=1 w=300.0n l=130.00n ng=1
MP2 net21 D net20 VPW sg13_lv_nmos m=1 w=300.0n l=130.00n ng=1
.ENDS

************************************************************************
* Library Name: ez130_8t
* Cell Name:    LATNRX3
* View Name:    schematic
************************************************************************

.SUBCKT LATNRX3 CK D Q RB VDD VNW VPW VSS QB
*.PININFO CK:I D:I RB:I Q:O QB:O VDD:B VNW:B VPW:B VSS:B
MP17 Q EDB VDD VNW sg13_lv_pmos m=1 w=1.32u l=130.00n ng=1
MP16 QB net9 VDD VNW sg13_lv_pmos m=1 w=1.32u l=130.00n ng=1
MP10 net9 EDB VDD VNW sg13_lv_pmos m=1 w=480.00n l=130.00n ng=1
MP9 EDB RB VDD VNW sg13_lv_pmos m=1 w=480.00n l=130.00n ng=1
MP8 EDB CKNEG net6 VNW sg13_lv_pmos m=1 w=480.00n l=130.00n ng=1
MP7 net6 net9 VDD VNW sg13_lv_pmos m=1 w=480.00n l=130.00n ng=1
MP5 CKPOS CKNEG VDD VNW sg13_lv_pmos m=1 w=980.00n l=130.00n ng=1
MP4 CKNEG CK VDD VNW sg13_lv_pmos m=1 w=480.00n l=130.00n ng=1
MP1 net12 CKPOS VDD VNW sg13_lv_pmos m=1 w=480.00n l=130.00n ng=1
MP18 EDB D net12 VNW sg13_lv_pmos m=1 w=480.00n l=130.00n ng=1
MN17 net20 RB VSS VPW sg13_lv_nmos m=1 w=300.0n l=130.00n ng=1
MN15 Q EDB VSS VPW sg13_lv_nmos m=1 w=860.00n l=130.00n ng=1
MN14 QB net9 VSS VPW sg13_lv_nmos m=1 w=860.00n l=130.00n ng=1
MN7 net9 EDB VSS VPW sg13_lv_nmos m=1 w=300.0n l=130.00n ng=1
MN6 net7 RB VSS VPW sg13_lv_nmos m=1 w=300.0n l=130.00n ng=1
MN5 net8 net9 net7 VPW sg13_lv_nmos m=1 w=300.0n l=130.00n ng=1
MN4 EDB CKPOS net8 VPW sg13_lv_nmos m=1 w=300.0n l=130.00n ng=1
MN2 CKPOS CKNEG VSS VPW sg13_lv_nmos m=1 w=640.00n l=130.00n ng=1
MN1 CKNEG CK VSS VPW sg13_lv_nmos m=1 w=300.0n l=130.00n ng=1
MN16 EDB CKNEG net21 VPW sg13_lv_nmos m=1 w=300.0n l=130.00n ng=1
MP2 net21 D net20 VPW sg13_lv_nmos m=1 w=300.0n l=130.00n ng=1
.ENDS

************************************************************************
* Library Name: ez130_8t
* Cell Name:    LATNQX1
* View Name:    schematic
************************************************************************

.SUBCKT LATNQX1 CK D Q VDD VNW VPW VSS
*.PININFO CK:I D:I Q:O VDD:B VNW:B VPW:B VSS:B
MN8 Q net17 VSS VPW sg13_lv_nmos m=1 w=300.0n l=130.00n ng=1
MN7 net17 net1 VSS VPW sg13_lv_nmos m=1 w=300.0n l=130.00n ng=1
MN5 net16 net17 VSS VPW sg13_lv_nmos m=1 w=300.0n l=130.00n ng=1
MN4 net1 CKPOS net16 VPW sg13_lv_nmos m=1 w=300.0n l=130.00n ng=1
MN3 net20 DB VSS VPW sg13_lv_nmos m=1 w=300.0n l=130.00n ng=1
MN0 net1 CKNEG net20 VPW sg13_lv_nmos m=1 w=300.0n l=130.00n ng=1
MN2 CKPOS CKNEG VSS VPW sg13_lv_nmos m=1 w=640.00n l=130.00n ng=1
MN1 CKNEG CK VSS VPW sg13_lv_nmos m=1 w=300.0n l=130.00n ng=1
MP2 DB D VSS VPW sg13_lv_nmos m=1 w=300.0n l=130.00n ng=1
MP10 Q net17 VDD VNW sg13_lv_pmos m=1 w=480.00n l=130.00n ng=1
MP9 net17 net1 VDD VNW sg13_lv_pmos m=1 w=480.00n l=130.00n ng=1
MP7 net1 CKNEG net15 VNW sg13_lv_pmos m=1 w=480.00n l=130.00n ng=1
MP6 net15 net17 VDD VNW sg13_lv_pmos m=1 w=480.00n l=130.00n ng=1
MP3 net1 CKPOS net19 VNW sg13_lv_pmos m=1 w=480.00n l=130.00n ng=1
MP0 net19 DB VDD VNW sg13_lv_pmos m=1 w=480.00n l=130.00n ng=1
MP5 CKPOS CKNEG VDD VNW sg13_lv_pmos m=1 w=980.00n l=130.00n ng=1
MP4 CKNEG CK VDD VNW sg13_lv_pmos m=1 w=480.00n l=130.00n ng=1
MP1 DB D VDD VNW sg13_lv_pmos m=1 w=480.00n l=130.00n ng=1
.ENDS

************************************************************************
* Library Name: ez130_8t
* Cell Name:    LATNQX2
* View Name:    schematic
************************************************************************

.SUBCKT LATNQX2 CK D Q VDD VNW VPW VSS
*.PININFO CK:I D:I Q:O VDD:B VNW:B VPW:B VSS:B
MN8 Q net17 VSS VPW sg13_lv_nmos m=1 w=640.00n l=130.00n ng=1
MN7 net17 net1 VSS VPW sg13_lv_nmos m=1 w=300.0n l=130.00n ng=1
MN5 net16 net17 VSS VPW sg13_lv_nmos m=1 w=300.0n l=130.00n ng=1
MN11 net1 CKPOS net16 VPW sg13_lv_nmos m=1 w=300.0n l=130.00n ng=1
MN3 net20 DB VSS VPW sg13_lv_nmos m=1 w=300.0n l=130.00n ng=1
MN12 net1 CKNEG net20 VPW sg13_lv_nmos m=1 w=300.0n l=130.00n ng=1
MN2 CKPOS CKNEG VSS VPW sg13_lv_nmos m=1 w=640.00n l=130.00n ng=1
MN1 CKNEG CK VSS VPW sg13_lv_nmos m=1 w=300.0n l=130.00n ng=1
MP2 DB D VSS VPW sg13_lv_nmos m=1 w=300.0n l=130.00n ng=1
MP13 net1 CKNEG net15 VNW sg13_lv_pmos m=1 w=480.00n l=130.00n ng=1
MP10 Q net17 VDD VNW sg13_lv_pmos m=1 w=980.00n l=130.00n ng=1
MP9 net17 net1 VDD VNW sg13_lv_pmos m=1 w=480.00n l=130.00n ng=1
MP6 net15 net17 VDD VNW sg13_lv_pmos m=1 w=480.00n l=130.00n ng=1
MP14 net1 CKPOS net19 VNW sg13_lv_pmos m=1 w=480.00n l=130.00n ng=1
MP0 net19 DB VDD VNW sg13_lv_pmos m=1 w=480.00n l=130.00n ng=1
MP5 CKPOS CKNEG VDD VNW sg13_lv_pmos m=1 w=980.00n l=130.00n ng=1
MP4 CKNEG CK VDD VNW sg13_lv_pmos m=1 w=480.00n l=130.00n ng=1
MP1 DB D VDD VNW sg13_lv_pmos m=1 w=480.00n l=130.00n ng=1
.ENDS

************************************************************************
* Library Name: ez130_8t
* Cell Name:    LATNQX3
* View Name:    schematic
************************************************************************

.SUBCKT LATNQX3 CK D Q VDD VNW VPW VSS
*.PININFO CK:I D:I Q:O VDD:B VNW:B VPW:B VSS:B
MN8 Q net17 VSS VPW sg13_lv_nmos m=1 w=860.00n l=130.00n ng=1
MN7 net17 net1 VSS VPW sg13_lv_nmos m=1 w=300.0n l=130.00n ng=1
MN5 net16 net17 VSS VPW sg13_lv_nmos m=1 w=300.0n l=130.00n ng=1
MN4 net1 CKPOS net16 VPW sg13_lv_nmos m=1 w=300.0n l=130.00n ng=1
MN3 net20 DB VSS VPW sg13_lv_nmos m=1 w=300.0n l=130.00n ng=1
MN0 net1 CKNEG net20 VPW sg13_lv_nmos m=1 w=300.0n l=130.00n ng=1
MN2 CKPOS CKNEG VSS VPW sg13_lv_nmos m=1 w=640.00n l=130.00n ng=1
MN1 CKNEG CK VSS VPW sg13_lv_nmos m=1 w=300.0n l=130.00n ng=1
MP2 DB D VSS VPW sg13_lv_nmos m=1 w=300.0n l=130.00n ng=1
MP10 Q net17 VDD VNW sg13_lv_pmos m=1 w=1.32u l=130.00n ng=1
MP9 net17 net1 VDD VNW sg13_lv_pmos m=1 w=480.00n l=130.00n ng=1
MP7 net1 CKNEG net15 VNW sg13_lv_pmos m=1 w=480.00n l=130.00n ng=1
MP6 net15 net17 VDD VNW sg13_lv_pmos m=1 w=480.00n l=130.00n ng=1
MP3 net1 CKPOS net19 VNW sg13_lv_pmos m=1 w=480.00n l=130.00n ng=1
MP0 net19 DB VDD VNW sg13_lv_pmos m=1 w=480.00n l=130.00n ng=1
MP5 CKPOS CKNEG VDD VNW sg13_lv_pmos m=1 w=980.00n l=130.00n ng=1
MP4 CKNEG CK VDD VNW sg13_lv_pmos m=1 w=480.00n l=130.00n ng=1
MP1 DB D VDD VNW sg13_lv_pmos m=1 w=480.00n l=130.00n ng=1
.ENDS

************************************************************************
* Library Name: ez130_8t
* Cell Name:    LATRX1
* View Name:    schematic
************************************************************************

.SUBCKT LATRX1 CK D Q RB VDD VNW VPW VSS QB
*.PININFO CK:I D:I RB:I Q:O QB:O VDD:B VNW:B VPW:B VSS:B
MP17 Q EDB VDD VNW sg13_lv_pmos m=1 w=480.00n l=130.00n ng=1
MP16 QB net9 VDD VNW sg13_lv_pmos m=1 w=480.00n l=130.00n ng=1
MP10 net9 EDB VDD VNW sg13_lv_pmos m=1 w=480.00n l=130.00n ng=1
MP9 EDB RB VDD VNW sg13_lv_pmos m=1 w=480.00n l=130.00n ng=1
MP8 EDB CKPOS net6 VNW sg13_lv_pmos m=1 w=480.00n l=130.00n ng=1
MP7 net6 net9 VDD VNW sg13_lv_pmos m=1 w=480.00n l=130.00n ng=1
MP5 CKPOS CKNEG VDD VNW sg13_lv_pmos m=1 w=980.00n l=130.00n ng=1
MP4 CKNEG CK VDD VNW sg13_lv_pmos m=1 w=480.00n l=130.00n ng=1
MP1 net12 CKNEG VDD VNW sg13_lv_pmos m=1 w=480.00n l=130.00n ng=1
MP18 EDB D net12 VNW sg13_lv_pmos m=1 w=480.00n l=130.00n ng=1
MN17 net20 RB VSS VPW sg13_lv_nmos m=1 w=300.0n l=130.00n ng=1
MN15 Q EDB VSS VPW sg13_lv_nmos m=1 w=300.0n l=130.00n ng=1
MN14 QB net9 VSS VPW sg13_lv_nmos m=1 w=300.0n l=130.00n ng=1
MN7 net9 EDB VSS VPW sg13_lv_nmos m=1 w=300.0n l=130.00n ng=1
MN6 net7 RB VSS VPW sg13_lv_nmos m=1 w=300.0n l=130.00n ng=1
MN5 net8 net9 net7 VPW sg13_lv_nmos m=1 w=300.0n l=130.00n ng=1
MN4 EDB CKNEG net8 VPW sg13_lv_nmos m=1 w=300.0n l=130.00n ng=1
MN2 CKPOS CKNEG VSS VPW sg13_lv_nmos m=1 w=640.00n l=130.00n ng=1
MN1 CKNEG CK VSS VPW sg13_lv_nmos m=1 w=300.0n l=130.00n ng=1
MN16 EDB CKPOS net21 VPW sg13_lv_nmos m=1 w=300.0n l=130.00n ng=1
MP2 net21 D net20 VPW sg13_lv_nmos m=1 w=300.0n l=130.00n ng=1
.ENDS

************************************************************************
* Library Name: ez130_8t
* Cell Name:    LATRX1P5
* View Name:    schematic
************************************************************************

.SUBCKT LATRX1P5 CK D Q RB VDD VNW VPW VSS QB
*.PININFO CK:I D:I RB:I Q:O QB:O VDD:B VNW:B VPW:B VSS:B
MP17 Q EDB VDD VNW sg13_lv_pmos m=1 w=720.00n l=130.00n ng=1
MP16 QB net9 VDD VNW sg13_lv_pmos m=1 w=720.00n l=130.00n ng=1
MP10 net9 EDB VDD VNW sg13_lv_pmos m=1 w=480.00n l=130.00n ng=1
MP9 EDB RB VDD VNW sg13_lv_pmos m=1 w=480.00n l=130.00n ng=1
MP8 EDB CKPOS net6 VNW sg13_lv_pmos m=1 w=480.00n l=130.00n ng=1
MP7 net6 net9 VDD VNW sg13_lv_pmos m=1 w=480.00n l=130.00n ng=1
MP5 CKPOS CKNEG VDD VNW sg13_lv_pmos m=1 w=980.00n l=130.00n ng=1
MP4 CKNEG CK VDD VNW sg13_lv_pmos m=1 w=480.00n l=130.00n ng=1
MP1 net12 CKNEG VDD VNW sg13_lv_pmos m=1 w=480.00n l=130.00n ng=1
MP18 EDB D net12 VNW sg13_lv_pmos m=1 w=480.00n l=130.00n ng=1
MN17 net20 RB VSS VPW sg13_lv_nmos m=1 w=300.0n l=130.00n ng=1
MN15 Q EDB VSS VPW sg13_lv_nmos m=1 w=480.00n l=130.00n ng=1
MN14 QB net9 VSS VPW sg13_lv_nmos m=1 w=480.00n l=130.00n ng=1
MN7 net9 EDB VSS VPW sg13_lv_nmos m=1 w=300.0n l=130.00n ng=1
MN6 net7 RB VSS VPW sg13_lv_nmos m=1 w=300.0n l=130.00n ng=1
MN5 net8 net9 net7 VPW sg13_lv_nmos m=1 w=300.0n l=130.00n ng=1
MN4 EDB CKNEG net8 VPW sg13_lv_nmos m=1 w=300.0n l=130.00n ng=1
MN2 CKPOS CKNEG VSS VPW sg13_lv_nmos m=1 w=640.00n l=130.00n ng=1
MN1 CKNEG CK VSS VPW sg13_lv_nmos m=1 w=300.0n l=130.00n ng=1
MN16 EDB CKPOS net21 VPW sg13_lv_nmos m=1 w=300.0n l=130.00n ng=1
MP2 net21 D net20 VPW sg13_lv_nmos m=1 w=300.0n l=130.00n ng=1
.ENDS

************************************************************************
* Library Name: ez130_8t
* Cell Name:    LATRX2
* View Name:    schematic
************************************************************************

.SUBCKT LATRX2 CK D Q RB VDD VNW VPW VSS QB
*.PININFO CK:I D:I RB:I Q:O QB:O VDD:B VNW:B VPW:B VSS:B
MP17 Q EDB VDD VNW sg13_lv_pmos m=1 w=980.00n l=130.00n ng=1
MP16 QB net9 VDD VNW sg13_lv_pmos m=1 w=980.00n l=130.00n ng=1
MP10 net9 EDB VDD VNW sg13_lv_pmos m=1 w=480.00n l=130.00n ng=1
MP9 EDB RB VDD VNW sg13_lv_pmos m=1 w=480.00n l=130.00n ng=1
MP8 EDB CKPOS net6 VNW sg13_lv_pmos m=1 w=480.00n l=130.00n ng=1
MP7 net6 net9 VDD VNW sg13_lv_pmos m=1 w=480.00n l=130.00n ng=1
MP5 CKPOS CKNEG VDD VNW sg13_lv_pmos m=1 w=980.00n l=130.00n ng=1
MP4 CKNEG CK VDD VNW sg13_lv_pmos m=1 w=480.00n l=130.00n ng=1
MP1 net12 CKNEG VDD VNW sg13_lv_pmos m=1 w=480.00n l=130.00n ng=1
MP18 EDB D net12 VNW sg13_lv_pmos m=1 w=480.00n l=130.00n ng=1
MN17 net20 RB VSS VPW sg13_lv_nmos m=1 w=300.0n l=130.00n ng=1
MN15 Q EDB VSS VPW sg13_lv_nmos m=1 w=640.00n l=130.00n ng=1
MN14 QB net9 VSS VPW sg13_lv_nmos m=1 w=640.00n l=130.00n ng=1
MN7 net9 EDB VSS VPW sg13_lv_nmos m=1 w=300.0n l=130.00n ng=1
MN6 net7 RB VSS VPW sg13_lv_nmos m=1 w=300.0n l=130.00n ng=1
MN5 net8 net9 net7 VPW sg13_lv_nmos m=1 w=300.0n l=130.00n ng=1
MN4 EDB CKNEG net8 VPW sg13_lv_nmos m=1 w=300.0n l=130.00n ng=1
MN2 CKPOS CKNEG VSS VPW sg13_lv_nmos m=1 w=640.00n l=130.00n ng=1
MN1 CKNEG CK VSS VPW sg13_lv_nmos m=1 w=300.0n l=130.00n ng=1
MN16 EDB CKPOS net21 VPW sg13_lv_nmos m=1 w=300.0n l=130.00n ng=1
MP2 net21 D net20 VPW sg13_lv_nmos m=1 w=300.0n l=130.00n ng=1
.ENDS

************************************************************************
* Library Name: ez130_8t
* Cell Name:    LATRX3
* View Name:    schematic
************************************************************************

.SUBCKT LATRX3 CK D Q RB VDD VNW VPW VSS QB
*.PININFO CK:I D:I RB:I Q:O QB:O VDD:B VNW:B VPW:B VSS:B
MP17 Q EDB VDD VNW sg13_lv_pmos m=1 w=1.32u l=130.00n ng=1
MP16 QB net9 VDD VNW sg13_lv_pmos m=1 w=1.32u l=130.00n ng=1
MP10 net9 EDB VDD VNW sg13_lv_pmos m=1 w=480.00n l=130.00n ng=1
MP9 EDB RB VDD VNW sg13_lv_pmos m=1 w=480.00n l=130.00n ng=1
MP8 EDB CKPOS net6 VNW sg13_lv_pmos m=1 w=480.00n l=130.00n ng=1
MP7 net6 net9 VDD VNW sg13_lv_pmos m=1 w=480.00n l=130.00n ng=1
MP5 CKPOS CKNEG VDD VNW sg13_lv_pmos m=1 w=980.00n l=130.00n ng=1
MP4 CKNEG CK VDD VNW sg13_lv_pmos m=1 w=480.00n l=130.00n ng=1
MP1 net12 CKNEG VDD VNW sg13_lv_pmos m=1 w=480.00n l=130.00n ng=1
MP18 EDB D net12 VNW sg13_lv_pmos m=1 w=480.00n l=130.00n ng=1
MN17 net20 RB VSS VPW sg13_lv_nmos m=1 w=300.0n l=130.00n ng=1
MN15 Q EDB VSS VPW sg13_lv_nmos m=1 w=860.00n l=130.00n ng=1
MN14 QB net9 VSS VPW sg13_lv_nmos m=1 w=860.00n l=130.00n ng=1
MN7 net9 EDB VSS VPW sg13_lv_nmos m=1 w=300.0n l=130.00n ng=1
MN6 net7 RB VSS VPW sg13_lv_nmos m=1 w=300.0n l=130.00n ng=1
MN5 net8 net9 net7 VPW sg13_lv_nmos m=1 w=300.0n l=130.00n ng=1
MN4 EDB CKNEG net8 VPW sg13_lv_nmos m=1 w=300.0n l=130.00n ng=1
MN2 CKPOS CKNEG VSS VPW sg13_lv_nmos m=1 w=640.00n l=130.00n ng=1
MN1 CKNEG CK VSS VPW sg13_lv_nmos m=1 w=300.0n l=130.00n ng=1
MN16 EDB CKPOS net21 VPW sg13_lv_nmos m=1 w=300.0n l=130.00n ng=1
MP2 net21 D net20 VPW sg13_lv_nmos m=1 w=300.0n l=130.00n ng=1
.ENDS

************************************************************************
* Library Name: ez130_8t
* Cell Name:    LATQX1
* View Name:    schematic
************************************************************************

.SUBCKT LATQX1 CK D Q VDD VNW VPW VSS
*.PININFO CK:I D:I Q:O VDD:B VNW:B VPW:B VSS:B
MN8 Q net17 VSS VPW sg13_lv_nmos m=1 w=300.0n l=130.00n ng=1
MN7 net17 net1 VSS VPW sg13_lv_nmos m=1 w=300.0n l=130.00n ng=1
MN5 net16 net17 VSS VPW sg13_lv_nmos m=1 w=300.0n l=130.00n ng=1
MN4 net1 CKNEG net16 VPW sg13_lv_nmos m=1 w=300.0n l=130.00n ng=1
MN3 net20 DB VSS VPW sg13_lv_nmos m=1 w=300.0n l=130.00n ng=1
MN0 net1 CKPOS net20 VPW sg13_lv_nmos m=1 w=300.0n l=130.00n ng=1
MN2 CKPOS CKNEG VSS VPW sg13_lv_nmos m=1 w=640.00n l=130.00n ng=1
MN1 CKNEG CK VSS VPW sg13_lv_nmos m=1 w=300.0n l=130.00n ng=1
MP2 DB D VSS VPW sg13_lv_nmos m=1 w=300.0n l=130.00n ng=1
MP10 Q net17 VDD VNW sg13_lv_pmos m=1 w=480.00n l=130.00n ng=1
MP9 net17 net1 VDD VNW sg13_lv_pmos m=1 w=480.00n l=130.00n ng=1
MP7 net1 CKPOS net15 VNW sg13_lv_pmos m=1 w=480.00n l=130.00n ng=1
MP6 net15 net17 VDD VNW sg13_lv_pmos m=1 w=480.00n l=130.00n ng=1
MP3 net1 CKNEG net19 VNW sg13_lv_pmos m=1 w=480.00n l=130.00n ng=1
MP0 net19 DB VDD VNW sg13_lv_pmos m=1 w=480.00n l=130.00n ng=1
MP5 CKPOS CKNEG VDD VNW sg13_lv_pmos m=1 w=980.00n l=130.00n ng=1
MP4 CKNEG CK VDD VNW sg13_lv_pmos m=1 w=480.00n l=130.00n ng=1
MP1 DB D VDD VNW sg13_lv_pmos m=1 w=480.00n l=130.00n ng=1
.ENDS

************************************************************************
* Library Name: ez130_8t
* Cell Name:    LATQX2
* View Name:    schematic
************************************************************************

.SUBCKT LATQX2 CK D Q VDD VNW VPW VSS
*.PININFO CK:I D:I Q:O VDD:B VNW:B VPW:B VSS:B
MN8 Q net17 VSS VPW sg13_lv_nmos m=1 w=640.00n l=130.00n ng=1
MN7 net17 net1 VSS VPW sg13_lv_nmos m=1 w=300.0n l=130.00n ng=1
MN5 net16 net17 VSS VPW sg13_lv_nmos m=1 w=300.0n l=130.00n ng=1
MN4 net1 CKNEG net16 VPW sg13_lv_nmos m=1 w=300.0n l=130.00n ng=1
MN3 net20 DB VSS VPW sg13_lv_nmos m=1 w=300.0n l=130.00n ng=1
MN0 net1 CKPOS net20 VPW sg13_lv_nmos m=1 w=300.0n l=130.00n ng=1
MN2 CKPOS CKNEG VSS VPW sg13_lv_nmos m=1 w=640.00n l=130.00n ng=1
MN1 CKNEG CK VSS VPW sg13_lv_nmos m=1 w=300.0n l=130.00n ng=1
MP2 DB D VSS VPW sg13_lv_nmos m=1 w=300.0n l=130.00n ng=1
MP10 Q net17 VDD VNW sg13_lv_pmos m=1 w=980.00n l=130.00n ng=1
MP9 net17 net1 VDD VNW sg13_lv_pmos m=1 w=480.00n l=130.00n ng=1
MP7 net1 CKPOS net15 VNW sg13_lv_pmos m=1 w=480.00n l=130.00n ng=1
MP6 net15 net17 VDD VNW sg13_lv_pmos m=1 w=480.00n l=130.00n ng=1
MP3 net1 CKNEG net19 VNW sg13_lv_pmos m=1 w=480.00n l=130.00n ng=1
MP0 net19 DB VDD VNW sg13_lv_pmos m=1 w=480.00n l=130.00n ng=1
MP5 CKPOS CKNEG VDD VNW sg13_lv_pmos m=1 w=980.00n l=130.00n ng=1
MP4 CKNEG CK VDD VNW sg13_lv_pmos m=1 w=480.00n l=130.00n ng=1
MP1 DB D VDD VNW sg13_lv_pmos m=1 w=480.00n l=130.00n ng=1
.ENDS

************************************************************************
* Library Name: ez130_8t
* Cell Name:    LATQX3
* View Name:    schematic
************************************************************************

.SUBCKT LATQX3 CK D Q VDD VNW VPW VSS
*.PININFO CK:I D:I Q:O VDD:B VNW:B VPW:B VSS:B
MN8 Q net17 VSS VPW sg13_lv_nmos m=1 w=860.00n l=130.00n ng=1
MN7 net17 net1 VSS VPW sg13_lv_nmos m=1 w=300.0n l=130.00n ng=1
MN5 net16 net17 VSS VPW sg13_lv_nmos m=1 w=300.0n l=130.00n ng=1
MN4 net1 CKNEG net16 VPW sg13_lv_nmos m=1 w=300.0n l=130.00n ng=1
MN3 net20 DB VSS VPW sg13_lv_nmos m=1 w=300.0n l=130.00n ng=1
MN0 net1 CKPOS net20 VPW sg13_lv_nmos m=1 w=300.0n l=130.00n ng=1
MN2 CKPOS CKNEG VSS VPW sg13_lv_nmos m=1 w=640.00n l=130.00n ng=1
MN1 CKNEG CK VSS VPW sg13_lv_nmos m=1 w=300.0n l=130.00n ng=1
MP2 DB D VSS VPW sg13_lv_nmos m=1 w=300.0n l=130.00n ng=1
MP10 Q net17 VDD VNW sg13_lv_pmos m=1 w=1.32u l=130.00n ng=1
MP9 net17 net1 VDD VNW sg13_lv_pmos m=1 w=480.00n l=130.00n ng=1
MP7 net1 CKPOS net15 VNW sg13_lv_pmos m=1 w=480.00n l=130.00n ng=1
MP6 net15 net17 VDD VNW sg13_lv_pmos m=1 w=480.00n l=130.00n ng=1
MP3 net1 CKNEG net19 VNW sg13_lv_pmos m=1 w=480.00n l=130.00n ng=1
MP0 net19 DB VDD VNW sg13_lv_pmos m=1 w=480.00n l=130.00n ng=1
MP5 CKPOS CKNEG VDD VNW sg13_lv_pmos m=1 w=980.00n l=130.00n ng=1
MP4 CKNEG CK VDD VNW sg13_lv_pmos m=1 w=480.00n l=130.00n ng=1
MP1 DB D VDD VNW sg13_lv_pmos m=1 w=480.00n l=130.00n ng=1
.ENDS

************************************************************************
* Library Name: ez130_8t
* Cell Name:    MIN3X1
* View Name:    schematic
************************************************************************

.SUBCKT MIN3X1 A B C VDD VNW VPW VSS Y
*.PININFO A:I B:I C:I Y:O VDD:B VNW:B VPW:B VSS:B
MP4 net4 A VDD VNW sg13_lv_pmos m=1 w=480.00n l=130.00n ng=1
MP3 net4 B VDD VNW sg13_lv_pmos m=1 w=480.00n l=130.00n ng=1
MP2 Y C net4 VNW sg13_lv_pmos m=1 w=480.00n l=130.00n ng=1
MP1 Y A net1 VNW sg13_lv_pmos m=1 w=480.00n l=130.00n ng=1
MP0 net1 B VDD VNW sg13_lv_pmos m=1 w=480.00n l=130.00n ng=1
MN4 Y A net2 VPW sg13_lv_nmos m=1 w=300.0n l=130.00n ng=1
MN3 net2 B VSS VPW sg13_lv_nmos m=1 w=300.0n l=130.00n ng=1
MN2 Y C net3 VPW sg13_lv_nmos m=1 w=300.0n l=130.00n ng=1
MN1 net3 A VSS VPW sg13_lv_nmos m=1 w=300.0n l=130.00n ng=1
MN0 net3 B VSS VPW sg13_lv_nmos m=1 w=300.0n l=130.00n ng=1
.ENDS

************************************************************************
* Library Name: ez130_8t
* Cell Name:    MIN3X1P5
* View Name:    schematic
************************************************************************

.SUBCKT MIN3X1P5 A B C VDD VNW VPW VSS Y
*.PININFO A:I B:I C:I Y:O VDD:B VNW:B VPW:B VSS:B
MP4 net4 A VDD VNW sg13_lv_pmos m=1 w=720.00n l=130.00n ng=1
MP3 net4 B VDD VNW sg13_lv_pmos m=1 w=720.00n l=130.00n ng=1
MP2 Y C net4 VNW sg13_lv_pmos m=1 w=720.00n l=130.00n ng=1
MP1 Y A net1 VNW sg13_lv_pmos m=1 w=720.00n l=130.00n ng=1
MP0 net1 B VDD VNW sg13_lv_pmos m=1 w=720.00n l=130.00n ng=1
MN4 Y A net2 VPW sg13_lv_nmos m=1 w=480.00n l=130.00n ng=1
MN3 net2 B VSS VPW sg13_lv_nmos m=1 w=480.00n l=130.00n ng=1
MN2 Y C net3 VPW sg13_lv_nmos m=1 w=480.00n l=130.00n ng=1
MN1 net3 A VSS VPW sg13_lv_nmos m=1 w=480.00n l=130.00n ng=1
MN0 net3 B VSS VPW sg13_lv_nmos m=1 w=480.00n l=130.00n ng=1
.ENDS

************************************************************************
* Library Name: ez130_8t
* Cell Name:    MIN3X2
* View Name:    schematic
************************************************************************

.SUBCKT MIN3X2 A B C VDD VNW VPW VSS Y
*.PININFO A:I B:I C:I Y:O VDD:B VNW:B VPW:B VSS:B
MP4 net4 A VDD VNW sg13_lv_pmos m=1 w=980.00n l=130.00n ng=1
MP3 net4 B VDD VNW sg13_lv_pmos m=1 w=980.00n l=130.00n ng=1
MP2 Y C net4 VNW sg13_lv_pmos m=1 w=980.00n l=130.00n ng=1
MP1 Y A net1 VNW sg13_lv_pmos m=1 w=980.00n l=130.00n ng=1
MP0 net1 B VDD VNW sg13_lv_pmos m=1 w=980.00n l=130.00n ng=1
MN4 Y A net2 VPW sg13_lv_nmos m=1 w=640.00n l=130.00n ng=1
MN3 net2 B VSS VPW sg13_lv_nmos m=1 w=640.00n l=130.00n ng=1
MN2 Y C net3 VPW sg13_lv_nmos m=1 w=600.0n l=130.00n ng=1
MN1 net3 A VSS VPW sg13_lv_nmos m=1 w=640.00n l=130.00n ng=1
MN0 net3 B VSS VPW sg13_lv_nmos m=1 w=640.00n l=130.00n ng=1
.ENDS

************************************************************************
* Library Name: ez130_8t
* Cell Name:    MUX2X1
* View Name:    schematic
************************************************************************

.SUBCKT MUX2X1 A0 A1 S0 VDD VNW VPW VSS Y
*.PININFO A0:I A1:I S0:I Y:O VDD:B VNW:B VPW:B VSS:B
MN8 net29 S0 VSS VPW sg13_lv_nmos m=1 w=300.0n l=130.00n ng=1
MN7 net3 A1 net29 VPW sg13_lv_nmos m=1 w=300.0n l=130.00n ng=1
MN4 net17 S0I VSS VPW sg13_lv_nmos m=1 w=300.0n l=130.00n ng=1
MN3 net3 A0 net17 VPW sg13_lv_nmos m=1 w=300.0n l=130.00n ng=1
MN9 Y net3 VSS VPW sg13_lv_nmos m=1 w=300.0n l=130.00n ng=1
MN0 S0I S0 VSS VPW sg13_lv_nmos m=1 w=300.0n l=130.00n ng=1
MP8 net2 S0I VDD VNW sg13_lv_pmos m=1 w=480.00n l=130.00n ng=1
MP7 net1 S0 VDD VNW sg13_lv_pmos m=1 w=480.00n l=130.00n ng=1
MP4 net3 A0 net1 VNW sg13_lv_pmos m=1 w=480.00n l=130.00n ng=1
MP3 net3 A1 net2 VNW sg13_lv_pmos m=1 w=480.00n l=130.00n ng=1
MP9 Y net3 VDD VNW sg13_lv_pmos m=1 w=480.00n l=130.00n ng=1
MP0 S0I S0 VDD VNW sg13_lv_pmos m=1 w=480.00n l=130.00n ng=1
.ENDS

************************************************************************
* Library Name: ez130_8t
* Cell Name:    MUX2X2
* View Name:    schematic
************************************************************************

.SUBCKT MUX2X2 A0 A1 S0 VDD VNW VPW VSS Y
*.PININFO A0:I A1:I S0:I Y:O VDD:B VNW:B VPW:B VSS:B
MN8 net29 S0 VSS VPW sg13_lv_nmos m=1 w=300.0n l=130.00n ng=1
MN7 net3 A1 net29 VPW sg13_lv_nmos m=1 w=300.0n l=130.00n ng=1
MN4 net17 S0I VSS VPW sg13_lv_nmos m=1 w=300.0n l=130.00n ng=1
MN3 net3 A0 net17 VPW sg13_lv_nmos m=1 w=300.0n l=130.00n ng=1
MN9 Y net3 VSS VPW sg13_lv_nmos m=1 w=640.00n l=130.00n ng=1
MN0 S0I S0 VSS VPW sg13_lv_nmos m=1 w=300.0n l=130.00n ng=1
MP8 net2 S0I VDD VNW sg13_lv_pmos m=1 w=480.00n l=130.00n ng=1
MP7 net1 S0 VDD VNW sg13_lv_pmos m=1 w=480.00n l=130.00n ng=1
MP4 net3 A0 net1 VNW sg13_lv_pmos m=1 w=480.00n l=130.00n ng=1
MP3 net3 A1 net2 VNW sg13_lv_pmos m=1 w=480.00n l=130.00n ng=1
MP9 Y net3 VDD VNW sg13_lv_pmos m=1 w=980.00n l=130.00n ng=1
MP0 S0I S0 VDD VNW sg13_lv_pmos m=1 w=480.00n l=130.00n ng=1
.ENDS

************************************************************************
* Library Name: ez130_8t
* Cell Name:    MUX4X1
* View Name:    schematic
************************************************************************

.SUBCKT MUX4X1 A0 A1 A2 A3 S0 S1 VDD VNW VPW VSS Y
*.PININFO A0:I A1:I A2:I A3:I S0:I S1:I Y:O VDD:B VNW:B VPW:B VSS:B
MN26 net8 A2 VSS VPW sg13_lv_nmos m=1 w=300.0n l=130.00n ng=1
MN25 net7 A3 VSS VPW sg13_lv_nmos m=1 w=300.0n l=130.00n ng=1
MN24 B1 S0B net8 VPW sg13_lv_nmos m=1 w=300.0n l=130.00n ng=1
MN17 B1 S1 net6 VPW sg13_lv_nmos m=1 w=300.0n l=130.00n ng=1
MN16 B0 S1B net6 VPW sg13_lv_nmos m=1 w=300.0n l=130.00n ng=1
MN11 Y net6 VSS VPW sg13_lv_nmos m=1 w=300.0n l=130.00n ng=1
MN23 B1 S0 net7 VPW sg13_lv_nmos m=1 w=300.0n l=130.00n ng=1
MN10 S1B S1 VSS VPW sg13_lv_nmos m=1 w=300.0n l=130.00n ng=1
MN20 B0 S0B net2 VPW sg13_lv_nmos m=1 w=300.0n l=130.00n ng=1
MN22 net3 A1 VSS VPW sg13_lv_nmos m=1 w=300.0n l=130.00n ng=1
MN21 B0 S0 net3 VPW sg13_lv_nmos m=1 w=300.0n l=130.00n ng=1
MN19 net2 A0 VSS VPW sg13_lv_nmos m=1 w=300.0n l=130.00n ng=1
MN0 S0B S0 VSS VPW sg13_lv_nmos m=1 w=300.0n l=130.00n ng=1
MP26 net9 A3 VDD VNW sg13_lv_pmos m=1 w=480.00n l=130.00n ng=1
MP25 B1 S0 net4 VNW sg13_lv_pmos m=1 w=480.00n l=130.00n ng=1
MP24 B1 S0B net9 VNW sg13_lv_pmos m=1 w=480.00n l=130.00n ng=1
MP17 B1 S1B net6 VNW sg13_lv_pmos m=1 w=480.00n l=130.00n ng=1
MP16 B0 S1 net6 VNW sg13_lv_pmos m=1 w=480.00n l=130.00n ng=1
MP21 net5 A1 VDD VNW sg13_lv_pmos m=1 w=480.00n l=130.00n ng=1
MP20 B0 S0 net1 VNW sg13_lv_pmos m=1 w=480.00n l=130.00n ng=1
MP22 B0 S0B net5 VNW sg13_lv_pmos m=1 w=480.00n l=130.00n ng=1
MP23 net4 A2 VDD VNW sg13_lv_pmos m=1 w=480.00n l=130.00n ng=1
MP10 S1B S1 VDD VNW sg13_lv_pmos m=1 w=480.00n l=130.00n ng=1
MP11 Y net6 VDD VNW sg13_lv_pmos m=1 w=480.00n l=130.00n ng=1
MP0 S0B S0 VDD VNW sg13_lv_pmos m=1 w=480.00n l=130.00n ng=1
MP19 net1 A0 VDD VNW sg13_lv_pmos m=1 w=480.00n l=130.00n ng=1
.ENDS

************************************************************************
* Library Name: ez130_8t
* Cell Name:    MUX4X1P5
* View Name:    schematic
************************************************************************

.SUBCKT MUX4X1P5 A0 A1 A2 A3 S0 S1 VDD VNW VPW VSS Y
*.PININFO A0:I A1:I A2:I A3:I S0:I S1:I Y:O VDD:B VNW:B VPW:B VSS:B
MN26 net8 A2 VSS VPW sg13_lv_nmos m=1 w=300.0n l=130.00n ng=1
MN25 net7 A3 VSS VPW sg13_lv_nmos m=1 w=300.0n l=130.00n ng=1
MN24 B1 S0B net8 VPW sg13_lv_nmos m=1 w=300.0n l=130.00n ng=1
MN17 B1 S1 net6 VPW sg13_lv_nmos m=1 w=300.0n l=130.00n ng=1
MN16 B0 S1B net6 VPW sg13_lv_nmos m=1 w=300.0n l=130.00n ng=1
MN11 Y net6 VSS VPW sg13_lv_nmos m=1 w=480.00n l=130.00n ng=1
MN23 B1 S0 net7 VPW sg13_lv_nmos m=1 w=300.0n l=130.00n ng=1
MN10 S1B S1 VSS VPW sg13_lv_nmos m=1 w=300.0n l=130.00n ng=1
MN20 B0 S0B net2 VPW sg13_lv_nmos m=1 w=300.0n l=130.00n ng=1
MN22 net3 A1 VSS VPW sg13_lv_nmos m=1 w=300.0n l=130.00n ng=1
MN21 B0 S0 net3 VPW sg13_lv_nmos m=1 w=300.0n l=130.00n ng=1
MN19 net2 A0 VSS VPW sg13_lv_nmos m=1 w=300.0n l=130.00n ng=1
MN0 S0B S0 VSS VPW sg13_lv_nmos m=1 w=300.0n l=130.00n ng=1
MP26 net9 A3 VDD VNW sg13_lv_pmos m=1 w=480.00n l=130.00n ng=1
MP25 B1 S0 net4 VNW sg13_lv_pmos m=1 w=480.00n l=130.00n ng=1
MP24 B1 S0B net9 VNW sg13_lv_pmos m=1 w=480.00n l=130.00n ng=1
MP17 B1 S1B net6 VNW sg13_lv_pmos m=1 w=480.00n l=130.00n ng=1
MP16 B0 S1 net6 VNW sg13_lv_pmos m=1 w=480.00n l=130.00n ng=1
MP21 net5 A1 VDD VNW sg13_lv_pmos m=1 w=480.00n l=130.00n ng=1
MP20 B0 S0 net1 VNW sg13_lv_pmos m=1 w=480.00n l=130.00n ng=1
MP22 B0 S0B net5 VNW sg13_lv_pmos m=1 w=480.00n l=130.00n ng=1
MP23 net4 A2 VDD VNW sg13_lv_pmos m=1 w=480.00n l=130.00n ng=1
MP10 S1B S1 VDD VNW sg13_lv_pmos m=1 w=480.00n l=130.00n ng=1
MP11 Y net6 VDD VNW sg13_lv_pmos m=1 w=720.00n l=130.00n ng=1
MP0 S0B S0 VDD VNW sg13_lv_pmos m=1 w=480.00n l=130.00n ng=1
MP19 net1 A0 VDD VNW sg13_lv_pmos m=1 w=480.00n l=130.00n ng=1
.ENDS

************************************************************************
* Library Name: ez130_8t
* Cell Name:    MUX4X2
* View Name:    schematic
************************************************************************

.SUBCKT MUX4X2 A0 A1 A2 A3 S0 S1 VDD VNW VPW VSS Y
*.PININFO A0:I A1:I A2:I A3:I S0:I S1:I Y:O VDD:B VNW:B VPW:B VSS:B
MN26 net8 A2 VSS VPW sg13_lv_nmos m=1 w=300.0n l=130.00n ng=1
MN25 net7 A3 VSS VPW sg13_lv_nmos m=1 w=300.0n l=130.00n ng=1
MN24 B1 S0B net8 VPW sg13_lv_nmos m=1 w=300.0n l=130.00n ng=1
MN17 B1 S1 net6 VPW sg13_lv_nmos m=1 w=300.0n l=130.00n ng=1
MN16 B0 S1B net6 VPW sg13_lv_nmos m=1 w=300.0n l=130.00n ng=1
MN11 Y net6 VSS VPW sg13_lv_nmos m=1 w=640.00n l=130.00n ng=1
MN23 B1 S0 net7 VPW sg13_lv_nmos m=1 w=300.0n l=130.00n ng=1
MN10 S1B S1 VSS VPW sg13_lv_nmos m=1 w=300.0n l=130.00n ng=1
MN20 B0 S0B net2 VPW sg13_lv_nmos m=1 w=300.0n l=130.00n ng=1
MN22 net3 A1 VSS VPW sg13_lv_nmos m=1 w=300.0n l=130.00n ng=1
MN21 B0 S0 net3 VPW sg13_lv_nmos m=1 w=300.0n l=130.00n ng=1
MN19 net2 A0 VSS VPW sg13_lv_nmos m=1 w=300.0n l=130.00n ng=1
MN0 S0B S0 VSS VPW sg13_lv_nmos m=1 w=300.0n l=130.00n ng=1
MP26 net9 A3 VDD VNW sg13_lv_pmos m=1 w=480.00n l=130.00n ng=1
MP25 B1 S0 net4 VNW sg13_lv_pmos m=1 w=480.00n l=130.00n ng=1
MP24 B1 S0B net9 VNW sg13_lv_pmos m=1 w=480.00n l=130.00n ng=1
MP17 B1 S1B net6 VNW sg13_lv_pmos m=1 w=480.00n l=130.00n ng=1
MP16 B0 S1 net6 VNW sg13_lv_pmos m=1 w=480.00n l=130.00n ng=1
MP21 net5 A1 VDD VNW sg13_lv_pmos m=1 w=480.00n l=130.00n ng=1
MP20 B0 S0 net1 VNW sg13_lv_pmos m=1 w=480.00n l=130.00n ng=1
MP22 B0 S0B net5 VNW sg13_lv_pmos m=1 w=480.00n l=130.00n ng=1
MP23 net4 A2 VDD VNW sg13_lv_pmos m=1 w=480.00n l=130.00n ng=1
MP10 S1B S1 VDD VNW sg13_lv_pmos m=1 w=480.00n l=130.00n ng=1
MP11 Y net6 VDD VNW sg13_lv_pmos m=1 w=980.00n l=130.00n ng=1
MP0 S0B S0 VDD VNW sg13_lv_pmos m=1 w=480.00n l=130.00n ng=1
MP19 net1 A0 VDD VNW sg13_lv_pmos m=1 w=480.00n l=130.00n ng=1
.ENDS

************************************************************************
* Library Name: ez130_8t
* Cell Name:    MUX4X3
* View Name:    schematic
************************************************************************

.SUBCKT MUX4X3 A0 A1 A2 A3 S0 S1 VDD VNW VPW VSS Y
*.PININFO A0:I A1:I A2:I A3:I S0:I S1:I Y:O VDD:B VNW:B VPW:B VSS:B
MN26 net8 A2 VSS VPW sg13_lv_nmos m=1 w=300.0n l=130.00n ng=1
MN25 net7 A3 VSS VPW sg13_lv_nmos m=1 w=300.0n l=130.00n ng=1
MN24 B1 S0B net8 VPW sg13_lv_nmos m=1 w=300.0n l=130.00n ng=1
MN17 B1 S1 net6 VPW sg13_lv_nmos m=1 w=300.0n l=130.00n ng=1
MN16 B0 S1B net6 VPW sg13_lv_nmos m=1 w=300.0n l=130.00n ng=1
MN11 Y net6 VSS VPW sg13_lv_nmos m=1 w=860.00n l=130.00n ng=1
MN23 B1 S0 net7 VPW sg13_lv_nmos m=1 w=300.0n l=130.00n ng=1
MN10 S1B S1 VSS VPW sg13_lv_nmos m=1 w=300.0n l=130.00n ng=1
MN20 B0 S0B net2 VPW sg13_lv_nmos m=1 w=300.0n l=130.00n ng=1
MN22 net3 A1 VSS VPW sg13_lv_nmos m=1 w=300.0n l=130.00n ng=1
MN21 B0 S0 net3 VPW sg13_lv_nmos m=1 w=300.0n l=130.00n ng=1
MN19 net2 A0 VSS VPW sg13_lv_nmos m=1 w=300.0n l=130.00n ng=1
MN0 S0B S0 VSS VPW sg13_lv_nmos m=1 w=300.0n l=130.00n ng=1
MP26 net9 A3 VDD VNW sg13_lv_pmos m=1 w=480.00n l=130.00n ng=1
MP25 B1 S0 net4 VNW sg13_lv_pmos m=1 w=480.00n l=130.00n ng=1
MP24 B1 S0B net9 VNW sg13_lv_pmos m=1 w=480.00n l=130.00n ng=1
MP17 B1 S1B net6 VNW sg13_lv_pmos m=1 w=480.00n l=130.00n ng=1
MP16 B0 S1 net6 VNW sg13_lv_pmos m=1 w=480.00n l=130.00n ng=1
MP21 net5 A1 VDD VNW sg13_lv_pmos m=1 w=480.00n l=130.00n ng=1
MP20 B0 S0 net1 VNW sg13_lv_pmos m=1 w=480.00n l=130.00n ng=1
MP22 B0 S0B net5 VNW sg13_lv_pmos m=1 w=480.00n l=130.00n ng=1
MP23 net4 A2 VDD VNW sg13_lv_pmos m=1 w=480.00n l=130.00n ng=1
MP10 S1B S1 VDD VNW sg13_lv_pmos m=1 w=480.00n l=130.00n ng=1
MP11 Y net6 VDD VNW sg13_lv_pmos m=1 w=1.32u l=130.00n ng=1
MP0 S0B S0 VDD VNW sg13_lv_pmos m=1 w=480.00n l=130.00n ng=1
MP19 net1 A0 VDD VNW sg13_lv_pmos m=1 w=480.00n l=130.00n ng=1
.ENDS

************************************************************************
* Library Name: ez130_8t
* Cell Name:    MUXI2X1
* View Name:    schematic
************************************************************************

.SUBCKT MUXI2X1 A0 A1 S0 VDD VNW VPW VSS Y
*.PININFO A0:I A1:I S0:I Y:O VDD:B VNW:B VPW:B VSS:B
MN0 S0I S0 VSS VPW sg13_lv_nmos m=1 w=300.0n l=130.00n ng=1
MN7 Y A1 net18 VPW sg13_lv_nmos m=1 w=300.0n l=130.00n ng=1
MN3 Y A0 net10 VPW sg13_lv_nmos m=1 w=300.0n l=130.00n ng=1
MN8 net18 S0 VSS VPW sg13_lv_nmos m=1 w=300.0n l=130.00n ng=1
MN4 net10 S0I VSS VPW sg13_lv_nmos m=1 w=300.0n l=130.00n ng=1
MP0 S0I S0 VDD VNW sg13_lv_pmos m=1 w=480.00n l=130.00n ng=1
MP8 net7 S0I VDD VNW sg13_lv_pmos m=1 w=480.00n l=130.00n ng=1
MP7 net15 S0 VDD VNW sg13_lv_pmos m=1 w=480.00n l=130.00n ng=1
MP4 Y A0 net15 VNW sg13_lv_pmos m=1 w=480.00n l=130.00n ng=1
MP3 Y A1 net7 VNW sg13_lv_pmos m=1 w=480.00n l=130.00n ng=1
.ENDS

************************************************************************
* Library Name: ez130_8t
* Cell Name:    MUXI2X2
* View Name:    schematic
************************************************************************

.SUBCKT MUXI2X2 A0 A1 S0 VDD VNW VPW VSS Y
*.PININFO A0:I A1:I S0:I Y:O VDD:B VNW:B VPW:B VSS:B
MN0 S0I S0 VSS VPW sg13_lv_nmos m=1 w=300.0n l=130.00n ng=1
MN7 Y A1 net18 VPW sg13_lv_nmos m=1 w=640.00n l=130.00n ng=1
MN3 Y A0 net10 VPW sg13_lv_nmos m=1 w=640.00n l=130.00n ng=1
MN8 net18 S0 VSS VPW sg13_lv_nmos m=1 w=640.00n l=130.00n ng=1
MN4 net10 S0I VSS VPW sg13_lv_nmos m=1 w=640.00n l=130.00n ng=1
MP0 S0I S0 VDD VNW sg13_lv_pmos m=1 w=480.00n l=130.00n ng=1
MP8 net7 S0I VDD VNW sg13_lv_pmos m=1 w=950.00n l=130.00n ng=1
MP7 net15 S0 VDD VNW sg13_lv_pmos m=1 w=950.00n l=130.00n ng=1
MP4 Y A0 net15 VNW sg13_lv_pmos m=1 w=950.00n l=130.00n ng=1
MP3 Y A1 net7 VNW sg13_lv_pmos m=1 w=950.00n l=130.00n ng=1
.ENDS

************************************************************************
* Library Name: ez130_8t
* Cell Name:    NAND2BX1
* View Name:    schematic
************************************************************************

.SUBCKT NAND2BX1 AB B VDD VNW VPW VSS Y
*.PININFO AB:I B:I Y:O VDD:B VNW:B VPW:B VSS:B
MP3 A AB VDD VNW sg13_lv_pmos m=1 w=480.00n l=130.00n ng=1
MP1 Y B VDD VNW sg13_lv_pmos m=1 w=480.00n l=130.00n ng=1
MP0 Y A VDD VNW sg13_lv_pmos m=1 w=480.00n l=130.00n ng=1
MN2 A AB VSS VPW sg13_lv_nmos m=1 w=300.0n l=130.00n ng=1
MN1 net1 B VSS VPW sg13_lv_nmos m=1 w=300.0n l=130.00n ng=1
MN0 Y A net1 VPW sg13_lv_nmos m=1 w=300.0n l=130.00n ng=1
.ENDS

************************************************************************
* Library Name: ez130_8t
* Cell Name:    NAND2BX1P5
* View Name:    schematic
************************************************************************

.SUBCKT NAND2BX1P5 AB B VDD VNW VPW VSS Y
*.PININFO AB:I B:I Y:O VDD:B VNW:B VPW:B VSS:B
MP3 A AB VDD VNW sg13_lv_pmos m=1 w=480.00n l=130.00n ng=1
MP1 Y B VDD VNW sg13_lv_pmos m=1 w=720.00n l=130.00n ng=1
MP0 Y A VDD VNW sg13_lv_pmos m=1 w=720.00n l=130.00n ng=1
MN2 A AB VSS VPW sg13_lv_nmos m=1 w=300.0n l=130.00n ng=1
MN1 net1 B VSS VPW sg13_lv_nmos m=1 w=480.00n l=130.00n ng=1
MN0 Y A net1 VPW sg13_lv_nmos m=1 w=480.00n l=130.00n ng=1
.ENDS

************************************************************************
* Library Name: ez130_8t
* Cell Name:    NAND2BX2
* View Name:    schematic
************************************************************************

.SUBCKT NAND2BX2 AB B VDD VNW VPW VSS Y
*.PININFO AB:I B:I Y:O VDD:B VNW:B VPW:B VSS:B
MP3 A AB VDD VNW sg13_lv_pmos m=1 w=480.00n l=130.00n ng=1
MP1 Y B VDD VNW sg13_lv_pmos m=1 w=980.00n l=130.00n ng=1
MP0 Y A VDD VNW sg13_lv_pmos m=1 w=980.00n l=130.00n ng=1
MN2 A AB VSS VPW sg13_lv_nmos m=1 w=300.0n l=130.00n ng=1
MN1 net1 B VSS VPW sg13_lv_nmos m=1 w=640.00n l=130.00n ng=1
MN0 Y A net1 VPW sg13_lv_nmos m=1 w=640.00n l=130.00n ng=1
.ENDS

************************************************************************
* Library Name: ez130_8t
* Cell Name:    NAND2BX3
* View Name:    schematic
************************************************************************

.SUBCKT NAND2BX3 AB B VDD VNW VPW VSS Y
*.PININFO AB:I B:I Y:O VDD:B VNW:B VPW:B VSS:B
MP3 A AB VDD VNW sg13_lv_pmos m=1 w=480.00n l=130.00n ng=1
MP1 Y B VDD VNW sg13_lv_pmos m=1 w=1.32u l=130.00n ng=1
MP0 Y A VDD VNW sg13_lv_pmos m=1 w=1.32u l=130.00n ng=1
MN2 A AB VSS VPW sg13_lv_nmos m=1 w=300.0n l=130.00n ng=1
MN1 net1 A VSS VPW sg13_lv_nmos m=1 w=860.00n l=130.00n ng=1
MN0 Y B net1 VPW sg13_lv_nmos m=1 w=860.00n l=130.00n ng=1
.ENDS

************************************************************************
* Library Name: ez130_8t
* Cell Name:    NAND2BX4
* View Name:    schematic
************************************************************************

.SUBCKT NAND2BX4 AB B VDD VNW VPW VSS Y
*.PININFO AB:I B:I Y:O VDD:B VNW:B VPW:B VSS:B
MP3 A AB VDD VNW sg13_lv_pmos m=1 w=480.00n l=130.00n ng=1
MP1 Y B VDD VNW sg13_lv_pmos m=2 w=980.00n l=130.00n ng=1
MP0 Y A VDD VNW sg13_lv_pmos m=2 w=980.00n l=130.00n ng=1
MN4 net2 A VSS VPW sg13_lv_nmos m=1 w=640.00n l=130.00n ng=1
MN3 Y B net2 VPW sg13_lv_nmos m=1 w=640.00n l=130.00n ng=1
MN2 A AB VSS VPW sg13_lv_nmos m=1 w=300.0n l=130.00n ng=1
MN1 net1 A VSS VPW sg13_lv_nmos m=1 w=640.00n l=130.00n ng=1
MN0 Y B net1 VPW sg13_lv_nmos m=1 w=640.00n l=130.00n ng=1
.ENDS

************************************************************************
* Library Name: ez130_8t
* Cell Name:    NAND2X1
* View Name:    schematic
************************************************************************

.SUBCKT NAND2X1 A B VDD VNW VPW VSS Y
*.PININFO A:I B:I Y:O VDD:B VNW:B VPW:B VSS:B
MP1 Y B VDD VNW sg13_lv_pmos m=1 w=480.00n l=130.00n ng=1
MP0 Y A VDD VNW sg13_lv_pmos m=1 w=480.00n l=130.00n ng=1
MN1 net1 B VSS VPW sg13_lv_nmos m=1 w=300.0n l=130.00n ng=1
MN0 Y A net1 VPW sg13_lv_nmos m=1 w=300.0n l=130.00n ng=1
.ENDS

************************************************************************
* Library Name: ez130_8t
* Cell Name:    NAND2X1P5
* View Name:    schematic
************************************************************************

.SUBCKT NAND2X1P5 A B VDD VNW VPW VSS Y
*.PININFO A:I B:I Y:O VDD:B VNW:B VPW:B VSS:B
MN0 Y A net4 VPW sg13_lv_nmos m=1 w=480.00n l=130.00n ng=1
MN1 net4 B VSS VPW sg13_lv_nmos m=1 w=480.00n l=130.00n ng=1
MP1 Y B VDD VNW sg13_lv_pmos m=1 w=720.00n l=130.00n ng=1
MP0 Y A VDD VNW sg13_lv_pmos m=1 w=720.00n l=130.00n ng=1
.ENDS

************************************************************************
* Library Name: ez130_8t
* Cell Name:    NAND2X2
* View Name:    schematic
************************************************************************

.SUBCKT NAND2X2 A B VDD VNW VPW VSS Y
*.PININFO A:I B:I Y:O VDD:B VNW:B VPW:B VSS:B
MP1 Y B VDD VNW sg13_lv_pmos m=1 w=980.00n l=130.00n ng=1
MP0 Y A VDD VNW sg13_lv_pmos m=1 w=980.00n l=130.00n ng=1
MN1 net1 B VSS VPW sg13_lv_nmos m=1 w=640.00n l=130.00n ng=1
MN0 Y A net1 VPW sg13_lv_nmos m=1 w=640.00n l=130.00n ng=1
.ENDS

************************************************************************
* Library Name: ez130_8t
* Cell Name:    NAND2X3
* View Name:    schematic
************************************************************************

.SUBCKT NAND2X3 A B VDD VNW VPW VSS Y
*.PININFO A:I B:I Y:O VDD:B VNW:B VPW:B VSS:B
MP1 Y B VDD VNW sg13_lv_pmos m=1 w=1.32u l=130.00n ng=1
MP0 Y A VDD VNW sg13_lv_pmos m=1 w=1.32u l=130.00n ng=1
MN1 net1 B VSS VPW sg13_lv_nmos m=1 w=860.00n l=130.00n ng=1
MN0 Y A net1 VPW sg13_lv_nmos m=1 w=860.00n l=130.00n ng=1
.ENDS

************************************************************************
* Library Name: ez130_8t
* Cell Name:    NAND2X4
* View Name:    schematic
************************************************************************

.SUBCKT NAND2X4 A B VDD VNW VPW VSS Y
*.PININFO A:I B:I Y:O VDD:B VNW:B VPW:B VSS:B
MN0 Y A net1 VPW sg13_lv_nmos m=2 w=640.00n l=130.00n ng=1
MN1 net1 B VSS VPW sg13_lv_nmos m=2 w=640.00n l=130.00n ng=1
MP1 Y B VDD VNW sg13_lv_pmos m=2 w=980.00n l=130.00n ng=1
MP0 Y A VDD VNW sg13_lv_pmos m=2 w=980.00n l=130.00n ng=1
.ENDS

************************************************************************
* Library Name: ez130_8t
* Cell Name:    NAND3BX1
* View Name:    schematic
************************************************************************

.SUBCKT NAND3BX1 AB B C VDD VNW VPW VSS Y
*.PININFO AB:I B:I C:I Y:O VDD:B VNW:B VPW:B VSS:B
MN4 net13 C VSS VPW sg13_lv_nmos m=1 w=300.0n l=130.00n ng=1
MN3 net2 B net13 VPW sg13_lv_nmos m=1 w=300.0n l=130.00n ng=1
MN5 net1 AB VSS VPW sg13_lv_nmos m=1 w=300.0n l=130.00n ng=1
MN0 Y net1 net2 VPW sg13_lv_nmos m=1 w=300.0n l=130.00n ng=1
MP4 net1 AB VDD VNW sg13_lv_pmos m=1 w=480.00n l=130.00n ng=1
MP1 Y net1 VDD VNW sg13_lv_pmos m=1 w=480.00n l=130.00n ng=1
MP0 Y B VDD VNW sg13_lv_pmos m=1 w=480.00n l=130.00n ng=1
MP3 Y C VDD VNW sg13_lv_pmos m=1 w=480.00n l=130.00n ng=1
.ENDS

************************************************************************
* Library Name: ez130_8t
* Cell Name:    NAND3BX2
* View Name:    schematic
************************************************************************

.SUBCKT NAND3BX2 AB B C VDD VNW VPW VSS Y
*.PININFO AB:I B:I C:I Y:O VDD:B VNW:B VPW:B VSS:B
MN3 net10 C VSS VPW sg13_lv_nmos m=1 w=640.00n l=130.00n ng=1
MN2 net6 B net10 VPW sg13_lv_nmos m=1 w=640.00n l=130.00n ng=1
MN1 Y net3 net6 VPW sg13_lv_nmos m=1 w=640.00n l=130.00n ng=1
MN0 net3 AB VSS VPW sg13_lv_nmos m=1 w=300.0n l=130.00n ng=1
MP3 Y C VDD VNW sg13_lv_pmos m=1 w=980.00n l=130.00n ng=1
MP2 Y net3 VDD VNW sg13_lv_pmos m=1 w=980.00n l=130.00n ng=1
MP1 Y B VDD VNW sg13_lv_pmos m=1 w=980.00n l=130.00n ng=1
MP0 net3 AB VDD VNW sg13_lv_pmos m=1 w=480.00n l=130.00n ng=1
.ENDS

************************************************************************
* Library Name: ez130_8t
* Cell Name:    NAND3BX3
* View Name:    schematic
************************************************************************

.SUBCKT NAND3BX3 AB B C VDD VNW VPW VSS Y
*.PININFO AB:I B:I C:I Y:O VDD:B VNW:B VPW:B VSS:B
MN3 net10 C VSS VPW sg13_lv_nmos m=1 w=860.00n l=130.00n ng=1
MN2 net6 B net10 VPW sg13_lv_nmos m=1 w=860.00n l=130.00n ng=1
MN1 Y net3 net6 VPW sg13_lv_nmos m=1 w=860.00n l=130.00n ng=1
MN0 net3 AB VSS VPW sg13_lv_nmos m=1 w=300.0n l=130.00n ng=1
MP3 Y C VDD VNW sg13_lv_pmos m=1 w=1.32u l=130.00n ng=1
MP2 Y net3 VDD VNW sg13_lv_pmos m=1 w=1.32u l=130.00n ng=1
MP1 Y B VDD VNW sg13_lv_pmos m=1 w=1.32u l=130.00n ng=1
MP0 net3 AB VDD VNW sg13_lv_pmos m=1 w=480.00n l=130.00n ng=1
.ENDS

************************************************************************
* Library Name: ez130_8t
* Cell Name:    NAND3X1
* View Name:    schematic
************************************************************************

.SUBCKT NAND3X1 A B VDD VNW VPW VSS Y C
*.PININFO A:I B:I C:I Y:O VDD:B VNW:B VPW:B VSS:B
MP2 Y C VDD VNW sg13_lv_pmos m=1 w=480.00n l=130.00n ng=1
MP1 Y B VDD VNW sg13_lv_pmos m=1 w=480.00n l=130.00n ng=1
MP0 Y A VDD VNW sg13_lv_pmos m=1 w=480.00n l=130.00n ng=1
MN2 net6 B VSS VPW sg13_lv_nmos m=1 w=300.0n l=130.00n ng=1
MN1 net1 A net6 VPW sg13_lv_nmos m=1 w=300.0n l=130.00n ng=1
MN0 Y C net1 VPW sg13_lv_nmos m=1 w=300.0n l=130.00n ng=1
.ENDS

************************************************************************
* Library Name: ez130_8t
* Cell Name:    NAND3X2
* View Name:    schematic
************************************************************************

.SUBCKT NAND3X2 A B VDD VNW VPW VSS Y C
*.PININFO A:I B:I C:I Y:O VDD:B VNW:B VPW:B VSS:B
MP2 Y C VDD VNW sg13_lv_pmos m=1 w=980.00n l=130.00n ng=1
MP1 Y B VDD VNW sg13_lv_pmos m=1 w=980.00n l=130.00n ng=1
MP0 Y A VDD VNW sg13_lv_pmos m=1 w=980.00n l=130.00n ng=1
MN2 net6 B VSS VPW sg13_lv_nmos m=1 w=640.00n l=130.00n ng=1
MN1 net1 A net6 VPW sg13_lv_nmos m=1 w=640.00n l=130.00n ng=1
MN0 Y C net1 VPW sg13_lv_nmos m=1 w=640.00n l=130.00n ng=1
.ENDS

************************************************************************
* Library Name: ez130_8t
* Cell Name:    NAND4BX1
* View Name:    schematic
************************************************************************

.SUBCKT NAND4BX1 AB B C D VDD VNW VPW VSS Y
*.PININFO AB:I B:I C:I D:I Y:O VDD:B VNW:B VPW:B VSS:B
MN1 net12 D VSS VPW sg13_lv_nmos m=1 w=300.0n l=130.00n ng=1
MN0 Y net42 net41 VPW sg13_lv_nmos m=1 w=300.0n l=130.00n ng=1
MN5 net42 AB VSS VPW sg13_lv_nmos m=1 w=300.0n l=130.00n ng=1
MN3 net41 B net40 VPW sg13_lv_nmos m=1 w=300.0n l=130.00n ng=1
MN4 net40 C net12 VPW sg13_lv_nmos m=1 w=300.0n l=130.00n ng=1
MP2 Y D VDD VNW sg13_lv_pmos m=1 w=480.00n l=130.00n ng=1
MP3 Y C VDD VNW sg13_lv_pmos m=1 w=480.00n l=130.00n ng=1
MP0 Y B VDD VNW sg13_lv_pmos m=1 w=480.00n l=130.00n ng=1
MP1 Y net42 VDD VNW sg13_lv_pmos m=1 w=480.00n l=130.00n ng=1
MP4 net42 AB VDD VNW sg13_lv_pmos m=1 w=480.00n l=130.00n ng=1
.ENDS

************************************************************************
* Library Name: ez130_8t
* Cell Name:    NAND4BX2
* View Name:    schematic
************************************************************************

.SUBCKT NAND4BX2 AB B C D VDD VNW VPW VSS Y
*.PININFO AB:I B:I C:I D:I Y:O VDD:B VNW:B VPW:B VSS:B
MN4 net51 C net48 VPW sg13_lv_nmos m=1 w=640.00n l=130.00n ng=1
MN3 net50 B net51 VPW sg13_lv_nmos m=1 w=640.00n l=130.00n ng=1
MN5 net49 AB VSS VPW sg13_lv_nmos m=1 w=300.0n l=130.00n ng=1
MN0 Y net49 net50 VPW sg13_lv_nmos m=1 w=640.00n l=130.00n ng=1
MN1 net48 D VSS VPW sg13_lv_nmos m=1 w=640.00n l=130.00n ng=1
MP4 net49 AB VDD VNW sg13_lv_pmos m=1 w=480.00n l=130.00n ng=1
MP1 Y net49 VDD VNW sg13_lv_pmos m=1 w=980.00n l=130.00n ng=1
MP0 Y B VDD VNW sg13_lv_pmos m=1 w=980.00n l=130.00n ng=1
MP3 Y C VDD VNW sg13_lv_pmos m=1 w=980.00n l=130.00n ng=1
MP2 Y D VDD VNW sg13_lv_pmos m=1 w=980.00n l=130.00n ng=1
.ENDS

************************************************************************
* Library Name: ez130_8t
* Cell Name:    NAND4BBX1
* View Name:    schematic
************************************************************************

.SUBCKT NAND4BBX1 AB BB C D VDD VNW VPW VSS Y
*.PININFO AB:I BB:I C:I D:I Y:O VDD:B VNW:B VPW:B VSS:B
MN0 Y net26 net25 VPW sg13_lv_nmos m=1 w=300.0n l=130.00n ng=1
MN4 net26 AB VSS VPW sg13_lv_nmos m=1 w=300.0n l=130.00n ng=1
MN1 net25 net23 net24 VPW sg13_lv_nmos m=1 w=300.0n l=130.00n ng=1
MN3 net24 C net22 VPW sg13_lv_nmos m=1 w=300.0n l=130.00n ng=1
MN5 net23 BB VSS VPW sg13_lv_nmos m=1 w=300.0n l=130.00n ng=1
MN2 net22 D VSS VPW sg13_lv_nmos m=1 w=300.0n l=130.00n ng=1
MP3 Y D VDD VNW sg13_lv_pmos m=1 w=480.00n l=130.00n ng=1
MP2 Y C VDD VNW sg13_lv_pmos m=1 w=480.00n l=130.00n ng=1
MP1 Y net23 VDD VNW sg13_lv_pmos m=1 w=480.00n l=130.00n ng=1
MP0 Y net26 VDD VNW sg13_lv_pmos m=1 w=480.00n l=130.00n ng=1
MP4 net26 AB VDD VNW sg13_lv_pmos m=1 w=480.00n l=130.00n ng=1
MP5 net23 BB VDD VNW sg13_lv_pmos m=1 w=480.00n l=130.00n ng=1
.ENDS

************************************************************************
* Library Name: ez130_8t
* Cell Name:    NAND4BBX2
* View Name:    schematic
************************************************************************

.SUBCKT NAND4BBX2 AB BB C D VDD VNW VPW VSS Y
*.PININFO AB:I BB:I C:I D:I Y:O VDD:B VNW:B VPW:B VSS:B
MP5 net5 BB VDD VNW sg13_lv_pmos m=1 w=480.00n l=130.00n ng=1
MP4 net4 AB VDD VNW sg13_lv_pmos m=1 w=480.00n l=130.00n ng=1
MP3 Y D VDD VNW sg13_lv_pmos m=1 w=980.00n l=130.00n ng=1
MP2 Y C VDD VNW sg13_lv_pmos m=1 w=980.00n l=130.00n ng=1
MP1 Y net5 VDD VNW sg13_lv_pmos m=1 w=980.00n l=130.00n ng=1
MP0 Y net4 VDD VNW sg13_lv_pmos m=1 w=980.00n l=130.00n ng=1
MN5 net5 BB VSS VPW sg13_lv_nmos m=1 w=300.0n l=130.00n ng=1
MN4 net4 AB VSS VPW sg13_lv_nmos m=1 w=300.0n l=130.00n ng=1
MN3 net2 C net3 VPW sg13_lv_nmos m=1 w=640.00n l=130.00n ng=1
MN2 net3 D VSS VPW sg13_lv_nmos m=1 w=640.00n l=130.00n ng=1
MN1 net1 net5 net2 VPW sg13_lv_nmos m=1 w=640.00n l=130.00n ng=1
MN0 Y net4 net1 VPW sg13_lv_nmos m=1 w=640.00n l=130.00n ng=1
.ENDS

************************************************************************
* Library Name: ez130_8t
* Cell Name:    NAND4X2
* View Name:    schematic
************************************************************************

.SUBCKT NAND4X2 A B VDD VNW VPW VSS Y C D
*.PININFO A:I B:I C:I D:I Y:O VDD:B VNW:B VPW:B VSS:B
MP3 Y D VDD VNW sg13_lv_pmos m=1 w=980.00n l=130.00n ng=1
MP2 Y C VDD VNW sg13_lv_pmos m=1 w=980.00n l=130.00n ng=1
MP1 Y B VDD VNW sg13_lv_pmos m=1 w=980.00n l=130.00n ng=1
MP0 Y A VDD VNW sg13_lv_pmos m=1 w=980.00n l=130.00n ng=1
MN3 net2 B net8 VPW sg13_lv_nmos m=1 w=640.00n l=130.00n ng=1
MN2 net8 A VSS VPW sg13_lv_nmos m=1 w=640.00n l=130.00n ng=1
MN1 net1 C net2 VPW sg13_lv_nmos m=1 w=640.00n l=130.00n ng=1
MN0 Y D net1 VPW sg13_lv_nmos m=1 w=640.00n l=130.00n ng=1
.ENDS

************************************************************************
* Library Name: ez130_8t
* Cell Name:    NOR2X1
* View Name:    schematic
************************************************************************

.SUBCKT NOR2X1 A B VDD VNW VPW VSS Y
*.PININFO A:I B:I Y:O VDD:B VNW:B VPW:B VSS:B
MP1 net2 B VDD VNW sg13_lv_pmos m=1 w=480.00n l=130.00n ng=1
MP0 Y A net2 VNW sg13_lv_pmos m=1 w=480.00n l=130.00n ng=1
MN1 Y B VSS VPW sg13_lv_nmos m=1 w=300.0n l=130.00n ng=1
MN0 Y A VSS VPW sg13_lv_nmos m=1 w=300.0n l=130.00n ng=1
.ENDS

************************************************************************
* Library Name: ez130_8t
* Cell Name:    NOR2X2
* View Name:    schematic
************************************************************************

.SUBCKT NOR2X2 A B VDD VNW VPW VSS Y
*.PININFO A:I B:I Y:O VDD:B VNW:B VPW:B VSS:B
MP1 net2 B VDD VNW sg13_lv_pmos m=1 w=980.00n l=130.00n ng=1
MP0 Y A net2 VNW sg13_lv_pmos m=1 w=980.00n l=130.00n ng=1
MN1 Y B VSS VPW sg13_lv_nmos m=1 w=640.00n l=130.00n ng=1
MN0 Y A VSS VPW sg13_lv_nmos m=1 w=640.00n l=130.00n ng=1
.ENDS

************************************************************************
* Library Name: ez130_8t
* Cell Name:    NOR2X3
* View Name:    schematic
************************************************************************

.SUBCKT NOR2X3 A B VDD VNW VPW VSS Y
*.PININFO A:I B:I Y:O VDD:B VNW:B VPW:B VSS:B
MP1 net2 B VDD VNW sg13_lv_pmos m=1 w=1.32u l=130.00n ng=1
MP0 Y A net2 VNW sg13_lv_pmos m=1 w=1.32u l=130.00n ng=1
MN1 Y B VSS VPW sg13_lv_nmos m=1 w=860.00n l=130.00n ng=1
MN0 Y A VSS VPW sg13_lv_nmos m=1 w=860.00n l=130.00n ng=1
.ENDS

************************************************************************
* Library Name: ez130_8t
* Cell Name:    NOR2X4
* View Name:    schematic
************************************************************************

.SUBCKT NOR2X4 A B VDD VNW VPW VSS Y
*.PININFO A:I B:I Y:O VDD:B VNW:B VPW:B VSS:B
MP1 net2 B VDD VNW sg13_lv_pmos m=2 w=980.00n l=130.00n ng=1
MP0 Y A net2 VNW sg13_lv_pmos m=2 w=980.00n l=130.00n ng=1
MN1 Y B VSS VPW sg13_lv_nmos m=2 w=640.00n l=130.00n ng=1
MN0 Y A VSS VPW sg13_lv_nmos m=2 w=640.00n l=130.00n ng=1
.ENDS

************************************************************************
* Library Name: ez130_8t
* Cell Name:    NOR2BX1
* View Name:    schematic
************************************************************************

.SUBCKT NOR2BX1 AB B VDD VNW VPW VSS Y
*.PININFO AB:I B:I Y:O VDD:B VNW:B VPW:B VSS:B
MP2 net1 AB VDD VNW sg13_lv_pmos m=1 w=480.00n l=130.00n ng=1
MP1 net2 B VDD VNW sg13_lv_pmos m=1 w=480.00n l=130.00n ng=1
MP0 Y net1 net2 VNW sg13_lv_pmos m=1 w=480.00n l=130.00n ng=1
MN2 net1 AB VSS VPW sg13_lv_nmos m=1 w=300.0n l=130.00n ng=1
MN1 Y B VSS VPW sg13_lv_nmos m=1 w=300.0n l=130.00n ng=1
MN0 Y net1 VSS VPW sg13_lv_nmos m=1 w=300.0n l=130.00n ng=1
.ENDS

************************************************************************
* Library Name: ez130_8t
* Cell Name:    NOR2BX2
* View Name:    schematic
************************************************************************

.SUBCKT NOR2BX2 AB B VDD VNW VPW VSS Y
*.PININFO AB:I B:I Y:O VDD:B VNW:B VPW:B VSS:B
MP2 net1 AB VDD VNW sg13_lv_pmos m=1 w=480.00n l=130.00n ng=1
MP1 net2 B VDD VNW sg13_lv_pmos m=1 w=980.00n l=130.00n ng=1
MP0 Y net1 net2 VNW sg13_lv_pmos m=1 w=980.00n l=130.00n ng=1
MN2 net1 AB VSS VPW sg13_lv_nmos m=1 w=300.0n l=130.00n ng=1
MN1 Y B VSS VPW sg13_lv_nmos m=1 w=640.00n l=130.00n ng=1
MN0 Y net1 VSS VPW sg13_lv_nmos m=1 w=640.00n l=130.00n ng=1
.ENDS

************************************************************************
* Library Name: ez130_8t
* Cell Name:    NOR3BX1
* View Name:    schematic
************************************************************************

.SUBCKT NOR3BX1 AB B C VDD VNW VPW VSS Y
*.PININFO AB:I B:I C:I Y:O VDD:B VNW:B VPW:B VSS:B
MN3 Y B VSS VPW sg13_lv_nmos m=1 w=300.0n l=130.00n ng=1
MN2 Y C VSS VPW sg13_lv_nmos m=1 w=300.0n l=130.00n ng=1
MN1 Y net1 VSS VPW sg13_lv_nmos m=1 w=300.0n l=130.00n ng=1
MN0 net1 AB VSS VPW sg13_lv_nmos m=1 w=300.0n l=130.00n ng=1
MP3 net5 C VDD VNW sg13_lv_pmos m=1 w=480.00n l=130.00n ng=1
MP2 Y net1 net12 VNW sg13_lv_pmos m=1 w=480.00n l=130.00n ng=1
MP1 net12 B net5 VNW sg13_lv_pmos m=1 w=480.00n l=130.00n ng=1
MP0 net1 AB VDD VNW sg13_lv_pmos m=1 w=480.00n l=130.00n ng=1
.ENDS

************************************************************************
* Library Name: ez130_8t
* Cell Name:    NOR3BX1P5
* View Name:    schematic
************************************************************************

.SUBCKT NOR3BX1P5 AB B C VDD VNW VPW VSS Y
*.PININFO AB:I B:I C:I Y:O VDD:B VNW:B VPW:B VSS:B
MN3 Y B VSS VPW sg13_lv_nmos m=1 w=480.00n l=130.00n ng=1
MN2 Y C VSS VPW sg13_lv_nmos m=1 w=480.00n l=130.00n ng=1
MN1 Y net1 VSS VPW sg13_lv_nmos m=1 w=480.00n l=130.00n ng=1
MN0 net1 AB VSS VPW sg13_lv_nmos m=1 w=480.00n l=130.00n ng=1
MP3 net5 C VDD VNW sg13_lv_pmos m=1 w=720.00n l=130.00n ng=1
MP2 Y net1 net12 VNW sg13_lv_pmos m=1 w=720.00n l=130.00n ng=1
MP1 net12 B net5 VNW sg13_lv_pmos m=1 w=720.00n l=130.00n ng=1
MP0 net1 AB VDD VNW sg13_lv_pmos m=1 w=720.00n l=130.00n ng=1
.ENDS

************************************************************************
* Library Name: ez130_8t
* Cell Name:    NOR3BX2
* View Name:    schematic
************************************************************************

.SUBCKT NOR3BX2 AB B C VDD VNW VPW VSS Y
*.PININFO AB:I B:I C:I Y:O VDD:B VNW:B VPW:B VSS:B
MN3 Y B VSS VPW sg13_lv_nmos m=1 w=640.00n l=130.00n ng=1
MN2 Y C VSS VPW sg13_lv_nmos m=1 w=640.00n l=130.00n ng=1
MN1 Y net1 VSS VPW sg13_lv_nmos m=1 w=640.00n l=130.00n ng=1
MN0 net1 AB VSS VPW sg13_lv_nmos m=1 w=300.0n l=130.00n ng=1
MP3 net5 C VDD VNW sg13_lv_pmos m=1 w=980.00n l=130.00n ng=1
MP2 Y net1 net12 VNW sg13_lv_pmos m=1 w=980.00n l=130.00n ng=1
MP1 net12 B net5 VNW sg13_lv_pmos m=1 w=980.00n l=130.00n ng=1
MP0 net1 AB VDD VNW sg13_lv_pmos m=1 w=480.00n l=130.00n ng=1
.ENDS

************************************************************************
* Library Name: ez130_8t
* Cell Name:    NOR3BX3
* View Name:    schematic
************************************************************************

.SUBCKT NOR3BX3 AB B C VDD VNW VPW VSS Y
*.PININFO AB:I B:I C:I Y:O VDD:B VNW:B VPW:B VSS:B
MN3 Y B VSS VPW sg13_lv_nmos m=1 w=860.00n l=130.00n ng=1
MN2 Y C VSS VPW sg13_lv_nmos m=1 w=860.00n l=130.00n ng=1
MN1 Y net1 VSS VPW sg13_lv_nmos m=1 w=860.00n l=130.00n ng=1
MN0 net1 AB VSS VPW sg13_lv_nmos m=1 w=300.0n l=130.00n ng=1
MP3 net5 C VDD VNW sg13_lv_pmos m=1 w=1.32u l=130.00n ng=1
MP2 Y net1 net12 VNW sg13_lv_pmos m=1 w=1.32u l=130.00n ng=1
MP1 net12 B net5 VNW sg13_lv_pmos m=1 w=1.32u l=130.00n ng=1
MP0 net1 AB VDD VNW sg13_lv_pmos m=1 w=480.00n l=130.00n ng=1
.ENDS

************************************************************************
* Library Name: ez130_8t
* Cell Name:    NOR3X1
* View Name:    schematic
************************************************************************

.SUBCKT NOR3X1 A B C VDD VNW VPW VSS Y
*.PININFO A:I B:I C:I Y:O VDD:B VNW:B VPW:B VSS:B
MP3 net3 B net2 VNW sg13_lv_pmos m=1 w=480.00n l=130.00n ng=1
MP4 net2 A VDD VNW sg13_lv_pmos m=1 w=480.00n l=130.00n ng=1
MP0 Y C net3 VNW sg13_lv_pmos m=1 w=480.00n l=130.00n ng=1
MN3 Y B VSS VPW sg13_lv_nmos m=1 w=300.0n l=130.00n ng=1
MN4 Y C VSS VPW sg13_lv_nmos m=1 w=300.0n l=130.00n ng=1
MN0 Y A VSS VPW sg13_lv_nmos m=1 w=300.0n l=130.00n ng=1
.ENDS

************************************************************************
* Library Name: ez130_8t
* Cell Name:    NOR3X2
* View Name:    schematic
************************************************************************

.SUBCKT NOR3X2 A B C VDD VNW VPW VSS Y
*.PININFO A:I B:I C:I Y:O VDD:B VNW:B VPW:B VSS:B
MP2 net2 A VDD VNW sg13_lv_pmos m=1 w=980.00n l=130.00n ng=1
MP1 net3 B net2 VNW sg13_lv_pmos m=1 w=980.00n l=130.00n ng=1
MP0 Y C net3 VNW sg13_lv_pmos m=1 w=980.00n l=130.00n ng=1
MN2 Y C VSS VPW sg13_lv_nmos m=1 w=640.00n l=130.00n ng=1
MN1 Y B VSS VPW sg13_lv_nmos m=1 w=640.00n l=130.00n ng=1
MN0 Y A VSS VPW sg13_lv_nmos m=1 w=640.00n l=130.00n ng=1
.ENDS

************************************************************************
* Library Name: ez130_8t
* Cell Name:    NOR4BX1
* View Name:    schematic
************************************************************************

.SUBCKT NOR4BX1 AB B C D VDD VNW VPW VSS Y
*.PININFO AB:I B:I C:I D:I Y:O VDD:B VNW:B VPW:B VSS:B
MN5 Y D VSS VPW sg13_lv_nmos m=1 w=300.0n l=130.00n ng=1
MN4 Y C VSS VPW sg13_lv_nmos m=1 w=300.0n l=130.00n ng=1
MN3 Y A VSS VPW sg13_lv_nmos m=1 w=300.0n l=130.00n ng=1
MN2 Y B VSS VPW sg13_lv_nmos m=1 w=300.0n l=130.00n ng=1
MN0 A AB VSS VPW sg13_lv_nmos m=1 w=300.0n l=130.00n ng=1
MP4 Y A net5 VNW sg13_lv_pmos m=1 w=480.00n l=130.00n ng=1
MP3 net5 D net4 VNW sg13_lv_pmos m=1 w=480.00n l=130.00n ng=1
MP2 net4 C net3 VNW sg13_lv_pmos m=1 w=480.00n l=130.00n ng=1
MP1 net3 B VDD VNW sg13_lv_pmos m=1 w=480.00n l=130.00n ng=1
MP0 A AB VDD VNW sg13_lv_pmos m=1 w=480.00n l=130.00n ng=1
.ENDS

************************************************************************
* Library Name: ez130_8t
* Cell Name:    NOR4BX2
* View Name:    schematic
************************************************************************

.SUBCKT NOR4BX2 AB B C D VDD VNW VPW VSS Y
*.PININFO AB:I B:I C:I D:I Y:O VDD:B VNW:B VPW:B VSS:B
MN5 Y D VSS VPW sg13_lv_nmos m=1 w=640.00n l=130.00n ng=1
MN4 Y C VSS VPW sg13_lv_nmos m=1 w=640.00n l=130.00n ng=1
MN3 Y A VSS VPW sg13_lv_nmos m=1 w=640.00n l=130.00n ng=1
MN2 Y B VSS VPW sg13_lv_nmos m=1 w=640.00n l=130.00n ng=1
MN0 A AB VSS VPW sg13_lv_nmos m=1 w=420.00n l=130.00n ng=1
MP4 Y A net5 VNW sg13_lv_pmos m=1 w=980.00n l=130.00n ng=1
MP3 net5 D net4 VNW sg13_lv_pmos m=1 w=980.00n l=130.00n ng=1
MP2 net4 C net3 VNW sg13_lv_pmos m=1 w=980.00n l=130.00n ng=1
MP1 net3 B VDD VNW sg13_lv_pmos m=1 w=980.00n l=130.00n ng=1
MP0 A AB VDD VNW sg13_lv_pmos m=1 w=640.00n l=130.00n ng=1
.ENDS

************************************************************************
* Library Name: ez130_8t
* Cell Name:    NOR4BBX1
* View Name:    schematic
************************************************************************

.SUBCKT NOR4BBX1 AB BB C D VDD VNW VPW VSS Y
*.PININFO AB:I BB:I C:I D:I Y:O VDD:B VNW:B VPW:B VSS:B
MN8 BBn BB VSS VPW sg13_lv_nmos m=1 w=300.0n l=130.00n ng=1
MN7 ABn AB VSS VPW sg13_lv_nmos m=1 w=300.0n l=130.00n ng=1
MN4 Y D VSS VPW sg13_lv_nmos m=1 w=300.0n l=130.00n ng=1
MN3 Y C VSS VPW sg13_lv_nmos m=1 w=300.0n l=130.00n ng=1
MN5 Y BBn VSS VPW sg13_lv_nmos m=1 w=300.0n l=130.00n ng=1
MN6 Y ABn VSS VPW sg13_lv_nmos m=1 w=300.0n l=130.00n ng=1
MP6 BBn BB VDD VNW sg13_lv_pmos m=1 w=480.00n l=130.00n ng=1
MP5 ABn AB VDD VNW sg13_lv_pmos m=1 w=480.00n l=130.00n ng=1
MP4 Y BBn net12 VNW sg13_lv_pmos m=1 w=480.00n l=130.00n ng=1
MP3 net1 C net2 VNW sg13_lv_pmos m=1 w=480.00n l=130.00n ng=1
MP1 net12 D net1 VNW sg13_lv_pmos m=1 w=480.00n l=130.00n ng=1
MP0 net2 ABn VDD VNW sg13_lv_pmos m=1 w=480.00n l=130.00n ng=1
.ENDS

************************************************************************
* Library Name: ez130_8t
* Cell Name:    NOR4BBX2
* View Name:    schematic
************************************************************************

.SUBCKT NOR4BBX2 AB BB C D VDD VNW VPW VSS Y
*.PININFO AB:I BB:I C:I D:I Y:O VDD:B VNW:B VPW:B VSS:B
MN8 BBn BB VSS VPW sg13_lv_nmos m=1 w=300.0n l=130.00n ng=1
MN7 ABn AB VSS VPW sg13_lv_nmos m=1 w=300.0n l=130.00n ng=1
MN4 Y D VSS VPW sg13_lv_nmos m=1 w=640.00n l=130.00n ng=1
MN3 Y C VSS VPW sg13_lv_nmos m=1 w=640.00n l=130.00n ng=1
MN5 Y BBn VSS VPW sg13_lv_nmos m=1 w=640.00n l=130.00n ng=1
MN6 Y ABn VSS VPW sg13_lv_nmos m=1 w=640.00n l=130.00n ng=1
MP6 BBn BB VDD VNW sg13_lv_pmos m=1 w=480.00n l=130.00n ng=1
MP5 ABn AB VDD VNW sg13_lv_pmos m=1 w=480.00n l=130.00n ng=1
MP4 Y BBn net12 VNW sg13_lv_pmos m=1 w=980.00n l=130.00n ng=1
MP3 net1 C net2 VNW sg13_lv_pmos m=1 w=980.00n l=130.00n ng=1
MP1 net12 D net1 VNW sg13_lv_pmos m=1 w=980.00n l=130.00n ng=1
MP0 net2 ABn VDD VNW sg13_lv_pmos m=1 w=980.00n l=130.00n ng=1
.ENDS

************************************************************************
* Library Name: ez130_8t
* Cell Name:    NOR4X1
* View Name:    schematic
************************************************************************

.SUBCKT NOR4X1 A B C D VDD VNW VPW VSS Y
*.PININFO A:I B:I C:I D:I Y:O VDD:B VNW:B VPW:B VSS:B
MP3 Y D net2 VNW sg13_lv_pmos m=1 w=480.00n l=130.00n ng=1
MP2 net2 C net3 VNW sg13_lv_pmos m=1 w=480.00n l=130.00n ng=1
MP1 net3 B net4 VNW sg13_lv_pmos m=1 w=480.00n l=130.00n ng=1
MP0 net4 A VDD VNW sg13_lv_pmos m=1 w=480.00n l=130.00n ng=1
MN3 Y D VSS VPW sg13_lv_nmos m=1 w=300.0n l=130.00n ng=1
MN2 Y C VSS VPW sg13_lv_nmos m=1 w=300.0n l=130.00n ng=1
MN1 Y B VSS VPW sg13_lv_nmos m=1 w=300.0n l=130.00n ng=1
MN0 Y A VSS VPW sg13_lv_nmos m=1 w=300.0n l=130.00n ng=1
.ENDS

************************************************************************
* Library Name: ez130_8t
* Cell Name:    NOR4X2
* View Name:    schematic
************************************************************************

.SUBCKT NOR4X2 A B C D VDD VNW VPW VSS Y
*.PININFO A:I B:I C:I D:I Y:O VDD:B VNW:B VPW:B VSS:B
MP3 Y D net2 VNW sg13_lv_pmos m=1 w=980.00n l=130.00n ng=1
MP2 net2 C net3 VNW sg13_lv_pmos m=1 w=980.00n l=130.00n ng=1
MP1 net3 B net4 VNW sg13_lv_pmos m=1 w=980.00n l=130.00n ng=1
MP0 net4 A VDD VNW sg13_lv_pmos m=1 w=980.00n l=130.00n ng=1
MN3 Y D VSS VPW sg13_lv_nmos m=1 w=640.00n l=130.00n ng=1
MN2 Y C VSS VPW sg13_lv_nmos m=1 w=640.00n l=130.00n ng=1
MN1 Y B VSS VPW sg13_lv_nmos m=1 w=640.00n l=130.00n ng=1
MN0 Y A VSS VPW sg13_lv_nmos m=1 w=640.00n l=130.00n ng=1
.ENDS

************************************************************************
* Library Name: ez130_8t
* Cell Name:    OA21X2
* View Name:    schematic
************************************************************************

.SUBCKT OA21X2 A B C VDD VNW VPW VSS Y
*.PININFO A:I B:I C:I Y:O VDD:B VNW:B VPW:B VSS:B
MN0 net1 A net24 VPW sg13_lv_nmos m=1 w=300.0n l=130.00n ng=1
MN3 net1 B net24 VPW sg13_lv_nmos m=1 w=300.0n l=130.00n ng=1
MN1 net24 C VSS VPW sg13_lv_nmos m=1 w=300.0n l=130.00n ng=1
MN5 Y net1 VSS VPW sg13_lv_nmos m=1 w=640.00n l=130.00n ng=1
MP3 net1 C VDD VNW sg13_lv_pmos m=1 w=480.00n l=130.00n ng=1
MP1 net4 A VDD VNW sg13_lv_pmos m=1 w=480.00n l=130.00n ng=1
MP0 net1 B net4 VNW sg13_lv_pmos m=1 w=480.00n l=130.00n ng=1
MP5 Y net1 VDD VNW sg13_lv_pmos m=1 w=980.00n l=130.00n ng=1
.ENDS

************************************************************************
* Library Name: ez130_8t
* Cell Name:    OA211X1
* View Name:    schematic
************************************************************************

.SUBCKT OA211X1 A B C D VDD VNW VPW VSS Y
*.PININFO A:I B:I C:I D:I Y:O VDD:B VNW:B VPW:B VSS:B
MP4 Y net2 VDD VNW sg13_lv_pmos m=1 w=480.00n l=130.00n ng=1
MP3 net1 A VDD VNW sg13_lv_pmos m=1 w=480.00n l=130.00n ng=1
MP2 net2 B net1 VNW sg13_lv_pmos m=1 w=480.00n l=130.00n ng=1
MP1 net2 D VDD VNW sg13_lv_pmos m=1 w=480.00n l=130.00n ng=1
MP0 net2 C VDD VNW sg13_lv_pmos m=1 w=480.00n l=130.00n ng=1
MN4 Y net2 VSS VPW sg13_lv_nmos m=1 w=300.0n l=130.00n ng=1
MN3 net4 D VSS VPW sg13_lv_nmos m=1 w=300.0n l=130.00n ng=1
MN2 net3 C net4 VPW sg13_lv_nmos m=1 w=300.0n l=130.00n ng=1
MN1 net2 A net3 VPW sg13_lv_nmos m=1 w=300.0n l=130.00n ng=1
MN0 net2 B net3 VPW sg13_lv_nmos m=1 w=300.0n l=130.00n ng=1
.ENDS

************************************************************************
* Library Name: ez130_8t
* Cell Name:    OA211X2
* View Name:    schematic
************************************************************************

.SUBCKT OA211X2 A B C D VDD VNW VPW VSS Y
*.PININFO A:I B:I C:I D:I Y:O VDD:B VNW:B VPW:B VSS:B
MP4 Y net2 VDD VNW sg13_lv_pmos m=1 w=980.00n l=130.00n ng=1
MP3 net1 A VDD VNW sg13_lv_pmos m=1 w=480.00n l=130.00n ng=1
MP2 net2 B net1 VNW sg13_lv_pmos m=1 w=480.00n l=130.00n ng=1
MP1 net2 D VDD VNW sg13_lv_pmos m=1 w=480.00n l=130.00n ng=1
MP0 net2 C VDD VNW sg13_lv_pmos m=1 w=480.00n l=130.00n ng=1
MN4 Y net2 VSS VPW sg13_lv_nmos m=1 w=640.00n l=130.00n ng=1
MN3 net4 D VSS VPW sg13_lv_nmos m=1 w=300.0n l=130.00n ng=1
MN2 net3 C net4 VPW sg13_lv_nmos m=1 w=300.0n l=130.00n ng=1
MN1 net2 A net3 VPW sg13_lv_nmos m=1 w=300.0n l=130.00n ng=1
MN0 net2 B net3 VPW sg13_lv_nmos m=1 w=300.0n l=130.00n ng=1
.ENDS

************************************************************************
* Library Name: ez130_8t
* Cell Name:    OAI2B2BX1
* View Name:    schematic
************************************************************************

.SUBCKT OAI2B2BX1 AB B CB D VDD VNW VPW VSS Y
*.PININFO AB:I B:I CB:I D:I Y:O VDD:B VNW:B VPW:B VSS:B
MN5 C CB VSS VPW sg13_lv_nmos m=1 w=300.0n l=130.00n ng=1
MN3 net9 D VSS VPW sg13_lv_nmos m=1 w=300.0n l=130.00n ng=1
MN2 Y B net9 VPW sg13_lv_nmos m=1 w=300.0n l=130.00n ng=1
MN1 net9 C VSS VPW sg13_lv_nmos m=1 w=300.0n l=130.00n ng=1
MN0 Y A net9 VPW sg13_lv_nmos m=1 w=300.0n l=130.00n ng=1
MN4 A AB VSS VPW sg13_lv_nmos m=1 w=300.0n l=130.00n ng=1
MP5 C CB VDD VNW sg13_lv_pmos m=1 w=480.00n l=130.00n ng=1
MP4 A AB VDD VNW sg13_lv_pmos m=1 w=480.00n l=130.00n ng=1
MP3 net3 D VDD VNW sg13_lv_pmos m=1 w=480.00n l=130.00n ng=1
MP2 Y C net3 VNW sg13_lv_pmos m=1 w=480.00n l=130.00n ng=1
MP1 net7 B VDD VNW sg13_lv_pmos m=1 w=480.00n l=130.00n ng=1
MP0 Y A net7 VNW sg13_lv_pmos m=1 w=480.00n l=130.00n ng=1
.ENDS

************************************************************************
* Library Name: ez130_8t
* Cell Name:    OAI2B2BX1P5
* View Name:    schematic
************************************************************************

.SUBCKT OAI2B2BX1P5 AB B CB D VDD VNW VPW VSS Y
*.PININFO AB:I B:I CB:I D:I Y:O VDD:B VNW:B VPW:B VSS:B
MN5 C CB VSS VPW sg13_lv_nmos m=1 w=300.0n l=130.00n ng=1
MN3 net9 D VSS VPW sg13_lv_nmos m=1 w=480.00n l=130.00n ng=1
MN2 Y B net9 VPW sg13_lv_nmos m=1 w=480.00n l=130.00n ng=1
MN1 net9 C VSS VPW sg13_lv_nmos m=1 w=480.00n l=130.00n ng=1
MN0 Y A net9 VPW sg13_lv_nmos m=1 w=480.00n l=130.00n ng=1
MN4 A AB VSS VPW sg13_lv_nmos m=1 w=300.0n l=130.00n ng=1
MP5 C CB VDD VNW sg13_lv_pmos m=1 w=480.00n l=130.00n ng=1
MP4 A AB VDD VNW sg13_lv_pmos m=1 w=480.00n l=130.00n ng=1
MP3 net3 D VDD VNW sg13_lv_pmos m=1 w=720.00n l=130.00n ng=1
MP2 Y C net3 VNW sg13_lv_pmos m=1 w=720.00n l=130.00n ng=1
MP1 net7 B VDD VNW sg13_lv_pmos m=1 w=720.00n l=130.00n ng=1
MP0 Y A net7 VNW sg13_lv_pmos m=1 w=720.00n l=130.00n ng=1
.ENDS

************************************************************************
* Library Name: ez130_8t
* Cell Name:    OAI2B2BX2
* View Name:    schematic
************************************************************************

.SUBCKT OAI2B2BX2 AB B CB D VDD VNW VPW VSS Y
*.PININFO AB:I B:I CB:I D:I Y:O VDD:B VNW:B VPW:B VSS:B
MN5 C CB VSS VPW sg13_lv_nmos m=1 w=300.0n l=130.00n ng=1
MN3 net9 D VSS VPW sg13_lv_nmos m=1 w=640.00n l=130.00n ng=1
MN2 Y B net9 VPW sg13_lv_nmos m=1 w=640.00n l=130.00n ng=1
MN1 net9 C VSS VPW sg13_lv_nmos m=1 w=640.00n l=130.00n ng=1
MN0 Y A net9 VPW sg13_lv_nmos m=1 w=640.00n l=130.00n ng=1
MN4 A AB VSS VPW sg13_lv_nmos m=1 w=300.0n l=130.00n ng=1
MP5 C CB VDD VNW sg13_lv_pmos m=1 w=480.00n l=130.00n ng=1
MP4 A AB VDD VNW sg13_lv_pmos m=1 w=480.00n l=130.00n ng=1
MP3 net3 D VDD VNW sg13_lv_pmos m=1 w=980.00n l=130.00n ng=1
MP2 Y C net3 VNW sg13_lv_pmos m=1 w=980.00n l=130.00n ng=1
MP1 net7 B VDD VNW sg13_lv_pmos m=1 w=980.00n l=130.00n ng=1
MP0 Y A net7 VNW sg13_lv_pmos m=1 w=980.00n l=130.00n ng=1
.ENDS

************************************************************************
* Library Name: ez130_8t
* Cell Name:    OAI2B2BX3
* View Name:    schematic
************************************************************************

.SUBCKT OAI2B2BX3 AB B CB D VDD VNW VPW VSS Y
*.PININFO AB:I B:I CB:I D:I Y:O VDD:B VNW:B VPW:B VSS:B
MN5 C CB VSS VPW sg13_lv_nmos m=1 w=300.0n l=130.00n ng=1
MN3 net9 D VSS VPW sg13_lv_nmos m=1 w=860.00n l=130.00n ng=1
MN2 Y B net9 VPW sg13_lv_nmos m=1 w=860.00n l=130.00n ng=1
MN1 net9 C VSS VPW sg13_lv_nmos m=1 w=860.00n l=130.00n ng=1
MN0 Y A net9 VPW sg13_lv_nmos m=1 w=860.00n l=130.00n ng=1
MN4 A AB VSS VPW sg13_lv_nmos m=1 w=300.0n l=130.00n ng=1
MP5 C CB VDD VNW sg13_lv_pmos m=1 w=480.00n l=130.00n ng=1
MP4 A AB VDD VNW sg13_lv_pmos m=1 w=480.00n l=130.00n ng=1
MP3 net3 D VDD VNW sg13_lv_pmos m=1 w=1.32u l=130.00n ng=1
MP2 Y C net3 VNW sg13_lv_pmos m=1 w=1.32u l=130.00n ng=1
MP1 net7 B VDD VNW sg13_lv_pmos m=1 w=1.32u l=130.00n ng=1
MP0 Y A net7 VNW sg13_lv_pmos m=1 w=1.32u l=130.00n ng=1
.ENDS

************************************************************************
* Library Name: ez130_8t
* Cell Name:    OAI2BB2X2
* View Name:    schematic
************************************************************************

.SUBCKT OAI2BB2X2 AB BB C D VDD VNW VPW VSS Y
*.PININFO AB:I BB:I C:I D:I Y:O VDD:B VNW:B VPW:B VSS:B
MP4 Y D net4 VNW sg13_lv_pmos m=1 w=980.00n l=130.00n ng=1
MP3 net4 C VDD VNW sg13_lv_pmos m=1 w=980.00n l=130.00n ng=1
MP2 Y net2 VDD VNW sg13_lv_pmos m=1 w=980.00n l=130.00n ng=1
MP1 net2 BB VDD VNW sg13_lv_pmos m=1 w=480.00n l=130.00n ng=1
MP0 net2 AB VDD VNW sg13_lv_pmos m=1 w=480.00n l=130.00n ng=1
MN4 net3 C VSS VPW sg13_lv_nmos m=1 w=640.00n l=130.00n ng=1
MN3 net3 D VSS VPW sg13_lv_nmos m=1 w=640.00n l=130.00n ng=1
MN2 Y net2 net3 VPW sg13_lv_nmos m=1 w=640.00n l=130.00n ng=1
MN1 net2 BB net1 VPW sg13_lv_nmos m=1 w=300.0n l=130.00n ng=1
MN0 net1 AB VSS VPW sg13_lv_nmos m=1 w=300.0n l=130.00n ng=1
.ENDS

************************************************************************
* Library Name: ez130_8t
* Cell Name:    OAI21X1
* View Name:    schematic
************************************************************************

.SUBCKT OAI21X1 A B C VDD VNW VPW VSS Y
*.PININFO A:I B:I C:I Y:O VDD:B VNW:B VPW:B VSS:B
MN2 Y C net18 VPW sg13_lv_nmos m=1 w=300.0n l=130.00n ng=1
MN1 net18 A VSS VPW sg13_lv_nmos m=1 w=300.0n l=130.00n ng=1
MN0 net18 B VSS VPW sg13_lv_nmos m=1 w=300.0n l=130.00n ng=1
MP0 net17 A VDD VNW sg13_lv_pmos m=1 w=480.00n l=130.00n ng=1
MP2 Y C VDD VNW sg13_lv_pmos m=1 w=480.00n l=130.00n ng=1
MP1 Y B net17 VNW sg13_lv_pmos m=1 w=480.00n l=130.00n ng=1
.ENDS

************************************************************************
* Library Name: ez130_8t
* Cell Name:    OAI21X2
* View Name:    schematic
************************************************************************

.SUBCKT OAI21X2 A B C VDD VNW VPW VSS Y
*.PININFO A:I B:I C:I Y:O VDD:B VNW:B VPW:B VSS:B
MP2 Y C VDD VNW sg13_lv_pmos m=1 w=980.00n l=130.00n ng=1
MP1 Y B net1 VNW sg13_lv_pmos m=1 w=980.00n l=130.00n ng=1
MP0 net1 A VDD VNW sg13_lv_pmos m=1 w=980.00n l=130.00n ng=1
MN2 Y C net3 VPW sg13_lv_nmos m=1 w=640.00n l=130.00n ng=1
MN1 net3 A VSS VPW sg13_lv_nmos m=1 w=640.00n l=130.00n ng=1
MN0 net3 B VSS VPW sg13_lv_nmos m=1 w=640.00n l=130.00n ng=1
.ENDS

************************************************************************
* Library Name: ez130_8t
* Cell Name:    OAI211X1
* View Name:    schematic
************************************************************************

.SUBCKT OAI211X1 A B C D VDD VNW VPW VSS Y
*.PININFO A:I B:I C:I D:I Y:O VDD:B VNW:B VPW:B VSS:B
MN4 net2 A VSS VPW sg13_lv_nmos m=1 w=300.0n l=130.00n ng=1
MN5 net2 B VSS VPW sg13_lv_nmos m=1 w=300.0n l=130.00n ng=1
MN6 net1 C net2 VPW sg13_lv_nmos m=1 w=300.0n l=130.00n ng=1
MN7 Y D net1 VPW sg13_lv_nmos m=1 w=300.0n l=130.00n ng=1
MP3 Y D VDD VNW sg13_lv_pmos m=1 w=480.00n l=130.00n ng=1
MP2 Y C VDD VNW sg13_lv_pmos m=1 w=480.00n l=130.00n ng=1
MP1 Y B net3 VNW sg13_lv_pmos m=1 w=480.00n l=130.00n ng=1
MP0 net3 A VDD VNW sg13_lv_pmos m=1 w=480.00n l=130.00n ng=1
.ENDS

************************************************************************
* Library Name: ez130_8t
* Cell Name:    OAI211X2
* View Name:    schematic
************************************************************************

.SUBCKT OAI211X2 A B C D VDD VNW VPW VSS Y
*.PININFO A:I B:I C:I D:I Y:O VDD:B VNW:B VPW:B VSS:B
MN4 net2 A VSS VPW sg13_lv_nmos m=1 w=640.00n l=130.00n ng=1
MN5 net2 B VSS VPW sg13_lv_nmos m=1 w=640.00n l=130.00n ng=1
MN6 net1 C net2 VPW sg13_lv_nmos m=1 w=640.00n l=130.00n ng=1
MN7 Y D net1 VPW sg13_lv_nmos m=1 w=640.00n l=130.00n ng=1
MP3 Y D VDD VNW sg13_lv_pmos m=1 w=980.00n l=130.00n ng=1
MP2 Y C VDD VNW sg13_lv_pmos m=1 w=980.00n l=130.00n ng=1
MP1 Y B net3 VNW sg13_lv_pmos m=1 w=980.00n l=130.00n ng=1
MP0 net3 A VDD VNW sg13_lv_pmos m=1 w=980.00n l=130.00n ng=1
.ENDS

************************************************************************
* Library Name: ez130_8t
* Cell Name:    OAI22X1
* View Name:    schematic
************************************************************************

.SUBCKT OAI22X1 A B C D VDD VNW VPW VSS Y
*.PININFO A:I B:I C:I D:I Y:O VDD:B VNW:B VPW:B VSS:B
MN2 Y D net7 VPW sg13_lv_nmos m=1 w=300.0n l=130.00n ng=1
MN0 Y C net7 VPW sg13_lv_nmos m=1 w=300.0n l=130.00n ng=1
MN3 net7 B VSS VPW sg13_lv_nmos m=1 w=300.0n l=130.00n ng=1
MN1 net7 A VSS VPW sg13_lv_nmos m=1 w=300.0n l=130.00n ng=1
MP3 net25 D VDD VNW sg13_lv_pmos m=1 w=480.00n l=130.00n ng=1
MP1 net24 A VDD VNW sg13_lv_pmos m=1 w=480.00n l=130.00n ng=1
MP2 Y C net25 VNW sg13_lv_pmos m=1 w=480.00n l=130.00n ng=1
MP0 Y B net24 VNW sg13_lv_pmos m=1 w=480.00n l=130.00n ng=1
.ENDS

************************************************************************
* Library Name: ez130_8t
* Cell Name:    OAI22X2
* View Name:    schematic
************************************************************************

.SUBCKT OAI22X2 A B C D VDD VNW VPW VSS Y
*.PININFO A:I B:I C:I D:I Y:O VDD:B VNW:B VPW:B VSS:B
MN2 Y D net7 VPW sg13_lv_nmos m=1 w=640.00n l=130.00n ng=1
MN0 Y C net7 VPW sg13_lv_nmos m=1 w=640.00n l=130.00n ng=1
MN3 net7 B VSS VPW sg13_lv_nmos m=1 w=640.00n l=130.00n ng=1
MN1 net7 A VSS VPW sg13_lv_nmos m=1 w=640.00n l=130.00n ng=1
MP3 net25 D VDD VNW sg13_lv_pmos m=1 w=980.00n l=130.00n ng=1
MP1 net24 A VDD VNW sg13_lv_pmos m=1 w=980.00n l=130.00n ng=1
MP2 Y C net25 VNW sg13_lv_pmos m=1 w=980.00n l=130.00n ng=1
MP0 Y B net24 VNW sg13_lv_pmos m=1 w=980.00n l=130.00n ng=1
.ENDS

************************************************************************
* Library Name: ez130_8t
* Cell Name:    OAI221X1
* View Name:    schematic
************************************************************************

.SUBCKT OAI221X1 A B C D E VDD VNW VPW VSS Y
*.PININFO A:I B:I C:I D:I E:I Y:O VDD:B VNW:B VPW:B VSS:B
MN7 net2 B VSS VPW sg13_lv_nmos m=1 w=300.0n l=130.00n ng=1
MN4 net2 A VSS VPW sg13_lv_nmos m=1 w=300.0n l=130.00n ng=1
MN3 Y C net13 VPW sg13_lv_nmos m=1 w=300.0n l=130.00n ng=1
MN6 Y D net13 VPW sg13_lv_nmos m=1 w=300.0n l=130.00n ng=1
MN0 net13 E net2 VPW sg13_lv_nmos m=1 w=300.0n l=130.00n ng=1
MP6 Y A net4 VNW sg13_lv_pmos m=1 w=480.00n l=130.00n ng=1
MP5 Y C net3 VNW sg13_lv_pmos m=1 w=480.00n l=130.00n ng=1
MP1 net4 B VDD VNW sg13_lv_pmos m=1 w=480.00n l=130.00n ng=1
MP0 net3 D VDD VNW sg13_lv_pmos m=1 w=480.00n l=130.00n ng=1
MP3 Y E VDD VNW sg13_lv_pmos m=1 w=480.00n l=130.00n ng=1
.ENDS

************************************************************************
* Library Name: ez130_8t
* Cell Name:    OAI221X2
* View Name:    schematic
************************************************************************

.SUBCKT OAI221X2 A B C D E VDD VNW VPW VSS Y
*.PININFO A:I B:I C:I D:I E:I Y:O VDD:B VNW:B VPW:B VSS:B
MN7 net2 B VSS VPW sg13_lv_nmos m=1 w=640.00n l=130.00n ng=1
MN4 net2 A VSS VPW sg13_lv_nmos m=1 w=640.00n l=130.00n ng=1
MN3 Y C net13 VPW sg13_lv_nmos m=1 w=640.00n l=130.00n ng=1
MN6 Y D net13 VPW sg13_lv_nmos m=1 w=640.00n l=130.00n ng=1
MN0 net13 E net2 VPW sg13_lv_nmos m=1 w=640.00n l=130.00n ng=1
MP6 Y A net4 VNW sg13_lv_pmos m=1 w=980.00n l=130.00n ng=1
MP5 Y C net3 VNW sg13_lv_pmos m=1 w=980.00n l=130.00n ng=1
MP1 net4 B VDD VNW sg13_lv_pmos m=1 w=980.00n l=130.00n ng=1
MP0 net3 D VDD VNW sg13_lv_pmos m=1 w=980.00n l=130.00n ng=1
MP3 Y E VDD VNW sg13_lv_pmos m=1 w=980.00n l=130.00n ng=1
.ENDS

************************************************************************
* Library Name: ez130_8t
* Cell Name:    OAOI211X1
* View Name:    schematic
************************************************************************

.SUBCKT OAOI211X1 A B C D VDD VNW VPW VSS Y
*.PININFO A:I B:I C:I D:I Y:O VDD:B VNW:B VPW:B VSS:B
MN3 Y D VSS VPW sg13_lv_nmos m=1 w=300.0n l=130.00n ng=1
MN2 net3 C VSS VPW sg13_lv_nmos m=1 w=300.0n l=130.00n ng=1
MN1 Y B net3 VPW sg13_lv_nmos m=1 w=300.0n l=130.00n ng=1
MN0 Y A net3 VPW sg13_lv_nmos m=1 w=300.0n l=130.00n ng=1
MP3 Y B net2 VNW sg13_lv_pmos m=1 w=480.00n l=130.00n ng=1
MP2 Y C net1 VNW sg13_lv_pmos m=1 w=480.00n l=130.00n ng=1
MP1 net2 A net1 VNW sg13_lv_pmos m=1 w=480.00n l=130.00n ng=1
MP0 net1 D VDD VNW sg13_lv_pmos m=1 w=480.00n l=130.00n ng=1
.ENDS

************************************************************************
* Library Name: ez130_8t
* Cell Name:    OAOI211X2
* View Name:    schematic
************************************************************************

.SUBCKT OAOI211X2 A B C D VDD VNW VPW VSS Y
*.PININFO A:I B:I C:I D:I Y:O VDD:B VNW:B VPW:B VSS:B
MN3 Y D VSS VPW sg13_lv_nmos m=1 w=640.00n l=130.00n ng=1
MN2 net3 C VSS VPW sg13_lv_nmos m=1 w=640.00n l=130.00n ng=1
MN1 Y B net3 VPW sg13_lv_nmos m=1 w=640.00n l=130.00n ng=1
MN0 Y A net3 VPW sg13_lv_nmos m=1 w=640.00n l=130.00n ng=1
MP3 Y B net2 VNW sg13_lv_pmos m=1 w=980.00n l=130.00n ng=1
MP2 Y C net1 VNW sg13_lv_pmos m=1 w=980.00n l=130.00n ng=1
MP1 net2 A net1 VNW sg13_lv_pmos m=1 w=980.00n l=130.00n ng=1
MP0 net1 D VDD VNW sg13_lv_pmos m=1 w=980.00n l=130.00n ng=1
.ENDS

************************************************************************
* Library Name: ez130_8t
* Cell Name:    OAI31X1
* View Name:    schematic
************************************************************************

.SUBCKT OAI31X1 A B C D VDD VNW VPW VSS Y
*.PININFO A:I B:I C:I D:I Y:O VDD:B VNW:B VPW:B VSS:B
MN3 net5 C VSS VPW sg13_lv_nmos m=1 w=300.0n l=130.00n ng=1
MN2 net5 B VSS VPW sg13_lv_nmos m=1 w=300.0n l=130.00n ng=1
MN1 net5 A VSS VPW sg13_lv_nmos m=1 w=300.0n l=130.00n ng=1
MN0 Y D net5 VPW sg13_lv_nmos m=1 w=300.0n l=130.00n ng=1
MP1 net9 A VDD VNW sg13_lv_pmos m=1 w=480.00n l=130.00n ng=1
MP0 Y C net8 VNW sg13_lv_pmos m=1 w=480.00n l=130.00n ng=1
MP3 net8 B net9 VNW sg13_lv_pmos m=1 w=480.00n l=130.00n ng=1
MP2 Y D VDD VNW sg13_lv_pmos m=1 w=480.00n l=130.00n ng=1
.ENDS

************************************************************************
* Library Name: ez130_8t
* Cell Name:    OAI31X2
* View Name:    schematic
************************************************************************

.SUBCKT OAI31X2 A B C D VDD VNW VPW VSS Y
*.PININFO A:I B:I C:I D:I Y:O VDD:B VNW:B VPW:B VSS:B
MN3 net5 C VSS VPW sg13_lv_nmos m=1 w=640.00n l=130.00n ng=1
MN2 net5 B VSS VPW sg13_lv_nmos m=1 w=640.00n l=130.00n ng=1
MN1 net5 A VSS VPW sg13_lv_nmos m=1 w=640.00n l=130.00n ng=1
MN0 Y D net5 VPW sg13_lv_nmos m=1 w=640.00n l=130.00n ng=1
MP1 net9 A VDD VNW sg13_lv_pmos m=1 w=980.00n l=130.00n ng=1
MP0 Y C net8 VNW sg13_lv_pmos m=1 w=980.00n l=130.00n ng=1
MP3 net8 B net9 VNW sg13_lv_pmos m=1 w=980.00n l=130.00n ng=1
MP2 Y D VDD VNW sg13_lv_pmos m=1 w=980.00n l=130.00n ng=1
.ENDS

************************************************************************
* Library Name: ez130_8t
* Cell Name:    OR2X1
* View Name:    schematic
************************************************************************

.SUBCKT OR2X1 A B VDD VNW VPW VSS Y
*.PININFO A:I B:I Y:O VDD:B VNW:B VPW:B VSS:B
MN2 Y net11 VSS VPW sg13_lv_nmos m=1 w=300.0n l=130.00n ng=1
MN1 net11 B VSS VPW sg13_lv_nmos m=1 w=300.0n l=130.00n ng=1
MN0 net11 A VSS VPW sg13_lv_nmos m=1 w=300.0n l=130.00n ng=1
MP2 Y net11 VDD VNW sg13_lv_pmos m=1 w=480.00n l=130.00n ng=1
MP1 net22 B VDD VNW sg13_lv_pmos m=1 w=480.00n l=130.00n ng=1
MP0 net11 A net22 VNW sg13_lv_pmos m=1 w=480.00n l=130.00n ng=1
.ENDS

************************************************************************
* Library Name: ez130_8t
* Cell Name:    OR2X2
* View Name:    schematic
************************************************************************

.SUBCKT OR2X2 A B VDD VNW VPW VSS Y
*.PININFO A:I B:I Y:O VDD:B VNW:B VPW:B VSS:B
MN2 Y net11 VSS VPW sg13_lv_nmos m=1 w=640.00n l=130.00n ng=1
MN1 net11 B VSS VPW sg13_lv_nmos m=1 w=300.0n l=130.00n ng=1
MN0 net11 A VSS VPW sg13_lv_nmos m=1 w=300.0n l=130.00n ng=1
MP2 Y net11 VDD VNW sg13_lv_pmos m=1 w=980.00n l=130.00n ng=1
MP1 net22 B VDD VNW sg13_lv_pmos m=1 w=480.00n l=130.00n ng=1
MP0 net11 A net22 VNW sg13_lv_pmos m=1 w=480.00n l=130.00n ng=1
.ENDS

************************************************************************
* Library Name: ez130_8t
* Cell Name:    OR2X3
* View Name:    schematic
************************************************************************

.SUBCKT OR2X3 A B VDD VNW VPW VSS Y
*.PININFO A:I B:I Y:O VDD:B VNW:B VPW:B VSS:B
MN2 Y net11 VSS VPW sg13_lv_nmos m=1 w=860.00n l=130.00n ng=1
MN1 net11 B VSS VPW sg13_lv_nmos m=1 w=300.0n l=130.00n ng=1
MN0 net11 A VSS VPW sg13_lv_nmos m=1 w=300.0n l=130.00n ng=1
MP2 Y net11 VDD VNW sg13_lv_pmos m=1 w=1.32u l=130.00n ng=1
MP1 net22 B VDD VNW sg13_lv_pmos m=1 w=480.00n l=130.00n ng=1
MP0 net11 A net22 VNW sg13_lv_pmos m=1 w=480.00n l=130.00n ng=1
.ENDS

************************************************************************
* Library Name: ez130_8t
* Cell Name:    OR3X1
* View Name:    schematic
************************************************************************

.SUBCKT OR3X1 A B C VDD VNW VPW VSS Y
*.PININFO A:I B:I C:I Y:O VDD:B VNW:B VPW:B VSS:B
MP4 Y net2 VDD VNW sg13_lv_pmos m=1 w=480.00n l=130.00n ng=1
MP2 net2 C net3 VNW sg13_lv_pmos m=1 w=480.00n l=130.00n ng=1
MP1 net3 B net1 VNW sg13_lv_pmos m=1 w=480.00n l=130.00n ng=1
MP3 net1 A VDD VNW sg13_lv_pmos m=1 w=480.00n l=130.00n ng=1
MN3 Y net2 VSS VPW sg13_lv_nmos m=1 w=300.0n l=130.00n ng=1
MN2 net2 C VSS VPW sg13_lv_nmos m=1 w=300.0n l=130.00n ng=1
MN1 net2 B VSS VPW sg13_lv_nmos m=1 w=300.0n l=130.00n ng=1
MN0 net2 A VSS VPW sg13_lv_nmos m=1 w=300.0n l=130.00n ng=1
.ENDS

************************************************************************
* Library Name: ez130_8t
* Cell Name:    OR3X2
* View Name:    schematic
************************************************************************

.SUBCKT OR3X2 A B C VDD VNW VPW VSS Y
*.PININFO A:I B:I C:I Y:O VDD:B VNW:B VPW:B VSS:B
MP4 Y net2 VDD VNW sg13_lv_pmos m=1 w=980.00n l=130.00n ng=1
MP2 net2 C net3 VNW sg13_lv_pmos m=1 w=480.00n l=130.00n ng=1
MP1 net3 B net1 VNW sg13_lv_pmos m=1 w=480.00n l=130.00n ng=1
MP3 net1 A VDD VNW sg13_lv_pmos m=1 w=480.00n l=130.00n ng=1
MN3 Y net2 VSS VPW sg13_lv_nmos m=1 w=640.00n l=130.00n ng=1
MN2 net2 C VSS VPW sg13_lv_nmos m=1 w=300.0n l=130.00n ng=1
MN1 net2 B VSS VPW sg13_lv_nmos m=1 w=300.0n l=130.00n ng=1
MN0 net2 A VSS VPW sg13_lv_nmos m=1 w=300.0n l=130.00n ng=1
.ENDS

************************************************************************
* Library Name: ez130_8t
* Cell Name:    OR4X1
* View Name:    schematic
************************************************************************

.SUBCKT OR4X1 A B VDD VNW VPW VSS Y C D
*.PININFO A:I B:I C:I D:I Y:O VDD:B VNW:B VPW:B VSS:B
MN3 net11 C VSS VPW sg13_lv_nmos m=1 w=300.0n l=130.00n ng=1
MN2 Y net11 VSS VPW sg13_lv_nmos m=1 w=300.0n l=130.00n ng=1
MN4 net11 D VSS VPW sg13_lv_nmos m=1 w=300.0n l=130.00n ng=1
MN1 net11 B VSS VPW sg13_lv_nmos m=1 w=300.0n l=130.00n ng=1
MN0 net11 A VSS VPW sg13_lv_nmos m=1 w=300.0n l=130.00n ng=1
MP2 Y net11 VDD VNW sg13_lv_pmos m=1 w=480.00n l=130.00n ng=1
MP3 net2 C net1 VNW sg13_lv_pmos m=1 w=480.00n l=130.00n ng=1
MP1 net22 B net2 VNW sg13_lv_pmos m=1 w=480.00n l=130.00n ng=1
MP0 net11 A net22 VNW sg13_lv_pmos m=1 w=480.00n l=130.00n ng=1
MP4 net1 D VDD VNW sg13_lv_pmos m=1 w=480.00n l=130.00n ng=1
.ENDS

************************************************************************
* Library Name: ez130_8t
* Cell Name:    OR4X2
* View Name:    schematic
************************************************************************

.SUBCKT OR4X2 A B VDD VNW VPW VSS Y C D
*.PININFO A:I B:I C:I D:I Y:O VDD:B VNW:B VPW:B VSS:B
MN3 net11 C VSS VPW sg13_lv_nmos m=1 w=300.0n l=130.00n ng=1
MN2 Y net11 VSS VPW sg13_lv_nmos m=1 w=640.00n l=130.00n ng=1
MN4 net11 D VSS VPW sg13_lv_nmos m=1 w=300.0n l=130.00n ng=1
MN1 net11 B VSS VPW sg13_lv_nmos m=1 w=300.0n l=130.00n ng=1
MN0 net11 A VSS VPW sg13_lv_nmos m=1 w=300.0n l=130.00n ng=1
MP2 Y net11 VDD VNW sg13_lv_pmos m=1 w=980.00n l=130.00n ng=1
MP3 net2 C net1 VNW sg13_lv_pmos m=1 w=480.00n l=130.00n ng=1
MP1 net22 B net2 VNW sg13_lv_pmos m=1 w=480.00n l=130.00n ng=1
MP0 net11 A net22 VNW sg13_lv_pmos m=1 w=480.00n l=130.00n ng=1
MP4 net1 D VDD VNW sg13_lv_pmos m=1 w=480.00n l=130.00n ng=1
.ENDS

************************************************************************
* Library Name: ez130_8t
* Cell Name:    OR3BX1
* View Name:    schematic
************************************************************************

.SUBCKT OR3BX1 AB B C VDD VNW VPW VSS Y
*.PININFO AB:I B:I C:I Y:O VDD:B VNW:B VPW:B VSS:B
MN11 net14 BNORC VSS VPW sg13_lv_nmos m=1 w=300.0n l=130.00n ng=1
MN10 Y AB net14 VPW sg13_lv_nmos m=1 w=300.0n l=130.00n ng=1
MN9 BNORC B VSS VPW sg13_lv_nmos m=1 w=300.0n l=130.00n ng=1
MN8 BNORC C VSS VPW sg13_lv_nmos m=1 w=300.0n l=130.00n ng=1
MP5 Y BNORC VDD VNW sg13_lv_pmos m=1 w=480.00n l=130.00n ng=1
MP4 Y AB VDD VNW sg13_lv_pmos m=1 w=480.00n l=130.00n ng=1
MP3 net1 C VDD VNW sg13_lv_pmos m=1 w=480.00n l=130.00n ng=1
MP2 BNORC B net1 VNW sg13_lv_pmos m=1 w=480.00n l=130.00n ng=1
.ENDS

************************************************************************
* Library Name: ez130_8t
* Cell Name:    OR3BX2
* View Name:    schematic
************************************************************************

.SUBCKT OR3BX2 AB B C VDD VNW VPW VSS Y
*.PININFO AB:I B:I C:I Y:O VDD:B VNW:B VPW:B VSS:B
MN7 net1 BNORC VSS VPW sg13_lv_nmos m=1 w=640.00n l=130.00n ng=1
MN1 Y AB net1 VPW sg13_lv_nmos m=1 w=640.00n l=130.00n ng=1
MN2 BNORC B VSS VPW sg13_lv_nmos m=1 w=300.0n l=130.00n ng=1
MN3 BNORC C VSS VPW sg13_lv_nmos m=1 w=300.0n l=130.00n ng=1
MP1 Y BNORC VDD VNW sg13_lv_pmos m=1 w=980.00n l=130.00n ng=1
MP0 Y AB VDD VNW sg13_lv_pmos m=1 w=980.00n l=130.00n ng=1
MN6 net11 C VDD VNW sg13_lv_pmos m=1 w=480.00n l=130.00n ng=1
MN5 BNORC B net11 VNW sg13_lv_pmos m=1 w=480.00n l=130.00n ng=1
.ENDS

************************************************************************
* Library Name: ez130_8t
* Cell Name:    TBUFX1
* View Name:    schematic
************************************************************************

.SUBCKT TBUFX1 A E VDD VNW VPW VSS Y
*.PININFO A:I E:I Y:O VDD:B VNW:B VPW:B VSS:B
MN3 Y net7 VSS VPW sg13_lv_nmos m=1 w=300.0n l=130.00n ng=1
MN2 net13 E net7 VPW sg13_lv_nmos m=1 w=300.0n l=130.00n ng=1
MN4 ENB E VSS VPW sg13_lv_nmos m=1 w=300.0n l=130.00n ng=1
MN0 net7 A VSS VPW sg13_lv_nmos m=1 w=300.0n l=130.00n ng=1
MN1 net7 ENB VSS VPW sg13_lv_nmos m=1 w=300.0n l=130.00n ng=1
MP3 net7 ENB net13 VNW sg13_lv_pmos m=1 w=480.00n l=130.00n ng=1
MP2 Y net13 VDD VNW sg13_lv_pmos m=1 w=480.00n l=130.00n ng=1
MP1 net13 E VDD VNW sg13_lv_pmos m=1 w=480.00n l=130.00n ng=1
MP4 ENB E VDD VNW sg13_lv_pmos m=1 w=480.00n l=130.00n ng=1
MP0 net13 A VDD VNW sg13_lv_pmos m=1 w=480.00n l=130.00n ng=1
.ENDS

************************************************************************
* Library Name: ez130_8t
* Cell Name:    TBUFX2
* View Name:    schematic
************************************************************************

.SUBCKT TBUFX2 A E VDD VNW VPW VSS Y
*.PININFO A:I E:I Y:O VDD:B VNW:B VPW:B VSS:B
MN3 Y net7 VSS VPW sg13_lv_nmos m=1 w=640.00n l=130.00n ng=1
MN2 net13 E net7 VPW sg13_lv_nmos m=1 w=300.0n l=130.00n ng=1
MN4 ENB E VSS VPW sg13_lv_nmos m=1 w=300.0n l=130.00n ng=1
MN0 net7 A VSS VPW sg13_lv_nmos m=1 w=300.0n l=130.00n ng=1
MN1 net7 ENB VSS VPW sg13_lv_nmos m=1 w=300.0n l=130.00n ng=1
MP3 net7 ENB net13 VNW sg13_lv_pmos m=1 w=480.00n l=130.00n ng=1
MP2 Y net13 VDD VNW sg13_lv_pmos m=1 w=980.00n l=130.00n ng=2
MP1 net13 E VDD VNW sg13_lv_pmos m=1 w=480.00n l=130.00n ng=1
MP4 ENB E VDD VNW sg13_lv_pmos m=1 w=480.00n l=130.00n ng=1
MP0 net13 A VDD VNW sg13_lv_pmos m=1 w=490.00n l=130.00n ng=1
.ENDS

************************************************************************
* Library Name: ez130_8t
* Cell Name:    TIEHI
* View Name:    schematic
************************************************************************

.SUBCKT TIEHI VDD VNW VPW VSS Y
*.PININFO Y:O VDD:B VNW:B VPW:B VSS:B
MP1 Y net5 VDD VNW sg13_lv_pmos m=1 w=980.00n l=130.00n ng=1
MN1 net5 net5 VSS VPW sg13_lv_nmos m=1 w=300.0n l=130.00n ng=1
.ENDS

************************************************************************
* Library Name: ez130_8t
* Cell Name:    TIELO
* View Name:    schematic
************************************************************************

.SUBCKT TIELO VDD VNW VPW VSS Y
*.PININFO Y:O VDD:B VNW:B VPW:B VSS:B
MP1 net5 net5 VDD VNW sg13_lv_pmos m=1 w=480.00n l=130.00n ng=1
MN1 Y net5 VSS VPW sg13_lv_nmos m=1 w=640.00n l=130.00n ng=1
.ENDS

************************************************************************
* Library Name: ez130_8t
* Cell Name:    TINVX1
* View Name:    schematic
************************************************************************

.SUBCKT TINVX1 A E VDD VNW VPW VSS Y
*.PININFO A:I E:I Y:O VDD:B VNW:B VPW:B VSS:B
MN4 ENB E VSS VPW sg13_lv_nmos m=1 w=300.0n l=130.00n ng=1
MN1 net1 E VSS VPW sg13_lv_nmos m=1 w=300.0n l=130.00n ng=1
MN0 Y A net1 VPW sg13_lv_nmos m=1 w=300.0n l=130.00n ng=1
MP4 ENB E VDD VNW sg13_lv_pmos m=1 w=480.00n l=130.00n ng=1
MP1 net3 ENB VDD VNW sg13_lv_pmos m=1 w=480.00n l=130.00n ng=1
MP0 Y A net3 VNW sg13_lv_pmos m=1 w=480.00n l=130.00n ng=1
.ENDS

************************************************************************
* Library Name: ez130_8t
* Cell Name:    TINVX2
* View Name:    schematic
************************************************************************

.SUBCKT TINVX2 A E VDD VNW VPW VSS Y
*.PININFO A:I E:I Y:O VDD:B VNW:B VPW:B VSS:B
MN4 ENB E VSS VPW sg13_lv_nmos m=1 w=300.0n l=130.00n ng=1
MN1 net1 E VSS VPW sg13_lv_nmos m=1 w=640.00n l=130.00n ng=1
MN0 Y A net1 VPW sg13_lv_nmos m=1 w=640.00n l=130.00n ng=1
MP4 ENB E VDD VNW sg13_lv_pmos m=1 w=480.00n l=130.00n ng=1
MP1 net3 ENB VDD VNW sg13_lv_pmos m=1 w=980.00n l=130.00n ng=1
MP0 Y A net3 VNW sg13_lv_pmos m=1 w=980.00n l=130.00n ng=1
.ENDS

************************************************************************
* Library Name: ez130_8t
* Cell Name:    XNOR2X1
* View Name:    schematic
************************************************************************

.SUBCKT XNOR2X1 A B VDD VNW VPW VSS Y
*.PININFO A:I B:I Y:O VDD:B VNW:B VPW:B VSS:B
MN2 net7 net2 VSS VPW sg13_lv_nmos m=1 w=300.0n l=130.00n ng=1
MN0 net3 A VSS VPW sg13_lv_nmos m=1 w=300.0n l=130.00n ng=1
MN3 Y A net7 VPW sg13_lv_nmos m=1 w=300.0n l=130.00n ng=1
MN1 net2 B net3 VPW sg13_lv_nmos m=1 w=300.0n l=130.00n ng=1
MN4 Y B net7 VPW sg13_lv_nmos m=1 w=300.0n l=130.00n ng=1
MP4 net4 A VDD VNW sg13_lv_pmos m=1 w=480.00n l=130.00n ng=1
MP0 net2 A VDD VNW sg13_lv_pmos m=1 w=480.00n l=130.00n ng=1
MP2 Y net2 VDD VNW sg13_lv_pmos m=1 w=480.00n l=130.00n ng=1
MP1 net2 B VDD VNW sg13_lv_pmos m=1 w=480.00n l=130.00n ng=1
MP3 Y B net4 VNW sg13_lv_pmos m=1 w=480.00n l=130.00n ng=1
.ENDS

************************************************************************
* Library Name: ez130_8t
* Cell Name:    XNOR2X2
* View Name:    schematic
************************************************************************

.SUBCKT XNOR2X2 A B VDD VNW VPW VSS Y
*.PININFO A:I B:I Y:O VDD:B VNW:B VPW:B VSS:B
MN2 net7 net2 VSS VPW sg13_lv_nmos m=1 w=680.00n l=130.00n ng=1
MN0 net3 A VSS VPW sg13_lv_nmos m=1 w=300.0n l=130.00n ng=1
MN3 Y A net7 VPW sg13_lv_nmos m=1 w=680.00n l=130.00n ng=1
MN1 net2 B net3 VPW sg13_lv_nmos m=1 w=300.0n l=130.00n ng=1
MN4 Y B net7 VPW sg13_lv_nmos m=1 w=680.00n l=130.00n ng=1
MP4 net4 A VDD VNW sg13_lv_pmos m=1 w=940.00n l=130.00n ng=1
MP0 net2 A VDD VNW sg13_lv_pmos m=1 w=480.00n l=130.00n ng=1
MP2 Y net2 VDD VNW sg13_lv_pmos m=1 w=940.00n l=130.00n ng=1
MP1 net2 B VDD VNW sg13_lv_pmos m=1 w=480.00n l=130.00n ng=1
MP3 Y B net4 VNW sg13_lv_pmos m=1 w=940.00n l=130.00n ng=1
.ENDS

************************************************************************
* Library Name: ez130_8t
* Cell Name:    XNOR3X1
* View Name:    schematic
************************************************************************

.SUBCKT XNOR3X1 A B C VDD VNW VPW VSS Y
*.PININFO A:I B:I C:I Y:O VDD:B VNW:B VPW:B VSS:B
MN11 net5 AI VSS VPW sg13_lv_nmos m=1 w=300.0n l=130.00n ng=1
MN14 net2 C net3 VPW sg13_lv_nmos m=1 w=300.0n l=130.00n ng=1
MN15 net3 net1 VSS VPW sg13_lv_nmos m=1 w=300.0n l=130.00n ng=1
MN9 AI B net1 VPW sg13_lv_nmos m=1 w=300.0n l=130.00n ng=1
MN13 Y net2 VSS VPW sg13_lv_nmos m=1 w=300.0n l=130.00n ng=1
MN7 net1 CI net2 VPW sg13_lv_nmos m=1 w=300.0n l=130.00n ng=1
MN4 net1 BI net5 VPW sg13_lv_nmos m=1 w=300.0n l=130.00n ng=1
MN2 CI C VSS VPW sg13_lv_nmos m=1 w=300.0n l=130.00n ng=1
MN1 BI B VSS VPW sg13_lv_nmos m=1 w=300.0n l=130.00n ng=1
MN0 AI A VSS VPW sg13_lv_nmos m=1 w=300.0n l=130.00n ng=1
MP11 net6 AI VDD VNW sg13_lv_pmos m=1 w=480.00n l=130.00n ng=1
MP10 AI A VDD VNW sg13_lv_pmos m=1 w=480.00n l=130.00n ng=1
MP9 BI B VDD VNW sg13_lv_pmos m=1 w=480.00n l=130.00n ng=1
MP8 CI C VDD VNW sg13_lv_pmos m=1 w=480.00n l=130.00n ng=1
MP6 net1 B net6 VNW sg13_lv_pmos m=1 w=480.00n l=130.00n ng=1
MP14 net4 net1 VDD VNW sg13_lv_pmos m=1 w=480.00n l=130.00n ng=1
MP3 net1 C net2 VNW sg13_lv_pmos m=1 w=480.00n l=130.00n ng=1
MP1 AI BI net1 VNW sg13_lv_pmos m=1 w=480.00n l=130.00n ng=1
MP15 net2 CI net4 VNW sg13_lv_pmos m=1 w=480.00n l=130.00n ng=1
MP13 Y net2 VDD VNW sg13_lv_pmos m=1 w=480.00n l=130.00n ng=1
.ENDS

************************************************************************
* Library Name: ez130_8t
* Cell Name:    XNOR3X2
* View Name:    schematic
************************************************************************

.SUBCKT XNOR3X2 A B C VDD VNW VPW VSS Y
*.PININFO A:I B:I C:I Y:O VDD:B VNW:B VPW:B VSS:B
MN11 net5 AI VSS VPW sg13_lv_nmos m=1 w=300.0n l=130.00n ng=1
MN14 net2 C net3 VPW sg13_lv_nmos m=1 w=300.0n l=130.00n ng=1
MN15 net3 net1 VSS VPW sg13_lv_nmos m=1 w=300.0n l=130.00n ng=1
MN9 AI B net1 VPW sg13_lv_nmos m=1 w=300.0n l=130.00n ng=1
MN13 Y net2 VSS VPW sg13_lv_nmos m=1 w=640.00n l=130.00n ng=1
MN7 net1 CI net2 VPW sg13_lv_nmos m=1 w=300.0n l=130.00n ng=1
MN4 net1 BI net5 VPW sg13_lv_nmos m=1 w=300.0n l=130.00n ng=1
MN2 CI C VSS VPW sg13_lv_nmos m=1 w=300.0n l=130.00n ng=1
MN1 BI B VSS VPW sg13_lv_nmos m=1 w=300.0n l=130.00n ng=1
MN0 AI A VSS VPW sg13_lv_nmos m=1 w=300.0n l=130.00n ng=1
MP11 net6 AI VDD VNW sg13_lv_pmos m=1 w=480.00n l=130.00n ng=1
MP10 AI A VDD VNW sg13_lv_pmos m=1 w=480.00n l=130.00n ng=1
MP9 BI B VDD VNW sg13_lv_pmos m=1 w=480.00n l=130.00n ng=1
MP8 CI C VDD VNW sg13_lv_pmos m=1 w=480.00n l=130.00n ng=1
MP6 net1 B net6 VNW sg13_lv_pmos m=1 w=480.00n l=130.00n ng=1
MP14 net4 net1 VDD VNW sg13_lv_pmos m=1 w=480.00n l=130.00n ng=1
MP3 net1 C net2 VNW sg13_lv_pmos m=1 w=480.00n l=130.00n ng=1
MP1 AI BI net1 VNW sg13_lv_pmos m=1 w=480.00n l=130.00n ng=1
MP15 net2 CI net4 VNW sg13_lv_pmos m=1 w=480.00n l=130.00n ng=1
MP13 Y net2 VDD VNW sg13_lv_pmos m=1 w=980.00n l=130.00n ng=1
.ENDS

************************************************************************
* Library Name: ez130_8t
* Cell Name:    XOR2X1
* View Name:    schematic
************************************************************************

.SUBCKT XOR2X1 A B VDD VNW VPW VSS Y
*.PININFO A:I B:I Y:O VDD:B VNW:B VPW:B VSS:B
MN6 I A VSS VPW sg13_lv_nmos m=1 w=300.0n l=130.00n ng=1
MN4 net2 A VSS VPW sg13_lv_nmos m=1 w=300.0n l=130.00n ng=1
MN3 Y B net2 VPW sg13_lv_nmos m=1 w=300.0n l=130.00n ng=1
MN2 Y I VSS VPW sg13_lv_nmos m=1 w=300.0n l=130.00n ng=1
MN0 I B VSS VPW sg13_lv_nmos m=1 w=300.0n l=130.00n ng=1
MP5 I B net5 VNW sg13_lv_pmos m=1 w=480.00n l=130.00n ng=1
MP4 net5 A VDD VNW sg13_lv_pmos m=1 w=480.00n l=130.00n ng=1
MP3 Y B net1 VNW sg13_lv_pmos m=1 w=480.00n l=130.00n ng=1
MP1 Y A net1 VNW sg13_lv_pmos m=1 w=480.00n l=130.00n ng=1
MP0 net1 I VDD VNW sg13_lv_pmos m=1 w=480.00n l=130.00n ng=1
.ENDS

************************************************************************
* Library Name: ez130_8t
* Cell Name:    XOR2X2
* View Name:    schematic
************************************************************************

.SUBCKT XOR2X2 A B VDD VNW VPW VSS Y
*.PININFO A:I B:I Y:O VDD:B VNW:B VPW:B VSS:B
MN6 I A VSS VPW sg13_lv_nmos m=1 w=300.0n l=130.00n ng=1
MN4 net2 A VSS VPW sg13_lv_nmos m=1 w=640.00n l=130.00n ng=1
MN3 Y B net2 VPW sg13_lv_nmos m=1 w=640.00n l=130.00n ng=1
MN2 Y I VSS VPW sg13_lv_nmos m=1 w=640.00n l=130.00n ng=1
MN0 I B VSS VPW sg13_lv_nmos m=1 w=300.0n l=130.00n ng=1
MP5 I B net5 VNW sg13_lv_pmos m=1 w=480.00n l=130.00n ng=1
MP4 net5 A VDD VNW sg13_lv_pmos m=1 w=480.00n l=130.00n ng=1
MP3 Y B net1 VNW sg13_lv_pmos m=1 w=980.00n l=130.00n ng=1
MP1 Y A net1 VNW sg13_lv_pmos m=1 w=980.00n l=130.00n ng=1
MP0 net1 I VDD VNW sg13_lv_pmos m=1 w=980.00n l=130.00n ng=1
.ENDS

************************************************************************
* Library Name: ez130_8t
* Cell Name:    XOR3X1
* View Name:    schematic
************************************************************************

.SUBCKT XOR3X1 A B C VDD VNW VPW VSS Y
*.PININFO A:I B:I C:I Y:O VDD:B VNW:B VPW:B VSS:B
MN11 net5 AI VSS VPW sg13_lv_nmos m=1 w=300.0n l=130.00n ng=1
MN14 net2 CI net3 VPW sg13_lv_nmos m=1 w=300.0n l=130.00n ng=1
MN15 net3 net1 VSS VPW sg13_lv_nmos m=1 w=300.0n l=130.00n ng=1
MN9 AI B net1 VPW sg13_lv_nmos m=1 w=300.0n l=130.00n ng=1
MN13 Y net2 VSS VPW sg13_lv_nmos m=1 w=300.0n l=130.00n ng=1
MN7 net1 C net2 VPW sg13_lv_nmos m=1 w=300.0n l=130.00n ng=1
MN4 net1 BI net5 VPW sg13_lv_nmos m=1 w=300.0n l=130.00n ng=1
MN2 CI C VSS VPW sg13_lv_nmos m=1 w=300.0n l=130.00n ng=1
MN1 BI B VSS VPW sg13_lv_nmos m=1 w=300.0n l=130.00n ng=1
MN0 AI A VSS VPW sg13_lv_nmos m=1 w=300.0n l=130.00n ng=1
MP11 net6 AI VDD VNW sg13_lv_pmos m=1 w=480.00n l=130.00n ng=1
MP10 AI A VDD VNW sg13_lv_pmos m=1 w=480.00n l=130.00n ng=1
MP9 BI B VDD VNW sg13_lv_pmos m=1 w=480.00n l=130.00n ng=1
MP8 CI C VDD VNW sg13_lv_pmos m=1 w=480.00n l=130.00n ng=1
MP6 net1 B net6 VNW sg13_lv_pmos m=1 w=480.00n l=130.00n ng=1
MP14 net4 net1 VDD VNW sg13_lv_pmos m=1 w=480.00n l=130.00n ng=1
MP3 net1 CI net2 VNW sg13_lv_pmos m=1 w=480.00n l=130.00n ng=1
MP1 AI BI net1 VNW sg13_lv_pmos m=1 w=480.00n l=130.00n ng=1
MP15 net2 C net4 VNW sg13_lv_pmos m=1 w=480.00n l=130.00n ng=1
MP13 Y net2 VDD VNW sg13_lv_pmos m=1 w=480.00n l=130.00n ng=1
.ENDS

************************************************************************
* Library Name: ez130_8t
* Cell Name:    XOR3X2
* View Name:    schematic
************************************************************************

.SUBCKT XOR3X2 A B C VDD VNW VPW VSS Y
*.PININFO A:I B:I C:I Y:O VDD:B VNW:B VPW:B VSS:B
MN11 net5 AI VSS VPW sg13_lv_nmos m=1 w=300.0n l=130.00n ng=1
MN14 net2 CI net3 VPW sg13_lv_nmos m=1 w=300.0n l=130.00n ng=1
MN15 net3 net1 VSS VPW sg13_lv_nmos m=1 w=300.0n l=130.00n ng=1
MN9 AI B net1 VPW sg13_lv_nmos m=1 w=300.0n l=130.00n ng=1
MN13 Y net2 VSS VPW sg13_lv_nmos m=1 w=640.00n l=130.00n ng=1
MN7 net1 C net2 VPW sg13_lv_nmos m=1 w=300.0n l=130.00n ng=1
MN4 net1 BI net5 VPW sg13_lv_nmos m=1 w=300.0n l=130.00n ng=1
MN2 CI C VSS VPW sg13_lv_nmos m=1 w=300.0n l=130.00n ng=1
MN1 BI B VSS VPW sg13_lv_nmos m=1 w=300.0n l=130.00n ng=1
MN0 AI A VSS VPW sg13_lv_nmos m=1 w=300.0n l=130.00n ng=1
MP11 net6 AI VDD VNW sg13_lv_pmos m=1 w=480.00n l=130.00n ng=1
MP10 AI A VDD VNW sg13_lv_pmos m=1 w=480.00n l=130.00n ng=1
MP9 BI B VDD VNW sg13_lv_pmos m=1 w=480.00n l=130.00n ng=1
MP8 CI C VDD VNW sg13_lv_pmos m=1 w=480.00n l=130.00n ng=1
MP6 net1 B net6 VNW sg13_lv_pmos m=1 w=480.00n l=130.00n ng=1
MP14 net4 net1 VDD VNW sg13_lv_pmos m=1 w=480.00n l=130.00n ng=1
MP3 net1 CI net2 VNW sg13_lv_pmos m=1 w=480.00n l=130.00n ng=1
MP1 AI BI net1 VNW sg13_lv_pmos m=1 w=480.00n l=130.00n ng=1
MP15 net2 C net4 VNW sg13_lv_pmos m=1 w=480.00n l=130.00n ng=1
MP13 Y net2 VDD VNW sg13_lv_pmos m=1 w=980.00n l=130.00n ng=1
.ENDS
