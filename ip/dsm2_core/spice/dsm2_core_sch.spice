* dsm2_core schematic netlist, ngspice syntax, all child subcircuits (standard cells come from the PDK, see header.spice)
* netlisted by xschem from the dsm2_core schematic (oscillator variant) with the quantizer2 preset fix on 2026-10-31
* SPDX-FileCopyrightText: 2026 Michael Koefinger
* SPDX-License-Identifier: Apache-2.0 WITH SHL-2.1

.subckt dsm2_core vi vcm di_clk di_ena di_rst_b di_trim[3] di_trim[2] di_trim[1] di_trim[0] di_dith_en di_dith_amp[1]
+ di_dith_amp[0] di_vcm_ext di_btest_en di_qout_en do_q do_q_b do_q_dec ibias_test vdd vss di_osc_en di_clk_sel do_clk_osc do_osc_oe
*.ipin di_ena
*.ipin di_rst_b
*.ipin di_trim[3],di_trim[2],di_trim[1],di_trim[0]
*.ipin di_dith_en
*.ipin di_dith_amp[1],di_dith_amp[0]
*.ipin di_vcm_ext
*.ipin di_btest_en
*.ipin di_qout_en
*.iopin vdd
*.iopin vss
*.iopin ibias_test
*.iopin vcm
*.ipin vi
*.ipin di_clk
*.opin do_q
*.opin do_q_b
*.opin do_q_dec
*.ipin di_osc_en
*.ipin di_clk_sel
*.opin do_clk_osc
*.opin do_osc_oe
xio vdd vss di_ena di_rst_b di_trim[3] di_trim[2] di_trim[1] di_trim[0] di_dith_en di_dith_amp[1] di_dith_amp[0] di_vcm_ext
+ di_btest_en di_qout_en d_ena d_rst_b d_trim_b[3] d_trim_b[2] d_trim_b[1] d_trim_b[0] d_dith_en d_dith_amp[1] d_dith_amp[0] d_btest_en
+ d_qout_en d_vcm_ext d_vcm_ext_b dsm2_io
xesd vdd vss ibias_test ibias_test_esd vcm vcm_esd vi vi_esd dsm2_io_esd
xsc vdd vss vi_esd vcm_esd d_phi1 d_phi2 d_qi d_qi_b ibias_200n d_ena vo_p vo_n sc_int2
xioclk vdd vss di_clk d_clk dsm2_io_clk
xclk d_clk_mod d_ena d_phi1 d_phi1_b d_phi2 d_phi2_b d_qclk vdd vss clk_noverlap
xvcmg vdd vss d_vcm_ext d_vcm_ext_b d_phi1_b d_phi2 d_vcm_phi1_b d_vcm_phi2 dsm2_io_vcmg
xvcm d_vcm_phi1_b d_vcm_phi2 vdd vss vcm_esd vcm_gen
xbias vdd vss d_ena d_trim_b[3] d_trim_b[2] d_trim_b[1] d_trim_b[0] ibias_200n d_btest_or ibias_bank bias_gm
xq vo_p vo_n d_qclk d_dith[2] d_dith[1] d_dith[0] d_amp_s[3] d_amp_s[2] d_amp_s[1] d_amp_s[0] d_amp_s_b[3] d_amp_s_b[2]
+ d_amp_s_b[1] d_amp_s_b[0] d_qi d_qi_b do_q do_q_b do_q_dec vdd d_ena d_rst_b d_dith_en d_qout_en vss quantizer2_top
xlfsr d_qclk d_dith_amp[1] d_dith_amp[0] d_dith[2] d_dith[1] d_dith[0] d_amp_s[3] d_amp_s[2] d_amp_s[1] d_amp_s[0] d_amp_s_b[3]
+ d_amp_s_b[2] d_amp_s_b[1] d_amp_s_b[0] vdd d_dith_en vss quantizer2_lfsr
XXMDN vss vdd vss vss sg13_lv_nmos w=840n l=1u ng=2 m=123 mm_ok=1
XXMDP vdd vss vdd vdd sg13_lv_pmos w=2u l=1u ng=2 m=123 mm_ok=1
xosc vdd vss di_osc_en di_clk_sel d_btest_en ibias_bank d_clk d_btest_or ibias_test_esd d_clk_mod do_clk_osc do_osc_oe dsm2_osc
.ends

.subckt dsm2_io vdd vss di_ena di_rst_b di_trim[3] di_trim[2] di_trim[1] di_trim[0] di_dith_en di_dith_amp[1] di_dith_amp[0]
+ di_vcm_ext di_btest_en di_qout_en do_ena do_rst_b do_trim_b[3] do_trim_b[2] do_trim_b[1] do_trim_b[0] do_dith_en do_dith_amp[1]
+ do_dith_amp[0] do_btest_en do_qout_en do_vcm_ext do_vcm_ext_b
*.iopin vdd
*.iopin vss
*.ipin di_ena
*.opin do_ena
*.ipin di_rst_b
*.opin do_rst_b
*.ipin di_vcm_ext
*.opin do_vcm_ext_b
*.opin do_vcm_ext
*.ipin di_trim[3],di_trim[2],di_trim[1],di_trim[0]
*.opin do_trim_b[3],do_trim_b[2],do_trim_b[1],do_trim_b[0]
*.ipin di_dith_en
*.opin do_dith_en
*.ipin di_dith_amp[1],di_dith_amp[0]
*.opin do_dith_amp[1],do_dith_amp[0]
*.ipin di_btest_en
*.opin do_btest_en
*.ipin di_qout_en
*.opin do_qout_en
XHE vdd vss di_ena d_ena_b dsm2_io_rx
XMPS vsw_p d_ena_b vdd vdd sg13_hv_pmos w=1u l=0.45u ng=1 m=1 mm_ok=1
XMPL do_ena vss vsw_p vdd sg13_hv_pmos w=1u l=5u ng=1 m=1 mm_ok=1
XMNL1 do_ena vdd vln1 vss sg13_hv_nmos w=1u l=10u ng=1 m=1 mm_ok=1
XMNL2 vln1 vdd vsw_n vss sg13_hv_nmos w=1u l=10u ng=1 m=1 mm_ok=1
XMNS vsw_n d_ena_b vss vss sg13_hv_nmos w=1u l=0.45u ng=1 m=1 mm_ok=1
XMCP vdd do_ena vdd vdd sg13_hv_pmos w=1u l=10u ng=1 m=2 mm_ok=1
XMCN vss do_ena vss vss sg13_hv_nmos w=1u l=5u ng=1 m=4 mm_ok=1
XMCD vdd vss vdd vdd sg13_hv_pmos w=1u l=5u ng=1 m=3 mm_ok=1
XHR vdd vss di_rst_b d_rst dsm2_io_rx
XLR do_rst_b d_rst vdd vss sg13cmos5l_inv_1
XHV vdd vss di_vcm_ext do_vcm_ext_b dsm2_io_rx
XLV do_vcm_ext do_vcm_ext_b vdd vss sg13cmos5l_inv_1
XHT[3] vdd vss di_trim[3] do_trim_b[3] dsm2_io_rx
XHT[2] vdd vss di_trim[2] do_trim_b[2] dsm2_io_rx
XHT[1] vdd vss di_trim[1] do_trim_b[1] dsm2_io_rx
XHT[0] vdd vss di_trim[0] do_trim_b[0] dsm2_io_rx
XHD vdd vss di_dith_en d_dith_en_b dsm2_io_rx
XLD do_dith_en d_dith_en_b vdd vss sg13cmos5l_inv_1
XHA[1] vdd vss di_dith_amp[1] d_dith_amp_b[1] dsm2_io_rx
XHA[0] vdd vss di_dith_amp[0] d_dith_amp_b[0] dsm2_io_rx
XLA[1] do_dith_amp[1] d_dith_amp_b[1] vdd vss sg13cmos5l_inv_1
XLA[0] do_dith_amp[0] d_dith_amp_b[0] vdd vss sg13cmos5l_inv_1
XHB vdd vss di_btest_en d_btest_en_b dsm2_io_rx
XLB do_btest_en d_btest_en_b vdd vss sg13cmos5l_inv_1
XHQ vdd vss di_qout_en d_qout_en_b dsm2_io_rx
XLQ do_qout_en d_qout_en_b vdd vss sg13cmos5l_inv_1
.ends

.subckt dsm2_io_esd vdd vss ibias_test_pad ibias_test vcm_pad vcm vi_pad vi
*.iopin vdd
*.iopin vss
*.ipin vi_pad
*.opin vi
*.iopin vcm_pad
*.iopin vcm
*.iopin ibias_test_pad
*.iopin ibias_test
XSP1 vi vss vi_pad vdd vss sg13cmos5l_SecondaryProtection
XSP2 vcm vss vcm_pad vdd vss sg13cmos5l_SecondaryProtection
XSP3 ibias_test vss ibias_test_pad vdd vss sg13cmos5l_SecondaryProtection
.ends

.subckt sc_int2 vdd vss vi vcm di_phi1 di_phi2 di_q di_q_b ibias_200n di_ena vo_p vo_n
*.ipin vi
*.ipin ibias_200n
*.ipin di_ena
*.ipin di_phi1
*.ipin di_phi2
*.iopin vdd
*.iopin vss
*.ipin vcm
*.ipin di_q
*.ipin di_q_b
*.opin vo_p
*.opin vo_n
XS_TI vc1l_p vi di_phi1 d_phi1_b vdd vss sw_tgate
XS_TVA vc1l_p vh_p di_phi2 d_phi2_b vdd vss sw_tgate
XS_TVB vh_p vdd di_q di_q_b vdd vss sw_tgate
XS_TBA vc1l_p vl_p di_phi2 d_phi2_b vdd vss sw_tgate
XS_TBB vl_p vss di_q_b di_q vdd vss sw_tgate
XC1P[1] vc1r_p vc1l_p cap_cmomf w=3e-6 l=11.39e-6 mmin=1 mmax=4 subblock=0 m=1 mm_ok=1
XC1P[0] vc1r_p vc1l_p cap_cmomf w=3e-6 l=11.39e-6 mmin=1 mmax=4 subblock=0 m=1 mm_ok=1
XS_TRV vc1r_p vvg_n di_phi2 d_phi2_b vdd vss sw_tgate
XS_TRC vc1r_p vcm di_phi1 d_phi1_b vdd vss sw_tgate
XS_BI vc1l_n vi di_phi2 d_phi2_b vdd vss sw_tgate
XS_BVA vc1l_n vh_n di_phi1 d_phi1_b vdd vss sw_tgate
XS_BVB vh_n vdd di_q di_q_b vdd vss sw_tgate
XS_BBA vc1l_n vl_n di_phi1 d_phi1_b vdd vss sw_tgate
XS_BBB vl_n vss di_q_b di_q vdd vss sw_tgate
XC1N[1] vc1r_n vc1l_n cap_cmomf w=3e-6 l=11.39e-6 mmin=1 mmax=4 subblock=0 m=1 mm_ok=1
XC1N[0] vc1r_n vc1l_n cap_cmomf w=3e-6 l=11.39e-6 mmin=1 mmax=4 subblock=0 m=1 mm_ok=1
XS_BRV vc1r_n vvg_p di_phi2 d_phi2_b vdd vss sw_tgate
XS_BRC vc1r_n vcm di_phi1 d_phi1_b vdd vss sw_tgate
xamp1 vdd vfb vo_p vo_n vvg_p vvg_n ibias_200n di_ena vss vbn ota_fcasc2_top
XC2P[11] vvg_n vo_p cap_cmomf w=3e-6 l=11.39e-6 mmin=1 mmax=4 subblock=0 m=1 mm_ok=1
XC2P[10] vvg_n vo_p cap_cmomf w=3e-6 l=11.39e-6 mmin=1 mmax=4 subblock=0 m=1 mm_ok=1
XC2P[9] vvg_n vo_p cap_cmomf w=3e-6 l=11.39e-6 mmin=1 mmax=4 subblock=0 m=1 mm_ok=1
XC2P[8] vvg_n vo_p cap_cmomf w=3e-6 l=11.39e-6 mmin=1 mmax=4 subblock=0 m=1 mm_ok=1
XC2P[7] vvg_n vo_p cap_cmomf w=3e-6 l=11.39e-6 mmin=1 mmax=4 subblock=0 m=1 mm_ok=1
XC2P[6] vvg_n vo_p cap_cmomf w=3e-6 l=11.39e-6 mmin=1 mmax=4 subblock=0 m=1 mm_ok=1
XC2P[5] vvg_n vo_p cap_cmomf w=3e-6 l=11.39e-6 mmin=1 mmax=4 subblock=0 m=1 mm_ok=1
XC2P[4] vvg_n vo_p cap_cmomf w=3e-6 l=11.39e-6 mmin=1 mmax=4 subblock=0 m=1 mm_ok=1
XC2P[3] vvg_n vo_p cap_cmomf w=3e-6 l=11.39e-6 mmin=1 mmax=4 subblock=0 m=1 mm_ok=1
XC2P[2] vvg_n vo_p cap_cmomf w=3e-6 l=11.39e-6 mmin=1 mmax=4 subblock=0 m=1 mm_ok=1
XC2P[1] vvg_n vo_p cap_cmomf w=3e-6 l=11.39e-6 mmin=1 mmax=4 subblock=0 m=1 mm_ok=1
XC2P[0] vvg_n vo_p cap_cmomf w=3e-6 l=11.39e-6 mmin=1 mmax=4 subblock=0 m=1 mm_ok=1
XC2N[11] vvg_p vo_n cap_cmomf w=3e-6 l=11.39e-6 mmin=1 mmax=4 subblock=0 m=1 mm_ok=1
XC2N[10] vvg_p vo_n cap_cmomf w=3e-6 l=11.39e-6 mmin=1 mmax=4 subblock=0 m=1 mm_ok=1
XC2N[9] vvg_p vo_n cap_cmomf w=3e-6 l=11.39e-6 mmin=1 mmax=4 subblock=0 m=1 mm_ok=1
XC2N[8] vvg_p vo_n cap_cmomf w=3e-6 l=11.39e-6 mmin=1 mmax=4 subblock=0 m=1 mm_ok=1
XC2N[7] vvg_p vo_n cap_cmomf w=3e-6 l=11.39e-6 mmin=1 mmax=4 subblock=0 m=1 mm_ok=1
XC2N[6] vvg_p vo_n cap_cmomf w=3e-6 l=11.39e-6 mmin=1 mmax=4 subblock=0 m=1 mm_ok=1
XC2N[5] vvg_p vo_n cap_cmomf w=3e-6 l=11.39e-6 mmin=1 mmax=4 subblock=0 m=1 mm_ok=1
XC2N[4] vvg_p vo_n cap_cmomf w=3e-6 l=11.39e-6 mmin=1 mmax=4 subblock=0 m=1 mm_ok=1
XC2N[3] vvg_p vo_n cap_cmomf w=3e-6 l=11.39e-6 mmin=1 mmax=4 subblock=0 m=1 mm_ok=1
XC2N[2] vvg_p vo_n cap_cmomf w=3e-6 l=11.39e-6 mmin=1 mmax=4 subblock=0 m=1 mm_ok=1
XC2N[1] vvg_p vo_n cap_cmomf w=3e-6 l=11.39e-6 mmin=1 mmax=4 subblock=0 m=1 mm_ok=1
XC2N[0] vvg_p vo_n cap_cmomf w=3e-6 l=11.39e-6 mmin=1 mmax=4 subblock=0 m=1 mm_ok=1
xcmfb1 di_phi2 di_phi1 vss vo_p vcm vbn vfb vo_n vdd cmfb_sc2
XINV_vphi1 di_phi1 d_phi1_b vdd vss inv_lv
XINV_vphi2 di_phi2 d_phi2_b vdd vss inv_lv
XCDUM_DCOL[17] vdd vss cap_cmomf w=3e-6 l=5.6e-6 mmin=1 mmax=4 subblock=0 m=1 mm_ok=1
XCDUM_DCOL[16] vdd vss cap_cmomf w=3e-6 l=5.6e-6 mmin=1 mmax=4 subblock=0 m=1 mm_ok=1
XCDUM_DCOL[15] vdd vss cap_cmomf w=3e-6 l=5.6e-6 mmin=1 mmax=4 subblock=0 m=1 mm_ok=1
XCDUM_DCOL[14] vdd vss cap_cmomf w=3e-6 l=5.6e-6 mmin=1 mmax=4 subblock=0 m=1 mm_ok=1
XCDUM_DCOL[13] vdd vss cap_cmomf w=3e-6 l=5.6e-6 mmin=1 mmax=4 subblock=0 m=1 mm_ok=1
XCDUM_DCOL[12] vdd vss cap_cmomf w=3e-6 l=5.6e-6 mmin=1 mmax=4 subblock=0 m=1 mm_ok=1
XCDUM_DCOL[11] vdd vss cap_cmomf w=3e-6 l=5.6e-6 mmin=1 mmax=4 subblock=0 m=1 mm_ok=1
XCDUM_DCOL[10] vdd vss cap_cmomf w=3e-6 l=5.6e-6 mmin=1 mmax=4 subblock=0 m=1 mm_ok=1
XCDUM_DCOL[9] vdd vss cap_cmomf w=3e-6 l=5.6e-6 mmin=1 mmax=4 subblock=0 m=1 mm_ok=1
XCDUM_DCOL[8] vdd vss cap_cmomf w=3e-6 l=5.6e-6 mmin=1 mmax=4 subblock=0 m=1 mm_ok=1
XCDUM_DCOL[7] vdd vss cap_cmomf w=3e-6 l=5.6e-6 mmin=1 mmax=4 subblock=0 m=1 mm_ok=1
XCDUM_DCOL[6] vdd vss cap_cmomf w=3e-6 l=5.6e-6 mmin=1 mmax=4 subblock=0 m=1 mm_ok=1
XCDUM_DCOL[5] vdd vss cap_cmomf w=3e-6 l=5.6e-6 mmin=1 mmax=4 subblock=0 m=1 mm_ok=1
XCDUM_DCOL[4] vdd vss cap_cmomf w=3e-6 l=5.6e-6 mmin=1 mmax=4 subblock=0 m=1 mm_ok=1
XCDUM_DCOL[3] vdd vss cap_cmomf w=3e-6 l=5.6e-6 mmin=1 mmax=4 subblock=0 m=1 mm_ok=1
XCDUM_DCOL[2] vdd vss cap_cmomf w=3e-6 l=5.6e-6 mmin=1 mmax=4 subblock=0 m=1 mm_ok=1
XCDUM_DCOL[1] vdd vss cap_cmomf w=3e-6 l=5.6e-6 mmin=1 mmax=4 subblock=0 m=1 mm_ok=1
XCDUM_DCOL[0] vdd vss cap_cmomf w=3e-6 l=5.6e-6 mmin=1 mmax=4 subblock=0 m=1 mm_ok=1
XCDUM_STRIP[7] vdd vss cap_cmomf w=3e-6 l=11.39e-6 mmin=1 mmax=4 subblock=0 m=1 mm_ok=1
XCDUM_STRIP[6] vdd vss cap_cmomf w=3e-6 l=11.39e-6 mmin=1 mmax=4 subblock=0 m=1 mm_ok=1
XCDUM_STRIP[5] vdd vss cap_cmomf w=3e-6 l=11.39e-6 mmin=1 mmax=4 subblock=0 m=1 mm_ok=1
XCDUM_STRIP[4] vdd vss cap_cmomf w=3e-6 l=11.39e-6 mmin=1 mmax=4 subblock=0 m=1 mm_ok=1
XCDUM_STRIP[3] vdd vss cap_cmomf w=3e-6 l=11.39e-6 mmin=1 mmax=4 subblock=0 m=1 mm_ok=1
XCDUM_STRIP[2] vdd vss cap_cmomf w=3e-6 l=11.39e-6 mmin=1 mmax=4 subblock=0 m=1 mm_ok=1
XCDUM_STRIP[1] vdd vss cap_cmomf w=3e-6 l=11.39e-6 mmin=1 mmax=4 subblock=0 m=1 mm_ok=1
XCDUM_STRIP[0] vdd vss cap_cmomf w=3e-6 l=11.39e-6 mmin=1 mmax=4 subblock=0 m=1 mm_ok=1
.ends

.subckt dsm2_io_clk vdd vss di_clk do_clk
*.iopin vdd
*.iopin vss
*.ipin di_clk
*.opin do_clk
XBC do_clk di_clk vdd vss sg13cmos5l_buf_2
.ends

.subckt clk_noverlap di_clk di_ena do_phi1 do_phi1_b do_phi2 do_phi2_b do_qclk vdd vss
*.ipin di_clk
*.ipin di_ena
*.opin do_phi1_b
*.opin do_phi1
*.opin do_phi2
*.opin do_phi2_b
*.iopin vdd
*.iopin vss
*.opin do_qclk
XAND0 d_clk_en di_clk di_ena vdd vss sg13cmos5l_and2_1
XINV0 d_clk_en_b d_clk_en vdd vss sg13cmos5l_inv_1
XNOR0 d_phi1_nor d_clk_en_b d_ena_b d_phi2_fb vdd vss sg13cmos5l_nor3_1
XNOR1 d_phi2_nor d_clk_en d_ena_b do_phi1 vdd vss sg13cmos5l_nor3_1
XINV_ENA d_ena_b di_ena vdd vss sg13cmos5l_inv_1
XINV11 d_phi1_1 d_phi1_nor vdd vss sg13cmos5l_inv_1
XINV21 d_phi2_1 d_phi2_nor vdd vss sg13cmos5l_inv_1
XINV12 d_phi1_2 d_phi1_1 vdd vss sg13cmos5l_inv_1
XINV22 d_phi2_2 d_phi2_1 vdd vss sg13cmos5l_inv_1
XINV13 do_phi1_b d_phi1_2 vdd vss sg13cmos5l_inv_1
XINV23 do_phi2_b d_phi2_2 vdd vss sg13cmos5l_inv_1
XINV14 do_phi1 do_phi1_b vdd vss sg13cmos5l_inv_1
XINV24 do_phi2 do_phi2_b vdd vss sg13cmos5l_inv_1
XDC8[11] vdd vss sg13cmos5l_decap_8
XDC8[10] vdd vss sg13cmos5l_decap_8
XDC8[9] vdd vss sg13cmos5l_decap_8
XDC8[8] vdd vss sg13cmos5l_decap_8
XDC8[7] vdd vss sg13cmos5l_decap_8
XDC8[6] vdd vss sg13cmos5l_decap_8
XDC8[5] vdd vss sg13cmos5l_decap_8
XDC8[4] vdd vss sg13cmos5l_decap_8
XDC8[3] vdd vss sg13cmos5l_decap_8
XDC8[2] vdd vss sg13cmos5l_decap_8
XDC8[1] vdd vss sg13cmos5l_decap_8
XDC8[0] vdd vss sg13cmos5l_decap_8
XDC4[1] vdd vss sg13cmos5l_decap_4
XDC4[0] vdd vss sg13cmos5l_decap_4
XDLY0 net1 do_phi2 vdd vss sg13cmos5l_dlygate4sd3_1
XDLY1 net2 net1 vdd vss sg13cmos5l_dlygate4sd3_1
XDLY2 net3 net2 vdd vss sg13cmos5l_dlygate4sd3_1
XDLY3 net4 net3 vdd vss sg13cmos5l_dlygate4sd3_1
XDLY4 net5 net4 vdd vss sg13cmos5l_dlygate4sd3_1
XDLY5 net6 net5 vdd vss sg13cmos5l_dlygate4sd3_1
XDLY6 net7 net6 vdd vss sg13cmos5l_dlygate4sd3_1
XDLY7 net8 net7 vdd vss sg13cmos5l_dlygate4sd3_1
XDLY8 net9 net8 vdd vss sg13cmos5l_dlygate4sd3_1
XDLY9 net10 net9 vdd vss sg13cmos5l_dlygate4sd3_1
XDLY10 net11 net10 vdd vss sg13cmos5l_dlygate4sd3_1
XDLY11 net12 net11 vdd vss sg13cmos5l_dlygate4sd3_1
XDLY12 net13 net12 vdd vss sg13cmos5l_dlygate4sd3_1
XDLY13 d_phi2_fb net13 vdd vss sg13cmos5l_dlygate4sd3_1
XQI1 d_qck1 do_phi2 vdd vss sg13cmos5l_inv_1
XQI2 d_qck2 d_qck1 vdd vss sg13cmos5l_inv_1
XQI3 d_qck3 d_qck2 vdd vss sg13cmos5l_inv_1
XQA do_qclk d_clk_en d_qck3 vdd vss sg13cmos5l_and2_1
.ends

.subckt dsm2_io_vcmg vdd vss di_vcm_ext di_vcm_ext_b di_phi1_b di_phi2 do_phi1_b do_phi2
*.iopin vdd
*.iopin vss
*.ipin di_phi1_b
*.opin do_phi1_b
*.ipin di_vcm_ext
*.ipin di_vcm_ext_b
*.ipin di_phi2
*.opin do_phi2
XOR do_phi1_b di_phi1_b di_vcm_ext vdd vss sg13cmos5l_or2_1
XAND do_phi2 di_phi2 di_vcm_ext_b vdd vss sg13cmos5l_and2_1
.ends

.subckt vcm_gen di_phi1_b di_phi2 vdd vss vcm
*.ipin di_phi1_b
*.ipin di_phi2
*.iopin vdd
*.iopin vss
*.iopin vcm
XMS1 vcf_t di_phi1_b vdd vdd sg13_hv_pmos w=4u l=0.45u ng=1 m=1 mm_ok=1
XMS4 vcf_b di_phi2 vss vss sg13_hv_nmos w=2u l=0.45u ng=1 m=1 mm_ok=1
XMS2 vcf_b di_phi1_b vcm vdd sg13_lv_pmos w=4u l=0.5u ng=1 m=1 mm_ok=1
XMS3 vcf_t di_phi2 vcm vss sg13_lv_nmos w=4u l=0.5u ng=1 m=1 mm_ok=1
XCF1[3] vcf_t vcf_b cap_cmomf w=4.2e-6 l=12.4e-6 mmin=3 mmax=4 subblock=0 m=1 mm_ok=1
XCF1[2] vcf_t vcf_b cap_cmomf w=4.2e-6 l=12.4e-6 mmin=3 mmax=4 subblock=0 m=1 mm_ok=1
XCF1[1] vcf_t vcf_b cap_cmomf w=4.2e-6 l=12.4e-6 mmin=3 mmax=4 subblock=0 m=1 mm_ok=1
XCF1[0] vcf_t vcf_b cap_cmomf w=4.2e-6 l=12.4e-6 mmin=3 mmax=4 subblock=0 m=1 mm_ok=1
XCF2[3] vcf_b vcf_t cap_cmomf w=4.2e-6 l=12.4e-6 mmin=3 mmax=4 subblock=0 m=1 mm_ok=1
XCF2[2] vcf_b vcf_t cap_cmomf w=4.2e-6 l=12.4e-6 mmin=3 mmax=4 subblock=0 m=1 mm_ok=1
XCF2[1] vcf_b vcf_t cap_cmomf w=4.2e-6 l=12.4e-6 mmin=3 mmax=4 subblock=0 m=1 mm_ok=1
XCF2[0] vcf_b vcf_t cap_cmomf w=4.2e-6 l=12.4e-6 mmin=3 mmax=4 subblock=0 m=1 mm_ok=1
XCR vss vcm vss vss sg13_hv_nmos w=10u l=10u ng=1 m=7 mm_ok=1
XMDEC vss vdd vss vss sg13_hv_nmos w=4u l=10u ng=1 m=2 mm_ok=1
XMDR vss vss vss vss sg13_hv_nmos w=10u l=0.45u ng=1 m=2 mm_ok=1
XMDS vss vss vss vss sg13_hv_nmos w=1.5u l=0.45u ng=1 m=1 mm_ok=1
.ends

.subckt bias_gm vdd vss di_ena di_trim_b[3] di_trim_b[2] di_trim_b[1] di_trim_b[0] ibias_200n di_btest_en ibias_test
*.iopin vdd
*.iopin vss
*.ipin di_ena
*.iopin ibias_200n
*.ipin di_trim_b[3],di_trim_b[2],di_trim_b[1],di_trim_b[0]
*.ipin di_btest_en
*.iopin ibias_test
XMCL1 vz di_ena vdd vdd sg13_lv_pmos w=0.5u l=5u ng=1 m=1 mm_ok=1
XMPI d_en_b di_ena vdd vdd sg13_lv_pmos w=0.5u l=0.5u ng=1 m=1 mm_ok=1
XMNI d_en_b di_ena vss vss sg13_lv_nmos w=0.5u l=1u ng=1 m=1 mm_ok=1
XMCL3 vx d_en_b vss vss sg13_hv_nmos w=0.5u l=1u ng=1 m=1 mm_ok=1
XMCL4 vy d_en_b vss vss sg13_hv_nmos w=0.5u l=1u ng=1 m=1 mm_ok=1
XMCL6 vs d_en_b vss vss sg13_lv_nmos w=0.5u l=1u ng=1 m=1 mm_ok=1
XM3 vy vz vdd vdd sg13_lv_pmos w=0.5u l=5u ng=1 m=24 mm_ok=1
XM5 vz vz vdd vdd sg13_lv_pmos w=0.5u l=5u ng=1 m=12 mm_ok=1
XM4 vx vz vdd vdd sg13_lv_pmos w=0.5u l=5u ng=1 m=24 mm_ok=1
XM6 vz vy vss vss sg13_hv_nmos w=0.5u l=10u ng=1 m=2 mm_ok=1
XM1 vy vx vss vss sg13_hv_nmos w=0.5u l=10u ng=1 m=4 mm_ok=1
XCC vss net1 vss vss sg13_hv_nmos w=10u l=10u ng=1 m=20 mm_ok=1
XM2 vx vx vnr vss sg13_lv_nmos w=0.5u l=10u ng=1 m=4 mm_ok=1
XR1 vnr vss vss rhigh w=0.5e-6 l=735e-6 m=1 b=0 mm_ok=1
XMSA[12] vua[1] vt1 vdd vdd sg13_lv_pmos w=0.5u l=10u ng=1 m=1 mm_ok=1
XMSA[11] vua[2] vt1 vua[1] vdd sg13_lv_pmos w=0.5u l=10u ng=1 m=1 mm_ok=1
XMSA[10] vua[3] vt1 vua[2] vdd sg13_lv_pmos w=0.5u l=10u ng=1 m=1 mm_ok=1
XMSA[9] vua[4] vt1 vua[3] vdd sg13_lv_pmos w=0.5u l=10u ng=1 m=1 mm_ok=1
XMSA[8] vua[5] vt1 vua[4] vdd sg13_lv_pmos w=0.5u l=10u ng=1 m=1 mm_ok=1
XMSA[7] vua[6] vt1 vua[5] vdd sg13_lv_pmos w=0.5u l=10u ng=1 m=1 mm_ok=1
XMSA[6] vua[7] vt1 vua[6] vdd sg13_lv_pmos w=0.5u l=10u ng=1 m=1 mm_ok=1
XMSA[5] vua[8] vt1 vua[7] vdd sg13_lv_pmos w=0.5u l=10u ng=1 m=1 mm_ok=1
XMSA[4] vua[9] vt1 vua[8] vdd sg13_lv_pmos w=0.5u l=10u ng=1 m=1 mm_ok=1
XMSA[3] vua[10] vt1 vua[9] vdd sg13_lv_pmos w=0.5u l=10u ng=1 m=1 mm_ok=1
XMSA[2] vua[11] vt1 vua[10] vdd sg13_lv_pmos w=0.5u l=10u ng=1 m=1 mm_ok=1
XMSA[1] vua[12] vt1 vua[11] vdd sg13_lv_pmos w=0.5u l=10u ng=1 m=1 mm_ok=1
XMSA[0] vt1 vt1 vua[12] vdd sg13_lv_pmos w=0.5u l=10u ng=1 m=1 mm_ok=1
XMSB[12] vub[1] vs vt1 vdd sg13_lv_pmos w=0.5u l=10u ng=1 m=1 mm_ok=1
XMSB[11] vub[2] vs vub[1] vdd sg13_lv_pmos w=0.5u l=10u ng=1 m=1 mm_ok=1
XMSB[10] vub[3] vs vub[2] vdd sg13_lv_pmos w=0.5u l=10u ng=1 m=1 mm_ok=1
XMSB[9] vub[4] vs vub[3] vdd sg13_lv_pmos w=0.5u l=10u ng=1 m=1 mm_ok=1
XMSB[8] vub[5] vs vub[4] vdd sg13_lv_pmos w=0.5u l=10u ng=1 m=1 mm_ok=1
XMSB[7] vub[6] vs vub[5] vdd sg13_lv_pmos w=0.5u l=10u ng=1 m=1 mm_ok=1
XMSB[6] vub[7] vs vub[6] vdd sg13_lv_pmos w=0.5u l=10u ng=1 m=1 mm_ok=1
XMSB[5] vub[8] vs vub[7] vdd sg13_lv_pmos w=0.5u l=10u ng=1 m=1 mm_ok=1
XMSB[4] vub[9] vs vub[8] vdd sg13_lv_pmos w=0.5u l=10u ng=1 m=1 mm_ok=1
XMSB[3] vub[10] vs vub[9] vdd sg13_lv_pmos w=0.5u l=10u ng=1 m=1 mm_ok=1
XMSB[2] vub[11] vs vub[10] vdd sg13_lv_pmos w=0.5u l=10u ng=1 m=1 mm_ok=1
XMSB[1] vub[12] vs vub[11] vdd sg13_lv_pmos w=0.5u l=10u ng=1 m=1 mm_ok=1
XMSB[0] vs vs vub[12] vdd sg13_lv_pmos w=0.5u l=10u ng=1 m=1 mm_ok=1
XMSN vs vx vss vss sg13_hv_nmos w=0.5u l=10u ng=1 m=2 mm_ok=1
XMINJ vz vs vss vss sg13_hv_nmos w=4u l=0.5u ng=1 m=2 mm_ok=1
XMPD vdd vdd vdd vdd sg13_lv_pmos w=0.5u l=5u ng=1 m=26 mm_ok=1
XMNDS vss vss vss vss sg13_hv_nmos w=10u l=1u ng=1 m=10 mm_ok=1
XRD1 vss vss vss rhigh w=0.5e-6 l=17.5e-6 m=4 b=0 mm_ok=1
XRD2 vss vss vss rhigh w=0.5e-6 l=10.975e-6 m=4 b=0 mm_ok=1
XMSD vdd vdd vdd vdd sg13_lv_pmos w=0.5u l=10u ng=1 m=1 mm_ok=1
XMSDS vs vs vs vdd sg13_lv_pmos w=0.5u l=10u ng=1 m=1 mm_ok=1
XRD3 vss vss vss rhigh w=0.5e-6 l=2.75e-6 m=46 b=0 mm_ok=1
XMNDJ vss vss vss vss sg13_hv_nmos w=0.5u l=10u ng=1 m=4 mm_ok=1
xtrim vdd vss vz di_trim_b[3] di_trim_b[2] di_trim_b[1] di_trim_b[0] ibias_200n bias_trim
XRZ vy net1 vss rhigh w=0.5e-6 l=43.9e-6 m=1 b=0 mm_ok=1
XMCI vss ibias_200n vss vss sg13_hv_nmos w=0.5u l=10u ng=1 m=4 mm_ok=1
XMNDL vss vss vss vss sg13_lv_nmos w=0.5u l=10u ng=1 m=6 mm_ok=1
XMNDT vss vss vss vss sg13_hv_nmos w=1u l=10u ng=1 m=8 mm_ok=1
XMNDR vnr vss vnr vss sg13_lv_nmos w=0.5u l=10u ng=1 m=4 mm_ok=1
XRD4 vss vss vss rhigh w=0.5e-6 l=9.28e-6 m=8 b=0 mm_ok=1
XMPBI d_btest_b di_btest_en vdd vdd sg13_lv_pmos w=0.5u l=5u ng=1 m=1 mm_ok=1
XMNBI d_btest_b di_btest_en vss vss sg13_lv_nmos w=0.5u l=10u ng=1 m=2 mm_ok=1
xtrim2 vdd vss vz di_trim_b[3] di_trim_b[2] di_trim_b[1] di_trim_b[0] vbt bias_trim
XMBS ibias_test d_btest_b vbt vdd sg13_lv_pmos w=0.5u l=5u ng=1 m=6 mm_ok=1
XMBSD vbt vdd vbt vdd sg13_lv_pmos w=0.5u l=5u ng=1 m=2 mm_ok=1
.ends

.subckt quantizer2_top vi_p vi_n di_clk di_dith[2] di_dith[1] di_dith[0] di_amp_s[3] di_amp_s[2] di_amp_s[1] di_amp_s[0]
+ di_amp_s_b[3] di_amp_s_b[2] di_amp_s_b[1] di_amp_s_b[0] do_qi do_qi_b do_q do_q_b do_q_dec vdd di_en di_rst_b di_dith_en di_qout_en vss
*.iopin vi_p
*.iopin vi_n
*.ipin di_clk
*.ipin di_en
*.opin do_qi
*.opin do_qi_b
*.ipin di_rst_b
*.iopin vdd
*.iopin vss
*.opin do_q
*.opin do_q_b
*.opin do_q_dec
*.ipin di_dith_en
*.ipin di_dith[2],di_dith[1],di_dith[0]
*.ipin di_amp_s[3],di_amp_s[2],di_amp_s[1],di_amp_s[0]
*.ipin di_amp_s_b[3],di_amp_s_b[2],di_amp_s_b[1],di_amp_s_b[0]
*.ipin di_qout_en
XSAL0 di_clk vdd vi_n vi_p d_n d_p vss di_en vg_q[2] vg_q[1] vg_q[0] vg_p[2] vg_p[1] vg_p[0] quantizer2_sal
XINV0 d_p_1 d_p vdd vss sg13cmos5l_inv_1
XINV1 d_p_2 d_p_1 vdd vss sg13cmos5l_inv_2
XGATE_P d_p_b d_p_2 d_preset_b vdd vss sg13cmos5l_nand2_2
XINV3 d_n_1 d_n vdd vss sg13cmos5l_inv_1
XINV4 d_n_2 d_n_1 vdd vss sg13cmos5l_inv_2
XGATE_N d_n_b d_n_2 d_preset vdd vss sg13cmos5l_nor2_2
XNOR0 do_qi d_p_b do_qi_b vdd vss sg13cmos5l_nor2_2
XNOR1 do_qi_b d_n_b do_qi vdd vss sg13cmos5l_nor2_2
XAND_RST d_preset_b di_en di_rst_b vdd vss sg13cmos5l_and2_2
XINV7 d_preset d_preset_b vdd vss sg13cmos5l_inv_4
XPDUMHV1 vdd vss vdd vdd sg13_hv_pmos w=3u l=450n ng=1 m=1 mm_ok=1
XNDUMHV1 vss vdd vss vss sg13_hv_nmos w=1u l=450n ng=1 m=1 mm_ok=1
XPDUMHV vdd vss vdd vdd sg13_hv_pmos w=3u l=450n ng=1 m=1 mm_ok=1
XNDUMHV vss vdd vss vss sg13_hv_nmos w=1u l=450n ng=1 m=1 mm_ok=1
XDITH di_clk di_dith[2] di_dith[1] di_dith[0] di_amp_s[3] di_amp_s[2] di_amp_s[1] di_amp_s[0] di_amp_s_b[3] di_amp_s_b[2]
+ di_amp_s_b[1] di_amp_s_b[0] vi_p vi_n vg_q[2] vg_q[1] vg_q[0] vg_p[2] vg_p[1] vg_p[0] vdd di_en di_dith_en vss quantizer2_dith
XAQ0 net1 do_qi di_qout_en vdd vss sg13cmos5l_and2_1
XQD10 net2 net1 vdd vss sg13cmos5l_inv_1
XQD20 do_q net2 vdd vss sg13cmos5l_inv_2
XAQ1 net3 do_qi_b di_qout_en vdd vss sg13cmos5l_and2_1
XQD11 net4 net3 vdd vss sg13cmos5l_inv_1
XQD21 do_q_b net4 vdd vss sg13cmos5l_inv_2
XDC1 net5 do_qi vdd vss sg13cmos5l_inv_1
XDC2 do_q_dec net5 vdd vss sg13cmos5l_inv_2
XDD1 net6 do_qi_b vdd vss sg13cmos5l_inv_1
XDD2 net7 net6 vdd vss sg13cmos5l_inv_2
XDDL d_qdum_x net7 vss vdd vss sg13cmos5l_and2_1
* noconn d_qdum_x
.ends

.subckt quantizer2_lfsr di_clk di_dith_amp[1] di_dith_amp[0] do_dith[2] do_dith[1] do_dith[0] do_amp_s[3] do_amp_s[2] do_amp_s[1]
+ do_amp_s[0] do_amp_s_b[3] do_amp_s_b[2] do_amp_s_b[1] do_amp_s_b[0] vdd di_dith_en vss
*.ipin di_clk
*.ipin di_dith_en
*.opin do_dith[2],do_dith[1],do_dith[0]
*.ipin di_dith_amp[1],di_dith_amp[0]
*.opin do_amp_s_b[3],do_amp_s_b[2],do_amp_s_b[1],do_amp_s_b[0]
*.opin do_amp_s[3],do_amp_s[2],do_amp_s[1],do_amp_s[0]
*.iopin vdd
*.iopin vss
XFF[16] s[16] di_clk s[13] di_dith_en vdd vss sg13cmos5l_dfrbpq_1
XFF[15] s[15] di_clk s[12] di_dith_en vdd vss sg13cmos5l_dfrbpq_1
XFF[14] s[14] di_clk s[11] di_dith_en vdd vss sg13cmos5l_dfrbpq_1
XFF[13] s[13] di_clk s[10] di_dith_en vdd vss sg13cmos5l_dfrbpq_1
XFF[12] s[12] di_clk s[9] di_dith_en vdd vss sg13cmos5l_dfrbpq_1
XFF[11] s[11] di_clk s[8] di_dith_en vdd vss sg13cmos5l_dfrbpq_1
XFF[10] s[10] di_clk s[7] di_dith_en vdd vss sg13cmos5l_dfrbpq_1
XFF[9] s[9] di_clk s[6] di_dith_en vdd vss sg13cmos5l_dfrbpq_1
XFF[8] s[8] di_clk s[5] di_dith_en vdd vss sg13cmos5l_dfrbpq_1
XFF[7] s[7] di_clk s[4] di_dith_en vdd vss sg13cmos5l_dfrbpq_1
XFF[6] s[6] di_clk s[3] di_dith_en vdd vss sg13cmos5l_dfrbpq_1
XFF[5] s[5] di_clk s[2] di_dith_en vdd vss sg13cmos5l_dfrbpq_1
XFF[4] s[4] di_clk s[1] di_dith_en vdd vss sg13cmos5l_dfrbpq_1
XFF[3] s[3] di_clk s[0] di_dith_en vdd vss sg13cmos5l_dfrbpq_1
XFF[2] s[2] di_clk d_nb[0] di_dith_en vdd vss sg13cmos5l_dfrbpq_1
XFF[1] s[1] di_clk d_nb[1] di_dith_en vdd vss sg13cmos5l_dfrbpq_1
XFF[0] s[0] di_clk d_nb[2] di_dith_en vdd vss sg13cmos5l_dfrbpq_1
XXN[2] d_nb[2] s[11] s[14] vdd vss sg13cmos5l_xnor2_1
XXN[1] d_nb[1] s[12] s[15] vdd vss sg13cmos5l_xnor2_1
XXN[0] d_nb[0] s[13] s[16] vdd vss sg13cmos5l_xnor2_1
XBO[2] do_dith[2] s[0] vdd vss sg13cmos5l_buf_1
XBO[1] do_dith[1] s[1] vdd vss sg13cmos5l_buf_1
XBO[0] do_dith[0] s[2] vdd vss sg13cmos5l_buf_1
XINVA[1] d_a_b[1] di_dith_amp[1] vdd vss sg13cmos5l_inv_1
XINVA[0] d_a_b[0] di_dith_amp[0] vdd vss sg13cmos5l_inv_1
XNORS[3] do_amp_s[3] d_a_b[1] d_a_b[0] vdd vss sg13cmos5l_nor2_1
XNORS[2] do_amp_s[2] d_a_b[1] di_dith_amp[0] vdd vss sg13cmos5l_nor2_1
XNORS[1] do_amp_s[1] di_dith_amp[1] d_a_b[0] vdd vss sg13cmos5l_nor2_1
XNORS[0] do_amp_s[0] di_dith_amp[1] di_dith_amp[0] vdd vss sg13cmos5l_nor2_1
XINVS[3] do_amp_s_b[3] do_amp_s[3] vdd vss sg13cmos5l_inv_1
XINVS[2] do_amp_s_b[2] do_amp_s[2] vdd vss sg13cmos5l_inv_1
XINVS[1] do_amp_s_b[1] do_amp_s[1] vdd vss sg13cmos5l_inv_1
XINVS[0] do_amp_s_b[0] do_amp_s[0] vdd vss sg13cmos5l_inv_1
.ends

.subckt dsm2_osc vdd vss di_osc_en di_clk_sel d_btest_en ibias_in di_clk_ext d_btest_or ibias_pad do_clk_mod do_clk_osc do_osc_oe
*.ipin di_osc_en
*.ipin di_clk_sel
*.opin do_osc_oe
*.ipin d_btest_en
*.opin d_btest_or
*.ipin ibias_in
*.opin ibias_pad
*.iopin vdd
*.iopin vss
*.ipin di_clk_ext
*.opin do_clk_mod
*.opin do_clk_osc
XRX0 vdd vss di_osc_en d_osc_en_b dsm2_io_rx
XI0 d_osc_en d_osc_en_b vdd vss sg13cmos5l_inv_1
XRX1 vdd vss di_clk_sel d_sel_b dsm2_io_rx
XI1 do_osc_oe d_sel_b vdd vss sg13cmos5l_inv_1
XBO d_btest_or d_btest_en d_osc_en vdd vss sg13cmos5l_or2_1
XMSP ibias_pad d_osc_en ibias_in vdd sg13_lv_pmos w=1u l=0.5u ng=1 m=2 mm_ok=1
XMSN ibias_in d_osc_en vg vss sg13_hv_nmos w=1u l=0.45u ng=1 m=1 mm_ok=1
XMD vg vg vss vss sg13_lv_nmos w=0.5u l=0.5u ng=1 m=2 mm_ok=1
XMGD vg d_osc_en_b vss vss sg13_lv_nmos w=0.5u l=0.5u ng=1 m=1 mm_ok=1
XM2 vbp vg vss vss sg13_lv_nmos w=0.5u l=0.5u ng=1 m=1 mm_ok=1
XMPD vbp vbp vdd vdd sg13_lv_pmos w=0.5u l=0.5u ng=1 m=1 mm_ok=1
XMPK vbp d_osc_en vdd vdd sg13_lv_pmos w=0.5u l=0.5u ng=1 m=1 mm_ok=1
XXTP1 net6 vbp vdd vdd sg13_lv_pmos w=0.5u l=0.5u ng=1 m=1 mm_ok=1
XXP1 n1 n5 net6 vdd sg13_lv_pmos w=1u l=0.13u ng=1 m=1 mm_ok=1
XXN1 n1 n5 net7 vss sg13_lv_nmos w=1u l=0.13u ng=1 m=1 mm_ok=1
XXTN1 net7 vg vss vss sg13_lv_nmos w=0.5u l=0.5u ng=1 m=1 mm_ok=1
XXC1 vss n1 vss vss sg13_lv_nmos w=0.5u l=0.5u ng=1 m=1 mm_ok=1
XXK1 n1 d_osc_en_b vss vss sg13_lv_nmos w=0.5u l=0.13u ng=1 m=1 mm_ok=1
XXTP2 net8 vbp vdd vdd sg13_lv_pmos w=0.5u l=0.5u ng=1 m=1 mm_ok=1
XXP2 n2 n1 net8 vdd sg13_lv_pmos w=1u l=0.13u ng=1 m=1 mm_ok=1
XXN2 n2 n1 net9 vss sg13_lv_nmos w=1u l=0.13u ng=1 m=1 mm_ok=1
XXTN2 net9 vg vss vss sg13_lv_nmos w=0.5u l=0.5u ng=1 m=1 mm_ok=1
XXC2 vss n2 vss vss sg13_lv_nmos w=0.5u l=0.5u ng=1 m=1 mm_ok=1
XXK2 n2 d_osc_en vdd vdd sg13_lv_pmos w=0.5u l=0.13u ng=1 m=1 mm_ok=1
XXTP3 net10 vbp vdd vdd sg13_lv_pmos w=0.5u l=0.5u ng=1 m=1 mm_ok=1
XXP3 n3 n2 net10 vdd sg13_lv_pmos w=1u l=0.13u ng=1 m=1 mm_ok=1
XXN3 n3 n2 net11 vss sg13_lv_nmos w=1u l=0.13u ng=1 m=1 mm_ok=1
XXTN3 net11 vg vss vss sg13_lv_nmos w=0.5u l=0.5u ng=1 m=1 mm_ok=1
XXC3 vss n3 vss vss sg13_lv_nmos w=0.5u l=0.5u ng=1 m=1 mm_ok=1
XXK3 n3 d_osc_en_b vss vss sg13_lv_nmos w=0.5u l=0.13u ng=1 m=1 mm_ok=1
XXTP4 net12 vbp vdd vdd sg13_lv_pmos w=0.5u l=0.5u ng=1 m=1 mm_ok=1
XXP4 n4 n3 net12 vdd sg13_lv_pmos w=1u l=0.13u ng=1 m=1 mm_ok=1
XXN4 n4 n3 net13 vss sg13_lv_nmos w=1u l=0.13u ng=1 m=1 mm_ok=1
XXTN4 net13 vg vss vss sg13_lv_nmos w=0.5u l=0.5u ng=1 m=1 mm_ok=1
XXC4 vss n4 vss vss sg13_lv_nmos w=0.5u l=0.5u ng=1 m=1 mm_ok=1
XXK4 n4 d_osc_en vdd vdd sg13_lv_pmos w=0.5u l=0.13u ng=1 m=1 mm_ok=1
XXTP5 net14 vbp vdd vdd sg13_lv_pmos w=0.5u l=0.5u ng=1 m=1 mm_ok=1
XXP5 n5 n4 net14 vdd sg13_lv_pmos w=1u l=0.13u ng=1 m=1 mm_ok=1
XXN5 n5 n4 net15 vss sg13_lv_nmos w=1u l=0.13u ng=1 m=1 mm_ok=1
XXTN5 net15 vg vss vss sg13_lv_nmos w=0.5u l=0.5u ng=1 m=1 mm_ok=1
XXC5 vss n5 vss vss sg13_lv_nmos w=0.5u l=0.5u ng=1 m=1 mm_ok=1
XXK5 n5 d_osc_en_b vss vss sg13_lv_nmos w=0.5u l=0.13u ng=1 m=1 mm_ok=1
XXDN1 vss vss vss vss sg13_lv_nmos w=0.5u l=0.5u ng=1 m=1 mm_ok=1
XXDN2 vss vss vss vss sg13_lv_nmos w=0.5u l=0.5u ng=1 m=1 mm_ok=1
XXDP1 vdd vdd vdd vdd sg13_lv_pmos w=0.5u l=0.5u ng=1 m=1 mm_ok=1
XXDP2 vdd vdd vdd vdd sg13_lv_pmos w=0.5u l=0.5u ng=1 m=1 mm_ok=1
XXSP1 sa n5 vdd vdd sg13_lv_pmos w=0.5u l=0.5u ng=1 m=1 mm_ok=1
XXSP2 r1 n5 sa vdd sg13_lv_pmos w=0.5u l=0.5u ng=1 m=1 mm_ok=1
XXSN2 r1 n5 sb vss sg13_lv_nmos w=0.5u l=0.5u ng=1 m=1 mm_ok=1
XXSN1 sb n5 vss vss sg13_lv_nmos w=0.5u l=0.5u ng=1 m=1 mm_ok=1
XXSP3 vss r1 sa vdd sg13_lv_pmos w=0.5u l=0.5u ng=1 m=1 mm_ok=1
XXSN3 vdd r1 sb vss sg13_lv_nmos w=0.5u l=0.5u ng=1 m=1 mm_ok=1
XR3 net1 r1 vdd vss sg13cmos5l_inv_1
XFF q net2 net1 net2 d_osc_en vdd vss sg13cmos5l_dfrbp_1
XMUX net3 di_clk_ext q do_osc_oe vdd vss sg13cmos5l_mux2_1
XBM do_clk_mod net3 vdd vss sg13cmos5l_buf_2
XA net4 q d_osc_en vdd vss sg13cmos5l_and2_1
XO1 net5 net4 vdd vss sg13cmos5l_inv_1
XO2 do_clk_osc net5 vdd vss sg13cmos5l_inv_2
.ends

.subckt dsm2_io_rx vdd vss di di_b
*.iopin vdd
*.iopin vss
*.ipin di
*.opin di_b
XP0 di_b di vdd vdd sg13_hv_pmos w=0.5u l=1u ng=1 m=1 mm_ok=1
XN0 di_b di vss vss sg13_hv_nmos w=1u l=450n ng=1 m=1 mm_ok=1
.ends

.subckt sg13cmos5l_inv_1 Y A VDD VSS

*.opin Y
*.ipin A
XM1 Y A VSS VSS sg13_lv_nmos w=740.00n l=130.00n ng=1 m=1 mm_ok=1
XM2 Y A VDD VDD sg13_lv_pmos w=1.12u l=130.00n ng=1 m=1 mm_ok=1
.ends

.subckt sg13cmos5l_SecondaryProtection core minus pad plus sub
*.iopin pad
*.iopin core
*.iopin plus
*.iopin minus
*.iopin sub
XR0 core pad sub rppd w=1e-6 l=2e-6 m=1 b=0 mm_ok=1
XD0 core plus dpantenna l=0.64u w=4.98u
XD1 sub core dantenna l=3.1u w=0.64u
.ends

.subckt sw_tgate p m g gb vdd vss
*.iopin vdd
*.iopin vss
*.iopin p
*.iopin m
*.ipin gb
*.ipin g
XMN p g m vss sg13_lv_nmos w=2u l=1u ng=1 m=1 mm_ok=1
XMP p gb m vdd sg13_lv_pmos w=4u l=1u ng=1 m=1 mm_ok=1
XMND1 p gb p vss sg13_lv_nmos w=1u l=1u ng=1 m=1 mm_ok=1
XMND2 m gb m vss sg13_lv_nmos w=1u l=1u ng=1 m=1 mm_ok=1
XMPD1 p g p vdd sg13_lv_pmos w=2u l=1u ng=1 m=1 mm_ok=1
XMPD2 m g m vdd sg13_lv_pmos w=2u l=1u ng=1 m=1 mm_ok=1
.ends

.subckt ota_fcasc2_top vdd vfb voutp voutn vi_p vi_n ibias_200n di_ena vss vbn
*.ipin ibias_200n
*.iopin vdd
*.iopin vss
*.ipin vi_p
*.ipin vi_n
*.opin voutn
*.opin voutp
*.ipin vfb
*.opin vbn
*.ipin di_ena
xdp1 vtail vi_p vi_n vd1 vd2 ota_fcasc2_dp
xnbc1 d_ena_b ibias_200n voutp voutn d_ena vcp vd2 vd1 vbn vfb vss ota_fcasc2_nbiascasc
xpbc1 vdd vtail d_ena_b voutn voutp d_ena vcp ota_fcasc2_pbiascasc
xena1 vdd d_ena di_ena d_ena_b vss ota_fcasc2_ena
xcdec19 vdd vss cap_dec
xcdec18 vdd vss cap_dec
xcdec17 vdd vss cap_dec
xcdec16 vdd vss cap_dec
xcdec15 vdd vss cap_dec
xcdec14 vdd vss cap_dec
xcdec13 vdd vss cap_dec
xcdec12 vdd vss cap_dec
xcdec11 vdd vss cap_dec
xcdec10 vdd vss cap_dec
.ends

.subckt cmfb_sc2 di_phi2 di_phi1 vss vo_p vcm vbias vfb vo_n vdd
*.opin vfb
*.ipin vcm
*.ipin vbias
*.iopin vo_p
*.iopin vo_n
*.ipin di_phi1
*.ipin di_phi2
*.iopin vdd
*.iopin vss
XS4 vcm vsw_cm_p di_phi2 d_phi2_b vdd vss sw_tgate_cmfb2
XS3 vsw_cm_p vo_p di_phi1 d_phi1_b vdd vss sw_tgate_cmfb2
XS7 vbias vsw_vbias di_phi2 d_phi2_b vdd vss sw_tgate_cmfb2
XS6 vsw_vbias vfb di_phi1 d_phi1_b vdd vss sw_tgate_cmfb2
XS10 vcm vsw_cm_n di_phi2 d_phi2_b vdd vss sw_tgate_cmfb2
XS9 vsw_cm_n vo_n di_phi1 d_phi1_b vdd vss sw_tgate_cmfb2
XC2[3] vsw_cm_p vsw_vbias cap_cmomf w=3e-6 l=4.105e-6 mmin=1 mmax=4 subblock=0 m=1 mm_ok=1
XC2[2] vsw_cm_p vsw_vbias cap_cmomf w=3e-6 l=4.105e-6 mmin=1 mmax=4 subblock=0 m=1 mm_ok=1
XC2[1] vsw_cm_p vsw_vbias cap_cmomf w=3e-6 l=4.105e-6 mmin=1 mmax=4 subblock=0 m=1 mm_ok=1
XC2[0] vsw_cm_p vsw_vbias cap_cmomf w=3e-6 l=4.105e-6 mmin=1 mmax=4 subblock=0 m=1 mm_ok=1
XC4[3] vsw_cm_n vsw_vbias cap_cmomf w=3e-6 l=4.105e-6 mmin=1 mmax=4 subblock=0 m=1 mm_ok=1
XC4[2] vsw_cm_n vsw_vbias cap_cmomf w=3e-6 l=4.105e-6 mmin=1 mmax=4 subblock=0 m=1 mm_ok=1
XC4[1] vsw_cm_n vsw_vbias cap_cmomf w=3e-6 l=4.105e-6 mmin=1 mmax=4 subblock=0 m=1 mm_ok=1
XC4[0] vsw_cm_n vsw_vbias cap_cmomf w=3e-6 l=4.105e-6 mmin=1 mmax=4 subblock=0 m=1 mm_ok=1
XC1[2] vo_p vfb cap_cmomf w=3e-6 l=11.39e-6 mmin=1 mmax=4 subblock=0 m=1 mm_ok=1
XC1[1] vo_p vfb cap_cmomf w=3e-6 l=11.39e-6 mmin=1 mmax=4 subblock=0 m=1 mm_ok=1
XC1[0] vo_p vfb cap_cmomf w=3e-6 l=11.39e-6 mmin=1 mmax=4 subblock=0 m=1 mm_ok=1
XC3[2] vo_n vfb cap_cmomf w=3e-6 l=11.39e-6 mmin=1 mmax=4 subblock=0 m=1 mm_ok=1
XC3[1] vo_n vfb cap_cmomf w=3e-6 l=11.39e-6 mmin=1 mmax=4 subblock=0 m=1 mm_ok=1
XC3[0] vo_n vfb cap_cmomf w=3e-6 l=11.39e-6 mmin=1 mmax=4 subblock=0 m=1 mm_ok=1
XINV_vphi1 di_phi1 d_phi1_b vdd vss inv_lv
XINV_vphi2 di_phi2 d_phi2_b vdd vss inv_lv
XCDUM_COL[13] vdd vss cap_cmomf w=3e-6 l=2e-6 mmin=1 mmax=4 subblock=0 m=1 mm_ok=1
XCDUM_COL[12] vdd vss cap_cmomf w=3e-6 l=2e-6 mmin=1 mmax=4 subblock=0 m=1 mm_ok=1
XCDUM_COL[11] vdd vss cap_cmomf w=3e-6 l=2e-6 mmin=1 mmax=4 subblock=0 m=1 mm_ok=1
XCDUM_COL[10] vdd vss cap_cmomf w=3e-6 l=2e-6 mmin=1 mmax=4 subblock=0 m=1 mm_ok=1
XCDUM_COL[9] vdd vss cap_cmomf w=3e-6 l=2e-6 mmin=1 mmax=4 subblock=0 m=1 mm_ok=1
XCDUM_COL[8] vdd vss cap_cmomf w=3e-6 l=2e-6 mmin=1 mmax=4 subblock=0 m=1 mm_ok=1
XCDUM_COL[7] vdd vss cap_cmomf w=3e-6 l=2e-6 mmin=1 mmax=4 subblock=0 m=1 mm_ok=1
XCDUM_COL[6] vdd vss cap_cmomf w=3e-6 l=2e-6 mmin=1 mmax=4 subblock=0 m=1 mm_ok=1
XCDUM_COL[5] vdd vss cap_cmomf w=3e-6 l=2e-6 mmin=1 mmax=4 subblock=0 m=1 mm_ok=1
XCDUM_COL[4] vdd vss cap_cmomf w=3e-6 l=2e-6 mmin=1 mmax=4 subblock=0 m=1 mm_ok=1
XCDUM_COL[3] vdd vss cap_cmomf w=3e-6 l=2e-6 mmin=1 mmax=4 subblock=0 m=1 mm_ok=1
XCDUM_COL[2] vdd vss cap_cmomf w=3e-6 l=2e-6 mmin=1 mmax=4 subblock=0 m=1 mm_ok=1
XCDUM_COL[1] vdd vss cap_cmomf w=3e-6 l=2e-6 mmin=1 mmax=4 subblock=0 m=1 mm_ok=1
XCDUM_COL[0] vdd vss cap_cmomf w=3e-6 l=2e-6 mmin=1 mmax=4 subblock=0 m=1 mm_ok=1
.ends

.subckt inv_lv a y vdd vss
*.iopin vdd
*.iopin vss
*.ipin a
*.opin y
XMP y a vdd vdd sg13_lv_pmos w=2u l=0.13u ng=1 m=1 mm_ok=1
XMN y a vss vss sg13_lv_nmos w=1u l=0.13u ng=1 m=1 mm_ok=1
.ends

.subckt sg13cmos5l_buf_2 X A VDD VSS

*.ipin A
*.opin X
XM1 net1 A VSS VSS sg13_lv_nmos w=640.00n l=130.00n ng=1 m=1 mm_ok=1
XM2 X net1 VSS VSS sg13_lv_nmos w=1.48u l=130.00n ng=2 m=1 mm_ok=1
XM3 net1 A VDD VDD sg13_lv_pmos w=1.000u l=130.00n ng=1 m=1 mm_ok=1
XM4 X net1 VDD VDD sg13_lv_pmos w=2.24u l=130.00n ng=2 m=1 mm_ok=1
.ends

.subckt sg13cmos5l_and2_1 X A B VDD VSS

*.ipin A
*.ipin B
*.opin X
XM1 net1 A net2 VSS sg13_lv_nmos w=640.00n l=130.00n ng=1 m=1 mm_ok=1
XM2 net2 B VSS VSS sg13_lv_nmos w=640.00n l=130.00n ng=1 m=1 mm_ok=1
XM3 X net1 VSS VSS sg13_lv_nmos w=740.00n l=130.00n ng=1 m=1 mm_ok=1
XM4 net1 B VDD VDD sg13_lv_pmos w=840.00n l=130.00n ng=1 m=1 mm_ok=1
XM5 net1 A VDD VDD sg13_lv_pmos w=840.00n l=130.00n ng=1 m=1 mm_ok=1
XM6 X net1 VDD VDD sg13_lv_pmos w=1.12u l=130.00n ng=1 m=1 mm_ok=1
.ends

.subckt sg13cmos5l_nor3_1 Y A B C VDD VSS

*.ipin B
*.opin Y
*.ipin A
*.ipin C
XM1 Y A VSS VSS sg13_lv_nmos w=770.00n l=130.00n ng=1 m=1 mm_ok=1
XM2 Y B VSS VSS sg13_lv_nmos w=770.00n l=130.00n ng=1 m=1 mm_ok=1
XM3 Y C VSS VSS sg13_lv_nmos w=770.00n l=130.00n ng=1 m=1 mm_ok=1
XM4 net1 A VDD VDD sg13_lv_pmos w=1.12u l=130.00n ng=1 m=1 mm_ok=1
XM5 net2 B net1 VDD sg13_lv_pmos w=1.12u l=130.00n ng=1 m=1 mm_ok=1
XM6 Y C net2 VDD sg13_lv_pmos w=1.12u l=130.00n ng=1 m=1 mm_ok=1
.ends

.subckt sg13cmos5l_decap_8 VDD VSS

XM1 VSS VDD VSS VSS sg13_lv_nmos w=840.00n l=1.000u ng=2 m=1 mm_ok=1
XM2 VDD VSS VDD VDD sg13_lv_pmos w=2.000u l=1.000u ng=2 m=1 mm_ok=1
.ends

.subckt sg13cmos5l_decap_4 VDD VSS

XM1 VSS VDD VSS VSS sg13_lv_nmos w=420.00n l=1.000u ng=1 m=1 mm_ok=1
XM2 VDD VSS VDD VDD sg13_lv_pmos w=1.000u l=1.000u ng=1 m=1 mm_ok=1
.ends

.subckt sg13cmos5l_dlygate4sd3_1 X A VDD VSS

*.ipin A
*.opin X
XM1 net3 A VSS VSS sg13_lv_nmos w=420.00n l=130.00n ng=1 m=1 mm_ok=1
XM2 net1 net3 VSS VSS sg13_lv_nmos w=420.00n l=500.0n ng=1 m=1 mm_ok=1
XM3 net2 net1 VSS VSS sg13_lv_nmos w=420.00n l=500.0n ng=1 m=1 mm_ok=1
XM4 X net2 VSS VSS sg13_lv_nmos w=740.00n l=130.00n ng=1 m=1 mm_ok=1
XM5 net3 A VDD VDD sg13_lv_pmos w=420.00n l=130.00n ng=1 m=1 mm_ok=1
XM6 net1 net3 VDD VDD sg13_lv_pmos w=1.000u l=500.0n ng=1 m=1 mm_ok=1
XM7 net2 net1 VDD VDD sg13_lv_pmos w=1.000u l=500.0n ng=1 m=1 mm_ok=1
XM8 X net2 VDD VDD sg13_lv_pmos w=1.12u l=130.00n ng=1 m=1 mm_ok=1
.ends

.subckt sg13cmos5l_or2_1 X A B VDD VSS

*.opin X
*.ipin B
*.ipin A
XM1 net1 B VSS VSS sg13_lv_nmos w=550.00n l=130.00n ng=1 m=1 mm_ok=1
XM2 net1 A VSS VSS sg13_lv_nmos w=550.00n l=130.00n ng=1 m=1 mm_ok=1
XM3 X net1 VSS VSS sg13_lv_nmos w=740.00n l=130.00n ng=1 m=1 mm_ok=1
XM4 net2 A VDD VDD sg13_lv_pmos w=840.00n l=130.00n ng=1 m=1 mm_ok=1
XM5 net1 B net2 VDD sg13_lv_pmos w=840.00n l=130.00n ng=1 m=1 mm_ok=1
XM6 X net1 VDD VDD sg13_lv_pmos w=1.12u l=130.00n ng=1 m=1 mm_ok=1
.ends

.subckt bias_trim vdd vss vz di_trim_b[3] di_trim_b[2] di_trim_b[1] di_trim_b[0] iout
*.iopin vdd
*.ipin vz
*.iopin iout
*.iopin vss
*.ipin di_trim_b[3],di_trim_b[2],di_trim_b[1],di_trim_b[0]
XMPF vdf vz vdd vdd sg13_lv_pmos w=0.5u l=5u ng=1 m=16 mm_ok=1
XMSF iout vss vdf vdd sg13_lv_pmos w=0.5u l=5u ng=1 m=2 mm_ok=1
XMP3 vd3 vz vdd vdd sg13_lv_pmos w=0.5u l=5u ng=1 m=16 mm_ok=1
XMS3 iout di_trim_b[3] vd3 vdd sg13_lv_pmos w=0.5u l=5u ng=1 m=2 mm_ok=1
XMP2 vd2 vz vdd vdd sg13_lv_pmos w=0.5u l=5u ng=1 m=8 mm_ok=1
XMS2 iout di_trim_b[2] vd2 vdd sg13_lv_pmos w=0.5u l=5u ng=1 m=2 mm_ok=1
XMP1 vd1 vz vdd vdd sg13_lv_pmos w=0.5u l=5u ng=1 m=4 mm_ok=1
XMS1 iout di_trim_b[1] vd1 vdd sg13_lv_pmos w=0.5u l=5u ng=1 m=2 mm_ok=1
XMP0 vd0 vz vdd vdd sg13_lv_pmos w=0.5u l=5u ng=1 m=2 mm_ok=1
XMS0 iout di_trim_b[0] vd0 vdd sg13_lv_pmos w=0.5u l=5u ng=1 m=2 mm_ok=1
XMPD vdd vdd vdd vdd sg13_lv_pmos w=0.5u l=5u ng=1 m=40 mm_ok=1
.ends

.subckt quantizer2_sal di_clk vdd vi_n vi_p do_n do_p vss di_en vg_q[2] vg_q[1] vg_q[0] vg_p[2] vg_p[1] vg_p[0]
*.iopin vdd
*.iopin vss
*.iopin di_en
*.iopin di_clk
*.iopin do_p
*.iopin do_n
*.iopin vi_n
*.iopin vi_p
*.iopin vg_q[2],vg_q[1],vg_q[0]
*.iopin vg_p[2],vg_p[1],vg_p[0]
XINV0 vdd vss di_en d_en_b inv_en
XINV1 vdd vss d_en_b d_en inv_en
XAND0 d_gclk d_en di_clk vdd vss sg13cmos5l_and2_2
XP1 do_p do_n vdd vdd sg13_lv_pmos w=6u l=500n ng=4 m=1 mm_ok=1
XP0 do_n do_p vdd vdd sg13_lv_pmos w=6u l=500n ng=4 m=1 mm_ok=1
XN4 do_p do_n v_p vss sg13_lv_nmos w=2u l=500n ng=4 m=1 mm_ok=1
XN3 do_n do_p v_q vss sg13_lv_nmos w=2u l=500n ng=4 m=1 mm_ok=1
XN1 v_p vi_n vtail vss sg13_lv_nmos w=16u l=500n ng=4 m=1 mm_ok=1
XN0 v_q vi_p vtail vss sg13_lv_nmos w=16u l=500n ng=4 m=1 mm_ok=1
XN2 vtail d_gclk vss vss sg13_lv_nmos w=32u l=500n ng=8 m=1 mm_ok=1
XP5 v_p d_gclk vdd vdd sg13_lv_pmos w=6u l=500n ng=4 m=1 mm_ok=1
XP2 do_p d_gclk vdd vdd sg13_lv_pmos w=6u l=500n ng=4 m=1 mm_ok=1
XP3 do_n d_gclk vdd vdd sg13_lv_pmos w=6u l=500n ng=4 m=1 mm_ok=1
XP4 v_q d_gclk vdd vdd sg13_lv_pmos w=6u l=500n ng=4 m=1 mm_ok=1
XMN43[3] do_p vss vss vss sg13_lv_nmos w=500n l=500n ng=1 m=1 mm_ok=1
XMN43[2] do_p vss vss vss sg13_lv_nmos w=500n l=500n ng=1 m=1 mm_ok=1
XMN43[1] do_p vss vss vss sg13_lv_nmos w=500n l=500n ng=1 m=1 mm_ok=1
XMN43[0] do_p vss vss vss sg13_lv_nmos w=500n l=500n ng=1 m=1 mm_ok=1
XMNDUM2[3] do_n vss vss vss sg13_lv_nmos w=500n l=500n ng=1 m=1 mm_ok=1
XMNDUM2[2] do_n vss vss vss sg13_lv_nmos w=500n l=500n ng=1 m=1 mm_ok=1
XMNDUM2[1] do_n vss vss vss sg13_lv_nmos w=500n l=500n ng=1 m=1 mm_ok=1
XMNDUM2[0] do_n vss vss vss sg13_lv_nmos w=500n l=500n ng=1 m=1 mm_ok=1
XNDUM1 vss vss vss vss sg13_lv_nmos w=16u l=500n ng=4 m=1 mm_ok=1
XNDUM0 vtail vss vss vss sg13_lv_nmos w=8u l=500n ng=2 m=1 mm_ok=1
XMPDUM1[3] do_p vdd vdd vdd sg13_lv_pmos w=1.5u l=500n ng=1 m=1 mm_ok=1
XMPDUM1[2] do_p vdd vdd vdd sg13_lv_pmos w=1.5u l=500n ng=1 m=1 mm_ok=1
XMPDUM1[1] do_p vdd vdd vdd sg13_lv_pmos w=1.5u l=500n ng=1 m=1 mm_ok=1
XMPDUM1[0] do_p vdd vdd vdd sg13_lv_pmos w=1.5u l=500n ng=1 m=1 mm_ok=1
XMPDUM0[3] do_n vdd vdd vdd sg13_lv_pmos w=1.5u l=500n ng=1 m=1 mm_ok=1
XMPDUM0[2] do_n vdd vdd vdd sg13_lv_pmos w=1.5u l=500n ng=1 m=1 mm_ok=1
XMPDUM0[1] do_n vdd vdd vdd sg13_lv_pmos w=1.5u l=500n ng=1 m=1 mm_ok=1
XMPDUM0[0] do_n vdd vdd vdd sg13_lv_pmos w=1.5u l=500n ng=1 m=1 mm_ok=1
XMPDUM2[11] vdd vdd vdd vdd sg13_lv_pmos w=1.5u l=500n ng=1 m=1 mm_ok=1
XMPDUM2[10] vdd vdd vdd vdd sg13_lv_pmos w=1.5u l=500n ng=1 m=1 mm_ok=1
XMPDUM2[9] vdd vdd vdd vdd sg13_lv_pmos w=1.5u l=500n ng=1 m=1 mm_ok=1
XMPDUM2[8] vdd vdd vdd vdd sg13_lv_pmos w=1.5u l=500n ng=1 m=1 mm_ok=1
XMPDUM2[7] vdd vdd vdd vdd sg13_lv_pmos w=1.5u l=500n ng=1 m=1 mm_ok=1
XMPDUM2[6] vdd vdd vdd vdd sg13_lv_pmos w=1.5u l=500n ng=1 m=1 mm_ok=1
XMPDUM2[5] vdd vdd vdd vdd sg13_lv_pmos w=1.5u l=500n ng=1 m=1 mm_ok=1
XMPDUM2[4] vdd vdd vdd vdd sg13_lv_pmos w=1.5u l=500n ng=1 m=1 mm_ok=1
XMPDUM2[3] vdd vdd vdd vdd sg13_lv_pmos w=1.5u l=500n ng=1 m=1 mm_ok=1
XMPDUM2[2] vdd vdd vdd vdd sg13_lv_pmos w=1.5u l=500n ng=1 m=1 mm_ok=1
XMPDUM2[1] vdd vdd vdd vdd sg13_lv_pmos w=1.5u l=500n ng=1 m=1 mm_ok=1
XMPDUM2[0] vdd vdd vdd vdd sg13_lv_pmos w=1.5u l=500n ng=1 m=1 mm_ok=1
XMNDUM3[5] vss vss vss vss sg13_lv_nmos w=500n l=500n ng=1 m=1 mm_ok=1
XMNDUM3[4] vss vss vss vss sg13_lv_nmos w=500n l=500n ng=1 m=1 mm_ok=1
XMNDUM3[3] vss vss vss vss sg13_lv_nmos w=500n l=500n ng=1 m=1 mm_ok=1
XMNDUM3[2] vss vss vss vss sg13_lv_nmos w=500n l=500n ng=1 m=1 mm_ok=1
XMNDUM3[1] vss vss vss vss sg13_lv_nmos w=500n l=500n ng=1 m=1 mm_ok=1
XMNDUM3[0] vss vss vss vss sg13_lv_nmos w=500n l=500n ng=1 m=1 mm_ok=1
XMAQ0 v_q vg_q[0] vtail vss sg13_lv_nmos w=1.5u l=500n ng=1 m=1 mm_ok=1
XMAQ1 v_q vg_q[1] vtail vss sg13_lv_nmos w=3u l=500n ng=2 m=1 mm_ok=1
XMAQ2 v_q vg_q[2] vtail vss sg13_lv_nmos w=6u l=500n ng=4 m=1 mm_ok=1
XMAP0 v_p vg_p[0] vtail vss sg13_lv_nmos w=1.5u l=500n ng=1 m=1 mm_ok=1
XMAP1 v_p vg_p[1] vtail vss sg13_lv_nmos w=3u l=500n ng=2 m=1 mm_ok=1
XMAP2 v_p vg_p[2] vtail vss sg13_lv_nmos w=6u l=500n ng=4 m=1 mm_ok=1
XMNDA0[1] vss vss vss vss sg13_lv_nmos w=1.5u l=500n ng=1 m=1 mm_ok=1
XMNDA0[0] vss vss vss vss sg13_lv_nmos w=1.5u l=500n ng=1 m=1 mm_ok=1
XMNDA1[1] vtail vss vss vss sg13_lv_nmos w=1.5u l=500n ng=1 m=1 mm_ok=1
XMNDA1[0] vtail vss vss vss sg13_lv_nmos w=1.5u l=500n ng=1 m=1 mm_ok=1
XMNDA2[1] vtail vss vtail vss sg13_lv_nmos w=1.5u l=500n ng=1 m=1 mm_ok=1
XMNDA2[0] vtail vss vtail vss sg13_lv_nmos w=1.5u l=500n ng=1 m=1 mm_ok=1
XMAQD v_q vss vtail vss sg13_lv_nmos w=1.5u l=500n ng=1 m=1 mm_ok=1
XMAPD v_p vss vtail vss sg13_lv_nmos w=1.5u l=500n ng=1 m=1 mm_ok=1
.ends

.subckt sg13cmos5l_inv_2 Y A VDD VSS

*.opin Y
*.ipin A
XM1 Y A VSS VSS sg13_lv_nmos w=1.48u l=130.00n ng=2 m=1 mm_ok=1
XM2 Y A VDD VDD sg13_lv_pmos w=2.24u l=130.00n ng=2 m=1 mm_ok=1
.ends

.subckt sg13cmos5l_nand2_2 Y A B VDD VSS

*.opin Y
*.ipin B
*.ipin A
XM1 Y A net1 VSS sg13_lv_nmos w=1.44u l=130.00n ng=2 m=1 mm_ok=1
XM2 net1 B VSS VSS sg13_lv_nmos w=1.44u l=130.00n ng=2 m=1 mm_ok=1
XM3 Y A VDD VDD sg13_lv_pmos w=2.24u l=130.00n ng=2 m=1 mm_ok=1
XM4 Y B VDD VDD sg13_lv_pmos w=2.24u l=130.00n ng=2 m=1 mm_ok=1
.ends

.subckt sg13cmos5l_nor2_2 Y A B VDD VSS

*.opin Y
*.ipin B
*.ipin A
XM1 Y A VSS VSS sg13_lv_nmos w=1.48u l=130.00n ng=2 m=1 mm_ok=1
XM2 Y B VSS VSS sg13_lv_nmos w=1.48u l=130.00n ng=2 m=1 mm_ok=1
XM3 net1 A VDD VDD sg13_lv_pmos w=2.24u l=130.00n ng=2 m=1 mm_ok=1
XM4 Y B net1 VDD sg13_lv_pmos w=2.24u l=130.00n ng=2 m=1 mm_ok=1
.ends

.subckt sg13cmos5l_and2_2 X A B VDD VSS

*.ipin A
*.ipin B
*.opin X
XM1 net1 A net2 VSS sg13_lv_nmos w=640.00n l=130.00n ng=1 m=1 mm_ok=1
XM2 net2 B VSS VSS sg13_lv_nmos w=640.00n l=130.00n ng=1 m=1 mm_ok=1
XM3 X net1 VSS VSS sg13_lv_nmos w=1.48u l=130.00n ng=2 m=1 mm_ok=1
XM4 net1 B VDD VDD sg13_lv_pmos w=840.00n l=130.00n ng=1 m=1 mm_ok=1
XM5 net1 A VDD VDD sg13_lv_pmos w=840.00n l=130.00n ng=1 m=1 mm_ok=1
XM6 X net1 VDD VDD sg13_lv_pmos w=2.24u l=130.00n ng=2 m=1 mm_ok=1
.ends

.subckt sg13cmos5l_inv_4 Y A VDD VSS

*.ipin A
*.opin Y
XM1 Y A VSS VSS sg13_lv_nmos w=2.96u l=130.00n ng=4 m=1 mm_ok=1
XM2 Y A VDD VDD sg13_lv_pmos w=4.48u l=130.00n ng=4 m=1 mm_ok=1
.ends

.subckt quantizer2_dith di_clk di_dith[2] di_dith[1] di_dith[0] di_amp_s[3] di_amp_s[2] di_amp_s[1] di_amp_s[0] di_amp_s_b[3]
+ di_amp_s_b[2] di_amp_s_b[1] di_amp_s_b[0] vi_p vi_n vg_q[2] vg_q[1] vg_q[0] vg_p[2] vg_p[1] vg_p[0] vdd di_en di_dith_en vss
*.ipin di_dith_en
*.ipin di_en
*.ipin di_clk
*.ipin di_dith[2],di_dith[1],di_dith[0]
*.ipin di_amp_s[3],di_amp_s[2],di_amp_s[1],di_amp_s[0]
*.ipin di_amp_s_b[3],di_amp_s_b[2],di_amp_s_b[1],di_amp_s_b[0]
*.iopin vg_q[2],vg_q[1],vg_q[0]
*.iopin vg_p[2],vg_p[1],vg_p[0]
*.iopin vi_p
*.iopin vi_n
*.iopin vdd
*.iopin vss
XINVEN d_en_b di_dith_en vdd vss sg13cmos5l_inv_1
XINVENL d_enl_b di_en vdd vss sg13cmos5l_inv_1
XRDLY d_rc di_clk vss rhigh w=0.5e-6 l=40e-6 m=1 b=0 mm_ok=1
XMCDLY vss d_rc vss vss sg13_lv_nmos w=7u l=1u ng=2 m=1 mm_ok=1
XIRC1 d_rc_b d_rc vdd vss sg13cmos5l_inv_1
XIRC2 d_dl[1] d_rc_b vdd vss sg13cmos5l_inv_1
XDLY[3] d_dl[3] d_dl[2] vdd vss sg13cmos5l_dlygate4sd3_1
XDLY[2] d_dl[2] d_dl[1] vdd vss sg13cmos5l_dlygate4sd3_1
XAPH d_p12 d_dl[2] d_dl[3] vdd vss sg13cmos5l_and2_1
XAPHE d_ph d_p12 di_dith_en vdd vss sg13cmos5l_and2_1
XNORBI d_nph d_dl[2] d_dl[3] vdd vss sg13cmos5l_nor2_1
XABVI d_bvi d_nph di_dith_en vdd vss sg13cmos5l_and2_1
XIBVI d_bvi_b d_bvi vdd vss sg13cmos5l_inv_1
XOBVC d_bvc d_p12 d_en_b vdd vss sg13cmos5l_or2_1
XIBVC d_bvc_b d_bvc vdd vss sg13cmos5l_inv_1
XINVB[2] d_bb[2] di_dith[2] vdd vss sg13cmos5l_inv_1
XINVB[1] d_bb[1] di_dith[1] vdd vss sg13cmos5l_inv_1
XINVB[0] d_bb[0] di_dith[0] vdd vss sg13cmos5l_inv_1
XNA1[2] d_c1_b[2] d_ph di_dith[2] vdd vss sg13cmos5l_nand2_1
XNA1[1] d_c1_b[1] d_ph di_dith[1] vdd vss sg13cmos5l_nand2_1
XNA1[0] d_c1_b[0] d_ph di_dith[0] vdd vss sg13cmos5l_nand2_1
XIA1[2] d_c1[2] d_c1_b[2] vdd vss sg13cmos5l_inv_1
XIA1[1] d_c1[1] d_c1_b[1] vdd vss sg13cmos5l_inv_1
XIA1[0] d_c1[0] d_c1_b[0] vdd vss sg13cmos5l_inv_1
XNA0[2] d_c0_b[2] d_ph d_bb[2] vdd vss sg13cmos5l_nand2_1
XNA0[1] d_c0_b[1] d_ph d_bb[1] vdd vss sg13cmos5l_nand2_1
XNA0[0] d_c0_b[0] d_ph d_bb[0] vdd vss sg13cmos5l_nand2_1
XIA0[2] d_c0[2] d_c0_b[2] vdd vss sg13cmos5l_inv_1
XIA0[1] d_c0[1] d_c0_b[1] vdd vss sg13cmos5l_inv_1
XIA0[0] d_c0[0] d_c0_b[0] vdd vss sg13cmos5l_inv_1
XMPLAD net1 d_enl_b vdd vdd sg13_lv_pmos w=1u l=0.5u ng=1 m=1 mm_ok=1
XRTOP net1 t[24] vss rhigh w=0.5e-6 l=80.4e-6 m=1 b=0 mm_ok=1
XRL[7] t[24] t[23] vss rhigh w=0.5e-6 l=4.08e-6 m=1 b=0 mm_ok=1
XRL[6] t[23] t[22] vss rhigh w=0.5e-6 l=4.08e-6 m=1 b=0 mm_ok=1
XRL[5] t[22] t[21] vss rhigh w=0.5e-6 l=4.08e-6 m=1 b=0 mm_ok=1
XRL[4] t[21] t[20] vss rhigh w=0.5e-6 l=4.08e-6 m=1 b=0 mm_ok=1
XRL[3] t[20] t[19] vss rhigh w=0.5e-6 l=4.08e-6 m=1 b=0 mm_ok=1
XRL[2] t[19] t[18] vss rhigh w=0.5e-6 l=4.08e-6 m=1 b=0 mm_ok=1
XRL[1] t[18] t[17] vss rhigh w=0.5e-6 l=4.08e-6 m=1 b=0 mm_ok=1
XRL[0] t[17] t[16] vss rhigh w=0.5e-6 l=4.08e-6 m=1 b=0 mm_ok=1
XRBOT t[16] vss vss rhigh w=0.5e-6 l=80.4e-6 m=1 b=0 mm_ok=1
XMCDLYD vss vdd vss vss sg13_lv_nmos w=7u l=1u ng=2 m=1 mm_ok=1
XMPLADD vdd vdd vdd vdd sg13_lv_pmos w=1u l=0.5u ng=1 m=1 mm_ok=1
XRDUM[1] vss vss vss rhigh w=0.5e-6 l=10.05e-6 m=1 b=0 mm_ok=1
XRDUM[0] vss vss vss rhigh w=0.5e-6 l=10.05e-6 m=1 b=0 mm_ok=1
XRDUMT[1] vss vss vss rhigh w=0.5e-6 l=20e-6 m=1 b=0 mm_ok=1
XRDUMT[0] vss vss vss rhigh w=0.5e-6 l=20e-6 m=1 b=0 mm_ok=1
XMAMHN[3] vh di_amp_s[3] t[21] vss sg13_lv_nmos w=0.5u l=0.13u ng=1 m=1 mm_ok=1
XMAMHN[2] vh di_amp_s[2] t[24] vss sg13_lv_nmos w=0.5u l=0.13u ng=1 m=1 mm_ok=1
XMAMHN[1] vh di_amp_s[1] t[22] vss sg13_lv_nmos w=0.5u l=0.13u ng=1 m=1 mm_ok=1
XMAMHN[0] vh di_amp_s[0] t[23] vss sg13_lv_nmos w=0.5u l=0.13u ng=1 m=1 mm_ok=1
XMAMHP[3] t[21] di_amp_s_b[3] vh vdd sg13_lv_pmos w=0.5u l=0.13u ng=1 m=1 mm_ok=1
XMAMHP[2] t[24] di_amp_s_b[2] vh vdd sg13_lv_pmos w=0.5u l=0.13u ng=1 m=1 mm_ok=1
XMAMHP[1] t[22] di_amp_s_b[1] vh vdd sg13_lv_pmos w=0.5u l=0.13u ng=1 m=1 mm_ok=1
XMAMHP[0] t[23] di_amp_s_b[0] vh vdd sg13_lv_pmos w=0.5u l=0.13u ng=1 m=1 mm_ok=1
XMAMLN[3] vl di_amp_s[3] t[19] vss sg13_lv_nmos w=0.5u l=0.13u ng=1 m=1 mm_ok=1
XMAMLN[2] vl di_amp_s[2] t[16] vss sg13_lv_nmos w=0.5u l=0.13u ng=1 m=1 mm_ok=1
XMAMLN[1] vl di_amp_s[1] t[18] vss sg13_lv_nmos w=0.5u l=0.13u ng=1 m=1 mm_ok=1
XMAMLN[0] vl di_amp_s[0] t[17] vss sg13_lv_nmos w=0.5u l=0.13u ng=1 m=1 mm_ok=1
XMAMLP[3] t[19] di_amp_s_b[3] vl vdd sg13_lv_pmos w=0.5u l=0.13u ng=1 m=1 mm_ok=1
XMAMLP[2] t[16] di_amp_s_b[2] vl vdd sg13_lv_pmos w=0.5u l=0.13u ng=1 m=1 mm_ok=1
XMAMLP[1] t[18] di_amp_s_b[1] vl vdd sg13_lv_pmos w=0.5u l=0.13u ng=1 m=1 mm_ok=1
XMAMLP[0] t[17] di_amp_s_b[0] vl vdd sg13_lv_pmos w=0.5u l=0.13u ng=1 m=1 mm_ok=1
XMGQHN[2] vg_q[2] d_c1[2] vh vss sg13_lv_nmos w=0.5u l=0.13u ng=1 m=1 mm_ok=1
XMGQHN[1] vg_q[1] d_c1[1] vh vss sg13_lv_nmos w=0.5u l=0.13u ng=1 m=1 mm_ok=1
XMGQHN[0] vg_q[0] d_c1[0] vh vss sg13_lv_nmos w=0.5u l=0.13u ng=1 m=1 mm_ok=1
XMGQHP[2] vh d_c1_b[2] vg_q[2] vdd sg13_lv_pmos w=0.5u l=0.13u ng=1 m=1 mm_ok=1
XMGQHP[1] vh d_c1_b[1] vg_q[1] vdd sg13_lv_pmos w=0.5u l=0.13u ng=1 m=1 mm_ok=1
XMGQHP[0] vh d_c1_b[0] vg_q[0] vdd sg13_lv_pmos w=0.5u l=0.13u ng=1 m=1 mm_ok=1
XMGQLN[2] vg_q[2] d_c0[2] vl vss sg13_lv_nmos w=0.5u l=0.13u ng=1 m=1 mm_ok=1
XMGQLN[1] vg_q[1] d_c0[1] vl vss sg13_lv_nmos w=0.5u l=0.13u ng=1 m=1 mm_ok=1
XMGQLN[0] vg_q[0] d_c0[0] vl vss sg13_lv_nmos w=0.5u l=0.13u ng=1 m=1 mm_ok=1
XMGQLP[2] vl d_c0_b[2] vg_q[2] vdd sg13_lv_pmos w=0.5u l=0.13u ng=1 m=1 mm_ok=1
XMGQLP[1] vl d_c0_b[1] vg_q[1] vdd sg13_lv_pmos w=0.5u l=0.13u ng=1 m=1 mm_ok=1
XMGQLP[0] vl d_c0_b[0] vg_q[0] vdd sg13_lv_pmos w=0.5u l=0.13u ng=1 m=1 mm_ok=1
XMGPHN[2] vg_p[2] d_c0[2] vh vss sg13_lv_nmos w=0.5u l=0.13u ng=1 m=1 mm_ok=1
XMGPHN[1] vg_p[1] d_c0[1] vh vss sg13_lv_nmos w=0.5u l=0.13u ng=1 m=1 mm_ok=1
XMGPHN[0] vg_p[0] d_c0[0] vh vss sg13_lv_nmos w=0.5u l=0.13u ng=1 m=1 mm_ok=1
XMGPHP[2] vh d_c0_b[2] vg_p[2] vdd sg13_lv_pmos w=0.5u l=0.13u ng=1 m=1 mm_ok=1
XMGPHP[1] vh d_c0_b[1] vg_p[1] vdd sg13_lv_pmos w=0.5u l=0.13u ng=1 m=1 mm_ok=1
XMGPHP[0] vh d_c0_b[0] vg_p[0] vdd sg13_lv_pmos w=0.5u l=0.13u ng=1 m=1 mm_ok=1
XMGPLN[2] vg_p[2] d_c1[2] vl vss sg13_lv_nmos w=0.5u l=0.13u ng=1 m=1 mm_ok=1
XMGPLN[1] vg_p[1] d_c1[1] vl vss sg13_lv_nmos w=0.5u l=0.13u ng=1 m=1 mm_ok=1
XMGPLN[0] vg_p[0] d_c1[0] vl vss sg13_lv_nmos w=0.5u l=0.13u ng=1 m=1 mm_ok=1
XMGPLP[2] vl d_c1_b[2] vg_p[2] vdd sg13_lv_pmos w=0.5u l=0.13u ng=1 m=1 mm_ok=1
XMGPLP[1] vl d_c1_b[1] vg_p[1] vdd sg13_lv_pmos w=0.5u l=0.13u ng=1 m=1 mm_ok=1
XMGPLP[0] vl d_c1_b[0] vg_p[0] vdd sg13_lv_pmos w=0.5u l=0.13u ng=1 m=1 mm_ok=1
XMPDQ[2] vg_q[2] d_en_b vss vss sg13_lv_nmos w=0.5u l=0.13u ng=1 m=1 mm_ok=1
XMPDQ[1] vg_q[1] d_en_b vss vss sg13_lv_nmos w=0.5u l=0.13u ng=1 m=1 mm_ok=1
XMPDQ[0] vg_q[0] d_en_b vss vss sg13_lv_nmos w=0.5u l=0.13u ng=1 m=1 mm_ok=1
XMPDP[2] vg_p[2] d_en_b vss vss sg13_lv_nmos w=0.5u l=0.13u ng=1 m=1 mm_ok=1
XMPDP[1] vg_p[1] d_en_b vss vss sg13_lv_nmos w=0.5u l=0.13u ng=1 m=1 mm_ok=1
XMPDP[0] vg_p[0] d_en_b vss vss sg13_lv_nmos w=0.5u l=0.13u ng=1 m=1 mm_ok=1
XCFQ0 v_bq vg_q[0] cap_cmomf w=7.6e-6 l=4.1e-6 mmin=1 mmax=4 subblock=0 m=1 mm_ok=1
XCFQ1[1] v_bq vg_q[1] cap_cmomf w=7.6e-6 l=4.1e-6 mmin=1 mmax=4 subblock=0 m=1 mm_ok=1
XCFQ1[0] v_bq vg_q[1] cap_cmomf w=7.6e-6 l=4.1e-6 mmin=1 mmax=4 subblock=0 m=1 mm_ok=1
XCFQ2[1] v_bq vg_q[2] cap_cmomf w=7.6e-6 l=4.1e-6 mmin=1 mmax=4 subblock=0 m=1 mm_ok=1
XCFQ2[0] v_bq vg_q[2] cap_cmomf w=7.6e-6 l=4.1e-6 mmin=1 mmax=4 subblock=0 m=1 mm_ok=1
XCFQ2[3] vg_q[2] v_bq cap_cmomf w=7.6e-6 l=4.1e-6 mmin=1 mmax=4 subblock=0 m=1 mm_ok=1
XCFQ2[2] vg_q[2] v_bq cap_cmomf w=7.6e-6 l=4.1e-6 mmin=1 mmax=4 subblock=0 m=1 mm_ok=1
XCFQD v_bq v_bq cap_cmomf w=7.6e-6 l=4.1e-6 mmin=1 mmax=4 subblock=0 m=1 mm_ok=1
XMBCQN t[20] d_bvc v_bq vss sg13_lv_nmos w=21u l=0.13u ng=6 m=1 mm_ok=1
XMBCQP v_bq d_bvc_b t[20] vdd sg13_lv_pmos w=21u l=0.13u ng=6 m=1 mm_ok=1
XMBIQN vi_p d_bvi v_bq vss sg13_lv_nmos w=21u l=0.13u ng=6 m=1 mm_ok=1
XMBIQP v_bq d_bvi_b vi_p vdd sg13_lv_pmos w=21u l=0.13u ng=6 m=1 mm_ok=1
XCFP0 vg_p[0] v_bp cap_cmomf w=7.6e-6 l=4.1e-6 mmin=1 mmax=4 subblock=0 m=1 mm_ok=1
XCFP1[1] vg_p[1] v_bp cap_cmomf w=7.6e-6 l=4.1e-6 mmin=1 mmax=4 subblock=0 m=1 mm_ok=1
XCFP1[0] vg_p[1] v_bp cap_cmomf w=7.6e-6 l=4.1e-6 mmin=1 mmax=4 subblock=0 m=1 mm_ok=1
XCFP2[1] vg_p[2] v_bp cap_cmomf w=7.6e-6 l=4.1e-6 mmin=1 mmax=4 subblock=0 m=1 mm_ok=1
XCFP2[0] vg_p[2] v_bp cap_cmomf w=7.6e-6 l=4.1e-6 mmin=1 mmax=4 subblock=0 m=1 mm_ok=1
XCFP2[3] v_bp vg_p[2] cap_cmomf w=7.6e-6 l=4.1e-6 mmin=1 mmax=4 subblock=0 m=1 mm_ok=1
XCFP2[2] v_bp vg_p[2] cap_cmomf w=7.6e-6 l=4.1e-6 mmin=1 mmax=4 subblock=0 m=1 mm_ok=1
XCFPD v_bp v_bp cap_cmomf w=7.6e-6 l=4.1e-6 mmin=1 mmax=4 subblock=0 m=1 mm_ok=1
XMBCPN t[20] d_bvc v_bp vss sg13_lv_nmos w=21u l=0.13u ng=6 m=1 mm_ok=1
XMBCPP v_bp d_bvc_b t[20] vdd sg13_lv_pmos w=21u l=0.13u ng=6 m=1 mm_ok=1
XMBIPN vi_n d_bvi v_bp vss sg13_lv_nmos w=21u l=0.13u ng=6 m=1 mm_ok=1
XMBIPP v_bp d_bvi_b vi_n vdd sg13_lv_pmos w=21u l=0.13u ng=6 m=1 mm_ok=1
.ends

.subckt sg13cmos5l_dfrbpq_1 Q CLK D RESET_B VDD VSS

*.opin Q
*.ipin CLK
*.ipin D
*.ipin RESET_B
XM1 Db D net12 VSS sg13_lv_nmos w=420.00n l=130.00n ng=1 m=1 mm_ok=1
XM2 net12 RESET_B VSS VSS sg13_lv_nmos w=420.00n l=130.00n ng=1 m=1 mm_ok=1
XM3 net3 clkneg net11 VSS sg13_lv_nmos w=420.00n l=130.00n ng=1 m=1 mm_ok=1
XM4 net11 net1 VSS VSS sg13_lv_nmos w=420.00n l=130.00n ng=1 m=1 mm_ok=1
XM5 net1 net3 net7 VSS sg13_lv_nmos w=420.00n l=130.00n ng=1 m=1 mm_ok=1
XM6 net7 RESET_B VSS VSS sg13_lv_nmos w=420.00n l=130.00n ng=1 m=1 mm_ok=1
XM7 net2 net3 VSS VSS sg13_lv_nmos w=740.00n l=130.00n ng=1 m=1 mm_ok=1
XM8 Q net2 VSS VSS sg13_lv_nmos w=740.00n l=130.00n ng=1 m=1 mm_ok=1
XM9 clkneg CLK VSS VSS sg13_lv_nmos w=740.00n l=130.00n ng=1 m=1 mm_ok=1
XM10 clkpos clkneg VSS VSS sg13_lv_nmos w=740.00n l=130.00n ng=1 m=1 mm_ok=1
XM11 Db clkneg net5 VSS sg13_lv_nmos w=420.00n l=130.00n ng=1 m=1 mm_ok=1
XM12 net5 clkpos net10 VSS sg13_lv_nmos w=420.00n l=130.00n ng=1 m=1 mm_ok=1
XM13 net10 net4 net6 VSS sg13_lv_nmos w=420.00n l=130.00n ng=1 m=1 mm_ok=1
XM14 net6 RESET_B VSS VSS sg13_lv_nmos w=420.00n l=130.00n ng=1 m=1 mm_ok=1
XM15 net4 net5 VSS VSS sg13_lv_nmos w=740.00n l=130.00n ng=1 m=1 mm_ok=1
XM16 net4 clkpos net3 VSS sg13_lv_nmos w=740.00n l=130.00n ng=1 m=1 mm_ok=1
XM17 Db RESET_B VDD VDD sg13_lv_pmos w=420.00n l=130.00n ng=1 m=1 mm_ok=1
XM18 Db D VDD VDD sg13_lv_pmos w=420.00n l=130.00n ng=1 m=1 mm_ok=1
XM19 net9 net1 VDD VDD sg13_lv_pmos w=420.00n l=130.00n ng=1 m=1 mm_ok=1
XM20 net3 clkpos net9 VDD sg13_lv_pmos w=420.00n l=130.00n ng=1 m=1 mm_ok=1
XM21 net1 net3 VDD VDD sg13_lv_pmos w=420.00n l=130.00n ng=1 m=1 mm_ok=1
XM22 net1 RESET_B VDD VDD sg13_lv_pmos w=420.00n l=130.00n ng=1 m=1 mm_ok=1
XM23 net2 net3 VDD VDD sg13_lv_pmos w=1.12u l=130.00n ng=1 m=1 mm_ok=1
XM24 Q net2 VDD VDD sg13_lv_pmos w=1.12u l=130.00n ng=1 m=1 mm_ok=1
XM25 clkneg CLK VDD VDD sg13_lv_pmos w=1.12u l=130.00n ng=1 m=1 mm_ok=1
XM26 clkpos clkneg VDD VDD sg13_lv_pmos w=1.12u l=130.00n ng=1 m=1 mm_ok=1
XM27 Db clkpos net5 VDD sg13_lv_pmos w=420.00n l=130.00n ng=1 m=1 mm_ok=1
XM28 net8 net4 VDD VDD sg13_lv_pmos w=420.00n l=130.00n ng=1 m=1 mm_ok=1
XM29 net5 clkneg net8 VDD sg13_lv_pmos w=420.00n l=130.00n ng=1 m=1 mm_ok=1
XM30 net5 RESET_B VDD VDD sg13_lv_pmos w=420.00n l=130.00n ng=1 m=1 mm_ok=1
XM31 net4 net5 VDD VDD sg13_lv_pmos w=1.000u l=130.00n ng=1 m=1 mm_ok=1
XM32 net4 clkneg net3 VDD sg13_lv_pmos w=1.000u l=130.00n ng=1 m=1 mm_ok=1
.ends

.subckt sg13cmos5l_xnor2_1 Y A B VDD VSS

*.ipin A
*.opin Y
*.ipin B
XM1 net1 B net4 VSS sg13_lv_nmos w=640.00n l=130.00n ng=1 m=1 mm_ok=1
XM2 net4 A VSS VSS sg13_lv_nmos w=640.00n l=130.00n ng=1 m=1 mm_ok=1
XM3 net2 A VSS VSS sg13_lv_nmos w=740.00n l=130.00n ng=1 m=1 mm_ok=1
XM4 Y net1 net2 VSS sg13_lv_nmos w=740.00n l=130.00n ng=1 m=1 mm_ok=1
XM5 net2 B VSS VSS sg13_lv_nmos w=740.00n l=130.00n ng=1 m=1 mm_ok=1
XM6 net1 A VDD VDD sg13_lv_pmos w=840.00n l=130.00n ng=1 m=1 mm_ok=1
XM7 net1 B VDD VDD sg13_lv_pmos w=840.00n l=130.00n ng=1 m=1 mm_ok=1
XM8 net3 A VDD VDD sg13_lv_pmos w=1.12u l=130.00n ng=1 m=1 mm_ok=1
XM9 Y B net3 VDD sg13_lv_pmos w=1.12u l=130.00n ng=1 m=1 mm_ok=1
XM10 Y net1 VDD VDD sg13_lv_pmos w=1.12u l=130.00n ng=1 m=1 mm_ok=1
.ends

.subckt sg13cmos5l_buf_1 X A VDD VSS

*.ipin A
*.opin X
XM1 net1 A VSS VSS sg13_lv_nmos w=550.00n l=130.00n ng=1 m=1 mm_ok=1
XM2 X net1 VSS VSS sg13_lv_nmos w=740.00n l=130.00n ng=1 m=1 mm_ok=1
XM3 net1 A VDD VDD sg13_lv_pmos w=840.00n l=130.00n ng=1 m=1 mm_ok=1
XM4 X net1 VDD VDD sg13_lv_pmos w=1.12u l=130.00n ng=1 m=1 mm_ok=1
.ends

.subckt sg13cmos5l_nor2_1 Y A B VDD VSS

*.opin Y
*.ipin B
*.ipin A
XM1 Y A VSS VSS sg13_lv_nmos w=740.00n l=130.00n ng=1 m=1 mm_ok=1
XM2 Y B VSS VSS sg13_lv_nmos w=740.00n l=130.00n ng=1 m=1 mm_ok=1
XM3 net1 A VDD VDD sg13_lv_pmos w=1.12u l=130.00n ng=1 m=1 mm_ok=1
XM4 Y B net1 VDD sg13_lv_pmos w=1.12u l=130.00n ng=1 m=1 mm_ok=1
.ends

.subckt sg13cmos5l_dfrbp_1 Q Q_N CLK D RESET_B VDD VSS

*.ipin D
*.ipin RESET_B
*.ipin CLK
*.opin Q
*.opin Q_N
XM1 Db D net12 VSS sg13_lv_nmos w=420.00n l=130.00n ng=1 m=1 mm_ok=1
XM2 net12 RESET_B VSS VSS sg13_lv_nmos w=420.00n l=130.00n ng=1 m=1 mm_ok=1
XM3 net2 clkneg net11 VSS sg13_lv_nmos w=420.00n l=130.00n ng=1 m=1 mm_ok=1
XM4 net11 net1 VSS VSS sg13_lv_nmos w=420.00n l=130.00n ng=1 m=1 mm_ok=1
XM5 net1 net2 net7 VSS sg13_lv_nmos w=420.00n l=130.00n ng=1 m=1 mm_ok=1
XM6 net7 RESET_B VSS VSS sg13_lv_nmos w=420.00n l=130.00n ng=1 m=1 mm_ok=1
XM7 Q_N net2 VSS VSS sg13_lv_nmos w=740.00n l=130.00n ng=1 m=1 mm_ok=1
XM8 net3 net2 VSS VSS sg13_lv_nmos w=740.00n l=130.00n ng=1 m=1 mm_ok=1
XM9 Q net3 VSS VSS sg13_lv_nmos w=740.00n l=130.00n ng=1 m=1 mm_ok=1
XM10 clkneg CLK VSS VSS sg13_lv_nmos w=740.00n l=130.00n ng=1 m=1 mm_ok=1
XM11 clkpos clkneg VSS VSS sg13_lv_nmos w=740.00n l=130.00n ng=1 m=1 mm_ok=1
XM12 Db clkneg net5 VSS sg13_lv_nmos w=420.00n l=130.00n ng=1 m=1 mm_ok=1
XM13 net5 clkpos net10 VSS sg13_lv_nmos w=420.00n l=130.00n ng=1 m=1 mm_ok=1
XM14 net10 net4 net6 VSS sg13_lv_nmos w=420.00n l=130.00n ng=1 m=1 mm_ok=1
XM15 net6 RESET_B VSS VSS sg13_lv_nmos w=420.00n l=130.00n ng=1 m=1 mm_ok=1
XM16 net4 net5 VSS VSS sg13_lv_nmos w=740.00n l=130.00n ng=1 m=1 mm_ok=1
XM17 net4 clkpos net2 VSS sg13_lv_nmos w=740.00n l=130.00n ng=1 m=1 mm_ok=1
XM18 Db RESET_B VDD VDD sg13_lv_pmos w=420.00n l=130.00n ng=1 m=1 mm_ok=1
XM19 Db D VDD VDD sg13_lv_pmos w=420.00n l=130.00n ng=1 m=1 mm_ok=1
XM20 net9 net1 VDD VDD sg13_lv_pmos w=420.00n l=130.00n ng=1 m=1 mm_ok=1
XM21 net2 clkpos net9 VDD sg13_lv_pmos w=420.00n l=130.00n ng=1 m=1 mm_ok=1
XM22 net1 net2 VDD VDD sg13_lv_pmos w=420.00n l=130.00n ng=1 m=1 mm_ok=1
XM23 net1 RESET_B VDD VDD sg13_lv_pmos w=420.00n l=130.00n ng=1 m=1 mm_ok=1
XM24 Q_N net2 VDD VDD sg13_lv_pmos w=1.12u l=130.00n ng=1 m=1 mm_ok=1
XM25 net3 net2 VDD VDD sg13_lv_pmos w=1.12u l=130.00n ng=1 m=1 mm_ok=1
XM26 Q net3 VDD VDD sg13_lv_pmos w=1.12u l=130.00n ng=1 m=1 mm_ok=1
XM27 clkneg CLK VDD VDD sg13_lv_pmos w=1.12u l=130.00n ng=1 m=1 mm_ok=1
XM28 clkpos clkneg VDD VDD sg13_lv_pmos w=1.12u l=130.00n ng=1 m=1 mm_ok=1
XM29 Db clkpos net5 VDD sg13_lv_pmos w=420.00n l=130.00n ng=1 m=1 mm_ok=1
XM30 net8 net4 VDD VDD sg13_lv_pmos w=420.00n l=130.00n ng=1 m=1 mm_ok=1
XM31 net5 clkneg net8 VDD sg13_lv_pmos w=420.00n l=130.00n ng=1 m=1 mm_ok=1
XM32 net5 RESET_B VDD VDD sg13_lv_pmos w=420.00n l=130.00n ng=1 m=1 mm_ok=1
XM33 net4 net5 VDD VDD sg13_lv_pmos w=1.000u l=130.00n ng=1 m=1 mm_ok=1
XM34 net4 clkneg net2 VDD sg13_lv_pmos w=1.000u l=130.00n ng=1 m=1 mm_ok=1
.ends

.subckt sg13cmos5l_mux2_1 X A0 A1 S VDD VSS

*.ipin S
*.ipin A0
*.ipin A1
*.opin X
XM1 Sb S VSS VSS sg13_lv_nmos w=550.00n l=130.00n ng=1 m=1 mm_ok=1
XM2 net1 A0 net5 VSS sg13_lv_nmos w=740.00n l=130.00n ng=1 m=1 mm_ok=1
XM3 net5 Sb VSS VSS sg13_lv_nmos w=740.00n l=130.00n ng=1 m=1 mm_ok=1
XM4 net1 A1 net4 VSS sg13_lv_nmos w=740.00n l=130.00n ng=1 m=1 mm_ok=1
XM5 net4 S VSS VSS sg13_lv_nmos w=740.00n l=130.00n ng=1 m=1 mm_ok=1
XM6 X net1 VSS VSS sg13_lv_nmos w=740.00n l=130.00n ng=1 m=1 mm_ok=1
XM7 Sb S VDD VDD sg13_lv_pmos w=840.00n l=130.00n ng=1 m=1 mm_ok=1
XM8 net2 S VDD VDD sg13_lv_pmos w=1.000u l=130.00n ng=1 m=1 mm_ok=1
XM9 net1 A0 net2 VDD sg13_lv_pmos w=1.000u l=130.00n ng=1 m=1 mm_ok=1
XM10 net3 Sb VDD VDD sg13_lv_pmos w=1.000u l=130.00n ng=1 m=1 mm_ok=1
XM11 net1 A1 net3 VDD sg13_lv_pmos w=1.000u l=130.00n ng=1 m=1 mm_ok=1
XM12 X net1 VDD VDD sg13_lv_pmos w=1.12u l=130.00n ng=1 m=1 mm_ok=1
.ends

.subckt ota_fcasc2_dp itail vi_p vi_n io_p io_n
*.ipin itail
*.ipin vi_p
*.ipin vi_n
*.iopin io_n
*.iopin io_p
XMP1 io_n vi_p itail itail sg13_lv_pmos w=2u l=1u ng=1 m=4 mm_ok=1
XMP2 io_p vi_n itail itail sg13_lv_pmos w=2u l=1u ng=1 m=4 mm_ok=1
XMPD1 itail itail itail itail sg13_lv_pmos w=2u l=1u ng=1 m=2 mm_ok=1
.ends

.subckt ota_fcasc2_nbiascasc d_ena_b ibias_200n voutp voutn d_ena io_bias_200n vd2 vd1 vbn vfb vss
*.iopin vss
*.ipin d_ena_b
*.ipin ibias_200n
*.ipin d_ena
*.opin vbn
*.ipin io_bias_200n
*.iopin vd1
*.iopin voutp
*.iopin vd2
*.iopin voutn
*.ipin vfb
XMNSW3 vcn d_ena_b vss vss sg13_lv_nmos w=0.5u l=3u ng=1 m=1 mm_ok=1
XMNSW4 vbn d_ena_b vss vss sg13_lv_nmos w=0.5u l=3u ng=1 m=1 mm_ok=1
XMNSW5 ibias_200n d_ena vcn vss sg13_lv_nmos w=0.5u l=3u ng=1 m=1 mm_ok=1
XMN6 vcn vcn vbn vss sg13_lv_nmos w=0.5u l=3u ng=1 m=1 mm_ok=1
XMN5 vbn vbn vss vss sg13_lv_nmos w=0.5u l=3u ng=1 m=1 mm_ok=1
XMND2 vss vcn vss vss sg13_lv_nmos w=0.5u l=3u ng=1 m=27 mm_ok=1
XMND1 vss vbn vss vss sg13_lv_nmos w=0.5u l=3u ng=1 m=20 mm_ok=1
XMN7 vd7 vbn vss vss sg13_lv_nmos w=0.5u l=3u ng=1 m=1 mm_ok=1
XMN8 io_bias_200n vcn vd7 vss sg13_lv_nmos w=0.5u l=3u ng=1 m=1 mm_ok=1
XMN1 vd1 vfb vss vss sg13_lv_nmos w=0.5u l=3u ng=1 m=8 mm_ok=1
XMN3 voutp vcn vd1 vss sg13_lv_nmos w=0.5u l=3u ng=1 m=5 mm_ok=1
XMN2 vd2 vfb vss vss sg13_lv_nmos w=0.5u l=3u ng=1 m=8 mm_ok=1
XMN4 voutn vcn vd2 vss sg13_lv_nmos w=0.5u l=3u ng=1 m=5 mm_ok=1
XMNSW1 vfb d_ena_b vss vss sg13_lv_nmos w=0.5u l=3u ng=1 m=1 mm_ok=1
XMNC7 vss vd7 vss vss sg13_lv_nmos w=0.5u l=3u ng=1 m=1 mm_ok=1
.ends

.subckt ota_fcasc2_pbiascasc vdd itail d_ena_b voutn voutp d_ena vcp
*.iopin vdd
*.ipin d_ena
*.ipin d_ena_b
*.iopin vcp
*.opin itail
*.iopin voutp
*.iopin voutn
XMPSW4 vcp d_ena vdd vdd sg13_lv_pmos w=3.5u l=2u ng=1 m=1 mm_ok=1
XMPSW3 vbp d_ena vdd vdd sg13_lv_pmos w=1u l=2u ng=1 m=1 mm_ok=1
XMP8 vp8 vbp vdd vdd sg13_lv_pmos w=1u l=2u ng=1 m=1 mm_ok=1
XMP9 vbp vcp vp8 vdd sg13_lv_pmos w=3.5u l=2u ng=1 m=1 mm_ok=1
XMPR vcp d_ena_b vbp vdd sg13_lv_pmos w=0.5u l=10u ng=1 m=1 mm_ok=1
XMP3 vp3 vbp vdd vdd sg13_lv_pmos w=1u l=2u ng=1 m=6 mm_ok=1
XMP10 itail vcp vp3 vdd sg13_lv_pmos w=3.5u l=2u ng=1 m=6 mm_ok=1
XMP4 vp4 vbp vdd vdd sg13_lv_pmos w=1u l=2u ng=1 m=5 mm_ok=1
XMP6 voutp vcp vp4 vdd sg13_lv_pmos w=3.5u l=2u ng=1 m=5 mm_ok=1
XMP5 vp5 vbp vdd vdd sg13_lv_pmos w=1u l=2u ng=1 m=5 mm_ok=1
XMP7 voutn vcp vp5 vdd sg13_lv_pmos w=3.5u l=2u ng=1 m=5 mm_ok=1
XMPD2 vdd vbp vdd vdd sg13_lv_pmos w=1u l=2u ng=1 m=48 mm_ok=1
XMPD3 vdd vcp vdd vdd sg13_lv_pmos w=3.5u l=2u ng=1 m=4 mm_ok=1
.ends

.subckt ota_fcasc2_ena vdd d_ena di_ena d_ena_b vss
*.iopin vdd
*.iopin vss
*.ipin di_ena
*.opin d_ena_b
*.opin d_ena
XMPEN0 d_ena_b di_ena vdd vdd sg13_lv_pmos w=1u l=2u ng=1 m=1 mm_ok=1
XMNEN0 d_ena_b di_ena vss vss sg13_lv_nmos w=0.5u l=3u ng=1 m=1 mm_ok=1
XMPEN1 d_ena d_ena_b vdd vdd sg13_lv_pmos w=1u l=2u ng=1 m=1 mm_ok=1
XMNEN1 d_ena d_ena_b vss vss sg13_lv_nmos w=0.5u l=3u ng=1 m=1 mm_ok=1
.ends

.subckt cap_dec vdd vss
*.iopin vdd
*.iopin vss
XM1 vdd vss vdd vdd sg13_hv_pmos w=1u l=4u ng=1 m=1 mm_ok=1
.ends

.subckt sw_tgate_cmfb2 p m g gb vdd vss
*.iopin vdd
*.iopin vss
*.iopin p
*.iopin m
*.ipin gb
*.ipin g
XMN p g m vss sg13_lv_nmos w=1u l=1u ng=1 m=1 mm_ok=1
XMP p gb m vdd sg13_lv_pmos w=3u l=1u ng=1 m=1 mm_ok=1
XMND1 p gb p vss sg13_lv_nmos w=0.5u l=1u ng=1 m=1 mm_ok=1
XMND2 m gb m vss sg13_lv_nmos w=0.5u l=1u ng=1 m=1 mm_ok=1
XMPD1 p g p vdd sg13_lv_pmos w=1.5u l=1u ng=1 m=1 mm_ok=1
XMPD2 m g m vdd sg13_lv_pmos w=1.5u l=1u ng=1 m=1 mm_ok=1
XMNG1 m vss m vss sg13_lv_nmos w=0.5u l=1u ng=1 m=1 mm_ok=1
XMNG2 m vss m vss sg13_lv_nmos w=0.5u l=1u ng=1 m=1 mm_ok=1
XMPG1 m vdd m vdd sg13_lv_pmos w=1.5u l=1u ng=1 m=1 mm_ok=1
XMPG2 m vdd m vdd sg13_lv_pmos w=1.5u l=1u ng=1 m=1 mm_ok=1
.ends

.subckt inv_en vdd vss di di_b
*.iopin vdd
*.iopin vss
*.ipin di
*.opin di_b
XP0 di_b di vdd vdd sg13_hv_pmos w=3u l=450n ng=3 m=1 mm_ok=1
XN0 di_b di vss vss sg13_hv_nmos w=1u l=450n ng=1 m=1 mm_ok=1
.ends

.subckt sg13cmos5l_nand2_1 Y A B VDD VSS

*.ipin A
*.ipin B
*.opin Y
XM1 Y A net1 VSS sg13_lv_nmos w=740.00n l=130.00n ng=1 m=1 mm_ok=1
XM2 net1 B VSS VSS sg13_lv_nmos w=740.00n l=130.00n ng=1 m=1 mm_ok=1
XM3 Y A VDD VDD sg13_lv_pmos w=1.12u l=130.00n ng=1 m=1 mm_ok=1
XM4 Y B VDD VDD sg13_lv_pmos w=1.12u l=130.00n ng=1 m=1 mm_ok=1
.ends
