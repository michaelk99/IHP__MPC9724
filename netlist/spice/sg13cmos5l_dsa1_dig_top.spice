* NGSPICE file created from sg13cmos5l_dsa1_dig_top.ext - technology: ihp-sg13cmos5l

* Black-box entry subcircuit for WELLTAP abstract view
.subckt WELLTAP VDD VSS
.ends

* Black-box entry subcircuit for FILLER2 abstract view
.subckt FILLER2 VSS VDD
.ends

* Black-box entry subcircuit for DECAPHV8 abstract view
.subckt DECAPHV8 VDD VSS
.ends

* Black-box entry subcircuit for sg13cmos5l_Filler400 abstract view
.subckt sg13cmos5l_Filler400 iovdd iovss vdd vss
.ends

* Black-box entry subcircuit for FILLER4 abstract view
.subckt FILLER4 VDD VSS
.ends

* Black-box entry subcircuit for DECAPHV32 abstract view
.subckt DECAPHV32 VDD VSS
.ends

* Black-box entry subcircuit for DECAPHV16 abstract view
.subckt DECAPHV16 VDD VSS
.ends

* Black-box entry subcircuit for FILLER1 abstract view
.subckt FILLER1 VDD VSS
.ends

* Black-box entry subcircuit for sg13cmos5l_Filler200 abstract view
.subckt sg13cmos5l_Filler200 iovdd iovss vdd vss
.ends

* Black-box entry subcircuit for sg13cmos5l_Filler4000 abstract view
.subckt sg13cmos5l_Filler4000 iovdd iovss vdd vss
.ends

* Black-box entry subcircuit for ANTENNA2 abstract view
.subckt ANTENNA2 A VDD VSS
.ends

* Black-box entry subcircuit for BUFX12 abstract view
.subckt BUFX12 A VDD VSS Y
.ends

* Black-box entry subcircuit for sg13cmos5l_ip__clamp_vddvss abstract view
.subckt sg13cmos5l_ip__clamp_vddvss iovdd iovss vdd vss
.ends

* Black-box entry subcircuit for sg13cmos5l_ip__bondpad_70x70 abstract view
.subckt sg13cmos5l_ip__bondpad_70x70 pad
.ends

* Black-box entry subcircuit for sg13cmos5l_IOPadIn abstract view
.subckt sg13cmos5l_IOPadIn iovdd iovss p2c pad vdd vss
.ends

* Black-box entry subcircuit for sg13cmos5l_Filler1000 abstract view
.subckt sg13cmos5l_Filler1000 iovdd iovss vdd vss
.ends

* Black-box entry subcircuit for INVX1 abstract view
.subckt INVX1 A VDD VSS Y
.ends

* Black-box entry subcircuit for sg13cmos5l_IOPadVss abstract view
.subckt sg13cmos5l_IOPadVss iovdd iovss vdd vss
.ends

* Black-box entry subcircuit for sg13cmos5l_Filler2000 abstract view
.subckt sg13cmos5l_Filler2000 iovdd iovss vdd vss
.ends

* Black-box entry subcircuit for sg13cmos5l_IOPadOut30mA abstract view
.subckt sg13cmos5l_IOPadOut30mA c2p iovdd iovss pad vdd vss
.ends

* Black-box entry subcircuit for sg13cmos5l_Corner abstract view
.subckt sg13cmos5l_Corner iovdd iovss vdd vss
.ends

* Black-box entry subcircuit for sg13cmos5l_IOPadAnalog abstract view
.subckt sg13cmos5l_IOPadAnalog iovdd iovss pad padbare padres vdd vss
.ends

* Black-box entry subcircuit for sg13cmos5l_IOPadVdd abstract view
.subckt sg13cmos5l_IOPadVdd iovdd iovss vdd vss
.ends

* Black-box entry subcircuit for sg13cmos5l_IOPadOut4mA abstract view
.subckt sg13cmos5l_IOPadOut4mA c2p iovdd iovss pad vdd vss
.ends

* Black-box entry subcircuit for sg13cmos5l_IOPadIOVss abstract view
.subckt sg13cmos5l_IOPadIOVss iovdd iovss vdd vss
.ends

* Black-box entry subcircuit for sg13cmos5l_IOPadIOVdd abstract view
.subckt sg13cmos5l_IOPadIOVdd iovdd iovss vdd vss
.ends

* Black-box entry subcircuit for sg13cmos5l_ip__jku abstract view
.subckt sg13cmos5l_ip__jku
.ends

* Black-box entry subcircuit for DFFRQX1 abstract view
.subckt DFFRQX1 CK D Q RB VDD VSS
.ends

* Black-box entry subcircuit for MUX2X1 abstract view
.subckt MUX2X1 A0 A1 S0 VDD VSS Y
.ends

* Black-box entry subcircuit for BUFX3 abstract view
.subckt BUFX3 A VDD VSS Y
.ends

* Black-box entry subcircuit for sg13cmos5l_ip__cut_vdd abstract view
.subckt sg13cmos5l_ip__cut_vdd iovdd iovss vss
.ends

* Black-box entry subcircuit for dsa1_dig_top abstract view
.subckt dsa1_dig_top VDD VSS adc_conv clk data_in miso mosi o_aux_ctrl[0] o_aux_ctrl[10]
+ o_aux_ctrl[11] o_aux_ctrl[12] o_aux_ctrl[13] o_aux_ctrl[14] o_aux_ctrl[15] o_aux_ctrl[1]
+ o_aux_ctrl[2] o_aux_ctrl[3] o_aux_ctrl[4] o_aux_ctrl[5] o_aux_ctrl[6] o_aux_ctrl[7]
+ o_aux_ctrl[8] o_aux_ctrl[9] o_bias_cfg[0] o_bias_cfg[10] o_bias_cfg[11] o_bias_cfg[12]
+ o_bias_cfg[13] o_bias_cfg[14] o_bias_cfg[15] o_bias_cfg[16] o_bias_cfg[17] o_bias_cfg[18]
+ o_bias_cfg[19] o_bias_cfg[1] o_bias_cfg[20] o_bias_cfg[21] o_bias_cfg[22] o_bias_cfg[23]
+ o_bias_cfg[24] o_bias_cfg[25] o_bias_cfg[26] o_bias_cfg[27] o_bias_cfg[28] o_bias_cfg[29]
+ o_bias_cfg[2] o_bias_cfg[30] o_bias_cfg[31] o_bias_cfg[32] o_bias_cfg[33] o_bias_cfg[34]
+ o_bias_cfg[3] o_bias_cfg[4] o_bias_cfg[5] o_bias_cfg[6] o_bias_cfg[7] o_bias_cfg[8]
+ o_bias_cfg[9] o_clk_cfg[0] o_clk_cfg[10] o_clk_cfg[11] o_clk_cfg[12] o_clk_cfg[13]
+ o_clk_cfg[14] o_clk_cfg[15] o_clk_cfg[16] o_clk_cfg[17] o_clk_cfg[18] o_clk_cfg[1]
+ o_clk_cfg[2] o_clk_cfg[3] o_clk_cfg[4] o_clk_cfg[5] o_clk_cfg[6] o_clk_cfg[7] o_clk_cfg[8]
+ o_clk_cfg[9] o_en_ctrl[0] o_en_ctrl[10] o_en_ctrl[1] o_en_ctrl[2] o_en_ctrl[3] o_en_ctrl[4]
+ o_en_ctrl[5] o_en_ctrl[6] o_en_ctrl[7] o_en_ctrl[8] o_en_ctrl[9] o_lf_cfg[0] o_lf_cfg[10]
+ o_lf_cfg[11] o_lf_cfg[12] o_lf_cfg[13] o_lf_cfg[14] o_lf_cfg[15] o_lf_cfg[1] o_lf_cfg[2]
+ o_lf_cfg[3] o_lf_cfg[4] o_lf_cfg[5] o_lf_cfg[6] o_lf_cfg[7] o_lf_cfg[8] o_lf_cfg[9]
+ o_rst_ctrl_b[0] o_rst_ctrl_b[1] o_tst_ctrl[0] o_tst_ctrl[10] o_tst_ctrl[11] o_tst_ctrl[12]
+ o_tst_ctrl[13] o_tst_ctrl[14] o_tst_ctrl[15] o_tst_ctrl[1] o_tst_ctrl[2] o_tst_ctrl[3]
+ o_tst_ctrl[4] o_tst_ctrl[5] o_tst_ctrl[6] o_tst_ctrl[7] o_tst_ctrl[8] o_tst_ctrl[9]
+ o_uwb_tx_cfg[0] o_uwb_tx_cfg[10] o_uwb_tx_cfg[11] o_uwb_tx_cfg[12] o_uwb_tx_cfg[13]
+ o_uwb_tx_cfg[14] o_uwb_tx_cfg[15] o_uwb_tx_cfg[16] o_uwb_tx_cfg[17] o_uwb_tx_cfg[18]
+ o_uwb_tx_cfg[19] o_uwb_tx_cfg[1] o_uwb_tx_cfg[20] o_uwb_tx_cfg[21] o_uwb_tx_cfg[22]
+ o_uwb_tx_cfg[23] o_uwb_tx_cfg[24] o_uwb_tx_cfg[25] o_uwb_tx_cfg[26] o_uwb_tx_cfg[27]
+ o_uwb_tx_cfg[28] o_uwb_tx_cfg[29] o_uwb_tx_cfg[2] o_uwb_tx_cfg[3] o_uwb_tx_cfg[4]
+ o_uwb_tx_cfg[5] o_uwb_tx_cfg[6] o_uwb_tx_cfg[7] o_uwb_tx_cfg[8] o_uwb_tx_cfg[9]
+ rst_b sclk ss
.ends

* Black-box entry subcircuit for dsm2_core abstract view
.subckt dsm2_core vi vcm ibias_test do_q_b do_q di_clk do_q_dec di_qout_en di_btest_en
+ di_vcm_ext di_dith_amp[1] di_dith_amp[0] di_dith_en di_trim[3] di_trim[2] di_trim[1]
+ di_trim[0] di_rst_b di_ena vdd vss
.ends

* Black-box entry subcircuit for sg13cmos5l_ip__jku_names abstract view
.subckt sg13cmos5l_ip__jku_names
.ends

* Black-box entry subcircuit for AND2X1 abstract view
.subckt AND2X1 A B VDD VSS Y
.ends

.subckt sg13cmos5l_dsa1_dig_top IOVDD IOVSS VDD VDDA VSS analog_PAD[0] analog_PAD[1]
+ analog_PAD[2] clk_PAD do_q_PAD do_q_b_PAD dsm_clk_PAD input_PAD[0] input_PAD[1]
+ input_PAD[2] input_PAD[3] output_PAD[0] output_PAD[1] rst_n_PAD
XTAP_TAPCELL_ROW_148_2_469 VDD VSS WELLTAP
XFILLER_36_973 VSS VDD FILLER2
XFILLER_126_1159 VSS VDD FILLER2
XFILLER_35_1009 VSS VDD FILLER2
XFILLER_74_1058 VDD VSS DECAPHV8
XIO_FILL_IO_NORTH_1_20 IOVDD IOVSS VDD VSS sg13cmos5l_Filler400
XFILLER_161_1017 VDD VSS FILLER4
XFILLER_137_1211 VDD VSS DECAPHV32
XTAP_TAPCELL_ROW_119_2_326 VDD VSS WELLTAP
XFILLER_172_1135 VDD VSS DECAPHV16
XFILLER_150_1422 VDD VSS FILLER4
XFILLER_137_1299 VSS VDD FILLER2
XFILLER_85_1198 VDD VSS DECAPHV8
XFILLER_19_929 VDD VSS DECAPHV32
XFILLER_92_1103 VDD VSS DECAPHV32
XTAP_TAPCELL_ROW_84_2_152 VDD VSS WELLTAP
XFILLER_109_1368 VDD VSS DECAPHV16
XTAP_TAPCELL_ROW_173_2_596 VDD VSS WELLTAP
XFILLER_177_1057 VDD VSS DECAPHV32
XFILLER_18_973 VSS VDD FILLER2
XFILLER_97_1025 VDD VSS DECAPHV32
XFILLER_162_1337 VDD VSS DECAPHV8
XFILLER_127_1413 VDD VSS DECAPHV8
XFILLER_121_1089 VDD VSS DECAPHV16
XFILLER_69_1105 VDD VSS DECAPHV8
XFILLER_132_1196 VDD VSS DECAPHV32
XTAP_TAPCELL_ROW_161_2_534 VDD VSS WELLTAP
XTAP_TAPCELL_ROW_87_2_167 VDD VSS WELLTAP
XFILLER_150_1252 VSS VDD FILLER2
XFILLER_98_1345 VSS VDD FILLER2
XFILLER_161_1392 VSS VDD FILLER2
XFILLER_122_1321 VDD VSS DECAPHV16
XFILLER_109_1198 VDD VSS DECAPHV8
XFILLER_168_970 VDD VSS FILLER4
XFILLER_116_1103 VDD VSS DECAPHV32
XFILLER_127_1243 VDD VSS DECAPHV32
XTAP_TAPCELL_ROW_126_2_360 VDD VSS WELLTAP
XFILLER_123_1118 VDD VSS DECAPHV32
XFILLER_71_1017 VDD VSS FILLER4
XFILLER_138_1350 VDD VSS DECAPHV32
XFILLER_101_1427 VDD VSS FILLER1
XFILLER_82_1135 VDD VSS DECAPHV16
XTAP_TAPCELL_ROW_75_2_105 VDD VSS WELLTAP
XFILLER_174_973 VSS VDD FILLER2
XTAP_TAPCELL_ROW_164_2_549 VDD VSS WELLTAP
XFILLER_180_1234 VDD VSS DECAPHV8
XFILLER_167_1089 VDD VSS DECAPHV16
XFILLER_93_1275 VDD VSS DECAPHV16
XTAP_TAPCELL_ROW_135_2_406 VDD VSS WELLTAP
XFILLER_87_1057 VDD VSS DECAPHV32
XFILLER_157_929 VDD VSS DECAPHV32
XFILLER_165_995 VDD VSS DECAPHV16
XFILLER_178_1196 VDD VSS DECAPHV32
XFILLER_98_1164 VDD VSS DECAPHV32
XFILLER_4_1157 VDD VSS DECAPHV32
XFILLER_150_1071 VDD VSS DECAPHV32
XFILLER_163_1421 VDD VSS FILLER4
XFILLER_72_1337 VDD VSS DECAPHV8
XFILLER_148_929 VDD VSS DECAPHV32
XTAP_TAPCELL_ROW_129_2_375 VDD VSS WELLTAP
XFILLER_122_1151 VDD VSS DECAPHV8
XFILLER_7_961 VDD VSS DECAPHV32
XFILLER_156_973 VSS VDD FILLER2
XFILLER_170_1414 VDD VSS DECAPHV8
XFILLER_133_1291 VDD VSS DECAPHV8
XFILLER_168_1321 VDD VSS DECAPHV16
XFILLER_90_1426 VSS VDD FILLER2
XFILLER_93_993 VDD VSS DECAPHV16
XFILLER_139_929 VDD VSS DECAPHV32
XFILLER_175_1336 VDD VSS DECAPHV32
XFILLER_169_1118 VDD VSS DECAPHV32
XFILLER_147_1427 VDD VSS FILLER1
XFILLER_95_1304 VDD VSS DECAPHV32
XTAP_TAPCELL_ROW_67_2_57 VDD VSS WELLTAP
XFILLER_134_1066 VSS VDD FILLER2
XFILLER_106_1135 VDD VSS DECAPHV16
XFILLER_71_1392 VSS VDD FILLER2
XTAP_TAPCELL_ROW_117_2_313 VDD VSS WELLTAP
XFILLER_138_973 VSS VDD FILLER2
XFILLER_117_1275 VDD VSS DECAPHV16
XFILLER_75_993 VDD VSS DECAPHV16
XFILLER_128_1382 VDD VSS DECAPHV32
XFILLER_124_1257 VDD VSS DECAPHV32
XIO_FILL_IO_WEST_1_35 IOVDD IOVSS VDD VSS sg13cmos5l_Filler200
XIO_FILL_IO_SOUTH_3_0 IOVDD IOVSS VDD VSS sg13cmos5l_Filler4000
XFILLER_170_1244 VDD VSS DECAPHV8
XTAP_TAPCELL_ROW_171_2_583 VDD VSS WELLTAP
XFILLER_168_1151 VDD VSS DECAPHV8
XFILLER_135_1397 VDD VSS DECAPHV16
XFILLER_131_1206 VSS VDD FILLER2
XFILLER_129_1113 VSS VDD FILLER2
XTAP_TAPCELL_ROW_3_2_11 VDD VSS WELLTAP
XTAP_TAPCELL_ROW_142_2_440 VDD VSS WELLTAP
XFILLER_90_1289 VDD VSS DECAPHV32
XFILLER_77_1089 VDD VSS DECAPHV16
XIO_FILL_IO_NORTH_4_20 IOVDD IOVSS VDD VSS sg13cmos5l_Filler400
XFILLER_179_1291 VDD VSS DECAPHV8
XFILLER_88_1196 VDD VSS DECAPHV32
XFILLER_101_1021 VDD VSS FILLER1
XFILLER_114_1426 VSS VDD FILLER2
XTAP_TAPCELL_ROW_73_2_94 VDD VSS WELLTAP
XTAP_TAPCELL_ROW_180_2_629 VDD VSS WELLTAP
XFILLER_171_1019 VSS VDD FILLER2
XFILLER_73_1421 VDD VSS FILLER4
XFILLER_1_1105 VDD VSS DECAPHV8
XFILLER_57_993 VDD VSS DECAPHV16
XFILLER_91_1009 VDD VSS DECAPHV8
XFILLER_154_1228 VDD VSS DECAPHV16
XFILLER_119_1304 VDD VSS DECAPHV32
XTAP_TAPCELL_ROW_85_2_154 VDD VSS WELLTAP
XFILLER_80_1414 VDD VSS DECAPHV8
XFILLER_67_1247 VDD VSS DECAPHV32
XANTENNA_5 _3_/Q VDD VSS ANTENNA2
XFILLER_78_1321 VDD VSS DECAPHV16
XTAP_TAPCELL_ROW_174_2_598 VDD VSS WELLTAP
XFILLER_165_1368 VDD VSS DECAPHV16
XFILLER_124_1010 VDD VSS DECAPHV32
XTAP_TAPCELL_ROW_145_2_455 VDD VSS WELLTAP
XFILLER_85_1336 VDD VSS DECAPHV32
XFILLER_135_1150 VDD VSS DECAPHV32
XFILLER_131_1025 VDD VSS DECAPHV32
Xdelaybuf_10_clk delaybuf_9_clk/Y VDD VSS delaybuf_10_clk/Y BUFX12
XTAP_TAPCELL_ROW_116_2_312 VDD VSS WELLTAP
XFILLER_79_1118 VDD VSS DECAPHV32
XFILLER_2_1414 VDD VSS DECAPHV8
XFILLER_39_993 VDD VSS DECAPHV16
XFILLER_177_1206 VSS VDD FILLER2
XFILLER_103_1105 VDD VSS DECAPHV8
XFILLER_90_1042 VDD VSS DECAPHV16
XFILLER_114_1289 VDD VSS DECAPHV32
XTAP_TAPCELL_ROW_170_2_582 VDD VSS WELLTAP
XTAP_TAPCELL_ROW_88_2_169 VDD VSS WELLTAP
XFILLER_147_1021 VDD VSS FILLER1
XFILLER_67_1022 VDD VSS DECAPHV32
XFILLER_132_1345 VSS VDD FILLER2
XFILLER_80_1244 VDD VSS DECAPHV8
XFILLER_67_1099 VDD VSS DECAPHV8
XFILLER_154_1058 VDD VSS DECAPHV8
XFILLER_115_1009 VDD VSS DECAPHV8
XFILLER_78_1151 VDD VSS DECAPHV8
XFILLER_165_1198 VDD VSS DECAPHV8
XFILLER_104_1414 VDD VSS DECAPHV8
XFILLER_91_1384 VDD VSS DECAPHV8
XFILLER_172_1103 VDD VSS DECAPHV32
XTAP_TAPCELL_ROW_119_2_327 VDD VSS WELLTAP
XFILLER_89_1291 VDD VSS DECAPHV8
XFILLER_109_1336 VDD VSS DECAPHV32
XFILLER_92_1159 VSS VDD FILLER2
XFILLER_2_1244 VDD VSS DECAPHV8
XTAP_TAPCELL_ROW_173_2_597 VDD VSS WELLTAP
XFILLER_177_1025 VDD VSS DECAPHV32
XFILLER_149_1105 VDD VSS DECAPHV8
XFILLER_114_1042 VDD VSS DECAPHV16
XTAP_TAPCELL_ROW_136_2_408 VDD VSS WELLTAP
Xclamp_vdda IOVDD IOVSS VDDA VSS sg13cmos5l_ip__clamp_vddvss
XFILLER_127_1425 VSS VDD FILLER2
XFILLER_125_1182 VDD VSS DECAPHV16
XFILLER_75_1368 VDD VSS DECAPHV16
XFILLER_34_1010 VDD VSS FILLER1
XFILLER_121_1057 VDD VSS DECAPHV32
XFILLER_132_1164 VDD VSS DECAPHV32
XFILLER_180_1427 VDD VSS FILLER1
XFILLER_93_1413 VDD VSS DECAPHV8
XFILLER_178_1345 VSS VDD FILLER2
XFILLER_104_1244 VDD VSS DECAPHV8
XFILLER_87_1206 VSS VDD FILLER2
XTAP_TAPCELL_ROW_161_2_535 VDD VSS WELLTAP
XFILLER_115_1384 VDD VSS DECAPHV8
XFILLER_101_993 VDD VSS DECAPHV16
XFILLER_30_969 VDD VSS FILLER4
XFILLER_116_1159 VSS VDD FILLER2
XFILLER_25_1009 VSS VDD FILLER2
XFILLER_151_1017 VDD VSS FILLER4
XFILLER_127_1211 VDD VSS DECAPHV32
XTAP_TAPCELL_ROW_126_2_361 VDD VSS WELLTAP
XIO_FILL_IO_WEST_4_35 IOVDD IOVSS VDD VSS sg13cmos5l_Filler200
XIO_FILL_IO_NORTH_0_0 IOVDD IOVSS VDD VSS sg13cmos5l_Filler4000
XFILLER_162_1135 VDD VSS DECAPHV16
XFILLER_140_1422 VDD VSS FILLER4
XFILLER_127_1299 VSS VDD FILLER2
XFILLER_75_1198 VDD VSS DECAPHV8
XFILLER_159_993 VDD VSS DECAPHV16
XFILLER_173_1275 VDD VSS DECAPHV16
XFILLER_82_1103 VDD VSS DECAPHV32
XTAP_TAPCELL_ROW_75_2_106 VDD VSS WELLTAP
XFILLER_88_969 VDD VSS FILLER4
XFILLER_167_1013 VDD VSS DECAPHV8
XFILLER_180_1279 VDD VSS DECAPHV8
XFILLER_180_1202 VDD VSS DECAPHV32
XFILLER_93_1243 VDD VSS DECAPHV32
XFILLER_167_1057 VDD VSS DECAPHV32
XFILLER_12_969 VDD VSS FILLER4
XFILLER_8_929 VDD VSS DECAPHV32
XFILLER_178_1164 VDD VSS DECAPHV32
XTAP_TAPCELL_ROW_135_2_407 VDD VSS WELLTAP
XFILLER_87_1025 VDD VSS DECAPHV32
XFILLER_165_963 VDD VSS DECAPHV32
XFILLER_180_977 VDD VSS DECAPHV32
XFILLER_152_1337 VDD VSS DECAPHV8
XFILLER_117_1413 VDD VSS DECAPHV8
XFILLER_111_1089 VDD VSS DECAPHV16
XFILLER_170_1426 VSS VDD FILLER2
XTAP_TAPCELL_ROW_129_2_376 VDD VSS WELLTAP
XFILLER_122_1196 VDD VSS DECAPHV32
XFILLER_93_961 VDD VSS DECAPHV32
XFILLER_175_1304 VDD VSS DECAPHV32
XFILLER_140_1252 VSS VDD FILLER2
XFILLER_88_1345 VSS VDD FILLER2
XFILLER_151_1392 VSS VDD FILLER2
XFILLER_112_1321 VDD VSS DECAPHV16
XTAP_TAPCELL_ROW_67_2_58 VDD VSS WELLTAP
XFILLER_84_961 VDD VSS DECAPHV8
XFILLER_106_1103 VDD VSS DECAPHV32
XFILLER_180_1054 VDD VSS DECAPHV8
XTAP_TAPCELL_ROW_117_2_314 VDD VSS WELLTAP
XFILLER_117_1243 VDD VSS DECAPHV32
XFILLER_113_1118 VDD VSS DECAPHV32
XFILLER_75_961 VDD VSS DECAPHV32
XFILLER_128_1350 VDD VSS DECAPHV32
XTAP_TAPCELL_ROW_82_2_140 VDD VSS WELLTAP
XFILLER_72_1135 VDD VSS DECAPHV16
XTAP_TAPCELL_ROW_171_2_584 VDD VSS WELLTAP
XFILLER_157_1089 VDD VSS DECAPHV16
XFILLER_83_1275 VDD VSS DECAPHV16
XFILLER_170_1289 VDD VSS DECAPHV32
XTAP_TAPCELL_ROW_3_2_12 VDD VSS WELLTAP
XFILLER_66_961 VDD VSS DECAPHV8
XFILLER_77_1057 VDD VSS DECAPHV32
XFILLER_168_1196 VDD VSS DECAPHV32
XTAP_TAPCELL_ROW_142_2_441 VDD VSS WELLTAP
XFILLER_94_1382 VDD VSS DECAPHV32
XFILLER_90_1257 VDD VSS DECAPHV32
XFILLER_88_1164 VDD VSS DECAPHV32
XTAP_TAPCELL_ROW_73_2_95 VDD VSS WELLTAP
XFILLER_140_1071 VDD VSS DECAPHV32
XFILLER_153_1421 VDD VSS FILLER4
XFILLER_112_1151 VDD VSS DECAPHV8
XFILLER_57_961 VDD VSS DECAPHV32
XFILLER_150_969 VDD VSS FILLER4
XFILLER_160_1414 VDD VSS DECAPHV8
XFILLER_95_1113 VSS VDD FILLER2
XFILLER_158_1321 VDD VSS DECAPHV16
XFILLER_123_1291 VDD VSS DECAPHV8
XANTENNA_6 _3_/Q VDD VSS ANTENNA2
XTAP_TAPCELL_ROW_85_2_155 VDD VSS WELLTAP
XFILLER_80_1426 VSS VDD FILLER2
XTAP_TAPCELL_ROW_174_2_599 VDD VSS WELLTAP
XFILLER_48_961 VDD VSS DECAPHV8
XFILLER_165_1336 VDD VSS DECAPHV32
XFILLER_124_1066 VSS VDD FILLER2
XFILLER_159_1118 VDD VSS DECAPHV32
XTAP_TAPCELL_ROW_145_2_456 VDD VSS WELLTAP
XFILLER_137_1427 VDD VSS FILLER1
XFILLER_85_1304 VDD VSS DECAPHV32
XFILLER_170_1042 VDD VSS DECAPHV16
XFILLER_39_961 VDD VSS DECAPHV32
XFILLER_132_969 VDD VSS FILLER4
XFILLER_96_1422 VDD VSS FILLER4
XFILLER_2_1426 VSS VDD FILLER2
XFILLER_90_1010 VDD VSS DECAPHV32
XFILLER_107_1275 VDD VSS DECAPHV16
Xdelaybuf_3_clk delaybuf_3_clk/A VDD VSS delaybuf_4_clk/A BUFX12
XFILLER_118_1382 VDD VSS DECAPHV32
XFILLER_114_1257 VDD VSS DECAPHV32
XFILLER_160_1244 VDD VSS DECAPHV8
XFILLER_121_1206 VSS VDD FILLER2
XFILLER_60_978 VDD VSS DECAPHV32
XFILLER_158_1151 VDD VSS DECAPHV8
XFILLER_125_1397 VDD VSS DECAPHV16
XFILLER_119_1113 VSS VDD FILLER2
XFILLER_171_1384 VDD VSS DECAPHV8
XFILLER_80_1289 VDD VSS DECAPHV32
XFILLER_67_1067 VDD VSS DECAPHV32
XFILLER_114_969 VDD VSS FILLER4
XFILLER_169_1291 VDD VSS DECAPHV8
XFILLER_78_1196 VDD VSS DECAPHV32
XFILLER_104_1426 VSS VDD FILLER2
XIO_FILL_IO_NORTH_1_22 IOVDD IOVSS VDD VSS sg13cmos5l_Filler400
XFILLER_172_1159 VSS VDD FILLER2
XFILLER_81_1009 VDD VSS DECAPHV8
XTAP_TAPCELL_ROW_127_2_363 VDD VSS WELLTAP
XFILLER_144_1228 VDD VSS DECAPHV16
XFILLER_109_1304 VDD VSS DECAPHV32
XFILLER_96_1252 VSS VDD FILLER2
XFILLER_70_1414 VDD VSS DECAPHV8
XFILLER_2_1289 VDD VSS DECAPHV32
XFILLER_42_978 VDD VSS DECAPHV32
XTAP_TAPCELL_ROW_76_2_108 VDD VSS WELLTAP
XFILLER_68_1321 VDD VSS DECAPHV16
XFILLER_155_1368 VDD VSS DECAPHV16
XFILLER_114_1010 VDD VSS DECAPHV32
XFILLER_75_1336 VDD VSS DECAPHV32
XTAP_TAPCELL_ROW_136_2_409 VDD VSS WELLTAP
XTAP_TAPCELL_ROW_152_2_490 VDD VSS WELLTAP
XFILLER_125_1150 VDD VSS DECAPHV32
XFILLER_121_1025 VDD VSS DECAPHV32
XFILLER_173_1413 VDD VSS DECAPHV8
XFILLER_69_1118 VDD VSS DECAPHV32
XFILLER_167_1206 VSS VDD FILLER2
XFILLER_80_1042 VDD VSS DECAPHV16
XFILLER_110_961 VDD VSS DECAPHV8
XFILLER_93_1425 VSS VDD FILLER2
XFILLER_24_978 VDD VSS DECAPHV32
XTAP_TAPCELL_ROW_161_2_536 VDD VSS WELLTAP
XFILLER_104_1289 VDD VSS DECAPHV32
XFILLER_91_1182 VDD VSS DECAPHV16
XFILLER_101_961 VDD VSS DECAPHV32
XFILLER_137_1021 VDD VSS FILLER1
XFILLER_2_1042 VDD VSS DECAPHV16
XFILLER_96_1071 VDD VSS DECAPHV32
XFILLER_122_1345 VSS VDD FILLER2
XFILLER_70_1244 VDD VSS DECAPHV8
XFILLER_144_1058 VDD VSS DECAPHV8
XFILLER_105_1009 VDD VSS DECAPHV8
XFILLER_68_1151 VDD VSS DECAPHV8
XFILLER_155_1198 VDD VSS DECAPHV8
XFILLER_81_1384 VDD VSS DECAPHV8
XFILLER_162_1103 VDD VSS DECAPHV32
XTAP_TAPCELL_ROW_126_2_362 VDD VSS WELLTAP
XFILLER_79_1291 VDD VSS DECAPHV8
XTAP_TAPCELL_ROW_60_2_53 VDD VSS WELLTAP
XFILLER_159_961 VDD VSS DECAPHV32
XFILLER_173_1243 VDD VSS DECAPHV32
XFILLER_82_1159 VSS VDD FILLER2
XTAP_TAPCELL_ROW_75_2_107 VDD VSS WELLTAP
XIO_BOND_g_inputs\[3\].input_pad input_PAD[3] sg13cmos5l_ip__bondpad_70x70
XFILLER_93_1211 VDD VSS DECAPHV32
XFILLER_3_1384 VDD VSS DECAPHV8
XFILLER_167_1025 VDD VSS DECAPHV32
XFILLER_180_1247 VDD VSS DECAPHV32
XFILLER_93_1299 VSS VDD FILLER2
XFILLER_104_1042 VDD VSS DECAPHV16
XFILLER_165_931 VDD VSS DECAPHV32
XFILLER_139_1105 VDD VSS DECAPHV8
Xdsm_clk_pad IOVDD IOVSS dsm2/di_clk dsm_clk_PAD VDDA VSS sg13cmos5l_IOPadIn
XTAP_TAPCELL_ROW_143_2_443 VDD VSS WELLTAP
XFILLER_117_1425 VSS VDD FILLER2
XFILLER_115_1182 VDD VSS DECAPHV16
XFILLER_24_1010 VDD VSS FILLER1
XFILLER_94_929 VDD VSS DECAPHV32
XTAP_TAPCELL_ROW_114_2_300 VDD VSS WELLTAP
XFILLER_111_1057 VDD VSS DECAPHV32
XFILLER_122_1164 VDD VSS DECAPHV32
XIO_FILL_IO_WEST_2_0 IOVDD IOVSS VDD VSS sg13cmos5l_Filler4000
XTAP_TAPCELL_ROW_129_2_377 VDD VSS WELLTAP
XFILLER_83_1413 VDD VSS DECAPHV8
XFILLER_168_1345 VSS VDD FILLER2
XFILLER_77_1206 VSS VDD FILLER2
XFILLER_85_929 VDD VSS DECAPHV32
XFILLER_105_1384 VDD VSS DECAPHV8
XFILLER_162_978 VDD VSS DECAPHV32
XFILLER_76_929 VDD VSS DECAPHV32
XFILLER_180_1022 VDD VSS DECAPHV32
XTAP_TAPCELL_ROW_67_2_59 VDD VSS WELLTAP
XFILLER_84_973 VSS VDD FILLER2
XTAP_TAPCELL_ROW_146_2_458 VDD VSS WELLTAP
XFILLER_180_1099 VDD VSS DECAPHV8
XFILLER_106_1159 VSS VDD FILLER2
XFILLER_15_1009 VSS VDD FILLER2
XFILLER_141_1017 VDD VSS FILLER4
XFILLER_152_1135 VDD VSS DECAPHV16
XTAP_TAPCELL_ROW_117_2_315 VDD VSS WELLTAP
XFILLER_117_1211 VDD VSS DECAPHV32
XFILLER_4_977 VDD VSS DECAPHV32
XFILLER_130_1422 VDD VSS FILLER4
XFILLER_117_1299 VSS VDD FILLER2
XFILLER_67_929 VDD VSS DECAPHV32
XFILLER_163_1275 VDD VSS DECAPHV16
XTAP_TAPCELL_ROW_82_2_141 VDD VSS WELLTAP
XFILLER_72_1103 VDD VSS DECAPHV32
XTAP_TAPCELL_ROW_171_2_585 VDD VSS WELLTAP
XFILLER_157_1057 VDD VSS DECAPHV32
XFILLER_144_978 VDD VSS DECAPHV32
XFILLER_174_1382 VDD VSS DECAPHV32
XFILLER_170_1257 VDD VSS DECAPHV32
XFILLER_83_1243 VDD VSS DECAPHV32
XTAP_TAPCELL_ROW_3_2_13 VDD VSS WELLTAP
XFILLER_58_929 VDD VSS DECAPHV32
XFILLER_168_1164 VDD VSS DECAPHV32
XTAP_TAPCELL_ROW_142_2_442 VDD VSS WELLTAP
XFILLER_94_1350 VDD VSS DECAPHV32
XFILLER_0_1332 VSS VDD FILLER2
XIO_FILL_IO_NORTH_4_22 IOVDD IOVSS VDD VSS sg13cmos5l_Filler400
XFILLER_66_973 VSS VDD FILLER2
XFILLER_77_1025 VDD VSS DECAPHV32
XFILLER_142_1337 VDD VSS DECAPHV8
XFILLER_107_1413 VDD VSS DECAPHV8
XFILLER_175_1113 VSS VDD FILLER2
XFILLER_101_1089 VDD VSS DECAPHV16
XTAP_TAPCELL_ROW_73_2_96 VDD VSS WELLTAP
XFILLER_1_1118 VDD VSS DECAPHV32
XFILLER_49_929 VDD VSS DECAPHV32
XFILLER_160_1426 VSS VDD FILLER2
XFILLER_112_1196 VDD VSS DECAPHV32
XIO_FILL_IO_SOUTH_7_20 IOVDD IOVSS VDDA VSS sg13cmos5l_Filler1000
XFILLER_126_978 VDD VSS DECAPHV32
XANTENNA_7 ANTENNA_7/A VDD VSS ANTENNA2
XTAP_TAPCELL_ROW_85_2_156 VDD VSS WELLTAP
XFILLER_165_1304 VDD VSS DECAPHV32
XFILLER_130_1252 VSS VDD FILLER2
XFILLER_78_1345 VSS VDD FILLER2
XFILLER_48_973 VSS VDD FILLER2
XFILLER_102_1321 VDD VSS DECAPHV16
XFILLER_176_1422 VDD VSS FILLER4
XTAP_TAPCELL_ROW_145_2_457 VDD VSS WELLTAP
XFILLER_141_1392 VSS VDD FILLER2
XFILLER_170_1010 VDD VSS DECAPHV32
XFILLER_107_1243 VDD VSS DECAPHV32
XFILLER_103_1118 VDD VSS DECAPHV32
XFILLER_90_1066 VSS VDD FILLER2
XFILLER_108_978 VDD VSS DECAPHV32
XFILLER_118_1350 VDD VSS DECAPHV32
XTAP_TAPCELL_ROW_162_2_538 VDD VSS WELLTAP
XFILLER_160_1289 VDD VSS DECAPHV32
XFILLER_147_1089 VDD VSS DECAPHV16
XFILLER_73_1275 VDD VSS DECAPHV16
XFILLER_158_1196 VDD VSS DECAPHV32
XFILLER_84_1382 VDD VSS DECAPHV32
XFILLER_80_1257 VDD VSS DECAPHV32
XFILLER_143_1421 VDD VSS FILLER4
XFILLER_78_1164 VDD VSS DECAPHV32
XTAP_TAPCELL_ROW_24_2_35 VDD VSS WELLTAP
XFILLER_130_1071 VDD VSS DECAPHV32
XFILLER_161_1009 VDD VSS DECAPHV8
XFILLER_102_1151 VDD VSS DECAPHV8
XFILLER_91_1397 VDD VSS DECAPHV16
XFILLER_85_1113 VSS VDD FILLER2
XFILLER_176_1252 VSS VDD FILLER2
XFILLER_150_1414 VDD VSS DECAPHV8
XTAP_TAPCELL_ROW_127_2_364 VDD VSS WELLTAP
XFILLER_120_929 VDD VSS DECAPHV32
XFILLER_148_1321 VDD VSS DECAPHV16
XFILLER_113_1291 VDD VSS DECAPHV8
XFILLER_2_1257 VDD VSS DECAPHV32
XTAP_TAPCELL_ROW_76_2_109 VDD VSS WELLTAP
XTAP_TAPCELL_ROW_92_2_190 VDD VSS WELLTAP
XFILLER_70_1426 VSS VDD FILLER2
XFILLER_155_1336 VDD VSS DECAPHV32
XFILLER_111_929 VDD VSS DECAPHV32
XFILLER_97_1017 VDD VSS FILLER4
XFILLER_114_1066 VSS VDD FILLER2
XTAP_TAPCELL_ROW_152_2_491 VDD VSS WELLTAP
XFILLER_149_1118 VDD VSS DECAPHV32
XFILLER_127_1427 VDD VSS FILLER1
XFILLER_75_1304 VDD VSS DECAPHV32
XFILLER_160_1042 VDD VSS DECAPHV16
XFILLER_173_1425 VSS VDD FILLER2
XFILLER_86_1422 VDD VSS FILLER4
XIO_FILL_IO_EAST_0_0 IOVDD IOVSS VDDA VSS sg13cmos5l_Filler4000
XIO_BOND_g_inputs\[2\].input_pad input_PAD[2] sg13cmos5l_ip__bondpad_70x70
XFILLER_80_1010 VDD VSS DECAPHV32
XFILLER_102_929 VDD VSS DECAPHV32
XFILLER_171_1182 VDD VSS DECAPHV16
XFILLER_110_973 VSS VDD FILLER2
XFILLER_108_1382 VDD VSS DECAPHV32
XFILLER_91_1150 VDD VSS DECAPHV32
XTAP_TAPCELL_ROW_161_2_537 VDD VSS WELLTAP
XFILLER_104_1257 VDD VSS DECAPHV32
XFILLER_176_1071 VDD VSS DECAPHV32
XFILLER_150_1244 VDD VSS DECAPHV8
XFILLER_111_1206 VSS VDD FILLER2
XFILLER_148_1151 VDD VSS DECAPHV8
XFILLER_115_1397 VDD VSS DECAPHV16
XFILLER_109_1113 VSS VDD FILLER2
XFILLER_98_1337 VDD VSS DECAPHV8
XFILLER_2_1010 VDD VSS DECAPHV32
XFILLER_161_1384 VDD VSS DECAPHV8
XFILLER_70_1289 VDD VSS DECAPHV32
Xclamp_vddvss IOVDD IOVSS VDD VSS sg13cmos5l_ip__clamp_vddvss
XFILLER_159_1291 VDD VSS DECAPHV8
XFILLER_68_1196 VDD VSS DECAPHV32
XFILLER_162_1159 VSS VDD FILLER2
XFILLER_71_1009 VDD VSS DECAPHV8
XFILLER_173_1211 VDD VSS DECAPHV32
XFILLER_86_1252 VSS VDD FILLER2
XFILLER_173_1299 VSS VDD FILLER2
XFILLER_134_1228 VDD VSS DECAPHV16
XTAP_TAPCELL_ROW_83_2_143 VDD VSS WELLTAP
XFILLER_97_1392 VSS VDD FILLER2
XFILLER_145_1368 VDD VSS DECAPHV16
XFILLER_104_1010 VDD VSS DECAPHV32
XTAP_TAPCELL_ROW_143_2_444 VDD VSS WELLTAP
XFILLER_115_1150 VDD VSS DECAPHV32
XFILLER_87_993 VDD VSS DECAPHV16
XFILLER_111_1025 VDD VSS DECAPHV32
XFILLER_163_1413 VDD VSS DECAPHV8
XTAP_TAPCELL_ROW_114_2_301 VDD VSS WELLTAP
XFILLER_157_1206 VSS VDD FILLER2
XFILLER_11_993 VDD VSS DECAPHV16
XFILLER_70_1042 VDD VSS DECAPHV16
XFILLER_83_1425 VSS VDD FILLER2
XFILLER_81_1182 VDD VSS DECAPHV16
XFILLER_171_979 VDD VSS DECAPHV32
XTAP_TAPCELL_ROW_86_2_158 VDD VSS WELLTAP
XTAP_TAPCELL_ROW_108_2_270 VDD VSS WELLTAP
XFILLER_127_1021 VDD VSS FILLER1
XFILLER_86_1071 VDD VSS DECAPHV32
XFILLER_112_1345 VSS VDD FILLER2
XFILLER_99_1421 VDD VSS FILLER4
XFILLER_69_993 VDD VSS DECAPHV16
XFILLER_134_1058 VDD VSS DECAPHV8
XFILLER_3_1182 VDD VSS DECAPHV16
XTAP_TAPCELL_ROW_146_2_459 VDD VSS WELLTAP
XFILLER_145_1198 VDD VSS DECAPHV8
XFILLER_71_1384 VDD VSS DECAPHV8
XFILLER_180_1067 VDD VSS DECAPHV32
XFILLER_152_1103 VDD VSS DECAPHV32
XTAP_TAPCELL_ROW_117_2_316 VDD VSS WELLTAP
XFILLER_69_1291 VDD VSS DECAPHV8
XFILLER_163_1243 VDD VSS DECAPHV32
XTAP_TAPCELL_ROW_82_2_142 VDD VSS WELLTAP
XFILLER_72_1159 VSS VDD FILLER2
XFILLER_174_1350 VDD VSS DECAPHV32
XTAP_TAPCELL_ROW_171_2_586 VDD VSS WELLTAP
XFILLER_83_1211 VDD VSS DECAPHV32
XFILLER_157_1025 VDD VSS DECAPHV32
XFILLER_83_1299 VSS VDD FILLER2
XTAP_TAPCELL_ROW_3_2_14 VDD VSS WELLTAP
XFILLER_129_1105 VDD VSS DECAPHV8
XFILLER_107_1425 VSS VDD FILLER2
XFILLER_0_1377 VSS VDD FILLER2
XFILLER_105_1182 VDD VSS DECAPHV16
XFILLER_14_1010 VDD VSS FILLER1
XFILLER_101_1057 VDD VSS DECAPHV32
XTAP_TAPCELL_ROW_73_2_97 VDD VSS WELLTAP
XFILLER_112_1164 VDD VSS DECAPHV32
XFILLER_73_1413 VDD VSS DECAPHV8
XFILLER_158_1345 VSS VDD FILLER2
XTAP_TAPCELL_ROW_85_2_157 VDD VSS WELLTAP
XANTENNA_8 _4_/RB VDD VSS ANTENNA2
XIO_FILL_IO_SOUTH_1_0 IOVDD IOVSS VDD VSS sg13cmos5l_Filler4000
XTAP_TAPCELL_ROW_153_2_493 VDD VSS WELLTAP
XFILLER_170_1066 VSS VDD FILLER2
XFILLER_131_1017 VDD VSS FILLER4
XFILLER_142_1135 VDD VSS DECAPHV16
XTAP_TAPCELL_ROW_124_2_350 VDD VSS WELLTAP
XFILLER_107_1211 VDD VSS DECAPHV32
XFILLER_0_1152 VSS VDD FILLER2
XFILLER_120_1422 VDD VSS FILLER4
XFILLER_107_1299 VSS VDD FILLER2
XFILLER_153_1275 VDD VSS DECAPHV16
XFILLER_131_993 VDD VSS DECAPHV16
XTAP_TAPCELL_ROW_162_2_539 VDD VSS WELLTAP
XFILLER_147_1057 VDD VSS DECAPHV32
XFILLER_164_1382 VDD VSS DECAPHV32
XFILLER_160_1257 VDD VSS DECAPHV32
XFILLER_73_1243 VDD VSS DECAPHV32
XFILLER_60_969 VDD VSS FILLER4
XFILLER_158_1164 VDD VSS DECAPHV32
XFILLER_84_1350 VDD VSS DECAPHV32
XIO_BOND_g_inputs\[1\].input_pad input_PAD[1] sg13cmos5l_ip__bondpad_70x70
XFILLER_171_1397 VDD VSS DECAPHV16
XFILLER_132_1337 VDD VSS DECAPHV8
XFILLER_165_1113 VSS VDD FILLER2
XFILLER_102_1196 VDD VSS DECAPHV32
XFILLER_150_1426 VSS VDD FILLER2
XTAP_TAPCELL_ROW_127_2_365 VDD VSS WELLTAP
XTAP_TAPCELL_ROW_70_2_78 VDD VSS WELLTAP
XFILLER_113_993 VDD VSS DECAPHV16
XTAP_TAPCELL_ROW_92_2_191 VDD VSS WELLTAP
XFILLER_42_969 VDD VSS FILLER4
XFILLER_155_1304 VDD VSS DECAPHV32
XFILLER_120_1252 VSS VDD FILLER2
XFILLER_68_1345 VSS VDD FILLER2
XFILLER_131_1392 VSS VDD FILLER2
XFILLER_166_1422 VDD VSS FILLER4
XTAP_TAPCELL_ROW_152_2_492 VDD VSS WELLTAP
XFILLER_160_1010 VDD VSS DECAPHV32
XFILLER_171_1150 VDD VSS DECAPHV32
XFILLER_80_1066 VSS VDD FILLER2
XTAP_TAPCELL_ROW_115_2_303 VDD VSS WELLTAP
XFILLER_93_1427 VDD VSS FILLER1
XFILLER_108_1350 VDD VSS DECAPHV32
XFILLER_1_1291 VDD VSS DECAPHV8
XFILLER_24_969 VDD VSS FILLER4
XFILLER_178_1337 VDD VSS DECAPHV8
XFILLER_150_1289 VDD VSS DECAPHV32
XFILLER_137_1089 VDD VSS DECAPHV16
XFILLER_148_1196 VDD VSS DECAPHV32
XTAP_TAPCELL_ROW_140_2_430 VDD VSS WELLTAP
XFILLER_2_1066 VSS VDD FILLER2
XFILLER_74_1382 VDD VSS DECAPHV32
XFILLER_70_1257 VDD VSS DECAPHV32
XFILLER_120_1071 VDD VSS DECAPHV32
XFILLER_168_974 VDD VSS FILLER1
XFILLER_133_1421 VDD VSS FILLER4
XFILLER_68_1164 VDD VSS DECAPHV32
XFILLER_151_1009 VDD VSS DECAPHV8
XFILLER_81_1397 VDD VSS DECAPHV16
XFILLER_75_1113 VSS VDD FILLER2
XTAP_TAPCELL_ROW_0_2_640 VDD VSS WELLTAP
XTAP_TAPCELL_ROW_118_2_318 VDD VSS WELLTAP
XFILLER_166_1252 VSS VDD FILLER2
XFILLER_140_1414 VDD VSS DECAPHV8
XFILLER_177_1392 VSS VDD FILLER2
XFILLER_138_1321 VDD VSS DECAPHV16
XFILLER_103_1291 VDD VSS DECAPHV8
XTAP_TAPCELL_ROW_83_2_144 VDD VSS WELLTAP
XFILLER_96_961 VDD VSS DECAPHV8
XFILLER_145_1336 VDD VSS DECAPHV32
XFILLER_3_1397 VDD VSS DECAPHV16
XTAP_TAPCELL_ROW_172_2_588 VDD VSS WELLTAP
XFILLER_20_961 VDD VSS DECAPHV8
XFILLER_87_1017 VDD VSS FILLER4
XFILLER_104_1066 VSS VDD FILLER2
XTAP_TAPCELL_ROW_143_2_445 VDD VSS WELLTAP
XFILLER_139_1118 VDD VSS DECAPHV32
XFILLER_117_1427 VDD VSS FILLER1
XFILLER_180_969 VDD VSS FILLER4
XFILLER_98_1135 VDD VSS DECAPHV16
XFILLER_76_1422 VDD VSS FILLER4
XFILLER_150_1042 VDD VSS DECAPHV16
XFILLER_87_961 VDD VSS DECAPHV32
XFILLER_163_1425 VSS VDD FILLER2
XTAP_TAPCELL_ROW_114_2_302 VDD VSS WELLTAP
XFILLER_11_961 VDD VSS DECAPHV32
XFILLER_70_1010 VDD VSS DECAPHV32
XFILLER_161_1182 VDD VSS DECAPHV16
XFILLER_171_947 VDD VSS DECAPHV32
XFILLER_81_1150 VDD VSS DECAPHV32
XFILLER_78_961 VDD VSS DECAPHV8
XFILLER_166_1071 VDD VSS DECAPHV32
XTAP_TAPCELL_ROW_86_2_159 VDD VSS WELLTAP
XFILLER_179_1421 VDD VSS FILLER4
XFILLER_140_1244 VDD VSS DECAPHV8
XTAP_TAPCELL_ROW_108_2_271 VDD VSS WELLTAP
XFILLER_105_1397 VDD VSS DECAPHV16
XFILLER_101_1206 VSS VDD FILLER2
XFILLER_88_1337 VDD VSS DECAPHV8
XFILLER_138_1151 VDD VSS DECAPHV8
XFILLER_162_969 VDD VSS FILLER4
XFILLER_151_1384 VDD VSS DECAPHV8
XFILLER_3_1150 VDD VSS DECAPHV32
XFILLER_69_961 VDD VSS DECAPHV32
XFILLER_149_1291 VDD VSS DECAPHV8
XFILLER_93_1021 VDD VSS FILLER1
XTAP_TAPCELL_ROW_117_2_317 VDD VSS WELLTAP
Xclkload0 _2_/CK VDD VSS clkload0/Y INVX1
XFILLER_152_1159 VSS VDD FILLER2
XFILLER_61_1009 VSS VDD FILLER2
XFILLER_163_1211 VDD VSS DECAPHV32
XFILLER_76_1252 VSS VDD FILLER2
XFILLER_90_978 VDD VSS DECAPHV32
XFILLER_163_1299 VSS VDD FILLER2
XFILLER_124_1228 VDD VSS DECAPHV16
Xg_vss_pads\[0\].vss_pad IOVDD IOVSS VDD VSS sg13cmos5l_IOPadVss
XTAP_TAPCELL_ROW_171_2_587 VDD VSS WELLTAP
XFILLER_87_1392 VSS VDD FILLER2
XFILLER_144_969 VDD VSS FILLER4
XFILLER_135_1368 VDD VSS DECAPHV16
XFILLER_105_1150 VDD VSS DECAPHV32
XFILLER_101_1025 VDD VSS DECAPHV32
XFILLER_153_1413 VDD VSS DECAPHV8
XFILLER_147_1206 VSS VDD FILLER2
XFILLER_95_1105 VDD VSS DECAPHV8
XFILLER_72_978 VDD VSS DECAPHV32
XFILLER_73_1425 VSS VDD FILLER2
XFILLER_71_1182 VDD VSS DECAPHV16
XIO_BOND_g_inputs\[0\].input_pad input_PAD[0] sg13cmos5l_ip__bondpad_70x70
XFILLER_117_1021 VDD VSS FILLER1
XFILLER_126_969 VDD VSS FILLER4
Xdelaybuf_6_clk delaybuf_6_clk/A VDD VSS delaybuf_7_clk/A BUFX12
XANTENNA_9 _4_/RB VDD VSS ANTENNA2
XTAP_TAPCELL_ROW_93_2_193 VDD VSS WELLTAP
XFILLER_76_1071 VDD VSS DECAPHV32
XFILLER_102_1345 VSS VDD FILLER2
XFILLER_89_1421 VDD VSS FILLER4
XFILLER_124_1058 VDD VSS DECAPHV8
XTAP_TAPCELL_ROW_153_2_494 VDD VSS WELLTAP
XFILLER_140_961 VDD VSS DECAPHV8
XFILLER_135_1198 VDD VSS DECAPHV8
XFILLER_96_1414 VDD VSS DECAPHV8
XFILLER_54_978 VDD VSS DECAPHV32
XFILLER_142_1103 VDD VSS DECAPHV32
XTAP_TAPCELL_ROW_124_2_351 VDD VSS WELLTAP
XFILLER_0_1197 VSS VDD FILLER2
XFILLER_108_969 VDD VSS FILLER4
XFILLER_153_1243 VDD VSS DECAPHV32
XFILLER_131_961 VDD VSS DECAPHV32
XFILLER_164_1350 VDD VSS DECAPHV32
XFILLER_73_1211 VDD VSS DECAPHV32
XFILLER_147_1025 VDD VSS DECAPHV32
XFILLER_73_1299 VSS VDD FILLER2
XFILLER_119_1105 VDD VSS DECAPHV8
XIO_FILL_IO_EAST_2_20 IOVDD IOVSS VDDA VSS sg13cmos5l_Filler2000
XFILLER_122_961 VDD VSS DECAPHV8
XFILLER_36_978 VDD VSS DECAPHV32
XTAP_TAPCELL_ROW_127_2_366 VDD VSS WELLTAP
XFILLER_102_1164 VDD VSS DECAPHV32
XTAP_TAPCELL_ROW_70_2_79 VDD VSS WELLTAP
XFILLER_113_961 VDD VSS DECAPHV32
XFILLER_148_1345 VSS VDD FILLER2
XFILLER_96_1244 VDD VSS DECAPHV8
XTAP_TAPCELL_ROW_92_2_192 VDD VSS WELLTAP
XFILLER_104_961 VDD VSS DECAPHV8
XFILLER_18_978 VDD VSS DECAPHV32
XFILLER_173_1427 VDD VSS FILLER1
XFILLER_160_1066 VSS VDD FILLER2
XFILLER_121_1017 VDD VSS FILLER4
XFILLER_132_1135 VDD VSS DECAPHV16
XTAP_TAPCELL_ROW_115_2_304 VDD VSS WELLTAP
XFILLER_110_1422 VDD VSS FILLER4
XFILLER_143_1275 VDD VSS DECAPHV16
XTAP_TAPCELL_ROW_80_2_130 VDD VSS WELLTAP
XFILLER_32_970 VDD VSS FILLER4
XTAP_TAPCELL_ROW_109_2_273 VDD VSS WELLTAP
XFILLER_137_1057 VDD VSS DECAPHV32
XFILLER_154_1382 VDD VSS DECAPHV32
XFILLER_150_1257 VDD VSS DECAPHV32
XFILLER_148_1164 VDD VSS DECAPHV32
XTAP_TAPCELL_ROW_140_2_431 VDD VSS WELLTAP
XFILLER_74_1350 VDD VSS DECAPHV32
XFILLER_30_929 VDD VSS DECAPHV32
XFILLER_168_931 VDD VSS DECAPHV8
XFILLER_161_1397 VDD VSS DECAPHV16
XFILLER_122_1337 VDD VSS DECAPHV8
XFILLER_155_1113 VSS VDD FILLER2
XFILLER_97_929 VDD VSS DECAPHV32
XTAP_TAPCELL_ROW_0_2_641 VDD VSS WELLTAP
XTAP_TAPCELL_ROW_118_2_319 VDD VSS WELLTAP
XFILLER_140_1426 VSS VDD FILLER2
XFILLER_21_929 VDD VSS DECAPHV32
XTAP_TAPCELL_ROW_83_2_145 VDD VSS WELLTAP
XFILLER_88_929 VDD VSS DECAPHV32
XFILLER_174_978 VDD VSS DECAPHV32
XIO_BOND_g_outputs\[1\].output_pad output_PAD[1] sg13cmos5l_ip__bondpad_70x70
XFILLER_96_973 VSS VDD FILLER2
XFILLER_145_1304 VDD VSS DECAPHV32
XFILLER_110_1252 VSS VDD FILLER2
XTAP_TAPCELL_ROW_172_2_589 VDD VSS WELLTAP
XFILLER_12_929 VDD VSS DECAPHV32
XFILLER_178_1135 VDD VSS DECAPHV16
XFILLER_121_1392 VSS VDD FILLER2
XFILLER_20_973 VSS VDD FILLER2
XFILLER_156_1422 VDD VSS FILLER4
XTAP_TAPCELL_ROW_143_2_446 VDD VSS WELLTAP
XFILLER_4_1107 VSS VDD FILLER2
XFILLER_79_929 VDD VSS DECAPHV32
XFILLER_150_1010 VDD VSS DECAPHV32
XFILLER_98_1103 VDD VSS DECAPHV32
XFILLER_161_1150 VDD VSS DECAPHV32
XFILLER_70_1066 VSS VDD FILLER2
XFILLER_83_1427 VDD VSS FILLER1
XFILLER_156_978 VDD VSS DECAPHV32
XFILLER_171_937 VSS VDD FILLER2
XFILLER_78_973 VSS VDD FILLER2
XFILLER_168_1337 VDD VSS DECAPHV8
XTAP_TAPCELL_ROW_108_2_272 VDD VSS WELLTAP
XFILLER_140_1289 VDD VSS DECAPHV32
XFILLER_127_1089 VDD VSS DECAPHV16
XFILLER_138_1196 VDD VSS DECAPHV32
XFILLER_173_1021 VDD VSS FILLER1
XFILLER_110_1071 VDD VSS DECAPHV32
XFILLER_123_1421 VDD VSS FILLER4
XFILLER_141_1009 VDD VSS DECAPHV8
XFILLER_156_1252 VSS VDD FILLER2
XFILLER_71_1397 VDD VSS DECAPHV16
XFILLER_4_969 VDD VSS FILLER4
XFILLER_138_978 VDD VSS DECAPHV32
XFILLER_130_1414 VDD VSS DECAPHV8
XTAP_TAPCELL_ROW_125_2_353 VDD VSS WELLTAP
XFILLER_167_1392 VSS VDD FILLER2
XFILLER_128_1321 VDD VSS DECAPHV16
XIO_FILL_IO_WEST_0_0 IOVDD IOVSS VDD VSS sg13cmos5l_Filler4000
XIO_FILL_IO_EAST_5_20 IOVDD IOVSS VDDA VSS sg13cmos5l_Filler2000
XFILLER_135_1336 VDD VSS DECAPHV32
XFILLER_129_1118 VDD VSS DECAPHV32
XFILLER_0_1324 VDD VSS DECAPHV8
XFILLER_77_1017 VDD VSS FILLER4
XTAP_TAPCELL_ROW_150_2_480 VDD VSS WELLTAP
XFILLER_107_1427 VDD VSS FILLER1
XFILLER_90_1228 VDD VSS DECAPHV16
XFILLER_175_1105 VDD VSS DECAPHV8
XFILLER_88_1135 VDD VSS DECAPHV16
XFILLER_140_1042 VDD VSS DECAPHV16
XFILLER_150_929 VDD VSS DECAPHV32
XFILLER_153_1425 VSS VDD FILLER2
XFILLER_151_1182 VDD VSS DECAPHV16
XFILLER_60_1010 VDD VSS FILLER1
XFILLER_99_1275 VDD VSS DECAPHV16
XTAP_TAPCELL_ROW_128_2_368 VDD VSS WELLTAP
XFILLER_71_1150 VDD VSS DECAPHV32
XTAP_TAPCELL_ROW_93_2_194 VDD VSS WELLTAP
XFILLER_156_1071 VDD VSS DECAPHV32
XFILLER_141_929 VDD VSS DECAPHV32
XFILLER_169_1421 VDD VSS FILLER4
XFILLER_130_1244 VDD VSS DECAPHV8
XFILLER_78_1337 VDD VSS DECAPHV8
XFILLER_0_961 VDD VSS DECAPHV8
XFILLER_128_1151 VDD VSS DECAPHV8
XFILLER_176_1414 VDD VSS DECAPHV8
XFILLER_141_1384 VDD VSS DECAPHV8
XFILLER_132_929 VDD VSS DECAPHV32
XTAP_TAPCELL_ROW_153_2_495 VDD VSS WELLTAP
XFILLER_139_1291 VDD VSS DECAPHV8
XFILLER_83_1021 VDD VSS FILLER1
XFILLER_140_973 VSS VDD FILLER2
XFILLER_96_1426 VSS VDD FILLER2
XFILLER_142_1159 VSS VDD FILLER2
XTAP_TAPCELL_ROW_124_2_352 VDD VSS WELLTAP
XTAP_TAPCELL_ROW_40_2_43 VDD VSS WELLTAP
XFILLER_51_1009 VSS VDD FILLER2
XFILLER_90_1058 VDD VSS DECAPHV8
XFILLER_153_1211 VDD VSS DECAPHV32
XFILLER_123_929 VDD VSS DECAPHV32
XFILLER_153_1299 VSS VDD FILLER2
XFILLER_114_1228 VDD VSS DECAPHV16
XFILLER_77_1392 VSS VDD FILLER2
XFILLER_125_1368 VDD VSS DECAPHV16
XFILLER_114_929 VDD VSS DECAPHV32
XFILLER_122_973 VSS VDD FILLER2
XTAP_TAPCELL_ROW_141_2_433 VDD VSS WELLTAP
XFILLER_143_1413 VDD VSS DECAPHV8
XFILLER_176_1244 VDD VSS DECAPHV8
XFILLER_137_1206 VSS VDD FILLER2
XTAP_TAPCELL_ROW_127_2_367 VDD VSS WELLTAP
XFILLER_85_1105 VDD VSS DECAPHV8
XFILLER_105_929 VDD VSS DECAPHV32
XFILLER_96_1289 VDD VSS DECAPHV32
XFILLER_107_1021 VDD VSS FILLER1
XFILLER_177_1019 VSS VDD FILLER2
XFILLER_104_973 VSS VDD FILLER2
XFILLER_79_1421 VDD VSS FILLER4
XFILLER_97_1009 VDD VSS DECAPHV8
XFILLER_114_1058 VDD VSS DECAPHV8
XTAP_TAPCELL_ROW_144_2_448 VDD VSS WELLTAP
XFILLER_125_1198 VDD VSS DECAPHV8
XFILLER_41_993 VDD VSS DECAPHV16
XTAP_TAPCELL_ROW_115_2_305 VDD VSS WELLTAP
XFILLER_86_1414 VDD VSS DECAPHV8
XFILLER_132_1103 VDD VSS DECAPHV32
XFILLER_143_1243 VDD VSS DECAPHV32
XTAP_TAPCELL_ROW_80_2_131 VDD VSS WELLTAP
XFILLER_177_987 VDD VSS DECAPHV32
XFILLER_154_1350 VDD VSS DECAPHV32
XTAP_TAPCELL_ROW_109_2_274 VDD VSS WELLTAP
XFILLER_99_993 VDD VSS DECAPHV16
XFILLER_137_1025 VDD VSS DECAPHV32
XFILLER_96_1042 VDD VSS DECAPHV16
XTAP_TAPCELL_ROW_140_2_432 VDD VSS WELLTAP
XFILLER_109_1105 VDD VSS DECAPHV8
XFILLER_23_993 VDD VSS DECAPHV16
XFILLER_168_954 VDD VSS DECAPHV16
XFILLER_168_943 VSS VDD FILLER2
XTAP_TAPCELL_ROW_0_2_642 VDD VSS WELLTAP
XFILLER_138_1345 VSS VDD FILLER2
XFILLER_86_1244 VDD VSS DECAPHV8
XTAP_TAPCELL_ROW_83_2_146 VDD VSS WELLTAP
XFILLER_97_1384 VDD VSS DECAPHV8
XFILLER_178_1103 VDD VSS DECAPHV32
XTAP_TAPCELL_ROW_143_2_447 VDD VSS WELLTAP
XFILLER_150_1066 VSS VDD FILLER2
Xg_outputs\[1\].output_pad g_outputs\[1\].output_pad/c2p IOVDD IOVSS output_PAD[1]
+ VDD VSS sg13cmos5l_IOPadOut30mA
XFILLER_111_1017 VDD VSS FILLER4
XFILLER_163_1427 VDD VSS FILLER1
XFILLER_98_1159 VSS VDD FILLER2
XFILLER_122_1135 VDD VSS DECAPHV16
XFILLER_100_1422 VDD VSS FILLER4
XFILLER_133_1275 VDD VSS DECAPHV16
XTAP_TAPCELL_ROW_160_2_528 VDD VSS WELLTAP
XFILLER_127_1057 VDD VSS DECAPHV32
XFILLER_144_1382 VDD VSS DECAPHV32
XFILLER_140_1257 VDD VSS DECAPHV32
XFILLER_138_1164 VDD VSS DECAPHV32
XFILLER_99_1413 VDD VSS DECAPHV8
XFILLER_173_1011 VDD VSS DECAPHV8
XFILLER_151_1397 VDD VSS DECAPHV16
XFILLER_145_1113 VSS VDD FILLER2
XFILLER_112_1337 VDD VSS DECAPHV8
XFILLER_93_1089 VDD VSS DECAPHV16
XTAP_TAPCELL_ROW_125_2_354 VDD VSS WELLTAP
XFILLER_161_993 VDD VSS DECAPHV16
XFILLER_130_1426 VSS VDD FILLER2
XFILLER_90_969 VDD VSS FILLER4
XFILLER_100_1252 VSS VDD FILLER2
XTAP_TAPCELL_ROW_90_2_180 VDD VSS WELLTAP
XFILLER_157_1017 VDD VSS FILLER4
XFILLER_170_1228 VDD VSS DECAPHV16
XFILLER_135_1304 VDD VSS DECAPHV32
XIO_BOND_vcm_pad analog_PAD[1] sg13cmos5l_ip__bondpad_70x70
XFILLER_168_1135 VDD VSS DECAPHV16
XFILLER_146_1422 VDD VSS FILLER4
XFILLER_111_1392 VSS VDD FILLER2
XFILLER_94_1321 VDD VSS DECAPHV16
XFILLER_0_1369 VDD VSS DECAPHV8
XTAP_TAPCELL_ROW_150_2_481 VDD VSS WELLTAP
XFILLER_88_1103 VDD VSS DECAPHV32
XFILLER_140_1010 VDD VSS DECAPHV32
XFILLER_179_1275 VDD VSS DECAPHV16
XFILLER_1_929 VDD VSS DECAPHV32
XFILLER_143_993 VDD VSS DECAPHV16
XFILLER_151_1150 VDD VSS DECAPHV32
XFILLER_99_1243 VDD VSS DECAPHV32
XFILLER_95_1118 VDD VSS DECAPHV32
XFILLER_73_1427 VDD VSS FILLER1
XFILLER_72_969 VDD VSS FILLER4
XTAP_TAPCELL_ROW_128_2_369 VDD VSS WELLTAP
XFILLER_158_1337 VDD VSS DECAPHV8
XFILLER_117_1089 VDD VSS DECAPHV16
XTAP_TAPCELL_ROW_93_2_195 VDD VSS WELLTAP
XFILLER_0_973 VDD VSS FILLER1
XFILLER_130_1289 VDD VSS DECAPHV32
XFILLER_128_1196 VDD VSS DECAPHV32
XFILLER_163_1021 VDD VSS FILLER1
XFILLER_176_1426 VSS VDD FILLER2
XTAP_TAPCELL_ROW_153_2_496 VDD VSS WELLTAP
XFILLER_100_1071 VDD VSS DECAPHV32
XFILLER_125_993 VDD VSS DECAPHV16
XFILLER_113_1421 VDD VSS FILLER4
XFILLER_170_1058 VDD VSS DECAPHV8
XFILLER_131_1009 VDD VSS DECAPHV8
XFILLER_146_1252 VSS VDD FILLER2
XFILLER_94_1151 VDD VSS DECAPHV8
XFILLER_0_1144 VDD VSS DECAPHV8
XFILLER_54_969 VDD VSS FILLER4
XFILLER_120_1414 VDD VSS DECAPHV8
XFILLER_157_1392 VSS VDD FILLER2
XFILLER_118_1321 VDD VSS DECAPHV16
XTAP_TAPCELL_ROW_81_2_133 VDD VSS WELLTAP
XFILLER_125_1336 VDD VSS DECAPHV32
XFILLER_119_1118 VDD VSS DECAPHV32
XTAP_TAPCELL_ROW_56_2_51 VDD VSS WELLTAP
XFILLER_67_1017 VSS VDD FILLER2
XFILLER_107_993 VDD VSS DECAPHV16
XTAP_TAPCELL_ROW_141_2_434 VDD VSS WELLTAP
XFILLER_80_1228 VDD VSS DECAPHV16
XFILLER_165_1105 VDD VSS DECAPHV8
XFILLER_78_1135 VDD VSS DECAPHV16
XFILLER_36_969 VDD VSS FILLER4
XFILLER_130_1042 VDD VSS DECAPHV16
XIO_CORNER_NORTH_EAST_INST IOVDD IOVSS VDD VSS sg13cmos5l_Corner
XFILLER_143_1425 VSS VDD FILLER2
XFILLER_141_1182 VDD VSS DECAPHV16
XFILLER_91_1368 VDD VSS DECAPHV16
XFILLER_50_1010 VDD VSS FILLER1
XFILLER_176_1289 VDD VSS DECAPHV32
XFILLER_89_1275 VDD VSS DECAPHV16
XFILLER_96_1257 VDD VSS DECAPHV32
XFILLER_2_1228 VDD VSS DECAPHV16
XTAP_TAPCELL_ROW_106_2_260 VDD VSS WELLTAP
XFILLER_146_1071 VDD VSS DECAPHV32
XFILLER_50_961 VDD VSS DECAPHV8
XTAP_TAPCELL_ROW_84_2_148 VDD VSS WELLTAP
XFILLER_159_1421 VDD VSS FILLER4
XFILLER_120_1244 VDD VSS DECAPHV8
XFILLER_68_1337 VDD VSS DECAPHV8
XFILLER_118_1151 VDD VSS DECAPHV8
XFILLER_166_1414 VDD VSS DECAPHV8
XFILLER_131_1384 VDD VSS DECAPHV8
XTAP_TAPCELL_ROW_144_2_449 VDD VSS WELLTAP
XFILLER_18_969 VDD VSS FILLER4
XFILLER_73_1021 VDD VSS FILLER1
XFILLER_129_1291 VDD VSS DECAPHV8
XFILLER_41_961 VDD VSS DECAPHV32
XTAP_TAPCELL_ROW_115_2_306 VDD VSS WELLTAP
XFILLER_86_1426 VSS VDD FILLER2
XFILLER_132_1159 VSS VDD FILLER2
XFILLER_41_1009 VSS VDD FILLER2
XFILLER_80_1058 VDD VSS DECAPHV8
XFILLER_143_1211 VDD VSS DECAPHV32
XTAP_TAPCELL_ROW_80_2_132 VDD VSS WELLTAP
XFILLER_177_955 VDD VSS DECAPHV32
XFILLER_143_1299 VSS VDD FILLER2
XFILLER_104_1228 VDD VSS DECAPHV16
XFILLER_91_1198 VDD VSS DECAPHV8
XFILLER_176_1042 VDD VSS DECAPHV16
XFILLER_115_1368 VDD VSS DECAPHV16
XTAP_TAPCELL_ROW_109_2_275 VDD VSS WELLTAP
Xvcm_pad IOVDD IOVSS analog_PAD[1] vcm_pad/padbare dsm2/vcm VDDA VSS sg13cmos5l_IOPadAnalog
XFILLER_99_961 VDD VSS DECAPHV32
XFILLER_2_1058 VDD VSS DECAPHV8
XFILLER_96_1010 VDD VSS DECAPHV32
XFILLER_23_961 VDD VSS DECAPHV32
XFILLER_133_1413 VDD VSS DECAPHV8
XTAP_TAPCELL_ROW_0_2_643 VDD VSS WELLTAP
XFILLER_166_1244 VDD VSS DECAPHV8
XFILLER_127_1206 VSS VDD FILLER2
XFILLER_75_1105 VDD VSS DECAPHV8
XFILLER_14_961 VDD VSS DECAPHV8
XFILLER_174_969 VDD VSS FILLER4
XFILLER_177_1384 VDD VSS DECAPHV8
XFILLER_86_1289 VDD VSS DECAPHV32
XTAP_TAPCELL_ROW_83_2_147 VDD VSS WELLTAP
XTAP_TAPCELL_ROW_6_2_26 VDD VSS WELLTAP
XFILLER_178_1159 VSS VDD FILLER2
XFILLER_69_1421 VDD VSS FILLER4
XFILLER_87_1009 VDD VSS DECAPHV8
XFILLER_104_1058 VDD VSS DECAPHV8
XFILLER_115_1198 VDD VSS DECAPHV8
XTAP_TAPCELL_ROW_151_2_483 VDD VSS WELLTAP
XFILLER_76_1414 VDD VSS DECAPHV8
XTAP_TAPCELL_ROW_122_2_340 VDD VSS WELLTAP
XFILLER_122_1103 VDD VSS DECAPHV32
XFILLER_156_969 VDD VSS FILLER4
XFILLER_133_1243 VDD VSS DECAPHV32
XFILLER_9_1009 VSS VDD FILLER2
XTAP_TAPCELL_ROW_160_2_529 VDD VSS WELLTAP
XFILLER_179_1413 VDD VSS DECAPHV8
XFILLER_144_1350 VDD VSS DECAPHV32
XFILLER_127_1025 VDD VSS DECAPHV32
XFILLER_86_1042 VDD VSS DECAPHV16
XFILLER_170_961 VDD VSS DECAPHV8
XFILLER_173_1089 VDD VSS DECAPHV16
XFILLER_99_1425 VSS VDD FILLER2
XFILLER_97_1182 VDD VSS DECAPHV16
XFILLER_84_978 VDD VSS DECAPHV32
XFILLER_93_1057 VDD VSS DECAPHV32
XTAP_TAPCELL_ROW_154_2_498 VDD VSS WELLTAP
XFILLER_138_969 VDD VSS FILLER4
XTAP_TAPCELL_ROW_125_2_355 VDD VSS WELLTAP
XFILLER_161_961 VDD VSS DECAPHV32
XFILLER_128_1345 VSS VDD FILLER2
XTAP_TAPCELL_ROW_90_2_181 VDD VSS WELLTAP
XFILLER_76_1244 VDD VSS DECAPHV8
Xdelaybuf_9_clk delaybuf_9_clk/A VDD VSS delaybuf_9_clk/Y BUFX12
XFILLER_174_1321 VDD VSS DECAPHV16
XFILLER_87_1384 VDD VSS DECAPHV8
XFILLER_152_961 VDD VSS DECAPHV8
XFILLER_168_1103 VDD VSS DECAPHV32
XFILLER_0_1337 VDD VSS DECAPHV32
XFILLER_66_978 VDD VSS DECAPHV32
XFILLER_179_1243 VDD VSS DECAPHV32
XTAP_TAPCELL_ROW_150_2_482 VDD VSS WELLTAP
XFILLER_140_1066 VSS VDD FILLER2
XFILLER_101_1017 VDD VSS FILLER4
XFILLER_175_1118 VDD VSS DECAPHV32
XFILLER_153_1427 VDD VSS FILLER1
XFILLER_88_1159 VSS VDD FILLER2
XFILLER_143_961 VDD VSS DECAPHV32
XFILLER_112_1135 VDD VSS DECAPHV16
XFILLER_99_1299 VSS VDD FILLER2
XFILLER_99_1211 VDD VSS DECAPHV32
XFILLER_123_1275 VDD VSS DECAPHV16
XFILLER_134_961 VDD VSS DECAPHV8
XFILLER_134_1382 VDD VSS DECAPHV32
XTAP_TAPCELL_ROW_93_2_196 VDD VSS WELLTAP
XFILLER_117_1057 VDD VSS DECAPHV32
XFILLER_130_1257 VDD VSS DECAPHV32
XFILLER_48_978 VDD VSS DECAPHV32
XFILLER_128_1164 VDD VSS DECAPHV32
XFILLER_102_1337 VDD VSS DECAPHV8
XFILLER_89_1413 VDD VSS DECAPHV8
XFILLER_174_1151 VDD VSS DECAPHV8
XTAP_TAPCELL_ROW_153_2_497 VDD VSS WELLTAP
XFILLER_141_1397 VDD VSS DECAPHV16
XFILLER_135_1113 VSS VDD FILLER2
XTAP_TAPCELL_ROW_72_2_90 VDD VSS WELLTAP
XFILLER_125_961 VDD VSS DECAPHV32
XFILLER_83_1089 VDD VSS DECAPHV16
XFILLER_94_1196 VDD VSS DECAPHV32
XFILLER_4_1292 VDD VSS DECAPHV32
XFILLER_0_1189 VDD VSS DECAPHV8
XFILLER_0_1112 VDD VSS DECAPHV32
XTAP_TAPCELL_ROW_116_2_308 VDD VSS WELLTAP
XFILLER_120_1426 VSS VDD FILLER2
XIO_FILL_IO_WEST_2_30 IOVDD IOVSS VDD VSS sg13cmos5l_Filler1000
XTAP_TAPCELL_ROW_81_2_134 VDD VSS WELLTAP
XFILLER_116_961 VDD VSS DECAPHV8
XFILLER_60_929 VDD VSS DECAPHV32
XTAP_TAPCELL_ROW_170_2_578 VDD VSS WELLTAP
XFILLER_147_1017 VDD VSS FILLER4
XFILLER_160_1228 VDD VSS DECAPHV16
XFILLER_125_1304 VDD VSS DECAPHV32
XIO_BOND_g_iovss_pads\[0\].iovss_pad IOVSS sg13cmos5l_ip__bondpad_70x70
XFILLER_158_1135 VDD VSS DECAPHV16
XTAP_TAPCELL_ROW_141_2_435 VDD VSS WELLTAP
XFILLER_136_1422 VDD VSS FILLER4
XFILLER_101_1392 VSS VDD FILLER2
XFILLER_84_1321 VDD VSS DECAPHV16
XFILLER_107_961 VDD VSS DECAPHV32
XFILLER_171_1368 VDD VSS DECAPHV16
XFILLER_78_1103 VDD VSS DECAPHV32
XFILLER_130_1010 VDD VSS DECAPHV32
XFILLER_169_1275 VDD VSS DECAPHV16
XFILLER_91_1336 VDD VSS DECAPHV32
XFILLER_1_1421 VDD VSS FILLER4
XFILLER_51_929 VDD VSS DECAPHV32
XFILLER_141_1150 VDD VSS DECAPHV32
XFILLER_89_1243 VDD VSS DECAPHV32
XFILLER_85_1118 VDD VSS DECAPHV32
XFILLER_176_1257 VDD VSS DECAPHV32
XFILLER_148_1337 VDD VSS DECAPHV8
XFILLER_42_929 VDD VSS DECAPHV32
XFILLER_107_1089 VDD VSS DECAPHV16
XTAP_TAPCELL_ROW_106_2_261 VDD VSS WELLTAP
XFILLER_50_973 VSS VDD FILLER2
XTAP_TAPCELL_ROW_84_2_149 VDD VSS WELLTAP
Xclkbuf_1_1__f_clk_PAD2CORE_regs clkbuf_0_clk_PAD2CORE_regs/Y VDD VSS _2_/CK BUFX12
XFILLER_120_1289 VDD VSS DECAPHV32
XFILLER_118_1196 VDD VSS DECAPHV32
XFILLER_153_1021 VDD VSS FILLER1
XFILLER_166_1426 VSS VDD FILLER2
XFILLER_33_929 VDD VSS DECAPHV32
XFILLER_103_1421 VDD VSS FILLER4
XFILLER_160_1058 VDD VSS DECAPHV8
XFILLER_121_1009 VDD VSS DECAPHV8
XFILLER_136_1252 VSS VDD FILLER2
XTAP_TAPCELL_ROW_115_2_307 VDD VSS WELLTAP
XFILLER_84_1151 VDD VSS DECAPHV8
XFILLER_171_1198 VDD VSS DECAPHV8
XFILLER_110_1414 VDD VSS DECAPHV8
XFILLER_24_929 VDD VSS DECAPHV32
XFILLER_110_978 VDD VSS DECAPHV32
XFILLER_147_1392 VSS VDD FILLER2
XFILLER_108_1321 VDD VSS DECAPHV16
XFILLER_95_1291 VDD VSS DECAPHV8
XFILLER_176_1010 VDD VSS DECAPHV32
XFILLER_115_1336 VDD VSS DECAPHV32
XTAP_TAPCELL_ROW_109_2_276 VDD VSS WELLTAP
XFILLER_67_1382 VDD VSS DECAPHV32
XFILLER_109_1118 VDD VSS DECAPHV32
XFILLER_15_929 VDD VSS DECAPHV32
XFILLER_96_1066 VSS VDD FILLER2
XFILLER_70_1228 VDD VSS DECAPHV16
XFILLER_120_1042 VDD VSS DECAPHV16
XFILLER_168_978 VDD VSS DECAPHV32
XFILLER_168_945 VDD VSS FILLER1
XFILLER_155_1105 VDD VSS DECAPHV8
XFILLER_133_1425 VSS VDD FILLER2
XFILLER_68_1135 VDD VSS DECAPHV16
XFILLER_131_1182 VDD VSS DECAPHV16
XFILLER_81_1368 VDD VSS DECAPHV16
XFILLER_79_1275 VDD VSS DECAPHV16
XTAP_TAPCELL_ROW_0_2_644 VDD VSS WELLTAP
XFILLER_40_1010 VDD VSS FILLER1
XFILLER_166_1289 VDD VSS DECAPHV32
XFILLER_14_973 VSS VDD FILLER2
XFILLER_86_1257 VDD VSS DECAPHV32
XFILLER_174_937 VDD VSS DECAPHV32
XTAP_TAPCELL_ROW_91_2_183 VDD VSS WELLTAP
XFILLER_136_1071 VDD VSS DECAPHV32
XFILLER_149_1421 VDD VSS FILLER4
XFILLER_110_1244 VDD VSS DECAPHV8
XFILLER_97_1397 VDD VSS DECAPHV16
XFILLER_93_1206 VSS VDD FILLER2
XFILLER_3_1368 VDD VSS DECAPHV16
XTAP_TAPCELL_ROW_69_2_73 VDD VSS WELLTAP
XFILLER_108_1151 VDD VSS DECAPHV8
XFILLER_156_1414 VDD VSS DECAPHV8
XTAP_TAPCELL_ROW_151_2_484 VDD VSS WELLTAP
XFILLER_121_1384 VDD VSS DECAPHV8
XFILLER_119_1291 VDD VSS DECAPHV8
XTAP_TAPCELL_ROW_122_2_341 VDD VSS WELLTAP
XFILLER_76_1426 VSS VDD FILLER2
XFILLER_122_1159 VSS VDD FILLER2
XFILLER_70_1058 VDD VSS DECAPHV8
XFILLER_171_929 VDD VSS DECAPHV8
XFILLER_133_1211 VDD VSS DECAPHV32
XFILLER_81_1198 VDD VSS DECAPHV8
XFILLER_133_1299 VSS VDD FILLER2
XFILLER_166_1042 VDD VSS DECAPHV16
XFILLER_179_1425 VSS VDD FILLER2
XFILLER_105_1368 VDD VSS DECAPHV16
XTAP_TAPCELL_ROW_94_2_198 VDD VSS WELLTAP
XFILLER_177_1182 VDD VSS DECAPHV16
XFILLER_173_1057 VDD VSS DECAPHV32
XFILLER_86_1010 VDD VSS DECAPHV32
XFILLER_162_929 VDD VSS DECAPHV32
XFILLER_170_973 VSS VDD FILLER2
XFILLER_97_1150 VDD VSS DECAPHV32
XFILLER_3_1198 VDD VSS DECAPHV8
XTAP_TAPCELL_ROW_154_2_499 VDD VSS WELLTAP
XFILLER_180_1017 VSS VDD FILLER2
XIO_FILL_IO_WEST_5_30 IOVDD IOVSS VDD VSS sg13cmos5l_Filler1000
XFILLER_93_1025 VDD VSS DECAPHV32
XFILLER_123_1413 VDD VSS DECAPHV8
XFILLER_153_929 VDD VSS DECAPHV32
XFILLER_156_1244 VDD VSS DECAPHV8
XTAP_TAPCELL_ROW_125_2_356 VDD VSS WELLTAP
XFILLER_117_1206 VSS VDD FILLER2
XFILLER_8_1010 VDD VSS FILLER1
XFILLER_167_1384 VDD VSS DECAPHV8
XTAP_TAPCELL_ROW_90_2_182 VDD VSS WELLTAP
XFILLER_76_1289 VDD VSS DECAPHV32
XFILLER_144_929 VDD VSS DECAPHV32
XFILLER_152_973 VSS VDD FILLER2
XFILLER_77_1009 VDD VSS DECAPHV8
XFILLER_168_1159 VSS VDD FILLER2
XFILLER_94_1345 VSS VDD FILLER2
XIO_BOND_g_iovdd_pads\[0\].iovdd_pad IOVDD sg13cmos5l_ip__bondpad_70x70
XFILLER_179_1211 VDD VSS DECAPHV32
XFILLER_105_1198 VDD VSS DECAPHV8
XFILLER_135_929 VDD VSS DECAPHV32
XFILLER_179_1299 VSS VDD FILLER2
XFILLER_112_1103 VDD VSS DECAPHV32
XFILLER_123_1243 VDD VSS DECAPHV32
XFILLER_126_929 VDD VSS DECAPHV32
XFILLER_134_973 VSS VDD FILLER2
XFILLER_169_1413 VDD VSS DECAPHV8
XFILLER_134_1350 VDD VSS DECAPHV32
XTAP_TAPCELL_ROW_93_2_197 VDD VSS WELLTAP
XTAP_TAPCELL_ROW_107_2_263 VDD VSS WELLTAP
XFILLER_117_1025 VDD VSS DECAPHV32
Xclkbuf_regs_0_clk delaybuf_10_clk/Y VDD VSS clkbuf_regs_0_clk/Y BUFX12
XFILLER_71_993 VDD VSS DECAPHV16
XFILLER_76_1042 VDD VSS DECAPHV16
XFILLER_163_1089 VDD VSS DECAPHV16
XFILLER_89_1425 VSS VDD FILLER2
XFILLER_117_929 VDD VSS DECAPHV32
XFILLER_174_1196 VDD VSS DECAPHV32
XFILLER_87_1182 VDD VSS DECAPHV16
XTAP_TAPCELL_ROW_72_2_91 VDD VSS WELLTAP
XFILLER_83_1057 VDD VSS DECAPHV32
XTAP_TAPCELL_ROW_132_2_390 VDD VSS WELLTAP
XFILLER_94_1164 VDD VSS DECAPHV32
XFILLER_0_1157 VDD VSS DECAPHV32
XIO_FILL_IO_WEST_2_20 IOVDD IOVSS VDD VSS sg13cmos5l_Filler2000
XTAP_TAPCELL_ROW_116_2_309 VDD VSS WELLTAP
XFILLER_108_929 VDD VSS DECAPHV32
XFILLER_116_973 VSS VDD FILLER2
XFILLER_118_1345 VSS VDD FILLER2
XTAP_TAPCELL_ROW_81_2_135 VDD VSS WELLTAP
XFILLER_164_1321 VDD VSS DECAPHV16
XFILLER_77_1384 VDD VSS DECAPHV8
XTAP_TAPCELL_ROW_170_2_579 VDD VSS WELLTAP
XFILLER_53_993 VDD VSS DECAPHV16
XFILLER_158_1103 VDD VSS DECAPHV32
XFILLER_171_1336 VDD VSS DECAPHV32
XTAP_TAPCELL_ROW_141_2_436 VDD VSS WELLTAP
XFILLER_169_1243 VDD VSS DECAPHV32
XFILLER_78_1159 VSS VDD FILLER2
XFILLER_130_1066 VSS VDD FILLER2
XFILLER_165_1118 VDD VSS DECAPHV32
XFILLER_143_1427 VDD VSS FILLER1
XFILLER_91_1304 VDD VSS DECAPHV32
XFILLER_102_1135 VDD VSS DECAPHV16
XFILLER_89_1299 VSS VDD FILLER2
XFILLER_89_1211 VDD VSS DECAPHV32
XFILLER_113_1275 VDD VSS DECAPHV16
XFILLER_35_993 VDD VSS DECAPHV16
XFILLER_124_1382 VDD VSS DECAPHV32
XTAP_TAPCELL_ROW_106_2_262 VDD VSS WELLTAP
XFILLER_107_1057 VDD VSS DECAPHV32
XFILLER_120_1257 VDD VSS DECAPHV32
XFILLER_131_1397 VDD VSS DECAPHV16
XFILLER_118_1164 VDD VSS DECAPHV32
XFILLER_79_1413 VDD VSS DECAPHV8
XFILLER_164_1151 VDD VSS DECAPHV8
XFILLER_125_1113 VSS VDD FILLER2
XFILLER_73_1089 VDD VSS DECAPHV16
XFILLER_175_1291 VDD VSS DECAPHV8
XFILLER_84_1196 VDD VSS DECAPHV32
XTAP_TAPCELL_ROW_123_2_343 VDD VSS WELLTAP
XFILLER_110_1426 VSS VDD FILLER2
XFILLER_17_993 VDD VSS DECAPHV16
XFILLER_32_974 VDD VSS FILLER1
XTAP_TAPCELL_ROW_109_2_277 VDD VSS WELLTAP
XFILLER_176_1066 VSS VDD FILLER2
XIO_BOND_g_vdd_pads\[0\].vdd_pad VDD sg13cmos5l_ip__bondpad_70x70
XFILLER_137_1017 VDD VSS FILLER4
XFILLER_150_1228 VDD VSS DECAPHV16
XFILLER_115_1304 VDD VSS DECAPHV32
XFILLER_148_1135 VDD VSS DECAPHV16
XFILLER_126_1422 VDD VSS FILLER4
XFILLER_74_1321 VDD VSS DECAPHV16
XFILLER_161_1368 VDD VSS DECAPHV16
XFILLER_68_1103 VDD VSS DECAPHV32
XFILLER_120_1010 VDD VSS DECAPHV32
XFILLER_159_1275 VDD VSS DECAPHV16
XFILLER_81_1336 VDD VSS DECAPHV32
XFILLER_166_1257 VDD VSS DECAPHV32
XFILLER_131_1150 VDD VSS DECAPHV32
XFILLER_79_1243 VDD VSS DECAPHV32
XFILLER_75_1118 VDD VSS DECAPHV32
XTAP_TAPCELL_ROW_0_2_645 VDD VSS WELLTAP
XTAP_TAPCELL_ROW_126_2_358 VDD VSS WELLTAP
XFILLER_177_1397 VDD VSS DECAPHV16
XFILLER_173_1206 VSS VDD FILLER2
XFILLER_138_1337 VDD VSS DECAPHV8
XTAP_TAPCELL_ROW_91_2_184 VDD VSS WELLTAP
XTAP_TAPCELL_ROW_69_2_74 VDD VSS WELLTAP
XFILLER_3_1336 VDD VSS DECAPHV32
XFILLER_110_1289 VDD VSS DECAPHV32
XFILLER_143_1021 VDD VSS FILLER1
XFILLER_108_1196 VDD VSS DECAPHV32
XFILLER_156_1426 VSS VDD FILLER2
XTAP_TAPCELL_ROW_151_2_485 VDD VSS WELLTAP
XFILLER_150_1058 VDD VSS DECAPHV8
XFILLER_111_1009 VDD VSS DECAPHV8
XFILLER_126_1252 VSS VDD FILLER2
XTAP_TAPCELL_ROW_122_2_342 VDD VSS WELLTAP
XFILLER_74_1151 VDD VSS DECAPHV8
XTAP_TAPCELL_ROW_20_2_33 VDD VSS WELLTAP
XFILLER_161_1198 VDD VSS DECAPHV8
XFILLER_100_1414 VDD VSS DECAPHV8
XFILLER_164_971 VDD VSS FILLER4
XFILLER_137_1392 VSS VDD FILLER2
XFILLER_85_1291 VDD VSS DECAPHV8
XFILLER_166_1010 VDD VSS DECAPHV32
XTAP_TAPCELL_ROW_94_2_199 VDD VSS WELLTAP
XFILLER_105_1336 VDD VSS DECAPHV32
XFILLER_177_1150 VDD VSS DECAPHV32
XFILLER_173_1025 VDD VSS DECAPHV32
XFILLER_86_1066 VSS VDD FILLER2
XFILLER_155_993 VDD VSS DECAPHV16
XFILLER_99_1427 VDD VSS FILLER1
XIO_FILL_IO_WEST_5_20 IOVDD IOVSS VDD VSS sg13cmos5l_Filler2000
XFILLER_84_969 VDD VSS FILLER4
XFILLER_110_1042 VDD VSS DECAPHV16
XFILLER_145_1105 VDD VSS DECAPHV8
XFILLER_123_1425 VSS VDD FILLER2
XFILLER_71_1368 VDD VSS DECAPHV16
Xvdda_pad IOVDD IOVSS VDDA VSS sg13cmos5l_IOPadVdd
XFILLER_121_1182 VDD VSS DECAPHV16
XFILLER_69_1275 VDD VSS DECAPHV16
XFILLER_30_1010 VDD VSS FILLER1
XFILLER_4_929 VDD VSS DECAPHV32
XFILLER_156_1289 VDD VSS DECAPHV32
XTAP_TAPCELL_ROW_125_2_357 VDD VSS WELLTAP
XTAP_TAPCELL_ROW_50_2_48 VDD VSS WELLTAP
XFILLER_76_1257 VDD VSS DECAPHV32
XFILLER_126_1071 VDD VSS DECAPHV32
XFILLER_174_1345 VSS VDD FILLER2
XFILLER_139_1421 VDD VSS FILLER4
XFILLER_100_1244 VDD VSS DECAPHV8
XFILLER_87_1397 VDD VSS DECAPHV16
XFILLER_83_1206 VSS VDD FILLER2
XFILLER_137_993 VDD VSS DECAPHV16
XFILLER_157_1009 VDD VSS DECAPHV8
XFILLER_66_969 VDD VSS FILLER4
XFILLER_146_1414 VDD VSS DECAPHV8
XFILLER_111_1384 VDD VSS DECAPHV8
XFILLER_109_1291 VDD VSS DECAPHV8
XTAP_TAPCELL_ROW_142_2_438 VDD VSS WELLTAP
XFILLER_21_1009 VSS VDD FILLER2
XFILLER_112_1159 VSS VDD FILLER2
XFILLER_80_961 VDD VSS DECAPHV8
XFILLER_123_1211 VDD VSS DECAPHV32
XFILLER_71_1198 VDD VSS DECAPHV8
XFILLER_123_1299 VSS VDD FILLER2
XFILLER_156_1042 VDD VSS DECAPHV16
XFILLER_119_993 VDD VSS DECAPHV16
XFILLER_169_1425 VSS VDD FILLER2
XTAP_TAPCELL_ROW_107_2_264 VDD VSS WELLTAP
XFILLER_48_969 VDD VSS FILLER4
XFILLER_167_1182 VDD VSS DECAPHV16
XFILLER_163_1057 VDD VSS DECAPHV32
XFILLER_71_961 VDD VSS DECAPHV32
XFILLER_76_1010 VDD VSS DECAPHV32
XFILLER_180_1382 VDD VSS DECAPHV32
XFILLER_87_1150 VDD VSS DECAPHV32
XFILLER_174_1164 VDD VSS DECAPHV32
XFILLER_113_1413 VDD VSS DECAPHV8
XTAP_TAPCELL_ROW_72_2_92 VDD VSS WELLTAP
XFILLER_83_1025 VDD VSS DECAPHV32
XFILLER_62_961 VDD VSS DECAPHV8
XFILLER_146_1244 VDD VSS DECAPHV8
XTAP_TAPCELL_ROW_132_2_391 VDD VSS WELLTAP
XFILLER_107_1206 VSS VDD FILLER2
XFILLER_157_1384 VDD VSS DECAPHV8
XTAP_TAPCELL_ROW_81_2_136 VDD VSS WELLTAP
XFILLER_99_1021 VDD VSS FILLER1
XFILLER_53_961 VDD VSS DECAPHV32
XFILLER_67_1009 VDD VSS DECAPHV8
XFILLER_171_1304 VDD VSS DECAPHV32
XFILLER_158_1159 VSS VDD FILLER2
XTAP_TAPCELL_ROW_141_2_437 VDD VSS WELLTAP
XFILLER_84_1345 VSS VDD FILLER2
XFILLER_169_1299 VSS VDD FILLER2
XFILLER_169_1211 VDD VSS DECAPHV32
XFILLER_44_961 VDD VSS DECAPHV8
XFILLER_102_1103 VDD VSS DECAPHV32
XFILLER_113_1243 VDD VSS DECAPHV32
XFILLER_35_961 VDD VSS DECAPHV32
XFILLER_159_1413 VDD VSS DECAPHV8
XFILLER_124_1350 VDD VSS DECAPHV32
XFILLER_107_1025 VDD VSS DECAPHV32
XIO_CORNER_SOUTH_EAST_INST IOVDD IOVSS VDDA VSS sg13cmos5l_Corner
XFILLER_153_1089 VDD VSS DECAPHV16
XFILLER_79_1425 VSS VDD FILLER2
XFILLER_164_1196 VDD VSS DECAPHV32
XFILLER_90_1382 VDD VSS DECAPHV32
XFILLER_77_1182 VDD VSS DECAPHV16
XFILLER_26_961 VDD VSS DECAPHV8
XFILLER_73_1057 VDD VSS DECAPHV32
XTAP_TAPCELL_ROW_123_2_344 VDD VSS WELLTAP
XFILLER_84_1164 VDD VSS DECAPHV32
XFILLER_110_969 VDD VSS FILLER4
XFILLER_91_1113 VSS VDD FILLER2
XFILLER_1_1275 VDD VSS DECAPHV16
XFILLER_17_961 VDD VSS DECAPHV32
XFILLER_108_1345 VSS VDD FILLER2
XFILLER_154_1321 VDD VSS DECAPHV16
XFILLER_148_1103 VDD VSS DECAPHV32
XFILLER_161_1336 VDD VSS DECAPHV32
XFILLER_159_1243 VDD VSS DECAPHV32
XFILLER_155_1118 VDD VSS DECAPHV32
XFILLER_68_1159 VSS VDD FILLER2
XFILLER_120_1066 VSS VDD FILLER2
XFILLER_133_1427 VDD VSS FILLER1
XFILLER_81_1304 VDD VSS DECAPHV32
XFILLER_92_1422 VDD VSS FILLER4
XFILLER_79_1299 VSS VDD FILLER2
XFILLER_79_1211 VDD VSS DECAPHV32
XTAP_TAPCELL_ROW_0_2_646 VDD VSS WELLTAP
XTAP_TAPCELL_ROW_126_2_359 VDD VSS WELLTAP
XFILLER_103_1275 VDD VSS DECAPHV16
XFILLER_114_1382 VDD VSS DECAPHV32
XFILLER_110_1257 VDD VSS DECAPHV32
XTAP_TAPCELL_ROW_91_2_185 VDD VSS WELLTAP
XTAP_TAPCELL_ROW_69_2_75 VDD VSS WELLTAP
XFILLER_3_1304 VDD VSS DECAPHV32
XFILLER_96_978 VDD VSS DECAPHV32
XFILLER_108_1164 VDD VSS DECAPHV32
XFILLER_121_1397 VDD VSS DECAPHV16
XFILLER_69_1413 VDD VSS DECAPHV8
XFILLER_20_978 VDD VSS DECAPHV32
XFILLER_154_1151 VDD VSS DECAPHV8
XTAP_TAPCELL_ROW_151_2_486 VDD VSS WELLTAP
XFILLER_115_1113 VSS VDD FILLER2
XFILLER_165_1291 VDD VSS DECAPHV8
XFILLER_74_1196 VDD VSS DECAPHV32
XFILLER_100_1426 VSS VDD FILLER2
XFILLER_78_978 VDD VSS DECAPHV32
XFILLER_105_1304 VDD VSS DECAPHV32
XFILLER_92_1252 VSS VDD FILLER2
XFILLER_166_1066 VSS VDD FILLER2
XFILLER_127_1017 VDD VSS FILLER4
XFILLER_179_1427 VDD VSS FILLER1
XFILLER_140_1228 VDD VSS DECAPHV16
XFILLER_155_961 VDD VSS DECAPHV32
XFILLER_138_1135 VDD VSS DECAPHV16
XFILLER_116_1422 VDD VSS FILLER4
XTAP_TAPCELL_ROW_36_2_41 VDD VSS WELLTAP
XFILLER_151_1368 VDD VSS DECAPHV16
XFILLER_149_1275 VDD VSS DECAPHV16
XFILLER_110_1010 VDD VSS DECAPHV32
XFILLER_71_1336 VDD VSS DECAPHV32
XFILLER_156_1257 VDD VSS DECAPHV32
XFILLER_121_1150 VDD VSS DECAPHV32
XFILLER_69_1243 VDD VSS DECAPHV32
XFILLER_146_961 VDD VSS DECAPHV8
XTAP_TAPCELL_ROW_133_2_393 VDD VSS WELLTAP
XFILLER_167_1397 VDD VSS DECAPHV16
XFILLER_163_1206 VSS VDD FILLER2
XFILLER_128_1337 VDD VSS DECAPHV8
XTAP_TAPCELL_ROW_82_2_138 VDD VSS WELLTAP
XFILLER_90_929 VDD VSS DECAPHV32
XTAP_TAPCELL_ROW_104_2_250 VDD VSS WELLTAP
XFILLER_137_961 VDD VSS DECAPHV32
XFILLER_100_1289 VDD VSS DECAPHV32
XFILLER_133_1021 VDD VSS FILLER1
XFILLER_81_929 VDD VSS DECAPHV32
XTAP_TAPCELL_ROW_66_2_56 VDD VSS WELLTAP
XFILLER_146_1426 VSS VDD FILLER2
XTAP_TAPCELL_ROW_142_2_439 VDD VSS WELLTAP
Xdo_q_pad dsm2/do_q IOVDD IOVSS do_q_PAD VDDA VSS sg13cmos5l_IOPadOut4mA
XFILLER_92_1071 VDD VSS DECAPHV32
XFILLER_140_1058 VDD VSS DECAPHV8
XFILLER_101_1009 VDD VSS DECAPHV8
XFILLER_128_961 VDD VSS DECAPHV8
XFILLER_151_1198 VDD VSS DECAPHV8
XFILLER_116_1252 VSS VDD FILLER2
XFILLER_72_929 VDD VSS DECAPHV32
XFILLER_80_973 VSS VDD FILLER2
XFILLER_127_1392 VSS VDD FILLER2
XFILLER_75_1291 VDD VSS DECAPHV8
XFILLER_119_961 VDD VSS DECAPHV32
XTAP_TAPCELL_ROW_107_2_265 VDD VSS WELLTAP
XFILLER_156_1010 VDD VSS DECAPHV32
XFILLER_63_929 VDD VSS DECAPHV32
XFILLER_0_977 VDD VSS DECAPHV32
XFILLER_167_1150 VDD VSS DECAPHV32
XFILLER_76_1066 VSS VDD FILLER2
XFILLER_163_1025 VDD VSS DECAPHV32
XFILLER_89_1427 VDD VSS FILLER1
XFILLER_100_1042 VDD VSS DECAPHV16
XFILLER_135_1105 VDD VSS DECAPHV8
XFILLER_113_1425 VSS VDD FILLER2
XFILLER_140_978 VDD VSS DECAPHV32
XFILLER_111_1182 VDD VSS DECAPHV16
XFILLER_54_929 VDD VSS DECAPHV32
XFILLER_20_1010 VDD VSS FILLER1
XFILLER_62_973 VSS VDD FILLER2
XFILLER_146_1289 VDD VSS DECAPHV32
XTAP_TAPCELL_ROW_132_2_392 VDD VSS WELLTAP
XFILLER_179_1021 VDD VSS FILLER1
XTAP_TAPCELL_ROW_81_2_137 VDD VSS WELLTAP
XFILLER_45_929 VDD VSS DECAPHV32
Xg_iovss_pads\[0\].iovss_pad IOVDD IOVSS VDD VSS sg13cmos5l_IOPadIOVss
XIO_CORNER_NORTH_WEST_INST IOVDD IOVSS VDD VSS sg13cmos5l_Corner
XFILLER_116_1071 VDD VSS DECAPHV32
XFILLER_164_1345 VSS VDD FILLER2
XFILLER_129_1421 VDD VSS FILLER4
XFILLER_77_1397 VDD VSS DECAPHV16
XFILLER_73_1206 VSS VDD FILLER2
XFILLER_147_1009 VDD VSS DECAPHV8
XFILLER_101_1384 VDD VSS DECAPHV8
XFILLER_136_1414 VDD VSS DECAPHV8
XFILLER_122_978 VDD VSS DECAPHV32
XFILLER_1_1413 VDD VSS DECAPHV8
XFILLER_44_973 VSS VDD FILLER2
XFILLER_36_929 VDD VSS DECAPHV32
XTAP_TAPCELL_ROW_120_2_330 VDD VSS WELLTAP
XFILLER_11_1009 VSS VDD FILLER2
XFILLER_102_1159 VSS VDD FILLER2
XFILLER_113_1299 VSS VDD FILLER2
XFILLER_113_1211 VDD VSS DECAPHV32
XFILLER_96_1228 VDD VSS DECAPHV16
XFILLER_27_929 VDD VSS DECAPHV32
XFILLER_146_1042 VDD VSS DECAPHV16
XFILLER_159_1425 VSS VDD FILLER2
XFILLER_66_1010 VDD VSS FILLER1
XTAP_TAPCELL_ROW_178_2_620 VDD VSS WELLTAP
XFILLER_157_1182 VDD VSS DECAPHV16
XFILLER_153_1057 VDD VSS DECAPHV32
XFILLER_104_978 VDD VSS DECAPHV32
XFILLER_170_1382 VDD VSS DECAPHV32
XFILLER_77_1150 VDD VSS DECAPHV32
XFILLER_26_973 VSS VDD FILLER2
XFILLER_18_929 VDD VSS DECAPHV32
XFILLER_164_1164 VDD VSS DECAPHV32
XFILLER_103_1413 VDD VSS DECAPHV8
XFILLER_90_1350 VDD VSS DECAPHV32
XFILLER_73_1025 VDD VSS DECAPHV32
XTAP_TAPCELL_ROW_152_2_488 VDD VSS WELLTAP
XFILLER_171_1113 VSS VDD FILLER2
XFILLER_136_1244 VDD VSS DECAPHV8
XTAP_TAPCELL_ROW_123_2_345 VDD VSS WELLTAP
XFILLER_147_1384 VDD VSS DECAPHV8
XFILLER_1_1243 VDD VSS DECAPHV32
XFILLER_89_1021 VDD VSS FILLER1
XFILLER_57_1009 VSS VDD FILLER2
XFILLER_96_1058 VDD VSS DECAPHV8
XFILLER_161_1304 VDD VSS DECAPHV32
XFILLER_148_1159 VSS VDD FILLER2
XFILLER_74_1345 VSS VDD FILLER2
XFILLER_172_1422 VDD VSS FILLER4
XFILLER_159_1299 VSS VDD FILLER2
XFILLER_159_1211 VDD VSS DECAPHV32
XTAP_TAPCELL_ROW_0_2_647 VDD VSS WELLTAP
XFILLER_103_1243 VDD VSS DECAPHV32
XFILLER_167_981 VDD VSS DECAPHV32
XTAP_TAPCELL_ROW_91_2_186 VDD VSS WELLTAP
XFILLER_149_1413 VDD VSS DECAPHV8
XFILLER_114_1350 VDD VSS DECAPHV32
XTAP_TAPCELL_ROW_69_2_76 VDD VSS WELLTAP
XIO_FILL_IO_NORTH_5_0 IOVDD IOVSS VDD VSS sg13cmos5l_Filler4000
XFILLER_143_1089 VDD VSS DECAPHV16
XFILLER_69_1425 VSS VDD FILLER2
XFILLER_173_995 VDD VSS DECAPHV16
XFILLER_154_1196 VDD VSS DECAPHV32
XTAP_TAPCELL_ROW_151_2_487 VDD VSS WELLTAP
XFILLER_80_1382 VDD VSS DECAPHV32
XFILLER_74_1164 VDD VSS DECAPHV32
XFILLER_156_929 VDD VSS DECAPHV32
XFILLER_172_1252 VSS VDD FILLER2
XFILLER_81_1113 VSS VDD FILLER2
XFILLER_144_1321 VDD VSS DECAPHV16
XFILLER_2_1382 VDD VSS DECAPHV32
XFILLER_147_929 VDD VSS DECAPHV32
XFILLER_138_1103 VDD VSS DECAPHV32
XFILLER_6_961 VDD VSS DECAPHV8
XFILLER_151_1336 VDD VSS DECAPHV32
XFILLER_149_1243 VDD VSS DECAPHV32
XFILLER_145_1118 VDD VSS DECAPHV32
XFILLER_3_1113 VSS VDD FILLER2
XFILLER_180_1009 VDD VSS DECAPHV8
XFILLER_93_1017 VDD VSS FILLER4
XFILLER_110_1066 VSS VDD FILLER2
XFILLER_123_1427 VDD VSS FILLER1
XFILLER_71_1304 VDD VSS DECAPHV32
XFILLER_69_1211 VDD VSS DECAPHV32
XFILLER_138_929 VDD VSS DECAPHV32
XFILLER_82_1422 VDD VSS FILLER4
XFILLER_69_1299 VSS VDD FILLER2
XFILLER_146_973 VSS VDD FILLER2
XTAP_TAPCELL_ROW_133_2_394 VDD VSS WELLTAP
XFILLER_83_993 VDD VSS DECAPHV16
XTAP_TAPCELL_ROW_82_2_139 VDD VSS WELLTAP
XFILLER_104_1382 VDD VSS DECAPHV32
XTAP_TAPCELL_ROW_104_2_251 VDD VSS WELLTAP
XFILLER_100_1257 VDD VSS DECAPHV32
XFILLER_129_929 VDD VSS DECAPHV32
XFILLER_172_1071 VDD VSS DECAPHV32
Xg_iovdd_pads\[0\].iovdd_pad IOVDD IOVSS VDD VSS sg13cmos5l_IOPadIOVdd
XFILLER_111_1397 VDD VSS DECAPHV16
XFILLER_94_1337 VDD VSS DECAPHV8
XFILLER_4_1422 VSS VDD FILLER2
XFILLER_144_1151 VDD VSS DECAPHV8
XFILLER_105_1113 VSS VDD FILLER2
XFILLER_128_973 VSS VDD FILLER2
XFILLER_155_1291 VDD VSS DECAPHV8
XFILLER_65_993 VDD VSS DECAPHV16
XTAP_TAPCELL_ROW_107_2_266 VDD VSS WELLTAP
XFILLER_82_1252 VSS VDD FILLER2
XFILLER_156_1066 VSS VDD FILLER2
XFILLER_117_1017 VDD VSS FILLER4
XFILLER_169_1427 VDD VSS FILLER1
XFILLER_130_1228 VDD VSS DECAPHV16
XFILLER_141_1368 VDD VSS DECAPHV16
XFILLER_128_1135 VDD VSS DECAPHV16
XFILLER_106_1422 VDD VSS FILLER4
XFILLER_93_1392 VSS VDD FILLER2
XIO_BOND_vi_pad analog_PAD[0] sg13cmos5l_ip__bondpad_70x70
XFILLER_139_1275 VDD VSS DECAPHV16
XFILLER_100_1010 VDD VSS DECAPHV32
XFILLER_146_1257 VDD VSS DECAPHV32
XFILLER_111_1150 VDD VSS DECAPHV32
XFILLER_47_993 VDD VSS DECAPHV16
XFILLER_157_1397 VDD VSS DECAPHV16
XFILLER_153_1206 VSS VDD FILLER2
XFILLER_118_1337 VDD VSS DECAPHV8
XFILLER_99_1089 VDD VSS DECAPHV16
XTAP_TAPCELL_ROW_2_2_5 VDD VSS WELLTAP
XFILLER_123_1021 VDD VSS FILLER1
XFILLER_136_1426 VSS VDD FILLER2
XFILLER_82_1071 VDD VSS DECAPHV32
XFILLER_95_1421 VDD VSS FILLER4
XFILLER_1_1425 VSS VDD FILLER2
XFILLER_29_993 VDD VSS DECAPHV16
XFILLER_130_1058 VDD VSS DECAPHV8
XFILLER_141_1198 VDD VSS DECAPHV8
XTAP_TAPCELL_ROW_120_2_331 VDD VSS WELLTAP
XFILLER_106_1252 VSS VDD FILLER2
XFILLER_176_1228 VDD VSS DECAPHV16
XFILLER_117_1392 VSS VDD FILLER2
XTAP_TAPCELL_ROW_92_2_188 VDD VSS WELLTAP
XFILLER_146_1010 VDD VSS DECAPHV32
XFILLER_157_1150 VDD VSS DECAPHV32
XTAP_TAPCELL_ROW_178_2_621 VDD VSS WELLTAP
XFILLER_170_1350 VDD VSS DECAPHV32
XFILLER_153_1025 VDD VSS DECAPHV32
XFILLER_125_1105 VDD VSS DECAPHV8
XFILLER_79_1427 VDD VSS FILLER1
XTAP_TAPCELL_ROW_152_2_489 VDD VSS WELLTAP
XFILLER_103_1425 VSS VDD FILLER2
XTAP_TAPCELL_ROW_123_2_346 VDD VSS WELLTAP
XFILLER_101_1182 VDD VSS DECAPHV16
XFILLER_10_1010 VDD VSS FILLER1
XFILLER_136_1289 VDD VSS DECAPHV32
XFILLER_1_1211 VDD VSS DECAPHV32
XFILLER_169_1021 VDD VSS FILLER1
XFILLER_1_1299 VSS VDD FILLER2
XFILLER_176_1058 VDD VSS DECAPHV8
XFILLER_106_1071 VDD VSS DECAPHV32
XFILLER_137_1009 VDD VSS DECAPHV8
XFILLER_154_1345 VSS VDD FILLER2
XFILLER_119_1421 VDD VSS FILLER4
XFILLER_126_1414 VDD VSS DECAPHV8
XIO_FILL_IO_NORTH_2_20 IOVDD IOVSS VDD VSS sg13cmos5l_Filler400
XFILLER_176_971 VDD VSS FILLER4
XTAP_TAPCELL_ROW_0_2_648 VDD VSS WELLTAP
Xjku_logo sg13cmos5l_ip__jku
XFILLER_103_1299 VSS VDD FILLER2
XFILLER_103_1211 VDD VSS DECAPHV32
XFILLER_86_1228 VDD VSS DECAPHV16
XTAP_TAPCELL_ROW_91_2_187 VDD VSS WELLTAP
XFILLER_96_969 VDD VSS FILLER4
XTAP_TAPCELL_ROW_105_2_253 VDD VSS WELLTAP
XFILLER_136_1042 VDD VSS DECAPHV16
XFILLER_149_1425 VSS VDD FILLER2
XFILLER_97_1368 VDD VSS DECAPHV16
XTAP_TAPCELL_ROW_69_2_77 VDD VSS WELLTAP
XFILLER_56_1010 VDD VSS FILLER1
XFILLER_160_1382 VDD VSS DECAPHV32
XFILLER_147_1182 VDD VSS DECAPHV16
XFILLER_143_1057 VDD VSS DECAPHV32
XFILLER_20_969 VDD VSS FILLER4
XFILLER_173_963 VDD VSS DECAPHV32
XFILLER_154_1164 VDD VSS DECAPHV32
XFILLER_80_1350 VDD VSS DECAPHV32
XFILLER_161_1113 VSS VDD FILLER2
XFILLER_126_1244 VDD VSS DECAPHV8
XTAP_TAPCELL_ROW_130_2_380 VDD VSS WELLTAP
XFILLER_7_929 VDD VSS DECAPHV32
XFILLER_164_963 VDD VSS DECAPHV8
XFILLER_149_993 VDD VSS DECAPHV16
XFILLER_137_1384 VDD VSS DECAPHV8
XFILLER_78_969 VDD VSS FILLER4
XFILLER_2_1350 VDD VSS DECAPHV32
XFILLER_79_1021 VDD VSS FILLER1
XTAP_TAPCELL_ROW_108_2_268 VDD VSS WELLTAP
XFILLER_138_1159 VSS VDD FILLER2
XFILLER_6_973 VSS VDD FILLER2
XFILLER_47_1009 VSS VDD FILLER2
XFILLER_86_1058 VDD VSS DECAPHV8
XFILLER_151_1304 VDD VSS DECAPHV32
XFILLER_162_1422 VDD VSS FILLER4
XFILLER_149_1299 VSS VDD FILLER2
XFILLER_149_1211 VDD VSS DECAPHV32
XFILLER_97_1198 VDD VSS DECAPHV8
XFILLER_92_961 VDD VSS DECAPHV8
XTAP_TAPCELL_ROW_133_2_395 VDD VSS WELLTAP
XFILLER_83_961 VDD VSS DECAPHV32
XTAP_TAPCELL_ROW_104_2_252 VDD VSS WELLTAP
XFILLER_174_1337 VDD VSS DECAPHV8
XFILLER_139_1413 VDD VSS DECAPHV8
XFILLER_104_1350 VDD VSS DECAPHV32
XFILLER_133_1089 VDD VSS DECAPHV16
XFILLER_74_961 VDD VSS DECAPHV8
XFILLER_144_1196 VDD VSS DECAPHV32
XFILLER_70_1382 VDD VSS DECAPHV32
XFILLER_65_961 VDD VSS DECAPHV32
XTAP_TAPCELL_ROW_121_2_333 VDD VSS WELLTAP
XFILLER_162_1252 VSS VDD FILLER2
XFILLER_71_1113 VSS VDD FILLER2
XFILLER_173_1392 VSS VDD FILLER2
XFILLER_134_1321 VDD VSS DECAPHV16
XTAP_TAPCELL_ROW_107_2_267 VDD VSS WELLTAP
XFILLER_128_1103 VDD VSS DECAPHV32
XTAP_TAPCELL_ROW_179_2_623 VDD VSS WELLTAP
XFILLER_56_961 VDD VSS DECAPHV8
XFILLER_141_1336 VDD VSS DECAPHV32
XFILLER_139_1243 VDD VSS DECAPHV32
XFILLER_135_1118 VDD VSS DECAPHV32
XFILLER_83_1017 VDD VSS FILLER4
XFILLER_100_1066 VSS VDD FILLER2
XFILLER_140_969 VDD VSS FILLER4
XFILLER_113_1427 VDD VSS FILLER1
XFILLER_4_1242 VSS VDD FILLER2
XFILLER_47_961 VDD VSS DECAPHV32
XFILLER_94_1135 VDD VSS DECAPHV16
XFILLER_72_1422 VDD VSS FILLER4
XTAP_TAPCELL_ROW_124_2_348 VDD VSS WELLTAP
XFILLER_179_1089 VDD VSS DECAPHV16
XIO_FILL_IO_WEST_2_35 IOVDD IOVSS VDD VSS sg13cmos5l_Filler200
XIO_FILL_IO_NORTH_5_20 IOVDD IOVSS VDD VSS sg13cmos5l_Filler400
XFILLER_38_961 VDD VSS DECAPHV8
XTAP_TAPCELL_ROW_2_2_6 VDD VSS WELLTAP
XFILLER_99_1057 VDD VSS DECAPHV32
XFILLER_162_1071 VDD VSS DECAPHV32
XFILLER_175_1421 VDD VSS FILLER4
XFILLER_101_1397 VDD VSS DECAPHV16
XFILLER_84_1337 VDD VSS DECAPHV8
Xdelaybuf_2_clk delaybuf_2_clk/A VDD VSS delaybuf_3_clk/A BUFX12
XFILLER_134_1151 VDD VSS DECAPHV8
XFILLER_29_961 VDD VSS DECAPHV32
XFILLER_122_969 VDD VSS FILLER4
XFILLER_145_1291 VDD VSS DECAPHV8
XTAP_TAPCELL_ROW_120_2_332 VDD VSS WELLTAP
XFILLER_72_1252 VSS VDD FILLER2
XFILLER_146_1066 VSS VDD FILLER2
XFILLER_50_978 VDD VSS DECAPHV32
XTAP_TAPCELL_ROW_92_2_189 VDD VSS WELLTAP
XFILLER_107_1017 VDD VSS FILLER4
XTAP_TAPCELL_ROW_178_2_622 VDD VSS WELLTAP
XFILLER_159_1427 VDD VSS FILLER1
XFILLER_120_1228 VDD VSS DECAPHV16
XFILLER_118_1135 VDD VSS DECAPHV16
XFILLER_131_1368 VDD VSS DECAPHV16
XFILLER_83_1392 VSS VDD FILLER2
XFILLER_104_969 VDD VSS FILLER4
XFILLER_129_1275 VDD VSS DECAPHV16
XFILLER_101_1150 VDD VSS DECAPHV32
XFILLER_136_1257 VDD VSS DECAPHV32
XTAP_TAPCELL_ROW_123_2_347 VDD VSS WELLTAP
XTAP_TAPCELL_ROW_30_2_38 VDD VSS WELLTAP
XFILLER_169_1011 VDD VSS DECAPHV8
XFILLER_147_1397 VDD VSS DECAPHV16
XFILLER_143_1206 VSS VDD FILLER2
XFILLER_108_1337 VDD VSS DECAPHV8
XFILLER_91_1105 VDD VSS DECAPHV8
XFILLER_32_978 VDD VSS DECAPHV32
XFILLER_89_1089 VDD VSS DECAPHV16
XFILLER_67_1332 VSS VDD FILLER2
XIO_FILL_IO_EAST_5_0 IOVDD IOVSS VDDA VSS sg13cmos5l_Filler4000
XFILLER_113_1021 VDD VSS FILLER1
XFILLER_126_1426 VSS VDD FILLER2
XTAP_TAPCELL_ROW_140_2_428 VDD VSS WELLTAP
XFILLER_72_1071 VDD VSS DECAPHV32
XFILLER_120_1058 VDD VSS DECAPHV8
XFILLER_168_939 VDD VSS FILLER4
XFILLER_85_1421 VDD VSS FILLER4
XFILLER_166_1228 VDD VSS DECAPHV16
XFILLER_131_1198 VDD VSS DECAPHV8
XTAP_TAPCELL_ROW_0_2_649 VDD VSS WELLTAP
XFILLER_100_961 VDD VSS DECAPHV8
XFILLER_92_1414 VDD VSS DECAPHV8
XFILLER_14_978 VDD VSS DECAPHV32
XFILLER_177_1368 VDD VSS DECAPHV16
XFILLER_107_1392 VSS VDD FILLER2
XTAP_TAPCELL_ROW_105_2_254 VDD VSS WELLTAP
XFILLER_136_1010 VDD VSS DECAPHV32
XFILLER_147_1150 VDD VSS DECAPHV32
XFILLER_97_1336 VDD VSS DECAPHV32
XFILLER_160_1350 VDD VSS DECAPHV32
XFILLER_69_1427 VDD VSS FILLER1
XFILLER_9_993 VDD VSS DECAPHV16
XFILLER_173_931 VDD VSS DECAPHV32
XFILLER_158_961 VDD VSS DECAPHV8
XFILLER_143_1025 VDD VSS DECAPHV32
XFILLER_115_1105 VDD VSS DECAPHV8
XFILLER_126_1289 VDD VSS DECAPHV32
XTAP_TAPCELL_ROW_130_2_381 VDD VSS WELLTAP
XFILLER_164_931 VDD VSS DECAPHV32
XFILLER_149_961 VDD VSS DECAPHV32
XFILLER_159_1021 VDD VSS FILLER1
XFILLER_93_929 VDD VSS DECAPHV32
XFILLER_109_1421 VDD VSS FILLER4
XFILLER_166_1058 VDD VSS DECAPHV8
XFILLER_127_1009 VDD VSS DECAPHV8
XFILLER_144_1345 VSS VDD FILLER2
XFILLER_92_1244 VDD VSS DECAPHV8
XTAP_TAPCELL_ROW_108_2_269 VDD VSS WELLTAP
XFILLER_177_1198 VDD VSS DECAPHV8
XFILLER_116_1414 VDD VSS DECAPHV8
XFILLER_170_978 VDD VSS DECAPHV32
XFILLER_84_929 VDD VSS DECAPHV32
XIO_FILL_IO_WEST_5_35 IOVDD IOVSS VDD VSS sg13cmos5l_Filler400
XFILLER_92_973 VSS VDD FILLER2
XTAP_TAPCELL_ROW_133_2_396 VDD VSS WELLTAP
XFILLER_75_929 VDD VSS DECAPHV32
XFILLER_76_1228 VDD VSS DECAPHV16
XFILLER_126_1042 VDD VSS DECAPHV16
XFILLER_139_1425 VSS VDD FILLER2
XFILLER_87_1368 VDD VSS DECAPHV16
XFILLER_46_1010 VDD VSS FILLER1
XFILLER_152_978 VDD VSS DECAPHV32
XFILLER_150_1382 VDD VSS DECAPHV32
XFILLER_137_1182 VDD VSS DECAPHV16
XFILLER_66_929 VDD VSS DECAPHV32
XFILLER_133_1057 VDD VSS DECAPHV32
XIO_BOND_g_vss_pads\[1\].vss_pad VSS sg13cmos5l_ip__bondpad_70x70
XFILLER_74_973 VSS VDD FILLER2
XFILLER_144_1164 VDD VSS DECAPHV32
XFILLER_70_1350 VDD VSS DECAPHV32
XFILLER_151_1113 VSS VDD FILLER2
XTAP_TAPCELL_ROW_121_2_334 VDD VSS WELLTAP
XFILLER_116_1244 VDD VSS DECAPHV8
XFILLER_99_1206 VSS VDD FILLER2
XFILLER_57_929 VDD VSS DECAPHV32
XFILLER_127_1384 VDD VSS DECAPHV8
XFILLER_69_1021 VDD VSS FILLER1
XFILLER_134_978 VDD VSS DECAPHV32
XFILLER_48_929 VDD VSS DECAPHV32
XFILLER_0_969 VDD VSS FILLER4
XTAP_TAPCELL_ROW_179_2_624 VDD VSS WELLTAP
XFILLER_128_1159 VSS VDD FILLER2
XFILLER_37_1009 VSS VDD FILLER2
XFILLER_56_973 VSS VDD FILLER2
XFILLER_76_1058 VDD VSS DECAPHV8
XFILLER_163_1017 VDD VSS FILLER4
XFILLER_141_1304 VDD VSS DECAPHV32
XFILLER_174_1135 VDD VSS DECAPHV16
XFILLER_152_1422 VDD VSS FILLER4
XFILLER_139_1299 VSS VDD FILLER2
XFILLER_139_1211 VDD VSS DECAPHV32
XFILLER_87_1198 VDD VSS DECAPHV8
XFILLER_94_1103 VDD VSS DECAPHV32
XFILLER_4_1287 VSS VDD FILLER2
XFILLER_0_1107 VSS VDD FILLER2
XFILLER_39_929 VDD VSS DECAPHV32
XTAP_TAPCELL_ROW_124_2_349 VDD VSS WELLTAP
XIO_FILL_IO_SOUTH_6_0 IOVDD IOVSS VDDA VSS sg13cmos5l_Filler4000
XFILLER_179_1057 VDD VSS DECAPHV32
XFILLER_116_978 VDD VSS DECAPHV32
XTAP_TAPCELL_ROW_2_2_7 VDD VSS WELLTAP
XFILLER_99_1025 VDD VSS DECAPHV32
XFILLER_164_1337 VDD VSS DECAPHV8
XFILLER_129_1413 VDD VSS DECAPHV8
XFILLER_38_973 VSS VDD FILLER2
XFILLER_123_1089 VDD VSS DECAPHV16
XFILLER_134_1196 VDD VSS DECAPHV32
XFILLER_1_1427 VDD VSS FILLER1
XIO_CORNER_SOUTH_WEST_INST IOVDD IOVSS VDD VSS sg13cmos5l_Corner
XFILLER_152_1252 VSS VDD FILLER2
XFILLER_4_1062 VSS VDD FILLER2
XFILLER_163_1392 VSS VDD FILLER2
XFILLER_124_1321 VDD VSS DECAPHV16
XFILLER_118_1103 VDD VSS DECAPHV32
XTAP_TAPCELL_ROW_16_2_31 VDD VSS WELLTAP
XFILLER_131_1336 VDD VSS DECAPHV32
XFILLER_129_1243 VDD VSS DECAPHV32
XFILLER_125_1118 VDD VSS DECAPHV32
XFILLER_73_1017 VDD VSS FILLER4
XFILLER_103_1427 VDD VSS FILLER1
XFILLER_171_1105 VDD VSS DECAPHV8
XFILLER_84_1135 VDD VSS DECAPHV16
XFILLER_110_929 VDD VSS DECAPHV32
XTAP_TAPCELL_ROW_131_2_383 VDD VSS WELLTAP
XFILLER_169_1089 VDD VSS DECAPHV16
XFILLER_95_1275 VDD VSS DECAPHV16
XTAP_TAPCELL_ROW_102_2_240 VDD VSS WELLTAP
XTAP_TAPCELL_ROW_80_2_128 VDD VSS WELLTAP
XFILLER_67_1377 VSS VDD FILLER2
XFILLER_89_1057 VDD VSS DECAPHV32
XFILLER_152_1071 VDD VSS DECAPHV32
XFILLER_101_929 VDD VSS DECAPHV32
XFILLER_165_1421 VDD VSS FILLER4
XFILLER_74_1337 VDD VSS DECAPHV8
XTAP_TAPCELL_ROW_140_2_429 VDD VSS WELLTAP
XTAP_TAPCELL_ROW_46_2_46 VDD VSS WELLTAP
XIO_FILL_IO_NORTH_2_22 IOVDD IOVSS VDD VSS sg13cmos5l_Filler400
XFILLER_124_1151 VDD VSS DECAPHV8
XFILLER_172_1414 VDD VSS DECAPHV8
XFILLER_135_1291 VDD VSS DECAPHV8
XFILLER_92_1426 VSS VDD FILLER2
XTAP_TAPCELL_ROW_0_2_639 VDD VSS WELLTAP
XFILLER_100_973 VSS VDD FILLER2
XTAP_TAPCELL_ROW_134_2_398 VDD VSS WELLTAP
XFILLER_159_929 VDD VSS DECAPHV32
XFILLER_177_1336 VDD VSS DECAPHV32
XFILLER_110_1228 VDD VSS DECAPHV16
XTAP_TAPCELL_ROW_105_2_255 VDD VSS WELLTAP
XFILLER_97_1304 VDD VSS DECAPHV32
XFILLER_136_1066 VSS VDD FILLER2
XFILLER_149_1427 VDD VSS FILLER1
XFILLER_108_1135 VDD VSS DECAPHV16
XFILLER_1_1021 VDD VSS FILLER1
XFILLER_121_1368 VDD VSS DECAPHV16
XFILLER_73_1392 VSS VDD FILLER2
XFILLER_9_961 VDD VSS DECAPHV32
XFILLER_158_973 VSS VDD FILLER2
XFILLER_119_1275 VDD VSS DECAPHV16
XFILLER_67_1152 VSS VDD FILLER2
XFILLER_95_993 VDD VSS DECAPHV16
XTAP_TAPCELL_ROW_130_2_382 VDD VSS WELLTAP
XFILLER_126_1257 VDD VSS DECAPHV32
XFILLER_81_1105 VDD VSS DECAPHV8
XFILLER_172_1244 VDD VSS DECAPHV8
XFILLER_137_1397 VDD VSS DECAPHV16
XFILLER_133_1206 VSS VDD FILLER2
XFILLER_79_1089 VDD VSS DECAPHV16
XFILLER_92_1289 VDD VSS DECAPHV32
XFILLER_103_1021 VDD VSS FILLER1
XFILLER_116_1426 VSS VDD FILLER2
XFILLER_173_1019 VSS VDD FILLER2
XFILLER_3_1105 VDD VSS DECAPHV8
XFILLER_77_993 VDD VSS DECAPHV16
XFILLER_93_1009 VDD VSS DECAPHV8
XFILLER_110_1058 VDD VSS DECAPHV8
XFILLER_75_1421 VDD VSS FILLER4
XIO_FILL_IO_NORTH_3_0 IOVDD IOVSS VDD VSS sg13cmos5l_Filler4000
XFILLER_156_1228 VDD VSS DECAPHV16
XFILLER_121_1198 VDD VSS DECAPHV8
XTAP_TAPCELL_ROW_133_2_397 VDD VSS WELLTAP
XFILLER_82_1414 VDD VSS DECAPHV8
XFILLER_167_1368 VDD VSS DECAPHV16
XFILLER_126_1010 VDD VSS DECAPHV32
XTAP_TAPCELL_ROW_176_2_610 VDD VSS WELLTAP
XFILLER_137_1150 VDD VSS DECAPHV32
XFILLER_87_1336 VDD VSS DECAPHV32
XFILLER_150_1350 VDD VSS DECAPHV32
XFILLER_4_1414 VDD VSS DECAPHV8
XFILLER_59_993 VDD VSS DECAPHV16
XFILLER_133_1025 VDD VSS DECAPHV32
XFILLER_105_1105 VDD VSS DECAPHV8
XFILLER_92_1042 VDD VSS DECAPHV16
XTAP_TAPCELL_ROW_150_2_478 VDD VSS WELLTAP
XFILLER_179_1206 VSS VDD FILLER2
XTAP_TAPCELL_ROW_121_2_335 VDD VSS WELLTAP
XFILLER_116_1289 VDD VSS DECAPHV32
XFILLER_149_1021 VDD VSS FILLER1
XFILLER_82_1244 VDD VSS DECAPHV8
XFILLER_156_1058 VDD VSS DECAPHV8
XFILLER_117_1009 VDD VSS DECAPHV8
XFILLER_134_1345 VSS VDD FILLER2
XFILLER_180_1332 VSS VDD FILLER2
XTAP_TAPCELL_ROW_179_2_625 VDD VSS WELLTAP
XFILLER_167_1198 VDD VSS DECAPHV8
XFILLER_106_1414 VDD VSS DECAPHV8
XFILLER_93_1384 VDD VSS DECAPHV8
XFILLER_174_1103 VDD VSS DECAPHV32
XFILLER_94_1159 VSS VDD FILLER2
XFILLER_179_1025 VDD VSS DECAPHV32
XTAP_TAPCELL_ROW_2_2_8 VDD VSS WELLTAP
XFILLER_116_1042 VDD VSS DECAPHV16
XIO_FILL_IO_NORTH_5_22 IOVDD IOVSS VDD VSS sg13cmos5l_Filler400
XFILLER_129_1425 VSS VDD FILLER2
XFILLER_77_1368 VDD VSS DECAPHV16
XFILLER_36_1010 VDD VSS FILLER1
XFILLER_140_1382 VDD VSS DECAPHV32
XFILLER_127_1182 VDD VSS DECAPHV16
XFILLER_123_1057 VDD VSS DECAPHV32
XFILLER_134_1164 VDD VSS DECAPHV32
XFILLER_95_1413 VDD VSS DECAPHV8
XFILLER_141_1113 VSS VDD FILLER2
XFILLER_106_1244 VDD VSS DECAPHV8
XFILLER_89_1206 VSS VDD FILLER2
XFILLER_117_1384 VDD VSS DECAPHV8
XFILLER_121_993 VDD VSS DECAPHV16
XFILLER_50_969 VDD VSS FILLER4
XFILLER_131_1304 VDD VSS DECAPHV32
XFILLER_118_1159 VSS VDD FILLER2
XFILLER_27_1009 VSS VDD FILLER2
XFILLER_153_1017 VDD VSS FILLER4
XFILLER_129_1211 VDD VSS DECAPHV32
XFILLER_164_1135 VDD VSS DECAPHV16
XFILLER_142_1422 VDD VSS FILLER4
XFILLER_129_1299 VSS VDD FILLER2
XFILLER_90_1321 VDD VSS DECAPHV16
XFILLER_77_1198 VDD VSS DECAPHV8
XFILLER_84_1103 VDD VSS DECAPHV32
XFILLER_175_1275 VDD VSS DECAPHV16
XTAP_TAPCELL_ROW_131_2_384 VDD VSS WELLTAP
XFILLER_103_993 VDD VSS DECAPHV16
XFILLER_95_1243 VDD VSS DECAPHV32
XFILLER_91_1118 VDD VSS DECAPHV32
XFILLER_169_1057 VDD VSS DECAPHV32
XTAP_TAPCELL_ROW_102_2_241 VDD VSS WELLTAP
XTAP_TAPCELL_ROW_80_2_129 VDD VSS WELLTAP
XFILLER_89_1025 VDD VSS DECAPHV32
XFILLER_154_1337 VDD VSS DECAPHV8
XFILLER_119_1413 VDD VSS DECAPHV8
XFILLER_113_1089 VDD VSS DECAPHV16
XFILLER_124_1196 VDD VSS DECAPHV32
XFILLER_176_963 VDD VSS DECAPHV8
XFILLER_172_1426 VSS VDD FILLER2
XFILLER_177_1304 VDD VSS DECAPHV32
XFILLER_142_1252 VSS VDD FILLER2
XFILLER_90_1151 VDD VSS DECAPHV8
XFILLER_14_969 VDD VSS FILLER4
XTAP_TAPCELL_ROW_134_2_399 VDD VSS WELLTAP
XFILLER_153_1392 VSS VDD FILLER2
XFILLER_114_1321 VDD VSS DECAPHV16
XTAP_TAPCELL_ROW_105_2_256 VDD VSS WELLTAP
XFILLER_108_1103 VDD VSS DECAPHV32
XFILLER_121_1336 VDD VSS DECAPHV32
XFILLER_119_1243 VDD VSS DECAPHV32
XFILLER_115_1118 VDD VSS DECAPHV32
XFILLER_67_1197 VSS VDD FILLER2
XFILLER_95_961 VDD VSS DECAPHV32
XFILLER_74_1135 VDD VSS DECAPHV16
XFILLER_161_1105 VDD VSS DECAPHV8
XFILLER_159_1089 VDD VSS DECAPHV16
XFILLER_85_1275 VDD VSS DECAPHV16
XFILLER_172_1289 VDD VSS DECAPHV32
XFILLER_79_1057 VDD VSS DECAPHV32
XFILLER_86_961 VDD VSS DECAPHV8
XFILLER_96_1382 VDD VSS DECAPHV32
XFILLER_92_1257 VDD VSS DECAPHV32
XFILLER_142_1071 VDD VSS DECAPHV32
XFILLER_10_961 VDD VSS DECAPHV8
XFILLER_155_1421 VDD VSS FILLER4
XFILLER_77_961 VDD VSS DECAPHV32
XFILLER_170_969 VDD VSS FILLER4
XFILLER_114_1151 VDD VSS DECAPHV8
XFILLER_97_1113 VSS VDD FILLER2
XIO_FILL_IO_WEST_5_37 IOVDD IOVSS VDD VSS sg13cmos5l_Filler200
XFILLER_162_1414 VDD VSS DECAPHV8
XFILLER_125_1291 VDD VSS DECAPHV8
XFILLER_82_1426 VSS VDD FILLER2
XFILLER_68_961 VDD VSS DECAPHV8
XFILLER_167_1336 VDD VSS DECAPHV32
XTAP_TAPCELL_ROW_112_2_290 VDD VSS WELLTAP
XFILLER_100_1228 VDD VSS DECAPHV16
XFILLER_87_1304 VDD VSS DECAPHV32
XTAP_TAPCELL_ROW_90_2_178 VDD VSS WELLTAP
XFILLER_126_1066 VSS VDD FILLER2
XTAP_TAPCELL_ROW_176_2_611 VDD VSS WELLTAP
XFILLER_139_1427 VDD VSS FILLER1
XFILLER_172_1042 VDD VSS DECAPHV16
XFILLER_3_968 VDD VSS DECAPHV32
XFILLER_152_969 VDD VSS FILLER4
XFILLER_111_1368 VDD VSS DECAPHV16
XFILLER_98_1422 VDD VSS FILLER4
XFILLER_59_961 VDD VSS DECAPHV32
XFILLER_109_1275 VDD VSS DECAPHV16
XTAP_TAPCELL_ROW_150_2_479 VDD VSS WELLTAP
XFILLER_92_1010 VDD VSS DECAPHV32
XIO_FILL_IO_WEST_5_0 IOVDD IOVSS VDD VSS sg13cmos5l_Filler4000
XTAP_TAPCELL_ROW_121_2_336 VDD VSS WELLTAP
XFILLER_116_1257 VDD VSS DECAPHV32
XFILLER_71_1105 VDD VSS DECAPHV8
XFILLER_80_978 VDD VSS DECAPHV32
XFILLER_162_1244 VDD VSS DECAPHV8
XFILLER_127_1397 VDD VSS DECAPHV16
XFILLER_123_1206 VSS VDD FILLER2
XFILLER_173_1384 VDD VSS DECAPHV8
XFILLER_82_1289 VDD VSS DECAPHV32
XFILLER_69_1089 VDD VSS DECAPHV16
XFILLER_134_969 VDD VSS FILLER4
XFILLER_180_1377 VSS VDD FILLER2
XTAP_TAPCELL_ROW_179_2_626 VDD VSS WELLTAP
XFILLER_106_1426 VSS VDD FILLER2
XFILLER_83_1009 VDD VSS DECAPHV8
XFILLER_100_1058 VDD VSS DECAPHV8
Xdelaybuf_5_clk delaybuf_5_clk/A VDD VSS delaybuf_6_clk/A BUFX12
XFILLER_174_1159 VSS VDD FILLER2
XFILLER_4_1234 VDD VSS DECAPHV8
XFILLER_146_1228 VDD VSS DECAPHV16
XFILLER_111_1198 VDD VSS DECAPHV8
XFILLER_98_1252 VSS VDD FILLER2
XFILLER_72_1414 VDD VSS DECAPHV8
XFILLER_62_978 VDD VSS DECAPHV32
XFILLER_157_1368 VDD VSS DECAPHV16
XFILLER_116_969 VDD VSS FILLER4
XFILLER_116_1010 VDD VSS DECAPHV32
XFILLER_77_1336 VDD VSS DECAPHV32
XTAP_TAPCELL_ROW_2_2_9 VDD VSS WELLTAP
XFILLER_5_1009 VSS VDD FILLER2
XTAP_TAPCELL_ROW_103_2_243 VDD VSS WELLTAP
XFILLER_127_1150 VDD VSS DECAPHV32
XFILLER_123_1025 VDD VSS DECAPHV32
XFILLER_175_1413 VDD VSS DECAPHV8
XFILLER_140_1350 VDD VSS DECAPHV32
XFILLER_169_1206 VSS VDD FILLER2
XFILLER_82_1042 VDD VSS DECAPHV16
XFILLER_130_961 VDD VSS DECAPHV8
XFILLER_95_1425 VSS VDD FILLER2
XFILLER_44_978 VDD VSS DECAPHV32
XFILLER_180_1152 VSS VDD FILLER2
XFILLER_106_1289 VDD VSS DECAPHV32
XFILLER_93_1182 VDD VSS DECAPHV16
XFILLER_139_1021 VDD VSS FILLER1
XFILLER_98_1071 VDD VSS DECAPHV32
XFILLER_121_961 VDD VSS DECAPHV32
XFILLER_72_1244 VDD VSS DECAPHV8
XFILLER_146_1058 VDD VSS DECAPHV8
XTAP_TAPCELL_ROW_106_2_258 VDD VSS WELLTAP
XFILLER_107_1009 VDD VSS DECAPHV8
XFILLER_124_1345 VSS VDD FILLER2
XFILLER_170_1321 VDD VSS DECAPHV16
XFILLER_157_1198 VDD VSS DECAPHV8
XFILLER_83_1384 VDD VSS DECAPHV8
XFILLER_112_961 VDD VSS DECAPHV8
XFILLER_164_1103 VDD VSS DECAPHV32
XFILLER_26_978 VDD VSS DECAPHV32
XFILLER_175_1243 VDD VSS DECAPHV32
XFILLER_171_1118 VDD VSS DECAPHV32
XFILLER_84_1159 VSS VDD FILLER2
XTAP_TAPCELL_ROW_131_2_385 VDD VSS WELLTAP
XFILLER_169_1025 VDD VSS DECAPHV32
XFILLER_103_961 VDD VSS DECAPHV32
XFILLER_95_1299 VSS VDD FILLER2
XFILLER_95_1211 VDD VSS DECAPHV32
XTAP_TAPCELL_ROW_102_2_242 VDD VSS WELLTAP
XFILLER_67_1324 VDD VSS DECAPHV8
XFILLER_106_1042 VDD VSS DECAPHV16
XFILLER_119_1425 VSS VDD FILLER2
XFILLER_117_1182 VDD VSS DECAPHV16
XFILLER_26_1010 VDD VSS FILLER1
XFILLER_130_1382 VDD VSS DECAPHV32
XFILLER_113_1057 VDD VSS DECAPHV32
XFILLER_124_1164 VDD VSS DECAPHV32
XFILLER_85_1413 VDD VSS DECAPHV8
XFILLER_170_1151 VDD VSS DECAPHV8
XFILLER_131_1113 VSS VDD FILLER2
XFILLER_79_1206 VSS VDD FILLER2
XFILLER_0_1292 VDD VSS DECAPHV32
XFILLER_107_1384 VDD VSS DECAPHV8
XFILLER_90_1196 VDD VSS DECAPHV32
XTAP_TAPCELL_ROW_105_2_257 VDD VSS WELLTAP
XFILLER_96_929 VDD VSS DECAPHV32
XFILLER_121_1304 VDD VSS DECAPHV32
XFILLER_108_1159 VSS VDD FILLER2
XFILLER_1_1089 VDD VSS DECAPHV16
XTAP_TAPCELL_ROW_177_2_613 VDD VSS WELLTAP
XFILLER_17_1009 VSS VDD FILLER2
XFILLER_20_929 VDD VSS DECAPHV32
XFILLER_143_1017 VDD VSS FILLER4
XFILLER_119_1211 VDD VSS DECAPHV32
XFILLER_154_1135 VDD VSS DECAPHV16
XIO_FILL_IO_EAST_3_0 IOVDD IOVSS VDDA VSS sg13cmos5l_Filler4000
XFILLER_132_1422 VDD VSS FILLER4
XFILLER_119_1299 VSS VDD FILLER2
XFILLER_80_1321 VDD VSS DECAPHV16
XFILLER_87_929 VDD VSS DECAPHV32
XFILLER_165_1275 VDD VSS DECAPHV16
XFILLER_74_1103 VDD VSS DECAPHV32
XFILLER_11_929 VDD VSS DECAPHV32
XTAP_TAPCELL_ROW_122_2_338 VDD VSS WELLTAP
XFILLER_176_1382 VDD VSS DECAPHV32
XFILLER_172_1257 VDD VSS DECAPHV32
XFILLER_85_1243 VDD VSS DECAPHV32
XFILLER_81_1118 VDD VSS DECAPHV32
XFILLER_159_1057 VDD VSS DECAPHV32
XFILLER_78_929 VDD VSS DECAPHV32
XFILLER_164_978 VDD VSS DECAPHV32
XFILLER_96_1350 VDD VSS DECAPHV32
XTAP_TAPCELL_ROW_68_2_70 VDD VSS WELLTAP
XFILLER_2_1321 VDD VSS DECAPHV16
XFILLER_79_1025 VDD VSS DECAPHV32
XFILLER_86_973 VSS VDD FILLER2
XFILLER_144_1337 VDD VSS DECAPHV8
XFILLER_109_1413 VDD VSS DECAPHV8
XFILLER_177_1113 VSS VDD FILLER2
XFILLER_103_1089 VDD VSS DECAPHV16
XFILLER_10_973 VSS VDD FILLER2
XFILLER_3_1118 VDD VSS DECAPHV32
XFILLER_69_929 VDD VSS DECAPHV32
XFILLER_114_1196 VDD VSS DECAPHV32
XIO_FILL_IO_EAST_0_20 IOVDD IOVSS VDDA VSS sg13cmos5l_Filler2000
XFILLER_162_1426 VSS VDD FILLER2
XFILLER_146_978 VDD VSS DECAPHV32
XFILLER_167_1304 VDD VSS DECAPHV32
XFILLER_132_1252 VSS VDD FILLER2
XFILLER_80_1151 VDD VSS DECAPHV8
XFILLER_68_973 VSS VDD FILLER2
XTAP_TAPCELL_ROW_90_2_179 VDD VSS WELLTAP
XFILLER_178_1422 VDD VSS FILLER4
XFILLER_143_1392 VSS VDD FILLER2
XTAP_TAPCELL_ROW_112_2_291 VDD VSS WELLTAP
XFILLER_104_1321 VDD VSS DECAPHV16
XFILLER_91_1291 VDD VSS DECAPHV8
XFILLER_3_936 VDD VSS DECAPHV32
XTAP_TAPCELL_ROW_176_2_612 VDD VSS WELLTAP
XFILLER_4_1427 VDD VSS FILLER1
XFILLER_172_1010 VDD VSS DECAPHV32
XFILLER_111_1336 VDD VSS DECAPHV32
XFILLER_2_1151 VDD VSS DECAPHV8
XFILLER_109_1243 VDD VSS DECAPHV32
XFILLER_105_1118 VDD VSS DECAPHV32
XFILLER_92_1066 VSS VDD FILLER2
XFILLER_151_1105 VDD VSS DECAPHV8
XFILLER_128_978 VDD VSS DECAPHV32
XTAP_TAPCELL_ROW_121_2_337 VDD VSS WELLTAP
XTAP_TAPCELL_ROW_10_2_28 VDD VSS WELLTAP
XFILLER_149_1089 VDD VSS DECAPHV16
XFILLER_75_1275 VDD VSS DECAPHV16
XFILLER_162_1289 VDD VSS DECAPHV32
XFILLER_69_1057 VDD VSS DECAPHV32
XFILLER_86_1382 VDD VSS DECAPHV32
XFILLER_82_1257 VDD VSS DECAPHV32
XTAP_TAPCELL_ROW_179_2_627 VDD VSS WELLTAP
XFILLER_132_1071 VDD VSS DECAPHV32
XFILLER_163_1009 VDD VSS DECAPHV8
XFILLER_145_1421 VDD VSS FILLER4
XFILLER_104_1151 VDD VSS DECAPHV8
XFILLER_93_1397 VDD VSS DECAPHV16
XFILLER_178_1252 VSS VDD FILLER2
XFILLER_87_1113 VSS VDD FILLER2
XTAP_TAPCELL_ROW_72_2_88 VDD VSS WELLTAP
XFILLER_140_929 VDD VSS DECAPHV32
XFILLER_152_1414 VDD VSS DECAPHV8
XFILLER_115_1291 VDD VSS DECAPHV8
XFILLER_4_1202 VDD VSS DECAPHV32
XFILLER_72_1426 VSS VDD FILLER2
XFILLER_4_1279 VDD VSS DECAPHV8
XFILLER_157_1336 VDD VSS DECAPHV32
XFILLER_131_929 VDD VSS DECAPHV32
XFILLER_116_1066 VSS VDD FILLER2
XFILLER_129_1427 VDD VSS FILLER1
XTAP_TAPCELL_ROW_103_2_244 VDD VSS WELLTAP
XFILLER_77_1304 VDD VSS DECAPHV32
XFILLER_99_1017 VDD VSS FILLER4
XFILLER_162_1042 VDD VSS DECAPHV16
XANTENNA_10 _4_/RB VDD VSS ANTENNA2
XFILLER_175_1425 VSS VDD FILLER2
XFILLER_101_1368 VDD VSS DECAPHV16
XFILLER_88_1422 VDD VSS FILLER4
XFILLER_82_1010 VDD VSS DECAPHV32
XFILLER_122_929 VDD VSS DECAPHV32
XFILLER_173_1182 VDD VSS DECAPHV16
XFILLER_130_973 VSS VDD FILLER2
XFILLER_93_1150 VDD VSS DECAPHV32
XFILLER_180_1197 VSS VDD FILLER2
XFILLER_106_1257 VDD VSS DECAPHV32
XFILLER_152_1244 VDD VSS DECAPHV8
XFILLER_113_1206 VSS VDD FILLER2
XFILLER_178_1071 VDD VSS DECAPHV32
XFILLER_113_929 VDD VSS DECAPHV32
XFILLER_117_1397 VDD VSS DECAPHV16
XFILLER_4_1054 VDD VSS DECAPHV8
XFILLER_163_1384 VDD VSS DECAPHV8
XFILLER_72_1289 VDD VSS DECAPHV32
XTAP_TAPCELL_ROW_106_2_259 VDD VSS WELLTAP
XIO_FILL_IO_SOUTH_4_0 IOVDD IOVSS VDDA VSS sg13cmos5l_Filler4000
XFILLER_104_929 VDD VSS DECAPHV32
XFILLER_112_973 VSS VDD FILLER2
XFILLER_164_1159 VSS VDD FILLER2
XTAP_TAPCELL_ROW_62_2_54 VDD VSS WELLTAP
XFILLER_73_1009 VDD VSS DECAPHV8
XFILLER_90_1345 VSS VDD FILLER2
XFILLER_175_1299 VSS VDD FILLER2
XFILLER_175_1211 VDD VSS DECAPHV32
XFILLER_136_1228 VDD VSS DECAPHV16
XFILLER_101_1198 VDD VSS DECAPHV8
XFILLER_88_1252 VSS VDD FILLER2
XTAP_TAPCELL_ROW_131_2_386 VDD VSS WELLTAP
XFILLER_99_1392 VSS VDD FILLER2
XFILLER_147_1368 VDD VSS DECAPHV16
XFILLER_32_938 VDD VSS DECAPHV32
XFILLER_106_1010 VDD VSS DECAPHV32
XIO_FILL_IO_EAST_3_20 IOVDD IOVSS VDDA VSS sg13cmos5l_Filler2000
XFILLER_117_1150 VDD VSS DECAPHV32
XFILLER_67_1369 VDD VSS DECAPHV8
XFILLER_113_1025 VDD VSS DECAPHV32
XFILLER_165_1413 VDD VSS DECAPHV8
XFILLER_130_1350 VDD VSS DECAPHV32
XFILLER_159_1206 VSS VDD FILLER2
XFILLER_72_1042 VDD VSS DECAPHV16
XFILLER_85_1425 VSS VDD FILLER2
XFILLER_170_1196 VDD VSS DECAPHV32
XFILLER_83_1182 VDD VSS DECAPHV16
XFILLER_90_1164 VDD VSS DECAPHV32
XFILLER_129_1021 VDD VSS FILLER1
XFILLER_88_1071 VDD VSS DECAPHV32
XFILLER_114_1345 VSS VDD FILLER2
XFILLER_89_993 VDD VSS DECAPHV16
XFILLER_136_1058 VDD VSS DECAPHV8
XFILLER_1_1057 VDD VSS DECAPHV32
XTAP_TAPCELL_ROW_113_2_293 VDD VSS WELLTAP
XTAP_TAPCELL_ROW_177_2_614 VDD VSS WELLTAP
XFILLER_160_1321 VDD VSS DECAPHV16
XFILLER_147_1198 VDD VSS DECAPHV8
XFILLER_73_1384 VDD VSS DECAPHV8
XFILLER_13_993 VDD VSS DECAPHV16
XFILLER_154_1103 VDD VSS DECAPHV32
XFILLER_67_1144 VDD VSS DECAPHV8
XFILLER_165_1243 VDD VSS DECAPHV32
XFILLER_161_1118 VDD VSS DECAPHV32
XFILLER_74_1159 VSS VDD FILLER2
XTAP_TAPCELL_ROW_122_2_339 VDD VSS WELLTAP
XFILLER_85_1211 VDD VSS DECAPHV32
XFILLER_159_1025 VDD VSS DECAPHV32
XFILLER_176_1350 VDD VSS DECAPHV32
XFILLER_85_1299 VSS VDD FILLER2
XTAP_TAPCELL_ROW_68_2_71 VDD VSS WELLTAP
XFILLER_109_1425 VSS VDD FILLER2
XFILLER_107_1182 VDD VSS DECAPHV16
XFILLER_16_1010 VDD VSS FILLER1
XFILLER_120_1382 VDD VSS DECAPHV32
XFILLER_6_978 VDD VSS DECAPHV32
XFILLER_103_1057 VDD VSS DECAPHV32
XFILLER_114_1164 VDD VSS DECAPHV32
XIO_BOND_ib_pad analog_PAD[2] sg13cmos5l_ip__bondpad_70x70
XFILLER_75_1413 VDD VSS DECAPHV8
XFILLER_160_1151 VDD VSS DECAPHV8
XFILLER_121_1113 VSS VDD FILLER2
XFILLER_69_1206 VSS VDD FILLER2
XFILLER_171_1291 VDD VSS DECAPHV8
XFILLER_80_1196 VDD VSS DECAPHV32
XTAP_TAPCELL_ROW_112_2_292 VDD VSS WELLTAP
XFILLER_111_1304 VDD VSS DECAPHV32
XFILLER_172_1066 VSS VDD FILLER2
XFILLER_133_1017 VDD VSS FILLER4
XFILLER_144_1135 VDD VSS DECAPHV16
XFILLER_109_1211 VDD VSS DECAPHV32
XFILLER_2_1196 VDD VSS DECAPHV32
XFILLER_122_1422 VDD VSS FILLER4
XFILLER_109_1299 VSS VDD FILLER2
XFILLER_70_1321 VDD VSS DECAPHV16
XFILLER_155_1275 VDD VSS DECAPHV16
XFILLER_151_993 VDD VSS DECAPHV16
XFILLER_166_1382 VDD VSS DECAPHV32
XFILLER_162_1257 VDD VSS DECAPHV32
XFILLER_75_1243 VDD VSS DECAPHV32
XFILLER_71_1118 VDD VSS DECAPHV32
XFILLER_149_1057 VDD VSS DECAPHV32
XFILLER_80_969 VDD VSS FILLER4
XIO_FILL_IO_NORTH_1_0 IOVDD IOVSS VDD VSS sg13cmos5l_Filler4000
XTAP_TAPCELL_ROW_100_2_230 VDD VSS WELLTAP
XFILLER_86_1350 VDD VSS DECAPHV32
XFILLER_69_1025 VDD VSS DECAPHV32
XFILLER_173_1397 VDD VSS DECAPHV16
XFILLER_134_1337 VDD VSS DECAPHV8
XFILLER_0_929 VDD VSS DECAPHV32
XFILLER_167_1113 VSS VDD FILLER2
XTAP_TAPCELL_ROW_26_2_36 VDD VSS WELLTAP
XFILLER_180_1324 VDD VSS DECAPHV8
XFILLER_152_1426 VSS VDD FILLER2
XFILLER_104_1196 VDD VSS DECAPHV32
XTAP_TAPCELL_ROW_72_2_89 VDD VSS WELLTAP
XFILLER_133_993 VDD VSS DECAPHV16
XTAP_TAPCELL_ROW_158_2_520 VDD VSS WELLTAP
XFILLER_4_1247 VDD VSS DECAPHV32
X_4_ _4_/CK _4_/D _4_/Q _4_/RB VDD VSS DFFRQX1
XFILLER_62_969 VDD VSS FILLER4
XTAP_TAPCELL_ROW_132_2_388 VDD VSS WELLTAP
XIO_FILL_IO_EAST_6_20 IOVDD IOVSS VDD VSS sg13cmos5l_Filler2000
XFILLER_157_1304 VDD VSS DECAPHV32
XFILLER_122_1252 VSS VDD FILLER2
XFILLER_70_1151 VDD VSS DECAPHV8
XTAP_TAPCELL_ROW_103_2_245 VDD VSS WELLTAP
XFILLER_81_1291 VDD VSS DECAPHV8
XFILLER_168_1422 VDD VSS FILLER4
XFILLER_133_1392 VSS VDD FILLER2
XANTENNA_11 _4_/RB VDD VSS ANTENNA2
XFILLER_162_1010 VDD VSS DECAPHV32
XFILLER_173_1150 VDD VSS DECAPHV32
XFILLER_101_1336 VDD VSS DECAPHV32
XFILLER_115_993 VDD VSS DECAPHV16
XFILLER_95_1427 VDD VSS FILLER1
XTAP_TAPCELL_ROW_1_2_0 VDD VSS WELLTAP
XFILLER_82_1066 VSS VDD FILLER2
XFILLER_141_1105 VDD VSS DECAPHV8
XFILLER_3_1291 VDD VSS DECAPHV8
XFILLER_44_969 VDD VSS FILLER4
XFILLER_139_1089 VDD VSS DECAPHV16
XFILLER_152_1289 VDD VSS DECAPHV32
XFILLER_4_1099 VDD VSS DECAPHV8
XFILLER_4_1022 VDD VSS DECAPHV32
XFILLER_76_1382 VDD VSS DECAPHV32
XFILLER_72_1257 VDD VSS DECAPHV32
XFILLER_135_1421 VDD VSS FILLER4
XFILLER_122_1071 VDD VSS DECAPHV32
XFILLER_153_1009 VDD VSS DECAPHV8
XFILLER_170_1345 VSS VDD FILLER2
XFILLER_83_1397 VDD VSS DECAPHV16
XFILLER_168_1252 VSS VDD FILLER2
XFILLER_142_1414 VDD VSS DECAPHV8
XFILLER_77_1113 VSS VDD FILLER2
XIO_BOND_do_q_b_pad do_q_b_PAD sg13cmos5l_ip__bondpad_70x70
XFILLER_26_969 VDD VSS FILLER4
XFILLER_105_1291 VDD VSS DECAPHV8
XFILLER_179_1392 VSS VDD FILLER2
XTAP_TAPCELL_ROW_131_2_387 VDD VSS WELLTAP
XFILLER_147_1336 VDD VSS DECAPHV32
XFILLER_1_1206 VSS VDD FILLER2
XFILLER_40_961 VDD VSS DECAPHV8
XFILLER_89_1017 VDD VSS FILLER4
XFILLER_106_1066 VSS VDD FILLER2
XFILLER_119_1427 VDD VSS FILLER1
XFILLER_67_1337 VDD VSS DECAPHV32
XTAP_TAPCELL_ROW_174_2_600 VDD VSS WELLTAP
XFILLER_152_1042 VDD VSS DECAPHV16
XFILLER_165_1425 VSS VDD FILLER2
XFILLER_78_1422 VDD VSS FILLER4
XFILLER_72_1010 VDD VSS DECAPHV32
XFILLER_163_1182 VDD VSS DECAPHV16
XFILLER_83_1150 VDD VSS DECAPHV32
XFILLER_98_961 VDD VSS DECAPHV8
XFILLER_170_1164 VDD VSS DECAPHV32
XFILLER_142_1244 VDD VSS DECAPHV8
XFILLER_103_1206 VSS VDD FILLER2
XFILLER_168_1071 VDD VSS DECAPHV32
XFILLER_22_961 VDD VSS DECAPHV8
XFILLER_107_1397 VDD VSS DECAPHV16
XFILLER_153_1384 VDD VSS DECAPHV8
XTAP_TAPCELL_ROW_113_2_294 VDD VSS WELLTAP
XFILLER_89_961 VDD VSS DECAPHV32
XTAP_TAPCELL_ROW_177_2_615 VDD VSS WELLTAP
XFILLER_1_1025 VDD VSS DECAPHV32
XFILLER_95_1021 VDD VSS FILLER1
XFILLER_13_961 VDD VSS DECAPHV32
XFILLER_154_1159 VSS VDD FILLER2
XFILLER_67_1189 VDD VSS DECAPHV8
XFILLER_67_1112 VDD VSS DECAPHV32
XFILLER_63_1009 VSS VDD FILLER2
XFILLER_80_1345 VSS VDD FILLER2
XFILLER_78_1252 VSS VDD FILLER2
XFILLER_165_1299 VSS VDD FILLER2
XFILLER_165_1211 VDD VSS DECAPHV32
XFILLER_126_1228 VDD VSS DECAPHV16
XFILLER_89_1392 VSS VDD FILLER2
XFILLER_137_1368 VDD VSS DECAPHV16
XTAP_TAPCELL_ROW_68_2_72 VDD VSS WELLTAP
XFILLER_2_1345 VSS VDD FILLER2
XFILLER_107_1150 VDD VSS DECAPHV32
XFILLER_103_1025 VDD VSS DECAPHV32
XFILLER_155_1413 VDD VSS DECAPHV8
XFILLER_120_1350 VDD VSS DECAPHV32
XFILLER_149_1206 VSS VDD FILLER2
XFILLER_97_1105 VDD VSS DECAPHV8
XFILLER_92_978 VDD VSS DECAPHV32
XFILLER_75_1425 VSS VDD FILLER2
XFILLER_73_1182 VDD VSS DECAPHV16
XFILLER_160_1196 VDD VSS DECAPHV32
XFILLER_146_969 VDD VSS FILLER4
XFILLER_80_1164 VDD VSS DECAPHV32
XFILLER_119_1021 VDD VSS FILLER1
XFILLER_78_1071 VDD VSS DECAPHV32
XFILLER_104_1345 VSS VDD FILLER2
XFILLER_126_1058 VDD VSS DECAPHV8
XFILLER_160_961 VDD VSS DECAPHV8
XFILLER_150_1321 VDD VSS DECAPHV16
XFILLER_137_1198 VDD VSS DECAPHV8
XFILLER_98_1414 VDD VSS DECAPHV8
XFILLER_144_1103 VDD VSS DECAPHV32
XFILLER_2_1164 VDD VSS DECAPHV32
XFILLER_74_978 VDD VSS DECAPHV32
XFILLER_128_969 VDD VSS FILLER4
Xdelaybuf_8_clk delaybuf_8_clk/A VDD VSS delaybuf_9_clk/A BUFX12
XFILLER_155_1243 VDD VSS DECAPHV32
XFILLER_151_1118 VDD VSS DECAPHV32
XFILLER_2_971 VDD VSS FILLER4
XFILLER_151_961 VDD VSS DECAPHV32
XFILLER_166_1350 VDD VSS DECAPHV32
XFILLER_75_1211 VDD VSS DECAPHV32
XFILLER_149_1025 VDD VSS DECAPHV32
XFILLER_75_1299 VSS VDD FILLER2
XTAP_TAPCELL_ROW_100_2_231 VDD VSS WELLTAP
XFILLER_142_961 VDD VSS DECAPHV8
XTAP_TAPCELL_ROW_98_2_220 VDD VSS WELLTAP
XFILLER_110_1382 VDD VSS DECAPHV32
XFILLER_56_978 VDD VSS DECAPHV32
XFILLER_180_1369 VDD VSS DECAPHV8
XFILLER_104_1164 VDD VSS DECAPHV32
XTAP_TAPCELL_ROW_158_2_521 VDD VSS WELLTAP
XFILLER_133_961 VDD VSS DECAPHV32
X_3_ _4_/CK _3_/D _3_/Q _4_/RB VDD VSS DFFRQX1
XFILLER_150_1151 VDD VSS DECAPHV8
XFILLER_111_1113 VSS VDD FILLER2
XFILLER_98_1244 VDD VSS DECAPHV8
XTAP_TAPCELL_ROW_132_2_389 VDD VSS WELLTAP
XFILLER_161_1291 VDD VSS DECAPHV8
XFILLER_70_1196 VDD VSS DECAPHV32
XIO_FILL_IO_WEST_3_0 IOVDD IOVSS VDD VSS sg13cmos5l_Filler4000
XFILLER_124_961 VDD VSS DECAPHV8
XTAP_TAPCELL_ROW_103_2_246 VDD VSS WELLTAP
XFILLER_38_978 VDD VSS DECAPHV32
XFILLER_101_1304 VDD VSS DECAPHV32
XFILLER_162_1066 VSS VDD FILLER2
XFILLER_123_1017 VDD VSS FILLER4
XANTENNA_12 _4_/RB VDD VSS ANTENNA2
XFILLER_175_1427 VDD VSS FILLER1
XFILLER_134_1135 VDD VSS DECAPHV16
XFILLER_115_961 VDD VSS DECAPHV32
XFILLER_112_1422 VDD VSS FILLER4
XTAP_TAPCELL_ROW_1_2_1 VDD VSS WELLTAP
XFILLER_180_1144 VDD VSS DECAPHV8
XFILLER_145_1275 VDD VSS DECAPHV16
XFILLER_139_1057 VDD VSS DECAPHV32
XFILLER_106_961 VDD VSS DECAPHV8
XFILLER_156_1382 VDD VSS DECAPHV32
XFILLER_152_1257 VDD VSS DECAPHV32
XFILLER_76_1350 VDD VSS DECAPHV32
XFILLER_50_929 VDD VSS DECAPHV32
XFILLER_4_1067 VDD VSS DECAPHV32
XFILLER_163_1397 VDD VSS DECAPHV16
XFILLER_124_1337 VDD VSS DECAPHV8
XFILLER_157_1113 VSS VDD FILLER2
XFILLER_142_1426 VSS VDD FILLER2
XFILLER_41_929 VDD VSS DECAPHV32
XFILLER_147_1304 VDD VSS DECAPHV32
XFILLER_112_1252 VSS VDD FILLER2
XFILLER_71_1291 VDD VSS DECAPHV8
XFILLER_40_973 VSS VDD FILLER2
XFILLER_158_1422 VDD VSS FILLER4
XFILLER_123_1392 VSS VDD FILLER2
XTAP_TAPCELL_ROW_110_2_280 VDD VSS WELLTAP
XFILLER_99_929 VDD VSS DECAPHV32
XFILLER_152_1010 VDD VSS DECAPHV32
XTAP_TAPCELL_ROW_174_2_601 VDD VSS WELLTAP
XFILLER_163_1150 VDD VSS DECAPHV32
XFILLER_23_929 VDD VSS DECAPHV32
XFILLER_72_1066 VSS VDD FILLER2
XFILLER_85_1427 VDD VSS FILLER1
XFILLER_31_995 VDD VSS DECAPHV16
XFILLER_176_978 VDD VSS DECAPHV32
XTAP_TAPCELL_ROW_168_2_570 VDD VSS WELLTAP
XFILLER_131_1105 VDD VSS DECAPHV8
XFILLER_98_973 VSS VDD FILLER2
XFILLER_14_929 VDD VSS DECAPHV32
XFILLER_100_978 VDD VSS DECAPHV32
XFILLER_142_1289 VDD VSS DECAPHV32
XFILLER_129_1089 VDD VSS DECAPHV16
XFILLER_22_973 VSS VDD FILLER2
XFILLER_175_1021 VDD VSS FILLER1
XTAP_TAPCELL_ROW_113_2_295 VDD VSS WELLTAP
XTAP_TAPCELL_ROW_177_2_616 VDD VSS WELLTAP
XFILLER_125_1421 VDD VSS FILLER4
XFILLER_112_1071 VDD VSS DECAPHV32
XFILLER_143_1009 VDD VSS DECAPHV8
XFILLER_160_1345 VSS VDD FILLER2
XFILLER_73_1397 VDD VSS DECAPHV16
XFILLER_158_978 VDD VSS DECAPHV32
XFILLER_158_1252 VSS VDD FILLER2
XFILLER_132_1414 VDD VSS DECAPHV8
XFILLER_67_1157 VDD VSS DECAPHV32
XFILLER_169_1392 VSS VDD FILLER2
XFILLER_137_1336 VDD VSS DECAPHV32
XIO_FILL_IO_WEST_0_30 IOVDD IOVSS VDD VSS sg13cmos5l_Filler1000
XFILLER_79_1017 VDD VSS FILLER4
XTAP_TAPCELL_ROW_101_2_233 VDD VSS WELLTAP
XFILLER_109_1427 VDD VSS FILLER1
XFILLER_92_1228 VDD VSS DECAPHV16
XFILLER_177_1105 VDD VSS DECAPHV8
XFILLER_68_1422 VDD VSS FILLER4
XFILLER_142_1042 VDD VSS DECAPHV16
XFILLER_6_969 VDD VSS FILLER4
XFILLER_155_1425 VSS VDD FILLER2
XFILLER_62_1010 VDD VSS FILLER1
XFILLER_170_929 VDD VSS DECAPHV32
XFILLER_153_1182 VDD VSS DECAPHV16
XFILLER_160_1164 VDD VSS DECAPHV32
XFILLER_73_1150 VDD VSS DECAPHV32
XTAP_TAPCELL_ROW_159_2_523 VDD VSS WELLTAP
XFILLER_158_1071 VDD VSS DECAPHV32
XFILLER_161_929 VDD VSS DECAPHV32
XFILLER_132_1244 VDD VSS DECAPHV8
XIO_FILL_IO_EAST_1_0 IOVDD IOVSS VDDA VSS sg13cmos5l_Filler4000
XFILLER_178_1414 VDD VSS DECAPHV8
XFILLER_143_1384 VDD VSS DECAPHV8
XTAP_TAPCELL_ROW_104_2_248 VDD VSS WELLTAP
XFILLER_85_1021 VDD VSS FILLER1
XFILLER_152_929 VDD VSS DECAPHV32
XFILLER_160_973 VSS VDD FILLER2
XFILLER_98_1426 VSS VDD FILLER2
XFILLER_144_1159 VSS VDD FILLER2
XFILLER_70_1345 VSS VDD FILLER2
XFILLER_53_1009 VSS VDD FILLER2
XFILLER_92_1058 VDD VSS DECAPHV8
XFILLER_155_1211 VDD VSS DECAPHV32
XFILLER_68_1252 VSS VDD FILLER2
XFILLER_143_929 VDD VSS DECAPHV32
XFILLER_155_1299 VSS VDD FILLER2
XFILLER_116_1228 VDD VSS DECAPHV16
XFILLER_79_1392 VSS VDD FILLER2
XFILLER_127_1368 VDD VSS DECAPHV16
XTAP_TAPCELL_ROW_100_2_232 VDD VSS WELLTAP
Xrst_n_pad IOVDD IOVSS _4_/RB rst_n_PAD VDD VSS sg13cmos5l_IOPadIn
XFILLER_134_929 VDD VSS DECAPHV32
XFILLER_142_973 VSS VDD FILLER2
XFILLER_110_1350 VDD VSS DECAPHV32
XTAP_TAPCELL_ROW_98_2_221 VDD VSS WELLTAP
XFILLER_180_1337 VDD VSS DECAPHV32
XFILLER_145_1413 VDD VSS DECAPHV8
XFILLER_178_1244 VDD VSS DECAPHV8
XFILLER_139_1206 VSS VDD FILLER2
XFILLER_87_1105 VDD VSS DECAPHV8
XFILLER_125_929 VDD VSS DECAPHV32
XTAP_TAPCELL_ROW_158_2_522 VDD VSS WELLTAP
X_2_ _2_/CK _2_/D _2_/Q _4_/RB VDD VSS DFFRQX1
XFILLER_150_1196 VDD VSS DECAPHV32
XFILLER_98_1289 VDD VSS DECAPHV32
XFILLER_109_1021 VDD VSS FILLER1
XFILLER_70_1164 VDD VSS DECAPHV32
XFILLER_179_1019 VSS VDD FILLER2
XFILLER_68_1071 VDD VSS DECAPHV32
XFILLER_116_929 VDD VSS DECAPHV32
XFILLER_124_973 VSS VDD FILLER2
XTAP_TAPCELL_ROW_103_2_247 VDD VSS WELLTAP
XFILLER_99_1009 VDD VSS DECAPHV8
XFILLER_116_1058 VDD VSS DECAPHV8
XTAP_TAPCELL_ROW_175_2_603 VDD VSS WELLTAP
XFILLER_61_993 VDD VSS DECAPHV16
XANTENNA_13 _4_/RB VDD VSS ANTENNA2
XFILLER_140_1321 VDD VSS DECAPHV16
XFILLER_127_1198 VDD VSS DECAPHV8
XFILLER_88_1414 VDD VSS DECAPHV8
XFILLER_107_929 VDD VSS DECAPHV32
XFILLER_134_1103 VDD VSS DECAPHV32
XTAP_TAPCELL_ROW_1_2_2 VDD VSS WELLTAP
XFILLER_180_1189 VDD VSS DECAPHV8
XFILLER_180_1112 VDD VSS DECAPHV32
XFILLER_145_1243 VDD VSS DECAPHV32
XFILLER_141_1118 VDD VSS DECAPHV32
XTAP_TAPCELL_ROW_120_2_328 VDD VSS WELLTAP
XFILLER_156_1350 VDD VSS DECAPHV32
XFILLER_106_973 VSS VDD FILLER2
XFILLER_139_1025 VDD VSS DECAPHV32
XFILLER_98_1042 VDD VSS DECAPHV16
XFILLER_43_993 VDD VSS DECAPHV16
XFILLER_100_1382 VDD VSS DECAPHV32
XTAP_TAPCELL_ROW_178_2_618 VDD VSS WELLTAP
XFILLER_0_1422 VSS VDD FILLER2
XFILLER_90_1337 VDD VSS DECAPHV8
XFILLER_179_987 VDD VSS DECAPHV32
XIO_FILL_IO_WEST_3_30 IOVDD IOVSS VDD VSS sg13cmos5l_Filler1000
XFILLER_140_1151 VDD VSS DECAPHV8
XFILLER_101_1113 VSS VDD FILLER2
XFILLER_88_1244 VDD VSS DECAPHV8
XFILLER_151_1291 VDD VSS DECAPHV8
XFILLER_99_1384 VDD VSS DECAPHV8
XFILLER_25_993 VDD VSS DECAPHV16
XTAP_TAPCELL_ROW_110_2_281 VDD VSS WELLTAP
XTAP_TAPCELL_ROW_174_2_602 VDD VSS WELLTAP
XFILLER_152_1066 VSS VDD FILLER2
XFILLER_113_1017 VDD VSS FILLER4
XFILLER_165_1427 VDD VSS FILLER1
XFILLER_124_1135 VDD VSS DECAPHV16
XFILLER_31_963 VDD VSS DECAPHV32
XFILLER_102_1422 VDD VSS FILLER4
XIO_FILL_IO_SOUTH_2_0 IOVDD IOVSS VDD VSS sg13cmos5l_Filler4000
XTAP_TAPCELL_ROW_168_2_571 VDD VSS WELLTAP
XFILLER_135_1275 VDD VSS DECAPHV16
XFILLER_129_1057 VDD VSS DECAPHV32
XFILLER_146_1382 VDD VSS DECAPHV32
XFILLER_142_1257 VDD VSS DECAPHV32
XFILLER_153_1397 VDD VSS DECAPHV16
XFILLER_114_1337 VDD VSS DECAPHV8
XTAP_TAPCELL_ROW_113_2_296 VDD VSS WELLTAP
XTAP_TAPCELL_ROW_177_2_617 VDD VSS WELLTAP
XFILLER_147_1113 VSS VDD FILLER2
XFILLER_95_1089 VDD VSS DECAPHV16
XFILLER_132_1426 VSS VDD FILLER2
XFILLER_91_1421 VDD VSS FILLER4
XFILLER_159_1017 VDD VSS FILLER4
XFILLER_172_1228 VDD VSS DECAPHV16
XFILLER_137_1304 VDD VSS DECAPHV32
XFILLER_102_1252 VSS VDD FILLER2
XIO_FILL_IO_WEST_0_20 IOVDD IOVSS VDD VSS sg13cmos5l_Filler2000
XFILLER_113_1392 VSS VDD FILLER2
XTAP_TAPCELL_ROW_101_2_234 VDD VSS WELLTAP
XFILLER_96_1321 VDD VSS DECAPHV16
XFILLER_148_1422 VDD VSS FILLER4
XFILLER_142_1010 VDD VSS DECAPHV32
XTAP_TAPCELL_ROW_99_2_223 VDD VSS WELLTAP
XFILLER_153_1150 VDD VSS DECAPHV32
XFILLER_163_993 VDD VSS DECAPHV16
XFILLER_97_1118 VDD VSS DECAPHV32
XFILLER_75_1427 VDD VSS FILLER1
XFILLER_92_969 VDD VSS FILLER4
XTAP_TAPCELL_ROW_159_2_524 VDD VSS WELLTAP
XFILLER_121_1105 VDD VSS DECAPHV8
Xg_inputs\[3\].input_pad IOVDD IOVSS ANTENNA_4/A input_PAD[3] VDD VSS sg13cmos5l_IOPadIn
XFILLER_132_1289 VDD VSS DECAPHV32
XFILLER_119_1089 VDD VSS DECAPHV16
XFILLER_165_1021 VDD VSS FILLER1
XFILLER_178_1426 VSS VDD FILLER2
XFILLER_102_1071 VDD VSS DECAPHV32
XTAP_TAPCELL_ROW_104_2_249 VDD VSS WELLTAP
XFILLER_115_1421 VDD VSS FILLER4
XFILLER_172_1058 VDD VSS DECAPHV8
XFILLER_133_1009 VDD VSS DECAPHV8
XFILLER_145_993 VDD VSS DECAPHV16
XFILLER_150_1345 VSS VDD FILLER2
XFILLER_148_1252 VSS VDD FILLER2
XFILLER_96_1151 VDD VSS DECAPHV8
XFILLER_74_969 VDD VSS FILLER4
XFILLER_122_1414 VDD VSS DECAPHV8
XTAP_TAPCELL_ROW_42_2_44 VDD VSS WELLTAP
XFILLER_159_1392 VSS VDD FILLER2
XFILLER_127_1336 VDD VSS DECAPHV32
XFILLER_69_1017 VDD VSS FILLER4
XFILLER_82_1228 VDD VSS DECAPHV16
XFILLER_127_993 VDD VSS DECAPHV16
XFILLER_167_1105 VDD VSS DECAPHV8
XTAP_TAPCELL_ROW_98_2_222 VDD VSS WELLTAP
XFILLER_56_969 VDD VSS FILLER4
XFILLER_132_1042 VDD VSS DECAPHV16
XFILLER_145_1425 VSS VDD FILLER2
XFILLER_143_1182 VDD VSS DECAPHV16
XFILLER_93_1368 VDD VSS DECAPHV16
XFILLER_52_1010 VDD VSS FILLER1
XFILLER_178_1289 VDD VSS DECAPHV32
XFILLER_150_1164 VDD VSS DECAPHV32
X_1_ _1_/A0 _1_/A1 _1_/S0 VDD VSS _4_/D MUX2X1
XFILLER_98_1257 VDD VSS DECAPHV32
XFILLER_148_1071 VDD VSS DECAPHV32
XFILLER_70_961 VDD VSS DECAPHV8
XFILLER_122_1244 VDD VSS DECAPHV8
XFILLER_109_993 VDD VSS DECAPHV16
XFILLER_168_1414 VDD VSS DECAPHV8
XFILLER_133_1384 VDD VSS DECAPHV8
XFILLER_38_969 VDD VSS FILLER4
XTAP_TAPCELL_ROW_111_2_283 VDD VSS WELLTAP
XTAP_TAPCELL_ROW_175_2_604 VDD VSS WELLTAP
XFILLER_61_961 VDD VSS DECAPHV32
XFILLER_75_1021 VDD VSS FILLER1
XANTENNA_14 _4_/RB VDD VSS ANTENNA2
XFILLER_88_1426 VSS VDD FILLER2
XFILLER_134_1159 VSS VDD FILLER2
XFILLER_43_1009 VSS VDD FILLER2
XFILLER_82_1058 VDD VSS DECAPHV8
XFILLER_145_1211 VDD VSS DECAPHV32
XTAP_TAPCELL_ROW_1_2_3 VDD VSS WELLTAP
XFILLER_52_961 VDD VSS DECAPHV8
XFILLER_180_1157 VDD VSS DECAPHV32
XFILLER_145_1299 VSS VDD FILLER2
XFILLER_106_1228 VDD VSS DECAPHV16
XFILLER_93_1198 VDD VSS DECAPHV8
XTAP_TAPCELL_ROW_169_2_573 VDD VSS WELLTAP
XTAP_TAPCELL_ROW_120_2_329 VDD VSS WELLTAP
XFILLER_69_1392 VSS VDD FILLER2
XFILLER_178_1042 VDD VSS DECAPHV16
XFILLER_117_1368 VDD VSS DECAPHV16
XFILLER_98_1010 VDD VSS DECAPHV32
XFILLER_43_961 VDD VSS DECAPHV32
XFILLER_100_1350 VDD VSS DECAPHV32
XTAP_TAPCELL_ROW_114_2_298 VDD VSS WELLTAP
XFILLER_170_1337 VDD VSS DECAPHV8
XFILLER_135_1413 VDD VSS DECAPHV8
XTAP_TAPCELL_ROW_178_2_619 VDD VSS WELLTAP
XFILLER_168_1244 VDD VSS DECAPHV8
XFILLER_129_1206 VSS VDD FILLER2
XFILLER_77_1105 VDD VSS DECAPHV8
XFILLER_34_961 VDD VSS DECAPHV8
XIO_FILL_IO_WEST_3_20 IOVDD IOVSS VDD VSS sg13cmos5l_Filler2000
XFILLER_179_955 VDD VSS DECAPHV32
XFILLER_179_1384 VDD VSS DECAPHV8
XFILLER_140_1196 VDD VSS DECAPHV32
XFILLER_88_1289 VDD VSS DECAPHV32
XFILLER_169_1019 VSS VDD FILLER2
XFILLER_25_961 VDD VSS DECAPHV32
XTAP_TAPCELL_ROW_110_2_282 VDD VSS WELLTAP
XFILLER_89_1009 VDD VSS DECAPHV8
XFILLER_106_1058 VDD VSS DECAPHV8
XFILLER_117_1198 VDD VSS DECAPHV8
XFILLER_130_1321 VDD VSS DECAPHV16
XFILLER_78_1414 VDD VSS DECAPHV8
XFILLER_16_961 VDD VSS DECAPHV8
XFILLER_124_1103 VDD VSS DECAPHV32
XFILLER_31_931 VDD VSS DECAPHV32
XFILLER_176_947 VDD VSS DECAPHV16
XTAP_TAPCELL_ROW_168_2_572 VDD VSS WELLTAP
XFILLER_135_1243 VDD VSS DECAPHV32
XFILLER_131_1118 VDD VSS DECAPHV32
XFILLER_100_969 VDD VSS FILLER4
XFILLER_146_1350 VDD VSS DECAPHV32
XFILLER_90_1135 VDD VSS DECAPHV16
XFILLER_0_1242 VSS VDD FILLER2
XFILLER_129_1025 VDD VSS DECAPHV32
XFILLER_88_1042 VDD VSS DECAPHV16
XFILLER_175_1089 VDD VSS DECAPHV16
XTAP_TAPCELL_ROW_113_2_297 VDD VSS WELLTAP
XFILLER_99_1182 VDD VSS DECAPHV16
XFILLER_1_1017 VDD VSS FILLER4
XFILLER_95_1057 VDD VSS DECAPHV32
XFILLER_158_969 VDD VSS FILLER4
Xg_inputs\[2\].input_pad IOVDD IOVSS ANTENNA_7/A input_PAD[2] VDD VSS sg13cmos5l_IOPadIn
XFILLER_171_1421 VDD VSS FILLER4
XTAP_TAPCELL_ROW_156_2_510 VDD VSS WELLTAP
XFILLER_130_1151 VDD VSS DECAPHV8
XFILLER_80_1337 VDD VSS DECAPHV8
Xhold1 _4_/Q VDD VSS _2_/D BUFX3
XFILLER_78_1244 VDD VSS DECAPHV8
XFILLER_176_1321 VDD VSS DECAPHV16
XFILLER_141_1291 VDD VSS DECAPHV8
XTAP_TAPCELL_ROW_130_2_378 VDD VSS WELLTAP
XFILLER_89_1384 VDD VSS DECAPHV8
XTAP_TAPCELL_ROW_101_2_235 VDD VSS WELLTAP
XFILLER_2_1337 VDD VSS DECAPHV8
XFILLER_86_978 VDD VSS DECAPHV32
XTAP_TAPCELL_ROW_99_2_224 VDD VSS WELLTAP
XFILLER_142_1066 VSS VDD FILLER2
XFILLER_103_1017 VDD VSS FILLER4
XFILLER_177_1118 VDD VSS DECAPHV32
XFILLER_155_1427 VDD VSS FILLER1
XFILLER_10_978 VDD VSS DECAPHV32
XFILLER_163_961 VDD VSS DECAPHV32
XFILLER_114_1135 VDD VSS DECAPHV16
XTAP_TAPCELL_ROW_159_2_525 VDD VSS WELLTAP
XFILLER_125_1275 VDD VSS DECAPHV16
XFILLER_5_993 VDD VSS DECAPHV16
XFILLER_119_1057 VDD VSS DECAPHV32
XFILLER_154_961 VDD VSS DECAPHV8
Xcut_vdd_e IOVDD IOVSS VSS sg13cmos5l_ip__cut_vdd
XFILLER_136_1382 VDD VSS DECAPHV32
XFILLER_132_1257 VDD VSS DECAPHV32
XFILLER_68_978 VDD VSS DECAPHV32
XFILLER_1_1392 VSS VDD FILLER2
XFILLER_165_1011 VDD VSS DECAPHV8
XFILLER_176_1151 VDD VSS DECAPHV8
XFILLER_143_1397 VDD VSS DECAPHV16
XFILLER_137_1113 VSS VDD FILLER2
XFILLER_104_1337 VDD VSS DECAPHV8
XFILLER_145_961 VDD VSS DECAPHV32
XFILLER_85_1089 VDD VSS DECAPHV16
XFILLER_96_1196 VDD VSS DECAPHV32
XFILLER_122_1426 VSS VDD FILLER2
XFILLER_81_1421 VDD VSS FILLER4
XFILLER_2_963 VDD VSS DECAPHV8
XFILLER_136_961 VDD VSS DECAPHV8
XFILLER_149_1017 VDD VSS FILLER4
XFILLER_162_1228 VDD VSS DECAPHV16
XFILLER_127_1304 VDD VSS DECAPHV32
XFILLER_80_929 VDD VSS DECAPHV32
XFILLER_138_1422 VDD VSS FILLER4
XFILLER_103_1392 VSS VDD FILLER2
XFILLER_86_1321 VDD VSS DECAPHV16
XTAP_TAPCELL_ROW_58_2_52 VDD VSS WELLTAP
XFILLER_127_961 VDD VSS DECAPHV32
XFILLER_173_1368 VDD VSS DECAPHV16
XFILLER_132_1010 VDD VSS DECAPHV32
XFILLER_93_1336 VDD VSS DECAPHV32
XFILLER_3_1421 VDD VSS FILLER4
XFILLER_71_929 VDD VSS DECAPHV32
XFILLER_143_1150 VDD VSS DECAPHV32
XFILLER_178_1257 VDD VSS DECAPHV32
XFILLER_87_1118 VDD VSS DECAPHV32
XFILLER_118_961 VDD VSS DECAPHV8
XFILLER_111_1105 VDD VSS DECAPHV8
XFILLER_62_929 VDD VSS DECAPHV32
XFILLER_70_973 VSS VDD FILLER2
XFILLER_122_1289 VDD VSS DECAPHV32
XFILLER_109_1089 VDD VSS DECAPHV16
XFILLER_109_961 VDD VSS DECAPHV32
XFILLER_155_1021 VDD VSS FILLER1
XFILLER_168_1426 VSS VDD FILLER2
XTAP_TAPCELL_ROW_111_2_284 VDD VSS WELLTAP
XFILLER_53_929 VDD VSS DECAPHV32
XTAP_TAPCELL_ROW_175_2_605 VDD VSS WELLTAP
XFILLER_140_1345 VSS VDD FILLER2
XFILLER_105_1421 VDD VSS FILLER4
XFILLER_162_1058 VDD VSS DECAPHV8
XFILLER_123_1009 VDD VSS DECAPHV8
XANTENNA_15 _4_/RB VDD VSS ANTENNA2
XFILLER_138_1252 VSS VDD FILLER2
XFILLER_86_1151 VDD VSS DECAPHV8
XFILLER_173_1198 VDD VSS DECAPHV8
XFILLER_112_1414 VDD VSS DECAPHV8
XTAP_TAPCELL_ROW_1_2_4 VDD VSS WELLTAP
XFILLER_130_978 VDD VSS DECAPHV32
XFILLER_149_1392 VSS VDD FILLER2
XFILLER_97_1291 VDD VSS DECAPHV8
XFILLER_44_929 VDD VSS DECAPHV32
XFILLER_52_973 VSS VDD FILLER2
XTAP_TAPCELL_ROW_169_2_574 VDD VSS WELLTAP
XFILLER_178_1010 VDD VSS DECAPHV32
XFILLER_117_1336 VDD VSS DECAPHV32
XFILLER_35_929 VDD VSS DECAPHV32
XFILLER_98_1066 VSS VDD FILLER2
XFILLER_72_1228 VDD VSS DECAPHV16
XTAP_TAPCELL_ROW_114_2_299 VDD VSS WELLTAP
XFILLER_157_1105 VDD VSS DECAPHV8
XIO_FILL_IO_WEST_1_0 IOVDD IOVSS VDD VSS sg13cmos5l_Filler4000
XFILLER_122_1042 VDD VSS DECAPHV16
XFILLER_135_1425 VSS VDD FILLER2
XFILLER_133_1182 VDD VSS DECAPHV16
XFILLER_83_1368 VDD VSS DECAPHV16
XFILLER_42_1010 VDD VSS FILLER1
XFILLER_112_978 VDD VSS DECAPHV32
XFILLER_168_1289 VDD VSS DECAPHV32
XFILLER_34_973 VSS VDD FILLER2
XFILLER_26_929 VDD VSS DECAPHV32
XFILLER_140_1164 VDD VSS DECAPHV32
XFILLER_88_1257 VDD VSS DECAPHV32
XTAP_TAPCELL_ROW_8_2_27 VDD VSS WELLTAP
XFILLER_138_1071 VDD VSS DECAPHV32
XFILLER_112_1244 VDD VSS DECAPHV8
XFILLER_99_1397 VDD VSS DECAPHV16
XFILLER_95_1206 VSS VDD FILLER2
XFILLER_17_929 VDD VSS DECAPHV32
XFILLER_158_1414 VDD VSS DECAPHV8
XFILLER_123_1384 VDD VSS DECAPHV8
Xg_inputs\[1\].input_pad IOVDD IOVSS g_inputs\[1\].input_pad/p2c input_PAD[1] VDD
+ VSS sg13cmos5l_IOPadIn
XFILLER_78_1426 VSS VDD FILLER2
Xdo_q_b_pad dsm2/do_q_b IOVDD IOVSS do_q_b_PAD VDDA VSS sg13cmos5l_IOPadOut4mA
XFILLER_16_973 VSS VDD FILLER2
XFILLER_124_1159 VSS VDD FILLER2
XFILLER_33_1009 VSS VDD FILLER2
XFILLER_72_1058 VDD VSS DECAPHV8
XFILLER_170_1135 VDD VSS DECAPHV16
XFILLER_135_1211 VDD VSS DECAPHV32
XFILLER_135_1299 VSS VDD FILLER2
XFILLER_83_1198 VDD VSS DECAPHV8
XFILLER_168_1042 VDD VSS DECAPHV16
XFILLER_107_1368 VDD VSS DECAPHV16
XFILLER_90_1103 VDD VSS DECAPHV32
XFILLER_0_1287 VSS VDD FILLER2
XFILLER_179_1182 VDD VSS DECAPHV16
XFILLER_88_1010 VDD VSS DECAPHV32
XFILLER_175_1057 VDD VSS DECAPHV32
XFILLER_99_1150 VDD VSS DECAPHV32
XTAP_TAPCELL_ROW_96_2_210 VDD VSS WELLTAP
XFILLER_95_1025 VDD VSS DECAPHV32
XFILLER_160_1337 VDD VSS DECAPHV8
XFILLER_125_1413 VDD VSS DECAPHV8
XFILLER_158_1244 VDD VSS DECAPHV8
XFILLER_119_1206 VSS VDD FILLER2
XTAP_TAPCELL_ROW_156_2_511 VDD VSS WELLTAP
Xhold2 _2_/Q VDD VSS _3_/D BUFX3
XFILLER_169_1384 VDD VSS DECAPHV8
XFILLER_130_1196 VDD VSS DECAPHV32
XFILLER_78_1289 VDD VSS DECAPHV32
XIO_BOND_g_vss_pads\[0\].vss_pad VSS sg13cmos5l_ip__bondpad_70x70
XTAP_TAPCELL_ROW_130_2_379 VDD VSS WELLTAP
XFILLER_172_951 VDD VSS DECAPHV16
XTAP_TAPCELL_ROW_101_2_236 VDD VSS WELLTAP
XFILLER_96_1345 VSS VDD FILLER2
XFILLER_0_1062 VSS VDD FILLER2
XFILLER_79_1009 VDD VSS DECAPHV8
XFILLER_107_1198 VDD VSS DECAPHV8
XTAP_TAPCELL_ROW_99_2_225 VDD VSS WELLTAP
XFILLER_155_929 VDD VSS DECAPHV32
XFILLER_120_1321 VDD VSS DECAPHV16
XFILLER_68_1414 VDD VSS DECAPHV8
XFILLER_114_1103 VDD VSS DECAPHV32
XTAP_TAPCELL_ROW_159_2_526 VDD VSS WELLTAP
XFILLER_125_1243 VDD VSS DECAPHV32
XFILLER_121_1118 VDD VSS DECAPHV32
XFILLER_146_929 VDD VSS DECAPHV32
XFILLER_154_973 VSS VDD FILLER2
XFILLER_136_1350 VDD VSS DECAPHV32
XFILLER_80_1135 VDD VSS DECAPHV16
XFILLER_5_961 VDD VSS DECAPHV32
XFILLER_119_1025 VDD VSS DECAPHV32
XFILLER_78_1042 VDD VSS DECAPHV16
XFILLER_165_1089 VDD VSS DECAPHV16
XFILLER_91_1275 VDD VSS DECAPHV16
XFILLER_137_929 VDD VSS DECAPHV32
XFILLER_91_993 VDD VSS DECAPHV16
XFILLER_176_1196 VDD VSS DECAPHV32
XFILLER_89_1182 VDD VSS DECAPHV16
XFILLER_85_1057 VDD VSS DECAPHV32
XFILLER_161_1421 VDD VSS FILLER4
XFILLER_96_1164 VDD VSS DECAPHV32
XFILLER_2_1135 VDD VSS DECAPHV16
XFILLER_120_1151 VDD VSS DECAPHV8
XFILLER_70_1337 VDD VSS DECAPHV8
XFILLER_128_929 VDD VSS DECAPHV32
XFILLER_68_1244 VDD VSS DECAPHV8
XFILLER_2_931 VDD VSS DECAPHV32
XFILLER_136_973 VSS VDD FILLER2
XFILLER_166_1321 VDD VSS DECAPHV16
XFILLER_131_1291 VDD VSS DECAPHV8
XFILLER_79_1384 VDD VSS DECAPHV8
XFILLER_73_993 VDD VSS DECAPHV16
XFILLER_119_929 VDD VSS DECAPHV32
XFILLER_173_1336 VDD VSS DECAPHV32
XFILLER_132_1066 VSS VDD FILLER2
XFILLER_167_1118 VDD VSS DECAPHV32
XFILLER_145_1427 VDD VSS FILLER1
XFILLER_93_1304 VDD VSS DECAPHV32
XFILLER_104_1135 VDD VSS DECAPHV16
XFILLER_118_973 VSS VDD FILLER2
XTAP_TAPCELL_ROW_166_2_560 VDD VSS WELLTAP
XFILLER_115_1275 VDD VSS DECAPHV16
XFILLER_126_1382 VDD VSS DECAPHV32
XFILLER_55_993 VDD VSS DECAPHV16
XFILLER_109_1057 VDD VSS DECAPHV32
XFILLER_122_1257 VDD VSS DECAPHV32
XFILLER_166_1151 VDD VSS DECAPHV8
XFILLER_133_1397 VDD VSS DECAPHV16
XFILLER_127_1113 VSS VDD FILLER2
XTAP_TAPCELL_ROW_111_2_285 VDD VSS WELLTAP
XTAP_TAPCELL_ROW_175_2_606 VDD VSS WELLTAP
XFILLER_75_1089 VDD VSS DECAPHV16
XANTENNA_16 _4_/RB VDD VSS ANTENNA2
XFILLER_177_1291 VDD VSS DECAPHV8
XFILLER_86_1196 VDD VSS DECAPHV32
XTAP_TAPCELL_ROW_71_2_83 VDD VSS WELLTAP
XFILLER_112_1426 VSS VDD FILLER2
XFILLER_71_1421 VDD VSS FILLER4
XFILLER_37_993 VDD VSS DECAPHV16
XTAP_TAPCELL_ROW_169_2_575 VDD VSS WELLTAP
XFILLER_178_1066 VSS VDD FILLER2
Xg_inputs\[0\].input_pad IOVDD IOVSS _1_/A0 input_PAD[0] VDD VSS sg13cmos5l_IOPadIn
XFILLER_139_1017 VDD VSS FILLER4
XFILLER_152_1228 VDD VSS DECAPHV16
XFILLER_117_1304 VDD VSS DECAPHV32
XFILLER_128_1422 VDD VSS FILLER4
XFILLER_76_1321 VDD VSS DECAPHV16
XFILLER_163_1368 VDD VSS DECAPHV16
XFILLER_122_1010 VDD VSS DECAPHV32
XFILLER_83_1336 VDD VSS DECAPHV32
XFILLER_133_1150 VDD VSS DECAPHV32
XFILLER_77_1118 VDD VSS DECAPHV32
XFILLER_168_1257 VDD VSS DECAPHV32
XFILLER_0_1414 VDD VSS DECAPHV8
XFILLER_19_993 VDD VSS DECAPHV16
XFILLER_179_1397 VDD VSS DECAPHV16
XFILLER_175_1206 VSS VDD FILLER2
XFILLER_101_1105 VDD VSS DECAPHV8
XTAP_TAPCELL_ROW_157_2_513 VDD VSS WELLTAP
XFILLER_112_1289 VDD VSS DECAPHV32
XTAP_TAPCELL_ROW_102_2_238 VDD VSS WELLTAP
XFILLER_145_1021 VDD VSS FILLER1
XFILLER_158_1426 VSS VDD FILLER2
XFILLER_130_1345 VSS VDD FILLER2
XFILLER_152_1058 VDD VSS DECAPHV8
XFILLER_113_1009 VDD VSS DECAPHV8
XFILLER_128_1252 VSS VDD FILLER2
XFILLER_76_1151 VDD VSS DECAPHV8
XFILLER_163_1198 VDD VSS DECAPHV8
XFILLER_102_1414 VDD VSS DECAPHV8
XFILLER_170_1103 VDD VSS DECAPHV32
XFILLER_139_1392 VSS VDD FILLER2
XFILLER_87_1291 VDD VSS DECAPHV8
Xi_sg13cmos5l_dsa1_dig_core.dsa1_dig VDD VSS i_sg13cmos5l_dsa1_dig_core.u_adc_conv_gate/A
+ clkbuf_1_0__f_clk_PAD2CORE/Y _3_/Q g_outputs\[0\].output_pad/c2p ANTENNA_7/A i_sg13cmos5l_dsa1_dig_core.dsa1_dig/o_aux_ctrl[0]
+ i_sg13cmos5l_dsa1_dig_core.dsa1_dig/o_aux_ctrl[10] i_sg13cmos5l_dsa1_dig_core.dsa1_dig/o_aux_ctrl[11]
+ i_sg13cmos5l_dsa1_dig_core.dsa1_dig/o_aux_ctrl[12] i_sg13cmos5l_dsa1_dig_core.dsa1_dig/o_aux_ctrl[13]
+ i_sg13cmos5l_dsa1_dig_core.dsa1_dig/o_aux_ctrl[14] i_sg13cmos5l_dsa1_dig_core.dsa1_dig/o_aux_ctrl[15]
+ i_sg13cmos5l_dsa1_dig_core.dsa1_dig/o_aux_ctrl[1] i_sg13cmos5l_dsa1_dig_core.dsa1_dig/o_aux_ctrl[2]
+ i_sg13cmos5l_dsa1_dig_core.dsa1_dig/o_aux_ctrl[3] i_sg13cmos5l_dsa1_dig_core.dsa1_dig/o_aux_ctrl[4]
+ i_sg13cmos5l_dsa1_dig_core.dsa1_dig/o_aux_ctrl[5] i_sg13cmos5l_dsa1_dig_core.dsa1_dig/o_aux_ctrl[6]
+ i_sg13cmos5l_dsa1_dig_core.dsa1_dig/o_aux_ctrl[7] i_sg13cmos5l_dsa1_dig_core.dsa1_dig/o_aux_ctrl[8]
+ i_sg13cmos5l_dsa1_dig_core.dsa1_dig/o_aux_ctrl[9] i_sg13cmos5l_dsa1_dig_core.dsa1_dig/o_bias_cfg[0]
+ i_sg13cmos5l_dsa1_dig_core.dsa1_dig/o_bias_cfg[10] i_sg13cmos5l_dsa1_dig_core.dsa1_dig/o_bias_cfg[11]
+ i_sg13cmos5l_dsa1_dig_core.dsa1_dig/o_bias_cfg[12] i_sg13cmos5l_dsa1_dig_core.dsa1_dig/o_bias_cfg[13]
+ i_sg13cmos5l_dsa1_dig_core.dsa1_dig/o_bias_cfg[14] i_sg13cmos5l_dsa1_dig_core.dsa1_dig/o_bias_cfg[15]
+ i_sg13cmos5l_dsa1_dig_core.dsa1_dig/o_bias_cfg[16] i_sg13cmos5l_dsa1_dig_core.dsa1_dig/o_bias_cfg[17]
+ i_sg13cmos5l_dsa1_dig_core.dsa1_dig/o_bias_cfg[18] dsm2/di_ena i_sg13cmos5l_dsa1_dig_core.dsa1_dig/o_bias_cfg[1]
+ dsm2/di_rst_b _1_/S0 dsm2/di_btest_en dsm2/di_vcm_ext dsm2/di_qout_en i_sg13cmos5l_dsa1_dig_core.u_adc_conv_gate/B
+ i_sg13cmos5l_dsa1_dig_core.dsa1_dig/o_bias_cfg[26] i_sg13cmos5l_dsa1_dig_core.dsa1_dig/o_bias_cfg[27]
+ i_sg13cmos5l_dsa1_dig_core.dsa1_dig/o_bias_cfg[28] i_sg13cmos5l_dsa1_dig_core.dsa1_dig/o_bias_cfg[29]
+ i_sg13cmos5l_dsa1_dig_core.dsa1_dig/o_bias_cfg[2] i_sg13cmos5l_dsa1_dig_core.dsa1_dig/o_bias_cfg[30]
+ i_sg13cmos5l_dsa1_dig_core.dsa1_dig/o_bias_cfg[31] i_sg13cmos5l_dsa1_dig_core.dsa1_dig/o_bias_cfg[32]
+ i_sg13cmos5l_dsa1_dig_core.dsa1_dig/o_bias_cfg[33] i_sg13cmos5l_dsa1_dig_core.dsa1_dig/o_bias_cfg[34]
+ dsm2/di_trim[0] dsm2/di_trim[1] dsm2/di_trim[2] dsm2/di_trim[3] dsm2/di_dith_en
+ dsm2/di_dith_amp[0] dsm2/di_dith_amp[1] i_sg13cmos5l_dsa1_dig_core.dsa1_dig/o_clk_cfg[0]
+ i_sg13cmos5l_dsa1_dig_core.dsa1_dig/o_clk_cfg[10] i_sg13cmos5l_dsa1_dig_core.dsa1_dig/o_clk_cfg[11]
+ i_sg13cmos5l_dsa1_dig_core.dsa1_dig/o_clk_cfg[12] i_sg13cmos5l_dsa1_dig_core.dsa1_dig/o_clk_cfg[13]
+ i_sg13cmos5l_dsa1_dig_core.dsa1_dig/o_clk_cfg[14] i_sg13cmos5l_dsa1_dig_core.dsa1_dig/o_clk_cfg[15]
+ i_sg13cmos5l_dsa1_dig_core.dsa1_dig/o_clk_cfg[16] i_sg13cmos5l_dsa1_dig_core.dsa1_dig/o_clk_cfg[17]
+ i_sg13cmos5l_dsa1_dig_core.dsa1_dig/o_clk_cfg[18] i_sg13cmos5l_dsa1_dig_core.dsa1_dig/o_clk_cfg[1]
+ i_sg13cmos5l_dsa1_dig_core.dsa1_dig/o_clk_cfg[2] i_sg13cmos5l_dsa1_dig_core.dsa1_dig/o_clk_cfg[3]
+ i_sg13cmos5l_dsa1_dig_core.dsa1_dig/o_clk_cfg[4] i_sg13cmos5l_dsa1_dig_core.dsa1_dig/o_clk_cfg[5]
+ i_sg13cmos5l_dsa1_dig_core.dsa1_dig/o_clk_cfg[6] i_sg13cmos5l_dsa1_dig_core.dsa1_dig/o_clk_cfg[7]
+ i_sg13cmos5l_dsa1_dig_core.dsa1_dig/o_clk_cfg[8] i_sg13cmos5l_dsa1_dig_core.dsa1_dig/o_clk_cfg[9]
+ i_sg13cmos5l_dsa1_dig_core.dsa1_dig/o_en_ctrl[0] i_sg13cmos5l_dsa1_dig_core.dsa1_dig/o_en_ctrl[10]
+ i_sg13cmos5l_dsa1_dig_core.dsa1_dig/o_en_ctrl[1] i_sg13cmos5l_dsa1_dig_core.dsa1_dig/o_en_ctrl[2]
+ i_sg13cmos5l_dsa1_dig_core.dsa1_dig/o_en_ctrl[3] i_sg13cmos5l_dsa1_dig_core.dsa1_dig/o_en_ctrl[4]
+ i_sg13cmos5l_dsa1_dig_core.dsa1_dig/o_en_ctrl[5] i_sg13cmos5l_dsa1_dig_core.dsa1_dig/o_en_ctrl[6]
+ i_sg13cmos5l_dsa1_dig_core.dsa1_dig/o_en_ctrl[7] i_sg13cmos5l_dsa1_dig_core.dsa1_dig/o_en_ctrl[8]
+ i_sg13cmos5l_dsa1_dig_core.dsa1_dig/o_en_ctrl[9] i_sg13cmos5l_dsa1_dig_core.dsa1_dig/o_lf_cfg[0]
+ i_sg13cmos5l_dsa1_dig_core.dsa1_dig/o_lf_cfg[10] i_sg13cmos5l_dsa1_dig_core.dsa1_dig/o_lf_cfg[11]
+ i_sg13cmos5l_dsa1_dig_core.dsa1_dig/o_lf_cfg[12] i_sg13cmos5l_dsa1_dig_core.dsa1_dig/o_lf_cfg[13]
+ i_sg13cmos5l_dsa1_dig_core.dsa1_dig/o_lf_cfg[14] i_sg13cmos5l_dsa1_dig_core.dsa1_dig/o_lf_cfg[15]
+ i_sg13cmos5l_dsa1_dig_core.dsa1_dig/o_lf_cfg[1] i_sg13cmos5l_dsa1_dig_core.dsa1_dig/o_lf_cfg[2]
+ i_sg13cmos5l_dsa1_dig_core.dsa1_dig/o_lf_cfg[3] i_sg13cmos5l_dsa1_dig_core.dsa1_dig/o_lf_cfg[4]
+ i_sg13cmos5l_dsa1_dig_core.dsa1_dig/o_lf_cfg[5] i_sg13cmos5l_dsa1_dig_core.dsa1_dig/o_lf_cfg[6]
+ i_sg13cmos5l_dsa1_dig_core.dsa1_dig/o_lf_cfg[7] i_sg13cmos5l_dsa1_dig_core.dsa1_dig/o_lf_cfg[8]
+ i_sg13cmos5l_dsa1_dig_core.dsa1_dig/o_lf_cfg[9] i_sg13cmos5l_dsa1_dig_core.dsa1_dig/o_rst_ctrl_b[0]
+ i_sg13cmos5l_dsa1_dig_core.dsa1_dig/o_rst_ctrl_b[1] i_sg13cmos5l_dsa1_dig_core.dsa1_dig/o_tst_ctrl[0]
+ i_sg13cmos5l_dsa1_dig_core.dsa1_dig/o_tst_ctrl[10] i_sg13cmos5l_dsa1_dig_core.dsa1_dig/o_tst_ctrl[11]
+ i_sg13cmos5l_dsa1_dig_core.dsa1_dig/o_tst_ctrl[12] i_sg13cmos5l_dsa1_dig_core.dsa1_dig/o_tst_ctrl[13]
+ i_sg13cmos5l_dsa1_dig_core.dsa1_dig/o_tst_ctrl[14] i_sg13cmos5l_dsa1_dig_core.dsa1_dig/o_tst_ctrl[15]
+ i_sg13cmos5l_dsa1_dig_core.dsa1_dig/o_tst_ctrl[1] i_sg13cmos5l_dsa1_dig_core.dsa1_dig/o_tst_ctrl[2]
+ i_sg13cmos5l_dsa1_dig_core.dsa1_dig/o_tst_ctrl[3] i_sg13cmos5l_dsa1_dig_core.dsa1_dig/o_tst_ctrl[4]
+ i_sg13cmos5l_dsa1_dig_core.dsa1_dig/o_tst_ctrl[5] i_sg13cmos5l_dsa1_dig_core.dsa1_dig/o_tst_ctrl[6]
+ i_sg13cmos5l_dsa1_dig_core.dsa1_dig/o_tst_ctrl[7] i_sg13cmos5l_dsa1_dig_core.dsa1_dig/o_tst_ctrl[8]
+ i_sg13cmos5l_dsa1_dig_core.dsa1_dig/o_tst_ctrl[9] i_sg13cmos5l_dsa1_dig_core.dsa1_dig/o_uwb_tx_cfg[0]
+ i_sg13cmos5l_dsa1_dig_core.dsa1_dig/o_uwb_tx_cfg[10] i_sg13cmos5l_dsa1_dig_core.dsa1_dig/o_uwb_tx_cfg[11]
+ i_sg13cmos5l_dsa1_dig_core.dsa1_dig/o_uwb_tx_cfg[12] i_sg13cmos5l_dsa1_dig_core.dsa1_dig/o_uwb_tx_cfg[13]
+ i_sg13cmos5l_dsa1_dig_core.dsa1_dig/o_uwb_tx_cfg[14] i_sg13cmos5l_dsa1_dig_core.dsa1_dig/o_uwb_tx_cfg[15]
+ i_sg13cmos5l_dsa1_dig_core.dsa1_dig/o_uwb_tx_cfg[16] i_sg13cmos5l_dsa1_dig_core.dsa1_dig/o_uwb_tx_cfg[17]
+ i_sg13cmos5l_dsa1_dig_core.dsa1_dig/o_uwb_tx_cfg[18] i_sg13cmos5l_dsa1_dig_core.dsa1_dig/o_uwb_tx_cfg[19]
+ i_sg13cmos5l_dsa1_dig_core.dsa1_dig/o_uwb_tx_cfg[1] i_sg13cmos5l_dsa1_dig_core.dsa1_dig/o_uwb_tx_cfg[20]
+ i_sg13cmos5l_dsa1_dig_core.dsa1_dig/o_uwb_tx_cfg[21] i_sg13cmos5l_dsa1_dig_core.dsa1_dig/o_uwb_tx_cfg[22]
+ i_sg13cmos5l_dsa1_dig_core.dsa1_dig/o_uwb_tx_cfg[23] i_sg13cmos5l_dsa1_dig_core.dsa1_dig/o_uwb_tx_cfg[24]
+ i_sg13cmos5l_dsa1_dig_core.dsa1_dig/o_uwb_tx_cfg[25] i_sg13cmos5l_dsa1_dig_core.dsa1_dig/o_uwb_tx_cfg[26]
+ i_sg13cmos5l_dsa1_dig_core.dsa1_dig/o_uwb_tx_cfg[27] i_sg13cmos5l_dsa1_dig_core.dsa1_dig/o_uwb_tx_cfg[28]
+ i_sg13cmos5l_dsa1_dig_core.dsa1_dig/o_uwb_tx_cfg[29] i_sg13cmos5l_dsa1_dig_core.dsa1_dig/o_uwb_tx_cfg[2]
+ i_sg13cmos5l_dsa1_dig_core.dsa1_dig/o_uwb_tx_cfg[3] i_sg13cmos5l_dsa1_dig_core.dsa1_dig/o_uwb_tx_cfg[4]
+ i_sg13cmos5l_dsa1_dig_core.dsa1_dig/o_uwb_tx_cfg[5] i_sg13cmos5l_dsa1_dig_core.dsa1_dig/o_uwb_tx_cfg[6]
+ i_sg13cmos5l_dsa1_dig_core.dsa1_dig/o_uwb_tx_cfg[7] i_sg13cmos5l_dsa1_dig_core.dsa1_dig/o_uwb_tx_cfg[8]
+ i_sg13cmos5l_dsa1_dig_core.dsa1_dig/o_uwb_tx_cfg[9] _4_/RB g_inputs\[1\].input_pad/p2c
+ ANTENNA_4/A dsa1_dig_top
XFILLER_168_1010 VDD VSS DECAPHV32
XFILLER_107_1336 VDD VSS DECAPHV32
XFILLER_90_1159 VSS VDD FILLER2
XFILLER_167_949 VDD VSS DECAPHV32
XFILLER_179_1150 VDD VSS DECAPHV32
XFILLER_175_1003 VDD VSS DECAPHV16
XFILLER_175_1025 VDD VSS DECAPHV32
XFILLER_88_1066 VSS VDD FILLER2
XFILLER_175_971 VDD VSS DECAPHV32
XFILLER_112_1042 VDD VSS DECAPHV16
XFILLER_147_1105 VDD VSS DECAPHV8
XTAP_TAPCELL_ROW_96_2_211 VDD VSS WELLTAP
XFILLER_125_1425 VSS VDD FILLER2
XFILLER_123_1182 VDD VSS DECAPHV16
XFILLER_73_1368 VDD VSS DECAPHV16
XFILLER_32_1010 VDD VSS FILLER1
XFILLER_158_1289 VDD VSS DECAPHV32
XTAP_TAPCELL_ROW_156_2_512 VDD VSS WELLTAP
XFILLER_130_1164 VDD VSS DECAPHV32
XFILLER_78_1257 VDD VSS DECAPHV32
XFILLER_91_1413 VDD VSS DECAPHV8
XFILLER_128_1071 VDD VSS DECAPHV32
XFILLER_176_1345 VSS VDD FILLER2
XFILLER_102_1244 VDD VSS DECAPHV8
XFILLER_89_1397 VDD VSS DECAPHV16
XFILLER_85_1206 VSS VDD FILLER2
XIO_FILL_IO_SOUTH_0_0 IOVDD IOVSS VDD VSS sg13cmos5l_Filler4000
XFILLER_157_993 VDD VSS DECAPHV16
XFILLER_159_1009 VDD VSS DECAPHV8
XTAP_TAPCELL_ROW_101_2_237 VDD VSS WELLTAP
XFILLER_86_969 VDD VSS FILLER4
XFILLER_148_1414 VDD VSS DECAPHV8
XFILLER_113_1384 VDD VSS DECAPHV8
XTAP_TAPCELL_ROW_99_2_226 VDD VSS WELLTAP
XFILLER_10_969 VDD VSS FILLER4
XFILLER_6_929 VDD VSS DECAPHV32
XFILLER_68_1426 VSS VDD FILLER2
XFILLER_114_1159 VSS VDD FILLER2
XFILLER_23_1009 VSS VDD FILLER2
XFILLER_160_1135 VDD VSS DECAPHV16
XTAP_TAPCELL_ROW_159_2_527 VDD VSS WELLTAP
XFILLER_125_1211 VDD VSS DECAPHV32
XFILLER_73_1198 VDD VSS DECAPHV8
XFILLER_125_1299 VSS VDD FILLER2
XFILLER_158_1042 VDD VSS DECAPHV16
XFILLER_139_993 VDD VSS DECAPHV16
XFILLER_171_1275 VDD VSS DECAPHV16
XFILLER_80_1103 VDD VSS DECAPHV32
XTAP_TAPCELL_ROW_4_2_20 VDD VSS WELLTAP
XFILLER_68_969 VDD VSS FILLER4
XFILLER_169_1182 VDD VSS DECAPHV16
XFILLER_165_1057 VDD VSS DECAPHV32
XFILLER_78_1010 VDD VSS DECAPHV32
XFILLER_91_961 VDD VSS DECAPHV32
XFILLER_91_1243 VDD VSS DECAPHV32
XFILLER_176_1164 VDD VSS DECAPHV32
XFILLER_89_1150 VDD VSS DECAPHV32
XFILLER_85_1025 VDD VSS DECAPHV32
XTAP_TAPCELL_ROW_176_2_608 VDD VSS WELLTAP
XFILLER_150_1337 VDD VSS DECAPHV8
XFILLER_115_1413 VDD VSS DECAPHV8
XFILLER_2_1103 VDD VSS DECAPHV32
XFILLER_148_1244 VDD VSS DECAPHV8
XFILLER_109_1206 VSS VDD FILLER2
XFILLER_82_961 VDD VSS DECAPHV8
XFILLER_120_1196 VDD VSS DECAPHV32
XFILLER_159_1384 VDD VSS DECAPHV8
XFILLER_68_1289 VDD VSS DECAPHV32
XFILLER_73_961 VDD VSS DECAPHV32
XFILLER_173_1304 VDD VSS DECAPHV32
XFILLER_86_1345 VSS VDD FILLER2
XFILLER_69_1009 VDD VSS DECAPHV8
XFILLER_110_1321 VDD VSS DECAPHV16
XFILLER_64_961 VDD VSS DECAPHV8
XFILLER_104_1103 VDD VSS DECAPHV32
XIO_FILL_IO_NORTH_0_20 IOVDD IOVSS VDD VSS sg13cmos5l_Filler2000
XFILLER_115_1243 VDD VSS DECAPHV32
XTAP_TAPCELL_ROW_166_2_561 VDD VSS WELLTAP
XFILLER_111_1118 VDD VSS DECAPHV32
XFILLER_55_961 VDD VSS DECAPHV32
XFILLER_126_1350 VDD VSS DECAPHV32
XFILLER_70_1135 VDD VSS DECAPHV16
XFILLER_109_1025 VDD VSS DECAPHV32
XFILLER_68_1042 VDD VSS DECAPHV16
XFILLER_155_1089 VDD VSS DECAPHV16
XTAP_TAPCELL_ROW_111_2_286 VDD VSS WELLTAP
XFILLER_81_1275 VDD VSS DECAPHV16
XTAP_TAPCELL_ROW_175_2_607 VDD VSS WELLTAP
XFILLER_166_1196 VDD VSS DECAPHV32
XFILLER_79_1182 VDD VSS DECAPHV16
XFILLER_46_961 VDD VSS DECAPHV8
XFILLER_75_1057 VDD VSS DECAPHV32
XFILLER_92_1382 VDD VSS DECAPHV32
XANTENNA_17 _4_/RB VDD VSS ANTENNA2
XFILLER_151_1421 VDD VSS FILLER4
XFILLER_86_1164 VDD VSS DECAPHV32
XTAP_TAPCELL_ROW_71_2_84 VDD VSS WELLTAP
XFILLER_130_969 VDD VSS FILLER4
XFILLER_110_1151 VDD VSS DECAPHV8
XFILLER_93_1113 VSS VDD FILLER2
XFILLER_3_1275 VDD VSS DECAPHV16
XFILLER_37_961 VDD VSS DECAPHV32
XTAP_TAPCELL_ROW_169_2_576 VDD VSS WELLTAP
XFILLER_156_1321 VDD VSS DECAPHV16
XFILLER_121_1291 VDD VSS DECAPHV8
XFILLER_69_1384 VDD VSS DECAPHV8
XFILLER_4_1017 VSS VDD FILLER2
Xdelaybuf_1_clk delaybuf_1_clk/A VDD VSS delaybuf_2_clk/A BUFX12
XFILLER_163_1336 VDD VSS DECAPHV32
XFILLER_28_972 VSS VDD FILLER2
XTAP_TAPCELL_ROW_97_2_213 VDD VSS WELLTAP
XFILLER_122_1066 VSS VDD FILLER2
XFILLER_157_1118 VDD VSS DECAPHV32
XFILLER_135_1427 VDD VSS FILLER1
XFILLER_83_1304 VDD VSS DECAPHV32
XFILLER_112_969 VDD VSS FILLER4
XFILLER_94_1422 VDD VSS FILLER4
XFILLER_19_961 VDD VSS DECAPHV32
XTAP_TAPCELL_ROW_157_2_514 VDD VSS WELLTAP
XFILLER_105_1275 VDD VSS DECAPHV16
XFILLER_116_1382 VDD VSS DECAPHV32
XFILLER_112_1257 VDD VSS DECAPHV32
XFILLER_123_1397 VDD VSS DECAPHV16
XFILLER_40_978 VDD VSS DECAPHV32
XTAP_TAPCELL_ROW_102_2_239 VDD VSS WELLTAP
XFILLER_156_1151 VDD VSS DECAPHV8
XFILLER_117_1113 VSS VDD FILLER2
XFILLER_167_1291 VDD VSS DECAPHV8
XFILLER_76_1196 VDD VSS DECAPHV32
XTAP_TAPCELL_ROW_22_2_34 VDD VSS WELLTAP
XFILLER_102_1426 VSS VDD FILLER2
XFILLER_170_1159 VSS VDD FILLER2
XFILLER_98_978 VDD VSS DECAPHV32
XFILLER_94_1252 VSS VDD FILLER2
XFILLER_0_1234 VDD VSS DECAPHV8
XFILLER_168_1066 VSS VDD FILLER2
XFILLER_129_1017 VDD VSS FILLER4
XFILLER_142_1228 VDD VSS DECAPHV16
XFILLER_107_1304 VDD VSS DECAPHV32
XFILLER_22_978 VDD VSS DECAPHV32
XFILLER_118_1422 VDD VSS FILLER4
XFILLER_153_1368 VDD VSS DECAPHV16
XTAP_TAPCELL_ROW_96_2_212 VDD VSS WELLTAP
XFILLER_1_1009 VDD VSS DECAPHV8
XFILLER_112_1010 VDD VSS DECAPHV32
XFILLER_73_1336 VDD VSS DECAPHV32
XFILLER_123_1150 VDD VSS DECAPHV32
XFILLER_67_1107 VSS VDD FILLER2
XFILLER_171_1413 VDD VSS DECAPHV8
XFILLER_158_1257 VDD VSS DECAPHV32
XTAP_TAPCELL_ROW_52_2_49 VDD VSS WELLTAP
XFILLER_169_1397 VDD VSS DECAPHV16
XFILLER_165_1206 VSS VDD FILLER2
XFILLER_91_1425 VSS VDD FILLER2
XFILLER_157_961 VDD VSS DECAPHV32
XFILLER_102_1289 VDD VSS DECAPHV32
XIO_FILL_IO_WEST_0_35 IOVDD IOVSS VDD VSS sg13cmos5l_Filler400
XFILLER_172_931 VSS VDD FILLER2
XFILLER_135_1021 VDD VSS FILLER1
XFILLER_148_1426 VSS VDD FILLER2
XFILLER_94_1071 VDD VSS DECAPHV32
XIO_FILL_IO_NORTH_3_20 IOVDD IOVSS VDD VSS sg13cmos5l_Filler400
XFILLER_120_1345 VSS VDD FILLER2
XTAP_TAPCELL_ROW_99_2_227 VDD VSS WELLTAP
XFILLER_142_1058 VDD VSS DECAPHV8
XFILLER_103_1009 VDD VSS DECAPHV8
XFILLER_148_961 VDD VSS DECAPHV8
XFILLER_118_1252 VSS VDD FILLER2
XFILLER_153_1198 VDD VSS DECAPHV8
XFILLER_92_929 VDD VSS DECAPHV32
XFILLER_160_1103 VDD VSS DECAPHV32
XFILLER_129_1392 VSS VDD FILLER2
XFILLER_77_1291 VDD VSS DECAPHV8
XTAP_TAPCELL_ROW_167_2_563 VDD VSS WELLTAP
XFILLER_139_961 VDD VSS DECAPHV32
XFILLER_158_1010 VDD VSS DECAPHV32
XFILLER_171_1243 VDD VSS DECAPHV32
XTAP_TAPCELL_ROW_138_2_420 VDD VSS WELLTAP
XFILLER_80_1159 VSS VDD FILLER2
XTAP_TAPCELL_ROW_4_2_21 VDD VSS WELLTAP
XFILLER_83_929 VDD VSS DECAPHV32
XFILLER_169_1150 VDD VSS DECAPHV32
XFILLER_91_1211 VDD VSS DECAPHV32
XFILLER_1_1384 VDD VSS DECAPHV8
XFILLER_78_1066 VSS VDD FILLER2
XFILLER_165_1025 VDD VSS DECAPHV32
XFILLER_91_1299 VSS VDD FILLER2
XFILLER_102_1042 VDD VSS DECAPHV16
XTAP_TAPCELL_ROW_112_2_288 VDD VSS WELLTAP
XFILLER_137_1105 VDD VSS DECAPHV8
XFILLER_115_1425 VSS VDD FILLER2
XTAP_TAPCELL_ROW_176_2_609 VDD VSS WELLTAP
XFILLER_160_978 VDD VSS DECAPHV32
XFILLER_113_1182 VDD VSS DECAPHV16
XFILLER_2_1159 VSS VDD FILLER2
XFILLER_74_929 VDD VSS DECAPHV32
XFILLER_22_1010 VDD VSS FILLER1
XFILLER_82_973 VSS VDD FILLER2
XFILLER_148_1289 VDD VSS DECAPHV32
XFILLER_120_1164 VDD VSS DECAPHV32
XFILLER_68_1257 VDD VSS DECAPHV32
XFILLER_81_1413 VDD VSS DECAPHV8
XFILLER_65_929 VDD VSS DECAPHV32
XFILLER_118_1071 VDD VSS DECAPHV32
XFILLER_166_1345 VSS VDD FILLER2
XFILLER_79_1397 VDD VSS DECAPHV16
XFILLER_75_1206 VSS VDD FILLER2
XFILLER_149_1009 VDD VSS DECAPHV8
XFILLER_138_1414 VDD VSS DECAPHV8
XFILLER_103_1384 VDD VSS DECAPHV8
XFILLER_142_978 VDD VSS DECAPHV32
XFILLER_3_1413 VDD VSS DECAPHV8
XFILLER_56_929 VDD VSS DECAPHV32
XFILLER_64_973 VSS VDD FILLER2
XFILLER_104_1159 VSS VDD FILLER2
XFILLER_13_1009 VSS VDD FILLER2
XFILLER_150_1135 VDD VSS DECAPHV16
XFILLER_115_1211 VDD VSS DECAPHV32
XFILLER_47_929 VDD VSS DECAPHV32
XTAP_TAPCELL_ROW_166_2_562 VDD VSS WELLTAP
XFILLER_115_1299 VSS VDD FILLER2
XFILLER_98_1228 VDD VSS DECAPHV16
XFILLER_148_1042 VDD VSS DECAPHV16
XFILLER_161_1275 VDD VSS DECAPHV16
XFILLER_70_1103 VDD VSS DECAPHV32
XFILLER_159_1182 VDD VSS DECAPHV16
XFILLER_155_1057 VDD VSS DECAPHV32
XFILLER_68_1010 VDD VSS DECAPHV32
XFILLER_124_978 VDD VSS DECAPHV32
XFILLER_172_1382 VDD VSS DECAPHV32
XTAP_TAPCELL_ROW_111_2_287 VDD VSS WELLTAP
XFILLER_81_1243 VDD VSS DECAPHV32
XFILLER_79_1150 VDD VSS DECAPHV32
XFILLER_38_929 VDD VSS DECAPHV32
XFILLER_166_1164 VDD VSS DECAPHV32
XFILLER_105_1413 VDD VSS DECAPHV8
XFILLER_92_1350 VDD VSS DECAPHV32
XFILLER_46_973 VSS VDD FILLER2
XFILLER_75_1025 VDD VSS DECAPHV32
XANTENNA_18 _4_/RB VDD VSS ANTENNA2
XFILLER_140_1337 VDD VSS DECAPHV8
XFILLER_173_1113 VSS VDD FILLER2
XFILLER_138_1244 VDD VSS DECAPHV8
XTAP_TAPCELL_ROW_71_2_85 VDD VSS WELLTAP
XFILLER_29_929 VDD VSS DECAPHV32
XTAP_TAPCELL_ROW_154_2_500 VDD VSS WELLTAP
XFILLER_149_1384 VDD VSS DECAPHV8
XFILLER_110_1196 VDD VSS DECAPHV32
XFILLER_3_1243 VDD VSS DECAPHV32
XTAP_TAPCELL_ROW_169_2_577 VDD VSS WELLTAP
XFILLER_106_978 VDD VSS DECAPHV32
XFILLER_59_1009 VSS VDD FILLER2
XFILLER_98_1058 VDD VSS DECAPHV8
XFILLER_163_1304 VDD VSS DECAPHV32
XFILLER_76_1345 VSS VDD FILLER2
XFILLER_100_1321 VDD VSS DECAPHV16
XTAP_TAPCELL_ROW_97_2_214 VDD VSS WELLTAP
XFILLER_174_1422 VDD VSS FILLER4
XFILLER_0_1427 VDD VSS FILLER1
XTAP_TAPCELL_ROW_157_2_515 VDD VSS WELLTAP
XFILLER_105_1243 VDD VSS DECAPHV32
XIO_FILL_IO_WEST_3_35 IOVDD IOVSS VDD VSS sg13cmos5l_Filler200
XFILLER_101_1118 VDD VSS DECAPHV32
XIO_FILL_IO_NORTH_6_20 IOVDD IOVSS VDD VSS sg13cmos5l_Filler2000
XFILLER_116_1350 VDD VSS DECAPHV32
XIO_BOND_clk_pad clk_PAD sg13cmos5l_ip__bondpad_70x70
XFILLER_145_1089 VDD VSS DECAPHV16
XFILLER_71_1275 VDD VSS DECAPHV16
XFILLER_156_1196 VDD VSS DECAPHV32
XFILLER_82_1382 VDD VSS DECAPHV32
XFILLER_69_1182 VDD VSS DECAPHV16
XIO_FILL_IO_SOUTH_0_20 IOVDD IOVSS VDD VSS sg13cmos5l_Filler1000
XFILLER_141_1421 VDD VSS FILLER4
XFILLER_76_1164 VDD VSS DECAPHV32
XFILLER_176_929 VDD VSS FILLER1
XFILLER_174_1252 VSS VDD FILLER2
XFILLER_100_1151 VDD VSS DECAPHV8
XFILLER_83_1113 VSS VDD FILLER2
XFILLER_100_929 VDD VSS DECAPHV32
XFILLER_146_1321 VDD VSS DECAPHV16
XFILLER_111_1291 VDD VSS DECAPHV8
XFILLER_4_1382 VDD VSS DECAPHV32
XFILLER_0_1279 VDD VSS DECAPHV8
XFILLER_0_1202 VDD VSS DECAPHV32
XFILLER_153_1336 VDD VSS DECAPHV32
XTAP_TAPCELL_ROW_38_2_42 VDD VSS WELLTAP
XFILLER_147_1118 VDD VSS DECAPHV32
XFILLER_95_1017 VDD VSS FILLER4
XFILLER_112_1066 VSS VDD FILLER2
XFILLER_125_1427 VDD VSS FILLER1
XFILLER_73_1304 VDD VSS DECAPHV32
XFILLER_158_929 VDD VSS DECAPHV32
XFILLER_84_1422 VDD VSS FILLER4
XFILLER_166_973 VSS VDD FILLER2
XFILLER_171_1425 VSS VDD FILLER2
XFILLER_106_1382 VDD VSS DECAPHV32
XFILLER_8_961 VDD VSS DECAPHV8
XFILLER_149_929 VDD VSS DECAPHV32
XFILLER_102_1257 VDD VSS DECAPHV32
XFILLER_174_1071 VDD VSS DECAPHV32
XFILLER_113_1397 VDD VSS DECAPHV16
XFILLER_96_1337 VDD VSS DECAPHV8
XTAP_TAPCELL_ROW_68_2_68 VDD VSS WELLTAP
XFILLER_146_1151 VDD VSS DECAPHV8
XFILLER_107_1113 VSS VDD FILLER2
XFILLER_0_1054 VDD VSS DECAPHV8
XFILLER_148_973 VSS VDD FILLER2
XFILLER_157_1291 VDD VSS DECAPHV8
XTAP_TAPCELL_ROW_78_2_120 VDD VSS WELLTAP
XFILLER_85_993 VDD VSS DECAPHV16
XTAP_TAPCELL_ROW_167_2_564 VDD VSS WELLTAP
XFILLER_160_1159 VSS VDD FILLER2
XFILLER_171_1211 VDD VSS DECAPHV32
XFILLER_84_1252 VSS VDD FILLER2
XFILLER_158_1066 VSS VDD FILLER2
XFILLER_119_1017 VDD VSS FILLER4
XFILLER_171_1299 VSS VDD FILLER2
XTAP_TAPCELL_ROW_138_2_421 VDD VSS WELLTAP
XFILLER_132_1228 VDD VSS DECAPHV16
XTAP_TAPCELL_ROW_4_2_22 VDD VSS WELLTAP
XFILLER_108_1422 VDD VSS FILLER4
XFILLER_95_1392 VSS VDD FILLER2
XFILLER_143_1368 VDD VSS DECAPHV16
XFILLER_102_1010 VDD VSS DECAPHV32
XTAP_TAPCELL_ROW_112_2_289 VDD VSS WELLTAP
XFILLER_148_1257 VDD VSS DECAPHV32
XFILLER_113_1150 VDD VSS DECAPHV32
XFILLER_161_1413 VDD VSS DECAPHV8
XFILLER_159_1397 VDD VSS DECAPHV16
XFILLER_155_1206 VSS VDD FILLER2
XFILLER_81_1425 VSS VDD FILLER2
XFILLER_2_978 VDD VSS DECAPHV32
Xclk_pad IOVDD IOVSS clk_pad/p2c clk_PAD VDD VSS sg13cmos5l_IOPadIn
XFILLER_125_1021 VDD VSS FILLER1
XFILLER_138_1426 VSS VDD FILLER2
XFILLER_84_1071 VDD VSS DECAPHV32
XFILLER_110_1345 VSS VDD FILLER2
XFILLER_97_1421 VDD VSS FILLER4
XFILLER_3_1425 VSS VDD FILLER2
XFILLER_49_993 VDD VSS DECAPHV16
XFILLER_132_1058 VDD VSS DECAPHV8
XFILLER_143_1198 VDD VSS DECAPHV8
XFILLER_108_1252 VSS VDD FILLER2
XFILLER_1_1182 VDD VSS DECAPHV16
XFILLER_178_1228 VDD VSS DECAPHV16
XFILLER_150_1103 VDD VSS DECAPHV32
XFILLER_119_1392 VSS VDD FILLER2
XFILLER_148_1010 VDD VSS DECAPHV32
XFILLER_161_1243 VDD VSS DECAPHV32
XFILLER_70_1159 VSS VDD FILLER2
XFILLER_172_1350 VDD VSS DECAPHV32
XFILLER_159_1150 VDD VSS DECAPHV32
XFILLER_81_1211 VDD VSS DECAPHV32
XFILLER_68_1066 VSS VDD FILLER2
XFILLER_155_1025 VDD VSS DECAPHV32
XTAP_TAPCELL_ROW_94_2_200 VDD VSS WELLTAP
XFILLER_81_1299 VSS VDD FILLER2
XFILLER_127_1105 VDD VSS DECAPHV8
XFILLER_105_1425 VSS VDD FILLER2
XANTENNA_19 _4_/RB VDD VSS ANTENNA2
XFILLER_103_1182 VDD VSS DECAPHV16
XFILLER_12_1010 VDD VSS FILLER1
XTAP_TAPCELL_ROW_154_2_501 VDD VSS WELLTAP
XFILLER_138_1289 VDD VSS DECAPHV32
XTAP_TAPCELL_ROW_71_2_86 VDD VSS WELLTAP
XFILLER_3_1211 VDD VSS DECAPHV32
XFILLER_180_1107 VSS VDD FILLER2
XFILLER_110_1164 VDD VSS DECAPHV32
XFILLER_3_1299 VSS VDD FILLER2
XFILLER_71_1413 VDD VSS DECAPHV8
XFILLER_108_1071 VDD VSS DECAPHV32
XFILLER_156_1345 VSS VDD FILLER2
XFILLER_69_1397 VDD VSS DECAPHV16
XFILLER_178_1058 VDD VSS DECAPHV8
XFILLER_139_1009 VDD VSS DECAPHV8
XTAP_TAPCELL_ROW_148_2_470 VDD VSS WELLTAP
XFILLER_28_974 VDD VSS FILLER1
Xclkbuf_1_0__f_clk_PAD2CORE_regs clkbuf_0_clk_PAD2CORE_regs/Y VDD VSS _4_/CK BUFX12
XFILLER_128_1414 VDD VSS DECAPHV8
XTAP_TAPCELL_ROW_97_2_215 VDD VSS WELLTAP
XTAP_TAPCELL_ROW_157_2_516 VDD VSS WELLTAP
XFILLER_140_1135 VDD VSS DECAPHV16
XFILLER_105_1299 VSS VDD FILLER2
XFILLER_105_1211 VDD VSS DECAPHV32
XFILLER_88_1228 VDD VSS DECAPHV16
XFILLER_138_1042 VDD VSS DECAPHV16
XFILLER_151_1275 VDD VSS DECAPHV16
XFILLER_99_1368 VDD VSS DECAPHV16
XFILLER_111_993 VDD VSS DECAPHV16
XFILLER_149_1182 VDD VSS DECAPHV16
XFILLER_71_1243 VDD VSS DECAPHV32
XFILLER_145_1057 VDD VSS DECAPHV32
XFILLER_40_969 VDD VSS FILLER4
XFILLER_58_1010 VDD VSS FILLER1
XFILLER_178_971 VDD VSS FILLER4
XFILLER_162_1382 VDD VSS DECAPHV32
XFILLER_69_1150 VDD VSS DECAPHV32
XFILLER_156_1164 VDD VSS DECAPHV32
XFILLER_82_1350 VDD VSS DECAPHV32
XFILLER_163_1113 VSS VDD FILLER2
XFILLER_130_1337 VDD VSS DECAPHV8
XFILLER_128_1244 VDD VSS DECAPHV8
XFILLER_139_1384 VDD VSS DECAPHV8
XFILLER_100_1196 VDD VSS DECAPHV32
XFILLER_98_969 VDD VSS FILLER4
XFILLER_0_1247 VDD VSS DECAPHV32
XFILLER_22_969 VDD VSS FILLER4
XFILLER_49_1009 VSS VDD FILLER2
XFILLER_88_1058 VDD VSS DECAPHV8
XTAP_TAPCELL_ROW_139_2_423 VDD VSS WELLTAP
XFILLER_153_1304 VDD VSS DECAPHV32
XFILLER_99_1198 VDD VSS DECAPHV8
XFILLER_164_1422 VDD VSS FILLER4
XFILLER_9_929 VDD VSS DECAPHV32
XTAP_TAPCELL_ROW_164_2_550 VDD VSS WELLTAP
XFILLER_91_1427 VDD VSS FILLER1
XFILLER_106_1350 VDD VSS DECAPHV32
XFILLER_8_973 VSS VDD FILLER2
XIO_FILL_IO_WEST_0_37 IOVDD IOVSS VDD VSS sg13cmos5l_Filler200
XFILLER_176_1337 VDD VSS DECAPHV8
XFILLER_135_1089 VDD VSS DECAPHV16
XFILLER_0_1022 VDD VSS DECAPHV32
XTAP_TAPCELL_ROW_68_2_69 VDD VSS WELLTAP
XFILLER_94_961 VDD VSS DECAPHV8
XFILLER_146_1196 VDD VSS DECAPHV32
XFILLER_72_1382 VDD VSS DECAPHV32
XFILLER_0_1099 VDD VSS DECAPHV8
XIO_FILL_IO_NORTH_3_22 IOVDD IOVSS VDD VSS sg13cmos5l_Filler400
XFILLER_131_1421 VDD VSS FILLER4
XFILLER_85_961 VDD VSS DECAPHV32
XFILLER_164_1252 VSS VDD FILLER2
XTAP_TAPCELL_ROW_78_2_121 VDD VSS WELLTAP
XFILLER_73_1113 VSS VDD FILLER2
XTAP_TAPCELL_ROW_167_2_565 VDD VSS WELLTAP
XFILLER_175_1392 VSS VDD FILLER2
XFILLER_136_1321 VDD VSS DECAPHV16
XFILLER_101_1291 VDD VSS DECAPHV8
XTAP_TAPCELL_ROW_138_2_422 VDD VSS WELLTAP
XTAP_TAPCELL_ROW_4_2_23 VDD VSS WELLTAP
XFILLER_76_961 VDD VSS DECAPHV8
XFILLER_143_1336 VDD VSS DECAPHV32
XFILLER_1_1397 VDD VSS DECAPHV16
XFILLER_137_1118 VDD VSS DECAPHV32
XFILLER_85_1017 VDD VSS FILLER4
XFILLER_102_1066 VSS VDD FILLER2
XFILLER_115_1427 VDD VSS FILLER1
Xdsm2 dsm2/vi dsm2/vcm ib_pad/padres dsm2/do_q_b dsm2/do_q dsm2/di_clk ANTENNA_1/A
+ dsm2/di_qout_en dsm2/di_btest_en dsm2/di_vcm_ext dsm2/di_dith_amp[1] dsm2/di_dith_amp[0]
+ dsm2/di_dith_en dsm2/di_trim[3] dsm2/di_trim[2] dsm2/di_trim[1] dsm2/di_trim[0]
+ dsm2/di_rst_b dsm2/di_ena VDDA VSS dsm2_core
XFILLER_67_961 VDD VSS DECAPHV8
XFILLER_160_969 VDD VSS FILLER4
XFILLER_96_1135 VDD VSS DECAPHV16
XFILLER_74_1422 VDD VSS FILLER4
XFILLER_161_1425 VSS VDD FILLER2
XTAP_TAPCELL_ROW_155_2_503 VDD VSS WELLTAP
XFILLER_58_961 VDD VSS DECAPHV8
XFILLER_164_1071 VDD VSS DECAPHV32
XFILLER_177_1421 VDD VSS FILLER4
XFILLER_103_1397 VDD VSS DECAPHV16
XFILLER_86_1337 VDD VSS DECAPHV8
XTAP_TAPCELL_ROW_100_2_228 VDD VSS WELLTAP
XFILLER_136_1151 VDD VSS DECAPHV8
XFILLER_49_961 VDD VSS DECAPHV32
XFILLER_142_969 VDD VSS FILLER4
XFILLER_1_1150 VDD VSS DECAPHV32
XTAP_TAPCELL_ROW_180_2_630 VDD VSS WELLTAP
XFILLER_147_1291 VDD VSS DECAPHV8
XFILLER_91_1021 VDD VSS FILLER1
XFILLER_67_1292 VDD VSS DECAPHV32
XFILLER_150_1159 VSS VDD FILLER2
XTAP_TAPCELL_ROW_158_2_518 VDD VSS WELLTAP
XFILLER_161_1211 VDD VSS DECAPHV32
XFILLER_74_1252 VSS VDD FILLER2
XFILLER_148_1066 VSS VDD FILLER2
XFILLER_70_978 VDD VSS DECAPHV32
XFILLER_109_1017 VDD VSS FILLER4
XFILLER_161_1299 VSS VDD FILLER2
XFILLER_122_1228 VDD VSS DECAPHV16
Xdelaybuf_4_clk delaybuf_4_clk/A VDD VSS delaybuf_5_clk/A BUFX12
XFILLER_85_1392 VSS VDD FILLER2
XFILLER_124_969 VDD VSS FILLER4
XFILLER_133_1368 VDD VSS DECAPHV16
XTAP_TAPCELL_ROW_94_2_201 VDD VSS WELLTAP
XFILLER_138_1257 VDD VSS DECAPHV32
XFILLER_103_1150 VDD VSS DECAPHV32
XTAP_TAPCELL_ROW_154_2_502 VDD VSS WELLTAP
XFILLER_151_1413 VDD VSS DECAPHV8
XTAP_TAPCELL_ROW_71_2_87 VDD VSS WELLTAP
XFILLER_149_1397 VDD VSS DECAPHV16
XFILLER_145_1206 VSS VDD FILLER2
XFILLER_93_1105 VDD VSS DECAPHV8
XTAP_TAPCELL_ROW_88_2_170 VDD VSS WELLTAP
XFILLER_71_1425 VSS VDD FILLER2
XFILLER_52_978 VDD VSS DECAPHV32
Xjku_names sg13cmos5l_ip__jku_names
XFILLER_106_969 VDD VSS FILLER4
XFILLER_115_1021 VDD VSS FILLER1
XTAP_TAPCELL_ROW_148_2_471 VDD VSS WELLTAP
XFILLER_4_1009 VDD VSS DECAPHV8
XFILLER_128_1426 VSS VDD FILLER2
XFILLER_74_1071 VDD VSS DECAPHV32
XFILLER_100_1345 VSS VDD FILLER2
XTAP_TAPCELL_ROW_97_2_216 VDD VSS WELLTAP
XFILLER_87_1421 VDD VSS FILLER4
XFILLER_122_1058 VDD VSS DECAPHV8
XFILLER_133_1198 VDD VSS DECAPHV8
XFILLER_120_961 VDD VSS DECAPHV8
XFILLER_168_1228 VDD VSS DECAPHV16
XFILLER_94_1414 VDD VSS DECAPHV8
XFILLER_34_978 VDD VSS DECAPHV32
XFILLER_179_1368 VDD VSS DECAPHV16
XTAP_TAPCELL_ROW_157_2_517 VDD VSS WELLTAP
XFILLER_140_1103 VDD VSS DECAPHV32
XFILLER_109_1392 VSS VDD FILLER2
XFILLER_138_1010 VDD VSS DECAPHV32
XFILLER_151_1243 VDD VSS DECAPHV32
XFILLER_149_1150 VDD VSS DECAPHV32
XFILLER_99_1336 VDD VSS DECAPHV32
XFILLER_3_1020 VSS VDD FILLER2
XFILLER_111_961 VDD VSS DECAPHV32
XFILLER_162_1350 VDD VSS DECAPHV32
XFILLER_71_1211 VDD VSS DECAPHV32
XFILLER_145_1025 VDD VSS DECAPHV32
XFILLER_71_1299 VSS VDD FILLER2
XFILLER_117_1105 VDD VSS DECAPHV8
XFILLER_102_961 VDD VSS DECAPHV8
XFILLER_16_978 VDD VSS DECAPHV32
XFILLER_128_1289 VDD VSS DECAPHV32
XFILLER_100_1164 VDD VSS DECAPHV32
XTAP_TAPCELL_ROW_79_2_123 VDD VSS WELLTAP
XFILLER_168_1058 VDD VSS DECAPHV8
XFILLER_129_1009 VDD VSS DECAPHV8
XFILLER_146_1345 VSS VDD FILLER2
XFILLER_94_1244 VDD VSS DECAPHV8
XFILLER_179_1198 VDD VSS DECAPHV8
XTAP_TAPCELL_ROW_139_2_424 VDD VSS WELLTAP
XFILLER_118_1414 VDD VSS DECAPHV8
XFILLER_171_1427 VDD VSS FILLER1
XTAP_TAPCELL_ROW_164_2_551 VDD VSS WELLTAP
XFILLER_130_1135 VDD VSS DECAPHV16
XFILLER_78_1228 VDD VSS DECAPHV16
XFILLER_95_929 VDD VSS DECAPHV32
XIO_BOND_vdda_pad VDDA sg13cmos5l_ip__bondpad_70x70
XFILLER_128_1042 VDD VSS DECAPHV16
XFILLER_141_1275 VDD VSS DECAPHV16
XFILLER_89_1368 VDD VSS DECAPHV16
Xg_vdd_pads\[0\].vdd_pad IOVDD IOVSS VDD VSS sg13cmos5l_IOPadVdd
XFILLER_48_1010 VDD VSS FILLER1
XFILLER_172_978 VDD VSS DECAPHV32
XFILLER_172_967 VDD VSS DECAPHV8
XFILLER_152_1382 VDD VSS DECAPHV32
XFILLER_139_1182 VDD VSS DECAPHV16
XFILLER_86_929 VDD VSS DECAPHV32
XFILLER_135_1057 VDD VSS DECAPHV32
XFILLER_0_1067 VDD VSS DECAPHV32
XFILLER_94_973 VSS VDD FILLER2
XFILLER_146_1164 VDD VSS DECAPHV32
XFILLER_72_1350 VDD VSS DECAPHV32
XFILLER_10_929 VDD VSS DECAPHV32
XFILLER_153_1113 VSS VDD FILLER2
XFILLER_120_1337 VDD VSS DECAPHV8
XFILLER_118_1244 VDD VSS DECAPHV8
XFILLER_77_929 VDD VSS DECAPHV32
XFILLER_129_1384 VDD VSS DECAPHV8
XTAP_TAPCELL_ROW_78_2_122 VDD VSS WELLTAP
XTAP_TAPCELL_ROW_167_2_566 VDD VSS WELLTAP
XFILLER_154_978 VDD VSS DECAPHV32
Xvi_pad IOVDD IOVSS analog_PAD[0] vi_pad/padbare dsm2/vi VDDA VSS sg13cmos5l_IOPadAnalog
XFILLER_68_929 VDD VSS DECAPHV32
XTAP_TAPCELL_ROW_4_2_24 VDD VSS WELLTAP
XFILLER_39_1009 VSS VDD FILLER2
XFILLER_76_973 VSS VDD FILLER2
XFILLER_78_1058 VDD VSS DECAPHV8
XFILLER_143_1304 VDD VSS DECAPHV32
XFILLER_176_1135 VDD VSS DECAPHV16
XFILLER_154_1422 VDD VSS FILLER4
XFILLER_89_1198 VDD VSS DECAPHV8
XTAP_TAPCELL_ROW_95_2_203 VDD VSS WELLTAP
XFILLER_96_1103 VDD VSS DECAPHV32
XFILLER_59_929 VDD VSS DECAPHV32
XFILLER_67_973 VDD VSS FILLER1
XTAP_TAPCELL_ROW_155_2_504 VDD VSS WELLTAP
XFILLER_136_978 VDD VSS DECAPHV32
XFILLER_81_1427 VDD VSS FILLER1
XFILLER_166_1337 VDD VSS DECAPHV8
XFILLER_58_973 VSS VDD FILLER2
XFILLER_125_1089 VDD VSS DECAPHV16
XTAP_TAPCELL_ROW_100_2_229 VDD VSS WELLTAP
XTAP_TAPCELL_ROW_149_2_473 VDD VSS WELLTAP
XTAP_TAPCELL_ROW_180_2_631 VDD VSS WELLTAP
XFILLER_136_1196 VDD VSS DECAPHV32
XFILLER_3_1427 VDD VSS FILLER1
XFILLER_171_1021 VDD VSS FILLER1
XTAP_TAPCELL_ROW_98_2_218 VDD VSS WELLTAP
XIO_FILL_IO_NORTH_6_0 IOVDD IOVSS VDD VSS sg13cmos5l_Filler4000
XFILLER_121_1421 VDD VSS FILLER4
XFILLER_154_1252 VSS VDD FILLER2
XTAP_TAPCELL_ROW_158_2_519 VDD VSS WELLTAP
XFILLER_118_978 VDD VSS DECAPHV32
XFILLER_165_1392 VSS VDD FILLER2
XFILLER_126_1321 VDD VSS DECAPHV16
XFILLER_133_1336 VDD VSS DECAPHV32
XFILLER_127_1118 VDD VSS DECAPHV32
XTAP_TAPCELL_ROW_94_2_202 VDD VSS WELLTAP
XFILLER_75_1017 VDD VSS FILLER4
XFILLER_105_1427 VDD VSS FILLER1
XFILLER_173_1105 VDD VSS DECAPHV8
XFILLER_86_1135 VDD VSS DECAPHV16
XTAP_TAPCELL_ROW_32_2_39 VDD VSS WELLTAP
XFILLER_130_929 VDD VSS DECAPHV32
XFILLER_151_1425 VSS VDD FILLER2
XFILLER_97_1275 VDD VSS DECAPHV16
XTAP_TAPCELL_ROW_88_2_171 VDD VSS WELLTAP
XFILLER_154_1071 VDD VSS DECAPHV32
XFILLER_121_929 VDD VSS DECAPHV32
XFILLER_167_1421 VDD VSS FILLER4
XTAP_TAPCELL_ROW_148_2_472 VDD VSS WELLTAP
XFILLER_76_1337 VDD VSS DECAPHV8
XFILLER_126_1151 VDD VSS DECAPHV8
XTAP_TAPCELL_ROW_97_2_217 VDD VSS WELLTAP
XFILLER_174_1414 VDD VSS DECAPHV8
XFILLER_81_1021 VDD VSS FILLER1
XFILLER_112_929 VDD VSS DECAPHV32
XFILLER_137_1291 VDD VSS DECAPHV8
XFILLER_120_973 VSS VDD FILLER2
XFILLER_94_1426 VSS VDD FILLER2
XFILLER_179_1336 VDD VSS DECAPHV32
XFILLER_140_1159 VSS VDD FILLER2
XTAP_TAPCELL_ROW_165_2_553 VDD VSS WELLTAP
XFILLER_151_1211 VDD VSS DECAPHV32
XFILLER_99_1304 VDD VSS DECAPHV32
XFILLER_103_929 VDD VSS DECAPHV32
XFILLER_138_1066 VSS VDD FILLER2
XFILLER_151_1299 VSS VDD FILLER2
XTAP_TAPCELL_ROW_136_2_410 VDD VSS WELLTAP
XFILLER_112_1228 VDD VSS DECAPHV16
XFILLER_123_1368 VDD VSS DECAPHV16
XFILLER_75_1392 VSS VDD FILLER2
XTAP_TAPCELL_ROW_54_2_50 VDD VSS WELLTAP
XTAP_TAPCELL_ROW_110_2_278 VDD VSS WELLTAP
XFILLER_102_973 VSS VDD FILLER2
XFILLER_128_1257 VDD VSS DECAPHV32
XFILLER_141_1413 VDD VSS DECAPHV8
XTAP_TAPCELL_ROW_79_2_124 VDD VSS WELLTAP
XFILLER_169_995 VDD VSS DECAPHV16
XFILLER_174_1244 VDD VSS DECAPHV8
XFILLER_139_1397 VDD VSS DECAPHV16
XFILLER_135_1206 VSS VDD FILLER2
XFILLER_83_1105 VDD VSS DECAPHV8
XTAP_TAPCELL_ROW_168_2_568 VDD VSS WELLTAP
XFILLER_94_1289 VDD VSS DECAPHV32
XFILLER_105_1021 VDD VSS FILLER1
XTAP_TAPCELL_ROW_139_2_425 VDD VSS WELLTAP
XFILLER_118_1426 VSS VDD FILLER2
XFILLER_175_1019 VSS VDD FILLER2
XFILLER_97_993 VDD VSS DECAPHV16
XFILLER_112_1058 VDD VSS DECAPHV8
XFILLER_77_1421 VDD VSS FILLER4
XFILLER_95_1009 VDD VSS DECAPHV8
XFILLER_158_1228 VDD VSS DECAPHV16
XFILLER_123_1198 VDD VSS DECAPHV8
XFILLER_21_993 VDD VSS DECAPHV16
XFILLER_166_965 VDD VSS DECAPHV8
XFILLER_84_1414 VDD VSS DECAPHV8
XFILLER_169_1368 VDD VSS DECAPHV16
XTAP_TAPCELL_ROW_164_2_552 VDD VSS WELLTAP
XFILLER_130_1103 VDD VSS DECAPHV32
XFILLER_180_1292 VDD VSS DECAPHV32
XFILLER_141_1243 VDD VSS DECAPHV32
XFILLER_128_1010 VDD VSS DECAPHV32
XFILLER_139_1150 VDD VSS DECAPHV32
XFILLER_89_1336 VDD VSS DECAPHV32
XFILLER_152_1350 VDD VSS DECAPHV32
XFILLER_79_993 VDD VSS DECAPHV16
XFILLER_135_1025 VDD VSS DECAPHV32
XFILLER_107_1105 VDD VSS DECAPHV8
XFILLER_94_1042 VDD VSS DECAPHV16
XFILLER_118_1289 VDD VSS DECAPHV32
XIO_BOND_do_q_pad do_q_PAD sg13cmos5l_ip__bondpad_70x70
XTAP_TAPCELL_ROW_167_2_567 VDD VSS WELLTAP
XFILLER_158_1058 VDD VSS DECAPHV8
XFILLER_119_1009 VDD VSS DECAPHV8
XFILLER_136_1345 VSS VDD FILLER2
XFILLER_84_1244 VDD VSS DECAPHV8
XTAP_TAPCELL_ROW_4_2_25 VDD VSS WELLTAP
XFILLER_169_1198 VDD VSS DECAPHV8
XFILLER_108_1414 VDD VSS DECAPHV8
XFILLER_95_1384 VDD VSS DECAPHV8
XTAP_TAPCELL_ROW_67_2_60 VDD VSS WELLTAP
XTAP_TAPCELL_ROW_95_2_204 VDD VSS WELLTAP
XFILLER_176_1103 VDD VSS DECAPHV32
XFILLER_161_1427 VDD VSS FILLER1
XFILLER_96_1159 VSS VDD FILLER2
XTAP_TAPCELL_ROW_155_2_505 VDD VSS WELLTAP
XFILLER_120_1135 VDD VSS DECAPHV16
XFILLER_68_1228 VDD VSS DECAPHV16
XTAP_TAPCELL_ROW_89_2_173 VDD VSS WELLTAP
XFILLER_118_1042 VDD VSS DECAPHV16
XFILLER_131_1275 VDD VSS DECAPHV16
XFILLER_79_1368 VDD VSS DECAPHV16
XFILLER_38_1010 VDD VSS FILLER1
XFILLER_142_1382 VDD VSS DECAPHV32
XFILLER_129_1182 VDD VSS DECAPHV16
XFILLER_125_1057 VDD VSS DECAPHV32
XTAP_TAPCELL_ROW_149_2_474 VDD VSS WELLTAP
XFILLER_171_1011 VDD VSS DECAPHV8
XTAP_TAPCELL_ROW_180_2_632 VDD VSS WELLTAP
XFILLER_136_1164 VDD VSS DECAPHV32
XFILLER_110_1337 VDD VSS DECAPHV8
XFILLER_97_1413 VDD VSS DECAPHV8
XIO_FILL_IO_EAST_1_20 IOVDD IOVSS VDDA VSS sg13cmos5l_Filler2000
XTAP_TAPCELL_ROW_98_2_219 VDD VSS WELLTAP
Xclkbuf_1_0__f_clk_PAD2CORE clkbuf_0_clk_PAD2CORE/Y VDD VSS clkbuf_1_0__f_clk_PAD2CORE/Y
+ BUFX12
XFILLER_143_1113 VSS VDD FILLER2
XFILLER_108_1244 VDD VSS DECAPHV8
XFILLER_91_1089 VDD VSS DECAPHV16
XFILLER_119_1384 VDD VSS DECAPHV8
XFILLER_141_993 VDD VSS DECAPHV16
XFILLER_70_969 VDD VSS FILLER4
XFILLER_29_1009 VSS VDD FILLER2
XTAP_TAPCELL_ROW_18_2_32 VDD VSS WELLTAP
XFILLER_68_1058 VDD VSS DECAPHV8
XFILLER_155_1017 VDD VSS FILLER4
XFILLER_133_1304 VDD VSS DECAPHV32
XFILLER_166_1135 VDD VSS DECAPHV16
XFILLER_144_1422 VDD VSS FILLER4
XFILLER_92_1321 VDD VSS DECAPHV16
XFILLER_79_1198 VDD VSS DECAPHV8
XFILLER_86_1103 VDD VSS DECAPHV32
XFILLER_177_1275 VDD VSS DECAPHV16
XFILLER_123_993 VDD VSS DECAPHV16
XFILLER_97_1243 VDD VSS DECAPHV32
XFILLER_93_1118 VDD VSS DECAPHV32
XTAP_TAPCELL_ROW_88_2_172 VDD VSS WELLTAP
XFILLER_71_1427 VDD VSS FILLER1
XFILLER_52_969 VDD VSS FILLER4
XFILLER_156_1337 VDD VSS DECAPHV8
XFILLER_115_1089 VDD VSS DECAPHV16
XTAP_TAPCELL_ROW_48_2_47 VDD VSS WELLTAP
XFILLER_126_1196 VDD VSS DECAPHV32
XFILLER_161_1021 VDD VSS FILLER1
XFILLER_174_1426 VSS VDD FILLER2
XFILLER_105_993 VDD VSS DECAPHV16
XFILLER_111_1421 VDD VSS FILLER4
XFILLER_144_1252 VSS VDD FILLER2
XFILLER_92_1151 VDD VSS DECAPHV8
XTAP_TAPCELL_ROW_76_2_110 VDD VSS WELLTAP
XFILLER_34_969 VDD VSS FILLER4
XFILLER_179_1304 VDD VSS DECAPHV32
XTAP_TAPCELL_ROW_165_2_554 VDD VSS WELLTAP
XFILLER_155_1392 VSS VDD FILLER2
XFILLER_116_1321 VDD VSS DECAPHV16
XFILLER_3_1000 VDD VSS DECAPHV16
XTAP_TAPCELL_ROW_136_2_411 VDD VSS WELLTAP
XFILLER_123_1336 VDD VSS DECAPHV32
XTAP_TAPCELL_ROW_110_2_279 VDD VSS WELLTAP
XFILLER_178_963 VDD VSS DECAPHV8
XFILLER_117_1118 VDD VSS DECAPHV32
XFILLER_163_1105 VDD VSS DECAPHV8
XFILLER_141_1425 VSS VDD FILLER2
XFILLER_76_1135 VDD VSS DECAPHV16
XFILLER_16_969 VDD VSS FILLER4
XFILLER_169_963 VDD VSS DECAPHV32
XFILLER_87_1275 VDD VSS DECAPHV16
XTAP_TAPCELL_ROW_79_2_125 VDD VSS WELLTAP
XFILLER_174_1289 VDD VSS DECAPHV32
XTAP_TAPCELL_ROW_168_2_569 VDD VSS WELLTAP
XFILLER_98_1382 VDD VSS DECAPHV32
XFILLER_94_1257 VDD VSS DECAPHV32
XTAP_TAPCELL_ROW_139_2_426 VDD VSS WELLTAP
XFILLER_144_1071 VDD VSS DECAPHV32
XFILLER_30_961 VDD VSS DECAPHV8
XFILLER_157_1421 VDD VSS FILLER4
XFILLER_116_1151 VDD VSS DECAPHV8
XFILLER_99_1113 VSS VDD FILLER2
XFILLER_97_961 VDD VSS DECAPHV32
XFILLER_164_1414 VDD VSS DECAPHV8
XFILLER_71_1021 VDD VSS FILLER1
XFILLER_127_1291 VDD VSS DECAPHV8
XFILLER_21_961 VDD VSS DECAPHV32
XFILLER_84_1426 VSS VDD FILLER2
XFILLER_88_961 VDD VSS DECAPHV8
XFILLER_169_1336 VDD VSS DECAPHV32
XFILLER_130_1159 VSS VDD FILLER2
XFILLER_141_1211 VDD VSS DECAPHV32
XFILLER_102_1228 VDD VSS DECAPHV16
XFILLER_89_1304 VDD VSS DECAPHV32
XFILLER_12_961 VDD VSS DECAPHV8
XFILLER_128_1066 VSS VDD FILLER2
XFILLER_141_1299 VSS VDD FILLER2
XIO_FILL_IO_EAST_4_20 IOVDD IOVSS VDDA VSS sg13cmos5l_Filler2000
XFILLER_174_1042 VDD VSS DECAPHV16
XFILLER_113_1368 VDD VSS DECAPHV16
XFILLER_79_961 VDD VSS DECAPHV32
XFILLER_94_1010 VDD VSS DECAPHV32
XFILLER_131_1413 VDD VSS DECAPHV8
XFILLER_118_1257 VDD VSS DECAPHV32
XIO_BOND_dsm_clk_pad dsm_clk_PAD sg13cmos5l_ip__bondpad_70x70
XFILLER_164_1244 VDD VSS DECAPHV8
XFILLER_129_1397 VDD VSS DECAPHV16
XFILLER_125_1206 VSS VDD FILLER2
XFILLER_73_1105 VDD VSS DECAPHV8
XFILLER_154_969 VDD VSS FILLER4
XFILLER_175_1384 VDD VSS DECAPHV8
XFILLER_84_1289 VDD VSS DECAPHV32
XTAP_TAPCELL_ROW_4_2_15 VDD VSS WELLTAP
XTAP_TAPCELL_ROW_146_2_460 VDD VSS WELLTAP
XFILLER_108_1426 VSS VDD FILLER2
XTAP_TAPCELL_ROW_67_2_61 VDD VSS WELLTAP
XFILLER_165_1019 VSS VDD FILLER2
XTAP_TAPCELL_ROW_95_2_205 VDD VSS WELLTAP
XFILLER_85_1009 VDD VSS DECAPHV8
XFILLER_102_1058 VDD VSS DECAPHV8
XIO_FILL_IO_EAST_6_0 IOVDD IOVSS VDD VSS sg13cmos5l_Filler4000
XFILLER_176_1159 VSS VDD FILLER2
XTAP_TAPCELL_ROW_74_2_98 VDD VSS WELLTAP
XFILLER_148_1228 VDD VSS DECAPHV16
XFILLER_113_1198 VDD VSS DECAPHV8
XFILLER_82_978 VDD VSS DECAPHV32
XTAP_TAPCELL_ROW_155_2_506 VDD VSS WELLTAP
XFILLER_74_1414 VDD VSS DECAPHV8
XFILLER_159_1368 VDD VSS DECAPHV16
XFILLER_120_1103 VDD VSS DECAPHV32
XTAP_TAPCELL_ROW_89_2_174 VDD VSS WELLTAP
XFILLER_118_1010 VDD VSS DECAPHV32
XFILLER_136_969 VDD VSS FILLER4
XFILLER_131_1243 VDD VSS DECAPHV32
XFILLER_7_1009 VSS VDD FILLER2
XFILLER_129_1150 VDD VSS DECAPHV32
XFILLER_79_1336 VDD VSS DECAPHV32
XFILLER_177_1413 VDD VSS DECAPHV8
XTAP_TAPCELL_ROW_149_2_475 VDD VSS WELLTAP
XFILLER_142_1350 VDD VSS DECAPHV32
XFILLER_125_1025 VDD VSS DECAPHV32
Xdelaybuf_7_clk delaybuf_7_clk/A VDD VSS delaybuf_8_clk/A BUFX12
XFILLER_84_1042 VDD VSS DECAPHV16
XFILLER_150_961 VDD VSS DECAPHV8
XTAP_TAPCELL_ROW_180_2_633 VDD VSS WELLTAP
XFILLER_171_1089 VDD VSS DECAPHV16
XFILLER_97_1425 VSS VDD FILLER2
XFILLER_1_993 VDD VSS DECAPHV16
XFILLER_64_978 VDD VSS DECAPHV32
XFILLER_108_1289 VDD VSS DECAPHV32
XFILLER_95_1182 VDD VSS DECAPHV16
XFILLER_91_1057 VDD VSS DECAPHV32
XFILLER_118_969 VDD VSS FILLER4
XFILLER_141_961 VDD VSS DECAPHV32
XFILLER_74_1244 VDD VSS DECAPHV8
XFILLER_148_1058 VDD VSS DECAPHV8
XFILLER_109_1009 VDD VSS DECAPHV8
XFILLER_126_1345 VSS VDD FILLER2
XTAP_TAPCELL_ROW_137_2_413 VDD VSS WELLTAP
XFILLER_172_1321 VDD VSS DECAPHV16
XFILLER_159_1198 VDD VSS DECAPHV8
XFILLER_85_1384 VDD VSS DECAPHV8
XFILLER_132_961 VDD VSS DECAPHV8
XFILLER_166_1103 VDD VSS DECAPHV32
XFILLER_46_978 VDD VSS DECAPHV32
XFILLER_177_1243 VDD VSS DECAPHV32
XFILLER_86_1159 VSS VDD FILLER2
XFILLER_173_1118 VDD VSS DECAPHV32
XFILLER_151_1427 VDD VSS FILLER1
XFILLER_123_961 VDD VSS DECAPHV32
XTAP_TAPCELL_ROW_162_2_540 VDD VSS WELLTAP
XFILLER_110_1135 VDD VSS DECAPHV16
XFILLER_97_1299 VSS VDD FILLER2
XFILLER_97_1211 VDD VSS DECAPHV32
XFILLER_108_1042 VDD VSS DECAPHV16
XFILLER_121_1275 VDD VSS DECAPHV16
XFILLER_69_1368 VDD VSS DECAPHV16
XFILLER_28_1010 VDD VSS FILLER1
XFILLER_114_961 VDD VSS DECAPHV8
XFILLER_132_1382 VDD VSS DECAPHV32
XFILLER_119_1182 VDD VSS DECAPHV16
XFILLER_115_1057 VDD VSS DECAPHV32
XFILLER_126_1164 VDD VSS DECAPHV32
XFILLER_28_978 VDD VSS DECAPHV32
XFILLER_100_1337 VDD VSS DECAPHV8
XFILLER_87_1413 VDD VSS DECAPHV8
XFILLER_172_1151 VDD VSS DECAPHV8
XFILLER_133_1113 VSS VDD FILLER2
XFILLER_81_1089 VDD VSS DECAPHV16
XFILLER_105_961 VDD VSS DECAPHV32
XTAP_TAPCELL_ROW_76_2_111 VDD VSS WELLTAP
XFILLER_109_1384 VDD VSS DECAPHV8
XFILLER_92_1196 VDD VSS DECAPHV32
XTAP_TAPCELL_ROW_165_2_555 VDD VSS WELLTAP
XTAP_TAPCELL_ROW_136_2_412 VDD VSS WELLTAP
XFILLER_3_1089 VDD VSS DECAPHV16
XFILLER_40_929 VDD VSS DECAPHV32
XFILLER_19_1009 VSS VDD FILLER2
XFILLER_145_1017 VDD VSS FILLER4
XFILLER_123_1304 VDD VSS DECAPHV32
XFILLER_156_1135 VDD VSS DECAPHV16
XFILLER_134_1422 VDD VSS FILLER4
XFILLER_82_1321 VDD VSS DECAPHV16
XFILLER_69_1198 VDD VSS DECAPHV8
XFILLER_76_1103 VDD VSS DECAPHV32
XFILLER_167_1275 VDD VSS DECAPHV16
XFILLER_169_931 VDD VSS DECAPHV32
XFILLER_178_1382 VDD VSS DECAPHV32
XFILLER_174_1257 VDD VSS DECAPHV32
XFILLER_87_1243 VDD VSS DECAPHV32
XFILLER_83_1118 VDD VSS DECAPHV32
XTAP_TAPCELL_ROW_79_2_126 VDD VSS WELLTAP
XFILLER_98_929 VDD VSS DECAPHV32
XFILLER_4_1332 VSS VDD FILLER2
XFILLER_146_1337 VDD VSS DECAPHV8
XFILLER_98_1350 VDD VSS DECAPHV32
XFILLER_22_929 VDD VSS DECAPHV32
XFILLER_179_1113 VSS VDD FILLER2
XTAP_TAPCELL_ROW_139_2_427 VDD VSS WELLTAP
XFILLER_105_1089 VDD VSS DECAPHV16
XIO_FILL_IO_SOUTH_7_0 IOVDD IOVSS VDDA VSS sg13cmos5l_Filler4000
XFILLER_30_973 VSS VDD FILLER2
XFILLER_89_929 VDD VSS DECAPHV32
XFILLER_151_1021 VDD VSS FILLER1
XFILLER_116_1196 VDD VSS DECAPHV32
XFILLER_164_1426 VSS VDD FILLER2
XFILLER_13_929 VDD VSS DECAPHV32
XFILLER_101_1421 VDD VSS FILLER4
XFILLER_166_978 VDD VSS DECAPHV32
XFILLER_169_1304 VDD VSS DECAPHV32
XFILLER_134_1252 VSS VDD FILLER2
XFILLER_82_1151 VDD VSS DECAPHV8
XFILLER_88_973 VSS VDD FILLER2
XTAP_TAPCELL_ROW_156_2_508 VDD VSS WELLTAP
XFILLER_145_1392 VSS VDD FILLER2
XFILLER_106_1321 VDD VSS DECAPHV16
XFILLER_93_1291 VDD VSS DECAPHV8
XFILLER_12_973 VSS VDD FILLER2
XFILLER_172_937 VSS VDD FILLER2
XFILLER_174_1010 VDD VSS DECAPHV32
XFILLER_113_1336 VDD VSS DECAPHV32
XFILLER_107_1118 VDD VSS DECAPHV32
XFILLER_94_1066 VSS VDD FILLER2
XFILLER_148_978 VDD VSS DECAPHV32
XFILLER_153_1105 VDD VSS DECAPHV8
XFILLER_131_1425 VSS VDD FILLER2
XTAP_TAPCELL_ROW_86_2_160 VDD VSS WELLTAP
XFILLER_77_1275 VDD VSS DECAPHV16
XFILLER_164_1289 VDD VSS DECAPHV32
XFILLER_88_1382 VDD VSS DECAPHV32
XFILLER_84_1257 VDD VSS DECAPHV32
XTAP_TAPCELL_ROW_67_2_62 VDD VSS WELLTAP
XTAP_TAPCELL_ROW_4_2_16 VDD VSS WELLTAP
Xi_sg13cmos5l_dsa1_dig_core.u_adc_conv_gate i_sg13cmos5l_dsa1_dig_core.u_adc_conv_gate/A
+ i_sg13cmos5l_dsa1_dig_core.u_adc_conv_gate/B VDD VSS g_outputs\[1\].output_pad/c2p
+ AND2X1
XFILLER_134_1071 VDD VSS DECAPHV32
XFILLER_147_1421 VDD VSS FILLER4
XTAP_TAPCELL_ROW_146_2_461 VDD VSS WELLTAP
XFILLER_95_1397 VDD VSS DECAPHV16
XFILLER_91_1206 VSS VDD FILLER2
XFILLER_1_1368 VDD VSS DECAPHV16
XFILLER_106_1151 VDD VSS DECAPHV8
XTAP_TAPCELL_ROW_95_2_206 VDD VSS WELLTAP
XFILLER_89_1113 VSS VDD FILLER2
XFILLER_67_1422 VSS VDD FILLER2
XFILLER_160_929 VDD VSS DECAPHV32
XFILLER_154_1414 VDD VSS DECAPHV8
XFILLER_117_1291 VDD VSS DECAPHV8
XTAP_TAPCELL_ROW_74_2_99 VDD VSS WELLTAP
XFILLER_74_1426 VSS VDD FILLER2
XTAP_TAPCELL_ROW_155_2_507 VDD VSS WELLTAP
XFILLER_159_1336 VDD VSS DECAPHV32
XFILLER_120_1159 VSS VDD FILLER2
XTAP_TAPCELL_ROW_89_2_175 VDD VSS WELLTAP
XFILLER_151_929 VDD VSS DECAPHV32
XFILLER_131_1211 VDD VSS DECAPHV32
XFILLER_79_1304 VDD VSS DECAPHV32
XFILLER_118_1066 VSS VDD FILLER2
XFILLER_131_1299 VSS VDD FILLER2
XFILLER_164_1042 VDD VSS DECAPHV16
XFILLER_177_1425 VSS VDD FILLER2
XTAP_TAPCELL_ROW_149_2_476 VDD VSS WELLTAP
XFILLER_103_1368 VDD VSS DECAPHV16
XFILLER_175_1182 VDD VSS DECAPHV16
XFILLER_171_1057 VDD VSS DECAPHV32
XFILLER_1_961 VDD VSS DECAPHV32
XFILLER_84_1010 VDD VSS DECAPHV32
XFILLER_142_929 VDD VSS DECAPHV32
XFILLER_150_973 VSS VDD FILLER2
XTAP_TAPCELL_ROW_180_2_634 VDD VSS WELLTAP
XFILLER_95_1150 VDD VSS DECAPHV32
XFILLER_121_1413 VDD VSS DECAPHV8
XFILLER_108_1257 VDD VSS DECAPHV32
XFILLER_1_1198 VDD VSS DECAPHV8
XFILLER_91_1025 VDD VSS DECAPHV32
XTAP_TAPCELL_ROW_77_2_113 VDD VSS WELLTAP
XFILLER_133_929 VDD VSS DECAPHV32
XFILLER_154_1244 VDD VSS DECAPHV8
XFILLER_119_1397 VDD VSS DECAPHV16
XFILLER_115_1206 VSS VDD FILLER2
XFILLER_6_1010 VDD VSS FILLER1
XFILLER_165_1384 VDD VSS DECAPHV8
XTAP_TAPCELL_ROW_137_2_414 VDD VSS WELLTAP
XFILLER_74_1289 VDD VSS DECAPHV32
XFILLER_124_929 VDD VSS DECAPHV32
XFILLER_132_973 VSS VDD FILLER2
XFILLER_75_1009 VDD VSS DECAPHV8
XFILLER_166_1159 VSS VDD FILLER2
XFILLER_92_1345 VSS VDD FILLER2
XFILLER_177_1299 VSS VDD FILLER2
XFILLER_177_1211 VDD VSS DECAPHV32
XFILLER_138_1228 VDD VSS DECAPHV16
XFILLER_103_1198 VDD VSS DECAPHV8
XFILLER_115_929 VDD VSS DECAPHV32
XFILLER_110_1103 VDD VSS DECAPHV32
XTAP_TAPCELL_ROW_162_2_541 VDD VSS WELLTAP
XFILLER_149_1368 VDD VSS DECAPHV16
XFILLER_108_1010 VDD VSS DECAPHV32
XIO_FILL_IO_NORTH_4_0 IOVDD IOVSS VDD VSS sg13cmos5l_Filler4000
XFILLER_121_1243 VDD VSS DECAPHV32
XFILLER_69_1336 VDD VSS DECAPHV32
XFILLER_119_1150 VDD VSS DECAPHV32
XFILLER_106_929 VDD VSS DECAPHV32
XFILLER_114_973 VSS VDD FILLER2
XFILLER_115_1025 VDD VSS DECAPHV32
XFILLER_167_1413 VDD VSS DECAPHV8
XFILLER_132_1350 VDD VSS DECAPHV32
XFILLER_28_968 VDD VSS FILLER4
XFILLER_51_993 VDD VSS DECAPHV16
XFILLER_74_1042 VDD VSS DECAPHV16
XFILLER_161_1089 VDD VSS DECAPHV16
XFILLER_87_1425 VSS VDD FILLER2
XFILLER_172_1196 VDD VSS DECAPHV32
XFILLER_85_1182 VDD VSS DECAPHV16
XTAP_TAPCELL_ROW_70_2_80 VDD VSS WELLTAP
XFILLER_81_1057 VDD VSS DECAPHV32
XTAP_TAPCELL_ROW_76_2_112 VDD VSS WELLTAP
XTAP_TAPCELL_ROW_165_2_556 VDD VSS WELLTAP
XFILLER_92_1164 VDD VSS DECAPHV32
XFILLER_138_1058 VDD VSS DECAPHV8
XFILLER_116_1345 VSS VDD FILLER2
XFILLER_3_1057 VDD VSS DECAPHV32
XFILLER_162_1321 VDD VSS DECAPHV16
XFILLER_149_1198 VDD VSS DECAPHV8
XFILLER_75_1384 VDD VSS DECAPHV8
XFILLER_33_993 VDD VSS DECAPHV16
XFILLER_156_1103 VDD VSS DECAPHV32
XFILLER_167_1243 VDD VSS DECAPHV32
XFILLER_163_1118 VDD VSS DECAPHV32
XFILLER_76_1159 VSS VDD FILLER2
XFILLER_141_1427 VDD VSS FILLER1
XFILLER_178_1350 VDD VSS DECAPHV32
XFILLER_100_1135 VDD VSS DECAPHV16
XFILLER_87_1299 VSS VDD FILLER2
XFILLER_87_1211 VDD VSS DECAPHV32
XTAP_TAPCELL_ROW_79_2_127 VDD VSS WELLTAP
XFILLER_4_1377 VSS VDD FILLER2
XFILLER_111_1275 VDD VSS DECAPHV16
XFILLER_18_1010 VDD VSS FILLER1
XFILLER_15_993 VDD VSS DECAPHV16
XFILLER_122_1382 VDD VSS DECAPHV32
XFILLER_109_1182 VDD VSS DECAPHV16
XFILLER_105_1057 VDD VSS DECAPHV32
XTAP_TAPCELL_ROW_147_2_463 VDD VSS WELLTAP
XFILLER_116_1164 VDD VSS DECAPHV32
XTAP_TAPCELL_ROW_118_2_320 VDD VSS WELLTAP
XFILLER_77_1413 VDD VSS DECAPHV8
XTAP_TAPCELL_ROW_96_2_208 VDD VSS WELLTAP
XFILLER_162_1151 VDD VSS DECAPHV8
XFILLER_123_1113 VSS VDD FILLER2
XFILLER_71_1089 VDD VSS DECAPHV16
XFILLER_173_1291 VDD VSS DECAPHV8
XFILLER_82_1196 VDD VSS DECAPHV32
XTAP_TAPCELL_ROW_156_2_509 VDD VSS WELLTAP
XTAP_TAPCELL_ROW_172_2_590 VDD VSS WELLTAP
XFILLER_8_978 VDD VSS DECAPHV32
XFILLER_113_1304 VDD VSS DECAPHV32
XFILLER_174_1066 VSS VDD FILLER2
XFILLER_135_1017 VDD VSS FILLER4
XFILLER_4_1152 VSS VDD FILLER2
XFILLER_146_1135 VDD VSS DECAPHV16
XFILLER_124_1422 VDD VSS FILLER4
XFILLER_72_1321 VDD VSS DECAPHV16
XFILLER_157_1275 VDD VSS DECAPHV16
XTAP_TAPCELL_ROW_12_2_29 VDD VSS WELLTAP
XFILLER_168_1382 VDD VSS DECAPHV32
XFILLER_164_1257 VDD VSS DECAPHV32
XTAP_TAPCELL_ROW_86_2_161 VDD VSS WELLTAP
XFILLER_77_1243 VDD VSS DECAPHV32
XFILLER_73_1118 VDD VSS DECAPHV32
XFILLER_88_1350 VDD VSS DECAPHV32
XFILLER_175_1397 VDD VSS DECAPHV16
XFILLER_171_1206 VSS VDD FILLER2
XFILLER_136_1337 VDD VSS DECAPHV8
XFILLER_169_1113 VSS VDD FILLER2
XTAP_TAPCELL_ROW_146_2_462 VDD VSS WELLTAP
XTAP_TAPCELL_ROW_67_2_63 VDD VSS WELLTAP
XFILLER_1_1336 VDD VSS DECAPHV32
XTAP_TAPCELL_ROW_4_2_17 VDD VSS WELLTAP
XFILLER_141_1021 VDD VSS FILLER1
XFILLER_106_1196 VDD VSS DECAPHV32
XTAP_TAPCELL_ROW_95_2_207 VDD VSS WELLTAP
XFILLER_153_993 VDD VSS DECAPHV16
XFILLER_154_1426 VSS VDD FILLER2
XFILLER_67_977 VDD VSS DECAPHV32
XFILLER_82_969 VDD VSS FILLER4
XFILLER_159_1304 VDD VSS DECAPHV32
XFILLER_124_1252 VSS VDD FILLER2
XFILLER_72_1151 VDD VSS DECAPHV8
XIO_FILL_IO_WEST_1_30 IOVDD IOVSS VDD VSS sg13cmos5l_Filler1000
XTAP_TAPCELL_ROW_163_2_543 VDD VSS WELLTAP
XTAP_TAPCELL_ROW_89_2_176 VDD VSS WELLTAP
XFILLER_135_1392 VSS VDD FILLER2
XTAP_TAPCELL_ROW_134_2_400 VDD VSS WELLTAP
XFILLER_83_1291 VDD VSS DECAPHV8
XFILLER_164_1010 VDD VSS DECAPHV32
XTAP_TAPCELL_ROW_149_2_477 VDD VSS WELLTAP
XFILLER_103_1336 VDD VSS DECAPHV32
XFILLER_175_1150 VDD VSS DECAPHV32
XFILLER_171_1025 VDD VSS DECAPHV32
XTAP_TAPCELL_ROW_34_2_40 VDD VSS WELLTAP
XFILLER_84_1066 VSS VDD FILLER2
XFILLER_135_993 VDD VSS DECAPHV16
XTAP_TAPCELL_ROW_180_2_635 VDD VSS WELLTAP
XFILLER_97_1427 VDD VSS FILLER1
XFILLER_64_969 VDD VSS FILLER4
XFILLER_143_1105 VDD VSS DECAPHV8
XFILLER_121_1425 VSS VDD FILLER2
XTAP_TAPCELL_ROW_77_2_114 VDD VSS WELLTAP
XFILLER_67_1242 VSS VDD FILLER2
XFILLER_154_1289 VDD VSS DECAPHV32
XTAP_TAPCELL_ROW_166_2_558 VDD VSS WELLTAP
XFILLER_78_1382 VDD VSS DECAPHV32
XFILLER_74_1257 VDD VSS DECAPHV32
XTAP_TAPCELL_ROW_137_2_415 VDD VSS WELLTAP
XFILLER_124_1071 VDD VSS DECAPHV32
XFILLER_155_1009 VDD VSS DECAPHV8
XFILLER_172_1345 VSS VDD FILLER2
XFILLER_137_1421 VDD VSS FILLER4
XFILLER_85_1397 VDD VSS DECAPHV16
XFILLER_81_1206 VSS VDD FILLER2
XFILLER_117_993 VDD VSS DECAPHV16
XFILLER_79_1113 VSS VDD FILLER2
Xg_vss_pads\[1\].vss_pad IOVDD IOVSS VDD VSS sg13cmos5l_IOPadVss
XFILLER_46_969 VDD VSS FILLER4
XTAP_TAPCELL_ROW_64_2_55 VDD VSS WELLTAP
XFILLER_144_1414 VDD VSS DECAPHV8
XFILLER_107_1291 VDD VSS DECAPHV8
XFILLER_3_1206 VSS VDD FILLER2
XTAP_TAPCELL_ROW_162_2_542 VDD VSS WELLTAP
XFILLER_149_1336 VDD VSS DECAPHV32
XFILLER_110_1159 VSS VDD FILLER2
XFILLER_60_961 VDD VSS DECAPHV8
XFILLER_121_1299 VSS VDD FILLER2
XFILLER_121_1211 VDD VSS DECAPHV32
XFILLER_69_1304 VDD VSS DECAPHV32
XFILLER_108_1066 VSS VDD FILLER2
XFILLER_154_1042 VDD VSS DECAPHV16
XFILLER_167_1425 VSS VDD FILLER2
XFILLER_28_936 VDD VSS DECAPHV32
XFILLER_74_1010 VDD VSS DECAPHV32
XFILLER_165_1182 VDD VSS DECAPHV16
XFILLER_161_1057 VDD VSS DECAPHV32
XFILLER_51_961 VDD VSS DECAPHV32
XFILLER_85_1150 VDD VSS DECAPHV32
XFILLER_172_1164 VDD VSS DECAPHV32
XFILLER_111_1413 VDD VSS DECAPHV8
XTAP_TAPCELL_ROW_70_2_81 VDD VSS WELLTAP
XFILLER_81_1025 VDD VSS DECAPHV32
XFILLER_144_1244 VDD VSS DECAPHV8
XFILLER_42_961 VDD VSS DECAPHV8
XTAP_TAPCELL_ROW_165_2_557 VDD VSS WELLTAP
XFILLER_109_1397 VDD VSS DECAPHV16
XFILLER_105_1206 VSS VDD FILLER2
XFILLER_155_1384 VDD VSS DECAPHV8
XFILLER_3_1025 VDD VSS DECAPHV32
XFILLER_97_1021 VDD VSS FILLER1
XFILLER_33_961 VDD VSS DECAPHV32
XFILLER_156_1159 VSS VDD FILLER2
XFILLER_65_1009 VSS VDD FILLER2
XFILLER_82_1345 VSS VDD FILLER2
XFILLER_180_1422 VSS VDD FILLER2
XFILLER_167_1299 VSS VDD FILLER2
XFILLER_167_1211 VDD VSS DECAPHV32
XFILLER_128_1228 VDD VSS DECAPHV16
XFILLER_24_961 VDD VSS DECAPHV8
XFILLER_100_1103 VDD VSS DECAPHV32
XFILLER_139_1368 VDD VSS DECAPHV16
XTAP_TAPCELL_ROW_87_2_163 VDD VSS WELLTAP
XFILLER_111_1243 VDD VSS DECAPHV32
XFILLER_109_1150 VDD VSS DECAPHV32
XFILLER_15_961 VDD VSS DECAPHV32
XFILLER_105_1025 VDD VSS DECAPHV32
XFILLER_157_1413 VDD VSS DECAPHV8
XTAP_TAPCELL_ROW_147_2_464 VDD VSS WELLTAP
XFILLER_122_1350 VDD VSS DECAPHV32
XFILLER_151_1089 VDD VSS DECAPHV16
XFILLER_99_1105 VDD VSS DECAPHV8
XTAP_TAPCELL_ROW_118_2_321 VDD VSS WELLTAP
XFILLER_77_1425 VSS VDD FILLER2
XIO_FILL_IO_WEST_4_30 IOVDD IOVSS VDD VSS sg13cmos5l_Filler1000
XTAP_TAPCELL_ROW_96_2_209 VDD VSS WELLTAP
XFILLER_162_1196 VDD VSS DECAPHV32
XFILLER_75_1182 VDD VSS DECAPHV16
XFILLER_71_1057 VDD VSS DECAPHV32
XFILLER_82_1164 VDD VSS DECAPHV32
XTAP_TAPCELL_ROW_172_2_591 VDD VSS WELLTAP
XFILLER_106_1345 VSS VDD FILLER2
XFILLER_128_1058 VDD VSS DECAPHV8
XFILLER_180_961 VDD VSS DECAPHV8
XFILLER_152_1321 VDD VSS DECAPHV16
XFILLER_139_1198 VDD VSS DECAPHV8
XFILLER_146_1103 VDD VSS DECAPHV32
XFILLER_4_1197 VSS VDD FILLER2
XFILLER_0_1017 VSS VDD FILLER2
XFILLER_94_978 VDD VSS DECAPHV32
XFILLER_148_969 VDD VSS FILLER4
XFILLER_157_1243 VDD VSS DECAPHV32
XFILLER_153_1118 VDD VSS DECAPHV32
XFILLER_131_1427 VDD VSS FILLER1
XFILLER_77_1211 VDD VSS DECAPHV32
XFILLER_168_1350 VDD VSS DECAPHV32
XFILLER_90_1422 VDD VSS FILLER4
XTAP_TAPCELL_ROW_86_2_162 VDD VSS WELLTAP
XFILLER_77_1299 VSS VDD FILLER2
XFILLER_101_1275 VDD VSS DECAPHV16
XTAP_TAPCELL_ROW_4_2_18 VDD VSS WELLTAP
XFILLER_162_961 VDD VSS DECAPHV8
XFILLER_112_1382 VDD VSS DECAPHV32
XTAP_TAPCELL_ROW_67_2_64 VDD VSS WELLTAP
XFILLER_1_1304 VDD VSS DECAPHV32
XTAP_TAPCELL_ROW_28_2_37 VDD VSS WELLTAP
XFILLER_76_978 VDD VSS DECAPHV32
XFILLER_106_1164 VDD VSS DECAPHV32
XFILLER_153_961 VDD VSS DECAPHV32
XFILLER_152_1151 VDD VSS DECAPHV8
XFILLER_113_1113 VSS VDD FILLER2
XTAP_TAPCELL_ROW_74_2_100 VDD VSS WELLTAP
XFILLER_163_1291 VDD VSS DECAPHV8
XTAP_TAPCELL_ROW_163_2_544 VDD VSS WELLTAP
XTAP_TAPCELL_ROW_89_2_177 VDD VSS WELLTAP
XFILLER_72_1196 VDD VSS DECAPHV32
XIO_FILL_IO_WEST_1_20 IOVDD IOVSS VDD VSS sg13cmos5l_Filler2000
XFILLER_144_961 VDD VSS DECAPHV8
XTAP_TAPCELL_ROW_134_2_401 VDD VSS WELLTAP
XFILLER_58_978 VDD VSS DECAPHV32
XFILLER_103_1304 VDD VSS DECAPHV32
XFILLER_90_1252 VSS VDD FILLER2
XFILLER_164_1066 VSS VDD FILLER2
XFILLER_125_1017 VDD VSS FILLER4
XFILLER_177_1427 VDD VSS FILLER1
XFILLER_135_961 VDD VSS DECAPHV32
XTAP_TAPCELL_ROW_180_2_636 VDD VSS WELLTAP
XFILLER_136_1135 VDD VSS DECAPHV16
XFILLER_114_1422 VDD VSS FILLER4
XFILLER_147_1275 VDD VSS DECAPHV16
XTAP_TAPCELL_ROW_128_2_370 VDD VSS WELLTAP
XANTENNA_1 ANTENNA_1/A VDD VSS ANTENNA2
XFILLER_158_1382 VDD VSS DECAPHV32
XFILLER_154_1257 VDD VSS DECAPHV32
XIO_FILL_IO_EAST_4_0 IOVDD IOVSS VDDA VSS sg13cmos5l_Filler4000
XTAP_TAPCELL_ROW_77_2_115 VDD VSS WELLTAP
XFILLER_67_1287 VSS VDD FILLER2
XFILLER_126_961 VDD VSS DECAPHV8
XFILLER_78_1350 VDD VSS DECAPHV32
XTAP_TAPCELL_ROW_166_2_559 VDD VSS WELLTAP
XFILLER_70_929 VDD VSS DECAPHV32
XFILLER_165_1397 VDD VSS DECAPHV16
XFILLER_161_1206 VSS VDD FILLER2
XFILLER_126_1337 VDD VSS DECAPHV8
XFILLER_159_1113 VSS VDD FILLER2
XTAP_TAPCELL_ROW_137_2_416 VDD VSS WELLTAP
XFILLER_117_961 VDD VSS DECAPHV32
XFILLER_131_1021 VDD VSS FILLER1
XFILLER_144_1426 VSS VDD FILLER2
XFILLER_61_929 VDD VSS DECAPHV32
XFILLER_90_1071 VDD VSS DECAPHV32
XFILLER_108_961 VDD VSS DECAPHV8
XFILLER_149_1304 VDD VSS DECAPHV32
XFILLER_114_1252 VSS VDD FILLER2
XFILLER_73_1291 VDD VSS DECAPHV8
XFILLER_52_929 VDD VSS DECAPHV32
XFILLER_60_973 VSS VDD FILLER2
XFILLER_125_1392 VSS VDD FILLER2
XFILLER_67_1062 VSS VDD FILLER2
XFILLER_154_1010 VDD VSS DECAPHV32
XFILLER_165_1150 VDD VSS DECAPHV32
XFILLER_43_929 VDD VSS DECAPHV32
XFILLER_74_1066 VSS VDD FILLER2
XFILLER_161_1025 VDD VSS DECAPHV32
XFILLER_133_1105 VDD VSS DECAPHV8
XFILLER_87_1427 VDD VSS FILLER1
XTAP_TAPCELL_ROW_119_2_323 VDD VSS WELLTAP
XFILLER_111_1425 VSS VDD FILLER2
XTAP_TAPCELL_ROW_70_2_82 VDD VSS WELLTAP
XFILLER_120_978 VDD VSS DECAPHV32
XFILLER_42_973 VSS VDD FILLER2
XFILLER_34_929 VDD VSS DECAPHV32
XFILLER_144_1289 VDD VSS DECAPHV32
XFILLER_177_1021 VDD VSS FILLER1
XTAP_TAPCELL_ROW_173_2_593 VDD VSS WELLTAP
XFILLER_68_1382 VDD VSS DECAPHV32
XTAP_TAPCELL_ROW_144_2_450 VDD VSS WELLTAP
XFILLER_25_929 VDD VSS DECAPHV32
XFILLER_114_1071 VDD VSS DECAPHV32
XFILLER_145_1009 VDD VSS DECAPHV8
XFILLER_162_1345 VSS VDD FILLER2
XFILLER_127_1421 VDD VSS FILLER4
XFILLER_75_1397 VDD VSS DECAPHV16
XFILLER_71_1206 VSS VDD FILLER2
XFILLER_178_978 VDD VSS DECAPHV32
XFILLER_134_1414 VDD VSS DECAPHV8
XFILLER_69_1113 VSS VDD FILLER2
XFILLER_102_978 VDD VSS DECAPHV32
XFILLER_24_973 VSS VDD FILLER2
XFILLER_16_929 VDD VSS DECAPHV32
XFILLER_100_1159 VSS VDD FILLER2
XFILLER_139_1336 VDD VSS DECAPHV32
XTAP_TAPCELL_ROW_87_2_164 VDD VSS WELLTAP
XFILLER_111_1299 VSS VDD FILLER2
XFILLER_111_1211 VDD VSS DECAPHV32
XFILLER_94_1228 VDD VSS DECAPHV16
XFILLER_4_1324 VDD VSS DECAPHV8
XFILLER_179_1105 VDD VSS DECAPHV8
XFILLER_144_1042 VDD VSS DECAPHV16
XFILLER_157_1425 VSS VDD FILLER2
XTAP_TAPCELL_ROW_147_2_465 VDD VSS WELLTAP
Xib_pad IOVDD IOVSS analog_PAD[2] ib_pad/padbare ib_pad/padres VDDA VSS sg13cmos5l_IOPadAnalog
XFILLER_64_1010 VDD VSS FILLER1
XFILLER_155_1182 VDD VSS DECAPHV16
XFILLER_151_1057 VDD VSS DECAPHV32
Xclkbuf_0_clk_PAD2CORE clk_pad/p2c VDD VSS clkbuf_0_clk_PAD2CORE/Y BUFX12
XTAP_TAPCELL_ROW_118_2_322 VDD VSS WELLTAP
XFILLER_75_1150 VDD VSS DECAPHV32
XIO_FILL_IO_WEST_4_20 IOVDD IOVSS VDD VSS sg13cmos5l_Filler2000
XFILLER_71_1025 VDD VSS DECAPHV32
XFILLER_162_1164 VDD VSS DECAPHV32
XFILLER_101_1413 VDD VSS DECAPHV8
XFILLER_134_1244 VDD VSS DECAPHV8
XTAP_TAPCELL_ROW_172_2_592 VDD VSS WELLTAP
XFILLER_180_1242 VSS VDD FILLER2
XFILLER_145_1384 VDD VSS DECAPHV8
XFILLER_8_969 VDD VSS FILLER4
XFILLER_87_1021 VDD VSS FILLER1
XTAP_TAPCELL_ROW_135_2_403 VDD VSS WELLTAP
XFILLER_180_973 VDD VSS FILLER1
XFILLER_146_1159 VSS VDD FILLER2
XFILLER_55_1009 VSS VDD FILLER2
XFILLER_94_1058 VDD VSS DECAPHV8
XFILLER_72_1345 VSS VDD FILLER2
XIO_FILL_IO_SOUTH_5_0 IOVDD IOVSS VDDA VSS sg13cmos5l_Filler4000
XFILLER_163_929 VDD VSS DECAPHV32
XFILLER_170_1422 VDD VSS FILLER4
XFILLER_157_1299 VSS VDD FILLER2
XFILLER_157_1211 VDD VSS DECAPHV32
XFILLER_118_1228 VDD VSS DECAPHV16
XTAP_TAPCELL_ROW_160_2_530 VDD VSS WELLTAP
XFILLER_129_1368 VDD VSS DECAPHV16
XFILLER_101_1243 VDD VSS DECAPHV32
XFILLER_154_929 VDD VSS DECAPHV32
XFILLER_162_973 VSS VDD FILLER2
XTAP_TAPCELL_ROW_4_2_19 VDD VSS WELLTAP
XTAP_TAPCELL_ROW_138_2_418 VDD VSS WELLTAP
XFILLER_147_1413 VDD VSS DECAPHV8
XFILLER_112_1350 VDD VSS DECAPHV32
XTAP_TAPCELL_ROW_67_2_65 VDD VSS WELLTAP
XFILLER_141_1089 VDD VSS DECAPHV16
XFILLER_89_1105 VDD VSS DECAPHV8
XFILLER_145_929 VDD VSS DECAPHV32
XFILLER_67_1414 VDD VSS DECAPHV8
XFILLER_4_961 VDD VSS DECAPHV8
XFILLER_152_1196 VDD VSS DECAPHV32
XTAP_TAPCELL_ROW_74_2_101 VDD VSS WELLTAP
XFILLER_72_1164 VDD VSS DECAPHV32
XTAP_TAPCELL_ROW_163_2_545 VDD VSS WELLTAP
XFILLER_136_929 VDD VSS DECAPHV32
XFILLER_144_973 VSS VDD FILLER2
XFILLER_170_1252 VSS VDD FILLER2
XFILLER_118_1058 VDD VSS DECAPHV8
XTAP_TAPCELL_ROW_134_2_402 VDD VSS WELLTAP
XFILLER_0_1382 VDD VSS DECAPHV32
XFILLER_81_993 VDD VSS DECAPHV16
XFILLER_142_1321 VDD VSS DECAPHV16
XFILLER_129_1198 VDD VSS DECAPHV8
XFILLER_127_929 VDD VSS DECAPHV32
XFILLER_136_1103 VDD VSS DECAPHV32
XTAP_TAPCELL_ROW_180_2_637 VDD VSS WELLTAP
XFILLER_1_1113 VSS VDD FILLER2
XFILLER_147_1243 VDD VSS DECAPHV32
XFILLER_143_1118 VDD VSS DECAPHV32
XTAP_TAPCELL_ROW_128_2_371 VDD VSS WELLTAP
XFILLER_91_1017 VDD VSS FILLER4
XFILLER_158_1350 VDD VSS DECAPHV32
XFILLER_121_1427 VDD VSS FILLER1
XTAP_TAPCELL_ROW_77_2_116 VDD VSS WELLTAP
XANTENNA_2 _1_/A0 VDD VSS ANTENNA2
XFILLER_118_929 VDD VSS DECAPHV32
XFILLER_126_973 VSS VDD FILLER2
XFILLER_80_1422 VDD VSS FILLER4
XFILLER_63_993 VDD VSS DECAPHV16
XFILLER_109_929 VDD VSS DECAPHV32
XTAP_TAPCELL_ROW_137_2_417 VDD VSS WELLTAP
XFILLER_102_1382 VDD VSS DECAPHV32
XFILLER_2_1422 VDD VSS FILLER4
XFILLER_170_1071 VDD VSS DECAPHV32
XFILLER_92_1337 VDD VSS DECAPHV8
XFILLER_142_1151 VDD VSS DECAPHV8
XFILLER_103_1113 VSS VDD FILLER2
XFILLER_108_973 VSS VDD FILLER2
XFILLER_153_1291 VDD VSS DECAPHV8
XFILLER_45_993 VDD VSS DECAPHV16
XFILLER_80_1252 VSS VDD FILLER2
XFILLER_154_1066 VSS VDD FILLER2
XFILLER_115_1017 VDD VSS FILLER4
XFILLER_167_1427 VDD VSS FILLER1
XFILLER_126_1135 VDD VSS DECAPHV16
XIO_BOND_g_outputs\[0\].output_pad output_PAD[0] sg13cmos5l_ip__bondpad_70x70
XFILLER_104_1422 VDD VSS FILLER4
XFILLER_91_1392 VSS VDD FILLER2
XFILLER_137_1275 VDD VSS DECAPHV16
XTAP_TAPCELL_ROW_119_2_324 VDD VSS WELLTAP
XFILLER_2_1252 VSS VDD FILLER2
XFILLER_148_1382 VDD VSS DECAPHV32
XFILLER_144_1257 VDD VSS DECAPHV32
XTAP_TAPCELL_ROW_84_2_150 VDD VSS WELLTAP
XFILLER_27_993 VDD VSS DECAPHV16
XTAP_TAPCELL_ROW_173_2_594 VDD VSS WELLTAP
XFILLER_68_1350 VDD VSS DECAPHV32
XFILLER_155_1397 VDD VSS DECAPHV16
XFILLER_151_1206 VSS VDD FILLER2
XFILLER_116_1337 VDD VSS DECAPHV8
XFILLER_3_1016 VDD VSS FILLER4
XFILLER_149_1113 VSS VDD FILLER2
XTAP_TAPCELL_ROW_144_2_451 VDD VSS WELLTAP
XFILLER_97_1089 VDD VSS DECAPHV16
XIO_FILL_IO_NORTH_2_0 IOVDD IOVSS VDD VSS sg13cmos5l_Filler4000
XFILLER_121_1021 VDD VSS FILLER1
XFILLER_134_1426 VSS VDD FILLER2
XFILLER_80_1071 VDD VSS DECAPHV32
XFILLER_93_1421 VDD VSS FILLER4
XFILLER_174_1228 VDD VSS DECAPHV16
XFILLER_139_1304 VDD VSS DECAPHV32
XFILLER_104_1252 VSS VDD FILLER2
XTAP_TAPCELL_ROW_87_2_165 VDD VSS WELLTAP
XFILLER_115_1392 VSS VDD FILLER2
XFILLER_98_1321 VDD VSS DECAPHV16
XFILLER_4_1369 VDD VSS DECAPHV8
XFILLER_2_1071 VDD VSS DECAPHV32
XFILLER_144_1010 VDD VSS DECAPHV32
XFILLER_155_1150 VDD VSS DECAPHV32
XTAP_TAPCELL_ROW_147_2_466 VDD VSS WELLTAP
XFILLER_99_1118 VDD VSS DECAPHV32
XFILLER_77_1427 VDD VSS FILLER1
XFILLER_151_1025 VDD VSS DECAPHV32
XFILLER_123_1105 VDD VSS DECAPHV8
XFILLER_101_1425 VSS VDD FILLER2
XFILLER_166_949 VDD VSS DECAPHV16
XFILLER_134_1289 VDD VSS DECAPHV32
XTAP_TAPCELL_ROW_75_2_103 VDD VSS WELLTAP
XFILLER_167_1021 VDD VSS FILLER1
XFILLER_180_1287 VSS VDD FILLER2
XTAP_TAPCELL_ROW_135_2_404 VDD VSS WELLTAP
XFILLER_117_1421 VDD VSS FILLER4
XFILLER_174_1058 VDD VSS DECAPHV8
XFILLER_104_1071 VDD VSS DECAPHV32
XFILLER_135_1009 VDD VSS DECAPHV8
XFILLER_152_1345 VSS VDD FILLER2
XFILLER_98_1151 VDD VSS DECAPHV8
XFILLER_4_1144 VDD VSS DECAPHV8
XFILLER_94_969 VDD VSS FILLER4
XFILLER_124_1414 VDD VSS DECAPHV8
XTAP_TAPCELL_ROW_129_2_373 VDD VSS WELLTAP
XTAP_TAPCELL_ROW_160_2_531 VDD VSS WELLTAP
XFILLER_129_1336 VDD VSS DECAPHV32
XTAP_TAPCELL_ROW_78_2_118 VDD VSS WELLTAP
XFILLER_101_1299 VSS VDD FILLER2
XFILLER_101_1211 VDD VSS DECAPHV32
XFILLER_84_1228 VDD VSS DECAPHV16
XFILLER_5_929 VDD VSS DECAPHV32
XFILLER_147_993 VDD VSS DECAPHV16
XFILLER_169_1105 VDD VSS DECAPHV8
XFILLER_76_969 VDD VSS FILLER4
XFILLER_134_1042 VDD VSS DECAPHV16
XTAP_TAPCELL_ROW_138_2_419 VDD VSS WELLTAP
XFILLER_147_1425 VSS VDD FILLER2
XFILLER_95_1368 VDD VSS DECAPHV16
XTAP_TAPCELL_ROW_67_2_66 VDD VSS WELLTAP
Xi_sg13cmos5l_dsa1_dig_core.u_dec_src_gate ANTENNA_1/A _1_/S0 VDD VSS _1_/A1 AND2X1
XFILLER_54_1010 VDD VSS FILLER1
XFILLER_145_1182 VDD VSS DECAPHV16
XFILLER_180_1062 VSS VDD FILLER2
XFILLER_141_1057 VDD VSS DECAPHV32
XFILLER_4_973 VDD VSS FILLER1
Xclkbuf_0_clk_PAD2CORE_regs clkbuf_regs_0_clk/Y VDD VSS clkbuf_0_clk_PAD2CORE_regs/Y
+ BUFX12
XFILLER_152_1164 VDD VSS DECAPHV32
XFILLER_67_969 VDD VSS FILLER4
XFILLER_90_961 VDD VSS DECAPHV8
XFILLER_124_1244 VDD VSS DECAPHV8
XTAP_TAPCELL_ROW_74_2_102 VDD VSS WELLTAP
XTAP_TAPCELL_ROW_163_2_546 VDD VSS WELLTAP
XFILLER_129_993 VDD VSS DECAPHV16
XFILLER_135_1384 VDD VSS DECAPHV8
XFILLER_58_969 VDD VSS FILLER4
XFILLER_77_1021 VDD VSS FILLER1
XFILLER_81_961 VDD VSS DECAPHV32
XFILLER_136_1159 VSS VDD FILLER2
XFILLER_45_1009 VSS VDD FILLER2
XFILLER_84_1058 VDD VSS DECAPHV8
XTAP_TAPCELL_ROW_180_2_638 VDD VSS WELLTAP
XFILLER_147_1211 VDD VSS DECAPHV32
XFILLER_160_1422 VDD VSS FILLER4
XFILLER_147_1299 VSS VDD FILLER2
XTAP_TAPCELL_ROW_128_2_372 VDD VSS WELLTAP
XFILLER_108_1228 VDD VSS DECAPHV16
XFILLER_95_1198 VDD VSS DECAPHV8
XFILLER_72_961 VDD VSS DECAPHV8
XTAP_TAPCELL_ROW_77_2_117 VDD VSS WELLTAP
XFILLER_67_1234 VDD VSS DECAPHV8
XANTENNA_3 ANTENNA_7/A VDD VSS ANTENNA2
XFILLER_119_1368 VDD VSS DECAPHV16
XFILLER_63_961 VDD VSS DECAPHV32
XFILLER_172_1337 VDD VSS DECAPHV8
XFILLER_137_1413 VDD VSS DECAPHV8
XFILLER_102_1350 VDD VSS DECAPHV32
XTAP_TAPCELL_ROW_145_2_453 VDD VSS WELLTAP
XFILLER_131_1089 VDD VSS DECAPHV16
XFILLER_79_1105 VDD VSS DECAPHV8
XTAP_TAPCELL_ROW_116_2_310 VDD VSS WELLTAP
XFILLER_54_961 VDD VSS DECAPHV8
XFILLER_142_1196 VDD VSS DECAPHV32
XTAP_TAPCELL_ROW_170_2_580 VDD VSS WELLTAP
XFILLER_45_961 VDD VSS DECAPHV32
XFILLER_160_1252 VSS VDD FILLER2
XFILLER_108_1058 VDD VSS DECAPHV8
XFILLER_171_1392 VSS VDD FILLER2
XFILLER_132_1321 VDD VSS DECAPHV16
XFILLER_119_1198 VDD VSS DECAPHV8
XTAP_TAPCELL_ROW_148_2_468 VDD VSS WELLTAP
XFILLER_126_1103 VDD VSS DECAPHV32
XFILLER_36_961 VDD VSS DECAPHV8
XTAP_TAPCELL_ROW_119_2_325 VDD VSS WELLTAP
XFILLER_137_1243 VDD VSS DECAPHV32
XFILLER_133_1118 VDD VSS DECAPHV32
XFILLER_81_1017 VDD VSS FILLER4
XFILLER_120_969 VDD VSS FILLER4
Xdelaybuf_0_clk clk_pad/p2c VDD VSS delaybuf_1_clk/A BUFX12
XFILLER_148_1350 VDD VSS DECAPHV32
XFILLER_111_1427 VDD VSS FILLER1
XFILLER_27_961 VDD VSS DECAPHV32
Xg_outputs\[0\].output_pad g_outputs\[0\].output_pad/c2p IOVDD IOVSS output_PAD[0]
+ VDD VSS sg13cmos5l_IOPadOut30mA
XFILLER_92_1135 VDD VSS DECAPHV16
XTAP_TAPCELL_ROW_84_2_151 VDD VSS WELLTAP
XFILLER_70_1422 VDD VSS FILLER4
XFILLER_177_1089 VDD VSS DECAPHV16
XTAP_TAPCELL_ROW_173_2_595 VDD VSS WELLTAP
XTAP_TAPCELL_ROW_144_2_452 VDD VSS WELLTAP
XFILLER_18_961 VDD VSS DECAPHV8
XFILLER_97_1057 VDD VSS DECAPHV32
XFILLER_160_1071 VDD VSS DECAPHV32
XFILLER_173_1421 VDD VSS FILLER4
XFILLER_82_1337 VDD VSS DECAPHV8
XFILLER_102_969 VDD VSS FILLER4
XFILLER_132_1151 VDD VSS DECAPHV8
XFILLER_180_1414 VDD VSS DECAPHV8
XFILLER_143_1291 VDD VSS DECAPHV8
XFILLER_178_1321 VDD VSS DECAPHV16
XTAP_TAPCELL_ROW_87_2_166 VDD VSS WELLTAP
XTAP_TAPCELL_ROW_161_2_533 VDD VSS WELLTAP
XFILLER_4_1337 VDD VSS DECAPHV32
XFILLER_179_1118 VDD VSS DECAPHV32
XTAP_TAPCELL_ROW_147_2_467 VDD VSS WELLTAP
XFILLER_70_1252 VSS VDD FILLER2
XFILLER_144_1066 VSS VDD FILLER2
XFILLER_30_978 VDD VSS DECAPHV32
XIO_FILL_IO_WEST_4_0 IOVDD IOVSS VDD VSS sg13cmos5l_Filler4000
XFILLER_105_1017 VDD VSS FILLER4
XFILLER_175_939 VDD VSS DECAPHV32
XFILLER_157_1427 VDD VSS FILLER1
XFILLER_116_1135 VDD VSS DECAPHV16
XTAP_TAPCELL_ROW_14_2_30 VDD VSS WELLTAP
XFILLER_81_1392 VSS VDD FILLER2
XFILLER_127_1275 VDD VSS DECAPHV16
XTAP_TAPCELL_ROW_75_2_104 VDD VSS WELLTAP
XFILLER_138_1382 VDD VSS DECAPHV32
XFILLER_134_1257 VDD VSS DECAPHV32
XFILLER_88_978 VDD VSS DECAPHV32
XTAP_TAPCELL_ROW_164_2_548 VDD VSS WELLTAP
XFILLER_3_1392 VSS VDD FILLER2
XFILLER_145_1397 VDD VSS DECAPHV16
XFILLER_141_1206 VSS VDD FILLER2
XFILLER_106_1337 VDD VSS DECAPHV8
XFILLER_12_978 VDD VSS DECAPHV32
XFILLER_178_1151 VDD VSS DECAPHV8
XFILLER_139_1113 VSS VDD FILLER2
XTAP_TAPCELL_ROW_135_2_405 VDD VSS WELLTAP
XFILLER_87_1089 VDD VSS DECAPHV16
XFILLER_98_1196 VDD VSS DECAPHV32
XFILLER_4_1189 VDD VSS DECAPHV8
XFILLER_4_1112 VDD VSS DECAPHV32
XFILLER_0_1009 VDD VSS DECAPHV8
XFILLER_111_1021 VDD VSS FILLER1
XFILLER_124_1426 VSS VDD FILLER2
XTAP_TAPCELL_ROW_44_2_45 VDD VSS WELLTAP
XTAP_TAPCELL_ROW_129_2_374 VDD VSS WELLTAP
XFILLER_7_993 VDD VSS DECAPHV16
XFILLER_70_1071 VDD VSS DECAPHV32
XFILLER_156_961 VDD VSS DECAPHV8
XFILLER_83_1421 VDD VSS FILLER4
XFILLER_164_1228 VDD VSS DECAPHV16
XTAP_TAPCELL_ROW_160_2_532 VDD VSS WELLTAP
XFILLER_129_1304 VDD VSS DECAPHV32
XFILLER_90_1414 VDD VSS DECAPHV8
XTAP_TAPCELL_ROW_78_2_119 VDD VSS WELLTAP
XFILLER_105_1392 VSS VDD FILLER2
XFILLER_88_1321 VDD VSS DECAPHV16
XIO_BOND_rst_n_pad rst_n_PAD sg13cmos5l_ip__bondpad_70x70
XFILLER_147_961 VDD VSS DECAPHV32
XFILLER_175_1368 VDD VSS DECAPHV16
XFILLER_134_1010 VDD VSS DECAPHV32
XTAP_TAPCELL_ROW_67_2_67 VDD VSS WELLTAP
Xcut_vdd_s IOVDD IOVSS VSS sg13cmos5l_ip__cut_vdd
XFILLER_91_929 VDD VSS DECAPHV32
XFILLER_145_1150 VDD VSS DECAPHV32
XFILLER_95_1336 VDD VSS DECAPHV32
XFILLER_141_1025 VDD VSS DECAPHV32
XFILLER_89_1118 VDD VSS DECAPHV32
XFILLER_67_1427 VDD VSS FILLER1
XFILLER_138_961 VDD VSS DECAPHV8
XFILLER_113_1105 VDD VSS DECAPHV8
XFILLER_82_929 VDD VSS DECAPHV32
XFILLER_90_973 VSS VDD FILLER2
XFILLER_124_1289 VDD VSS DECAPHV32
XFILLER_129_961 VDD VSS DECAPHV32
XTAP_TAPCELL_ROW_163_2_547 VDD VSS WELLTAP
XFILLER_157_1021 VDD VSS FILLER1
XFILLER_73_929 VDD VSS DECAPHV32
XTAP_TAPCELL_ROW_3_2_10 VDD VSS WELLTAP
XFILLER_107_1421 VDD VSS FILLER4
XFILLER_90_1244 VDD VSS DECAPHV8
XFILLER_164_1058 VDD VSS DECAPHV8
XFILLER_125_1009 VDD VSS DECAPHV8
XFILLER_142_1345 VSS VDD FILLER2
XFILLER_88_1151 VDD VSS DECAPHV8
XFILLER_175_1198 VDD VSS DECAPHV8
XFILLER_114_1414 VDD VSS DECAPHV8
XTAP_TAPCELL_ROW_73_2_93 VDD VSS WELLTAP
XFILLER_150_978 VDD VSS DECAPHV32
XFILLER_99_1291 VDD VSS DECAPHV8
XFILLER_64_929 VDD VSS DECAPHV32
XFILLER_72_973 VSS VDD FILLER2
XTAP_TAPCELL_ROW_180_2_628 VDD VSS WELLTAP
XFILLER_119_1336 VDD VSS DECAPHV32
XFILLER_67_1279 VDD VSS DECAPHV8
XFILLER_67_1202 VDD VSS DECAPHV32
XTAP_TAPCELL_ROW_85_2_153 VDD VSS WELLTAP
XANTENNA_4 ANTENNA_4/A VDD VSS ANTENNA2
XFILLER_55_929 VDD VSS DECAPHV32
XFILLER_74_1228 VDD VSS DECAPHV16
XFILLER_159_1105 VDD VSS DECAPHV8
XFILLER_124_1042 VDD VSS DECAPHV16
XTAP_TAPCELL_ROW_145_2_454 VDD VSS WELLTAP
XFILLER_137_1425 VSS VDD FILLER2
XFILLER_85_1368 VDD VSS DECAPHV16
XFILLER_44_1010 VDD VSS FILLER1
XFILLER_132_978 VDD VSS DECAPHV32
XFILLER_135_1182 VDD VSS DECAPHV16
XFILLER_46_929 VDD VSS DECAPHV32
XFILLER_54_973 VSS VDD FILLER2
XFILLER_131_1057 VDD VSS DECAPHV32
XFILLER_142_1164 VDD VSS DECAPHV32
XTAP_TAPCELL_ROW_116_2_311 VDD VSS WELLTAP
XFILLER_114_1244 VDD VSS DECAPHV8
XFILLER_97_1206 VSS VDD FILLER2
XFILLER_37_929 VDD VSS DECAPHV32
XTAP_TAPCELL_ROW_170_2_581 VDD VSS WELLTAP
XTAP_TAPCELL_ROW_88_2_168 VDD VSS WELLTAP
XFILLER_125_1384 VDD VSS DECAPHV8
XIO_FILL_IO_EAST_2_0 IOVDD IOVSS VDDA VSS sg13cmos5l_Filler4000
XFILLER_67_1054 VDD VSS DECAPHV8
XFILLER_114_978 VDD VSS DECAPHV32
.ends
