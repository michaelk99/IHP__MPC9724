* SPDX-FileCopyrightText: 2026 Harald Pretl, Johannes Kepler University
* SPDX-License-Identifier: Apache-2.0 WITH SHL-2.1
* Generated by ip/ez130_8t_decap_hv/scripts/decap_hv_gen.py -- do not edit.

.SUBCKT DECAPHV8 VDD VNW VPW VSS
*.PININFO VDD:B VNW:B VPW:B VSS:B
MP0 VDD VSS VDD VNW sg13_hv_pmos m=1 w=1.660u l=0.820u ng=1
.ENDS

.SUBCKT DECAPHV16 VDD VNW VPW VSS
*.PININFO VDD:B VNW:B VPW:B VSS:B
MP0 VDD VSS VDD VNW sg13_hv_pmos m=1 w=1.660u l=4.180u ng=1
.ENDS

.SUBCKT DECAPHV32 VDD VNW VPW VSS
*.PININFO VDD:B VNW:B VPW:B VSS:B
MP0 VDD VSS VDD VNW sg13_hv_pmos m=1 w=1.660u l=10.900u ng=1
.ENDS
