* NGSPICE file created from sg13cmos5l_dsa1_dig_top.ext - technology: ihp-sg13cmos5l

* Black-box entry subcircuit for FILLER2 abstract view
.subckt FILLER2 VSS VDD
.ends

* Black-box entry subcircuit for sg13cmos5l_Filler400 abstract view
.subckt sg13cmos5l_Filler400 iovdd iovss vdd vss
.ends

* Black-box entry subcircuit for WELLTAP abstract view
.subckt WELLTAP VDD VSS
.ends

* Black-box entry subcircuit for DECAPHV32 abstract view
.subckt DECAPHV32 VDD VSS
.ends

* Black-box entry subcircuit for DECAPHV8 abstract view
.subckt DECAPHV8 VDD VSS
.ends

* Black-box entry subcircuit for sg13cmos5l_Filler4000 abstract view
.subckt sg13cmos5l_Filler4000 iovdd iovss vdd vss
.ends

* Black-box entry subcircuit for FILLER4 abstract view
.subckt FILLER4 VDD VSS
.ends

* Black-box entry subcircuit for sg13cmos5l_ip__clamp_vddvss abstract view
.subckt sg13cmos5l_ip__clamp_vddvss iovdd iovss vdd vss
.ends

* Black-box entry subcircuit for DECAPHV16 abstract view
.subckt DECAPHV16 VDD VSS
.ends

* Black-box entry subcircuit for BUFX12 abstract view
.subckt BUFX12 A VDD VSS Y
.ends

* Black-box entry subcircuit for FILLER1 abstract view
.subckt FILLER1 VDD VSS
.ends

* Black-box entry subcircuit for sg13cmos5l_ip__bondpad_70x70 abstract view
.subckt sg13cmos5l_ip__bondpad_70x70 pad
.ends

* Black-box entry subcircuit for sg13cmos5l_IOPadInOut4mA abstract view
.subckt sg13cmos5l_IOPadInOut4mA c2p c2p_en iovdd iovss p2c pad vdd vss
.ends

* Black-box entry subcircuit for sg13cmos5l_Filler1000 abstract view
.subckt sg13cmos5l_Filler1000 iovdd iovss vdd vss
.ends

* Black-box entry subcircuit for DFFRQX1 abstract view
.subckt DFFRQX1 CK D Q RB VDD VSS
.ends

* Black-box entry subcircuit for sg13cmos5l_IOPadVss abstract view
.subckt sg13cmos5l_IOPadVss iovdd iovss vdd vss
.ends

* Black-box entry subcircuit for sg13cmos5l_Filler2000 abstract view
.subckt sg13cmos5l_Filler2000 iovdd iovss vdd vss
.ends

* Black-box entry subcircuit for sg13cmos5l_ip__title abstract view
.subckt sg13cmos5l_ip__title
.ends

* Black-box entry subcircuit for sg13cmos5l_IOPadOut30mA abstract view
.subckt sg13cmos5l_IOPadOut30mA c2p iovdd iovss pad vdd vss
.ends

* Black-box entry subcircuit for sg13cmos5l_Corner abstract view
.subckt sg13cmos5l_Corner iovdd iovss vdd vss
.ends

* Black-box entry subcircuit for sg13cmos5l_IOPadAnalog abstract view
.subckt sg13cmos5l_IOPadAnalog iovdd iovss pad padbare padres vdd vss
.ends

* Black-box entry subcircuit for sg13cmos5l_IOPadVdd abstract view
.subckt sg13cmos5l_IOPadVdd iovdd iovss vdd vss
.ends

* Black-box entry subcircuit for XNOR2X1 abstract view
.subckt XNOR2X1 A B VDD VSS Y
.ends

* Black-box entry subcircuit for sg13cmos5l_IOPadOut4mA abstract view
.subckt sg13cmos5l_IOPadOut4mA c2p iovdd iovss pad vdd vss
.ends

* Black-box entry subcircuit for sg13cmos5l_IOPadIOVdd abstract view
.subckt sg13cmos5l_IOPadIOVdd iovdd iovss vdd vss
.ends

* Black-box entry subcircuit for sg13cmos5l_IOPadIOVss abstract view
.subckt sg13cmos5l_IOPadIOVss iovdd iovss vdd vss
.ends

* Black-box entry subcircuit for decap_vdda abstract view
.subckt decap_vdda VDD VSS
.ends

* Black-box entry subcircuit for sg13cmos5l_ip__jku abstract view
.subckt sg13cmos5l_ip__jku
.ends

* Black-box entry subcircuit for XOR2X1 abstract view
.subckt XOR2X1 A B VDD VSS Y
.ends

* Black-box entry subcircuit for sg13cmos5l_IOPadIn abstract view
.subckt sg13cmos5l_IOPadIn iovdd iovss p2c pad vdd vss
.ends

* Black-box entry subcircuit for BUFX3 abstract view
.subckt BUFX3 A VDD VSS Y
.ends

* Black-box entry subcircuit for sg13cmos5l_ip__cut_vdd abstract view
.subckt sg13cmos5l_ip__cut_vdd iovdd iovss vss
.ends

* Black-box entry subcircuit for dsa1_dig_top abstract view
.subckt dsa1_dig_top VDD VSS adc_conv clk data_in miso mosi o_aux_ctrl[0] o_aux_ctrl[10]
+ o_aux_ctrl[11] o_aux_ctrl[12] o_aux_ctrl[13] o_aux_ctrl[14] o_aux_ctrl[15] o_aux_ctrl[1]
+ o_aux_ctrl[2] o_aux_ctrl[3] o_aux_ctrl[4] o_aux_ctrl[5] o_aux_ctrl[6] o_aux_ctrl[7]
+ o_aux_ctrl[8] o_aux_ctrl[9] o_bias_cfg[0] o_bias_cfg[10] o_bias_cfg[11] o_bias_cfg[12]
+ o_bias_cfg[13] o_bias_cfg[14] o_bias_cfg[15] o_bias_cfg[16] o_bias_cfg[17] o_bias_cfg[18]
+ o_bias_cfg[19] o_bias_cfg[1] o_bias_cfg[20] o_bias_cfg[21] o_bias_cfg[22] o_bias_cfg[23]
+ o_bias_cfg[24] o_bias_cfg[25] o_bias_cfg[26] o_bias_cfg[27] o_bias_cfg[28] o_bias_cfg[29]
+ o_bias_cfg[2] o_bias_cfg[30] o_bias_cfg[31] o_bias_cfg[32] o_bias_cfg[33] o_bias_cfg[34]
+ o_bias_cfg[3] o_bias_cfg[4] o_bias_cfg[5] o_bias_cfg[6] o_bias_cfg[7] o_bias_cfg[8]
+ o_bias_cfg[9] o_clk_cfg[0] o_clk_cfg[10] o_clk_cfg[11] o_clk_cfg[12] o_clk_cfg[13]
+ o_clk_cfg[14] o_clk_cfg[15] o_clk_cfg[16] o_clk_cfg[17] o_clk_cfg[18] o_clk_cfg[1]
+ o_clk_cfg[2] o_clk_cfg[3] o_clk_cfg[4] o_clk_cfg[5] o_clk_cfg[6] o_clk_cfg[7] o_clk_cfg[8]
+ o_clk_cfg[9] o_en_ctrl[0] o_en_ctrl[10] o_en_ctrl[1] o_en_ctrl[2] o_en_ctrl[3] o_en_ctrl[4]
+ o_en_ctrl[5] o_en_ctrl[6] o_en_ctrl[7] o_en_ctrl[8] o_en_ctrl[9] o_lf_cfg[0] o_lf_cfg[10]
+ o_lf_cfg[11] o_lf_cfg[12] o_lf_cfg[13] o_lf_cfg[14] o_lf_cfg[15] o_lf_cfg[1] o_lf_cfg[2]
+ o_lf_cfg[3] o_lf_cfg[4] o_lf_cfg[5] o_lf_cfg[6] o_lf_cfg[7] o_lf_cfg[8] o_lf_cfg[9]
+ o_rst_ctrl_b[0] o_rst_ctrl_b[1] o_tst_ctrl[0] o_tst_ctrl[10] o_tst_ctrl[11] o_tst_ctrl[12]
+ o_tst_ctrl[13] o_tst_ctrl[14] o_tst_ctrl[15] o_tst_ctrl[1] o_tst_ctrl[2] o_tst_ctrl[3]
+ o_tst_ctrl[4] o_tst_ctrl[5] o_tst_ctrl[6] o_tst_ctrl[7] o_tst_ctrl[8] o_tst_ctrl[9]
+ o_uwb_tx_cfg[0] o_uwb_tx_cfg[10] o_uwb_tx_cfg[11] o_uwb_tx_cfg[12] o_uwb_tx_cfg[13]
+ o_uwb_tx_cfg[14] o_uwb_tx_cfg[15] o_uwb_tx_cfg[16] o_uwb_tx_cfg[17] o_uwb_tx_cfg[18]
+ o_uwb_tx_cfg[19] o_uwb_tx_cfg[1] o_uwb_tx_cfg[20] o_uwb_tx_cfg[21] o_uwb_tx_cfg[22]
+ o_uwb_tx_cfg[23] o_uwb_tx_cfg[24] o_uwb_tx_cfg[25] o_uwb_tx_cfg[26] o_uwb_tx_cfg[27]
+ o_uwb_tx_cfg[28] o_uwb_tx_cfg[29] o_uwb_tx_cfg[2] o_uwb_tx_cfg[3] o_uwb_tx_cfg[4]
+ o_uwb_tx_cfg[5] o_uwb_tx_cfg[6] o_uwb_tx_cfg[7] o_uwb_tx_cfg[8] o_uwb_tx_cfg[9]
+ rst_b sclk ss
.ends

* Black-box entry subcircuit for NAND4BX1 abstract view
.subckt NAND4BX1 AB B C D VDD VSS Y
.ends

* Black-box entry subcircuit for NOR2X1 abstract view
.subckt NOR2X1 A B VDD VSS Y
.ends

* Black-box entry subcircuit for AOI2B1X1 abstract view
.subckt AOI2B1X1 AB B C VDD VSS Y
.ends

* Black-box entry subcircuit for sg13cmos5l_ip__helm abstract view
.subckt sg13cmos5l_ip__helm
.ends

* Black-box entry subcircuit for AND3BX1 abstract view
.subckt AND3BX1 AB B C VDD VSS Y
.ends

* Black-box entry subcircuit for dsm2_core abstract view
.subckt dsm2_core di_btest_en di_clk di_clk_sel di_dith_amp[0] di_dith_amp[1] di_dith_en
+ di_ena di_osc_en di_qout_en di_rst_b di_trim[0] di_trim[1] di_trim[2] di_trim[3]
+ di_vcm_ext do_clk_osc do_osc_oe do_q do_q_b do_q_dec ibias_test vcm vdd vi vss
.ends

* Black-box entry subcircuit for sg13cmos5l_ip__jku_names abstract view
.subckt sg13cmos5l_ip__jku_names
.ends

* Black-box entry subcircuit for MUX2X1 abstract view
.subckt MUX2X1 A0 A1 S0 VDD VSS Y
.ends

* Black-box entry subcircuit for NOR2BX1 abstract view
.subckt NOR2BX1 AB B VDD VSS Y
.ends

* Black-box entry subcircuit for AO31X1 abstract view
.subckt AO31X1 A B C D VDD VSS Y
.ends

* Black-box entry subcircuit for AND2X1 abstract view
.subckt AND2X1 A B VDD VSS Y
.ends

* Black-box entry subcircuit for INVX1 abstract view
.subckt INVX1 A VDD VSS Y
.ends

* Black-box entry subcircuit for ANTENNA2 abstract view
.subckt ANTENNA2 A VDD VSS
.ends

.subckt MPC9724 IOVDD IOVSS VDD VDDA VSS analog_PAD[0] analog_PAD[1]
+ analog_PAD[2] clk_PAD do_q_PAD do_q_b_PAD dsm_clk_PAD input_PAD[0] input_PAD[1]
+ input_PAD[2] input_PAD[3] output_PAD[0] output_PAD[1] rst_n_PAD
XFILLER_22_133 VSS VDD FILLER2
XIO_FILL_IO_NORTH_1_20 IOVDD IOVSS VDD VSS sg13cmos5l_Filler400
XTAP_TAPCELL_ROW_8_1_134 VDD VSS WELLTAP
XTAP_TAPCELL_ROW_176_1_247 VDD VSS WELLTAP
XFILLER_1_593 VDD VSS DECAPHV32
XFILLER_10_125 VDD VSS DECAPHV8
XFILLER_6_129 VDD VSS DECAPHV8
XFILLER_12_43 VSS VDD FILLER2
XFILLER_15_965 VDD VSS DECAPHV32
XFILLER_14_453 VDD VSS DECAPHV32
XFILLER_5_184 VSS VDD FILLER2
XTAP_TAPCELL_ROW_7_1_122 VDD VSS WELLTAP
XTAP_TAPCELL_ROW_175_1_235 VDD VSS WELLTAP
XFILLER_12_935 VDD VSS DECAPHV8
XFILLER_3_1393 VSS VDD FILLER2
XFILLER_19_556 VSS VDD FILLER2
XFILLER_4_1168 VSS VDD FILLER2
XFILLER_9_55 VDD VSS DECAPHV32
XFILLER_9_1013 VDD VSS DECAPHV8
XFILLER_4_408 VDD VSS DECAPHV32
XFILLER_12_710 VDD VSS DECAPHV8
XFILLER_3_463 VSS VDD FILLER2
XTAP_TAPCELL_ROW_174_1_234 VDD VSS WELLTAP
XTAP_TAPCELL_ROW_6_1_110 VDD VSS WELLTAP
XFILLER_19_375 VDD VSS DECAPHV32
XIO_FILL_IO_SOUTH_3_0 IOVDD IOVSS VDD VSS sg13cmos5l_Filler4000
XFILLER_6_290 VDD VSS DECAPHV8
XIO_FILL_IO_NORTH_4_20 IOVDD IOVSS VDD VSS sg13cmos5l_Filler400
XTAP_TAPCELL_ROW_5_1_312 VDD VSS WELLTAP
XFILLER_0_1385 VDD VSS DECAPHV8
XFILLER_20_32 VDD VSS DECAPHV8
XFILLER_17_835 VSS VDD FILLER2
XFILLER_16_323 VSS VDD FILLER2
XTAP_TAPCELL_ROW_9_1_147 VDD VSS WELLTAP
XFILLER_3_282 VDD VSS DECAPHV32
XFILLER_0_1160 VDD VSS DECAPHV8
XFILLER_15_32 VDD VSS DECAPHV32
XTAP_TAPCELL_ROW_173_1_222 VDD VSS WELLTAP
XFILLER_21_370 VSS VDD FILLER2
XTAP_TAPCELL_ROW_2_46 VDD VSS WELLTAP
XFILLER_1_742 VSS VDD FILLER2
XTAP_TAPCELL_ROW_2_57 VDD VSS WELLTAP
XFILLER_17_654 VDD VSS DECAPHV32
XFILLER_16_142 VDD VSS DECAPHV32
XFILLER_22_178 VSS VDD FILLER2
XTAP_TAPCELL_ROW_8_1_135 VDD VSS WELLTAP
XTAP_TAPCELL_ROW_176_1_248 VDD VSS WELLTAP
XFILLER_14_602 VSS VDD FILLER2
XFILLER_13_189 VDD VSS DECAPHV32
XFILLER_1_561 VDD VSS DECAPHV32
XFILLER_5_366 VDD VSS FILLER4
XFILLER_18_974 VSS VDD FILLER2
Xclamp_vdda IOVDD IOVSS VDDA VSS sg13cmos5l_ip__clamp_vddvss
XTAP_TAPCELL_ROW_172_1_210 VDD VSS WELLTAP
XFILLER_12_88 VSS VDD FILLER2
XFILLER_15_933 VDD VSS DECAPHV32
XFILLER_14_421 VDD VSS DECAPHV32
XFILLER_2_881 VSS VDD FILLER2
XFILLER_18_793 VDD VSS DECAPHV32
XIO_FILL_IO_NORTH_0_0 IOVDD IOVSS VDD VSS sg13cmos5l_Filler4000
XTAP_TAPCELL_ROW_7_1_123 VDD VSS WELLTAP
XTAP_TAPCELL_ROW_175_1_236 VDD VSS WELLTAP
XFILLER_12_903 VDD VSS DECAPHV32
XFILLER_8_918 VDD VSS DECAPHV32
XFILLER_7_439 VDD VSS DECAPHV16
XFILLER_9_12 VSS VDD FILLER2
XFILLER_9_23 VDD VSS DECAPHV32
XFILLER_18_32 VDD VSS DECAPHV8
XFILLER_12_755 VDD VSS DECAPHV8
XFILLER_4_943 VSS VDD FILLER2
XTAP_TAPCELL_ROW_6_1_111 VDD VSS WELLTAP
XTAP_TAPCELL_ROW_174_1_224 VDD VSS WELLTAP
XFILLER_15_593 VDD VSS DECAPHV32
XFILLER_0_1353 VDD VSS DECAPHV32
XTAP_TAPCELL_ROW_5_1_313 VDD VSS WELLTAP
XFILLER_4_228 VDD VSS DECAPHV32
XFILLER_5_718 VDD VSS DECAPHV16
XFILLER_20_44 VSS VDD FILLER2
XFILLER_1_1106 VDD VSS DECAPHV8
XTAP_TAPCELL_ROW_9_1_148 VDD VSS WELLTAP
XFILLER_12_530 VDD VSS DECAPHV8
XFILLER_8_501 VDD VSS DECAPHV8
XFILLER_8_578 VDD VSS DECAPHV16
XFILLER_19_184 VSS VDD FILLER2
XFILLER_22_305 VDD VSS DECAPHV8
XFILLER_2_1415 VDD VSS DECAPHV8
XTAP_TAPCELL_ROW_173_1_223 VDD VSS WELLTAP
XFILLER_15_88 VDD VSS FILLER4
XTAP_TAPCELL_ROW_2_47 VDD VSS WELLTAP
XFILLER_5_548 VDD VSS DECAPHV8
XTAP_TAPCELL_ROW_2_58 VDD VSS WELLTAP
Xdelaybuf_3_clk delaybuf_3_clk/A VDD VSS delaybuf_4_clk/A BUFX12
XFILLER_13_872 VDD VSS DECAPHV32
XFILLER_8_320 VDD VSS FILLER1
XIO_FILL_IO_NORTH_1_22 IOVDD IOVSS VDD VSS sg13cmos5l_Filler400
XTAP_TAPCELL_ROW_8_1_136 VDD VSS WELLTAP
XFILLER_2_1245 VDD VSS DECAPHV8
XTAP_TAPCELL_ROW_176_1_249 VDD VSS WELLTAP
XFILLER_18_408 VDD VSS DECAPHV8
XFILLER_9_128 VDD VSS DECAPHV32
XFILLER_6_857 VDD VSS DECAPHV16
XFILLER_10_853 VSS VDD FILLER2
XFILLER_17_463 VSS VDD FILLER2
XFILLER_20_639 VDD VSS DECAPHV32
XTAP_TAPCELL_ROW_172_1_211 VDD VSS WELLTAP
XTAP_TAPCELL_ROW_180_1_290 VDD VSS WELLTAP
XFILLER_10_138 VDD VSS DECAPHV32
XFILLER_3_827 VDD VSS DECAPHV8
XFILLER_12_23 VDD VSS DECAPHV16
XFILLER_2_315 VDD VSS DECAPHV8
XFILLER_6_687 VDD VSS DECAPHV8
XFILLER_1_370 VSS VDD FILLER2
XFILLER_21_904 VDD VSS DECAPHV16
XTAP_TAPCELL_ROW_7_1_124 VDD VSS WELLTAP
XFILLER_17_282 VDD VSS DECAPHV32
XTAP_TAPCELL_ROW_175_1_237 VDD VSS WELLTAP
XIO_BOND_g_inputs\[3\].input_pad input_PAD[3] sg13cmos5l_ip__bondpad_70x70
XFILLER_0_808 VSS VDD FILLER2
XFILLER_12_948 VDD VSS DECAPHV32
XFILLER_7_407 VDD VSS DECAPHV32
Xdsm_clk_pad dsm_clk_pad/c2p dsm2/do_osc_oe IOVDD IOVSS dsm2/di_clk dsm_clk_PAD VDDA
+ VSS sg13cmos5l_IOPadInOut4mA
XFILLER_4_1115 VDD VSS DECAPHV8
XFILLER_15_742 VSS VDD FILLER2
XFILLER_0_48 VDD VSS DECAPHV32
XFILLER_14_230 VSS VDD FILLER2
XIO_FILL_IO_WEST_2_0 IOVDD IOVSS VDD VSS sg13cmos5l_Filler4000
XFILLER_21_734 VDD VSS DECAPHV8
XFILLER_20_222 VDD VSS DECAPHV8
XFILLER_20_299 VDD VSS DECAPHV16
XFILLER_18_44 VSS VDD FILLER2
XFILLER_12_723 VDD VSS DECAPHV32
XFILLER_1_0 VDD VSS DECAPHV32
XTAP_TAPCELL_ROW_6_1_112 VDD VSS WELLTAP
XFILLER_4_988 VSS VDD FILLER2
XTAP_TAPCELL_ROW_174_1_225 VDD VSS WELLTAP
XFILLER_15_561 VDD VSS DECAPHV32
XIO_FILL_IO_NORTH_4_22 IOVDD IOVSS VDD VSS sg13cmos5l_Filler400
XFILLER_1_80 VDD VSS DECAPHV8
XTAP_TAPCELL_ROW_5_1_314 VDD VSS WELLTAP
XFILLER_0_1398 VDD VSS DECAPHV16
XFILLER_21_1013 VDD VSS DECAPHV8
XFILLER_8_546 VDD VSS DECAPHV32
XIO_FILL_IO_SOUTH_7_20 IOVDD IOVSS VDDA VSS sg13cmos5l_Filler1000
XFILLER_12_575 VDD VSS DECAPHV8
XFILLER_0_980 VDD VSS DECAPHV8
XFILLER_4_763 VSS VDD FILLER2
XFILLER_16_881 VSS VDD FILLER2
XFILLER_2_1427 VDD VSS FILLER1
XFILLER_0_1173 VDD VSS DECAPHV32
XTAP_TAPCELL_ROW_2_48 VDD VSS WELLTAP
XTAP_TAPCELL_ROW_2_59 VDD VSS WELLTAP
XFILLER_13_840 VDD VSS DECAPHV32
XFILLER_8_310 VSS VDD FILLER2
XFILLER_9_811 VDD VSS DECAPHV16
XFILLER_22_125 VDD VSS DECAPHV8
XTAP_TAPCELL_ROW_8_1_137 VDD VSS WELLTAP
XFILLER_6_825 VDD VSS DECAPHV32
XFILLER_10_898 VSS VDD FILLER2
XFILLER_20_607 VDD VSS DECAPHV32
XFILLER_9_641 VDD VSS DECAPHV8
XIO_BOND_g_inputs\[2\].input_pad input_PAD[2] sg13cmos5l_ip__bondpad_70x70
XIO_FILL_IO_EAST_0_0 IOVDD IOVSS VDDA VSS sg13cmos5l_Filler4000
XTAP_TAPCELL_ROW_172_1_212 VDD VSS WELLTAP
XTAP_TAPCELL_ROW_180_1_291 VDD VSS WELLTAP
XFILLER_19_718 VDD VSS DECAPHV16
XFILLER_4_1308 VDD VSS DECAPHV32
XFILLER_18_206 VDD VSS DECAPHV16
XFILLER_2_1043 VDD VSS DECAPHV16
Xclamp_vddvss IOVDD IOVSS VDD VSS sg13cmos5l_ip__clamp_vddvss
XFILLER_10_673 VSS VDD FILLER2
XFILLER_5_176 VDD VSS DECAPHV8
XTAP_TAPCELL_ROW_10_1_170 VDD VSS WELLTAP
XTAP_TAPCELL_ROW_7_1_125 VDD VSS WELLTAP
XTAP_TAPCELL_ROW_175_1_238 VDD VSS WELLTAP
XFILLER_4_80 VDD VSS DECAPHV8
XFILLER_3_1385 VDD VSS DECAPHV8
XFILLER_2_113 VDD VSS DECAPHV16
XFILLER_3_625 VDD VSS DECAPHV16
XFILLER_19_548 VDD VSS DECAPHV8
XFILLER_9_14 VDD VSS FILLER1
XTAP_TAPCELL_ROW_171_1_200 VDD VSS WELLTAP
XFILLER_6_485 VDD VSS DECAPHV16
XFILLER_7_920 VDD VSS DECAPHV8
XFILLER_7_997 VDD VSS DECAPHV16
XFILLER_21_779 VDD VSS DECAPHV32
XFILLER_20_267 VDD VSS DECAPHV32
XFILLER_0_628 VSS VDD FILLER2
XFILLER_9_290 VDD VSS FILLER1
XFILLER_12_768 VDD VSS DECAPHV32
XFILLER_3_455 VDD VSS DECAPHV8
XTAP_TAPCELL_ROW_6_1_113 VDD VSS WELLTAP
XTAP_TAPCELL_ROW_174_1_226 VDD VSS WELLTAP
X_29_ _30_/CK _29_/D _29_/Q _30_/RB VDD VSS DFFRQX1
XFILLER_1_92 VDD VSS FILLER1
XFILLER_14_1021 VDD VSS FILLER1
XFILLER_21_532 VDD VSS DECAPHV16
XTAP_TAPCELL_ROW_5_1_315 VDD VSS WELLTAP
XFILLER_0_403 VSS VDD FILLER2
XFILLER_1_904 VDD VSS DECAPHV16
XFILLER_17_827 VDD VSS DECAPHV8
XFILLER_1_1119 VDD VSS DECAPHV32
XFILLER_16_315 VDD VSS DECAPHV8
XTAP_TAPCELL_ROW_9_1_139 VDD VSS WELLTAP
XFILLER_8_514 VDD VSS DECAPHV32
XFILLER_12_543 VDD VSS DECAPHV32
XFILLER_6_1019 VSS VDD FILLER2
XFILLER_15_370 VSS VDD FILLER2
XFILLER_22_318 VDD VSS DECAPHV32
XIO_FILL_IO_SOUTH_1_0 IOVDD IOVSS VDD VSS sg13cmos5l_Filler4000
XFILLER_21_362 VDD VSS DECAPHV8
XTAP_TAPCELL_ROW_2_49 VDD VSS WELLTAP
XTAP_TAPCELL_ROW_173_1_214 VDD VSS WELLTAP
XFILLER_1_734 VDD VSS DECAPHV8
XFILLER_12_395 VDD VSS DECAPHV8
XIO_BOND_g_inputs\[1\].input_pad input_PAD[1] sg13cmos5l_ip__bondpad_70x70
XFILLER_4_583 VSS VDD FILLER2
XFILLER_2_509 VSS VDD FILLER2
XFILLER_7_80 VDD VSS DECAPHV8
XTAP_TAPCELL_ROW_8_1_138 VDD VSS WELLTAP
XFILLER_2_1258 VDD VSS DECAPHV32
XFILLER_10_800 VDD VSS DECAPHV8
XFILLER_5_358 VDD VSS DECAPHV8
XFILLER_18_966 VDD VSS DECAPHV8
XFILLER_8_174 VDD VSS DECAPHV32
XTAP_TAPCELL_ROW_3_70 VDD VSS WELLTAP
XFILLER_9_686 VDD VSS DECAPHV32
XFILLER_12_170 VDD VSS DECAPHV8
XTAP_TAPCELL_ROW_172_1_213 VDD VSS WELLTAP
XTAP_TAPCELL_ROW_180_1_292 VDD VSS WELLTAP
XFILLER_2_328 VDD VSS DECAPHV32
XFILLER_2_1011 VDD VSS DECAPHV32
XFILLER_18_1019 VSS VDD FILLER2
XFILLER_2_873 VDD VSS DECAPHV8
XTAP_TAPCELL_ROW_10_1_160 VDD VSS WELLTAP
XFILLER_21_928 VSS VDD FILLER2
XTAP_TAPCELL_ROW_7_1_126 VDD VSS WELLTAP
XFILLER_20_416 VSS VDD FILLER2
XTAP_TAPCELL_ROW_175_1_239 VDD VSS WELLTAP
XFILLER_20_950 VDD VSS DECAPHV16
XFILLER_4_1128 VDD VSS DECAPHV32
XTAP_TAPCELL_ROW_171_1_201 VDD VSS WELLTAP
XFILLER_6_453 VDD VSS DECAPHV32
XFILLER_10_493 VSS VDD FILLER2
XFILLER_7_965 VDD VSS DECAPHV32
XFILLER_21_747 VDD VSS DECAPHV32
XFILLER_20_235 VDD VSS DECAPHV32
XFILLER_3_1183 VDD VSS DECAPHV16
XFILLER_20_780 VDD VSS DECAPHV8
XFILLER_4_935 VDD VSS DECAPHV8
XTAP_TAPCELL_ROW_6_1_114 VDD VSS WELLTAP
XTAP_TAPCELL_ROW_174_1_227 VDD VSS WELLTAP
XFILLER_19_346 VDD VSS DECAPHV16
Xg_vss_pads\[0\].vss_pad IOVDD IOVSS VDD VSS sg13cmos5l_IOPadVss
X_28_ _28_/CK _28_/D _28_/Q _30_/RB VDD VSS DFFRQX1
XFILLER_21_500 VDD VSS DECAPHV32
XTAP_TAPCELL_ROW_5_1_316 VDD VSS WELLTAP
XFILLER_14_1011 VDD VSS DECAPHV8
XFILLER_0_448 VSS VDD FILLER2
XFILLER_12_588 VDD VSS DECAPHV16
XFILLER_3_253 VDD VSS DECAPHV16
XFILLER_10_80 VDD VSS DECAPHV8
Xdelaybuf_6_clk delaybuf_6_clk/A VDD VSS delaybuf_7_clk/A BUFX12
XIO_BOND_g_inputs\[0\].input_pad input_PAD[0] sg13cmos5l_ip__bondpad_70x70
XFILLER_6_49 VDD VSS DECAPHV32
XFILLER_4_710 VDD VSS DECAPHV8
XFILLER_0_993 VDD VSS DECAPHV32
XFILLER_19_176 VDD VSS DECAPHV8
XFILLER_22_853 VSS VDD FILLER2
XTAP_TAPCELL_ROW_173_1_215 VDD VSS WELLTAP
XFILLER_0_223 VSS VDD FILLER2
XFILLER_1_779 VDD VSS DECAPHV32
XFILLER_17_625 VDD VSS DECAPHV16
XFILLER_16_113 VDD VSS DECAPHV16
XFILLER_8_312 VDD VSS FILLER1
XFILLER_9_835 VSS VDD FILLER2
XFILLER_12_363 VDD VSS DECAPHV32
XIO_FILL_IO_EAST_2_20 IOVDD IOVSS VDDA VSS sg13cmos5l_Filler2000
Xtitle_art sg13cmos5l_ip__title
XFILLER_22_138 VDD VSS DECAPHV32
XFILLER_7_92 VDD VSS FILLER1
XTAP_TAPCELL_ROW_8_1_128 VDD VSS WELLTAP
XFILLER_14_639 VDD VSS DECAPHV32
XFILLER_5_326 VDD VSS DECAPHV32
XFILLER_10_845 VDD VSS DECAPHV8
XFILLER_21_160 VDD VSS DECAPHV16
XFILLER_1_532 VDD VSS DECAPHV16
XFILLER_17_455 VDD VSS DECAPHV8
XFILLER_8_142 VDD VSS DECAPHV32
XFILLER_9_654 VDD VSS DECAPHV32
XTAP_TAPCELL_ROW_3_71 VDD VSS WELLTAP
XTAP_TAPCELL_ROW_172_1_203 VDD VSS WELLTAP
XFILLER_1_1292 VDD VSS DECAPHV8
XTAP_TAPCELL_ROW_180_1_293 VDD VSS WELLTAP
XFILLER_12_48 VDD VSS DECAPHV32
XFILLER_15_904 VDD VSS DECAPHV16
XFILLER_10_620 VDD VSS DECAPHV8
XFILLER_2_1067 VSS VDD FILLER2
XFILLER_5_189 VDD VSS DECAPHV32
XFILLER_6_602 VSS VDD FILLER2
XFILLER_1_362 VDD VSS DECAPHV8
XTAP_TAPCELL_ROW_10_1_150 VDD VSS WELLTAP
XTAP_TAPCELL_ROW_10_1_161 VDD VSS WELLTAP
XFILLER_18_764 VDD VSS DECAPHV16
XTAP_TAPCELL_ROW_7_1_127 VDD VSS WELLTAP
XIO_BOND_g_outputs\[1\].output_pad output_PAD[1] sg13cmos5l_ip__bondpad_70x70
XFILLER_4_93 VDD VSS DECAPHV32
XFILLER_3_1398 VDD VSS DECAPHV16
XFILLER_2_137 VSS VDD FILLER2
XFILLER_3_649 VSS VDD FILLER2
XFILLER_15_734 VDD VSS DECAPHV8
XFILLER_14_222 VDD VSS DECAPHV8
XFILLER_7_933 VDD VSS DECAPHV32
XFILLER_14_299 VDD VSS DECAPHV16
XTAP_TAPCELL_ROW_171_1_202 VDD VSS WELLTAP
XFILLER_6_421 VDD VSS DECAPHV32
XFILLER_13_91 VSS VDD FILLER2
XFILLER_2_671 VDD VSS DECAPHV16
XFILLER_18_594 VDD VSS DECAPHV8
XFILLER_9_270 VDD VSS FILLER1
XFILLER_3_1151 VDD VSS DECAPHV32
XFILLER_16_509 VSS VDD FILLER2
XFILLER_3_468 VDD VSS DECAPHV32
XFILLER_4_903 VDD VSS DECAPHV32
XTAP_TAPCELL_ROW_6_1_115 VDD VSS WELLTAP
XTAP_TAPCELL_ROW_174_1_228 VDD VSS WELLTAP
XFILLER_19_314 VDD VSS DECAPHV32
XIO_FILL_IO_WEST_0_0 IOVDD IOVSS VDD VSS sg13cmos5l_Filler4000
XIO_FILL_IO_EAST_5_20 IOVDD IOVSS VDDA VSS sg13cmos5l_Filler2000
X_27_ _28_/CK _27_/D _27_/Q _30_/RB VDD VSS DFFRQX1
XFILLER_21_556 VSS VDD FILLER2
XTAP_TAPCELL_ROW_5_1_317 VDD VSS WELLTAP
XFILLER_1_928 VSS VDD FILLER2
XFILLER_16_328 VDD VSS DECAPHV16
XFILLER_3_221 VDD VSS DECAPHV32
XFILLER_4_755 VDD VSS DECAPHV8
XFILLER_13_8 VDD VSS FILLER4
XFILLER_16_873 VDD VSS DECAPHV8
XFILLER_7_593 VDD VSS DECAPHV32
XFILLER_22_898 VSS VDD FILLER2
XTAP_TAPCELL_ROW_173_1_216 VDD VSS WELLTAP
XFILLER_21_375 VDD VSS DECAPHV32
XFILLER_1_747 VDD VSS DECAPHV32
XFILLER_0_268 VSS VDD FILLER2
XFILLER_5_1021 VDD VSS FILLER1
XFILLER_12_353 VDD VSS FILLER4
XFILLER_4_530 VDD VSS DECAPHV8
XFILLER_21_80 VDD VSS DECAPHV8
XTAP_TAPCELL_ROW_8_1_129 VDD VSS WELLTAP
XFILLER_13_128 VDD VSS DECAPHV32
XFILLER_14_607 VDD VSS DECAPHV32
XFILLER_22_673 VSS VDD FILLER2
XFILLER_10_813 VDD VSS DECAPHV32
XFILLER_1_500 VDD VSS DECAPHV32
XFILLER_18_979 VDD VSS DECAPHV32
XFILLER_12_183 VDD VSS DECAPHV32
XTAP_TAPCELL_ROW_3_61 VDD VSS WELLTAP
XFILLER_5_872 VDD VSS DECAPHV32
XTAP_TAPCELL_ROW_3_72 VDD VSS WELLTAP
XTAP_TAPCELL_ROW_172_1_204 VDD VSS WELLTAP
XTAP_TAPCELL_ROW_180_1_294 VDD VSS WELLTAP
XFILLER_10_665 VDD VSS DECAPHV8
XTAP_TAPCELL_ROW_10_1_151 VDD VSS WELLTAP
XTAP_TAPCELL_ROW_10_1_162 VDD VSS WELLTAP
XFILLER_2_886 VDD VSS DECAPHV32
XFILLER_18_732 VDD VSS DECAPHV32
XFILLER_17_253 VDD VSS DECAPHV16
XFILLER_9_463 VSS VDD FILLER2
XFILLER_3_1300 VSS VDD FILLER2
XFILLER_17_1021 VDD VSS FILLER1
XFILLER_1_1090 VDD VSS DECAPHV16
XFILLER_20_974 VSS VDD FILLER2
Xg_outputs\[1\].output_pad g_outputs\[1\].output_pad/c2p IOVDD IOVSS output_PAD[1]
+ VDD VSS sg13cmos5l_IOPadOut30mA
XFILLER_15_779 VDD VSS DECAPHV32
XFILLER_10_440 VDD VSS DECAPHV8
XFILLER_14_267 VDD VSS DECAPHV32
XFILLER_1_160 VDD VSS DECAPHV16
XFILLER_9_282 VDD VSS DECAPHV8
XFILLER_20_793 VDD VSS DECAPHV32
XFILLER_4_948 VDD VSS DECAPHV32
XTAP_TAPCELL_ROW_6_1_116 VDD VSS WELLTAP
XTAP_TAPCELL_ROW_174_1_229 VDD VSS WELLTAP
XFILLER_15_532 VDD VSS DECAPHV16
XFILLER_6_263 VDD VSS FILLER4
XFILLER_6_230 VSS VDD FILLER2
XFILLER_7_742 VSS VDD FILLER2
XIO_BOND_vcm_pad analog_PAD[1] sg13cmos5l_ip__bondpad_70x70
X_26_ _30_/CK _26_/D _26_/Q _30_/RB VDD VSS DFFRQX1
XFILLER_0_1303 VSS VDD FILLER2
XFILLER_18_392 VDD VSS DECAPHV16
XTAP_TAPCELL_ROW_5_1_318 VDD VSS WELLTAP
XFILLER_20_49 VDD VSS DECAPHV32
XFILLER_4_723 VDD VSS DECAPHV32
XFILLER_3_277 VSS VDD FILLER2
XFILLER_10_93 VDD VSS DECAPHV32
XFILLER_19_80 VDD VSS DECAPHV8
XFILLER_19_189 VDD VSS DECAPHV32
XFILLER_15_362 VDD VSS DECAPHV8
XFILLER_7_561 VDD VSS DECAPHV32
XFILLER_22_800 VDD VSS DECAPHV8
XTAP_TAPCELL_ROW_173_1_217 VDD VSS WELLTAP
XFILLER_17_649 VSS VDD FILLER2
XFILLER_16_137 VSS VDD FILLER2
XFILLER_13_811 VDD VSS DECAPHV16
XFILLER_4_575 VDD VSS DECAPHV8
XFILLER_21_92 VDD VSS FILLER1
XFILLER_16_671 VDD VSS DECAPHV16
XIO_CORNER_NORTH_EAST_INST IOVDD IOVSS VDD VSS sg13cmos5l_Corner
XFILLER_8_881 VSS VDD FILLER2
XFILLER_10_858 VDD VSS DECAPHV32
XFILLER_21_184 VSS VDD FILLER2
XFILLER_1_556 VSS VDD FILLER2
XFILLER_17_468 VDD VSS DECAPHV32
XFILLER_16_81 VDD VSS DECAPHV32
XFILLER_13_641 VDD VSS DECAPHV8
XTAP_TAPCELL_ROW_3_62 VDD VSS WELLTAP
XFILLER_4_350 VDD VSS DECAPHV8
XFILLER_5_840 VDD VSS DECAPHV32
XTAP_TAPCELL_ROW_3_73 VDD VSS WELLTAP
XTAP_TAPCELL_ROW_172_1_205 VDD VSS WELLTAP
XTAP_TAPCELL_ROW_180_1_295 VDD VSS WELLTAP
XFILLER_12_39 VDD VSS FILLER4
Xvcm_pad IOVDD IOVSS analog_PAD[1] vcm_pad/padbare dsm2/vcm VDDA VSS sg13cmos5l_IOPadAnalog
XFILLER_15_928 VSS VDD FILLER2
XFILLER_14_416 VSS VDD FILLER2
XFILLER_22_493 VSS VDD FILLER2
XFILLER_10_633 VDD VSS DECAPHV32
XFILLER_18_700 VDD VSS DECAPHV32
XFILLER_1_375 VDD VSS DECAPHV32
XTAP_TAPCELL_ROW_10_1_152 VDD VSS WELLTAP
XTAP_TAPCELL_ROW_10_1_163 VDD VSS WELLTAP
XFILLER_17_221 VDD VSS DECAPHV32
XFILLER_18_788 VSS VDD FILLER2
XFILLER_14_950 VDD VSS DECAPHV16
XTAP_TAPCELL_ROW_7_1_118 VDD VSS WELLTAP
XFILLER_20_408 VDD VSS DECAPHV8
XFILLER_4_40 VDD VSS FILLER4
XFILLER_15_747 VDD VSS DECAPHV32
XFILLER_14_235 VDD VSS DECAPHV32
XFILLER_10_485 VDD VSS DECAPHV8
XFILLER_2_695 VSS VDD FILLER2
XTAP_TAPCELL_ROW_0_30 VDD VSS WELLTAP
XFILLER_14_780 VDD VSS DECAPHV8
XFILLER_18_49 VDD VSS DECAPHV32
XTAP_TAPCELL_ROW_6_1_117 VDD VSS WELLTAP
XFILLER_15_500 VDD VSS DECAPHV32
Xdelaybuf_9_clk delaybuf_9_clk/A VDD VSS delaybuf_9_clk/Y BUFX12
XFILLER_10_293 VSS VDD FILLER2
XFILLER_19_872 VDD VSS DECAPHV32
XFILLER_1_96 VDD VSS DECAPHV32
X_25_ _28_/CK _25_/D _25_/Q _30_/RB VDD VSS DFFRQX1
XFILLER_0_1348 VSS VDD FILLER2
XFILLER_18_360 VDD VSS DECAPHV32
XFILLER_4_768 VDD VSS DECAPHV32
XFILLER_16_886 VDD VSS DECAPHV32
XFILLER_19_92 VDD VSS FILLER1
XFILLER_18_0 VDD VSS DECAPHV32
XFILLER_22_845 VDD VSS DECAPHV8
XFILLER_0_1123 VSS VDD FILLER2
XIO_BOND_g_iovdd_pads\[1\].iovdd_pad IOVDD sg13cmos5l_ip__bondpad_70x70
XTAP_TAPCELL_ROW_173_1_218 VDD VSS WELLTAP
XFILLER_0_215 VDD VSS DECAPHV8
XFILLER_9_827 VDD VSS DECAPHV8
XIO_BOND_g_iovss_pads\[0\].iovss_pad IOVSS sg13cmos5l_ip__bondpad_70x70
XFILLER_4_543 VDD VSS DECAPHV32
XFILLER_15_160 VDD VSS DECAPHV16
XFILLER_7_370 VSS VDD FILLER2
XFILLER_2_1229 VDD VSS DECAPHV16
XFILLER_22_620 VDD VSS DECAPHV8
Xclkbuf_1_1__f_clk_PAD2CORE_regs clkbuf_0_clk_PAD2CORE_regs/Y VDD VSS _28_/CK BUFX12
XFILLER_13_686 VDD VSS DECAPHV32
XTAP_TAPCELL_ROW_3_63 VDD VSS WELLTAP
XTAP_TAPCELL_ROW_3_74 VDD VSS WELLTAP
XFILLER_4_395 VDD VSS DECAPHV8
XTAP_TAPCELL_ROW_172_1_206 VDD VSS WELLTAP
XTAP_TAPCELL_ROW_180_1_296 VDD VSS WELLTAP
XFILLER_2_1059 VDD VSS DECAPHV8
XFILLER_10_678 VDD VSS DECAPHV32
XTAP_TAPCELL_ROW_10_1_153 VDD VSS WELLTAP
XTAP_TAPCELL_ROW_10_1_164 VDD VSS WELLTAP
XTAP_TAPCELL_ROW_7_1_119 VDD VSS WELLTAP
XFILLER_17_277 VSS VDD FILLER2
XFILLER_4_170 VDD VSS DECAPHV8
XFILLER_2_129 VDD VSS DECAPHV8
XFILLER_10_453 VDD VSS DECAPHV32
XFILLER_1_184 VSS VDD FILLER2
XTAP_TAPCELL_ROW_0_20 VDD VSS WELLTAP
XFILLER_21_718 VDD VSS DECAPHV16
XFILLER_20_206 VDD VSS DECAPHV16
XFILLER_12_718 VSS VDD FILLER2
XTAP_TAPCELL_ROW_6_1_107 VDD VSS WELLTAP
XFILLER_8_1021 VDD VSS FILLER1
XFILLER_15_556 VSS VDD FILLER2
XFILLER_6_298 VDD VSS FILLER4
XFILLER_19_840 VDD VSS DECAPHV32
XFILLER_1_64 VDD VSS DECAPHV16
X_24_ _28_/CK _24_/D _24_/Q _30_/RB VDD VSS DFFRQX1
XIO_BOND_g_iovdd_pads\[0\].iovdd_pad IOVDD sg13cmos5l_ip__bondpad_70x70
XFILLER_21_548 VDD VSS DECAPHV8
XTAP_TAPCELL_ROW_5_1_309 VDD VSS WELLTAP
XFILLER_0_408 VDD VSS DECAPHV32
Xclkbuf_regs_0_clk delaybuf_9_clk/Y VDD VSS clkbuf_regs_0_clk/Y BUFX12
XFILLER_15_375 VDD VSS DECAPHV32
XFILLER_22_813 VDD VSS DECAPHV32
XFILLER_0_1168 VSS VDD FILLER2
XTAP_TAPCELL_ROW_173_1_219 VDD VSS WELLTAP
XFILLER_5_1013 VDD VSS DECAPHV8
XFILLER_13_835 VSS VDD FILLER2
XFILLER_12_345 VDD VSS DECAPHV8
XFILLER_4_588 VDD VSS DECAPHV32
XFILLER_1_1422 VDD VSS FILLER4
XFILLER_16_695 VSS VDD FILLER2
XFILLER_12_890 VDD VSS DECAPHV8
XFILLER_7_96 VDD VSS DECAPHV32
XFILLER_22_665 VDD VSS DECAPHV8
XFILLER_13_654 VDD VSS DECAPHV32
XFILLER_9_625 VDD VSS DECAPHV16
XTAP_TAPCELL_ROW_3_64 VDD VSS WELLTAP
XFILLER_8_113 VDD VSS DECAPHV16
XTAP_TAPCELL_ROW_3_75 VDD VSS WELLTAP
XFILLER_4_363 VDD VSS DECAPHV32
XTAP_TAPCELL_ROW_180_1_297 VDD VSS WELLTAP
XTAP_TAPCELL_ROW_172_1_207 VDD VSS WELLTAP
XIO_BOND_g_vdd_pads\[0\].vdd_pad VDD sg13cmos5l_ip__bondpad_70x70
XFILLER_22_440 VDD VSS DECAPHV8
XFILLER_6_639 VDD VSS DECAPHV32
XTAP_TAPCELL_ROW_10_1_154 VDD VSS WELLTAP
XTAP_TAPCELL_ROW_10_1_165 VDD VSS WELLTAP
XFILLER_14_974 VSS VDD FILLER2
XFILLER_9_455 VDD VSS DECAPHV8
XFILLER_17_1013 VDD VSS DECAPHV8
XFILLER_3_1369 VDD VSS DECAPHV16
XFILLER_20_966 VDD VSS DECAPHV8
XFILLER_7_904 VDD VSS DECAPHV16
XTAP_TAPCELL_ROW_0_10 VDD VSS WELLTAP
XFILLER_8_0 VDD VSS DECAPHV32
XFILLER_10_498 VDD VSS DECAPHV32
XTAP_TAPCELL_ROW_0_21 VDD VSS WELLTAP
XFILLER_14_793 VDD VSS DECAPHV32
XFILLER_3_1199 VDD VSS DECAPHV8
Xvdda_pad IOVDD IOVSS VDDA VSS sg13cmos5l_IOPadVdd
XFILLER_3_439 VDD VSS DECAPHV16
XTAP_TAPCELL_ROW_6_1_108 VDD VSS WELLTAP
XFILLER_8_1011 VDD VSS DECAPHV8
XFILLER_6_222 VDD VSS DECAPHV8
XFILLER_7_734 VDD VSS DECAPHV8
XFILLER_6_255 VDD VSS DECAPHV8
XFILLER_1_32 VDD VSS DECAPHV32
X_23_ _30_/CK _23_/D _23_/Q _30_/RB VDD VSS DFFRQX1
XFILLER_8_509 VSS VDD FILLER2
XFILLER_12_538 VSS VDD FILLER2
XFILLER_3_269 VDD VSS DECAPHV8
XFILLER_0_943 VSS VDD FILLER2
XFILLER_4_1250 VDD VSS DECAPHV8
XFILLER_22_858 VDD VSS DECAPHV32
XFILLER_21_346 VDD VSS DECAPHV16
XFILLER_0_228 VDD VSS DECAPHV32
XFILLER_1_718 VDD VSS DECAPHV16
XFILLER_16_129 VDD VSS DECAPHV8
XFILLER_12_313 VSS VDD FILLER2
XFILLER_8_306 VDD VSS FILLER4
XFILLER_8_328 VDD VSS DECAPHV32
XFILLER_12_357 VSS VDD FILLER2
XFILLER_15_184 VSS VDD FILLER2
XFILLER_7_64 VDD VSS DECAPHV16
XFILLER_8_873 VDD VSS DECAPHV8
XFILLER_22_633 VDD VSS DECAPHV32
XFILLER_21_176 VDD VSS DECAPHV8
XFILLER_1_548 VDD VSS DECAPHV8
XIO_CORNER_SOUTH_EAST_INST IOVDD IOVSS VDDA VSS sg13cmos5l_Corner
XFILLER_16_40 VDD VSS FILLER4
XTAP_TAPCELL_ROW_3_65 VDD VSS WELLTAP
XTAP_TAPCELL_ROW_172_1_208 VDD VSS WELLTAP
XTAP_TAPCELL_ROW_180_1_298 VDD VSS WELLTAP
XTAP_TAPCELL_ROW_180_1_287 VDD VSS WELLTAP
XFILLER_22_485 VDD VSS DECAPHV8
XFILLER_14_408 VDD VSS DECAPHV8
XFILLER_5_128 VDD VSS DECAPHV32
XFILLER_6_607 VDD VSS DECAPHV32
XTAP_TAPCELL_ROW_10_1_155 VDD VSS WELLTAP
XFILLER_2_857 VDD VSS DECAPHV16
XTAP_TAPCELL_ROW_10_1_166 VDD VSS WELLTAP
XFILLER_13_463 VSS VDD FILLER2
XFILLER_4_183 VDD VSS DECAPHV32
XFILLER_4_32 VDD VSS DECAPHV8
XFILLER_3_1337 VDD VSS DECAPHV32
XFILLER_22_260 VDD VSS DECAPHV8
XTAP_TAPCELL_ROW_0_11 VDD VSS WELLTAP
XTAP_TAPCELL_ROW_0_22 VDD VSS WELLTAP
XFILLER_13_96 VDD VSS DECAPHV32
XFILLER_2_687 VDD VSS DECAPHV8
XFILLER_9_242 VDD VSS DECAPHV16
XFILLER_13_282 VDD VSS DECAPHV32
XFILLER_20_764 VDD VSS DECAPHV16
XFILLER_3_407 VDD VSS DECAPHV32
XTAP_TAPCELL_ROW_6_1_109 VDD VSS WELLTAP
XFILLER_10_252 VSS VDD FILLER2
XFILLER_6_267 VSS VDD FILLER2
XFILLER_7_779 VDD VSS DECAPHV32
XFILLER_1_88 VDD VSS FILLER4
X_22_ _23_/Q _28_/Q VDD VSS _23_/D XNOR2X1
Xdo_q_pad dsm2/do_q IOVDD IOVSS do_q_PAD VDDA VSS sg13cmos5l_IOPadOut4mA
XFILLER_20_594 VDD VSS DECAPHV8
XFILLER_0_988 VSS VDD FILLER2
XFILLER_7_532 VDD VSS DECAPHV16
Xg_iovdd_pads\[1\].iovdd_pad IOVDD IOVSS VDD VSS sg13cmos5l_IOPadIOVdd
XFILLER_20_1021 VDD VSS FILLER1
XFILLER_0_1115 VDD VSS DECAPHV8
XFILLER_4_1295 VDD VSS DECAPHV8
XFILLER_21_314 VDD VSS DECAPHV32
Xg_iovss_pads\[0\].iovss_pad IOVDD IOVSS VDD VSS sg13cmos5l_IOPadIOVss
XIO_CORNER_NORTH_WEST_INST IOVDD IOVSS VDD VSS sg13cmos5l_Corner
XFILLER_12_336 VDD VSS FILLER1
XFILLER_21_96 VDD VSS DECAPHV32
XFILLER_0_763 VSS VDD FILLER2
XFILLER_7_32 VDD VSS DECAPHV32
XFILLER_4_1070 VDD VSS DECAPHV8
XFILLER_16_0 VDD VSS DECAPHV32
XFILLER_22_678 VDD VSS DECAPHV32
XFILLER_18_918 VDD VSS DECAPHV32
XFILLER_17_439 VDD VSS DECAPHV16
XFILLER_8_137 VSS VDD FILLER2
XFILLER_9_649 VSS VDD FILLER2
XFILLER_12_133 VSS VDD FILLER2
XTAP_TAPCELL_ROW_3_66 VDD VSS WELLTAP
XFILLER_5_811 VDD VSS DECAPHV16
XTAP_TAPCELL_ROW_172_1_209 VDD VSS WELLTAP
XTAP_TAPCELL_ROW_180_1_299 VDD VSS WELLTAP
XFILLER_1_1276 VDD VSS DECAPHV16
XTAP_TAPCELL_ROW_180_1_288 VDD VSS WELLTAP
XFILLER_8_671 VDD VSS DECAPHV16
XFILLER_22_453 VDD VSS DECAPHV32
XFILLER_2_825 VDD VSS DECAPHV32
XFILLER_1_346 VDD VSS DECAPHV16
XTAP_TAPCELL_ROW_10_1_156 VDD VSS WELLTAP
XTAP_TAPCELL_ROW_10_1_167 VDD VSS WELLTAP
XFILLER_17_269 VDD VSS DECAPHV8
XFILLER_5_641 VDD VSS DECAPHV8
XFILLER_9_468 VDD VSS DECAPHV32
XFILLER_4_44 VDD VSS FILLER1
XFILLER_4_88 VSS VDD FILLER2
XFILLER_3_1305 VDD VSS DECAPHV32
XIO_FILL_IO_NORTH_5_0 IOVDD IOVSS VDD VSS sg13cmos5l_Filler4000
XFILLER_20_979 VDD VSS DECAPHV32
XFILLER_15_718 VDD VSS DECAPHV16
XFILLER_14_206 VDD VSS DECAPHV16
XFILLER_6_416 VSS VDD FILLER2
XFILLER_7_928 VSS VDD FILLER2
XTAP_TAPCELL_ROW_0_12 VDD VSS WELLTAP
XFILLER_1_176 VDD VSS DECAPHV8
XTAP_TAPCELL_ROW_0_23 VDD VSS WELLTAP
XFILLER_18_578 VDD VSS DECAPHV16
XFILLER_18_501 VDD VSS DECAPHV8
XFILLER_9_210 VDD VSS DECAPHV32
XFILLER_9_298 VDD VSS FILLER4
XFILLER_6_950 VDD VSS DECAPHV16
XFILLER_20_732 VDD VSS DECAPHV32
XFILLER_15_548 VDD VSS DECAPHV8
XFILLER_3_920 VDD VSS DECAPHV8
XFILLER_7_747 VDD VSS DECAPHV32
XFILLER_2_485 VDD VSS DECAPHV16
X_21_ _26_/Q _21_/B VDD VSS _26_/D XNOR2X1
XFILLER_3_997 VDD VSS DECAPHV16
Xg_iovdd_pads\[0\].iovdd_pad IOVDD IOVSS VDD VSS sg13cmos5l_IOPadIOVdd
XFILLER_0_1308 VDD VSS DECAPHV32
XFILLER_4_1422 VDD VSS FILLER4
XFILLER_6_780 VDD VSS DECAPHV8
XFILLER_10_43 VSS VDD FILLER2
XFILLER_16_857 VDD VSS DECAPHV16
XFILLER_19_96 VDD VSS DECAPHV32
XFILLER_19_128 VDD VSS DECAPHV32
XFILLER_7_500 VDD VSS DECAPHV32
XIO_BOND_vi_pad analog_PAD[0] sg13cmos5l_ip__bondpad_70x70
XFILLER_20_1011 VDD VSS DECAPHV8
XFILLER_4_1263 VDD VSS DECAPHV32
XFILLER_13_827 VDD VSS DECAPHV8
XFILLER_12_326 VSS VDD FILLER2
XFILLER_12_359 VDD VSS FILLER1
XFILLER_21_64 VDD VSS DECAPHV16
XFILLER_20_392 VDD VSS DECAPHV16
XFILLER_16_687 VDD VSS DECAPHV8
XFILLER_1_1414 VDD VSS DECAPHV8
XFILLER_7_88 VDD VSS FILLER4
XFILLER_8_886 VDD VSS DECAPHV32
XFILLER_10_808 VSS VDD FILLER2
XFILLER_21_189 VDD VSS DECAPHV32
XFILLER_17_407 VDD VSS DECAPHV32
XTAP_TAPCELL_ROW_3_67 VDD VSS WELLTAP
XFILLER_12_178 VSS VDD FILLER2
Xvdda_decap VDDA VSS decap_vdda
XFILLER_0_583 VSS VDD FILLER2
XFILLER_1_1244 VDD VSS DECAPHV32
XTAP_TAPCELL_ROW_180_1_289 VDD VSS WELLTAP
XFILLER_7_160 VDD VSS DECAPHV16
XIO_FILL_IO_NORTH_2_20 IOVDD IOVSS VDD VSS sg13cmos5l_Filler400
XFILLER_22_498 VDD VSS DECAPHV32
XFILLER_1_314 VDD VSS DECAPHV32
Xjku_logo sg13cmos5l_ip__jku
XTAP_TAPCELL_ROW_10_1_157 VDD VSS WELLTAP
XTAP_TAPCELL_ROW_10_1_168 VDD VSS WELLTAP
XFILLER_14_966 VDD VSS DECAPHV8
XFILLER_5_686 VDD VSS DECAPHV32
XFILLER_13_87 VDD VSS FILLER4
XFILLER_22_273 VDD VSS DECAPHV32
XTAP_TAPCELL_ROW_0_13 VDD VSS WELLTAP
XTAP_TAPCELL_ROW_0_24 VDD VSS WELLTAP
XFILLER_18_546 VDD VSS DECAPHV32
XFILLER_2_1383 VDD VSS DECAPHV32
XFILLER_9_266 VDD VSS FILLER4
XFILLER_10_980 VDD VSS FILLER4
XFILLER_3_1114 VSS VDD FILLER2
XFILLER_20_700 VDD VSS DECAPHV32
XFILLER_20_788 VSS VDD FILLER2
XFILLER_6_269 VDD VSS FILLER1
XFILLER_6_0 VDD VSS DECAPHV32
XFILLER_3_965 VDD VSS DECAPHV32
XFILLER_19_811 VDD VSS DECAPHV16
XFILLER_2_453 VDD VSS DECAPHV32
X_20_ _25_/Q _20_/B VDD VSS _25_/D XOR2X1
XFILLER_14_1019 VSS VDD FILLER2
XFILLER_4_718 VSS VDD FILLER2
XFILLER_10_88 VSS VDD FILLER2
XFILLER_0_935 VDD VSS DECAPHV8
XFILLER_19_64 VDD VSS DECAPHV16
XFILLER_16_825 VDD VSS DECAPHV32
XFILLER_15_346 VDD VSS DECAPHV16
XFILLER_7_556 VSS VDD FILLER2
XFILLER_19_641 VDD VSS DECAPHV8
XFILLER_0_1128 VDD VSS DECAPHV32
XIO_FILL_IO_NORTH_5_20 IOVDD IOVSS VDD VSS sg13cmos5l_Filler400
XFILLER_21_872 VDD VSS DECAPHV32
XFILLER_12_305 VDD VSS DECAPHV8
XFILLER_20_360 VDD VSS DECAPHV32
XFILLER_0_710 VDD VSS DECAPHV8
XFILLER_21_32 VDD VSS DECAPHV32
Xdelaybuf_2_clk delaybuf_2_clk/A VDD VSS delaybuf_3_clk/A BUFX12
XFILLER_1_1426 VSS VDD FILLER2
XFILLER_15_176 VDD VSS DECAPHV8
XFILLER_7_375 VDD VSS DECAPHV32
XFILLER_4_1083 VDD VSS DECAPHV32
XFILLER_16_32 VDD VSS DECAPHV8
XFILLER_13_625 VDD VSS DECAPHV16
XTAP_TAPCELL_ROW_3_68 VDD VSS WELLTAP
XFILLER_5_835 VSS VDD FILLER2
XFILLER_17_920 VDD VSS DECAPHV8
XFILLER_1_1212 VDD VSS DECAPHV32
XFILLER_17_997 VDD VSS DECAPHV16
XFILLER_16_485 VDD VSS DECAPHV16
XFILLER_8_695 VSS VDD FILLER2
XIO_FILL_IO_EAST_5_0 IOVDD IOVSS VDDA VSS sg13cmos5l_Filler4000
XFILLER_21_0 VDD VSS DECAPHV32
XFILLER_10_628 VSS VDD FILLER2
XTAP_TAPCELL_ROW_10_1_158 VDD VSS WELLTAP
XTAP_TAPCELL_ROW_10_1_169 VDD VSS WELLTAP
XFILLER_13_455 VDD VSS DECAPHV8
XFILLER_5_654 VDD VSS DECAPHV32
XFILLER_10_403 VSS VDD FILLER2
XFILLER_2_602 VSS VDD FILLER2
XFILLER_13_55 VDD VSS DECAPHV32
XFILLER_1_189 VDD VSS DECAPHV32
XTAP_TAPCELL_ROW_0_14 VDD VSS WELLTAP
XTAP_TAPCELL_ROW_0_25 VDD VSS WELLTAP
XFILLER_18_514 VDD VSS DECAPHV32
XFILLER_2_1351 VDD VSS DECAPHV32
XFILLER_14_764 VDD VSS DECAPHV16
XFILLER_6_974 VSS VDD FILLER2
XFILLER_10_244 VDD VSS DECAPHV8
XFILLER_2_421 VDD VSS DECAPHV32
XFILLER_3_933 VDD VSS DECAPHV32
XIO_BOND_g_vss_pads\[1\].vss_pad VSS sg13cmos5l_ip__bondpad_70x70
XFILLER_14_594 VDD VSS DECAPHV8
XFILLER_6_793 VDD VSS DECAPHV32
XFILLER_10_23 VDD VSS DECAPHV16
XFILLER_10_12 VSS VDD FILLER2
XFILLER_0_903 VDD VSS DECAPHV32
XFILLER_19_32 VDD VSS DECAPHV32
XFILLER_15_314 VDD VSS DECAPHV32
XFILLER_19_686 VDD VSS DECAPHV32
XFILLER_18_174 VDD VSS DECAPHV32
XIO_FILL_IO_SOUTH_6_0 IOVDD IOVSS VDDA VSS sg13cmos5l_Filler4000
XFILLER_21_840 VDD VSS DECAPHV32
XFILLER_4_538 VSS VDD FILLER2
XFILLER_0_755 VDD VSS DECAPHV8
XFILLER_21_88 VDD VSS FILLER4
XIO_CORNER_SOUTH_WEST_INST IOVDD IOVSS VDD VSS sg13cmos5l_Corner
XFILLER_3_593 VDD VSS DECAPHV32
XTAP_TAPCELL_ROW_0_0 VDD VSS WELLTAP
XFILLER_12_125 VDD VSS DECAPHV8
XFILLER_16_44 VSS VDD FILLER2
XFILLER_8_129 VDD VSS DECAPHV8
XFILLER_4_313 VSS VDD FILLER2
XTAP_TAPCELL_ROW_3_69 VDD VSS WELLTAP
XFILLER_0_530 VDD VSS DECAPHV8
XFILLER_17_965 VDD VSS DECAPHV32
XFILLER_16_453 VDD VSS DECAPHV32
XFILLER_7_184 VSS VDD FILLER2
XFILLER_4_880 VDD VSS FILLER1
XFILLER_14_0 VDD VSS DECAPHV32
XIO_FILL_IO_NORTH_2_22 IOVDD IOVSS VDD VSS sg13cmos5l_Filler400
XTAP_TAPCELL_ROW_10_1_159 VDD VSS WELLTAP
XFILLER_14_979 VDD VSS DECAPHV32
XFILLER_1_872 VDD VSS DECAPHV32
XFILLER_1_1021 VSS VDD FILLER2
XTAP_TAPCELL_ROW_4_90 VDD VSS WELLTAP
XFILLER_6_408 VDD VSS DECAPHV8
XFILLER_10_448 VSS VDD FILLER2
XFILLER_13_12 VSS VDD FILLER2
XFILLER_13_23 VDD VSS DECAPHV32
XTAP_TAPCELL_ROW_0_15 VDD VSS WELLTAP
XTAP_TAPCELL_ROW_0_26 VDD VSS WELLTAP
XFILLER_14_732 VDD VSS DECAPHV32
XFILLER_10_993 VDD VSS DECAPHV16
XFILLER_13_253 VDD VSS DECAPHV16
XFILLER_5_463 VSS VDD FILLER2
XIO_FILL_IO_NORTH_3_0 IOVDD IOVSS VDD VSS sg13cmos5l_Filler4000
XFILLER_10_223 VSS VDD FILLER2
XFILLER_19_835 VSS VDD FILLER2
XFILLER_4_1414 VDD VSS DECAPHV8
XFILLER_18_323 VSS VDD FILLER2
XFILLER_2_1160 VSS VDD FILLER2
XFILLER_5_282 VDD VSS DECAPHV16
XFILLER_0_948 VDD VSS DECAPHV32
XFILLER_19_88 VDD VSS FILLER4
XFILLER_13_1021 VDD VSS FILLER1
XFILLER_2_230 VSS VDD FILLER2
XFILLER_3_742 VSS VDD FILLER2
XFILLER_22_808 VSS VDD FILLER2
XFILLER_19_654 VDD VSS DECAPHV32
XFILLER_18_142 VDD VSS DECAPHV32
XFILLER_14_392 VDD VSS DECAPHV16
XIO_FILL_IO_NORTH_5_22 IOVDD IOVSS VDD VSS sg13cmos5l_Filler400
XFILLER_12_318 VDD VSS DECAPHV8
XFILLER_0_723 VDD VSS DECAPHV32
XFILLER_16_602 VSS VDD FILLER2
XFILLER_7_300 VDD VSS DECAPHV16
XFILLER_15_189 VDD VSS DECAPHV32
XFILLER_3_561 VDD VSS DECAPHV32
XFILLER_7_366 VDD VSS FILLER4
XTAP_TAPCELL_ROW_0_1 VDD VSS WELLTAP
XFILLER_13_649 VSS VDD FILLER2
XFILLER_4_358 VSS VDD FILLER2
XFILLER_10_1013 VSS VDD FILLER2
XFILLER_0_575 VDD VSS DECAPHV8
XFILLER_17_933 VDD VSS DECAPHV32
XFILLER_16_421 VDD VSS DECAPHV32
XFILLER_4_892 VDD VSS DECAPHV8
XTAP_TAPCELL_ROW_10_1_149 VDD VSS WELLTAP
XTAP_TAPCELL_ROW_4_100 VDD VSS WELLTAP
XFILLER_22_980 VDD VSS DECAPHV8
XFILLER_9_439 VDD VSS DECAPHV16
XFILLER_13_468 VDD VSS DECAPHV32
XFILLER_4_48 VDD VSS DECAPHV32
XFILLER_4_133 VSS VDD FILLER2
XFILLER_1_840 VDD VSS DECAPHV32
XFILLER_0_350 VDD VSS DECAPHV8
XTAP_TAPCELL_ROW_170_1_190 VDD VSS WELLTAP
XTAP_TAPCELL_ROW_4_80 VDD VSS WELLTAP
XTAP_TAPCELL_ROW_4_91 VDD VSS WELLTAP
XTAP_TAPCELL_ROW_0_16 VDD VSS WELLTAP
XTAP_TAPCELL_ROW_0_27 VDD VSS WELLTAP
XFILLER_14_788 VSS VDD FILLER2
XFILLER_14_700 VDD VSS DECAPHV32
XFILLER_13_221 VDD VSS DECAPHV32
XFILLER_9_258 VDD VSS DECAPHV8
XFILLER_3_1106 VDD VSS DECAPHV8
XFILLER_17_593 VDD VSS DECAPHV32
XFILLER_5_80 VDD VSS DECAPHV8
XFILLER_6_206 VDD VSS DECAPHV16
XFILLER_7_718 VDD VSS DECAPHV16
XFILLER_4_1426 VSS VDD FILLER2
XIO_FILL_IO_WEST_5_0 IOVDD IOVSS VDD VSS sg13cmos5l_Filler4000
XFILLER_10_14 VDD VSS FILLER1
XFILLER_4_0 VDD VSS DECAPHV32
XFILLER_7_548 VDD VSS DECAPHV8
Xdelaybuf_5_clk delaybuf_5_clk/A VDD VSS delaybuf_6_clk/A BUFX12
XFILLER_15_872 VDD VSS DECAPHV32
XFILLER_14_360 VDD VSS DECAPHV32
XFILLER_2_81 VDD VSS DECAPHV32
XFILLER_0_768 VDD VSS DECAPHV32
XFILLER_12_853 VSS VDD FILLER2
XFILLER_8_857 VDD VSS DECAPHV16
XFILLER_19_463 VSS VDD FILLER2
XFILLER_22_628 VSS VDD FILLER2
XTAP_TAPCELL_ROW_0_2 VDD VSS WELLTAP
XFILLER_12_138 VDD VSS DECAPHV32
XFILLER_5_827 VDD VSS DECAPHV8
XFILLER_0_543 VDD VSS DECAPHV32
XFILLER_8_687 VDD VSS DECAPHV8
XFILLER_3_370 VSS VDD FILLER2
XFILLER_19_282 VDD VSS DECAPHV32
XFILLER_22_403 VSS VDD FILLER2
XTAP_TAPCELL_ROW_4_101 VDD VSS WELLTAP
XFILLER_9_407 VDD VSS DECAPHV32
XFILLER_4_178 VSS VDD FILLER2
XFILLER_17_742 VSS VDD FILLER2
XFILLER_0_395 VDD VSS DECAPHV8
XFILLER_16_230 VSS VDD FILLER2
XFILLER_20_918 VDD VSS DECAPHV32
XTAP_TAPCELL_ROW_170_1_191 VDD VSS WELLTAP
XTAP_TAPCELL_ROW_170_1_180 VDD VSS WELLTAP
XTAP_TAPCELL_ROW_4_81 VDD VSS WELLTAP
XTAP_TAPCELL_ROW_4_92 VDD VSS WELLTAP
XIO_FILL_IO_EAST_3_0 IOVDD IOVSS VDDA VSS sg13cmos5l_Filler4000
XFILLER_13_14 VDD VSS FILLER1
XTAP_TAPCELL_ROW_0_17 VDD VSS WELLTAP
XTAP_TAPCELL_ROW_0_28 VDD VSS WELLTAP
XFILLER_13_277 VSS VDD FILLER2
XFILLER_6_966 VDD VSS DECAPHV8
XFILLER_10_984 VDD VSS FILLER1
XFILLER_0_170 VDD VSS DECAPHV8
XFILLER_17_561 VDD VSS DECAPHV32
XIO_FILL_IO_EAST_0_20 IOVDD IOVSS VDDA VSS sg13cmos5l_Filler2000
XFILLER_5_92 VDD VSS FILLER1
XFILLER_18_881 VSS VDD FILLER2
XFILLER_20_501 VDD VSS DECAPHV8
XFILLER_20_578 VDD VSS DECAPHV16
XFILLER_10_48 VDD VSS DECAPHV32
XFILLER_4_1213 VSS VDD FILLER2
XFILLER_15_840 VDD VSS DECAPHV32
XFILLER_12_898 VSS VDD FILLER2
XFILLER_8_825 VDD VSS DECAPHV32
XFILLER_21_128 VDD VSS DECAPHV32
XIO_FILL_IO_SOUTH_4_0 IOVDD IOVSS VDDA VSS sg13cmos5l_Filler4000
XTAP_TAPCELL_ROW_0_3 VDD VSS WELLTAP
XTAP_TAPCELL_ROW_171_1_193 VDD VSS WELLTAP
XFILLER_4_305 VDD VSS DECAPHV8
XFILLER_10_1015 VDD VSS FILLER1
XFILLER_0_588 VDD VSS DECAPHV32
XFILLER_12_673 VSS VDD FILLER2
XFILLER_7_176 VDD VSS DECAPHV8
XIO_FILL_IO_EAST_3_20 IOVDD IOVSS VDDA VSS sg13cmos5l_Filler2000
XFILLER_8_81 VDD VSS DECAPHV32
XFILLER_22_448 VSS VDD FILLER2
XTAP_TAPCELL_ROW_4_102 VDD VSS WELLTAP
XFILLER_22_993 VDD VSS DECAPHV16
XFILLER_5_625 VDD VSS DECAPHV16
XFILLER_0_363 VDD VSS DECAPHV32
XFILLER_1_1013 VDD VSS DECAPHV8
XTAP_TAPCELL_ROW_170_1_181 VDD VSS WELLTAP
XTAP_TAPCELL_ROW_170_1_192 VDD VSS WELLTAP
XTAP_TAPCELL_ROW_4_82 VDD VSS WELLTAP
XFILLER_9_920 VDD VSS DECAPHV8
XFILLER_9_997 VDD VSS DECAPHV16
XFILLER_8_485 VDD VSS DECAPHV16
XTAP_TAPCELL_ROW_4_93 VDD VSS WELLTAP
XFILLER_12_0 VDD VSS FILLER4
XFILLER_22_223 VSS VDD FILLER2
XFILLER_2_639 VDD VSS DECAPHV32
XTAP_TAPCELL_ROW_0_18 VDD VSS WELLTAP
XTAP_TAPCELL_ROW_0_29 VDD VSS WELLTAP
XFILLER_2_1322 VDD VSS DECAPHV16
XFILLER_16_1021 VDD VSS FILLER1
XFILLER_5_455 VDD VSS DECAPHV8
XFILLER_3_1119 VDD VSS DECAPHV32
XIO_BOND_ib_pad analog_PAD[2] sg13cmos5l_ip__bondpad_70x70
XFILLER_8_1019 VSS VDD FILLER2
XFILLER_10_215 VDD VSS DECAPHV8
XFILLER_3_904 VDD VSS DECAPHV16
XFILLER_19_827 VDD VSS DECAPHV8
XFILLER_18_315 VDD VSS DECAPHV8
XFILLER_2_1152 VDD VSS DECAPHV8
XFILLER_6_764 VDD VSS DECAPHV16
XFILLER_20_546 VDD VSS DECAPHV32
XIO_FILL_IO_NORTH_1_0 IOVDD IOVSS VDD VSS sg13cmos5l_Filler4000
XFILLER_17_370 VSS VDD FILLER2
XFILLER_13_1013 VDD VSS DECAPHV8
XFILLER_2_299 VDD VSS DECAPHV16
XFILLER_2_222 VDD VSS DECAPHV8
XFILLER_3_734 VDD VSS DECAPHV8
XFILLER_4_1258 VSS VDD FILLER2
XIO_FILL_IO_EAST_6_20 IOVDD IOVSS VDD VSS sg13cmos5l_Filler2000
XFILLER_6_594 VDD VSS DECAPHV8
XFILLER_21_811 VDD VSS DECAPHV16
XFILLER_12_800 VDD VSS DECAPHV8
XFILLER_7_358 VDD VSS DECAPHV8
XFILLER_4_1033 VSS VDD FILLER2
XTAP_TAPCELL_ROW_0_4 VDD VSS WELLTAP
XTAP_TAPCELL_ROW_171_1_194 VDD VSS WELLTAP
XIO_BOND_do_q_b_pad do_q_b_PAD sg13cmos5l_ip__bondpad_70x70
XFILLER_21_641 VDD VSS DECAPHV8
XFILLER_22_80 VDD VSS DECAPHV8
XTAP_TAPCELL_ROW_4_103 VDD VSS WELLTAP
XFILLER_0_1250 VDD VSS DECAPHV8
XFILLER_4_125 VDD VSS DECAPHV8
XFILLER_1_1058 VDD VSS DECAPHV32
XTAP_TAPCELL_ROW_170_1_171 VDD VSS WELLTAP
XFILLER_17_80 VDD VSS DECAPHV8
XTAP_TAPCELL_ROW_170_1_182 VDD VSS WELLTAP
XTAP_TAPCELL_ROW_4_83 VDD VSS WELLTAP
XFILLER_8_453 VDD VSS DECAPHV32
XTAP_TAPCELL_ROW_4_94 VDD VSS WELLTAP
XFILLER_9_965 VDD VSS DECAPHV32
XFILLER_12_493 VSS VDD FILLER2
XFILLER_10_408 VDD VSS DECAPHV32
XFILLER_22_268 VSS VDD FILLER2
XFILLER_2_607 VDD VSS DECAPHV32
XTAP_TAPCELL_ROW_0_19 VDD VSS WELLTAP
XFILLER_1_128 VDD VSS DECAPHV32
XFILLER_16_1011 VDD VSS DECAPHV8
XFILLER_6_979 VDD VSS DECAPHV32
XFILLER_0_183 VDD VSS DECAPHV32
XFILLER_2_1197 VDD VSS DECAPHV32
Xdelaybuf_8_clk delaybuf_8_clk/A VDD VSS delaybuf_9_clk/A BUFX12
XFILLER_5_253 VDD VSS DECAPHV16
XFILLER_6_732 VDD VSS DECAPHV32
XFILLER_14_81 VDD VSS DECAPHV32
XTAP_TAPCELL_ROW_1_40 VDD VSS WELLTAP
XFILLER_20_514 VDD VSS DECAPHV32
XFILLER_10_39 VDD VSS FILLER4
XFILLER_2_267 VDD VSS DECAPHV32
XFILLER_3_779 VDD VSS DECAPHV32
XFILLER_19_625 VDD VSS DECAPHV16
XFILLER_18_113 VDD VSS DECAPHV16
XIO_FILL_IO_WEST_3_0 IOVDD IOVSS VDD VSS sg13cmos5l_Filler4000
XFILLER_2_40 VDD VSS FILLER4
XFILLER_16_639 VDD VSS DECAPHV32
XFILLER_12_845 VDD VSS DECAPHV8
XFILLER_3_1292 VDD VSS DECAPHV8
XFILLER_3_532 VDD VSS DECAPHV16
XFILLER_2_0 VDD VSS DECAPHV32
XFILLER_7_326 VDD VSS DECAPHV32
XFILLER_4_1078 VSS VDD FILLER2
XFILLER_19_455 VDD VSS DECAPHV8
XTAP_TAPCELL_ROW_0_5 VDD VSS WELLTAP
XFILLER_6_392 VDD VSS DECAPHV16
XTAP_TAPCELL_ROW_171_1_195 VDD VSS WELLTAP
XFILLER_16_49 VDD VSS DECAPHV32
XFILLER_21_686 VDD VSS DECAPHV32
XFILLER_4_318 VDD VSS DECAPHV32
XFILLER_20_174 VDD VSS DECAPHV32
XFILLER_17_904 VDD VSS DECAPHV16
XFILLER_1_1207 VSS VDD FILLER2
XFILLER_8_602 VSS VDD FILLER2
XFILLER_3_362 VDD VSS DECAPHV8
XFILLER_7_189 VDD VSS DECAPHV32
XFILLER_4_874 VDD VSS FILLER4
XTAP_TAPCELL_ROW_4_104 VDD VSS WELLTAP
XFILLER_14_918 VDD VSS DECAPHV32
XFILLER_0_1295 VDD VSS DECAPHV8
XFILLER_13_439 VDD VSS DECAPHV16
XFILLER_1_811 VDD VSS DECAPHV16
XFILLER_5_649 VSS VDD FILLER2
XFILLER_17_734 VDD VSS DECAPHV8
XFILLER_1_1026 VDD VSS DECAPHV32
XTAP_TAPCELL_ROW_170_1_172 VDD VSS WELLTAP
XFILLER_16_222 VDD VSS DECAPHV8
XFILLER_17_92 VDD VSS FILLER1
XTAP_TAPCELL_ROW_170_1_183 VDD VSS WELLTAP
XFILLER_16_299 VDD VSS DECAPHV16
XTAP_TAPCELL_ROW_4_84 VDD VSS WELLTAP
XFILLER_8_421 VDD VSS DECAPHV32
XTAP_TAPCELL_ROW_4_95 VDD VSS WELLTAP
XFILLER_9_933 VDD VSS DECAPHV32
XFILLER_18_509 VSS VDD FILLER2
XFILLER_0_1070 VDD VSS DECAPHV8
XFILLER_2_1346 VSS VDD FILLER2
XFILLER_10_943 VSS VDD FILLER2
XFILLER_13_269 VDD VSS DECAPHV8
XFILLER_1_641 VDD VSS DECAPHV8
XFILLER_5_468 VDD VSS DECAPHV32
XFILLER_8_251 VDD VSS FILLER4
XIO_FILL_IO_EAST_1_0 IOVDD IOVSS VDDA VSS sg13cmos5l_Filler4000
XFILLER_10_228 VDD VSS DECAPHV16
XFILLER_2_416 VSS VDD FILLER2
XFILLER_3_928 VSS VDD FILLER2
XFILLER_2_1165 VDD VSS DECAPHV32
XFILLER_18_328 VDD VSS DECAPHV32
XFILLER_14_501 VDD VSS DECAPHV8
XFILLER_14_578 VDD VSS DECAPHV16
XFILLER_5_221 VDD VSS DECAPHV32
XFILLER_5_298 VDD VSS DECAPHV8
XFILLER_6_700 VDD VSS DECAPHV32
XFILLER_6_788 VSS VDD FILLER2
XTAP_TAPCELL_ROW_1_41 VDD VSS WELLTAP
XFILLER_2_950 VDD VSS DECAPHV16
XFILLER_7_1021 VDD VSS FILLER1
XFILLER_18_873 VDD VSS DECAPHV8
XFILLER_9_593 VDD VSS DECAPHV32
Xrst_n_pad IOVDD IOVSS _30_/RB rst_n_PAD VDD VSS sg13cmos5l_IOPadIn
XFILLER_2_235 VDD VSS DECAPHV32
XFILLER_3_747 VDD VSS DECAPHV32
XFILLER_4_1205 VDD VSS DECAPHV8
XFILLER_20_1019 VSS VDD FILLER2
XFILLER_2_780 VDD VSS DECAPHV8
XFILLER_21_835 VSS VDD FILLER2
XFILLER_20_323 VSS VDD FILLER2
XFILLER_15_128 VDD VSS DECAPHV32
XFILLER_16_607 VDD VSS DECAPHV32
XFILLER_12_813 VDD VSS DECAPHV32
XFILLER_7_316 VSS VDD FILLER2
XFILLER_3_500 VDD VSS DECAPHV32
XTAP_TAPCELL_ROW_0_6 VDD VSS WELLTAP
XFILLER_6_360 VDD VSS DECAPHV32
XFILLER_7_872 VDD VSS DECAPHV32
XTAP_TAPCELL_ROW_171_1_196 VDD VSS WELLTAP
XFILLER_0_1422 VDD VSS FILLER4
XFILLER_21_654 VDD VSS DECAPHV32
XFILLER_20_142 VDD VSS DECAPHV32
XFILLER_19_1021 VDD VSS FILLER1
XFILLER_3_1090 VDD VSS DECAPHV16
XFILLER_12_665 VDD VSS DECAPHV8
XFILLER_22_93 VDD VSS DECAPHV32
XFILLER_4_853 VSS VDD FILLER2
XFILLER_19_253 VDD VSS DECAPHV16
XFILLER_8_40 VDD VSS FILLER4
XIO_FILL_IO_SOUTH_2_0 IOVDD IOVSS VDD VSS sg13cmos5l_Filler4000
XTAP_TAPCELL_ROW_4_105 VDD VSS WELLTAP
XFILLER_0_1263 VDD VSS DECAPHV32
XFILLER_13_407 VDD VSS DECAPHV32
XFILLER_4_138 VDD VSS DECAPHV32
XFILLER_17_779 VDD VSS DECAPHV32
XTAP_TAPCELL_ROW_170_1_173 VDD VSS WELLTAP
XFILLER_16_267 VDD VSS DECAPHV32
XFILLER_12_440 VDD VSS DECAPHV8
XTAP_TAPCELL_ROW_170_1_184 VDD VSS WELLTAP
XTAP_TAPCELL_ROW_4_85 VDD VSS WELLTAP
XTAP_TAPCELL_ROW_4_96 VDD VSS WELLTAP
XFILLER_3_160 VDD VSS DECAPHV16
XFILLER_22_215 VDD VSS DECAPHV8
XFILLER_1_686 VDD VSS DECAPHV32
XFILLER_17_532 VDD VSS DECAPHV16
XFILLER_9_742 VSS VDD FILLER2
Xg_inputs\[3\].input_pad IOVDD IOVSS hold3/A input_PAD[3] VDD VSS sg13cmos5l_IOPadIn
XFILLER_5_96 VDD VSS DECAPHV32
XFILLER_10_0 VDD VSS DECAPHV8
XFILLER_10_763 VSS VDD FILLER2
XFILLER_14_546 VDD VSS DECAPHV32
XFILLER_5_277 VSS VDD FILLER2
XTAP_TAPCELL_ROW_1_31 VDD VSS WELLTAP
XTAP_TAPCELL_ROW_1_42 VDD VSS WELLTAP
XFILLER_17_362 VDD VSS DECAPHV8
XFILLER_9_561 VDD VSS DECAPHV32
XFILLER_19_649 VSS VDD FILLER2
XFILLER_15_811 VDD VSS DECAPHV16
XFILLER_18_137 VSS VDD FILLER2
XFILLER_18_671 VDD VSS DECAPHV16
XFILLER_0_718 VSS VDD FILLER2
XFILLER_12_858 VDD VSS DECAPHV32
XFILLER_3_556 VSS VDD FILLER2
XFILLER_19_468 VDD VSS DECAPHV32
XFILLER_4_1025 VDD VSS DECAPHV8
XFILLER_15_641 VDD VSS DECAPHV8
XTAP_TAPCELL_ROW_0_7 VDD VSS WELLTAP
XFILLER_7_840 VDD VSS DECAPHV32
XTAP_TAPCELL_ROW_171_1_197 VDD VSS WELLTAP
XFILLER_17_928 VSS VDD FILLER2
XFILLER_12_633 VDD VSS DECAPHV32
XFILLER_3_375 VDD VSS DECAPHV32
XFILLER_16_950 VDD VSS DECAPHV16
XFILLER_19_221 VDD VSS DECAPHV32
XFILLER_22_408 VDD VSS DECAPHV32
XTAP_TAPCELL_ROW_179_1_280 VDD VSS WELLTAP
XTAP_TAPCELL_ROW_4_106 VDD VSS WELLTAP
XFILLER_21_463 VSS VDD FILLER2
XFILLER_1_835 VSS VDD FILLER2
XFILLER_17_747 VDD VSS DECAPHV32
XFILLER_16_235 VDD VSS DECAPHV32
XFILLER_13_997 VDD VSS DECAPHV16
XFILLER_13_920 VDD VSS DECAPHV8
XTAP_TAPCELL_ROW_170_1_185 VDD VSS WELLTAP
XTAP_TAPCELL_ROW_170_1_174 VDD VSS WELLTAP
XFILLER_12_485 VDD VSS DECAPHV8
Xg_inputs\[2\].input_pad IOVDD IOVSS ANTENNA_2/A input_PAD[2] VDD VSS sg13cmos5l_IOPadIn
XTAP_TAPCELL_ROW_4_86 VDD VSS WELLTAP
XFILLER_4_673 VSS VDD FILLER2
XTAP_TAPCELL_ROW_4_97 VDD VSS WELLTAP
Xhold1 _27_/Q VDD VSS _29_/D BUFX3
XFILLER_0_890 VDD VSS DECAPHV8
XFILLER_12_4 VSS VDD FILLER2
XFILLER_16_780 VDD VSS DECAPHV8
XFILLER_0_1083 VDD VSS DECAPHV32
XFILLER_21_282 VDD VSS DECAPHV32
XFILLER_1_654 VDD VSS DECAPHV32
XFILLER_17_500 VDD VSS DECAPHV32
XFILLER_12_260 VSS VDD FILLER2
XFILLER_5_64 VDD VSS DECAPHV16
Xcut_vdd_e IOVDD IOVSS VSS sg13cmos5l_ip__cut_vdd
XFILLER_14_514 VDD VSS DECAPHV32
XFILLER_14_40 VDD VSS FILLER4
XTAP_TAPCELL_ROW_1_32 VDD VSS WELLTAP
XFILLER_2_974 VSS VDD FILLER2
XTAP_TAPCELL_ROW_1_43 VDD VSS WELLTAP
XFILLER_18_886 VDD VSS DECAPHV32
XFILLER_4_1218 VDD VSS DECAPHV32
XFILLER_10_583 VSS VDD FILLER2
XFILLER_2_32 VDD VSS DECAPHV8
XFILLER_2_793 VDD VSS DECAPHV32
XFILLER_17_160 VDD VSS DECAPHV16
XFILLER_20_881 VSS VDD FILLER2
XFILLER_7_318 VDD VSS FILLER1
XFILLER_15_686 VDD VSS DECAPHV32
XFILLER_14_174 VDD VSS DECAPHV32
XTAP_TAPCELL_ROW_0_8 VDD VSS WELLTAP
XIO_FILL_IO_WEST_1_0 IOVDD IOVSS VDD VSS sg13cmos5l_Filler4000
XTAP_TAPCELL_ROW_171_1_198 VDD VSS WELLTAP
XFILLER_10_1009 VDD VSS FILLER4
XFILLER_0_538 VSS VDD FILLER2
XFILLER_16_417 VDD VSS FILLER1
XFILLER_12_678 VDD VSS DECAPHV32
XFILLER_12_612 VSS VDD FILLER2
Xg_inputs\[1\].input_pad IOVDD IOVSS g_inputs\[1\].input_pad/p2c input_PAD[1] VDD
+ VSS sg13cmos5l_IOPadIn
XFILLER_4_800 VDD VSS DECAPHV8
XFILLER_22_40 VDD VSS FILLER4
XFILLER_0_0 VDD VSS DECAPHV32
Xdo_q_b_pad dsm2/do_q_b IOVDD IOVSS do_q_b_PAD VDDA VSS sg13cmos5l_IOPadOut4mA
XFILLER_19_277 VSS VDD FILLER2
XTAP_TAPCELL_ROW_179_1_281 VDD VSS WELLTAP
XFILLER_22_943 VSS VDD FILLER2
XFILLER_0_313 VSS VDD FILLER2
XTAP_TAPCELL_ROW_170_1_186 VDD VSS WELLTAP
XTAP_TAPCELL_ROW_170_1_175 VDD VSS WELLTAP
XFILLER_13_965 VDD VSS DECAPHV32
XTAP_TAPCELL_ROW_4_76 VDD VSS WELLTAP
XTAP_TAPCELL_ROW_4_87 VDD VSS WELLTAP
XFILLER_12_453 VDD VSS DECAPHV32
XFILLER_3_184 VSS VDD FILLER2
XTAP_TAPCELL_ROW_4_98 VDD VSS WELLTAP
Xhold2 _29_/Q VDD VSS _30_/D BUFX3
XFILLER_22_228 VDD VSS DECAPHV32
XIO_BOND_g_vss_pads\[0\].vss_pad VSS sg13cmos5l_ip__bondpad_70x70
XFILLER_2_1338 VDD VSS DECAPHV8
XFILLER_10_935 VDD VSS DECAPHV8
XFILLER_17_556 VSS VDD FILLER2
XFILLER_8_298 VDD VSS DECAPHV8
XFILLER_5_32 VDD VSS DECAPHV32
XFILLER_4_493 VSS VDD FILLER2
XFILLER_1_1393 VSS VDD FILLER2
XFILLER_2_408 VDD VSS DECAPHV8
XFILLER_10_710 VDD VSS DECAPHV8
XFILLER_1_463 VSS VDD FILLER2
XTAP_TAPCELL_ROW_1_33 VDD VSS WELLTAP
XFILLER_7_1013 VDD VSS DECAPHV8
XTAP_TAPCELL_ROW_1_44 VDD VSS WELLTAP
XFILLER_17_375 VDD VSS DECAPHV32
XFILLER_3_1422 VDD VSS FILLER4
XFILLER_15_835 VSS VDD FILLER2
XFILLER_14_323 VSS VDD FILLER2
XFILLER_1_282 VDD VSS DECAPHV32
XFILLER_2_44 VSS VDD FILLER2
XFILLER_18_695 VSS VDD FILLER2
XFILLER_21_827 VDD VSS DECAPHV8
XFILLER_20_315 VDD VSS DECAPHV8
Xg_inputs\[0\].input_pad IOVDD IOVSS _15_/A0 input_PAD[0] VDD VSS sg13cmos5l_IOPadIn
XFILLER_15_654 VDD VSS DECAPHV32
XFILLER_4_1038 VDD VSS DECAPHV32
XTAP_TAPCELL_ROW_0_9 VDD VSS WELLTAP
XFILLER_14_142 VDD VSS DECAPHV32
XTAP_TAPCELL_ROW_171_1_199 VDD VSS WELLTAP
XFILLER_0_1414 VDD VSS DECAPHV8
XFILLER_19_1013 VDD VSS DECAPHV8
XFILLER_8_639 VDD VSS DECAPHV32
XFILLER_12_624 VDD VSS FILLER4
XFILLER_4_845 VDD VSS DECAPHV8
XFILLER_4_878 VSS VDD FILLER2
XFILLER_16_974 VSS VDD FILLER2
XTAP_TAPCELL_ROW_179_1_282 VDD VSS WELLTAP
XFILLER_8_32 VDD VSS DECAPHV8
Xi_sg13cmos5l_dsa1_dig_core.dsa1_dig VDD VSS i_sg13cmos5l_dsa1_dig_core.u_adc_conv_gate/A
+ clkbuf_1_0__f_clk_PAD2CORE/Y _30_/Q g_outputs\[0\].output_pad/c2p ANTENNA_2/A i_sg13cmos5l_dsa1_dig_core.dsa1_dig/o_aux_ctrl[0]
+ i_sg13cmos5l_dsa1_dig_core.dsa1_dig/o_aux_ctrl[10] i_sg13cmos5l_dsa1_dig_core.dsa1_dig/o_aux_ctrl[11]
+ i_sg13cmos5l_dsa1_dig_core.dsa1_dig/o_aux_ctrl[12] i_sg13cmos5l_dsa1_dig_core.dsa1_dig/o_aux_ctrl[13]
+ i_sg13cmos5l_dsa1_dig_core.dsa1_dig/o_aux_ctrl[14] i_sg13cmos5l_dsa1_dig_core.dsa1_dig/o_aux_ctrl[15]
+ i_sg13cmos5l_dsa1_dig_core.dsa1_dig/o_aux_ctrl[1] i_sg13cmos5l_dsa1_dig_core.dsa1_dig/o_aux_ctrl[2]
+ i_sg13cmos5l_dsa1_dig_core.dsa1_dig/o_aux_ctrl[3] i_sg13cmos5l_dsa1_dig_core.dsa1_dig/o_aux_ctrl[4]
+ i_sg13cmos5l_dsa1_dig_core.dsa1_dig/o_aux_ctrl[5] i_sg13cmos5l_dsa1_dig_core.dsa1_dig/o_aux_ctrl[6]
+ i_sg13cmos5l_dsa1_dig_core.dsa1_dig/o_aux_ctrl[7] i_sg13cmos5l_dsa1_dig_core.dsa1_dig/o_aux_ctrl[8]
+ i_sg13cmos5l_dsa1_dig_core.dsa1_dig/o_aux_ctrl[9] i_sg13cmos5l_dsa1_dig_core.dsa1_dig/o_bias_cfg[0]
+ dsm2/di_osc_en dsm2/di_clk_sel i_sg13cmos5l_dsa1_dig_core.dsa1_dig/o_bias_cfg[12]
+ i_sg13cmos5l_dsa1_dig_core.dsa1_dig/o_bias_cfg[13] i_sg13cmos5l_dsa1_dig_core.dsa1_dig/o_bias_cfg[14]
+ i_sg13cmos5l_dsa1_dig_core.dsa1_dig/o_bias_cfg[15] i_sg13cmos5l_dsa1_dig_core.dsa1_dig/o_bias_cfg[16]
+ i_sg13cmos5l_dsa1_dig_core.dsa1_dig/o_bias_cfg[17] i_sg13cmos5l_dsa1_dig_core.dsa1_dig/o_bias_cfg[18]
+ _11_/A i_sg13cmos5l_dsa1_dig_core.dsa1_dig/o_bias_cfg[1] _14_/B _15_/S0 dsm2/di_btest_en
+ dsm2/di_vcm_ext _10_/A i_sg13cmos5l_dsa1_dig_core.u_adc_conv_gate/B i_sg13cmos5l_dsa1_dig_core.dsa1_dig/o_bias_cfg[26]
+ i_sg13cmos5l_dsa1_dig_core.dsa1_dig/o_bias_cfg[27] i_sg13cmos5l_dsa1_dig_core.dsa1_dig/o_bias_cfg[28]
+ i_sg13cmos5l_dsa1_dig_core.dsa1_dig/o_bias_cfg[29] i_sg13cmos5l_dsa1_dig_core.dsa1_dig/o_bias_cfg[2]
+ i_sg13cmos5l_dsa1_dig_core.dsa1_dig/o_bias_cfg[30] i_sg13cmos5l_dsa1_dig_core.dsa1_dig/o_bias_cfg[31]
+ i_sg13cmos5l_dsa1_dig_core.dsa1_dig/o_bias_cfg[32] i_sg13cmos5l_dsa1_dig_core.dsa1_dig/o_bias_cfg[33]
+ i_sg13cmos5l_dsa1_dig_core.dsa1_dig/o_bias_cfg[34] dsm2/di_trim[0] dsm2/di_trim[1]
+ dsm2/di_trim[2] dsm2/di_trim[3] dsm2/di_dith_en dsm2/di_dith_amp[0] dsm2/di_dith_amp[1]
+ i_sg13cmos5l_dsa1_dig_core.dsa1_dig/o_clk_cfg[0] i_sg13cmos5l_dsa1_dig_core.dsa1_dig/o_clk_cfg[10]
+ i_sg13cmos5l_dsa1_dig_core.dsa1_dig/o_clk_cfg[11] i_sg13cmos5l_dsa1_dig_core.dsa1_dig/o_clk_cfg[12]
+ i_sg13cmos5l_dsa1_dig_core.dsa1_dig/o_clk_cfg[13] i_sg13cmos5l_dsa1_dig_core.dsa1_dig/o_clk_cfg[14]
+ i_sg13cmos5l_dsa1_dig_core.dsa1_dig/o_clk_cfg[15] i_sg13cmos5l_dsa1_dig_core.dsa1_dig/o_clk_cfg[16]
+ i_sg13cmos5l_dsa1_dig_core.dsa1_dig/o_clk_cfg[17] i_sg13cmos5l_dsa1_dig_core.dsa1_dig/o_clk_cfg[18]
+ i_sg13cmos5l_dsa1_dig_core.dsa1_dig/o_clk_cfg[1] i_sg13cmos5l_dsa1_dig_core.dsa1_dig/o_clk_cfg[2]
+ i_sg13cmos5l_dsa1_dig_core.dsa1_dig/o_clk_cfg[3] i_sg13cmos5l_dsa1_dig_core.dsa1_dig/o_clk_cfg[4]
+ i_sg13cmos5l_dsa1_dig_core.dsa1_dig/o_clk_cfg[5] i_sg13cmos5l_dsa1_dig_core.dsa1_dig/o_clk_cfg[6]
+ i_sg13cmos5l_dsa1_dig_core.dsa1_dig/o_clk_cfg[7] i_sg13cmos5l_dsa1_dig_core.dsa1_dig/o_clk_cfg[8]
+ i_sg13cmos5l_dsa1_dig_core.dsa1_dig/o_clk_cfg[9] i_sg13cmos5l_dsa1_dig_core.dsa1_dig/o_en_ctrl[0]
+ i_sg13cmos5l_dsa1_dig_core.dsa1_dig/o_en_ctrl[10] i_sg13cmos5l_dsa1_dig_core.dsa1_dig/o_en_ctrl[1]
+ i_sg13cmos5l_dsa1_dig_core.dsa1_dig/o_en_ctrl[2] i_sg13cmos5l_dsa1_dig_core.dsa1_dig/o_en_ctrl[3]
+ i_sg13cmos5l_dsa1_dig_core.dsa1_dig/o_en_ctrl[4] i_sg13cmos5l_dsa1_dig_core.dsa1_dig/o_en_ctrl[5]
+ i_sg13cmos5l_dsa1_dig_core.dsa1_dig/o_en_ctrl[6] i_sg13cmos5l_dsa1_dig_core.dsa1_dig/o_en_ctrl[7]
+ i_sg13cmos5l_dsa1_dig_core.dsa1_dig/o_en_ctrl[8] i_sg13cmos5l_dsa1_dig_core.dsa1_dig/o_en_ctrl[9]
+ i_sg13cmos5l_dsa1_dig_core.dsa1_dig/o_lf_cfg[0] i_sg13cmos5l_dsa1_dig_core.dsa1_dig/o_lf_cfg[10]
+ i_sg13cmos5l_dsa1_dig_core.dsa1_dig/o_lf_cfg[11] i_sg13cmos5l_dsa1_dig_core.dsa1_dig/o_lf_cfg[12]
+ i_sg13cmos5l_dsa1_dig_core.dsa1_dig/o_lf_cfg[13] i_sg13cmos5l_dsa1_dig_core.dsa1_dig/o_lf_cfg[14]
+ i_sg13cmos5l_dsa1_dig_core.dsa1_dig/o_lf_cfg[15] i_sg13cmos5l_dsa1_dig_core.dsa1_dig/o_lf_cfg[1]
+ i_sg13cmos5l_dsa1_dig_core.dsa1_dig/o_lf_cfg[2] i_sg13cmos5l_dsa1_dig_core.dsa1_dig/o_lf_cfg[3]
+ i_sg13cmos5l_dsa1_dig_core.dsa1_dig/o_lf_cfg[4] i_sg13cmos5l_dsa1_dig_core.dsa1_dig/o_lf_cfg[5]
+ i_sg13cmos5l_dsa1_dig_core.dsa1_dig/o_lf_cfg[6] i_sg13cmos5l_dsa1_dig_core.dsa1_dig/o_lf_cfg[7]
+ i_sg13cmos5l_dsa1_dig_core.dsa1_dig/o_lf_cfg[8] i_sg13cmos5l_dsa1_dig_core.dsa1_dig/o_lf_cfg[9]
+ i_sg13cmos5l_dsa1_dig_core.dsa1_dig/o_rst_ctrl_b[0] i_sg13cmos5l_dsa1_dig_core.dsa1_dig/o_rst_ctrl_b[1]
+ i_sg13cmos5l_dsa1_dig_core.dsa1_dig/o_tst_ctrl[0] i_sg13cmos5l_dsa1_dig_core.dsa1_dig/o_tst_ctrl[10]
+ i_sg13cmos5l_dsa1_dig_core.dsa1_dig/o_tst_ctrl[11] i_sg13cmos5l_dsa1_dig_core.dsa1_dig/o_tst_ctrl[12]
+ i_sg13cmos5l_dsa1_dig_core.dsa1_dig/o_tst_ctrl[13] i_sg13cmos5l_dsa1_dig_core.dsa1_dig/o_tst_ctrl[14]
+ i_sg13cmos5l_dsa1_dig_core.dsa1_dig/o_tst_ctrl[15] i_sg13cmos5l_dsa1_dig_core.dsa1_dig/o_tst_ctrl[1]
+ i_sg13cmos5l_dsa1_dig_core.dsa1_dig/o_tst_ctrl[2] i_sg13cmos5l_dsa1_dig_core.dsa1_dig/o_tst_ctrl[3]
+ i_sg13cmos5l_dsa1_dig_core.dsa1_dig/o_tst_ctrl[4] i_sg13cmos5l_dsa1_dig_core.dsa1_dig/o_tst_ctrl[5]
+ i_sg13cmos5l_dsa1_dig_core.dsa1_dig/o_tst_ctrl[6] i_sg13cmos5l_dsa1_dig_core.dsa1_dig/o_tst_ctrl[7]
+ i_sg13cmos5l_dsa1_dig_core.dsa1_dig/o_tst_ctrl[8] i_sg13cmos5l_dsa1_dig_core.dsa1_dig/o_tst_ctrl[9]
+ i_sg13cmos5l_dsa1_dig_core.dsa1_dig/o_uwb_tx_cfg[0] i_sg13cmos5l_dsa1_dig_core.dsa1_dig/o_uwb_tx_cfg[10]
+ i_sg13cmos5l_dsa1_dig_core.dsa1_dig/o_uwb_tx_cfg[11] i_sg13cmos5l_dsa1_dig_core.dsa1_dig/o_uwb_tx_cfg[12]
+ i_sg13cmos5l_dsa1_dig_core.dsa1_dig/o_uwb_tx_cfg[13] i_sg13cmos5l_dsa1_dig_core.dsa1_dig/o_uwb_tx_cfg[14]
+ i_sg13cmos5l_dsa1_dig_core.dsa1_dig/o_uwb_tx_cfg[15] i_sg13cmos5l_dsa1_dig_core.dsa1_dig/o_uwb_tx_cfg[16]
+ i_sg13cmos5l_dsa1_dig_core.dsa1_dig/o_uwb_tx_cfg[17] i_sg13cmos5l_dsa1_dig_core.dsa1_dig/o_uwb_tx_cfg[18]
+ i_sg13cmos5l_dsa1_dig_core.dsa1_dig/o_uwb_tx_cfg[19] i_sg13cmos5l_dsa1_dig_core.dsa1_dig/o_uwb_tx_cfg[1]
+ i_sg13cmos5l_dsa1_dig_core.dsa1_dig/o_uwb_tx_cfg[20] i_sg13cmos5l_dsa1_dig_core.dsa1_dig/o_uwb_tx_cfg[21]
+ i_sg13cmos5l_dsa1_dig_core.dsa1_dig/o_uwb_tx_cfg[22] i_sg13cmos5l_dsa1_dig_core.dsa1_dig/o_uwb_tx_cfg[23]
+ i_sg13cmos5l_dsa1_dig_core.dsa1_dig/o_uwb_tx_cfg[24] i_sg13cmos5l_dsa1_dig_core.dsa1_dig/o_uwb_tx_cfg[25]
+ i_sg13cmos5l_dsa1_dig_core.dsa1_dig/o_uwb_tx_cfg[26] i_sg13cmos5l_dsa1_dig_core.dsa1_dig/o_uwb_tx_cfg[27]
+ i_sg13cmos5l_dsa1_dig_core.dsa1_dig/o_uwb_tx_cfg[28] i_sg13cmos5l_dsa1_dig_core.dsa1_dig/o_uwb_tx_cfg[29]
+ i_sg13cmos5l_dsa1_dig_core.dsa1_dig/o_uwb_tx_cfg[2] i_sg13cmos5l_dsa1_dig_core.dsa1_dig/o_uwb_tx_cfg[3]
+ i_sg13cmos5l_dsa1_dig_core.dsa1_dig/o_uwb_tx_cfg[4] i_sg13cmos5l_dsa1_dig_core.dsa1_dig/o_uwb_tx_cfg[5]
+ i_sg13cmos5l_dsa1_dig_core.dsa1_dig/o_uwb_tx_cfg[6] i_sg13cmos5l_dsa1_dig_core.dsa1_dig/o_uwb_tx_cfg[7]
+ i_sg13cmos5l_dsa1_dig_core.dsa1_dig/o_uwb_tx_cfg[8] i_sg13cmos5l_dsa1_dig_core.dsa1_dig/o_uwb_tx_cfg[9]
+ _30_/RB g_inputs\[1\].input_pad/p2c hold3/Y dsa1_dig_top
X_19_ _28_/Q _25_/Q _24_/Q _23_/Q VDD VSS _21_/B NAND4BX1
XFILLER_22_988 VSS VDD FILLER2
XFILLER_0_358 VSS VDD FILLER2
XFILLER_13_933 VDD VSS DECAPHV32
XTAP_TAPCELL_ROW_170_1_187 VDD VSS WELLTAP
XTAP_TAPCELL_ROW_170_1_176 VDD VSS WELLTAP
XFILLER_17_96 VDD VSS DECAPHV32
XTAP_TAPCELL_ROW_4_77 VDD VSS WELLTAP
XTAP_TAPCELL_ROW_4_88 VDD VSS WELLTAP
XFILLER_9_904 VDD VSS DECAPHV16
XTAP_TAPCELL_ROW_4_99 VDD VSS WELLTAP
XFILLER_12_498 VDD VSS DECAPHV32
XFILLER_4_620 VDD VSS DECAPHV8
Xhold3 hold3/A VDD VSS hold3/Y BUFX3
XFILLER_12_6 VDD VSS FILLER1
XFILLER_16_793 VDD VSS DECAPHV32
XIO_FILL_IO_SOUTH_0_0 IOVDD IOVSS VDD VSS sg13cmos5l_Filler4000
XFILLER_22_763 VSS VDD FILLER2
XFILLER_6_918 VDD VSS DECAPHV32
XFILLER_10_903 VDD VSS DECAPHV32
XFILLER_0_133 VSS VDD FILLER2
XFILLER_5_439 VDD VSS DECAPHV16
XTAP_TAPCELL_ROW_178_1_270 VDD VSS WELLTAP
XFILLER_9_734 VDD VSS DECAPHV8
XFILLER_8_266 VDD VSS DECAPHV32
XFILLER_8_255 VSS VDD FILLER2
XFILLER_12_273 VDD VSS DECAPHV32
XFILLER_5_88 VDD VSS FILLER4
XFILLER_2_1136 VDD VSS DECAPHV16
XTAP_TAPCELL_ROW_1_34 VDD VSS WELLTAP
XFILLER_5_269 VDD VSS DECAPHV8
XFILLER_10_755 VDD VSS DECAPHV8
XTAP_TAPCELL_ROW_1_45 VDD VSS WELLTAP
XFILLER_13_593 VDD VSS DECAPHV32
XFILLER_3_718 VDD VSS DECAPHV16
XIO_FILL_IO_NORTH_0_20 IOVDD IOVSS VDD VSS sg13cmos5l_Filler2000
XFILLER_2_206 VDD VSS DECAPHV16
XFILLER_18_129 VDD VSS DECAPHV8
XFILLER_6_501 VDD VSS DECAPHV8
XFILLER_10_530 VDD VSS DECAPHV8
XFILLER_6_578 VDD VSS DECAPHV16
XFILLER_17_184 VSS VDD FILLER2
XFILLER_3_548 VDD VSS DECAPHV8
Xdelaybuf_1_clk delaybuf_1_clk/A VDD VSS delaybuf_2_clk/A BUFX12
XFILLER_0_1426 VSS VDD FILLER2
XFILLER_21_625 VDD VSS DECAPHV16
XFILLER_20_113 VDD VSS DECAPHV16
XFILLER_7_128 VDD VSS DECAPHV32
XFILLER_8_607 VDD VSS DECAPHV32
XFILLER_4_813 VDD VSS DECAPHV32
XFILLER_15_463 VSS VDD FILLER2
XTAP_TAPCELL_ROW_179_1_283 VDD VSS WELLTAP
XFILLER_8_44 VSS VDD FILLER2
X_18_ _20_/B _18_/B VDD VSS _24_/D NOR2X1
XFILLER_19_0 VDD VSS DECAPHV32
XFILLER_21_455 VDD VSS DECAPHV8
XFILLER_1_827 VDD VSS DECAPHV8
XTAP_TAPCELL_ROW_170_1_188 VDD VSS WELLTAP
XFILLER_17_64 VDD VSS DECAPHV16
XTAP_TAPCELL_ROW_170_1_177 VDD VSS WELLTAP
XTAP_TAPCELL_ROW_4_78 VDD VSS WELLTAP
XTAP_TAPCELL_ROW_4_89 VDD VSS WELLTAP
XFILLER_4_665 VDD VSS DECAPHV8
XFILLER_15_282 VDD VSS DECAPHV32
XIO_FILL_IO_NORTH_3_20 IOVDD IOVSS VDD VSS sg13cmos5l_Filler400
XFILLER_5_407 VDD VSS DECAPHV32
XFILLER_10_948 VDD VSS DECAPHV32
XFILLER_0_178 VSS VDD FILLER2
XTAP_TAPCELL_ROW_178_1_271 VDD VSS WELLTAP
XFILLER_13_742 VSS VDD FILLER2
XFILLER_12_252 VDD VSS DECAPHV8
XFILLER_4_440 VDD VSS DECAPHV8
XFILLER_9_779 VDD VSS DECAPHV32
XFILLER_22_1021 VDD VSS FILLER1
XFILLER_2_1104 VDD VSS DECAPHV32
XFILLER_22_583 VSS VDD FILLER2
XFILLER_10_723 VDD VSS DECAPHV32
XFILLER_14_32 VDD VSS DECAPHV8
XTAP_TAPCELL_ROW_1_35 VDD VSS WELLTAP
XFILLER_2_966 VDD VSS DECAPHV8
XFILLER_20_509 VSS VDD FILLER2
XFILLER_9_532 VDD VSS DECAPHV16
XFILLER_13_561 VDD VSS DECAPHV32
XFILLER_10_575 VDD VSS DECAPHV8
XFILLER_6_546 VDD VSS DECAPHV32
XFILLER_14_881 VSS VDD FILLER2
XFILLER_20_328 VDD VSS DECAPHV32
XFILLER_9_340 VDD VSS DECAPHV32
XFILLER_3_1276 VDD VSS DECAPHV16
XFILLER_20_873 VDD VSS DECAPHV8
XFILLER_19_439 VDD VSS DECAPHV16
XFILLER_7_811 VDD VSS DECAPHV16
XIO_BOND_clk_pad clk_PAD sg13cmos5l_ip__bondpad_70x70
XIO_FILL_IO_NORTH_6_20 IOVDD IOVSS VDD VSS sg13cmos5l_Filler2000
XFILLER_12_604 VDD VSS DECAPHV8
XFILLER_22_32 VDD VSS DECAPHV8
XFILLER_3_346 VDD VSS DECAPHV16
XFILLER_4_858 VDD VSS DECAPHV16
XIO_FILL_IO_SOUTH_0_20 IOVDD IOVSS VDD VSS sg13cmos5l_Filler1000
XFILLER_19_269 VDD VSS DECAPHV8
XTAP_TAPCELL_ROW_179_1_284 VDD VSS WELLTAP
XFILLER_7_641 VDD VSS DECAPHV8
XFILLER_22_935 VDD VSS DECAPHV8
X_17_ _28_/Q _23_/Q _24_/Q VDD VSS _18_/B AOI2B1X1
XFILLER_0_1213 VSS VDD FILLER2
XFILLER_4_1393 VSS VDD FILLER2
XFILLER_0_305 VDD VSS DECAPHV8
XFILLER_17_718 VDD VSS DECAPHV16
XFILLER_16_206 VDD VSS DECAPHV16
XFILLER_17_32 VDD VSS DECAPHV32
XTAP_TAPCELL_ROW_170_1_189 VDD VSS WELLTAP
XFILLER_8_416 VSS VDD FILLER2
XFILLER_9_928 VSS VDD FILLER2
XTAP_TAPCELL_ROW_170_1_178 VDD VSS WELLTAP
XTAP_TAPCELL_ROW_4_79 VDD VSS WELLTAP
XFILLER_4_633 VDD VSS DECAPHV32
XFILLER_3_176 VDD VSS DECAPHV8
XFILLER_8_950 VSS VDD FILLER2
XFILLER_22_710 VDD VSS DECAPHV8
XFILLER_21_253 VDD VSS DECAPHV16
XTAP_TAPCELL_ROW_178_1_272 VDD VSS WELLTAP
XFILLER_1_625 VDD VSS DECAPHV16
XFILLER_17_548 VDD VSS DECAPHV8
XFILLER_8_257 VDD VSS FILLER1
XFILLER_8_235 VDD VSS DECAPHV16
XFILLER_8_224 VDD VSS DECAPHV8
XFILLER_9_747 VDD VSS DECAPHV32
XFILLER_4_485 VDD VSS DECAPHV8
XFILLER_5_920 VDD VSS DECAPHV8
XFILLER_5_997 VDD VSS DECAPHV16
XFILLER_1_1385 VDD VSS DECAPHV8
XFILLER_7_290 VSS VDD FILLER2
XFILLER_8_780 VDD VSS DECAPHV8
XFILLER_10_768 VDD VSS DECAPHV32
XFILLER_14_44 VSS VDD FILLER2
XTAP_TAPCELL_ROW_1_36 VDD VSS WELLTAP
XFILLER_1_455 VDD VSS DECAPHV8
Xclk_pad IOVDD IOVSS clk_pad/p2c clk_PAD VDD VSS sg13cmos5l_IOPadIn
XFILLER_18_857 VDD VSS DECAPHV16
XFILLER_9_500 VDD VSS DECAPHV32
XFILLER_4_260 VDD VSS DECAPHV8
XFILLER_3_1414 VDD VSS DECAPHV8
XTAP_TAPCELL_ROW_177_1_260 VDD VSS WELLTAP
XFILLER_15_827 VDD VSS DECAPHV8
XFILLER_14_315 VDD VSS DECAPHV8
XFILLER_6_514 VDD VSS DECAPHV32
XFILLER_10_543 VDD VSS DECAPHV32
Xhelm_art sg13cmos5l_ip__helm
XFILLER_9_0 VDD VSS DECAPHV8
XFILLER_2_764 VDD VSS DECAPHV16
XFILLER_18_687 VDD VSS DECAPHV8
XFILLER_13_370 VSS VDD FILLER2
XFILLER_12_1021 VDD VSS FILLER1
XFILLER_12_808 VSS VDD FILLER2
XFILLER_3_1244 VDD VSS DECAPHV32
Xclkbuf_1_0__f_clk_PAD2CORE_regs clkbuf_0_clk_PAD2CORE_regs/Y VDD VSS _30_/CK BUFX12
XFILLER_19_407 VDD VSS DECAPHV32
XFILLER_10_340 VDD VSS DECAPHV16
XFILLER_10_395 VDD VSS DECAPHV8
XFILLER_2_594 VDD VSS DECAPHV8
XFILLER_21_649 VSS VDD FILLER2
XFILLER_9_160 VDD VSS DECAPHV16
XFILLER_20_137 VSS VDD FILLER2
XFILLER_12_616 VDD VSS DECAPHV8
XFILLER_20_671 VDD VSS DECAPHV16
XFILLER_3_314 VDD VSS DECAPHV32
XFILLER_22_44 VDD VSS FILLER1
XFILLER_22_88 VSS VDD FILLER2
XFILLER_16_966 VDD VSS DECAPHV8
XTAP_TAPCELL_ROW_179_1_285 VDD VSS WELLTAP
XFILLER_10_170 VDD VSS DECAPHV8
XFILLER_6_174 VDD VSS DECAPHV32
XFILLER_7_686 VDD VSS DECAPHV32
X_16_ _28_/Q _24_/Q _23_/Q VDD VSS _20_/B AND3BX1
XFILLER_22_903 VDD VSS DECAPHV32
XFILLER_0_1258 VSS VDD FILLER2
XFILLER_21_468 VDD VSS DECAPHV32
XFILLER_17_88 VDD VSS FILLER4
XTAP_TAPCELL_ROW_170_1_179 VDD VSS WELLTAP
XFILLER_4_678 VDD VSS DECAPHV32
XFILLER_12_980 VDD VSS DECAPHV8
XFILLER_8_973 VSS VDD FILLER2
XFILLER_0_80 VDD VSS DECAPHV8
XFILLER_0_1033 VSS VDD FILLER2
XFILLER_16_1019 VSS VDD FILLER2
XIO_FILL_IO_NORTH_3_22 IOVDD IOVSS VDD VSS sg13cmos5l_Filler400
XFILLER_22_755 VDD VSS DECAPHV8
XFILLER_21_221 VDD VSS DECAPHV32
XTAP_TAPCELL_ROW_178_1_273 VDD VSS WELLTAP
XFILLER_0_125 VDD VSS DECAPHV8
XFILLER_8_214 VDD VSS FILLER4
XFILLER_4_453 VDD VSS DECAPHV32
XFILLER_5_965 VDD VSS DECAPHV32
Xdsm2 dsm2/di_btest_en dsm2/di_clk dsm2/di_clk_sel dsm2/di_dith_amp[0] dsm2/di_dith_amp[1]
+ dsm2/di_dith_en _11_/Y dsm2/di_osc_en _10_/Y _14_/Y dsm2/di_trim[0] dsm2/di_trim[1]
+ dsm2/di_trim[2] dsm2/di_trim[3] dsm2/di_vcm_ext dsm_clk_pad/c2p dsm2/do_osc_oe dsm2/do_q
+ dsm2/do_q_b dsm2/do_q_dec ib_pad/padres dsm2/vcm VDDA dsm2/vi VSS dsm2_core
XFILLER_22_530 VDD VSS DECAPHV8
XTAP_TAPCELL_ROW_1_37 VDD VSS WELLTAP
XFILLER_2_979 VDD VSS DECAPHV32
XFILLER_18_825 VDD VSS DECAPHV32
XFILLER_17_346 VDD VSS DECAPHV16
XFILLER_9_556 VSS VDD FILLER2
XFILLER_1_1183 VDD VSS DECAPHV16
XFILLER_3_1426 VSS VDD FILLER2
XTAP_TAPCELL_ROW_177_1_261 VDD VSS WELLTAP
XFILLER_10_588 VDD VSS DECAPHV32
Xdelaybuf_4_clk delaybuf_4_clk/A VDD VSS delaybuf_5_clk/A BUFX12
XFILLER_1_253 VDD VSS DECAPHV16
XFILLER_2_732 VDD VSS DECAPHV32
XFILLER_17_176 VDD VSS DECAPHV8
XFILLER_9_375 VDD VSS DECAPHV32
XFILLER_3_1212 VDD VSS DECAPHV32
Xjku_names sg13cmos5l_ip__jku_names
XFILLER_20_886 VDD VSS DECAPHV32
XFILLER_14_113 VDD VSS DECAPHV16
XFILLER_15_625 VDD VSS DECAPHV16
XFILLER_10_363 VDD VSS DECAPHV32
XFILLER_7_835 VSS VDD FILLER2
XFILLER_19_920 VDD VSS DECAPHV8
XFILLER_19_997 VDD VSS DECAPHV16
XFILLER_18_485 VDD VSS DECAPHV16
XFILLER_3_80 VDD VSS DECAPHV8
XFILLER_12_628 VSS VDD FILLER2
XFILLER_15_455 VDD VSS DECAPHV8
XTAP_TAPCELL_ROW_179_1_286 VDD VSS WELLTAP
XFILLER_6_142 VDD VSS DECAPHV32
XFILLER_7_654 VDD VSS DECAPHV32
XFILLER_2_392 VDD VSS DECAPHV16
X_15_ _15_/A0 _15_/A1 _15_/S0 VDD VSS _27_/D MUX2X1
XFILLER_4_1340 VDD VSS DECAPHV8
XFILLER_22_948 VDD VSS DECAPHV32
XFILLER_0_318 VDD VSS DECAPHV32
XFILLER_13_904 VDD VSS DECAPHV16
XFILLER_12_403 VSS VDD FILLER2
XFILLER_3_189 VDD VSS DECAPHV32
XIO_BOND_vdda_pad VDDA sg13cmos5l_ip__bondpad_70x70
XFILLER_16_764 VDD VSS DECAPHV16
Xg_vdd_pads\[0\].vdd_pad IOVDD IOVSS VDD VSS sg13cmos5l_IOPadVdd
XFILLER_0_1078 VSS VDD FILLER2
XFILLER_17_0 VDD VSS DECAPHV32
XFILLER_22_723 VDD VSS DECAPHV32
XFILLER_21_277 VSS VDD FILLER2
XFILLER_1_649 VSS VDD FILLER2
XTAP_TAPCELL_ROW_178_1_274 VDD VSS WELLTAP
XFILLER_13_734 VDD VSS DECAPHV8
XFILLER_5_933 VDD VSS DECAPHV32
XFILLER_4_498 VDD VSS DECAPHV32
Xvi_pad IOVDD IOVSS analog_PAD[0] vi_pad/padbare dsm2/vi VDDA VSS sg13cmos5l_IOPadAnalog
XTAP_TAPCELL_ROW_180_1_300 VDD VSS WELLTAP
XFILLER_1_1398 VDD VSS DECAPHV16
XFILLER_16_594 VDD VSS DECAPHV8
XFILLER_8_793 VDD VSS DECAPHV32
XFILLER_14_509 VSS VDD FILLER2
XFILLER_22_575 VDD VSS DECAPHV8
XFILLER_1_468 VDD VSS DECAPHV32
XTAP_TAPCELL_ROW_1_38 VDD VSS WELLTAP
XFILLER_17_314 VDD VSS DECAPHV32
XFILLER_4_273 VDD VSS DECAPHV32
XIO_FILL_IO_NORTH_6_0 IOVDD IOVSS VDD VSS sg13cmos5l_Filler4000
XFILLER_1_1151 VDD VSS DECAPHV32
XTAP_TAPCELL_ROW_177_1_262 VDD VSS WELLTAP
XFILLER_14_328 VDD VSS DECAPHV32
XFILLER_22_350 VDD VSS DECAPHV8
XFILLER_2_700 VDD VSS DECAPHV32
XFILLER_1_221 VDD VSS DECAPHV32
XFILLER_2_49 VDD VSS DECAPHV32
XFILLER_2_788 VSS VDD FILLER2
XFILLER_14_873 VDD VSS DECAPHV8
XFILLER_5_593 VDD VSS DECAPHV32
XFILLER_6_302 VSS VDD FILLER2
XFILLER_19_965 VDD VSS DECAPHV32
XTAP_TAPCELL_ROW_176_1_250 VDD VSS WELLTAP
XFILLER_18_453 VDD VSS DECAPHV32
XFILLER_2_1290 VDD VSS DECAPHV32
XFILLER_9_184 VSS VDD FILLER2
XFILLER_3_92 VDD VSS FILLER1
XFILLER_3_1021 VSS VDD FILLER2
XFILLER_20_695 VSS VDD FILLER2
XFILLER_16_979 VDD VSS DECAPHV32
XFILLER_10_183 VDD VSS DECAPHV32
XFILLER_2_360 VDD VSS DECAPHV32
XFILLER_3_872 VDD VSS DECAPHV32
X_14_ _28_/Q _14_/B VDD VSS _14_/Y NOR2BX1
XFILLER_0_1205 VDD VSS DECAPHV8
XFILLER_4_1385 VDD VSS DECAPHV8
XFILLER_8_408 VDD VSS DECAPHV8
XFILLER_12_448 VSS VDD FILLER2
XFILLER_0_853 VSS VDD FILLER2
XFILLER_16_732 VDD VSS DECAPHV32
XFILLER_15_253 VDD VSS DECAPHV16
XFILLER_12_993 VDD VSS DECAPHV16
XFILLER_7_463 VSS VDD FILLER2
XFILLER_8_975 VDD VSS FILLER1
XFILLER_0_93 VDD VSS DECAPHV32
XFILLER_4_1160 VDD VSS DECAPHV8
XFILLER_22_768 VDD VSS DECAPHV32
XFILLER_9_91 VSS VDD FILLER2
XFILLER_0_138 VDD VSS DECAPHV32
XTAP_TAPCELL_ROW_178_1_275 VDD VSS WELLTAP
XIO_BOND_do_q_pad do_q_PAD sg13cmos5l_ip__bondpad_70x70
XFILLER_13_779 VDD VSS DECAPHV32
XFILLER_12_223 VSS VDD FILLER2
XFILLER_10_8 VDD VSS FILLER4
XTAP_TAPCELL_ROW_180_1_301 VDD VSS WELLTAP
XFILLER_1_1300 VSS VDD FILLER2
XFILLER_15_1021 VDD VSS FILLER1
XFILLER_7_282 VDD VSS DECAPHV8
XFILLER_22_543 VDD VSS DECAPHV32
XTAP_TAPCELL_ROW_1_39 VDD VSS WELLTAP
XFILLER_13_532 VDD VSS DECAPHV16
XFILLER_5_742 VSS VDD FILLER2
XIO_FILL_IO_EAST_1_20 IOVDD IOVSS VDDA VSS sg13cmos5l_Filler2000
Xclkbuf_1_0__f_clk_PAD2CORE clkbuf_0_clk_PAD2CORE/Y VDD VSS clkbuf_1_0__f_clk_PAD2CORE/Y
+ BUFX12
XTAP_TAPCELL_ROW_177_1_263 VDD VSS WELLTAP
XFILLER_6_81 VDD VSS DECAPHV32
XFILLER_22_395 VDD VSS DECAPHV8
XFILLER_18_602 VSS VDD FILLER2
XFILLER_1_277 VSS VDD FILLER2
XFILLER_17_189 VDD VSS DECAPHV32
XFILLER_13_362 VDD VSS DECAPHV8
XFILLER_5_561 VDD VSS DECAPHV32
XTAP_TAPCELL_ROW_2_60 VDD VSS WELLTAP
XFILLER_15_649 VSS VDD FILLER2
XFILLER_14_137 VSS VDD FILLER2
XFILLER_22_170 VDD VSS DECAPHV8
XFILLER_7_0 VDD VSS DECAPHV32
XFILLER_19_933 VDD VSS DECAPHV32
XTAP_TAPCELL_ROW_176_1_251 VDD VSS WELLTAP
X_30_ _30_/CK _30_/D _30_/Q _30_/RB VDD VSS DFFRQX1
XFILLER_18_421 VDD VSS DECAPHV32
XFILLER_14_671 VDD VSS DECAPHV16
XFILLER_20_129 VDD VSS DECAPHV8
XFILLER_6_881 VSS VDD FILLER2
XFILLER_8_49 VDD VSS DECAPHV32
XTAP_TAPCELL_ROW_179_1_277 VDD VSS WELLTAP
XFILLER_15_468 VDD VSS DECAPHV32
XFILLER_3_840 VDD VSS DECAPHV32
XFILLER_12_80 VDD VSS DECAPHV8
X_13_ _23_/Q _26_/Q _13_/C _28_/Q VDD VSS _28_/D AO31X1
XFILLER_4_1353 VDD VSS DECAPHV32
XFILLER_13_928 VSS VDD FILLER2
XFILLER_0_898 VSS VDD FILLER2
XFILLER_16_700 VDD VSS DECAPHV32
XFILLER_15_221 VDD VSS DECAPHV32
XFILLER_16_788 VSS VDD FILLER2
XIO_FILL_IO_EAST_4_20 IOVDD IOVSS VDDA VSS sg13cmos5l_Filler2000
XFILLER_19_593 VDD VSS DECAPHV32
XFILLER_0_1025 VDD VSS DECAPHV8
XTAP_TAPCELL_ROW_178_1_276 VDD VSS WELLTAP
XIO_BOND_dsm_clk_pad dsm_clk_PAD sg13cmos5l_ip__bondpad_70x70
XFILLER_13_747 VDD VSS DECAPHV32
XFILLER_8_206 VDD VSS DECAPHV8
XFILLER_9_718 VDD VSS DECAPHV16
XTAP_TAPCELL_ROW_180_1_302 VDD VSS WELLTAP
XFILLER_0_673 VSS VDD FILLER2
XIO_FILL_IO_EAST_6_0 IOVDD IOVSS VDD VSS sg13cmos5l_Filler4000
XFILLER_22_0 VDD VSS DECAPHV32
XFILLER_22_588 VDD VSS DECAPHV32
XFILLER_13_500 VDD VSS DECAPHV32
Xdelaybuf_7_clk delaybuf_7_clk/A VDD VSS delaybuf_8_clk/A BUFX12
XFILLER_9_548 VDD VSS DECAPHV8
XFILLER_17_872 VDD VSS DECAPHV32
XTAP_TAPCELL_ROW_9_1_140 VDD VSS WELLTAP
XTAP_TAPCELL_ROW_177_1_264 VDD VSS WELLTAP
XFILLER_22_363 VDD VSS DECAPHV32
XFILLER_14_886 VDD VSS DECAPHV32
XFILLER_15_80 VDD VSS DECAPHV8
XTAP_TAPCELL_ROW_2_50 VDD VSS WELLTAP
XFILLER_6_304 VDD VSS FILLER1
XFILLER_7_827 VDD VSS DECAPHV8
XTAP_TAPCELL_ROW_176_1_252 VDD VSS WELLTAP
XFILLER_13_160 VDD VSS DECAPHV16
XFILLER_5_370 VSS VDD FILLER2
XFILLER_4_808 VSS VDD FILLER2
XFILLER_22_48 VDD VSS DECAPHV32
XTAP_TAPCELL_ROW_179_1_278 VDD VSS WELLTAP
XFILLER_19_742 VSS VDD FILLER2
X_12_ _24_/Q _25_/Q VDD VSS _13_/C NOR2X1
XFILLER_0_1218 VDD VSS DECAPHV32
XFILLER_4_1398 VDD VSS DECAPHV16
XFILLER_18_230 VSS VDD FILLER2
XIO_FILL_IO_SOUTH_7_0 IOVDD IOVSS VDDA VSS sg13cmos5l_Filler4000
XFILLER_21_439 VDD VSS DECAPHV16
XTAP_TAPCELL_ROW_175_1_240 VDD VSS WELLTAP
XFILLER_0_800 VDD VSS DECAPHV8
XFILLER_15_277 VSS VDD FILLER2
XFILLER_19_561 VDD VSS DECAPHV32
XFILLER_0_40 VDD VSS FILLER4
XFILLER_4_1173 VDD VSS DECAPHV32
XFILLER_21_269 VDD VSS DECAPHV8
XTAP_TAPCELL_ROW_178_1_266 VDD VSS WELLTAP
XFILLER_8_218 VSS VDD FILLER2
XFILLER_12_236 VDD VSS DECAPHV16
XTAP_TAPCELL_ROW_180_1_303 VDD VSS WELLTAP
Xi_sg13cmos5l_dsa1_dig_core.u_adc_conv_gate i_sg13cmos5l_dsa1_dig_core.u_adc_conv_gate/A
+ i_sg13cmos5l_dsa1_dig_core.u_adc_conv_gate/B VDD VSS g_outputs\[1\].output_pad/c2p
+ AND2X1
XFILLER_4_980 VDD VSS DECAPHV8
XFILLER_15_0 VDD VSS DECAPHV32
XFILLER_10_718 VSS VDD FILLER2
XFILLER_14_49 VDD VSS DECAPHV32
XFILLER_13_556 VSS VDD FILLER2
XFILLER_20_81 VDD VSS DECAPHV32
XFILLER_17_840 VDD VSS DECAPHV32
XFILLER_0_493 VSS VDD FILLER2
XTAP_TAPCELL_ROW_177_1_265 VDD VSS WELLTAP
XTAP_TAPCELL_ROW_9_1_141 VDD VSS WELLTAP
XFILLER_6_1021 VDD VSS FILLER1
XFILLER_9_302 VDD VSS FILLER1
XFILLER_15_92 VDD VSS FILLER1
XFILLER_13_375 VDD VSS DECAPHV32
XTAP_TAPCELL_ROW_2_51 VDD VSS WELLTAP
XIO_FILL_IO_NORTH_4_0 IOVDD IOVSS VDD VSS sg13cmos5l_Filler4000
XFILLER_20_857 VDD VSS DECAPHV16
XFILLER_22_183 VDD VSS DECAPHV32
XFILLER_10_356 VDD VSS FILLER4
XTAP_TAPCELL_ROW_176_1_253 VDD VSS WELLTAP
XFILLER_14_695 VSS VDD FILLER2
XFILLER_9_176 VDD VSS DECAPHV8
XFILLER_10_890 VDD VSS DECAPHV8
XFILLER_3_1013 VDD VSS DECAPHV8
XFILLER_20_687 VDD VSS DECAPHV8
XFILLER_6_113 VDD VSS DECAPHV16
XFILLER_7_625 VDD VSS DECAPHV16
XTAP_TAPCELL_ROW_179_1_279 VDD VSS WELLTAP
XFILLER_12_93 VDD VSS DECAPHV32
X_11_ _11_/A VDD VSS _11_/Y INVX1
XFILLER_18_1021 VDD VSS FILLER1
XFILLER_21_407 VDD VSS DECAPHV32
XTAP_TAPCELL_ROW_175_1_241 VDD VSS WELLTAP
XFILLER_4_628 VSS VDD FILLER2
XFILLER_0_845 VDD VSS DECAPHV8
XFILLER_7_455 VDD VSS DECAPHV8
XFILLER_0_1038 VDD VSS DECAPHV32
XTAP_TAPCELL_ROW_178_1_267 VDD VSS WELLTAP
XFILLER_12_215 VDD VSS DECAPHV8
XFILLER_4_403 VSS VDD FILLER2
XFILLER_5_904 VDD VSS DECAPHV16
XFILLER_0_620 VDD VSS DECAPHV8
XTAP_TAPCELL_ROW_180_1_304 VDD VSS WELLTAP
XFILLER_18_81 VDD VSS DECAPHV32
XFILLER_15_1013 VDD VSS DECAPHV8
XFILLER_1_1369 VDD VSS DECAPHV16
XFILLER_7_274 VDD VSS FILLER4
XFILLER_8_764 VDD VSS DECAPHV16
XFILLER_22_1017 VDD VSS FILLER4
XFILLER_19_370 VSS VDD FILLER2
XFILLER_1_439 VDD VSS DECAPHV16
XFILLER_2_918 VDD VSS DECAPHV32
XFILLER_5_734 VDD VSS DECAPHV8
XFILLER_1_1199 VDD VSS DECAPHV8
XTAP_TAPCELL_ROW_9_1_142 VDD VSS WELLTAP
XFILLER_6_40 VDD VSS FILLER4
XFILLER_8_594 VDD VSS DECAPHV8
XFILLER_6_1011 VDD VSS DECAPHV8
XFILLER_6_509 VSS VDD FILLER2
XFILLER_10_538 VSS VDD FILLER2
XFILLER_1_269 VDD VSS DECAPHV8
Xg_vss_pads\[1\].vss_pad IOVDD IOVSS VDD VSS sg13cmos5l_IOPadVss
XTAP_TAPCELL_ROW_2_52 VDD VSS WELLTAP
XFILLER_20_825 VDD VSS DECAPHV32
XFILLER_14_129 VDD VSS DECAPHV8
XFILLER_2_501 VDD VSS DECAPHV8
XFILLER_6_328 VDD VSS DECAPHV32
XTAP_TAPCELL_ROW_176_1_254 VDD VSS WELLTAP
XFILLER_2_578 VDD VSS DECAPHV16
XTAP_TAPCELL_ROW_8_1_130 VDD VSS WELLTAP
XFILLER_6_873 VDD VSS DECAPHV8
XFILLER_13_184 VSS VDD FILLER2
XIO_FILL_IO_WEST_6_0 IOVDD IOVSS VDD VSS sg13cmos5l_Filler4000
XFILLER_3_96 VDD VSS DECAPHV32
XFILLER_3_1058 VDD VSS DECAPHV32
XFILLER_5_0 VDD VSS DECAPHV32
X_10_ _10_/A VDD VSS _10_/Y INVX1
XFILLER_18_1011 VDD VSS DECAPHV8
XFILLER_12_408 VDD VSS DECAPHV32
XFILLER_21_997 VDD VSS DECAPHV16
XFILLER_21_920 VSS VDD FILLER2
XTAP_TAPCELL_ROW_175_1_242 VDD VSS WELLTAP
XFILLER_20_485 VDD VSS DECAPHV16
XFILLER_3_128 VDD VSS DECAPHV32
XFILLER_0_813 VDD VSS DECAPHV32
XFILLER_8_957 VDD VSS DECAPHV16
XFILLER_8_979 VDD VSS DECAPHV32
XTAP_TAPCELL_ROW_178_1_268 VDD VSS WELLTAP
XFILLER_4_448 VSS VDD FILLER2
XFILLER_0_665 VDD VSS DECAPHV8
XTAP_TAPCELL_ROW_180_1_305 VDD VSS WELLTAP
XFILLER_1_1337 VDD VSS DECAPHV32
XFILLER_8_732 VDD VSS DECAPHV32
XFILLER_7_253 VDD VSS FILLER1
XFILLER_4_993 VDD VSS DECAPHV32
XTAP_TAPCELL_ROW_174_1_230 VDD VSS WELLTAP
XFILLER_1_407 VDD VSS DECAPHV32
XFILLER_4_223 VSS VDD FILLER2
XFILLER_5_779 VDD VSS DECAPHV32
XFILLER_0_440 VDD VSS DECAPHV8
XTAP_TAPCELL_ROW_9_1_143 VDD VSS WELLTAP
XFILLER_16_385 VDD VSS DECAPHV32
XANTENNA_1 _15_/A0 VDD VSS ANTENNA2
XTAP_TAPCELL_ROW_177_1_256 VDD VSS WELLTAP
XIO_FILL_IO_EAST_4_0 IOVDD IOVSS VDDA VSS sg13cmos5l_Filler4000
XFILLER_20_0 VDD VSS DECAPHV32
XFILLER_18_639 VDD VSS DECAPHV32
XFILLER_12_1017 VDD VSS FILLER4
XFILLER_5_532 VDD VSS DECAPHV16
XTAP_TAPCELL_ROW_2_53 VDD VSS WELLTAP
XFILLER_3_1207 VSS VDD FILLER2
XFILLER_8_392 VDD VSS DECAPHV16
XFILLER_2_546 VDD VSS DECAPHV32
XTAP_TAPCELL_ROW_8_1_131 VDD VSS WELLTAP
XTAP_TAPCELL_ROW_176_1_255 VDD VSS WELLTAP
XFILLER_19_904 VDD VSS DECAPHV16
XFILLER_9_189 VDD VSS FILLER1
XFILLER_3_64 VDD VSS DECAPHV16
XFILLER_3_1026 VDD VSS DECAPHV32
XFILLER_16_918 VDD VSS DECAPHV32
XFILLER_15_439 VDD VSS DECAPHV16
XFILLER_10_133 VSS VDD FILLER2
XFILLER_6_137 VSS VDD FILLER2
XFILLER_3_811 VDD VSS DECAPHV16
XFILLER_7_649 VSS VDD FILLER2
XFILLER_19_734 VDD VSS DECAPHV8
XFILLER_18_222 VDD VSS DECAPHV8
XFILLER_18_299 VDD VSS DECAPHV16
XFILLER_6_671 VDD VSS DECAPHV16
Xib_pad IOVDD IOVSS analog_PAD[2] ib_pad/padbare ib_pad/padres VDDA VSS sg13cmos5l_IOPadAnalog
Xclkbuf_0_clk_PAD2CORE clk_pad/p2c VDD VSS clkbuf_0_clk_PAD2CORE/Y BUFX12
XFILLER_21_965 VDD VSS DECAPHV32
XTAP_TAPCELL_ROW_175_1_243 VDD VSS WELLTAP
XFILLER_20_453 VDD VSS DECAPHV32
XFILLER_0_858 VDD VSS DECAPHV32
XFILLER_12_943 VSS VDD FILLER2
XFILLER_15_269 VDD VSS DECAPHV8
XFILLER_3_641 VDD VSS DECAPHV8
XFILLER_7_468 VDD VSS DECAPHV32
XFILLER_22_718 VSS VDD FILLER2
XFILLER_0_32 VDD VSS DECAPHV8
XIO_FILL_IO_SOUTH_5_0 IOVDD IOVSS VDDA VSS sg13cmos5l_Filler4000
XFILLER_9_96 VDD VSS DECAPHV32
XFILLER_9_1021 VDD VSS FILLER1
XTAP_TAPCELL_ROW_178_1_269 VDD VSS WELLTAP
XFILLER_13_718 VDD VSS DECAPHV16
XFILLER_5_928 VSS VDD FILLER2
XTAP_TAPCELL_ROW_180_1_306 VDD VSS WELLTAP
XFILLER_0_633 VDD VSS DECAPHV32
XFILLER_1_1305 VDD VSS DECAPHV32
XFILLER_16_501 VDD VSS DECAPHV8
XFILLER_16_578 VDD VSS DECAPHV16
XFILLER_7_221 VDD VSS DECAPHV32
XFILLER_8_700 VDD VSS DECAPHV32
XFILLER_8_788 VSS VDD FILLER2
XTAP_TAPCELL_ROW_174_1_231 VDD VSS WELLTAP
XFILLER_0_1393 VSS VDD FILLER2
XFILLER_13_548 VDD VSS DECAPHV8
XFILLER_4_268 VSS VDD FILLER2
XFILLER_1_920 VDD VSS DECAPHV8
XFILLER_5_747 VDD VSS DECAPHV32
XFILLER_20_40 VDD VSS FILLER4
XFILLER_0_485 VDD VSS DECAPHV8
XFILLER_1_997 VDD VSS DECAPHV16
XTAP_TAPCELL_ROW_9_1_144 VDD VSS WELLTAP
XFILLER_16_353 VDD VSS DECAPHV32
XTAP_TAPCELL_ROW_177_1_257 VDD VSS WELLTAP
XANTENNA_2 ANTENNA_2/A VDD VSS ANTENNA2
XFILLER_13_0 VDD VSS DECAPHV8
XFILLER_9_8 VDD VSS FILLER4
XFILLER_18_607 VDD VSS DECAPHV32
XFILLER_14_857 VDD VSS DECAPHV16
XFILLER_17_128 VDD VSS DECAPHV32
XFILLER_22_890 VDD VSS DECAPHV8
XFILLER_5_500 VDD VSS DECAPHV32
XFILLER_9_327 VSS VDD FILLER2
XTAP_TAPCELL_ROW_2_54 VDD VSS WELLTAP
XFILLER_0_260 VDD VSS DECAPHV8
XFILLER_9_872 VDD VSS DECAPHV32
XFILLER_8_360 VDD VSS DECAPHV32
XIO_BOND_g_outputs\[0\].output_pad output_PAD[0] sg13cmos5l_ip__bondpad_70x70
XFILLER_2_514 VDD VSS DECAPHV32
XTAP_TAPCELL_ROW_8_1_132 VDD VSS WELLTAP
XTAP_TAPCELL_ROW_176_1_245 VDD VSS WELLTAP
XFILLER_14_687 VDD VSS DECAPHV8
XFILLER_6_886 VDD VSS DECAPHV32
XFILLER_3_32 VDD VSS DECAPHV32
XIO_FILL_IO_NORTH_2_0 IOVDD IOVSS VDD VSS sg13cmos5l_Filler4000
XFILLER_20_602 VSS VDD FILLER2
XFILLER_15_407 VDD VSS DECAPHV32
XFILLER_10_178 VSS VDD FILLER2
XFILLER_4_1303 VSS VDD FILLER2
XFILLER_19_779 VDD VSS DECAPHV32
XFILLER_18_267 VDD VSS DECAPHV32
XFILLER_5_160 VDD VSS DECAPHV16
XFILLER_21_933 VDD VSS DECAPHV32
XTAP_TAPCELL_ROW_7_1_120 VDD VSS WELLTAP
XFILLER_20_421 VDD VSS DECAPHV32
XTAP_TAPCELL_ROW_175_1_244 VDD VSS WELLTAP
XFILLER_12_988 VSS VDD FILLER2
XFILLER_2_174 VDD VSS DECAPHV32
XFILLER_3_686 VDD VSS DECAPHV32
XFILLER_19_532 VDD VSS DECAPHV16
XFILLER_0_44 VDD VSS FILLER1
XFILLER_0_88 VSS VDD FILLER2
XTAP_TAPCELL_ROW_180_1_307 VDD VSS WELLTAP
XFILLER_0_678 VDD VSS DECAPHV32
XFILLER_18_40 VDD VSS FILLER4
Xi_sg13cmos5l_dsa1_dig_core.u_dec_src_gate dsm2/do_q_dec _15_/S0 VDD VSS _15_/A1 AND2X1
XFILLER_16_546 VDD VSS DECAPHV32
XFILLER_12_763 VSS VDD FILLER2
XFILLER_7_266 VDD VSS DECAPHV8
Xclkbuf_0_clk_PAD2CORE_regs clkbuf_regs_0_clk/Y VDD VSS clkbuf_0_clk_PAD2CORE_regs/Y
+ BUFX12
XFILLER_22_1009 VDD VSS DECAPHV8
XTAP_TAPCELL_ROW_174_1_232 VDD VSS WELLTAP
XFILLER_19_362 VDD VSS DECAPHV8
XFILLER_22_538 VSS VDD FILLER2
XFILLER_21_593 VDD VSS DECAPHV32
XTAP_TAPCELL_ROW_5_1_310 VDD VSS WELLTAP
XFILLER_0_453 VDD VSS DECAPHV32
XFILLER_1_965 VDD VSS DECAPHV32
XFILLER_17_811 VDD VSS DECAPHV16
XFILLER_1_1114 VSS VDD FILLER2
XTAP_TAPCELL_ROW_9_1_145 VDD VSS WELLTAP
XTAP_TAPCELL_ROW_177_1_258 VDD VSS WELLTAP
XANTENNA_3 hold3/A VDD VSS ANTENNA2
XFILLER_6_32 VDD VSS DECAPHV8
XFILLER_22_313 VSS VDD FILLER2
XFILLER_2_1423 VDD VSS FILLER4
XFILLER_14_825 VDD VSS DECAPHV32
XFILLER_15_96 VDD VSS DECAPHV32
XFILLER_13_346 VDD VSS DECAPHV16
XTAP_TAPCELL_ROW_173_1_220 VDD VSS WELLTAP
XFILLER_5_556 VSS VDD FILLER2
XTAP_TAPCELL_ROW_2_55 VDD VSS WELLTAP
XFILLER_17_641 VDD VSS DECAPHV8
XFILLER_9_840 VDD VSS DECAPHV32
XTAP_TAPCELL_ROW_8_1_133 VDD VSS WELLTAP
XTAP_TAPCELL_ROW_176_1_246 VDD VSS WELLTAP
Xdelaybuf_0_clk clk_pad/p2c VDD VSS delaybuf_1_clk/A BUFX12
XFILLER_19_928 VSS VDD FILLER2
XFILLER_2_1253 VSS VDD FILLER2
XFILLER_18_416 VSS VDD FILLER2
Xg_outputs\[0\].output_pad g_outputs\[0\].output_pad/c2p IOVDD IOVSS output_PAD[0]
+ VDD VSS sg13cmos5l_IOPadOut30mA
XFILLER_13_176 VDD VSS DECAPHV8
XFILLER_5_375 VDD VSS DECAPHV32
XFILLER_3_88 VDD VSS FILLER4
XFILLER_18_950 VDD VSS DECAPHV16
XFILLER_2_323 VSS VDD FILLER2
XFILLER_3_835 VSS VDD FILLER2
XFILLER_19_747 VDD VSS DECAPHV32
XFILLER_4_1348 VSS VDD FILLER2
XFILLER_15_997 VDD VSS DECAPHV16
XFILLER_15_920 VDD VSS DECAPHV8
XFILLER_2_1072 VDD VSS DECAPHV32
XFILLER_18_235 VDD VSS DECAPHV32
XIO_FILL_IO_WEST_4_0 IOVDD IOVSS VDD VSS sg13cmos5l_Filler4000
XFILLER_14_485 VDD VSS DECAPHV16
XFILLER_6_695 VSS VDD FILLER2
XFILLER_18_780 VDD VSS DECAPHV8
XTAP_TAPCELL_ROW_7_1_121 VDD VSS WELLTAP
XFILLER_2_142 VDD VSS DECAPHV32
XFILLER_3_0 VDD VSS DECAPHV32
XFILLER_3_654 VDD VSS DECAPHV32
XFILLER_19_500 VDD VSS DECAPHV32
XFILLER_4_1123 VSS VDD FILLER2
XFILLER_9_87 VDD VSS FILLER4
XIO_BOND_rst_n_pad rst_n_PAD sg13cmos5l_ip__bondpad_70x70
XFILLER_21_742 VSS VDD FILLER2
XFILLER_20_230 VSS VDD FILLER2
XTAP_TAPCELL_ROW_180_1_308 VDD VSS WELLTAP
Xcut_vdd_s IOVDD IOVSS VSS sg13cmos5l_ip__cut_vdd
XFILLER_16_514 VDD VSS DECAPHV32
XFILLER_7_278 VDD VSS FILLER1
XTAP_TAPCELL_ROW_174_1_233 VDD VSS WELLTAP
XFILLER_0_1340 VDD VSS DECAPHV8
XFILLER_21_561 VDD VSS DECAPHV32
XTAP_TAPCELL_ROW_5_1_311 VDD VSS WELLTAP
XFILLER_4_215 VDD VSS DECAPHV8
XFILLER_0_498 VDD VSS DECAPHV32
XFILLER_1_933 VDD VSS DECAPHV32
XFILLER_21_1021 VDD VSS FILLER1
XFILLER_16_344 VDD VSS FILLER1
XTAP_TAPCELL_ROW_9_1_146 VDD VSS WELLTAP
XFILLER_12_583 VSS VDD FILLER2
XTAP_TAPCELL_ROW_177_1_259 VDD VSS WELLTAP
XFILLER_6_44 VSS VDD FILLER2
XFILLER_19_160 VDD VSS DECAPHV16
XFILLER_22_358 VSS VDD FILLER2
XFILLER_12_1009 VDD VSS DECAPHV8
XFILLER_15_64 VDD VSS DECAPHV16
XFILLER_13_314 VDD VSS DECAPHV32
XTAP_TAPCELL_ROW_173_1_221 VDD VSS WELLTAP
XTAP_TAPCELL_ROW_2_56 VDD VSS WELLTAP
XFILLER_0_273 VDD VSS DECAPHV32
XFILLER_17_686 VDD VSS DECAPHV32
XFILLER_16_174 VDD VSS DECAPHV32
XIO_FILL_IO_EAST_2_0 IOVDD IOVSS VDDA VSS sg13cmos5l_Filler4000
.ends
