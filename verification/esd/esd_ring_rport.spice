* esd_ring_rport: Kron-reduced pad-ring resistance, scripts/esd/pex.py
.subckt esd_ring_rport cls_clamp clv_clamp iovdd_adcconv iovdd_ana0 iovdd_ana1 iovdd_bidir0 iovdd_bidir1 iovdd_clamp iovdd_clk iovdd_datain iovdd_iovdd_w5 iovdd_iovss_w4 iovdd_miso iovdd_mosi iovdd_rstn iovdd_sclk iovdd_ss iovdd_tst0 iovdd_tst1 iovdd_tst10 iovdd_tst11 iovdd_tst12 iovdd_tst13 iovdd_tst14 iovdd_tst15 iovdd_tst2 iovdd_tst3 iovdd_tst4 iovdd_tst5 iovdd_tst6 iovdd_tst7 iovdd_tst8 iovdd_tst9 iovdd_vdd_w3 iovdd_vss_w2 iovss_adcconv iovss_ana0 iovss_ana1 iovss_bidir0 iovss_bidir1 iovss_clamp iovss_clk iovss_datain iovss_iovdd_w5 iovss_iovss_w4 iovss_miso iovss_mosi iovss_rstn iovss_sclk iovss_ss iovss_tst0 iovss_tst1 iovss_tst10 iovss_tst11 iovss_tst12 iovss_tst13 iovss_tst14 iovss_tst15 iovss_tst2 iovss_tst3 iovss_tst4 iovss_tst5 iovss_tst6 iovss_tst7 iovss_tst8 iovss_tst9 iovss_vdd_w3 iovss_vss_w2 pad_adcconv pad_ana0 pad_ana1 pad_bidir0 pad_bidir1 pad_clk pad_datain pad_iovdd_w5 pad_iovss_w4 pad_miso pad_mosi pad_rstn pad_sclk pad_ss pad_tst0 pad_tst1 pad_tst10 pad_tst11 pad_tst12 pad_tst13 pad_tst14 pad_tst15 pad_tst2 pad_tst3 pad_tst4 pad_tst5 pad_tst6 pad_tst7 pad_tst8 pad_tst9 pad_vdd_w3 pad_vss_w2 padc_adcconv padc_ana0 padc_ana1 padc_bidir0 padc_bidir1 padc_clk padc_datain padc_iovdd_w5 padc_iovss_w4 padc_miso padc_mosi padc_rstn padc_sclk padc_ss padc_tst0 padc_tst1 padc_tst10 padc_tst11 padc_tst12 padc_tst13 padc_tst14 padc_tst15 padc_tst2 padc_tst3 padc_tst4 padc_tst5 padc_tst6 padc_tst7 padc_tst8 padc_tst9 padc_vdd_w3 padc_vss_w2 vdd_adcconv vdd_ana0 vdd_ana1 vdd_bidir0 vdd_bidir1 vdd_clamp vdd_clk vdd_datain vdd_iovdd_w5 vdd_iovss_w4 vdd_miso vdd_mosi vdd_rstn vdd_sclk vdd_ss vdd_tst0 vdd_tst1 vdd_tst10 vdd_tst11 vdd_tst12 vdd_tst13 vdd_tst14 vdd_tst15 vdd_tst2 vdd_tst3 vdd_tst4 vdd_tst5 vdd_tst6 vdd_tst7 vdd_tst8 vdd_tst9 vdd_vdd_w3 vdd_vss_w2 vddring_0 vddring_1 vddring_2 vddring_3 vddring_4 vddring_5 vddring_6 vddring_7 vss_adcconv vss_ana0 vss_ana1 vss_bidir0 vss_bidir1 vss_clamp vss_clk vss_datain vss_iovdd_w5 vss_iovss_w4 vss_miso vss_mosi vss_rstn vss_sclk vss_ss vss_tst0 vss_tst1 vss_tst10 vss_tst11 vss_tst12 vss_tst13 vss_tst14 vss_tst15 vss_tst2 vss_tst3 vss_tst4 vss_tst5 vss_tst6 vss_tst7 vss_tst8 vss_tst9 vss_vdd_w3 vss_vss_w2 vssring_0 vssring_1 vssring_2 vssring_3 vssring_4 vssring_5 vssring_6 vssring_7
R0 cls_clamp pad_vss_w2 18.2344
R1 cls_clamp vss_clamp 0.381894
R2 cls_clamp vss_iovdd_w5 186835
R3 cls_clamp vss_iovss_w4 978.378
R4 cls_clamp vss_miso 169.899
R5 cls_clamp vss_tst4 206161
R6 cls_clamp vss_vdd_w3 1.27675
R7 cls_clamp vss_vss_w2 1.34227
R8 clv_clamp pad_vdd_w3 8.83878
R9 clv_clamp vdd_clamp 0.332216
R10 clv_clamp vdd_datain 10558.5
R11 clv_clamp vdd_iovdd_w5 328.566
R12 clv_clamp vdd_iovss_w4 41.5547
R13 clv_clamp vdd_miso 5514.15
R14 clv_clamp vdd_rstn 328671
R15 clv_clamp vdd_vdd_w3 2.83583
R16 clv_clamp vdd_vss_w2 2.37163
R17 clv_clamp vddring_0 15.421
R18 clv_clamp vddring_1 1561.15
R19 clv_clamp vddring_4 167289
R20 iovdd_adcconv iovdd_clk 25913.1
R21 iovdd_adcconv iovdd_mosi 430.288
R22 iovdd_adcconv iovdd_rstn 240529
R23 iovdd_adcconv iovdd_sclk 3280.12
R24 iovdd_adcconv iovdd_ss 0.0281847
R25 iovdd_adcconv iovdd_tst0 0.0281767
R26 iovdd_adcconv iovdd_tst1 259.681
R27 iovdd_adcconv iovdd_tst15 330298
R28 iovdd_adcconv iovdd_tst2 3365.16
R29 iovdd_adcconv iovdd_tst3 24175.8
R30 iovdd_ana0 iovdd_ana1 0.0281792
R31 iovdd_ana0 iovdd_bidir0 175.623
R32 iovdd_ana0 iovdd_bidir1 3195.53
R33 iovdd_ana0 iovdd_tst10 627.034
R34 iovdd_ana0 iovdd_tst11 0.0766195
R35 iovdd_ana0 iovdd_tst12 23777.3
R36 iovdd_ana0 iovdd_tst13 182216
R37 iovdd_ana0 iovdd_tst7 426486
R38 iovdd_ana0 iovdd_tst8 55652
R39 iovdd_ana0 iovdd_tst9 7256.92
R40 iovdd_ana1 iovdd_bidir0 0.0281797
R41 iovdd_ana1 iovdd_bidir1 253.515
R42 iovdd_ana1 iovdd_tst10 4976.12
R43 iovdd_ana1 iovdd_tst11 316.946
R44 iovdd_ana1 iovdd_tst12 3131.33
R45 iovdd_ana1 iovdd_tst13 24018
R46 iovdd_ana1 iovdd_tst14 184063
R47 iovdd_ana1 iovdd_tst8 292509
R48 iovdd_ana1 iovdd_tst9 38169.4
R49 iovdd_bidir0 iovdd_bidir1 0.0281766
R50 iovdd_bidir0 iovdd_tst10 37356.5
R51 iovdd_bidir0 iovdd_tst11 3751.21
R52 iovdd_bidir0 iovdd_tst12 254.664
R53 iovdd_bidir0 iovdd_tst13 3256.64
R54 iovdd_bidir0 iovdd_tst14 24980.3
R55 iovdd_bidir0 iovdd_tst15 179292
R56 iovdd_bidir0 iovdd_tst9 286280
R57 iovdd_bidir1 iovdd_tst10 276218
R58 iovdd_bidir1 iovdd_tst11 27784.2
R59 iovdd_bidir1 iovdd_tst12 0.0281767
R60 iovdd_bidir1 iovdd_tst13 260.019
R61 iovdd_bidir1 iovdd_tst14 3372.57
R62 iovdd_bidir1 iovdd_tst15 24229.1
R63 iovdd_bidir1 iovdd_tst3 331027
R64 iovdd_clamp iovdd_miso 286.196
R65 iovdd_clamp iovdd_tst4 4059.99
R66 iovdd_clamp iovdd_tst5 6166.98
R67 iovdd_clamp iovdd_tst6 47260.2
R68 iovdd_clamp iovdd_tst7 362176
R69 iovdd_clamp iovdd_vdd_w3 0.0580874
R70 iovdd_clamp iovdd_vss_w2 0.015566
R71 iovdd_clk iovdd_datain 346.301
R72 iovdd_clk iovdd_iovdd_w5 2410.7
R73 iovdd_clk iovdd_iovss_w4 15937.7
R74 iovdd_clk iovdd_mosi 458.255
R75 iovdd_clk iovdd_rstn 0.0246622
R76 iovdd_clk iovdd_sclk 0.0713057
R77 iovdd_clk iovdd_ss 3436.35
R78 iovdd_clk iovdd_tst0 198583
R79 iovdd_clk iovdd_vdd_w3 122100
R80 iovdd_clk padc_iovdd_w5 55528
R81 iovdd_datain iovdd_iovdd_w5 0.0272926
R82 iovdd_datain iovdd_iovss_w4 198.656
R83 iovdd_datain iovdd_mosi 28825.2
R84 iovdd_datain iovdd_rstn 0.0246632
R85 iovdd_datain iovdd_sclk 5617.43
R86 iovdd_datain iovdd_ss 216154
R87 iovdd_datain iovdd_vdd_w3 2940.69
R88 iovdd_datain padc_iovdd_w5 0.28771
R89 iovdd_iovdd_w5 iovdd_iovss_w4 0.0273178
R90 iovdd_iovdd_w5 iovdd_mosi 200661
R91 iovdd_iovdd_w5 iovdd_rstn 387.81
R92 iovdd_iovdd_w5 iovdd_sclk 39104.7
R93 iovdd_iovdd_w5 iovdd_vdd_w3 433.255
R94 iovdd_iovdd_w5 padc_iovdd_w5 0.0264144
R95 iovdd_iovss_w4 iovdd_rstn 2563.9
R96 iovdd_iovss_w4 iovdd_sclk 258530
R97 iovdd_iovss_w4 iovdd_vdd_w3 0.0722368
R98 iovdd_iovss_w4 padc_iovdd_w5 0.287813
R99 iovdd_miso iovdd_tst4 0.0713548
R100 iovdd_miso iovdd_tst5 622.171
R101 iovdd_miso iovdd_tst6 7428.05
R102 iovdd_miso iovdd_tst7 56968.2
R103 iovdd_miso iovdd_tst8 436572
R104 iovdd_miso iovdd_vss_w2 0.0246549
R105 iovdd_mosi iovdd_rstn 4253.59
R106 iovdd_mosi iovdd_sclk 0.0281697
R107 iovdd_mosi iovdd_ss 0.0281694
R108 iovdd_mosi iovdd_tst0 3297.49
R109 iovdd_mosi iovdd_tst1 25270.1
R110 iovdd_mosi iovdd_tst2 193658
R111 iovdd_rstn iovdd_sclk 828.934
R112 iovdd_rstn iovdd_ss 31896.7
R113 iovdd_rstn iovdd_vdd_w3 19642.3
R114 iovdd_rstn padc_iovdd_w5 8932.79
R115 iovdd_sclk iovdd_ss 434.978
R116 iovdd_sclk iovdd_tst0 25137
R117 iovdd_sclk iovdd_tst1 192636
R118 iovdd_sclk padc_iovdd_w5 900734
R119 iovdd_ss iovdd_tst0 259.951
R120 iovdd_ss iovdd_tst1 3368.33
R121 iovdd_ss iovdd_tst2 25837.9
R122 iovdd_ss iovdd_tst3 185447
R123 iovdd_tst0 iovdd_tst1 0.0281767
R124 iovdd_tst0 iovdd_tst14 901664
R125 iovdd_tst0 iovdd_tst15 43091
R126 iovdd_tst0 iovdd_tst2 259.649
R127 iovdd_tst0 iovdd_tst3 3151.19
R128 iovdd_tst1 iovdd_tst13 901666
R129 iovdd_tst1 iovdd_tst14 117657
R130 iovdd_tst1 iovdd_tst15 5619.85
R131 iovdd_tst1 iovdd_tst2 0.0281767
R132 iovdd_tst1 iovdd_tst3 249.645
R133 iovdd_tst10 iovdd_tst11 0.0281748
R134 iovdd_tst10 iovdd_tst5 196771
R135 iovdd_tst10 iovdd_tst6 25800.9
R136 iovdd_tst10 iovdd_tst7 3363.83
R137 iovdd_tst10 iovdd_tst8 259.622
R138 iovdd_tst10 iovdd_tst9 0.0281767
R139 iovdd_tst11 iovdd_tst12 206331
R140 iovdd_tst11 iovdd_tst6 183976
R141 iovdd_tst11 iovdd_tst7 24008.9
R142 iovdd_tst11 iovdd_tst8 3130.15
R143 iovdd_tst11 iovdd_tst9 248.632
R144 iovdd_tst12 iovdd_tst13 0.0281767
R145 iovdd_tst12 iovdd_tst14 259.706
R146 iovdd_tst12 iovdd_tst15 3152.36
R147 iovdd_tst12 iovdd_tst2 902001
R148 iovdd_tst12 iovdd_tst3 43107.1
R149 iovdd_tst13 iovdd_tst14 0.0281767
R150 iovdd_tst13 iovdd_tst15 249.646
R151 iovdd_tst13 iovdd_tst2 117658
R152 iovdd_tst13 iovdd_tst3 5619.88
R153 iovdd_tst14 iovdd_tst15 0.0281749
R154 iovdd_tst14 iovdd_tst2 15332.9
R155 iovdd_tst14 iovdd_tst3 525.606
R156 iovdd_tst15 iovdd_tst2 525.606
R157 iovdd_tst15 iovdd_tst3 0.0766057
R158 iovdd_tst2 iovdd_tst3 0.0281749
R159 iovdd_tst4 iovdd_tst5 0.028176
R160 iovdd_tst4 iovdd_tst6 260.724
R161 iovdd_tst4 iovdd_tst7 3388.32
R162 iovdd_tst4 iovdd_tst8 25991.1
R163 iovdd_tst4 iovdd_tst9 199181
R164 iovdd_tst4 iovdd_vss_w2 537.785
R165 iovdd_tst5 iovdd_tst6 0.0281766
R166 iovdd_tst5 iovdd_tst7 258.892
R167 iovdd_tst5 iovdd_tst8 3347.88
R168 iovdd_tst5 iovdd_tst9 25680.5
R169 iovdd_tst5 iovdd_vss_w2 1265.8
R170 iovdd_tst6 iovdd_tst7 0.0281767
R171 iovdd_tst6 iovdd_tst8 259.633
R172 iovdd_tst6 iovdd_tst9 3364.07
R173 iovdd_tst6 iovdd_vss_w2 9701.67
R174 iovdd_tst7 iovdd_tst8 0.0281767
R175 iovdd_tst7 iovdd_tst9 259.646
R176 iovdd_tst7 iovdd_vss_w2 74348.2
R177 iovdd_tst8 iovdd_tst9 0.0281767
R178 iovdd_tst8 iovdd_vss_w2 569763
R179 iovdd_vdd_w3 padc_iovdd_w5 8495.89
R180 iovss_adcconv iovss_ana0 10856.4
R181 iovss_adcconv iovss_ana1 5644.17
R182 iovss_adcconv iovss_bidir0 2610.02
R183 iovss_adcconv iovss_bidir1 1185.7
R184 iovss_adcconv iovss_clamp 15968
R185 iovss_adcconv iovss_clk 40.9696
R186 iovss_adcconv iovss_datain 166.08
R187 iovss_adcconv iovss_iovdd_w5 876.969
R188 iovss_adcconv iovss_iovss_w4 1027.75
R189 iovss_adcconv iovss_mosi 3.13389
R190 iovss_adcconv iovss_rstn 80.483
R191 iovss_adcconv iovss_sclk 8.22427
R192 iovss_adcconv iovss_ss 0.0214193
R193 iovss_adcconv iovss_tst0 0.0214083
R194 iovss_adcconv iovss_tst1 2.96312
R195 iovss_adcconv iovss_tst10 84197
R196 iovss_adcconv iovss_tst11 45739.9
R197 iovss_adcconv iovss_tst12 534.293
R198 iovss_adcconv iovss_tst13 236.863
R199 iovss_adcconv iovss_tst14 99.9155
R200 iovss_adcconv iovss_tst15 87.5338
R201 iovss_adcconv iovss_tst2 7.86887
R202 iovss_adcconv iovss_tst3 20.1068
R203 iovss_adcconv iovss_tst7 932715
R204 iovss_adcconv iovss_tst8 422397
R205 iovss_adcconv iovss_tst9 190237
R206 iovss_adcconv iovss_vdd_w3 8514.94
R207 iovss_adcconv pad_iovss_w4 550591
R208 iovss_ana0 iovss_ana1 0.0213486
R209 iovss_ana0 iovss_bidir0 2.6372
R210 iovss_ana0 iovss_bidir1 7.28668
R211 iovss_ana0 iovss_clk 565054
R212 iovss_ana0 iovss_miso 1475.23
R213 iovss_ana0 iovss_mosi 57209.6
R214 iovss_ana0 iovss_sclk 121607
R215 iovss_ana0 iovss_ss 24806.8
R216 iovss_ana0 iovss_tst0 4984.01
R217 iovss_ana0 iovss_tst1 2216.66
R218 iovss_ana0 iovss_tst10 4.13346
R219 iovss_ana0 iovss_tst11 0.072763
R220 iovss_ana0 iovss_tst12 17.3041
R221 iovss_ana0 iovss_tst13 38.7588
R222 iovss_ana0 iovss_tst14 81.8482
R223 iovss_ana0 iovss_tst15 193.815
R224 iovss_ana0 iovss_tst2 942.089
R225 iovss_ana0 iovss_tst3 834.206
R226 iovss_ana0 iovss_tst4 542.842
R227 iovss_ana0 iovss_tst5 281.822
R228 iovss_ana0 iovss_tst6 129.459
R229 iovss_ana0 iovss_tst7 58.5141
R230 iovss_ana0 iovss_tst8 25.9946
R231 iovss_ana0 iovss_tst9 11.0383
R232 iovss_ana0 iovss_vss_w2 4322.6
R233 iovss_ana1 iovss_bidir0 0.0214106
R234 iovss_ana1 iovss_bidir1 2.99257
R235 iovss_ana1 iovss_clk 293769
R236 iovss_ana1 iovss_miso 3610.43
R237 iovss_ana1 iovss_mosi 29743
R238 iovss_ana1 iovss_rstn 564457
R239 iovss_ana1 iovss_sclk 63223.2
R240 iovss_ana1 iovss_ss 12896.9
R241 iovss_ana1 iovss_tst0 2591.1
R242 iovss_ana1 iovss_tst1 1152.34
R243 iovss_ana1 iovss_tst10 12.0247
R244 iovss_ana1 iovss_tst11 5.24018
R245 iovss_ana1 iovss_tst12 8.29242
R246 iovss_ana1 iovss_tst13 19.6301
R247 iovss_ana1 iovss_tst14 42.2223
R248 iovss_ana1 iovss_tst15 100.514
R249 iovss_ana1 iovss_tst2 489.671
R250 iovss_ana1 iovss_tst3 433.557
R251 iovss_ana1 iovss_tst4 1328.72
R252 iovss_ana1 iovss_tst5 690.117
R253 iovss_ana1 iovss_tst6 317.445
R254 iovss_ana1 iovss_tst7 144.096
R255 iovss_ana1 iovss_tst8 64.8778
R256 iovss_ana1 iovss_tst9 28.6929
R257 iovss_ana1 iovss_vss_w2 10578.6
R258 iovss_bidir0 iovss_bidir1 0.0214127
R259 iovss_bidir0 iovss_clk 135850
R260 iovss_bidir0 iovss_datain 535996
R261 iovss_bidir0 iovss_miso 7943.1
R262 iovss_bidir0 iovss_mosi 13754.3
R263 iovss_bidir0 iovss_rstn 261027
R264 iovss_bidir0 iovss_sclk 29236.8
R265 iovss_bidir0 iovss_ss 5964
R266 iovss_bidir0 iovss_tst0 1198.13
R267 iovss_bidir0 iovss_tst1 532.752
R268 iovss_bidir0 iovss_tst10 27.9571
R269 iovss_bidir0 iovss_tst11 14.0933
R270 iovss_bidir0 iovss_tst12 3.03192
R271 iovss_bidir0 iovss_tst13 8.37469
R272 iovss_bidir0 iovss_tst14 19.0487
R273 iovss_bidir0 iovss_tst15 46.1162
R274 iovss_bidir0 iovss_tst2 226.271
R275 iovss_bidir0 iovss_tst3 200.282
R276 iovss_bidir0 iovss_tst4 2923.37
R277 iovss_bidir0 iovss_tst5 1518.54
R278 iovss_bidir0 iovss_tst6 698.789
R279 iovss_bidir0 iovss_tst7 317.597
R280 iovss_bidir0 iovss_tst8 143.566
R281 iovss_bidir0 iovss_tst9 64.2876
R282 iovss_bidir0 iovss_vss_w2 23273.2
R283 iovss_bidir1 iovss_clk 61720
R284 iovss_bidir1 iovss_datain 243516
R285 iovss_bidir1 iovss_miso 17508
R286 iovss_bidir1 iovss_mosi 6248.87
R287 iovss_bidir1 iovss_rstn 118591
R288 iovss_bidir1 iovss_sclk 13283
R289 iovss_bidir1 iovss_ss 2709.52
R290 iovss_bidir1 iovss_tst0 544.2
R291 iovss_bidir1 iovss_tst1 241.848
R292 iovss_bidir1 iovss_tst10 62.7274
R293 iovss_bidir1 iovss_tst11 33.2602
R294 iovss_bidir1 iovss_tst12 0.0214132
R295 iovss_bidir1 iovss_tst13 3.02083
R296 iovss_bidir1 iovss_tst14 8.02428
R297 iovss_bidir1 iovss_tst15 20.4393
R298 iovss_bidir1 iovss_tst2 102.554
R299 iovss_bidir1 iovss_tst3 90.6912
R300 iovss_bidir1 iovss_tst4 6443.72
R301 iovss_bidir1 iovss_tst5 3347.32
R302 iovss_bidir1 iovss_tst6 1540.53
R303 iovss_bidir1 iovss_tst7 700.444
R304 iovss_bidir1 iovss_tst8 317.025
R305 iovss_bidir1 iovss_tst9 142.521
R306 iovss_bidir1 iovss_vss_w2 51298.2
R307 iovss_clamp iovss_clk 297.946
R308 iovss_clamp iovss_datain 29.9135
R309 iovss_clamp iovss_iovdd_w5 14.5618
R310 iovss_clamp iovss_iovss_w4 1.99876
R311 iovss_clamp iovss_mosi 2594.54
R312 iovss_clamp iovss_rstn 106.266
R313 iovss_clamp iovss_sclk 915.661
R314 iovss_clamp iovss_ss 6518.61
R315 iovss_clamp iovss_tst0 36818.5
R316 iovss_clamp iovss_tst1 81327.4
R317 iovss_clamp iovss_tst2 172522
R318 iovss_clamp iovss_tst3 410336
R319 iovss_clamp iovss_vdd_w3 0.0399217
R320 iovss_clamp iovss_vss_w2 0.0118331
R321 iovss_clamp pad_iovss_w4 813.173
R322 iovss_clk iovss_datain 2.56912
R323 iovss_clk iovss_iovdd_w5 15.7322
R324 iovss_clk iovss_iovss_w4 19.0532
R325 iovss_clk iovss_mosi 5.3683
R326 iovss_clk iovss_rstn 0.019412
R327 iovss_clk iovss_sclk 0.0700994
R328 iovss_clk iovss_ss 15.8013
R329 iovss_clk iovss_tst0 96.3411
R330 iovss_clk iovss_tst1 214.162
R331 iovss_clk iovss_tst12 27818.7
R332 iovss_clk iovss_tst13 12341.9
R333 iovss_clk iovss_tst14 5217.51
R334 iovss_clk iovss_tst15 4576.51
R335 iovss_clk iovss_tst2 455.201
R336 iovss_clk iovss_tst3 1083.29
R337 iovss_clk iovss_vdd_w3 158.699
R338 iovss_clk pad_iovss_w4 10211.3
R339 iovss_datain iovss_iovdd_w5 0.0462346
R340 iovss_datain iovss_iovss_w4 1.83037
R341 iovss_datain iovss_mosi 26.5958
R342 iovss_datain iovss_rstn 0.0193385
R343 iovss_datain iovss_sclk 9.06782
R344 iovss_datain iovss_ss 67.558
R345 iovss_datain iovss_tst0 383.398
R346 iovss_datain iovss_tst1 847.198
R347 iovss_datain iovss_tst12 109759
R348 iovss_datain iovss_tst13 48695.1
R349 iovss_datain iovss_tst14 20586.1
R350 iovss_datain iovss_tst15 18057.2
R351 iovss_datain iovss_tst2 1797.39
R352 iovss_datain iovss_tst3 4275.16
R353 iovss_datain iovss_vdd_w3 15.8393
R354 iovss_datain pad_iovss_w4 817.617
R355 iovss_iovdd_w5 iovss_iovss_w4 0.0464353
R356 iovss_iovdd_w5 iovss_mosi 142.088
R357 iovss_iovdd_w5 iovss_rstn 5.28743
R358 iovss_iovdd_w5 iovss_sclk 49.8015
R359 iovss_iovdd_w5 iovss_ss 357.757
R360 iovss_iovdd_w5 iovss_tst0 2022.55
R361 iovss_iovdd_w5 iovss_tst1 4467.9
R362 iovss_iovdd_w5 iovss_tst12 578760
R363 iovss_iovdd_w5 iovss_tst13 256771
R364 iovss_iovdd_w5 iovss_tst14 108551
R365 iovss_iovdd_w5 iovss_tst15 95216.1
R366 iovss_iovdd_w5 iovss_tst2 9478.06
R367 iovss_iovdd_w5 iovss_tst3 22543.3
R368 iovss_iovdd_w5 iovss_vdd_w3 6.56909
R369 iovss_iovdd_w5 pad_iovss_w4 2.47955
R370 iovss_iovss_w4 iovss_mosi 166.915
R371 iovss_iovss_w4 iovss_rstn 6.7268
R372 iovss_iovss_w4 iovss_sclk 58.8417
R373 iovss_iovss_w4 iovss_ss 419.511
R374 iovss_iovss_w4 iovss_tst0 2369.84
R375 iovss_iovss_w4 iovss_tst1 5234.74
R376 iovss_iovss_w4 iovss_tst12 678076
R377 iovss_iovss_w4 iovss_tst13 300833
R378 iovss_iovss_w4 iovss_tst14 127179
R379 iovss_iovss_w4 iovss_tst15 111555
R380 iovss_iovss_w4 iovss_tst2 11104.6
R381 iovss_iovss_w4 iovss_tst3 26411.9
R382 iovss_iovss_w4 iovss_vdd_w3 0.0459351
R383 iovss_iovss_w4 pad_iovss_w4 0.0967015
R384 iovss_miso iovss_tst10 227.304
R385 iovss_miso iovss_tst11 522.25
R386 iovss_miso iovss_tst12 38519.1
R387 iovss_miso iovss_tst13 84155.6
R388 iovss_miso iovss_tst14 176307
R389 iovss_miso iovss_tst15 416542
R390 iovss_miso iovss_tst4 0.0695636
R391 iovss_miso iovss_tst5 3.58552
R392 iovss_miso iovss_tst6 9.31971
R393 iovss_miso iovss_tst7 21.7193
R394 iovss_miso iovss_tst8 48.6884
R395 iovss_miso iovss_tst9 107.185
R396 iovss_miso iovss_vss_w2 0.0192936
R397 iovss_mosi iovss_rstn 12.3827
R398 iovss_mosi iovss_sclk 0.0213476
R399 iovss_mosi iovss_ss 0.0214077
R400 iovss_mosi iovss_tst0 8.83706
R401 iovss_mosi iovss_tst1 21.0147
R402 iovss_mosi iovss_tst10 443688
R403 iovss_mosi iovss_tst11 241033
R404 iovss_mosi iovss_tst12 2816.45
R405 iovss_mosi iovss_tst13 1249.45
R406 iovss_mosi iovss_tst14 528.104
R407 iovss_mosi iovss_tst15 463.175
R408 iovss_mosi iovss_tst2 45.6572
R409 iovss_mosi iovss_tst3 109.351
R410 iovss_mosi iovss_vdd_w3 1383.43
R411 iovss_mosi pad_iovss_w4 89423.4
R412 iovss_rstn iovss_sclk 3.87019
R413 iovss_rstn iovss_ss 32.4129
R414 iovss_rstn iovss_tst0 186.423
R415 iovss_rstn iovss_tst1 412.385
R416 iovss_rstn iovss_tst12 53451.7
R417 iovss_rstn iovss_tst13 23714.2
R418 iovss_rstn iovss_tst14 10025.3
R419 iovss_rstn iovss_tst15 8793.68
R420 iovss_rstn iovss_tst2 875.195
R421 iovss_rstn iovss_tst3 2081.89
R422 iovss_rstn iovss_vdd_w3 56.4993
R423 iovss_rstn pad_iovss_w4 3607.3
R424 iovss_sclk iovss_ss 2.81417
R425 iovss_sclk iovss_tst0 20.2652
R426 iovss_sclk iovss_tst1 45.766
R427 iovss_sclk iovss_tst10 943123
R428 iovss_sclk iovss_tst11 512351
R429 iovss_sclk iovss_tst12 5986.92
R430 iovss_sclk iovss_tst13 2656.08
R431 iovss_sclk iovss_tst14 1122.81
R432 iovss_sclk iovss_tst15 984.843
R433 iovss_sclk iovss_tst2 97.7601
R434 iovss_sclk iovss_tst3 232.983
R435 iovss_sclk iovss_vdd_w3 488.141
R436 iovss_sclk pad_iovss_w4 31526
R437 iovss_ss iovss_tst0 3.05887
R438 iovss_ss iovss_tst1 8.43659
R439 iovss_ss iovss_tst10 192389
R440 iovss_ss iovss_tst11 104515
R441 iovss_ss iovss_tst12 1221.15
R442 iovss_ss iovss_tst13 541.645
R443 iovss_ss iovss_tst14 228.826
R444 iovss_ss iovss_tst15 200.638
R445 iovss_ss iovss_tst2 19.3304
R446 iovss_ss iovss_tst3 47.0532
R447 iovss_ss iovss_tst8 965171
R448 iovss_ss iovss_tst9 434690
R449 iovss_ss iovss_vdd_w3 3475.99
R450 iovss_ss pad_iovss_w4 224744
R451 iovss_tst0 iovss_tst1 0.021409
R452 iovss_tst0 iovss_tst10 38653.8
R453 iovss_tst0 iovss_tst11 20998.6
R454 iovss_tst0 iovss_tst12 245.087
R455 iovss_tst0 iovss_tst13 108.465
R456 iovss_tst0 iovss_tst14 45.5251
R457 iovss_tst0 iovss_tst15 39.7723
R458 iovss_tst0 iovss_tst2 2.90041
R459 iovss_tst0 iovss_tst3 8.55013
R460 iovss_tst0 iovss_tst6 941590
R461 iovss_tst0 iovss_tst7 428198
R462 iovss_tst0 iovss_tst8 193917
R463 iovss_tst0 iovss_tst9 87335.6
R464 iovss_tst0 iovss_vdd_w3 19633.6
R465 iovss_tst1 iovss_tst10 17191.8
R466 iovss_tst1 iovss_tst11 9339.36
R467 iovss_tst1 iovss_tst12 108.733
R468 iovss_tst1 iovss_tst13 47.8667
R469 iovss_tst1 iovss_tst14 19.788
R470 iovss_tst1 iovss_tst15 17.1427
R471 iovss_tst1 iovss_tst2 0.0213961
R472 iovss_tst1 iovss_tst3 3.06623
R473 iovss_tst1 iovss_tst5 909900
R474 iovss_tst1 iovss_tst6 418786
R475 iovss_tst1 iovss_tst7 190447
R476 iovss_tst1 iovss_tst8 86247.4
R477 iovss_tst1 iovss_tst9 38843.7
R478 iovss_tst1 iovss_vdd_w3 43368.3
R479 iovss_tst10 iovss_tst11 0.0214098
R480 iovss_tst10 iovss_tst12 138.787
R481 iovss_tst10 iovss_tst13 303.761
R482 iovss_tst10 iovss_tst14 636.746
R483 iovss_tst10 iovss_tst15 1504.61
R484 iovss_tst10 iovss_tst2 7307.05
R485 iovss_tst10 iovss_tst3 6470.52
R486 iovss_tst10 iovss_tst4 83.438
R487 iovss_tst10 iovss_tst5 42.9943
R488 iovss_tst10 iovss_tst6 19.2918
R489 iovss_tst10 iovss_tst7 8.11584
R490 iovss_tst10 iovss_tst8 2.93649
R491 iovss_tst10 iovss_tst9 0.0214003
R492 iovss_tst10 iovss_vss_w2 666.458
R493 iovss_tst11 iovss_tst12 74.8212
R494 iovss_tst11 iovss_tst13 164.626
R495 iovss_tst11 iovss_tst14 345.668
R496 iovss_tst11 iovss_tst15 817.196
R497 iovss_tst11 iovss_tst2 3969.46
R498 iovss_tst11 iovss_tst3 3515
R499 iovss_tst11 iovss_tst4 192.048
R500 iovss_tst11 iovss_tst5 99.5043
R501 iovss_tst11 iovss_tst6 45.421
R502 iovss_tst11 iovss_tst7 20.1267
R503 iovss_tst11 iovss_tst8 8.41994
R504 iovss_tst11 iovss_tst9 3.02341
R505 iovss_tst11 iovss_vss_w2 1530.52
R506 iovss_tst12 iovss_tst13 0.0214111
R507 iovss_tst12 iovss_tst14 2.90934
R508 iovss_tst12 iovss_tst15 8.54303
R509 iovss_tst12 iovss_tst2 45.8767
R510 iovss_tst12 iovss_tst3 40.4523
R511 iovss_tst12 iovss_tst4 14176.8
R512 iovss_tst12 iovss_tst5 7364.5
R513 iovss_tst12 iovss_tst6 3389.49
R514 iovss_tst12 iovss_tst7 1541.32
R515 iovss_tst12 iovss_tst8 697.885
R516 iovss_tst12 iovss_tst9 314.131
R517 iovss_tst12 iovss_vss_w2 112860
R518 iovss_tst13 iovss_tst14 0.0213968
R519 iovss_tst13 iovss_tst15 3.06065
R520 iovss_tst13 iovss_tst2 19.8893
R521 iovss_tst13 iovss_tst3 17.3839
R522 iovss_tst13 iovss_tst4 30973.1
R523 iovss_tst13 iovss_tst5 16089.9
R524 iovss_tst13 iovss_tst6 7405.4
R525 iovss_tst13 iovss_tst7 3367.63
R526 iovss_tst13 iovss_tst8 1525
R527 iovss_tst13 iovss_tst9 686.702
R528 iovss_tst13 iovss_vss_w2 246574
R529 iovss_tst14 iovss_tst15 0.0214147
R530 iovss_tst14 iovss_tst2 7.87965
R531 iovss_tst14 iovss_tst3 6.70405
R532 iovss_tst14 iovss_tst4 64889.2
R533 iovss_tst14 iovss_tst5 33708.6
R534 iovss_tst14 iovss_tst6 15514.5
R535 iovss_tst14 iovss_tst7 7055.36
R536 iovss_tst14 iovss_tst8 3195.09
R537 iovss_tst14 iovss_tst9 1438.92
R538 iovss_tst14 iovss_vss_w2 516576
R539 iovss_tst15 iovss_tst2 6.65055
R540 iovss_tst15 iovss_tst3 0.0722649
R541 iovss_tst15 iovss_tst4 153306
R542 iovss_tst15 iovss_tst5 79639.6
R543 iovss_tst15 iovss_tst6 36654.5
R544 iovss_tst15 iovss_tst7 16669
R545 iovss_tst15 iovss_tst8 7548.81
R546 iovss_tst15 iovss_tst9 3399.74
R547 iovss_tst15 iovss_vdd_w3 924200
R548 iovss_tst2 iovss_tst3 0.0214158
R549 iovss_tst2 iovss_tst4 744471
R550 iovss_tst2 iovss_tst5 386738
R551 iovss_tst2 iovss_tst6 177998
R552 iovss_tst2 iovss_tst7 80946.4
R553 iovss_tst2 iovss_tst8 36658
R554 iovss_tst2 iovss_tst9 16509.8
R555 iovss_tst2 iovss_vdd_w3 91998.1
R556 iovss_tst3 iovss_tst4 659244
R557 iovss_tst3 iovss_tst5 342464
R558 iovss_tst3 iovss_tst6 157621
R559 iovss_tst3 iovss_tst7 71679.7
R560 iovss_tst3 iovss_tst8 32461.4
R561 iovss_tst3 iovss_tst9 14619.8
R562 iovss_tst3 iovss_vdd_w3 218814
R563 iovss_tst4 iovss_tst5 0.021351
R564 iovss_tst4 iovss_tst6 2.67425
R565 iovss_tst4 iovss_tst7 7.33836
R566 iovss_tst4 iovss_tst8 17.4298
R567 iovss_tst4 iovss_tst9 39.1069
R568 iovss_tst4 iovss_vss_w2 3.52415
R569 iovss_tst5 iovss_tst6 0.0214093
R570 iovss_tst5 iovss_tst7 3.00485
R571 iovss_tst5 iovss_tst8 8.33816
R572 iovss_tst5 iovss_tst9 19.7816
R573 iovss_tst5 iovss_vss_w2 13.0499
R574 iovss_tst6 iovss_tst7 0.0214128
R575 iovss_tst6 iovss_tst8 3.03411
R576 iovss_tst6 iovss_tst9 8.3955
R577 iovss_tst6 iovss_vss_w2 29.3657
R578 iovss_tst7 iovss_tst8 0.0214133
R579 iovss_tst7 iovss_tst9 3.02563
R580 iovss_tst7 iovss_vss_w2 65.1379
R581 iovss_tst8 iovss_tst9 0.0214117
R582 iovss_tst8 iovss_vss_w2 143.709
R583 iovss_tst9 iovss_vss_w2 314.77
R584 iovss_vdd_w3 pad_iovss_w4 2.90536
R585 pad_adcconv padc_adcconv 0.001
R586 pad_ana0 padc_ana0 0.001
R587 pad_ana1 padc_ana1 0.001
R588 pad_bidir0 padc_bidir0 0.001
R589 pad_bidir1 padc_bidir1 0.001
R590 pad_clk padc_clk 0.001
R591 pad_datain padc_datain 0.001
R592 pad_iovdd_w5 padc_iovdd_w5 0.001
R593 pad_iovss_w4 padc_iovss_w4 0.001
R594 pad_miso padc_miso 0.001
R595 pad_mosi padc_mosi 0.001
R596 pad_rstn padc_rstn 0.001
R597 pad_sclk padc_sclk 0.001
R598 pad_ss padc_ss 0.001
R599 pad_tst0 padc_tst0 0.001
R600 pad_tst1 padc_tst1 0.001
R601 pad_tst10 padc_tst10 0.001
R602 pad_tst11 padc_tst11 0.001
R603 pad_tst12 padc_tst12 0.001
R604 pad_tst13 padc_tst13 0.001
R605 pad_tst14 padc_tst14 0.001
R606 pad_tst15 padc_tst15 0.001
R607 pad_tst2 padc_tst2 0.001
R608 pad_tst3 padc_tst3 0.001
R609 pad_tst4 padc_tst4 0.001
R610 pad_tst5 padc_tst5 0.001
R611 pad_tst6 padc_tst6 0.001
R612 pad_tst7 padc_tst7 0.001
R613 pad_tst8 padc_tst8 0.001
R614 pad_tst9 padc_tst9 0.001
R615 pad_vdd_w3 padc_vdd_w3 0.001
R616 pad_vdd_w3 vdd_clamp 1.53594
R617 pad_vdd_w3 vdd_clk 111172
R618 pad_vdd_w3 vdd_datain 484.455
R619 pad_vdd_w3 vdd_iovdd_w5 15.0718
R620 pad_vdd_w3 vdd_iovss_w4 1.18925
R621 pad_vdd_w3 vdd_miso 316129
R622 pad_vdd_w3 vdd_rstn 15080.9
R623 pad_vdd_w3 vdd_vdd_w3 0.0843113
R624 pad_vdd_w3 vdd_vss_w2 319.486
R625 pad_vdd_w3 vddring_0 4.73806
R626 pad_vdd_w3 vddring_1 71.6336
R627 pad_vdd_w3 vddring_6 379028
R628 pad_vss_w2 padc_vss_w2 0.001
R629 pad_vss_w2 vss_clamp 7.19649
R630 pad_vss_w2 vss_miso 6.5309
R631 pad_vss_w2 vss_tst4 9939.5
R632 pad_vss_w2 vss_vdd_w3 79896.6
R633 pad_vss_w2 vss_vss_w2 0.317189
R634 vdd_adcconv vdd_mosi 430.111
R635 vdd_adcconv vdd_sclk 112540
R636 vdd_adcconv vdd_ss 0.290837
R637 vdd_adcconv vdd_tst0 0.290837
R638 vdd_adcconv vdd_tst1 429.737
R639 vdd_adcconv vdd_tst2 112476
R640 vdd_ana0 vdd_ana1 0.30006
R641 vdd_ana0 vdd_bidir0 37.4755
R642 vdd_ana0 vdd_bidir1 4855.94
R643 vdd_ana0 vdd_tst10 688.541
R644 vdd_ana0 vdd_tst11 0.50654
R645 vdd_ana0 vdd_tst12 9659.34
R646 vdd_ana0 vdd_tst13 14637.9
R647 vdd_ana0 vdd_tst9 180214
R648 vdd_ana0 vddring_2 4.53395
R649 vdd_ana0 vddring_3 30381.1
R650 vdd_ana0 vddring_5 3.14379
R651 vdd_ana1 vdd_bidir0 0.376685
R652 vdd_ana1 vdd_bidir1 75.8808
R653 vdd_ana1 vdd_tst10 248912
R654 vdd_ana1 vdd_tst11 740.556
R655 vdd_ana1 vdd_tst12 170.751
R656 vdd_ana1 vdd_tst13 259.024
R657 vdd_ana1 vddring_2 0.480943
R658 vdd_ana1 vddring_3 537.607
R659 vdd_ana1 vddring_5 1.82977
R660 vdd_bidir0 vdd_bidir1 0.29919
R661 vdd_bidir0 vdd_tst11 119117
R662 vdd_bidir0 vdd_tst12 13.3761
R663 vdd_bidir0 vdd_tst13 20.9071
R664 vdd_bidir0 vdd_tst14 162016
R665 vdd_bidir0 vddring_2 0.212532
R666 vdd_bidir0 vddring_3 43.3995
R667 vdd_bidir0 vddring_5 88.4026
R668 vdd_bidir1 vdd_tst12 0.296307
R669 vdd_bidir1 vdd_tst13 8.8543
R670 vdd_bidir1 vdd_tst14 44308.5
R671 vdd_bidir1 vddring_2 3.49745
R672 vdd_bidir1 vddring_3 18.6949
R673 vdd_bidir1 vddring_5 11300.3
R674 vdd_clamp vdd_clk 491630
R675 vdd_clamp vdd_datain 2142.28
R676 vdd_clamp vdd_iovdd_w5 66.6308
R677 vdd_clamp vdd_iovss_w4 8.02064
R678 vdd_clamp vdd_miso 385.932
R679 vdd_clamp vdd_rstn 66691.1
R680 vdd_clamp vdd_tst4 113833
R681 vdd_clamp vdd_vdd_w3 0.333706
R682 vdd_clamp vdd_vss_w2 0.29323
R683 vdd_clamp vddring_0 3.25311
R684 vdd_clamp vddring_1 316.783
R685 vdd_clamp vddring_4 11708.5
R686 vdd_clk vdd_datain 6.48114
R687 vdd_clk vdd_iovdd_w5 500.663
R688 vdd_clk vdd_iovss_w4 4529.06
R689 vdd_clk vdd_mosi 621.662
R690 vdd_clk vdd_rstn 0.238973
R691 vdd_clk vdd_sclk 0.451502
R692 vdd_clk vdd_ss 162851
R693 vdd_clk vdd_vdd_w3 47708.9
R694 vdd_clk vddring_0 153833
R695 vdd_clk vddring_1 7.35901
R696 vdd_clk vddring_6 0.943324
R697 vdd_datain vdd_iovdd_w5 0.333944
R698 vdd_datain vdd_iovss_w4 18.9049
R699 vdd_datain vdd_rstn 0.266752
R700 vdd_datain vdd_sclk 43072
R701 vdd_datain vdd_vdd_w3 207.422
R702 vdd_datain vdd_vss_w2 559705
R703 vdd_datain vddring_0 670.445
R704 vdd_datain vddring_1 0.177816
R705 vdd_datain vddring_6 22.4415
R706 vdd_iovdd_w5 vdd_iovss_w4 0.234919
R707 vdd_iovdd_w5 vdd_rstn 58.8546
R708 vdd_iovdd_w5 vdd_vdd_w3 6.37707
R709 vdd_iovdd_w5 vdd_vss_w2 17392.8
R710 vdd_iovdd_w5 vddring_0 20.8715
R711 vdd_iovdd_w5 vddring_1 0.440172
R712 vdd_iovdd_w5 vddring_6 1717.83
R713 vdd_iovss_w4 vdd_rstn 609.947
R714 vdd_iovss_w4 vdd_vdd_w3 0.28083
R715 vdd_iovss_w4 vdd_vss_w2 1928.04
R716 vdd_iovss_w4 vddring_0 3.04997
R717 vdd_iovss_w4 vddring_1 2.92487
R718 vdd_iovss_w4 vddring_6 15446
R719 vdd_miso vdd_tst4 0.444491
R720 vdd_miso vdd_tst5 604.512
R721 vdd_miso vdd_tst6 158221
R722 vdd_miso vdd_vdd_w3 49310.2
R723 vdd_miso vdd_vss_w2 0.266431
R724 vdd_miso vddring_0 5.85562
R725 vdd_miso vddring_4 6.27151
R726 vdd_mosi vdd_rstn 170451
R727 vdd_mosi vdd_sclk 0.290776
R728 vdd_mosi vdd_ss 0.290837
R729 vdd_mosi vdd_tst0 112574
R730 vdd_rstn vdd_sclk 532.255
R731 vdd_rstn vdd_vdd_w3 6469.44
R732 vdd_rstn vddring_0 20868.6
R733 vdd_rstn vddring_1 1.00201
R734 vdd_rstn vddring_6 2.20157
R735 vdd_sclk vdd_ss 429.606
R736 vdd_sclk vddring_1 79976.6
R737 vdd_sclk vddring_6 10726.7
R738 vdd_ss vdd_tst0 429.737
R739 vdd_ss vdd_tst1 112477
R740 vdd_tst0 vdd_tst1 0.290837
R741 vdd_tst0 vdd_tst2 429.737
R742 vdd_tst0 vdd_tst3 112309
R743 vdd_tst1 vdd_tst15 184727
R744 vdd_tst1 vdd_tst2 0.290837
R745 vdd_tst1 vdd_tst3 429.096
R746 vdd_tst10 vdd_tst11 0.290763
R747 vdd_tst10 vdd_tst7 112476
R748 vdd_tst10 vdd_tst8 429.737
R749 vdd_tst10 vdd_tst9 0.290837
R750 vdd_tst11 vdd_tst8 112315
R751 vdd_tst11 vdd_tst9 429.12
R752 vdd_tst11 vddring_2 29292.6
R753 vdd_tst11 vddring_5 46274.3
R754 vdd_tst12 vdd_tst13 0.305735
R755 vdd_tst12 vdd_tst14 459.956
R756 vdd_tst12 vdd_tst15 56436
R757 vdd_tst12 vddring_2 6.56551
R758 vdd_tst12 vddring_3 1.82278
R759 vdd_tst12 vddring_5 21616.9
R760 vdd_tst12 vddring_7 46797.2
R761 vdd_tst13 vdd_tst14 0.332158
R762 vdd_tst13 vdd_tst15 33.1748
R763 vdd_tst13 vdd_tst3 128460
R764 vdd_tst13 vddring_2 9.94512
R765 vdd_tst13 vddring_3 0.357227
R766 vdd_tst13 vddring_5 32748.9
R767 vdd_tst13 vddring_7 15.283
R768 vdd_tst14 vdd_tst15 0.29403
R769 vdd_tst14 vdd_tst2 239186
R770 vdd_tst14 vdd_tst3 707.744
R771 vdd_tst14 vddring_2 77463.4
R772 vdd_tst14 vddring_3 0.5638
R773 vdd_tst14 vddring_7 2.20992
R774 vdd_tst15 vdd_tst2 705.783
R775 vdd_tst15 vdd_tst3 0.513092
R776 vdd_tst15 vddring_3 15.3676
R777 vdd_tst15 vddring_7 6.2701
R778 vdd_tst2 vdd_tst3 0.29076
R779 vdd_tst3 vddring_3 152992
R780 vdd_tst3 vddring_7 67310.3
R781 vdd_tst4 vdd_tst5 0.29078
R782 vdd_tst4 vdd_tst6 429.263
R783 vdd_tst4 vdd_tst7 112353
R784 vdd_tst4 vdd_vss_w2 545.332
R785 vdd_tst4 vddring_0 24102.9
R786 vdd_tst4 vddring_4 25816.9
R787 vdd_tst5 vdd_tst6 0.290837
R788 vdd_tst5 vdd_tst7 429.737
R789 vdd_tst5 vdd_tst8 112476
R790 vdd_tst5 vdd_vss_w2 169840
R791 vdd_tst6 vdd_tst7 0.290837
R792 vdd_tst6 vdd_tst8 429.737
R793 vdd_tst6 vdd_tst9 112476
R794 vdd_tst7 vdd_tst8 0.290837
R795 vdd_tst7 vdd_tst9 429.737
R796 vdd_tst8 vdd_tst9 0.290837
R797 vdd_vdd_w3 vdd_vss_w2 49.8418
R798 vdd_vdd_w3 vddring_0 2.1633
R799 vdd_vdd_w3 vddring_1 30.7449
R800 vdd_vdd_w3 vddring_6 162661
R801 vdd_vss_w2 vddring_0 1.34324
R802 vdd_vss_w2 vddring_1 82779.9
R803 vdd_vss_w2 vddring_4 1.44074
R804 vddring_0 vddring_1 99.1219
R805 vddring_0 vddring_4 6.38058
R806 vddring_0 vddring_6 524477
R807 vddring_1 vddring_6 25.0859
R808 vddring_2 vddring_3 20.6411
R809 vddring_2 vddring_5 9.96297
R810 vddring_3 vddring_5 67970.3
R811 vddring_3 vddring_7 6.58171
R812 vddring_4 vddring_5 0.48
R813 vddring_6 vddring_7 0.48
R814 vss_adcconv vss_mosi 421.097
R815 vss_adcconv vss_sclk 110999
R816 vss_adcconv vss_ss 0.301632
R817 vss_adcconv vss_tst0 0.29083
R818 vss_adcconv vss_tst1 429.223
R819 vss_adcconv vss_tst2 111697
R820 vss_ana0 vss_ana1 0.278829
R821 vss_ana0 vss_bidir0 7.30857
R822 vss_ana0 vss_bidir1 30337.9
R823 vss_ana0 vss_tst10 741.372
R824 vss_ana0 vss_tst11 0.521307
R825 vss_ana0 vss_tst9 193991
R826 vss_ana0 vssring_2 2.09929
R827 vss_ana0 vssring_5 0.828194
R828 vss_ana1 vss_bidir0 0.351
R829 vss_ana1 vss_bidir1 423.246
R830 vss_ana1 vss_tst10 275439
R831 vss_ana1 vss_tst11 850.191
R832 vss_ana1 vss_tst12 116651
R833 vss_ana1 vssring_2 0.978306
R834 vss_ana1 vssring_5 10.6179
R835 vss_bidir0 vss_bidir1 0.301019
R836 vss_bidir0 vss_tst11 81684.3
R837 vss_bidir0 vss_tst12 438.423
R838 vss_bidir0 vss_tst13 76546.7
R839 vss_bidir0 vssring_2 1.26376
R840 vss_bidir0 vssring_3 254208
R841 vss_bidir0 vssring_5 125.727
R842 vss_bidir1 vss_tst12 0.221313
R843 vss_bidir1 vss_tst13 13.6062
R844 vss_bidir1 vss_tst14 35590.8
R845 vss_bidir1 vssring_2 1.0242
R846 vss_bidir1 vssring_3 17.5965
R847 vss_bidir1 vssring_5 659009
R848 vss_clamp vss_iovdd_w5 159603
R849 vss_clamp vss_iovss_w4 835.775
R850 vss_clamp vss_miso 64.1958
R851 vss_clamp vss_tst4 80828.4
R852 vss_clamp vss_vdd_w3 0.380447
R853 vss_clamp vss_vss_w2 0.376585
R854 vss_clamp vssring_0 0.0675652
R855 vss_clamp vssring_1 32.7774
R856 vss_clk vss_datain 335.981
R857 vss_clk vss_iovdd_w5 62193.2
R858 vss_clk vss_mosi 689.974
R859 vss_clk vss_rstn 0.254424
R860 vss_clk vss_sclk 0.467016
R861 vss_clk vss_ss 182507
R862 vss_datain vss_iovdd_w5 0.254521
R863 vss_datain vss_iovss_w4 336.978
R864 vss_datain vss_rstn 0.26593
R865 vss_datain vss_sclk 114331
R866 vss_datain vss_vdd_w3 64265.2
R867 vss_iovdd_w5 vss_iovss_w4 0.254515
R868 vss_iovdd_w5 vss_rstn 320.34
R869 vss_iovdd_w5 vss_vdd_w3 336.479
R870 vss_iovss_w4 vss_rstn 61173.3
R871 vss_iovss_w4 vss_vdd_w3 0.254467
R872 vss_miso vss_tst4 0.458675
R873 vss_miso vss_tst5 694.123
R874 vss_miso vss_tst6 185117
R875 vss_miso vss_vdd_w3 744437
R876 vss_miso vss_vss_w2 0.259752
R877 vss_mosi vss_rstn 183270
R878 vss_mosi vss_sclk 0.301351
R879 vss_mosi vss_ss 0.301515
R880 vss_mosi vss_tst0 115961
R881 vss_rstn vss_sclk 598.89
R882 vss_sclk vss_ss 420.574
R883 vss_ss vss_tst0 439.765
R884 vss_ss vss_tst1 114441
R885 vss_tst0 vss_tst1 0.290834
R886 vss_tst0 vss_tst2 429.262
R887 vss_tst0 vss_tst3 111530
R888 vss_tst1 vss_tst15 195250
R889 vss_tst1 vss_tst2 0.290834
R890 vss_tst1 vss_tst3 428.58
R891 vss_tst10 vss_tst11 0.290754
R892 vss_tst10 vss_tst7 112081
R893 vss_tst10 vss_tst8 429.5
R894 vss_tst10 vss_tst9 0.290836
R895 vss_tst11 vss_tst8 111945
R896 vss_tst11 vss_tst9 428.934
R897 vss_tst11 vssring_2 35379.6
R898 vss_tst11 vssring_5 34085.2
R899 vss_tst12 vss_tst13 0.290064
R900 vss_tst12 vss_tst14 430.252
R901 vss_tst12 vss_tst15 111791
R902 vss_tst12 vssring_2 8.74753
R903 vss_tst12 vssring_3 0.949928
R904 vss_tst13 vss_tst14 0.290839
R905 vss_tst13 vss_tst15 428.628
R906 vss_tst13 vss_tst3 204498
R907 vss_tst13 vssring_2 292.279
R908 vss_tst13 vssring_3 3.08065
R909 vss_tst14 vss_tst15 0.290754
R910 vss_tst14 vss_tst2 257880
R911 vss_tst14 vss_tst3 785.767
R912 vss_tst14 vssring_3 13755.1
R913 vss_tst14 vssring_7 13826
R914 vss_tst15 vss_tst2 750.291
R915 vss_tst15 vss_tst3 0.534029
R916 vss_tst15 vssring_3 1.38424
R917 vss_tst15 vssring_7 0.716518
R918 vss_tst2 vss_tst3 0.290753
R919 vss_tst2 vssring_3 92317
R920 vss_tst2 vssring_7 47785.6
R921 vss_tst3 vssring_3 53.3322
R922 vss_tst3 vssring_7 27.6061
R923 vss_tst4 vss_tst5 0.301326
R924 vss_tst4 vss_tst6 423.969
R925 vss_tst4 vss_tst7 110810
R926 vss_tst4 vss_vss_w2 592.533
R927 vss_tst5 vss_tst6 0.302154
R928 vss_tst5 vss_tst7 417.728
R929 vss_tst5 vss_tst8 115732
R930 vss_tst5 vss_vss_w2 169837
R931 vss_tst6 vss_tst7 0.301441
R932 vss_tst6 vss_tst8 440.754
R933 vss_tst6 vss_tst9 115029
R934 vss_tst7 vss_tst8 0.290831
R935 vss_tst7 vss_tst9 429.458
R936 vss_tst8 vss_tst9 0.290836
R937 vss_vdd_w3 vss_vss_w2 5881.35
R938 vss_vdd_w3 vssring_0 0.619875
R939 vss_vdd_w3 vssring_1 1.90337
R940 vssring_0 vssring_1 32.0503
R941 vssring_0 vssring_4 1.84138
R942 vssring_1 vssring_6 1.83763
R943 vssring_2 vssring_3 368.678
R944 vssring_2 vssring_5 35.6693
R945 vssring_3 vssring_7 15.5692
R946 vssring_4 vssring_5 0.48
R947 vssring_6 vssring_7 0.48
.ends
