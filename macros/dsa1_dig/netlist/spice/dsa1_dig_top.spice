* NGSPICE file created from dsa1_dig_top.ext - technology: ihp-sg13cmos5l

* Black-box entry subcircuit for FILLER4 abstract view
.subckt FILLER4 VDD VSS
.ends

* Black-box entry subcircuit for FILLER2 abstract view
.subckt FILLER2 VSS VDD
.ends

* Black-box entry subcircuit for MUXI2X1 abstract view
.subckt MUXI2X1 A0 A1 S0 VDD VSS Y
.ends

* Black-box entry subcircuit for DFFQX1 abstract view
.subckt DFFQX1 CK D Q VDD VSS
.ends

* Black-box entry subcircuit for FILLER1 abstract view
.subckt FILLER1 VDD VSS
.ends

* Black-box entry subcircuit for WELLTAP abstract view
.subckt WELLTAP VDD VSS
.ends

* Black-box entry subcircuit for BUFX3 abstract view
.subckt BUFX3 A VDD VSS Y
.ends

* Black-box entry subcircuit for XOR2X1 abstract view
.subckt XOR2X1 A B VDD VSS Y
.ends

* Black-box entry subcircuit for DFFRQX1 abstract view
.subckt DFFRQX1 CK D Q RB VDD VSS
.ends

* Black-box entry subcircuit for XNOR3X1 abstract view
.subckt XNOR3X1 A B C VDD VSS Y
.ends

* Black-box entry subcircuit for DECAPHV8 abstract view
.subckt DECAPHV8 VDD VSS
.ends

* Black-box entry subcircuit for INVX1 abstract view
.subckt INVX1 A VDD VSS Y
.ends

* Black-box entry subcircuit for AND2X1 abstract view
.subckt AND2X1 A B VDD VSS Y
.ends

* Black-box entry subcircuit for MIN3X1 abstract view
.subckt MIN3X1 A B C VDD VSS Y
.ends

* Black-box entry subcircuit for NAND3X1 abstract view
.subckt NAND3X1 A B VDD VSS Y C
.ends

* Black-box entry subcircuit for XNOR2X1 abstract view
.subckt XNOR2X1 A B VDD VSS Y
.ends

* Black-box entry subcircuit for NOR3X1 abstract view
.subckt NOR3X1 A B C VDD VSS Y
.ends

* Black-box entry subcircuit for OAI21X1 abstract view
.subckt OAI21X1 A B C VDD VSS Y
.ends

* Black-box entry subcircuit for OAOI211X1 abstract view
.subckt OAOI211X1 A B C D VDD VSS Y
.ends

* Black-box entry subcircuit for AOAI211X1 abstract view
.subckt AOAI211X1 A B C D VDD VSS Y
.ends

* Black-box entry subcircuit for AND3BX1 abstract view
.subckt AND3BX1 AB B C VDD VSS Y
.ends

* Black-box entry subcircuit for NOR2BX1 abstract view
.subckt NOR2BX1 AB B VDD VSS Y
.ends

* Black-box entry subcircuit for OA21X2 abstract view
.subckt OA21X2 A B C VDD VSS Y
.ends

* Black-box entry subcircuit for OR2X2 abstract view
.subckt OR2X2 A B VDD VSS Y
.ends

* Black-box entry subcircuit for NOR2X1 abstract view
.subckt NOR2X1 A B VDD VSS Y
.ends

* Black-box entry subcircuit for NAND2X1 abstract view
.subckt NAND2X1 A B VDD VSS Y
.ends

* Black-box entry subcircuit for AOI211X1 abstract view
.subckt AOI211X1 A B C D VDD VSS Y
.ends

* Black-box entry subcircuit for AOI21X1 abstract view
.subckt AOI21X1 A B C VDD VSS Y
.ends

* Black-box entry subcircuit for DECAPHV16 abstract view
.subckt DECAPHV16 VDD VSS
.ends

* Black-box entry subcircuit for OAI31X1 abstract view
.subckt OAI31X1 A B C D VDD VSS Y
.ends

* Black-box entry subcircuit for AOI31X1 abstract view
.subckt AOI31X1 A B C D VDD VSS Y
.ends

* Black-box entry subcircuit for AOI22X1 abstract view
.subckt AOI22X1 A B C D VDD VSS Y
.ends

* Black-box entry subcircuit for AO22X2 abstract view
.subckt AO22X2 A B C D VDD VSS Y
.ends

* Black-box entry subcircuit for AO21X2 abstract view
.subckt AO21X2 A B C VDD VSS Y
.ends

* Black-box entry subcircuit for NAND2BX1 abstract view
.subckt NAND2BX1 AB B VDD VSS Y
.ends

* Black-box entry subcircuit for AND3X2 abstract view
.subckt AND3X2 A B VDD VSS Y C
.ends

* Black-box entry subcircuit for OR3BX1 abstract view
.subckt OR3BX1 AB B C VDD VSS Y
.ends

* Black-box entry subcircuit for BUFX4 abstract view
.subckt BUFX4 A VDD VSS Y
.ends

* Black-box entry subcircuit for BUFX6 abstract view
.subckt BUFX6 A VDD VSS Y
.ends

* Black-box entry subcircuit for NOR3BX1 abstract view
.subckt NOR3BX1 AB B C VDD VSS Y
.ends

* Black-box entry subcircuit for AOI221X1 abstract view
.subckt AOI221X1 A B C D E VDD VSS Y
.ends

* Black-box entry subcircuit for ANTENNA2 abstract view
.subckt ANTENNA2 A VDD VSS
.ends

* Black-box entry subcircuit for BUFX12 abstract view
.subckt BUFX12 A VDD VSS Y
.ends

* Black-box entry subcircuit for OA211X2 abstract view
.subckt OA211X2 A B C D VDD VSS Y
.ends

* Black-box entry subcircuit for OAOI211X2 abstract view
.subckt OAOI211X2 A B C D VDD VSS Y
.ends

* Black-box entry subcircuit for OR3X2 abstract view
.subckt OR3X2 A B C VDD VSS Y
.ends

* Black-box entry subcircuit for OAI211X1 abstract view
.subckt OAI211X1 A B C D VDD VSS Y
.ends

* Black-box entry subcircuit for INVX2 abstract view
.subckt INVX2 A VDD VSS Y
.ends

* Black-box entry subcircuit for AOI21BX1 abstract view
.subckt AOI21BX1 A B CB VDD VSS Y
.ends

* Black-box entry subcircuit for XOR3X1 abstract view
.subckt XOR3X1 A B C VDD VSS Y
.ends

* Black-box entry subcircuit for AOI2B2BX1 abstract view
.subckt AOI2B2BX1 AB B CB D VDD VSS Y
.ends

* Black-box entry subcircuit for NAND4X2 abstract view
.subckt NAND4X2 A B VDD VSS Y C D
.ends

* Black-box entry subcircuit for AOI2B1X1 abstract view
.subckt AOI2B1X1 AB B C VDD VSS Y
.ends

* Black-box entry subcircuit for DECAPHV32 abstract view
.subckt DECAPHV32 VDD VSS
.ends

* Black-box entry subcircuit for MUX2X1 abstract view
.subckt MUX2X1 A0 A1 S0 VDD VSS Y
.ends

* Black-box entry subcircuit for NOR4X2 abstract view
.subckt NOR4X2 A B C D VDD VSS Y
.ends

* Black-box entry subcircuit for AO31X2 abstract view
.subckt AO31X2 A B C D VDD VSS Y
.ends

* Black-box entry subcircuit for AO211X2 abstract view
.subckt AO211X2 A B C D VDD VSS Y
.ends

* Black-box entry subcircuit for AND4X2 abstract view
.subckt AND4X2 A B C D VDD VSS Y
.ends

* Black-box entry subcircuit for NAND3BX1 abstract view
.subckt NAND3BX1 AB B C VDD VSS Y
.ends

* Black-box entry subcircuit for CGX3 abstract view
.subckt CGX3 CK E ECK VDD VSS
.ends

* Black-box entry subcircuit for OAI22X1 abstract view
.subckt OAI22X1 A B C D VDD VSS Y
.ends

* Black-box entry subcircuit for INVX8 abstract view
.subckt INVX8 A VDD VSS Y
.ends

* Black-box entry subcircuit for OAI221X1 abstract view
.subckt OAI221X1 A B C D E VDD VSS Y
.ends

* Black-box entry subcircuit for OAI2B2BX1 abstract view
.subckt OAI2B2BX1 AB B CB D VDD VSS Y
.ends

* Black-box entry subcircuit for INVX6 abstract view
.subckt INVX6 A VDD VSS Y
.ends

* Black-box entry subcircuit for OR3BX2 abstract view
.subckt OR3BX2 AB B C VDD VSS Y
.ends

* Black-box entry subcircuit for NOR2X2 abstract view
.subckt NOR2X2 A B VDD VSS Y
.ends

* Black-box entry subcircuit for INVX4 abstract view
.subckt INVX4 A VDD VSS Y
.ends

* Black-box entry subcircuit for INVX14 abstract view
.subckt INVX14 A VDD VSS Y
.ends

* Black-box entry subcircuit for AOI2B2X1 abstract view
.subckt AOI2B2X1 AB B C D VDD VSS Y
.ends

* Black-box entry subcircuit for AOI2BB2X1 abstract view
.subckt AOI2BB2X1 AB BB C D VDD VSS Y
.ends

* Black-box entry subcircuit for NAND3BX2 abstract view
.subckt NAND3BX2 AB B C VDD VSS Y
.ends

* Black-box entry subcircuit for BUFX8 abstract view
.subckt BUFX8 A VDD VSS Y
.ends

* Black-box entry subcircuit for OR4X1 abstract view
.subckt OR4X1 A B VDD VSS Y C D
.ends

* Black-box entry subcircuit for NOR2BX2 abstract view
.subckt NOR2BX2 AB B VDD VSS Y
.ends

* Black-box entry subcircuit for NAND2X1P5 abstract view
.subckt NAND2X1P5 A B VDD VSS Y
.ends

* Black-box entry subcircuit for NAND4BX1 abstract view
.subckt NAND4BX1 AB B C D VDD VSS Y
.ends

.subckt dsa1_dig_top VDD VSS adc_conv clk data_in miso mosi o_aux_ctrl[0] o_aux_ctrl[10]
+ o_aux_ctrl[11] o_aux_ctrl[12] o_aux_ctrl[13] o_aux_ctrl[14] o_aux_ctrl[15] o_aux_ctrl[1]
+ o_aux_ctrl[2] o_aux_ctrl[3] o_aux_ctrl[4] o_aux_ctrl[5] o_aux_ctrl[6] o_aux_ctrl[7]
+ o_aux_ctrl[8] o_aux_ctrl[9] o_bias_cfg[0] o_bias_cfg[10] o_bias_cfg[11] o_bias_cfg[12]
+ o_bias_cfg[13] o_bias_cfg[14] o_bias_cfg[15] o_bias_cfg[16] o_bias_cfg[17] o_bias_cfg[18]
+ o_bias_cfg[19] o_bias_cfg[1] o_bias_cfg[20] o_bias_cfg[21] o_bias_cfg[22] o_bias_cfg[23]
+ o_bias_cfg[24] o_bias_cfg[25] o_bias_cfg[26] o_bias_cfg[27] o_bias_cfg[28] o_bias_cfg[29]
+ o_bias_cfg[2] o_bias_cfg[30] o_bias_cfg[31] o_bias_cfg[32] o_bias_cfg[33] o_bias_cfg[34]
+ o_bias_cfg[3] o_bias_cfg[4] o_bias_cfg[5] o_bias_cfg[6] o_bias_cfg[7] o_bias_cfg[8]
+ o_bias_cfg[9] o_clk_cfg[0] o_clk_cfg[10] o_clk_cfg[11] o_clk_cfg[12] o_clk_cfg[13]
+ o_clk_cfg[14] o_clk_cfg[15] o_clk_cfg[16] o_clk_cfg[17] o_clk_cfg[18] o_clk_cfg[1]
+ o_clk_cfg[2] o_clk_cfg[3] o_clk_cfg[4] o_clk_cfg[5] o_clk_cfg[6] o_clk_cfg[7] o_clk_cfg[8]
+ o_clk_cfg[9] o_en_ctrl[0] o_en_ctrl[10] o_en_ctrl[1] o_en_ctrl[2] o_en_ctrl[3] o_en_ctrl[4]
+ o_en_ctrl[5] o_en_ctrl[6] o_en_ctrl[7] o_en_ctrl[8] o_en_ctrl[9] o_lf_cfg[0] o_lf_cfg[10]
+ o_lf_cfg[11] o_lf_cfg[12] o_lf_cfg[13] o_lf_cfg[14] o_lf_cfg[15] o_lf_cfg[1] o_lf_cfg[2]
+ o_lf_cfg[3] o_lf_cfg[4] o_lf_cfg[5] o_lf_cfg[6] o_lf_cfg[7] o_lf_cfg[8] o_lf_cfg[9]
+ o_rst_ctrl_b[0] o_rst_ctrl_b[1] o_tst_ctrl[0] o_tst_ctrl[10] o_tst_ctrl[11] o_tst_ctrl[12]
+ o_tst_ctrl[13] o_tst_ctrl[14] o_tst_ctrl[15] o_tst_ctrl[1] o_tst_ctrl[2] o_tst_ctrl[3]
+ o_tst_ctrl[4] o_tst_ctrl[5] o_tst_ctrl[6] o_tst_ctrl[7] o_tst_ctrl[8] o_tst_ctrl[9]
+ o_uwb_tx_cfg[0] o_uwb_tx_cfg[10] o_uwb_tx_cfg[11] o_uwb_tx_cfg[12] o_uwb_tx_cfg[13]
+ o_uwb_tx_cfg[14] o_uwb_tx_cfg[15] o_uwb_tx_cfg[16] o_uwb_tx_cfg[17] o_uwb_tx_cfg[18]
+ o_uwb_tx_cfg[19] o_uwb_tx_cfg[1] o_uwb_tx_cfg[20] o_uwb_tx_cfg[21] o_uwb_tx_cfg[22]
+ o_uwb_tx_cfg[23] o_uwb_tx_cfg[24] o_uwb_tx_cfg[25] o_uwb_tx_cfg[26] o_uwb_tx_cfg[27]
+ o_uwb_tx_cfg[28] o_uwb_tx_cfg[29] o_uwb_tx_cfg[2] o_uwb_tx_cfg[3] o_uwb_tx_cfg[4]
+ o_uwb_tx_cfg[5] o_uwb_tx_cfg[6] o_uwb_tx_cfg[7] o_uwb_tx_cfg[8] o_uwb_tx_cfg[9]
+ rst_b sclk ss
XFILLER_140_296 VDD VSS FILLER4
XFILLER_39_244 VSS VDD FILLER2
X_09671_ _20139_/A _20187_/A _09753_/A VDD VSS _09682_/B MUXI2X1
X_18869_ _19197_/CK _18869_/D _18869_/Q VDD VSS DFFQX1
XFILLER_54_225 VSS VDD FILLER2
XFILLER_82_534 VDD VSS FILLER1
XFILLER_94_394 VSS VDD FILLER2
XTAP_TAPCELL_ROW_105_1064 VDD VSS WELLTAP
XFILLER_23_645 VDD VSS FILLER4
XFILLER_11_818 VSS VDD FILLER2
XFILLER_50_453 VSS VDD FILLER2
XFILLER_50_464 VSS VDD FILLER2
XFILLER_10_328 VSS VDD FILLER2
XFILLER_109_717 VDD VSS FILLER1
XFILLER_109_728 VSS VDD FILLER2
XFILLER_136_514 VDD VSS FILLER1
XFILLER_136_525 VSS VDD FILLER2
XTAP_TAPCELL_ROW_9_104 VDD VSS WELLTAP
XTAP_TAPCELL_ROW_116_1171 VDD VSS WELLTAP
XFILLER_116_293 VSS VDD FILLER2
XFILLER_120_915 VDD VSS FILLER1
XFILLER_104_499 VDD VSS FILLER1
XFILLER_131_263 VDD VSS FILLER1
XFILLER_132_797 VSS VDD FILLER2
X_09938_ _09938_/A VDD VSS _10034_/A BUFX3
X_20127_ _20127_/A VDD VSS _20127_/Y BUFX3
XFILLER_18_417 VDD VSS FILLER1
X_09869_ _18575_/Q _09869_/B VDD VSS _09869_/Y XOR2X1
X_20058_ clkload5/A _20193_/A _20059_/D _20064_/RB VDD VSS DFFRQX1
XFILLER_133_98 VDD VSS FILLER1
XFILLER_46_737 VDD VSS FILLER4
X_11900_ _11968_/A _11961_/B _11961_/C VDD VSS _11958_/C XNOR3X1
X_12880_ _18881_/Q _13181_/B _12885_/C VDD VSS _17880_/B XNOR3X1
XFILLER_45_247 VDD VSS FILLER1
XFILLER_93_69 VDD VSS DECAPHV8
X_11831_ _19230_/Q VDD VSS _11876_/A INVX1
XFILLER_54_770 VDD VSS FILLER1
XTAP_TAPCELL_ROW_71_724 VDD VSS WELLTAP
X_14550_ _19990_/Q _14558_/B VDD VSS _19254_/D AND2X1
XFILLER_26_85 VDD VSS DECAPHV8
XTAP_TAPCELL_ROW_43_448 VDD VSS WELLTAP
X_11762_ _19172_/Q _11762_/B _11762_/C VDD VSS _11852_/B MIN3X1
X_13501_ _18914_/Q _14159_/B VDD VSS _13502_/C _14159_/C NAND3X1
XFILLER_41_464 VDD VSS FILLER1
X_10713_ _18642_/Q _18804_/Q VDD VSS _10715_/C XNOR2X1
X_11693_ _19988_/Q _19252_/Q VDD VSS _11716_/C AND2X1
X_14481_ _14490_/A _14481_/B _14481_/C VDD VSS _19194_/D NOR3X1
XFILLER_139_341 VDD VSS DECAPHV8
XFILLER_9_148 VDD VSS FILLER4
X_10644_ _10718_/A _10718_/B _11195_/A VDD VSS _10645_/D OAI21X1
X_13432_ _13432_/A _13432_/B _13432_/C _13432_/D VDD VSS _14388_/B OAOI211X1
X_16220_ _19719_/Q _16883_/B VDD VSS _16222_/C XNOR2X1
XFILLER_10_862 VDD VSS FILLER1
XFILLER_139_363 VDD VSS FILLER1
XFILLER_42_95 VDD VSS DECAPHV8
X_10575_ _10576_/A _10576_/B _10576_/D _10576_/C VDD VSS _10642_/B AOAI211X1
X_13363_ _13219_/A _14386_/B _14386_/C VDD VSS _13364_/C AND3BX1
X_16151_ _16845_/B _19684_/Q VDD VSS _16152_/C NOR2BX1
X_12314_ _19183_/Q VDD VSS _12331_/A INVX1
X_15102_ _19536_/Q _15102_/B VDD VSS _15903_/B XOR2X1
X_13294_ _13494_/B _13385_/B _13385_/C VDD VSS _13502_/A OA21X2
X_16082_ _19617_/Q _16769_/B VDD VSS _16083_/C OR2X2
XFILLER_107_282 VDD VSS FILLER4
X_12245_ _19126_/Q _14405_/B VDD VSS _12258_/B XNOR2X1
X_19910_ clkload9/A _19910_/D _19910_/Q VDD VSS DFFQX1
X_15033_ _15036_/B _15033_/B VDD VSS _18089_/B XNOR2X1
X_12176_ _14436_/B _14436_/C VDD VSS _12177_/B NOR2X1
X_19841_ _19843_/CK _19841_/D _19841_/Q VDD VSS DFFQX1
XFILLER_96_615 VSS VDD FILLER2
XTAP_TAPCELL_ROW_79_802 VDD VSS WELLTAP
X_11127_ _11127_/A VDD VSS _11364_/B BUFX3
X_19772_ _19843_/CK _19772_/D _19772_/Q VDD VSS DFFQX1
X_16984_ _16984_/A _16984_/B VDD VSS _16996_/A NAND2X1
X_11058_ _11090_/A _11090_/B _11127_/A VDD VSS _11083_/A OAI21X1
X_18723_ _19948_/CK _18723_/D _18723_/Q VDD VSS DFFQX1
X_15935_ _19612_/Q _16764_/B _15935_/C VDD VSS _15969_/A OAI21X1
XFILLER_76_394 VSS VDD FILLER2
XTAP_TAPCELL_ROW_87_890 VDD VSS WELLTAP
X_10009_ _10180_/A _11407_/C VDD VSS _18529_/D NOR2X1
X_18654_ _19963_/CK _18654_/D _18654_/Q VDD VSS DFFQX1
X_15866_ _15879_/A _15866_/B VDD VSS _19475_/D AND2X1
XFILLER_92_854 VSS VDD FILLER2
X_18585_ _18595_/CK _18585_/D _18585_/Q VDD VSS DFFQX1
X_17605_ _19882_/Q _19850_/Q VDD VSS _17610_/A XNOR2X1
X_14817_ _19447_/Q _14865_/A _14817_/C VDD VSS _14818_/D XNOR3X1
XFILLER_51_206 VSS VDD FILLER2
XFILLER_92_898 VSS VDD FILLER2
X_17536_ _17536_/A _17536_/B _17537_/C VDD VSS _19867_/D NOR3X1
X_15797_ _15800_/A _15797_/B VDD VSS _19415_/D NOR2X1
X_14748_ _19500_/Q _14748_/B VDD VSS _14785_/C NAND2X1
X_14679_ _19526_/Q _14742_/C VDD VSS _15892_/B XNOR2X1
X_17467_ _17468_/A _17468_/B _17468_/D _17468_/C VDD VSS _17470_/C AOI211X1
XFILLER_80_2 VDD VSS FILLER1
X_19206_ _19234_/CK _19206_/D _19206_/Q VDD VSS DFFQX1
X_17398_ _19837_/Q _19805_/Q _17398_/C VDD VSS _17402_/B AOI21X1
X_16418_ _16784_/B _19630_/Q VDD VSS _16429_/A NOR2BX1
XFILLER_118_503 VDD VSS FILLER1
X_19137_ _19137_/CK _19137_/D _19137_/Q VDD VSS DFFQX1
X_16349_ _16390_/B _16349_/B VDD VSS _16853_/B NOR2BX1
XFILLER_66_0 VDD VSS DECAPHV8
XFILLER_105_208 VDD VSS DECAPHV16
X_19068_ _19096_/CK _19068_/D _19068_/Q VDD VSS DFFQX1
XFILLER_114_720 VDD VSS FILLER4
XFILLER_126_591 VDD VSS FILLER4
X_18019_ _18020_/B _18045_/B _18019_/C _18056_/C VDD VSS _19967_/D OAI31X1
XFILLER_101_414 VDD VSS FILLER1
XFILLER_113_263 VDD VSS DECAPHV8
XFILLER_141_561 VDD VSS FILLER4
XFILLER_99_486 VSS VDD FILLER2
XFILLER_99_497 VDD VSS FILLER4
XFILLER_101_458 VDD VSS FILLER4
X_09723_ _20172_/A _09784_/C VDD VSS _09725_/C NAND2X1
XFILLER_103_24 VDD VSS FILLER1
XFILLER_82_320 VDD VSS FILLER4
X_09654_ _18493_/Q VDD VSS _20106_/A INVX1
XFILLER_63_28 VDD VSS FILLER1
XFILLER_83_887 VSS VDD FILLER2
X_09585_ _18441_/Q VDD VSS _20153_/A INVX1
XFILLER_11_604 VDD VSS DECAPHV16
XTAP_TAPCELL_ROW_40_418 VDD VSS WELLTAP
XTAP_TAPCELL_ROW_118_1200 VDD VSS WELLTAP
XFILLER_12_54 VSS VDD FILLER2
XFILLER_136_366 VDD VSS FILLER1
X_10360_ _19939_/Q _18821_/Q VDD VSS _10417_/A NAND2X1
XFILLER_124_528 VDD VSS FILLER4
XFILLER_3_836 VDD VSS FILLER1
X_10291_ _19937_/Q _18819_/Q VDD VSS _10343_/A AND2X1
X_12030_ _14433_/C _19150_/Q _12116_/B VDD VSS _12031_/D AND3BX1
XFILLER_144_64 VDD VSS FILLER4
XFILLER_59_840 VDD VSS DECAPHV16
XFILLER_19_704 VDD VSS FILLER1
XFILLER_59_862 VDD VSS FILLER1
X_13981_ _13981_/A _13981_/B _13981_/C _13981_/D VDD VSS _13995_/B AOAI211X1
XFILLER_19_726 VDD VSS DECAPHV8
X_12932_ _12932_/A _12932_/B _12932_/C _12932_/D VDD VSS _14413_/B OAOI211X1
X_15720_ _15725_/A _15720_/B VDD VSS _19346_/D AND2X1
X_15651_ _19329_/Q _15701_/B VDD VSS _15652_/C NOR2BX1
XTAP_TAPCELL_ROW_56_573 VDD VSS WELLTAP
XTAP_TAPCELL_ROW_84_860 VDD VSS WELLTAP
X_12863_ _19105_/Q _12863_/B _12939_/C VDD VSS _13102_/B XNOR3X1
X_14602_ _14624_/A _14624_/B VDD VSS _14607_/B NOR2X1
XTAP_TAPCELL_ROW_28_297 VDD VSS WELLTAP
XTAP_TAPCELL_ROW_8_99 VDD VSS WELLTAP
X_11814_ _19091_/Q VDD VSS _11908_/A INVX1
X_12794_ _12877_/A _12877_/B _14184_/B VDD VSS _12883_/C XNOR3X1
X_18370_ _18375_/CK _18498_/D _20207_/A _18370_/RB VDD VSS DFFRQX1
X_15582_ _15597_/A _15582_/B VDD VSS _15759_/B XNOR2X1
XFILLER_30_902 VDD VSS FILLER4
XFILLER_53_50 VDD VSS FILLER1
X_11745_ _11745_/A _11745_/B _11745_/C _11745_/D VDD VSS _11835_/B OAOI211X1
X_14533_ _14766_/A _14533_/B VDD VSS _19239_/D AND2X1
X_17321_ _19821_/Q _19789_/Q VDD VSS _17323_/B XOR2X1
X_14464_ _14467_/A _14464_/B VDD VSS _19178_/D AND2X1
X_17252_ _17250_/B _17252_/B VDD VSS _17253_/C NOR2BX1
X_11676_ _18813_/Q _14547_/B VDD VSS _18840_/D AND2X1
X_13415_ _13415_/A _13415_/B _13415_/C _13415_/D VDD VSS _13420_/B OAOI211X1
X_16203_ _19654_/Q _16203_/B _16811_/B VDD VSS _16228_/A MIN3X1
XFILLER_128_834 VDD VSS FILLER4
XFILLER_139_182 VDD VSS FILLER4
X_10627_ _10627_/A _10630_/B VDD VSS _10665_/B XNOR2X1
X_14395_ _14457_/A VDD VSS _14426_/A BUFX3
X_17183_ _17185_/C _17183_/B _17183_/C VDD VSS _19791_/D AOI21X1
XFILLER_10_692 VDD VSS FILLER4
XFILLER_127_355 VSS VDD FILLER2
XFILLER_128_867 VDD VSS DECAPHV16
X_10558_ _10686_/D _10558_/B _10633_/B _10558_/D VDD VSS _10578_/A AOI31X1
X_13346_ _14544_/A _14544_/B _19249_/Q VDD VSS _13347_/D OA21X2
X_16134_ _16134_/A _16134_/B _16736_/B VDD VSS _16157_/A MIN3X1
XTAP_TAPCELL_ROW_136_1377 VDD VSS WELLTAP
X_13277_ _13308_/A _13300_/B _13300_/C VDD VSS _14221_/C XNOR3X1
X_16065_ _19585_/Q _16734_/B VDD VSS _16066_/B XNOR2X1
XFILLER_108_591 VSS VDD FILLER2
X_10489_ _19943_/Q _18825_/Q VDD VSS _10530_/C XNOR2X1
X_12228_ _12236_/A _12236_/B _12236_/D _12236_/C VDD VSS _12396_/B AOI211X1
X_15016_ _15016_/A VDD VSS _15017_/D INVX1
XFILLER_111_712 VSS VDD FILLER2
XFILLER_123_561 VDD VSS DECAPHV8
XFILLER_69_637 VSS VDD FILLER2
XFILLER_78_91 VDD VSS FILLER4
X_12159_ _12401_/B _14499_/C _19208_/Q VDD VSS _12160_/D AND3BX1
X_19824_ _19828_/CK _19824_/D _19824_/Q VDD VSS DFFQX1
XFILLER_68_147 VDD VSS DECAPHV8
X_19755_ _19792_/CK _19755_/D _19755_/Q VDD VSS DFFQX1
X_16967_ _19749_/Q _16978_/B VDD VSS _16971_/B XOR2X1
XFILLER_37_534 VDD VSS FILLER4
X_18706_ _19940_/CK _18706_/D _18706_/Q VDD VSS DFFQX1
X_15918_ _19578_/Q _16727_/B VDD VSS _15929_/A NAND2X1
XFILLER_92_651 VDD VSS FILLER4
XFILLER_94_90 VDD VSS DECAPHV8
X_19686_ _19730_/CK _19686_/D _19686_/Q VDD VSS DFFQX1
X_16898_ _16976_/A _16898_/B VDD VSS _19733_/D NOR2X1
X_18637_ _19947_/CK _18637_/D _18637_/Q VDD VSS DFFQX1
X_15849_ _15849_/A _15849_/B VDD VSS _19461_/D AND2X1
XFILLER_80_868 VDD VSS FILLER1
X_09370_ _18506_/Q _18505_/Q VDD VSS _09624_/B _09630_/C NAND3X1
X_18568_ _18571_/CK _18568_/D _18568_/Q VDD VSS DFFQX1
XTAP_TAPCELL_ROW_102_1034 VDD VSS WELLTAP
X_18499_ _18503_/CK _18499_/D _20112_/A _18503_/RB VDD VSS DFFRQX1
X_17519_ _17522_/A _17520_/B _17597_/C VDD VSS _17520_/C OAI21X1
XFILLER_138_609 VDD VSS FILLER1
XFILLER_118_300 VDD VSS FILLER4
XFILLER_119_834 VSS VDD FILLER2
XFILLER_134_848 VDD VSS FILLER1
XFILLER_134_859 VDD VSS FILLER1
XFILLER_133_369 VSS VDD FILLER2
XFILLER_58_28 VDD VSS FILLER1
XTAP_TAPCELL_ROW_113_1141 VDD VSS WELLTAP
XFILLER_142_892 VSS VDD FILLER2
XFILLER_102_789 VDD VSS FILLER1
XFILLER_68_692 VDD VSS FILLER4
XTAP_TAPCELL_ROW_98_996 VDD VSS WELLTAP
X_09706_ _18432_/Q _09811_/B _09811_/C _20205_/A VDD VSS _09707_/B AOI22X1
XFILLER_71_835 VSS VDD FILLER2
X_09637_ _18348_/Q VDD VSS _20216_/A INVX1
XFILLER_130_22 VDD VSS DECAPHV8
XFILLER_130_44 VSS VDD FILLER2
XTAP_TAPCELL_ROW_81_830 VDD VSS WELLTAP
X_09568_ _20101_/A _09788_/B _09811_/C _20197_/A VDD VSS _09569_/C AOI22X1
XFILLER_130_88 VDD VSS DECAPHV8
XTAP_TAPCELL_ROW_53_543 VDD VSS WELLTAP
XFILLER_51_570 VDD VSS FILLER1
XTAP_TAPCELL_ROW_25_267 VDD VSS WELLTAP
X_09499_ _18516_/Q _09501_/B _09506_/C _20073_/Q VDD VSS _20073_/D AO22X2
X_11530_ _18682_/Q _11531_/B VDD VSS _18709_/D AND2X1
XFILLER_11_456 VDD VSS DECAPHV8
XFILLER_109_300 VDD VSS FILLER1
XFILLER_139_64 VDD VSS DECAPHV16
XFILLER_23_75 VDD VSS FILLER1
X_11461_ _16860_/A VDD VSS _11473_/B BUFX3
X_10412_ _18687_/Q _18741_/Q VDD VSS _10413_/D NAND2X1
X_11392_ _11392_/A _11392_/B _11392_/C _11392_/D VDD VSS _11393_/B AOAI211X1
X_13200_ _18995_/Q _14257_/B VDD VSS _13203_/C _14257_/C NAND3X1
X_14180_ _14186_/A _14180_/B VDD VSS _18932_/D NOR2X1
XFILLER_109_399 VSS VDD FILLER2
X_10343_ _10343_/A _10343_/B _10343_/C _10343_/D VDD VSS _10417_/B AOAI211X1
X_13131_ _13131_/A _13131_/B _13131_/C _13131_/D VDD VSS _14478_/B OAOI211X1
XFILLER_140_829 VDD VSS FILLER1
XFILLER_78_401 VDD VSS FILLER1
X_10274_ _11436_/C _10274_/B _232_/E VDD VSS _11386_/C AOI21X1
X_13062_ _13131_/A _13131_/B _13131_/C VDD VSS _13125_/C OAI21X1
X_18207__253 _18259_/CK VDD VSS _20048_/CK INVX1
X_12013_ _19039_/Q VDD VSS _12285_/A INVX1
X_17870_ _18851_/Q _17870_/B _17870_/C VDD VSS _17876_/C MIN3X1
XFILLER_38_309 VDD VSS FILLER1
XFILLER_66_607 VDD VSS FILLER4
XFILLER_94_905 VDD VSS DECAPHV8
X_16821_ _16843_/A _16821_/B VDD VSS _19663_/D AND2X1
XFILLER_59_681 VDD VSS FILLER1
XFILLER_78_489 VDD VSS FILLER1
XFILLER_94_938 VDD VSS DECAPHV8
X_19540_ _19716_/CK _19540_/D _19540_/Q VDD VSS DFFQX1
X_16752_ _16759_/A _16752_/B VDD VSS _19601_/D NOR2X1
X_13964_ _13965_/A _13965_/C _13965_/B VDD VSS _14301_/A AO21X2
X_15703_ _15710_/A _15703_/B VDD VSS _19331_/D NOR2X1
XFILLER_19_567 VDD VSS FILLER4
X_12915_ _12915_/A _12915_/B _12915_/C _12915_/D VDD VSS _14319_/B OAOI211X1
X_13895_ _19004_/Q VDD VSS _13951_/A INVX1
X_19471_ _19495_/CK _19471_/D _19471_/Q VDD VSS DFFQX1
X_16683_ _16683_/A _16683_/B VDD VSS _16832_/B XNOR2X1
XFILLER_73_172 VDD VSS FILLER4
XFILLER_73_183 VSS VDD FILLER2
XFILLER_74_695 VSS VDD FILLER2
X_12846_ _12955_/A _12955_/B _12966_/C VDD VSS _14538_/B AO21X2
X_18422_ _18423_/CK _18470_/D _20177_/A _18444_/RB VDD VSS DFFRQX1
X_15634_ _19328_/Q VDD VSS _15635_/A INVX1
XFILLER_15_740 VDD VSS FILLER4
XFILLER_61_356 VDD VSS DECAPHV16
X_18353_ _18359_/CK _18465_/D _20221_/A _20065_/RB VDD VSS DFFRQX1
X_15565_ _19353_/Q _15728_/B VDD VSS _15566_/C NOR2BX1
XFILLER_9_33 VDD VSS FILLER4
X_12777_ _12868_/D _12915_/A _12916_/B VDD VSS _12799_/D XNOR3X1
X_14516_ _14766_/A _14516_/B VDD VSS _19223_/D AND2X1
X_17304_ _19818_/Q _19786_/Q VDD VSS _17309_/A XNOR2X1
X_11728_ _19199_/Q _11728_/B _11760_/C VDD VSS _11733_/C XNOR3X1
X_18284_ _18291_/CK _18284_/D _18284_/Q VDD VSS DFFQX1
X_15496_ _19323_/Q _15695_/B VDD VSS _15499_/A XOR2X1
X_11659_ _16273_/A VDD VSS _11669_/B BUFX3
X_14447_ _14421_/Y _14447_/B _14447_/C VDD VSS _19163_/D AND3BX1
X_17235_ _19802_/Q _19770_/Q _17236_/C VDD VSS _17237_/B AOI21X1
X_14378_ _14410_/A _14378_/B _14378_/C VDD VSS _19101_/D NOR3X1
X_17166_ _19788_/Q _19756_/Q VDD VSS _17168_/D XNOR2X1
XFILLER_143_634 VDD VSS FILLER1
X_13329_ _13329_/A _13329_/B _13329_/C _13329_/D VDD VSS _13466_/A AOAI211X1
X_16117_ _19619_/Q _16772_/B VDD VSS _16118_/B XNOR2X1
XFILLER_142_111 VSS VDD FILLER2
X_17097_ _17094_/B _17097_/B VDD VSS _17098_/C NOR2BX1
XFILLER_115_369 VSS VDD FILLER2
XFILLER_124_870 VDD VSS DECAPHV8
XFILLER_131_818 VDD VSS DECAPHV8
X_16048_ _16055_/C _16055_/B VDD VSS _16049_/B NAND2BX1
XFILLER_123_391 VDD VSS FILLER4
XFILLER_130_328 VSS VDD FILLER2
XFILLER_96_231 VDD VSS FILLER1
X_19807_ _19843_/CK _19807_/D _19807_/Q VDD VSS DFFQX1
XFILLER_85_949 VDD VSS FILLER1
X_17999_ _18541_/Q _18542_/Q VDD VSS _18044_/B _18042_/B AND3X2
XTAP_TAPCELL_ROW_95_966 VDD VSS WELLTAP
X_19738_ clkload4/A _19738_/D _19738_/Q VDD VSS DFFQX1
XFILLER_37_375 VDD VSS DECAPHV8
X_19669_ _19671_/CK _19669_/D _19669_/Q VDD VSS DFFQX1
XFILLER_52_323 VSS VDD FILLER2
XFILLER_80_621 VSS VDD FILLER2
X_09422_ _09816_/D _09422_/B VDD VSS _09447_/B NAND2BX1
XFILLER_52_356 VDD VSS FILLER1
XFILLER_80_687 VDD VSS FILLER4
X_09353_ _09362_/AB _09414_/D VDD VSS _09353_/Y NOR2BX1
XFILLER_33_570 VDD VSS DECAPHV8
XTAP_TAPCELL_ROW_50_513 VDD VSS WELLTAP
XFILLER_139_929 VDD VSS FILLER1
XTAP_TAPCELL_ROW_22_237 VDD VSS WELLTAP
X_09284_ _09362_/AB _09349_/B VDD VSS _09284_/Y NOR2BX1
XFILLER_106_303 VDD VSS FILLER1
XFILLER_118_174 VDD VSS FILLER1
XFILLER_134_623 VDD VSS DECAPHV16
XFILLER_107_859 VDD VSS FILLER1
XFILLER_69_49 VDD VSS FILLER4
Xclkload90 _19393_/CK VDD VSS clkload90/Y INVX1
XFILLER_0_625 VDD VSS FILLER4
XFILLER_102_531 VSS VDD FILLER2
XFILLER_102_553 VDD VSS FILLER4
XFILLER_48_607 VDD VSS FILLER4
XFILLER_102_586 VDD VSS FILLER1
XFILLER_47_106 VDD VSS FILLER1
XFILLER_75_426 VDD VSS FILLER1
XFILLER_18_75 VDD VSS DECAPHV16
XFILLER_55_150 VDD VSS FILLER1
XFILLER_90_407 VDD VSS FILLER4
X_10961_ _18648_/Q _18810_/Q VDD VSS _10962_/C NAND2X1
X_12700_ _18880_/Q VDD VSS _12884_/A INVX1
X_13680_ _14226_/A wire155/Y _14226_/C VDD VSS _13682_/B OAI21X1
XFILLER_70_142 VDD VSS DECAPHV8
XFILLER_71_676 VDD VSS DECAPHV16
XTAP_TAPCELL_ROW_38_392 VDD VSS WELLTAP
X_10892_ _19954_/Q _18836_/Q VDD VSS _10931_/B NAND2X1
X_12631_ _12731_/B _14315_/C _19046_/Q VDD VSS _12632_/D AND3BX1
XFILLER_11_220 VSS VDD FILLER2
XFILLER_34_85 VSS VDD FILLER2
XTAP_TAPCELL_ROW_5_67 VDD VSS WELLTAP
X_12562_ _12561_/A _14440_/B _14440_/C VDD VSS _12654_/C OR3BX1
X_15350_ _19459_/Q _15845_/B VDD VSS _15351_/C NAND2X1
XFILLER_8_736 VDD VSS DECAPHV8
X_11513_ _18666_/Q _11519_/B VDD VSS _18693_/D AND2X1
X_12493_ _20003_/Q _19267_/Q VDD VSS _12499_/C NAND2X1
X_14301_ _14301_/A _14301_/B _17827_/B VDD VSS _19033_/D AOI21X1
X_15281_ _15281_/A _15281_/B _15281_/C VDD VSS _15844_/C NOR3X1
XFILLER_50_51 VDD VSS FILLER1
XFILLER_7_257 VDD VSS FILLER4
X_11444_ _19939_/Q _17990_/A VDD VSS _18632_/D AND2X1
X_14232_ _14136_/Y _14232_/B _14232_/C VDD VSS _18977_/D AND3BX1
Xwire155 wire155/A VDD VSS wire155/Y BUFX4
Xwire166 wire166/A VDD VSS wire166/Y BUFX6
X_17020_ _18006_/C VDD VSS _17838_/A BUFX3
XFILLER_137_461 VDD VSS FILLER4
XFILLER_50_73 VSS VDD FILLER2
XFILLER_50_84 VDD VSS FILLER1
XFILLER_7_268 VDD VSS FILLER1
XFILLER_109_185 VDD VSS FILLER1
XTAP_TAPCELL_ROW_133_1347 VDD VSS WELLTAP
X_11375_ _18591_/Q _11375_/B _11375_/C VDD VSS _11381_/B MIN3X1
X_14163_ _14163_/A _14163_/B _14163_/C VDD VSS _18917_/D NOR3X1
XFILLER_125_667 VSS VDD FILLER2
XFILLER_140_615 VDD VSS DECAPHV8
X_10326_ _18686_/Q _18740_/Q VDD VSS _10329_/D XOR2X1
X_13114_ _13314_/A _13314_/B _13314_/D _13314_/C VDD VSS _14385_/C AOI211X1
X_14094_ _17975_/B _17975_/C VDD VSS _17969_/B OR2X2
X_18971_ _19001_/CK _18971_/D _18971_/Q VDD VSS DFFQX1
XFILLER_112_339 VSS VDD FILLER2
XFILLER_3_496 VSS VDD FILLER2
X_10257_ _18630_/Q _18792_/Q VDD VSS _10258_/C XOR2X1
X_13045_ _19191_/Q VDD VSS _13137_/A INVX1
X_17922_ _17927_/A _17927_/B VDD VSS _17923_/B XOR2X1
XFILLER_121_851 VSS VDD FILLER2
XFILLER_67_927 VSS VDD FILLER2
XFILLER_38_106 VDD VSS FILLER4
XFILLER_93_201 VDD VSS FILLER1
XFILLER_93_212 VDD VSS DECAPHV8
X_10188_ _10188_/A _10188_/B VDD VSS _10189_/C NAND2X1
X_17853_ _17853_/A _17853_/B _17853_/C VDD VSS _17868_/C MIN3X1
XFILLER_66_448 VDD VSS FILLER4
XFILLER_93_234 VDD VSS FILLER1
X_17784_ _19920_/Q _19888_/Q VDD VSS _17785_/C NAND2X1
X_16804_ _16811_/A _16804_/B VDD VSS _19647_/D NOR2X1
X_14996_ _19423_/Q _15806_/B _15806_/C VDD VSS _15045_/C NOR3BX1
XFILLER_19_375 VSS VDD FILLER2
XFILLER_46_150 VDD VSS FILLER1
X_13947_ _13957_/A _14198_/B _13957_/C VDD VSS _14199_/C NOR3X1
X_19523_ _19716_/CK _19523_/D _19523_/Q VDD VSS DFFQX1
X_16735_ _16735_/A _16735_/B VDD VSS _19586_/D NOR2X1
XFILLER_90_941 VDD VSS DECAPHV8
XTAP_TAPCELL_ROW_144_1454 VDD VSS WELLTAP
XTAP_TAPCELL_ROW_144_1465 VDD VSS WELLTAP
XTAP_TAPCELL_ROW_92_936 VDD VSS WELLTAP
X_19454_ _19483_/CK _19454_/D _19454_/Q VDD VSS DFFQX1
X_16666_ _16668_/B _16667_/B _18168_/C VDD VSS _16667_/C OAI21X1
X_13878_ _17924_/B _17924_/C _13929_/D _13929_/C VDD VSS _17940_/C AOI211X1
X_18405_ _18407_/CK _18405_/D _18405_/Q _20080_/RB VDD VSS DFFRQX1
X_15617_ _15617_/A _15617_/B _15617_/C VDD VSS _15637_/A OAI21X1
X_12829_ _12940_/A _12940_/B _12940_/C _12940_/D VDD VSS _13039_/A AOI31X1
X_19385_ _19385_/CK _19385_/D _19385_/Q VDD VSS DFFQX1
X_16597_ _19637_/Q _16597_/B _16791_/B VDD VSS _16622_/A MIN3X1
X_18336_ _18342_/CK _18336_/D _18336_/Q _18373_/RB VDD VSS DFFRQX1
X_15548_ _19465_/Q _15855_/B VDD VSS _15549_/B XNOR2X1
X_18267_ _18272_/CK _18267_/D _18267_/Q _20079_/RB VDD VSS DFFRQX1
X_15479_ _15515_/A _15515_/B VDD VSS _15884_/B XOR2X1
X_17218_ _19799_/Q _19767_/Q VDD VSS _17219_/B XOR2X1
X_18198_ _20014_/Q output5/A _18201_/A _20015_/Q VDD VSS _18199_/B AOI211X1
XFILLER_115_111 VDD VSS DECAPHV8
XFILLER_144_943 VSS VDD FILLER2
X_17149_ _17149_/A _17151_/C _17149_/C VDD VSS _19784_/D AOI21X1
XFILLER_115_166 VSS VDD FILLER2
XFILLER_116_689 VSS VDD FILLER2
XFILLER_89_507 VDD VSS DECAPHV8
X_20160_ _20160_/A VDD VSS _20160_/Y BUFX3
XFILLER_103_317 VDD VSS FILLER1
XFILLER_115_199 VDD VSS FILLER1
XFILLER_130_103 VDD VSS DECAPHV16
XTAP_TAPCELL_ROW_110_1111 VDD VSS WELLTAP
X_20091_ _20091_/A VDD VSS _20091_/Y BUFX3
XFILLER_130_136 VSS VDD FILLER2
XFILLER_58_949 VDD VSS FILLER1
XFILLER_84_223 VDD VSS FILLER1
XFILLER_38_673 VDD VSS DECAPHV8
XFILLER_44_109 VSS VDD FILLER2
XFILLER_111_35 VDD VSS FILLER4
XFILLER_25_356 VDD VSS FILLER4
XFILLER_52_120 VDD VSS FILLER1
XFILLER_52_142 VDD VSS FILLER4
XTAP_TAPCELL_ROW_108_1095 VDD VSS WELLTAP
X_09405_ _13283_/A _09405_/B VDD VSS _231_/E NAND2X1
XFILLER_34_890 VDD VSS FILLER1
XTAP_TAPCELL_ROW_35_362 VDD VSS WELLTAP
XFILLER_139_704 VDD VSS FILLER1
XFILLER_40_359 VDD VSS FILLER1
X_09336_ _18445_/D _09335_/Y _09302_/A VDD VSS _18514_/D MUXI2X1
X_09267_ _09301_/A _09277_/A VDD VSS _09354_/A NAND2BX1
XFILLER_119_461 VDD VSS FILLER4
X_09198_ _18513_/Q VDD VSS _18444_/D INVX1
XFILLER_107_645 VDD VSS FILLER4
XFILLER_107_678 VSS VDD FILLER2
XFILLER_20_54 VDD VSS DECAPHV8
XFILLER_20_76 VDD VSS FILLER4
X_11160_ _11364_/B _11221_/A VDD VSS _11184_/A NAND2X1
XFILLER_121_114 VDD VSS FILLER1
XFILLER_20_87 VSS VDD FILLER2
X_10111_ _10120_/A _10111_/B VDD VSS _11415_/C XOR2X1
X_11091_ _11263_/A _11128_/A VDD VSS _11122_/A NOR2X1
XFILLER_121_136 VDD VSS DECAPHV8
XFILLER_96_36 VSS VDD FILLER2
X_10042_ _18580_/Q _18581_/Q VDD VSS _10054_/B _10042_/C NAND3X1
XFILLER_0_488 VSS VDD FILLER2
XFILLER_29_41 VDD VSS FILLER1
XFILLER_49_927 VSS VDD FILLER2
XFILLER_49_949 VDD VSS FILLER1
XFILLER_75_201 VDD VSS FILLER1
XFILLER_29_96 VSS VDD FILLER2
XFILLER_75_234 VDD VSS FILLER4
X_14850_ _14850_/A _14850_/B _15707_/B VDD VSS _14855_/C MIN3X1
XFILLER_75_278 VDD VSS FILLER1
X_13801_ _18919_/Q _13809_/B _13918_/D VDD VSS _14132_/C XNOR3X1
X_14781_ _14781_/A _14781_/B _14872_/B _14781_/D VDD VSS _15865_/C AO22X2
X_11993_ _19998_/Q _19262_/Q VDD VSS _12055_/D NOR2X1
X_13732_ _13837_/A _13837_/B _13837_/D _13837_/C VDD VSS _13735_/B AOAI211X1
X_16520_ _19634_/Q _16788_/B VDD VSS _16521_/C NOR2X1
XFILLER_32_805 VSS VDD FILLER2
XFILLER_71_440 VSS VDD FILLER2
X_10944_ _10944_/A _10944_/B VDD VSS _10984_/B _10944_/C NAND3X1
XFILLER_32_827 VDD VSS FILLER4
X_10875_ _11078_/A _18727_/Q wire170/Y _10875_/D _10875_/E VDD VSS _10876_/C AOI221X1
X_13663_ _18889_/Q _13751_/A _13807_/B VDD VSS _13869_/D XNOR3X1
X_16451_ _16451_/A _16476_/C VDD VSS _16751_/B XNOR2X1
XFILLER_31_359 VDD VSS FILLER1
X_12614_ _18934_/Q VDD VSS _12617_/A INVX1
X_13594_ _13594_/A _13594_/B _13594_/C _13594_/D VDD VSS _13686_/B AOAI211X1
X_19170_ _19171_/CK _19170_/D _19170_/Q VDD VSS DFFQX1
X_16382_ _19725_/Q _16889_/B VDD VSS _16386_/B XNOR2X1
X_15402_ _15440_/B _15402_/B VDD VSS _15434_/B XNOR2X1
XFILLER_40_882 VDD VSS FILLER1
X_12545_ _19101_/Q VDD VSS _12557_/A INVX1
X_18121_ _18121_/A _18121_/B _18121_/C VDD VSS _18123_/C OA21X2
X_15333_ _15341_/B _15333_/B VDD VSS _15690_/B XNOR2X1
X_18052_ _18546_/Q _18052_/B VDD VSS _18053_/B NAND2X1
XFILLER_126_910 VDD VSS DECAPHV16
XFILLER_129_269 VDD VSS FILLER1
XFILLER_138_781 VDD VSS FILLER1
X_12476_ _19183_/Q _14469_/B VDD VSS _12483_/C _14469_/C NAND3X1
X_17003_ _19754_/Q _17049_/B _17006_/A _17006_/B VDD VSS _17004_/B AOAI211X1
X_15264_ _19402_/Q VDD VSS _15304_/A INVX1
XANTENNA_5 _14467_/A VDD VSS ANTENNA2
XFILLER_144_228 VSS VDD FILLER2
X_11427_ _18548_/D _11428_/B VDD VSS _18620_/D NOR2BX1
X_14215_ _14231_/A _14215_/B VDD VSS _18964_/D AND2X1
X_15195_ _15243_/A _15243_/B VDD VSS _15842_/B XOR2X1
X_11358_ _11379_/A _11358_/B _11358_/C VDD VSS _11364_/D OAI21X1
X_14146_ _14154_/A _14146_/B VDD VSS _18902_/D NOR2X1
XFILLER_113_637 VDD VSS FILLER1
XFILLER_125_486 VDD VSS FILLER4
XFILLER_140_401 VDD VSS FILLER1
XFILLER_4_772 VDD VSS FILLER4
XFILLER_4_783 VDD VSS FILLER1
X_10309_ _10312_/B _10310_/B _11386_/C VDD VSS _10310_/C OAI21X1
XTAP_TAPCELL_ROW_69_708 VDD VSS WELLTAP
X_11289_ _11289_/A VDD VSS _11370_/A BUFX3
X_14077_ _14089_/A _14078_/B _14078_/C VDD VSS _14140_/B OR3BX1
X_18954_ _18993_/CK _18954_/D _18954_/Q VDD VSS DFFQX1
X_13028_ _13028_/A _14445_/B VDD VSS _13111_/A OR2X2
X_18885_ _18936_/CK _18885_/D _18885_/Q VDD VSS DFFQX1
X_17905_ _17905_/A _17905_/B _17905_/C VDD VSS _17911_/C MIN3X1
XFILLER_66_223 VSS VDD FILLER2
XFILLER_94_543 VDD VSS FILLER1
X_17836_ _19934_/Q _17836_/B _18168_/C VDD VSS _17837_/B OAI21X1
XFILLER_82_738 VDD VSS FILLER1
XTAP_TAPCELL_ROW_77_785 VDD VSS WELLTAP
X_19506_ _19543_/CK _19506_/D _19506_/Q VDD VSS DFFQX1
X_17767_ _17768_/C _18127_/B _17767_/C VDD VSS _19916_/D AND3BX1
X_14979_ _19395_/Q _15774_/B VDD VSS _15026_/B NOR2X1
X_17698_ _19901_/Q _19869_/Q _17698_/C VDD VSS _17702_/B AOI21X1
X_16718_ _16718_/A _16724_/B VDD VSS _19570_/D NOR2X1
XFILLER_50_613 VDD VSS FILLER1
X_19437_ _19466_/CK _19437_/D _19437_/Q VDD VSS DFFQX1
X_16649_ _16649_/A _16649_/B _16793_/B VDD VSS _16674_/B MIN3X1
XFILLER_22_348 VDD VSS FILLER4
XTAP_TAPCELL_ROW_32_332 VDD VSS WELLTAP
X_19368_ _19547_/CK _19368_/D _19368_/Q VDD VSS DFFQX1
X_18319_ _18324_/CK _18516_/Q _18319_/Q _20079_/RB VDD VSS DFFRQX1
X_19299_ _19304_/CK _19299_/D _19299_/Q VDD VSS DFFQX1
XFILLER_136_718 VSS VDD FILLER2
XFILLER_116_453 VDD VSS FILLER4
X_20212_ _20212_/A VDD VSS _20212_/Y BUFX3
XFILLER_116_475 VDD VSS FILLER1
X_20143_ _20143_/A VDD VSS _20143_/Y BUFX3
X_09954_ _18599_/Q _09980_/B VDD VSS _09981_/C XOR2X1
Xclkbuf_leaf_9_clk_regs clkbuf_leaf_9_clk_regs/A VDD VSS _19892_/CK BUFX12
X_09885_ _09885_/A VDD VSS _10032_/A BUFX3
X_20074_ _20079_/CK _20074_/D _20074_/Q _20075_/RB VDD VSS DFFRQX1
XFILLER_112_692 VDD VSS FILLER4
XFILLER_122_23 VDD VSS FILLER4
XFILLER_85_565 VDD VSS DECAPHV16
XFILLER_25_164 VSS VDD FILLER2
XFILLER_82_49 VDD VSS FILLER1
XFILLER_13_326 VSS VDD FILLER2
XFILLER_25_197 VDD VSS FILLER1
XFILLER_41_646 VDD VSS FILLER4
XFILLER_53_495 VDD VSS FILLER1
X_10660_ _10960_/A _10660_/B VDD VSS _10661_/C NAND2X1
XFILLER_139_501 VDD VSS DECAPHV8
X_09319_ _18452_/RB _09346_/B VDD VSS _09319_/Y NOR2BX1
X_10591_ _10594_/A _10592_/D _10592_/A _10592_/B VDD VSS _10593_/B OA211X2
XFILLER_108_910 VSS VDD FILLER2
X_12330_ _12474_/A _12474_/C VDD VSS _12473_/C AND2X1
XFILLER_110_2 VDD VSS FILLER1
XFILLER_31_86 VSS VDD FILLER2
XTAP_TAPCELL_ROW_2_35 VDD VSS WELLTAP
X_12261_ _19070_/Q _12512_/B _14343_/B VDD VSS _14278_/B XNOR3X1
XFILLER_5_569 VDD VSS FILLER4
X_11212_ _11080_/Y _11267_/B _11298_/A VDD VSS _11307_/B MUXI2X1
X_14000_ _18977_/Q _14232_/B VDD VSS _14001_/D _14232_/C NAND3X1
XFILLER_122_401 VDD VSS FILLER1
XFILLER_123_924 VDD VSS FILLER4
XTAP_TAPCELL_ROW_130_1317 VDD VSS WELLTAP
X_12192_ _18985_/Q _12201_/B _12201_/C VDD VSS _14208_/B XNOR3X1
Xoutput31 _20115_/Y VDD VSS o_bias_cfg[17] BUFX3
Xoutput42 _20125_/Y VDD VSS o_bias_cfg[27] BUFX3
Xoutput7 output7/A VDD VSS o_aux_ctrl[0] BUFX3
Xoutput20 _20089_/Y VDD VSS o_aux_ctrl[7] BUFX3
X_11143_ _11143_/A _11173_/C VDD VSS _11144_/C XNOR2X1
Xoutput53 _20103_/Y VDD VSS o_bias_cfg[5] BUFX3
Xoutput64 _20148_/Y VDD VSS o_clk_cfg[15] BUFX3
Xoutput75 _20141_/Y VDD VSS o_clk_cfg[8] BUFX3
XFILLER_76_510 VDD VSS FILLER1
XFILLER_89_871 VDD VSS DECAPHV8
X_11074_ _18651_/Q _18813_/Q _11074_/C VDD VSS _11099_/C MIN3X1
Xoutput86 _20160_/Y VDD VSS o_en_ctrl[8] BUFX3
Xoutput97 _20166_/Y VDD VSS o_lf_cfg[3] BUFX3
X_15951_ _19610_/Q _16762_/B VDD VSS _16797_/B XNOR2X1
XFILLER_49_735 VSS VDD FILLER2
XFILLER_49_757 VDD VSS DECAPHV16
X_10025_ _18602_/Q VDD VSS _10026_/A INVX1
X_18670_ _19949_/CK _18670_/D _18670_/Q VDD VSS DFFQX1
X_15882_ _15895_/A _15882_/B VDD VSS _19489_/D NOR2X1
X_14902_ _19365_/Q _14902_/B _15740_/B VDD VSS _14954_/B MIN3X1
XFILLER_64_716 VDD VSS FILLER4
XFILLER_76_554 VDD VSS FILLER1
XFILLER_91_502 VDD VSS DECAPHV16
X_17621_ _19885_/Q _19853_/Q VDD VSS _17623_/B XOR2X1
XFILLER_17_610 VDD VSS DECAPHV8
XFILLER_48_289 VDD VSS FILLER4
XFILLER_64_738 VDD VSS FILLER4
XFILLER_76_598 VDD VSS FILLER4
X_14833_ _19448_/Q _14833_/B _14865_/C VDD VSS _14867_/C XNOR3X1
XFILLER_17_654 VDD VSS DECAPHV8
XTAP_TAPCELL_ROW_141_1424 VDD VSS WELLTAP
XTAP_TAPCELL_ROW_74_755 VDD VSS WELLTAP
X_11976_ _19177_/Q _14463_/B VDD VSS _12029_/C _14463_/C AND3X2
X_17552_ _19870_/Q _19838_/Q _17552_/C VDD VSS _17556_/B AOI21X1
X_14764_ _19306_/Q _15674_/B VDD VSS _14765_/B XOR2X1
XFILLER_16_153 VSS VDD FILLER2
XFILLER_44_451 VDD VSS FILLER4
XTAP_TAPCELL_ROW_46_479 VDD VSS WELLTAP
X_10927_ _10962_/A _10962_/B _10927_/C VDD VSS _10928_/C AOI21X1
X_13715_ _19113_/Q _14391_/B _14391_/C VDD VSS _13716_/D NOR3BX1
X_17483_ _19856_/Q _19824_/Q VDD VSS _17488_/A XNOR2X1
X_16503_ _16503_/A _16522_/B VDD VSS _16788_/B XOR2X1
X_14695_ _19389_/Q VDD VSS _14758_/A INVX1
XFILLER_72_60 VSS VDD FILLER2
XFILLER_72_71 VDD VSS DECAPHV16
X_13646_ _19083_/Q _14359_/B VDD VSS _13727_/A NAND2X1
X_19222_ _19250_/CK _19222_/D _19222_/Q VDD VSS DFFQX1
X_16434_ _16459_/B _16434_/B VDD VSS _16856_/B NOR2BX1
XFILLER_31_145 VSS VDD FILLER2
X_10858_ _18700_/Q _18754_/Q VDD VSS _10862_/A XNOR2X1
X_10789_ _10790_/A _10790_/B _10790_/D _10790_/C VDD VSS _10805_/A OAOI211X1
X_13577_ _18915_/Q _14161_/B VDD VSS _13591_/A NAND2X1
X_19153_ _19215_/CK _19153_/D _19153_/Q VDD VSS DFFQX1
X_16365_ _16365_/A _16365_/B VDD VSS _16392_/B NAND2X1
XFILLER_12_392 VDD VSS DECAPHV8
X_12528_ _12528_/A _12528_/B _14116_/B VDD VSS _12532_/C MIN3X1
X_19084_ _19085_/CK _19084_/D _19084_/Q VDD VSS DFFQX1
X_18104_ _18105_/A _18105_/B _18187_/C VDD VSS _18105_/C OAI21X1
X_16296_ _16296_/A _16296_/B VDD VSS _16297_/B _16296_/C NAND3X1
X_15316_ _19514_/Q _15909_/B VDD VSS _15359_/C NAND2BX1
X_12459_ _14345_/B _14345_/C _12460_/A VDD VSS _12461_/C OAI21X1
X_18035_ _18056_/A _18035_/B _18056_/C VDD VSS _19975_/D OAI21X1
X_15247_ _15247_/A _15247_/B VDD VSS _15813_/B XNOR2X1
XFILLER_114_902 VSS VDD FILLER2
X_15178_ _15178_/A _15178_/B _15178_/C VDD VSS _15223_/A AOI21X1
XFILLER_141_743 VDD VSS FILLER1
X_14129_ _18196_/A _14129_/B _14129_/C VDD VSS _18888_/D AND3BX1
X_19986_ _19986_/CK _19986_/D _19986_/Q VDD VSS DFFQX1
XFILLER_97_90 VSS VDD FILLER2
XFILLER_98_167 VDD VSS DECAPHV8
X_18937_ _18970_/CK _18937_/D _18937_/Q VDD VSS DFFQX1
X_09670_ _18446_/Q VDD VSS _20158_/A INVX1
XFILLER_94_340 VDD VSS DECAPHV8
X_18868_ _19197_/CK _18868_/D _18868_/Q VDD VSS DFFQX1
X_18799_ _18799_/CK _18799_/D _18799_/Q VDD VSS DFFQX1
X_17819_ _19928_/Q _19896_/Q VDD VSS _17823_/B XNOR2X1
XFILLER_54_248 VDD VSS FILLER4
XFILLER_54_259 VDD VSS DECAPHV8
XFILLER_23_613 VSS VDD FILLER2
XFILLER_35_484 VDD VSS FILLER1
XFILLER_63_771 VDD VSS DECAPHV8
XTAP_TAPCELL_ROW_105_1065 VDD VSS WELLTAP
XTAP_TAPCELL_ROW_17_181 VDD VSS WELLTAP
XFILLER_11_808 VSS VDD FILLER2
XFILLER_50_487 VDD VSS FILLER1
XFILLER_109_707 VDD VSS DECAPHV8
XFILLER_108_217 VDD VSS FILLER1
XFILLER_108_239 VDD VSS DECAPHV8
XTAP_TAPCELL_ROW_9_105 VDD VSS WELLTAP
XFILLER_104_423 VDD VSS FILLER1
XFILLER_117_45 VDD VSS FILLER1
XFILLER_144_581 VDD VSS FILLER4
XTAP_TAPCELL_ROW_116_1172 VDD VSS WELLTAP
XFILLER_104_456 VDD VSS FILLER1
XFILLER_78_808 VDD VSS FILLER4
Xclkbuf_leaf_41__001_ clkbuf_leaf_5__001_/A VDD VSS _19215_/CK BUFX12
XFILLER_131_253 VDD VSS DECAPHV8
XFILLER_89_156 VDD VSS DECAPHV8
XFILLER_89_189 VSS VDD FILLER2
X_09937_ _09981_/A _11399_/C VDD VSS _09955_/A NAND2X1
X_20126_ _20126_/A VDD VSS _20126_/Y BUFX3
XFILLER_120_949 VDD VSS FILLER1
X_20057_ clkload5/A _20057_/D _20057_/Q _20064_/RB VDD VSS DFFRQX1
XFILLER_133_55 VSS VDD FILLER2
XFILLER_46_716 VDD VSS FILLER4
X_09868_ _18574_/Q _09871_/B VDD VSS _09869_/B NAND2X1
XFILLER_45_215 VDD VSS DECAPHV8
X_09799_ _18438_/Q _09811_/B _09813_/C _20147_/A _09799_/E VDD VSS _09803_/B AOI221X1
XFILLER_26_42 VDD VSS FILLER4
X_11830_ _11830_/A _11830_/B _11830_/C _11830_/D VDD VSS _11918_/A OAOI211X2
XFILLER_26_473 VDD VSS FILLER4
XTAP_TAPCELL_ROW_127_1290 VDD VSS WELLTAP
XTAP_TAPCELL_ROW_71_725 VDD VSS WELLTAP
X_11761_ _11761_/A _11761_/B _14456_/B VDD VSS _11762_/B MIN3X1
XFILLER_14_635 VDD VSS DECAPHV8
XFILLER_54_793 VDD VSS DECAPHV16
XTAP_TAPCELL_ROW_43_449 VDD VSS WELLTAP
X_10712_ _18641_/Q _18803_/Q VDD VSS _10715_/D NOR2X1
X_13500_ _14159_/B _14159_/C _18914_/Q VDD VSS _13502_/B AOI21X1
XFILLER_41_476 VSS VDD FILLER2
XFILLER_9_105 VSS VDD FILLER2
X_11692_ _19987_/Q _19251_/Q VDD VSS _11716_/A OR2X2
X_14480_ _14766_/A _14480_/B VDD VSS _19193_/D AND2X1
XFILLER_13_189 VDD VSS DECAPHV16
X_10643_ _10718_/A _10718_/B VDD VSS _10675_/B NAND2X1
X_13431_ _19138_/Q _13617_/A _13617_/B VDD VSS _13432_/D XNOR3X1
XFILLER_127_504 VDD VSS DECAPHV8
X_10574_ _10574_/A VDD VSS _10576_/C INVX1
X_13362_ _19082_/Q _13418_/B _13437_/C VDD VSS _13601_/A XNOR3X1
X_16150_ _16150_/A _16150_/B _16880_/B VDD VSS _16174_/B MIN3X1
XFILLER_127_526 VDD VSS FILLER4
XFILLER_127_537 VDD VSS FILLER1
X_12313_ _12313_/A _14436_/B _12373_/C _12313_/D VDD VSS _12483_/A OAOI211X1
X_16081_ _19649_/Q _16081_/B _16806_/B VDD VSS _16106_/A MIN3X1
X_15101_ _19535_/Q _15146_/C VDD VSS _15102_/B NAND2X1
X_13293_ _13291_/B _13494_/A _13393_/B VDD VSS _13385_/C OR3BX1
X_15032_ _19312_/Q _15683_/B VDD VSS _15033_/B XNOR2X1
XFILLER_5_366 VDD VSS FILLER4
X_12244_ _12471_/A _12471_/B VDD VSS _14405_/B XNOR2X1
XFILLER_123_743 VDD VSS FILLER1
X_12175_ _12214_/A _12214_/B _12214_/D _12214_/C VDD VSS _14436_/C AOI211X1
X_19840_ _19843_/CK _19840_/D _19840_/Q VDD VSS DFFQX1
XFILLER_110_415 VSS VDD FILLER2
XFILLER_1_550 VDD VSS FILLER1
XTAP_TAPCELL_ROW_79_803 VDD VSS WELLTAP
X_11126_ _11126_/A _11126_/B _11126_/C VDD VSS _11158_/B MIN3X1
X_19771_ clkload4/A _19771_/D _19771_/Q VDD VSS DFFQX1
XFILLER_111_949 VDD VSS FILLER1
X_18722_ _18828_/CK _18722_/D _18722_/Q VDD VSS DFFQX1
X_16983_ _17151_/B _17011_/B VDD VSS _16994_/A XNOR2X1
XFILLER_110_459 VDD VSS FILLER4
XFILLER_49_576 VDD VSS DECAPHV8
XFILLER_64_502 VSS VDD FILLER2
XFILLER_67_82 VDD VSS FILLER1
XFILLER_77_852 VDD VSS FILLER4
XFILLER_92_800 VDD VSS DECAPHV8
X_11057_ _18572_/Q _11057_/B VDD VSS _11086_/A NAND2X1
X_15934_ _15948_/A _15948_/B VDD VSS _15935_/C NAND2X1
XFILLER_64_535 VDD VSS FILLER4
X_10008_ _10011_/B _10008_/B VDD VSS _11407_/C XOR2X1
X_18653_ _18817_/CK _18653_/D _18653_/Q VDD VSS DFFQX1
X_15865_ _14522_/Y _15865_/B _15865_/C VDD VSS _19474_/D AND3BX1
XFILLER_52_708 VDD VSS FILLER1
XFILLER_64_546 VDD VSS FILLER4
XFILLER_64_557 VDD VSS FILLER1
XFILLER_92_877 VDD VSS FILLER1
X_18584_ _18595_/CK _18584_/D _18584_/Q VDD VSS DFFQX1
X_17604_ _17606_/C _17604_/B _17604_/C VDD VSS _19881_/D AOI21X1
X_14816_ _19447_/Q _15832_/B VDD VSS _14908_/A NAND2X1
XFILLER_33_900 VDD VSS DECAPHV8
XFILLER_64_579 VDD VSS FILLER1
X_17535_ _19866_/Q _19834_/Q VDD VSS _17537_/C _17535_/C AND3X2
X_15796_ _15800_/A _15796_/B VDD VSS _19414_/D NOR2X1
XFILLER_32_421 VDD VSS FILLER4
XFILLER_33_933 VDD VSS FILLER1
XFILLER_83_92 VDD VSS FILLER1
XFILLER_91_398 VDD VSS FILLER1
X_11959_ _11959_/A _11959_/B _14336_/B VDD VSS _12014_/B MIN3X1
X_14747_ _15893_/B VDD VSS _14748_/B INVX1
X_14678_ _19499_/Q VDD VSS _14681_/A INVX1
X_17466_ _19852_/Q _19820_/Q VDD VSS _17468_/D XNOR2X1
XTAP_TAPCELL_ROW_14_151 VDD VSS WELLTAP
X_13629_ _13640_/A _13640_/B _13630_/C VDD VSS _14422_/B OR3X2
X_19205_ _19234_/CK _19205_/D _19205_/Q VDD VSS DFFQX1
X_17397_ _17395_/B _17397_/B VDD VSS _17398_/C NOR2BX1
X_16417_ _19662_/Q _16820_/B VDD VSS _16433_/A NOR2X1
XFILLER_9_650 VDD VSS FILLER1
X_19136_ _19137_/CK _19136_/D _19136_/Q VDD VSS DFFQX1
X_16348_ _16348_/A _16348_/B _16348_/C _16348_/D VDD VSS _16349_/B AOI211X1
X_19067_ _19096_/CK _19067_/D _19067_/Q VDD VSS DFFQX1
X_16279_ _19657_/Q _16815_/B VDD VSS _16296_/A NAND2BX1
X_18018_ _18528_/Q _18527_/Q _18529_/Q _18530_/Q VDD VSS _18019_/C AOI31X1
XFILLER_114_776 VDD VSS FILLER4
XFILLER_141_584 VDD VSS FILLER4
XFILLER_68_841 VDD VSS FILLER1
XFILLER_86_115 VDD VSS FILLER4
X_09722_ _18269_/Q _09818_/C _09722_/C _09788_/B VDD VSS _09731_/C AOI22X1
X_19969_ _19984_/CK _19969_/D _19969_/Q VDD VSS DFFQX1
XFILLER_68_863 VDD VSS FILLER4
XFILLER_28_727 VDD VSS FILLER4
XFILLER_68_896 VDD VSS FILLER1
X_09653_ _18445_/Q VDD VSS _20157_/A INVX1
Xclkbuf_2_0__f__001_ clkbuf_0__001_/Y VDD VSS clkbuf_leaf_5__001_/A BUFX12
XFILLER_27_237 VDD VSS DECAPHV8
XFILLER_55_557 VDD VSS FILLER1
X_09584_ _18345_/Q VDD VSS _20213_/A INVX1
XFILLER_36_793 VDD VSS FILLER4
XFILLER_51_730 VDD VSS DECAPHV8
XTAP_TAPCELL_ROW_40_419 VDD VSS WELLTAP
XFILLER_109_504 VDD VSS FILLER1
XFILLER_137_824 VDD VSS DECAPHV8
XFILLER_124_507 VDD VSS FILLER4
XFILLER_12_99 VDD VSS FILLER1
XFILLER_136_378 VDD VSS FILLER1
XFILLER_88_26 VDD VSS FILLER4
X_10290_ _10405_/A _10405_/B VDD VSS _10294_/B XNOR2X1
XFILLER_105_743 VDD VSS FILLER1
XFILLER_120_702 VDD VSS FILLER1
XFILLER_144_32 VDD VSS DECAPHV8
XFILLER_77_104 VDD VSS FILLER1
XFILLER_78_627 VDD VSS DECAPHV8
XFILLER_120_735 VDD VSS FILLER4
XFILLER_58_340 VDD VSS DECAPHV8
XFILLER_93_619 VDD VSS FILLER4
X_13980_ _18921_/Q _14168_/B VDD VSS _13995_/A NAND2X1
X_20109_ _20109_/A VDD VSS _20109_/Y BUFX3
XFILLER_19_738 VDD VSS FILLER1
XFILLER_86_693 VDD VSS FILLER4
X_12931_ _13028_/A _13039_/A _13108_/B VDD VSS _12932_/D XNOR3X1
XFILLER_100_492 VSS VDD FILLER2
XFILLER_37_85 VDD VSS DECAPHV8
XFILLER_46_546 VDD VSS FILLER1
XFILLER_46_568 VSS VDD FILLER2
X_12862_ _12938_/A _13107_/D _12925_/C VDD VSS _12939_/C XNOR3X1
X_15650_ _15672_/A _18179_/B VDD VSS _19301_/D NOR2X1
XFILLER_37_96 VDD VSS FILLER4
XTAP_TAPCELL_ROW_56_574 VDD VSS WELLTAP
X_11813_ _19062_/Q _14334_/B VDD VSS _11944_/B NOR2X1
X_14601_ _14601_/A _14601_/B _14615_/B _14601_/D VDD VSS _14624_/B AOI211X1
XFILLER_14_421 VDD VSS FILLER4
XFILLER_15_933 VSS VDD FILLER2
XFILLER_15_944 VSS VDD FILLER2
XTAP_TAPCELL_ROW_28_298 VDD VSS WELLTAP
X_12793_ _18936_/Q VDD VSS _12877_/A INVX1
X_15581_ _15597_/C _15597_/B VDD VSS _15582_/B NOR2BX1
X_11744_ _11751_/A _14520_/B VDD VSS _11835_/A NOR2X1
X_14532_ _14532_/A _14532_/B _17827_/B VDD VSS _19238_/D AOI21X1
X_17320_ _19820_/Q _19788_/Q _17320_/C VDD VSS _17325_/C AO21X2
X_11675_ _11675_/A _16704_/B VDD VSS _18839_/D NOR2X1
X_14463_ _14421_/Y _14463_/B _14463_/C VDD VSS _19177_/D AND3BX1
X_17251_ _17390_/A _17251_/B VDD VSS _19806_/D NOR2X1
XTAP_TAPCELL_ROW_11_121 VDD VSS WELLTAP
X_10626_ _10298_/Y _10624_/Y _11120_/A VDD VSS _10630_/B MUXI2X1
X_13414_ _19052_/Q _14323_/B VDD VSS _13415_/D _14322_/C AND3X2
X_17182_ _17185_/C _17183_/B _17229_/C VDD VSS _17183_/C OAI21X1
X_16202_ _16202_/A VDD VSS _16811_/B INVX1
XFILLER_127_301 VSS VDD FILLER2
X_14394_ _14415_/A _14394_/B VDD VSS _19116_/D AND2X1
X_16133_ _16133_/A _16133_/B _16772_/B VDD VSS _16155_/B MIN3X1
XFILLER_127_334 VDD VSS FILLER1
X_10557_ _18628_/Q _18719_/Q VDD VSS _10558_/D AND2X1
X_13345_ _13345_/A _13345_/B _13345_/C _13345_/D VDD VSS _14544_/B OAOI211X1
XFILLER_5_152 VDD VSS FILLER4
XTAP_TAPCELL_ROW_136_1378 VDD VSS WELLTAP
X_10488_ _19942_/Q _18824_/Q VDD VSS _10530_/A NAND2X1
X_13276_ _19025_/Q _14292_/B VDD VSS _13300_/C XNOR2X1
X_16064_ _16088_/C _16064_/B VDD VSS _16734_/B XNOR2X1
XFILLER_5_185 VDD VSS FILLER1
X_09974__244 _20081_/CK VDD VSS _18521_/CK INVX1
X_12227_ _20001_/Q _19265_/Q VDD VSS _12396_/A AND2X1
X_15015_ _15015_/A _15015_/B _15015_/C _15015_/D VDD VSS _15017_/B OAOI211X1
XFILLER_97_925 VDD VSS FILLER4
X_19823_ _19828_/CK _19823_/D _19823_/Q VDD VSS DFFQX1
XFILLER_111_724 VDD VSS FILLER4
XFILLER_68_115 VSS VDD FILLER2
XFILLER_68_137 VSS VDD FILLER2
XFILLER_78_70 VDD VSS DECAPHV8
X_12158_ _12158_/A _12158_/B _12158_/C _12158_/D VDD VSS _14499_/C OAI211X1
XFILLER_49_351 VSS VDD FILLER2
XFILLER_65_800 VSS VDD FILLER2
XFILLER_68_159 VSS VDD FILLER2
X_11109_ _18680_/Q _18788_/Q VDD VSS _11132_/B NAND2X1
X_12089_ _12155_/A _12116_/B _12091_/C VDD VSS _14434_/B AND3BX1
X_19754_ _19830_/CK _19754_/D _19754_/Q VDD VSS DFFQX1
X_16966_ _16971_/A _16968_/C _16966_/C VDD VSS _19748_/D AOI21X1
X_19685_ _19737_/CK _19685_/D _19685_/Q VDD VSS DFFQX1
X_18705_ _18817_/CK _18705_/D _18705_/Q VDD VSS DFFQX1
X_15917_ _19898_/Q _19546_/Q VDD VSS _16727_/B XNOR2X1
XTAP_TAPCELL_ROW_19_210 VDD VSS WELLTAP
X_18636_ _18799_/CK _18636_/D _18636_/Q VDD VSS DFFQX1
X_16897_ _16976_/A _16897_/B VDD VSS _19732_/D NOR2X1
XFILLER_92_663 VSS VDD FILLER2
XFILLER_92_674 VDD VSS DECAPHV8
X_15848_ _15867_/A _15848_/B VDD VSS _19460_/D NOR2X1
XFILLER_18_793 VDD VSS DECAPHV16
XFILLER_45_590 VDD VSS FILLER4
X_18567_ _18571_/CK _18567_/D _18567_/Q VDD VSS DFFQX1
X_15779_ _15779_/A VDD VSS _15780_/B INVX1
XTAP_TAPCELL_ROW_102_1035 VDD VSS WELLTAP
X_18498_ _18503_/CK _18498_/D _20111_/A _18503_/RB VDD VSS DFFRQX1
X_17518_ _19863_/Q _19831_/Q VDD VSS _17520_/B XNOR2X1
X_17449_ _19848_/Q VDD VSS _17600_/B INVX1
XFILLER_118_323 VSS VDD FILLER2
X_19119_ _19137_/CK _19119_/D _19119_/Q VDD VSS DFFQX1
XFILLER_133_315 VSS VDD FILLER2
XFILLER_134_827 VDD VSS FILLER1
XFILLER_0_807 VSS VDD FILLER2
XFILLER_0_829 VSS VDD FILLER2
XTAP_TAPCELL_ROW_113_1142 VDD VSS WELLTAP
XFILLER_102_735 VDD VSS FILLER4
XFILLER_59_104 VSS VDD FILLER2
XFILLER_87_424 VDD VSS FILLER4
XFILLER_75_619 VDD VSS FILLER1
XFILLER_87_468 VDD VSS FILLER1
XFILLER_68_660 VDD VSS FILLER1
XTAP_TAPCELL_ROW_98_997 VDD VSS WELLTAP
X_09705_ _20074_/Q _09770_/B _09812_/B _18304_/Q VDD VSS _09707_/A AOI22X1
XFILLER_67_181 VDD VSS FILLER4
XFILLER_95_490 VDD VSS DECAPHV16
X_09636_ _09636_/A _09636_/B _09812_/C _09636_/D VDD VSS _18283_/D AOAI211X1
XFILLER_16_708 VSS VDD FILLER2
XFILLER_28_579 VSS VDD FILLER2
XFILLER_43_505 VDD VSS DECAPHV8
XFILLER_70_302 VSS VDD FILLER2
XFILLER_24_730 VDD VSS DECAPHV16
XFILLER_36_590 VDD VSS DECAPHV8
XFILLER_55_398 VSS VDD FILLER2
XFILLER_70_324 VDD VSS FILLER1
XTAP_TAPCELL_ROW_124_1260 VDD VSS WELLTAP
X_09567_ _09815_/B VDD VSS _09811_/C BUFX3
XTAP_TAPCELL_ROW_53_544 VDD VSS WELLTAP
X_09498_ _18515_/Q _09501_/B _09506_/C _20072_/Q VDD VSS _20072_/D AO22X2
XFILLER_12_947 VSS VDD FILLER2
XTAP_TAPCELL_ROW_25_268 VDD VSS WELLTAP
XFILLER_139_43 VDD VSS FILLER4
XFILLER_23_87 VDD VSS FILLER1
X_11460_ _19953_/Q _11460_/B VDD VSS _18646_/D AND2X1
XFILLER_136_142 VDD VSS FILLER4
X_09958__228 _18259_/CK VDD VSS _18505_/CK INVX1
X_10411_ _10411_/A VDD VSS _10460_/A INVX1
X_11391_ _11392_/A _11392_/B _11392_/D _11392_/C VDD VSS _11391_/Y AOI211X1
XFILLER_125_827 VDD VSS DECAPHV8
XFILLER_137_698 VDD VSS FILLER4
X_10342_ _10343_/A _10343_/B _10343_/D _10343_/C VDD VSS _10342_/Y AOI211X1
X_13130_ _19219_/Q _13444_/A _13139_/B VDD VSS _13131_/D XNOR3X1
X_13061_ _19218_/Q _13061_/B VDD VSS _13131_/C _13061_/C NAND3X1
XFILLER_140_819 VDD VSS DECAPHV8
X_10273_ _18551_/Q _10306_/A VDD VSS _10312_/B NAND2X1
X_12012_ _19010_/Q _12012_/B _14273_/B VDD VSS _14240_/A MIN3X1
XFILLER_120_543 VDD VSS FILLER1
X_16820_ _16826_/A _16820_/B VDD VSS _19662_/D NOR2X1
XFILLER_59_671 VDD VSS DECAPHV8
XFILLER_65_107 VSS VDD FILLER2
X_16751_ _16759_/A _16751_/B VDD VSS _19600_/D NOR2X1
XFILLER_93_449 VDD VSS DECAPHV16
X_13963_ _19034_/Q _14302_/B VDD VSS _14010_/D XOR2X1
X_15702_ _15710_/A _15702_/B VDD VSS _19330_/D NOR2X1
XFILLER_34_505 VSS VDD FILLER2
X_12914_ _19077_/Q _13102_/A _13102_/B VDD VSS _12915_/D XNOR3X1
X_13894_ _13957_/A _14198_/B VDD VSS _13936_/B NOR2X1
X_19470_ _19495_/CK _19470_/D _19470_/Q VDD VSS DFFQX1
X_16682_ _19641_/Q _16796_/B VDD VSS _16683_/B XNOR2X1
XFILLER_73_195 VDD VSS DECAPHV8
X_12845_ _12955_/A _12955_/B VDD VSS _14538_/A _12966_/C NAND3X1
X_18421_ _18423_/CK _18469_/D _20176_/A _18453_/RB VDD VSS DFFRQX1
X_15633_ _15674_/A _18174_/B VDD VSS _19300_/D AND2X1
XFILLER_15_763 VDD VSS FILLER1
XFILLER_64_83 VDD VSS FILLER1
XFILLER_9_12 VSS VDD FILLER2
X_12776_ _19076_/Q _12776_/B _12821_/C VDD VSS _12916_/B XNOR3X1
X_18352_ _18359_/CK _18352_/D _18352_/Q _20065_/RB VDD VSS DFFRQX1
X_15564_ _15564_/A _15564_/B _15564_/C _15564_/D VDD VSS _15591_/A AOAI211X1
XFILLER_15_785 VDD VSS FILLER4
XFILLER_30_700 VDD VSS FILLER4
XFILLER_30_711 VSS VDD FILLER2
X_11727_ _14486_/A _11745_/D VDD VSS _11760_/C XNOR2X1
X_14515_ _14766_/A _14515_/B VDD VSS _19222_/D AND2X1
X_17303_ _17305_/C _17303_/B _17303_/C VDD VSS _19817_/D AOI21X1
XFILLER_30_766 VDD VSS FILLER1
X_18283_ _18291_/CK _18283_/D _18283_/Q VDD VSS DFFQX1
X_15495_ _15495_/A _15504_/B VDD VSS _15695_/B XOR2X1
XFILLER_128_632 VDD VSS DECAPHV8
XFILLER_80_93 VDD VSS FILLER4
X_11658_ _18798_/Q _11658_/B VDD VSS _18825_/D AND2X1
X_14446_ _14421_/Y _14446_/B _14446_/C VDD VSS _19162_/D AND3BX1
X_17234_ _19803_/Q _19771_/Q VDD VSS _17236_/C XOR2X1
X_10609_ _18666_/Q _18774_/Q VDD VSS _10642_/D NOR2X1
X_11589_ _18735_/Q _11589_/B VDD VSS _18762_/D AND2X1
X_14377_ _14393_/A _14377_/B VDD VSS _19100_/D NOR2X1
X_17165_ _17168_/A _17165_/B _17165_/C VDD VSS _19787_/D AOI21X1
XFILLER_116_827 VDD VSS FILLER4
XFILLER_128_676 VDD VSS FILLER1
XFILLER_143_602 VDD VSS DECAPHV16
X_13328_ _19192_/Q _14479_/B VDD VSS _13331_/C _14479_/C NAND3X1
X_16116_ _16134_/B _16116_/B VDD VSS _16772_/B XNOR2X1
X_17096_ _17391_/A VDD VSS _17390_/A BUFX3
XFILLER_143_668 VDD VSS FILLER1
X_13259_ _20012_/Q _19276_/Q VDD VSS _13345_/C NAND2X1
X_16047_ _19680_/Q _16840_/B VDD VSS _16055_/B NAND2X1
XFILLER_124_882 VDD VSS FILLER1
XFILLER_57_608 VDD VSS FILLER1
XFILLER_96_243 VDD VSS DECAPHV16
XFILLER_97_755 VDD VSS FILLER4
X_19806_ _19843_/CK _19806_/D _19806_/Q VDD VSS DFFQX1
XFILLER_38_822 VSS VDD FILLER2
XFILLER_56_107 VDD VSS FILLER4
X_19737_ _19737_/CK _19737_/D _19737_/Q VDD VSS DFFQX1
X_17998_ _18540_/Q _18038_/B VDD VSS _18042_/B AND2X1
XTAP_TAPCELL_ROW_95_967 VDD VSS WELLTAP
X_16949_ _19745_/Q _17078_/B VDD VSS _16951_/B XOR2X1
X_19668_ _19696_/CK _19668_/D _19668_/Q VDD VSS DFFQX1
XFILLER_37_387 VDD VSS FILLER1
XFILLER_53_836 VDD VSS FILLER1
X_09421_ _09421_/A _09520_/D _09421_/C VDD VSS _18228_/E AOI21X1
X_19599_ _19604_/CK _19599_/D _19599_/Q VDD VSS DFFQX1
X_18619_ _18622_/CK _18619_/D _18619_/Q VDD VSS DFFQX1
XFILLER_52_346 VDD VSS DECAPHV8
X_09352_ _09369_/B _09258_/B _09351_/Y VDD VSS _18509_/D MUXI2X1
XTAP_TAPCELL_ROW_50_514 VDD VSS WELLTAP
XFILLER_100_59 VDD VSS DECAPHV8
XFILLER_21_755 VDD VSS FILLER4
XFILLER_60_19 VSS VDD FILLER2
XTAP_TAPCELL_ROW_22_238 VDD VSS WELLTAP
X_09283_ _09349_/B _20046_/Q _09296_/A _09283_/D VDD VSS _18258_/D OAI31X1
XFILLER_138_429 VSS VDD FILLER2
XFILLER_119_654 VDD VSS DECAPHV8
XFILLER_118_142 VDD VSS DECAPHV8
Xclkload80 _19521_/CK VDD VSS clkload80/Y INVX2
XFILLER_133_167 VSS VDD FILLER2
XFILLER_88_700 VDD VSS DECAPHV8
Xclkload91 _19547_/CK VDD VSS clkload91/Y INVX2
XFILLER_102_510 VDD VSS FILLER1
XFILLER_133_189 VSS VDD FILLER2
XFILLER_0_659 VDD VSS FILLER4
XFILLER_130_841 VDD VSS DECAPHV8
XFILLER_88_755 VDD VSS FILLER1
XFILLER_125_78 VDD VSS DECAPHV8
XFILLER_18_32 VSS VDD FILLER2
XFILLER_18_43 VSS VDD FILLER2
XFILLER_87_298 VDD VSS FILLER1
XFILLER_28_343 VSS VDD FILLER2
XFILLER_29_888 VDD VSS FILLER1
XFILLER_44_825 VDD VSS DECAPHV16
XFILLER_56_652 VDD VSS FILLER4
XFILLER_56_663 VDD VSS DECAPHV8
X_10960_ _10960_/A VDD VSS _11364_/A BUFX3
XFILLER_16_549 VSS VDD FILLER2
XFILLER_44_847 VDD VSS FILLER1
XFILLER_56_696 VDD VSS FILLER1
XTAP_TAPCELL_ROW_66_680 VDD VSS WELLTAP
X_09619_ _18347_/Q VDD VSS _20215_/A INVX1
X_10891_ _19954_/Q _18836_/Q VDD VSS _10931_/D NOR2X1
XFILLER_31_508 VSS VDD FILLER2
XFILLER_43_357 VDD VSS FILLER1
XTAP_TAPCELL_ROW_38_393 VDD VSS WELLTAP
X_12630_ _12630_/A _12630_/B _12630_/C _12630_/D VDD VSS _14315_/C OAI211X1
XFILLER_12_700 VDD VSS FILLER4
XFILLER_52_880 VSS VDD FILLER2
X_12561_ _12561_/A _14439_/B _14440_/C VDD VSS _14441_/B AOI21BX1
XFILLER_129_418 VDD VSS DECAPHV8
XTAP_TAPCELL_ROW_5_68 VDD VSS WELLTAP
X_11512_ _18665_/Q _11519_/B VDD VSS _18692_/D AND2X1
X_12492_ _19213_/Q VDD VSS _12659_/A INVX1
X_14300_ _14352_/A _14300_/B _14300_/C VDD VSS _19032_/D NOR3X1
X_15280_ _15281_/A _15281_/B _15281_/C VDD VSS _15844_/B OA21X2
XFILLER_126_0 VSS VDD FILLER2
XFILLER_8_759 VSS VDD FILLER2
X_11443_ _19938_/Q _17990_/A VDD VSS _18631_/D AND2X1
X_14231_ _14231_/A _14231_/B VDD VSS _18976_/D AND2X1
XFILLER_125_624 VSS VDD FILLER2
X_14162_ _14163_/A _14162_/B _14162_/C VDD VSS _18916_/D NOR3X1
Xwire167 wire168/Y VDD VSS wire167/Y BUFX4
XFILLER_125_646 VDD VSS FILLER1
XTAP_TAPCELL_ROW_133_1348 VDD VSS WELLTAP
X_11374_ _11381_/C _11381_/A VDD VSS _11377_/B NOR2BX1
X_13113_ _13113_/A _13113_/B _13113_/C _13113_/D VDD VSS _14385_/B OAOI211X1
XFILLER_98_508 VSS VDD FILLER2
X_10325_ _10721_/D _10325_/B _10381_/C _10325_/D VDD VSS _10345_/A OAI31X1
X_14093_ _14093_/A _14093_/B _14093_/C _14093_/D VDD VSS _17975_/C OAOI211X1
X_18970_ _18970_/CK _18970_/D _18970_/Q VDD VSS DFFQX1
XFILLER_106_882 VDD VSS FILLER1
XFILLER_106_893 VDD VSS FILLER1
X_10256_ _19937_/Q _18819_/Q VDD VSS _10258_/B XOR2X1
X_13044_ _13138_/A _13138_/B VDD VSS _13122_/B NOR2X1
X_17921_ _18862_/Q _17921_/B _17921_/C VDD VSS _17927_/B XOR3X1
XFILLER_39_608 VDD VSS FILLER1
X_17852_ _18849_/Q _17868_/B VDD VSS _17855_/B XNOR2X1
X_10187_ _18616_/Q VDD VSS _10189_/A INVX1
X_16803_ _16843_/A _16803_/B VDD VSS _19646_/D AND2X1
XFILLER_38_129 VDD VSS FILLER4
XFILLER_82_909 VDD VSS DECAPHV16
XFILLER_94_747 VSS VDD FILLER2
X_17783_ _17785_/A _17785_/B _17783_/C VDD VSS _19920_/D AOI21X1
X_14995_ _14995_/A _14995_/B _14995_/C VDD VSS _15806_/C NOR3X1
XFILLER_19_365 VDD VSS FILLER4
XFILLER_35_814 VDD VSS FILLER1
XFILLER_81_419 VDD VSS FILLER1
X_13946_ _14001_/A _14001_/B _13957_/C VDD VSS _14199_/B AOI21BX1
X_19522_ _19533_/CK _19522_/D _19522_/Q VDD VSS DFFQX1
X_16734_ _16768_/A _16734_/B VDD VSS _19585_/D AND2X1
XFILLER_35_836 VDD VSS FILLER1
XFILLER_62_611 VDD VSS FILLER1
XFILLER_74_471 VDD VSS DECAPHV8
XTAP_TAPCELL_ROW_144_1455 VDD VSS WELLTAP
XTAP_TAPCELL_ROW_144_1466 VDD VSS WELLTAP
XTAP_TAPCELL_ROW_92_937 VDD VSS WELLTAP
X_19453_ _19483_/CK _19453_/D _19453_/Q VDD VSS DFFQX1
X_16665_ _19736_/Q _16901_/B VDD VSS _16667_/B XNOR2X1
X_13877_ _14133_/B _13877_/B _18891_/Q VDD VSS _13929_/C AND3BX1
X_18404_ _18407_/CK _18404_/D _18404_/Q _18452_/RB VDD VSS DFFRQX1
X_15616_ _19355_/Q _15730_/B VDD VSS _15617_/C NAND2X1
X_12828_ _14475_/C _19188_/Q _13036_/B VDD VSS _12940_/D AND3BX1
X_19384_ _19385_/CK _19384_/D _19384_/Q VDD VSS DFFQX1
X_16596_ _16596_/A VDD VSS _16791_/B INVX1
XFILLER_15_593 VSS VDD FILLER2
X_12759_ _12759_/A _14537_/B _14537_/C VDD VSS _12760_/D NOR3X1
X_18335_ _18342_/CK _18516_/Q _20089_/A _18373_/RB VDD VSS DFFRQX1
X_15547_ _19492_/Q _15547_/B _15885_/B VDD VSS _15855_/B MIN3X1
X_18266_ _18272_/CK _18266_/D _18266_/Q _20078_/RB VDD VSS DFFRQX1
X_15478_ _15514_/B _15478_/B VDD VSS _15515_/B XNOR2X1
X_14429_ _14456_/A _14429_/B VDD VSS _19146_/D NOR2X1
X_17217_ _19798_/Q _19766_/Q _17217_/C VDD VSS _17221_/B AOI21X1
XFILLER_7_770 VSS VDD FILLER2
X_18197_ _20014_/Q _20061_/Q _09421_/C _18197_/D VDD VSS _20014_/D AOI2B2BX1
XFILLER_115_123 VSS VDD FILLER2
XFILLER_143_410 VDD VSS FILLER1
X_17148_ _17149_/A _17151_/C _17164_/C VDD VSS _17149_/C OAI21X1
XFILLER_103_307 VDD VSS DECAPHV8
XFILLER_115_134 VDD VSS FILLER1
XFILLER_131_616 VSS VDD FILLER2
XFILLER_89_519 VSS VDD FILLER2
X_17079_ _17079_/A _17079_/B VDD VSS _17080_/B XNOR2X1
XFILLER_115_189 VDD VSS DECAPHV8
XTAP_TAPCELL_ROW_110_1112 VDD VSS WELLTAP
X_20090_ _20090_/A VDD VSS _20090_/Y BUFX3
XFILLER_29_118 VDD VSS DECAPHV8
XFILLER_97_563 VDD VSS FILLER1
XFILLER_84_235 VSS VDD FILLER2
XFILLER_85_747 VDD VSS DECAPHV8
XFILLER_85_769 VDD VSS DECAPHV8
XFILLER_37_140 VDD VSS DECAPHV8
XFILLER_111_14 VDD VSS FILLER4
XFILLER_111_25 VSS VDD FILLER2
XFILLER_80_452 VSS VDD FILLER2
XTAP_TAPCELL_ROW_108_1096 VDD VSS WELLTAP
X_09404_ _13283_/A _11440_/B VDD VSS _18229_/E NAND2X1
XTAP_TAPCELL_ROW_121_1230 VDD VSS WELLTAP
XTAP_TAPCELL_ROW_35_363 VDD VSS WELLTAP
XTAP_TAPCELL_ROW_63_650 VDD VSS WELLTAP
XFILLER_40_349 VDD VSS DECAPHV8
X_09335_ _18285_/Q _18513_/Q _09354_/B VDD VSS _09335_/Y MUXI2X1
XFILLER_21_552 VDD VSS FILLER4
X_09266_ _18277_/Q _18276_/Q _18278_/Q VDD VSS _09269_/C AOI21X1
X_09197_ _18514_/Q VDD VSS _18445_/D INVX1
XFILLER_112_6 VDD VSS FILLER1
XFILLER_119_484 VSS VDD FILLER2
XFILLER_134_432 VDD VSS FILLER4
XFILLER_135_933 VDD VSS DECAPHV16
XFILLER_134_454 VSS VDD FILLER2
XFILLER_136_33 VDD VSS DECAPHV8
XFILLER_1_924 VDD VSS FILLER1
X_10110_ _10120_/B _10122_/A VDD VSS _10111_/B NAND2X1
X_11090_ _11090_/A _11090_/B _11090_/C VDD VSS _11128_/A NOR3X1
XFILLER_121_148 VSS VDD FILLER2
XFILLER_1_946 VDD VSS FILLER4
X_10041_ _11208_/A VDD VSS _10131_/A BUFX3
XFILLER_130_671 VDD VSS FILLER1
XFILLER_29_75 VDD VSS FILLER1
XFILLER_75_246 VSS VDD FILLER2
XFILLER_91_706 VDD VSS FILLER4
X_11992_ _12055_/A _12055_/B _12055_/C VDD VSS _11996_/B OAI21X1
X_13800_ _18947_/Q _13921_/A _13987_/B VDD VSS _13918_/D XNOR3X1
X_14780_ _14781_/A _14781_/B VDD VSS _15865_/B _14872_/B _14781_/D NAND4X2
XFILLER_16_324 VDD VSS FILLER1
XFILLER_17_836 VDD VSS FILLER1
XFILLER_29_696 VDD VSS DECAPHV16
XFILLER_45_30 VSS VDD FILLER2
X_10943_ _11195_/A _10943_/B _10943_/C VDD VSS _10944_/C AOI21X1
X_13731_ _13731_/A _14327_/B _14327_/C VDD VSS _13837_/D NOR3X1
XFILLER_44_677 VSS VDD FILLER2
X_10874_ _10874_/A _10896_/C _10874_/C _10874_/D VDD VSS _10875_/E AOAI211X1
X_13662_ _13662_/A _13662_/B _13662_/C _13662_/D VDD VSS _13751_/A OAOI211X1
X_16450_ _19567_/Q _16715_/A _16450_/C VDD VSS _16476_/C MIN3X1
X_12613_ _18878_/Q _12613_/B _17861_/B VDD VSS _12790_/B MIN3X1
X_13593_ _18999_/Q _14261_/B VDD VSS _13686_/A NAND2X1
X_16381_ _16381_/A _16388_/C VDD VSS _16889_/B XNOR2X1
X_15401_ _19516_/Q _15911_/B VDD VSS _15402_/B XNOR2X1
XFILLER_101_91 VSS VDD FILLER2
XFILLER_61_51 VDD VSS FILLER4
X_12544_ _12544_/A _12544_/B _12544_/C _12544_/D VDD VSS _12634_/B AOAI211X1
X_18120_ _18121_/A _18121_/B _18121_/C VDD VSS _18122_/B NOR3X1
X_15332_ _15341_/A _15721_/B VDD VSS _15333_/B XNOR2X1
XFILLER_61_84 VSS VDD FILLER2
X_18051_ _18054_/A _18051_/B _18056_/A VDD VSS _19983_/D AOI21X1
XFILLER_138_771 VDD VSS DECAPHV8
X_12475_ _19184_/Q _12662_/A _12662_/B VDD VSS _12483_/D XNOR3X1
X_17002_ _19754_/Q _17049_/B _17006_/A _17006_/B VDD VSS _17002_/Y AOI211X1
X_15263_ _15305_/A _15305_/B VDD VSS _15289_/A NAND2X1
XANTENNA_6 _14467_/A VDD VSS ANTENNA2
XFILLER_137_270 VDD VSS DECAPHV8
XFILLER_138_793 VDD VSS DECAPHV8
X_11426_ _14163_/A _11429_/B _11426_/C VDD VSS _18619_/D NOR3X1
X_14214_ _14218_/A _14214_/B VDD VSS _18963_/D NOR2X1
X_15194_ _19484_/Q _15876_/B VDD VSS _15243_/B XNOR2X1
X_11357_ _11357_/A VDD VSS _11358_/C INVX1
X_14145_ _14154_/A _14145_/B VDD VSS _18901_/D NOR2X1
X_10308_ _10312_/A _10312_/C VDD VSS _10310_/B XNOR2X1
X_14076_ _14171_/B _18924_/Q VDD VSS _14089_/A NAND2BX1
X_18953_ _19171_/CK _18953_/D _18953_/Q VDD VSS DFFQX1
XFILLER_140_435 VSS VDD FILLER2
XTAP_TAPCELL_ROW_69_709 VDD VSS WELLTAP
X_11288_ _11298_/A _11288_/B _11298_/C VDD VSS _11363_/B OAI21X1
X_13027_ _13041_/A _14413_/B _13041_/C VDD VSS _14414_/B OAI21X1
X_17904_ _18859_/Q _17911_/B VDD VSS _17906_/B XNOR2X1
X_10239_ _18624_/Q _18623_/Q _10268_/B VDD VSS _10240_/D AOI2B1X1
X_18884_ _18936_/CK _18884_/D _18884_/Q VDD VSS DFFQX1
XFILLER_66_213 VDD VSS FILLER1
XFILLER_67_747 VSS VDD FILLER2
XFILLER_86_70 VDD VSS DECAPHV16
XFILLER_94_522 VSS VDD FILLER2
X_17835_ _19934_/Q _17836_/B VDD VSS _17842_/C AND2X1
XFILLER_54_408 VDD VSS DECAPHV8
XFILLER_82_728 VSS VDD FILLER2
X_17766_ _17766_/A _17766_/B _17766_/C _17766_/D VDD VSS _17767_/C AOAI211X1
XFILLER_35_633 VSS VDD FILLER2
XFILLER_47_471 VDD VSS FILLER1
XFILLER_81_238 VDD VSS FILLER4
XTAP_TAPCELL_ROW_77_786 VDD VSS WELLTAP
X_19505_ _19533_/CK _19505_/D _19505_/Q VDD VSS DFFQX1
X_16717_ _16717_/A _16724_/B VDD VSS _19569_/D NOR2X1
X_14978_ _19395_/Q _15774_/B VDD VSS _15026_/C NAND2X1
XFILLER_62_441 VSS VDD FILLER2
X_13929_ _17924_/B _17924_/C _13929_/C _13929_/D VDD VSS _13941_/B AOAI211X1
X_17697_ _17695_/B _17697_/B VDD VSS _17698_/C NOR2BX1
X_19436_ _19466_/CK _19436_/D _19436_/Q VDD VSS DFFQX1
X_16648_ _19639_/Q VDD VSS _16649_/A INVX1
XFILLER_50_636 VDD VSS FILLER4
XTAP_TAPCELL_ROW_60_620 VDD VSS WELLTAP
X_19367_ _19393_/CK _19367_/D _19367_/Q VDD VSS DFFQX1
X_16579_ _19637_/Q _16596_/A VDD VSS _16580_/B XOR2X1
XTAP_TAPCELL_ROW_32_333 VDD VSS WELLTAP
X_18318_ _18324_/CK _18515_/Q _18318_/Q _20078_/RB VDD VSS DFFRQX1
X_19298_ _19304_/CK _19298_/D _19298_/Q VDD VSS DFFQX1
X_18249_ _18255_/CK _18249_/D _18268_/D _20080_/RB VDD VSS DFFRQX1
XFILLER_116_421 VDD VSS FILLER4
XFILLER_117_933 VDD VSS FILLER1
XFILLER_143_240 VDD VSS FILLER4
X_20211_ _20211_/A VDD VSS _20211_/Y BUFX3
XFILLER_104_638 VDD VSS FILLER1
XFILLER_143_273 VDD VSS FILLER1
X_20142_ _20142_/A VDD VSS _20142_/Y BUFX3
XFILLER_98_861 VDD VSS FILLER4
X_09953_ _10034_/A _09953_/B _09953_/C _09953_/D VDD VSS _09980_/B AOAI211X1
XFILLER_112_671 VDD VSS DECAPHV8
XFILLER_131_468 VDD VSS DECAPHV32
XFILLER_98_894 VDD VSS FILLER1
X_09884_ _10966_/A _09884_/B _09884_/C VDD VSS _09884_/Y OAI21X1
X_20073_ _20081_/CK _20073_/D _20073_/Q _20075_/RB VDD VSS DFFRQX1
XFILLER_57_235 VDD VSS FILLER4
XFILLER_73_706 VDD VSS DECAPHV8
XFILLER_38_460 VDD VSS DECAPHV8
XFILLER_72_216 VSS VDD FILLER2
XFILLER_73_739 VDD VSS FILLER4
XFILLER_122_57 VDD VSS FILLER1
XFILLER_14_828 VDD VSS FILLER1
XFILLER_81_761 VDD VSS FILLER1
XFILLER_40_113 VDD VSS FILLER1
XFILLER_40_124 VDD VSS DECAPHV8
XFILLER_41_636 VDD VSS FILLER4
XFILLER_139_524 VDD VSS DECAPHV16
X_09318_ _18451_/D _09317_/Y _09302_/Y VDD VSS _18520_/D MUXI2X1
XFILLER_21_371 VDD VSS FILLER1
XFILLER_21_382 VDD VSS FILLER1
X_10590_ _10542_/B _18558_/Q VDD VSS _10592_/A NAND2BX1
XFILLER_127_719 VDD VSS FILLER1
X_09249_ _18496_/D VDD VSS _18336_/D INVX1
XTAP_TAPCELL_ROW_2_36 VDD VSS WELLTAP
X_12260_ _12451_/B _12451_/C VDD VSS _14343_/B NAND2X1
XFILLER_103_2 VDD VSS FILLER1
XFILLER_135_752 VDD VSS FILLER4
X_11211_ _11150_/Y _11244_/B _10947_/Y VDD VSS _11267_/B MUX2X1
X_12191_ _14243_/A _14244_/A _14277_/B VDD VSS _12201_/C XNOR3X1
XFILLER_134_284 VDD VSS FILLER1
XFILLER_1_710 VDD VSS FILLER1
XTAP_TAPCELL_ROW_130_1318 VDD VSS WELLTAP
X_11142_ _11469_/A _11142_/B _11142_/C VDD VSS _11173_/C MIN3X1
Xoutput32 _20116_/Y VDD VSS o_bias_cfg[18] BUFX3
Xoutput43 _20126_/Y VDD VSS o_bias_cfg[28] BUFX3
Xoutput8 output8/A VDD VSS o_aux_ctrl[10] BUFX3
Xoutput21 _20090_/Y VDD VSS o_aux_ctrl[8] BUFX3
Xoutput10 _20094_/Y VDD VSS o_aux_ctrl[12] BUFX3
Xdelaybuf_3_clk delaybuf_3_clk/A VDD VSS _18228_/CK BUFX12
XFILLER_1_732 VDD VSS FILLER1
XFILLER_89_850 VDD VSS FILLER1
Xoutput54 _20104_/Y VDD VSS o_bias_cfg[6] BUFX3
Xoutput65 _20149_/Y VDD VSS o_clk_cfg[16] BUFX3
Xoutput76 _20142_/Y VDD VSS o_clk_cfg[9] BUFX3
XFILLER_89_883 VSS VDD FILLER2
X_11073_ _18652_/Q _18814_/Q VDD VSS _11075_/A XOR2X1
Xoutput87 _20161_/Y VDD VSS o_en_ctrl[9] BUFX3
Xoutput98 _20167_/Y VDD VSS o_lf_cfg[4] BUFX3
X_15950_ _15950_/A _15950_/B VDD VSS _16800_/B XNOR2X1
XFILLER_48_235 VSS VDD FILLER2
X_10024_ _10021_/Y _10026_/C _17172_/A VDD VSS _18530_/D AND3BX1
X_15881_ _16768_/A _15881_/B VDD VSS _19488_/D AND2X1
X_14901_ _14901_/A _14901_/B _15710_/B VDD VSS _14952_/B MIN3X1
XFILLER_48_257 VDD VSS FILLER4
X_17620_ _19884_/Q _19852_/Q _17620_/C VDD VSS _17625_/C AO21X2
X_14832_ _19476_/Q _14918_/A _14918_/B VDD VSS _14865_/C XNOR3X1
XFILLER_17_622 VSS VDD FILLER2
XFILLER_91_547 VDD VSS FILLER4
XTAP_TAPCELL_ROW_141_1425 VDD VSS WELLTAP
XTAP_TAPCELL_ROW_74_756 VDD VSS WELLTAP
X_11975_ _11987_/A _14462_/B _11987_/C VDD VSS _14463_/C OR3X2
X_17551_ _17549_/B _17551_/B VDD VSS _17552_/C NOR2BX1
X_14763_ _14770_/B _14763_/B VDD VSS _15674_/B XNOR2X1
XFILLER_17_666 VDD VSS FILLER1
XFILLER_60_923 VSS VDD FILLER2
X_10926_ _18647_/Q _18809_/Q _10926_/C VDD VSS _10962_/B AOI21X1
X_13714_ _13714_/A _13714_/B _13714_/C _13714_/D VDD VSS _14391_/C OAOI211X1
X_17482_ _17484_/C _17482_/B _17482_/C VDD VSS _19855_/D AOI21X1
X_16502_ _19601_/Q _16502_/B _16752_/B VDD VSS _16522_/B MIN3X1
X_14694_ _14694_/A _14694_/B _15735_/B VDD VSS _14728_/B MIN3X1
XFILLER_44_496 VSS VDD FILLER2
XFILLER_71_271 VDD VSS FILLER4
X_10857_ _10857_/A _10890_/C VDD VSS _10876_/B XNOR2X1
X_13645_ _13728_/A _13728_/B _13728_/C VDD VSS _13649_/B OAI21X1
X_19221_ _19250_/CK _19221_/D _19221_/Q VDD VSS DFFQX1
X_16433_ _16433_/A _16433_/B _16433_/C VDD VSS _16434_/B NOR3X1
X_19152_ _19182_/CK _19152_/D _19152_/Q VDD VSS DFFQX1
X_10788_ _19951_/Q _18833_/Q VDD VSS _10790_/C XOR2X1
X_13576_ _13662_/A _13662_/B _13662_/C VDD VSS _14129_/B OAI21X1
X_18103_ _18109_/C _18109_/B VDD VSS _18105_/B NAND2BX1
X_16364_ _16345_/A _16364_/B VDD VSS _16365_/B NAND2BX1
XFILLER_117_207 VDD VSS FILLER1
X_12527_ _18904_/Q _12527_/B _12527_/C VDD VSS _14116_/B XNOR3X1
X_19083_ _19085_/CK _19083_/D _19083_/Q VDD VSS DFFQX1
X_16295_ _16296_/A _16296_/B _16296_/C VDD VSS _16308_/C AO21X2
X_15315_ _19514_/Q _15909_/B VDD VSS _15359_/D NOR2BX1
X_12458_ _12544_/A _12544_/B _12544_/D _12544_/C VDD VSS _14345_/C AOI211X1
X_18034_ _18538_/Q _18036_/B VDD VSS _18035_/B XNOR2X1
X_15246_ _15284_/D _15284_/C VDD VSS _15247_/B NOR2BX1
XFILLER_125_240 VDD VSS DECAPHV8
XFILLER_126_763 VSS VDD FILLER2
X_11409_ _11422_/A _17990_/B _11409_/C VDD VSS _18603_/D NOR3X1
XFILLER_114_947 VSS VDD FILLER2
X_12389_ _12472_/A _12472_/B _12472_/C VDD VSS _12416_/B AOI21X1
X_15177_ _19399_/Q _15778_/B VDD VSS _15178_/C NOR2BX1
X_14128_ _14142_/A _14128_/B VDD VSS _18887_/D NOR2X1
X_19985_ _19986_/CK _19985_/D _19985_/Q VDD VSS DFFQX1
XFILLER_79_360 VDD VSS DECAPHV8
XFILLER_98_179 VSS VDD FILLER2
X_14059_ _14078_/B _14139_/C _18896_/Q VDD VSS _14060_/D AND3BX1
X_18936_ _18936_/CK _18936_/D _18936_/Q VDD VSS DFFQX1
XFILLER_100_129 VDD VSS FILLER4
X_18867_ _18950_/CK _18867_/D _18867_/Q VDD VSS DFFQX1
XFILLER_39_246 VDD VSS FILLER1
X_17818_ _19927_/Q _19895_/Q _17818_/C VDD VSS _17823_/A AOI21X1
XFILLER_54_205 VDD VSS FILLER4
XFILLER_54_227 VDD VSS FILLER1
XFILLER_94_363 VDD VSS FILLER4
XFILLER_94_396 VDD VSS FILLER1
X_18798_ _18799_/CK _18798_/D _18798_/Q VDD VSS DFFQX1
XFILLER_82_569 VDD VSS FILLER1
X_17749_ _19913_/Q _19881_/Q VDD VSS _17752_/B XOR2X1
XFILLER_35_452 VDD VSS DECAPHV8
XFILLER_51_912 VDD VSS DECAPHV8
XFILLER_63_783 VSS VDD FILLER2
XTAP_TAPCELL_ROW_105_1066 VDD VSS WELLTAP
X_19419_ _19492_/CK _19419_/D _19419_/Q VDD VSS DFFQX1
XFILLER_23_669 VDD VSS FILLER1
XFILLER_50_455 VDD VSS FILLER1
XTAP_TAPCELL_ROW_17_182 VDD VSS WELLTAP
XFILLER_31_680 VSS VDD FILLER2
XTAP_TAPCELL_ROW_9_106 VDD VSS WELLTAP
XFILLER_132_700 VDD VSS FILLER4
XFILLER_2_529 VDD VSS FILLER1
XTAP_TAPCELL_ROW_116_1173 VDD VSS WELLTAP
XFILLER_116_295 VDD VSS FILLER1
XFILLER_89_135 VDD VSS DECAPHV8
XFILLER_89_168 VSS VDD FILLER2
X_09936_ _11398_/B _11398_/C _11398_/A VDD VSS _11399_/C OAI21X1
X_20125_ _20125_/A VDD VSS _20125_/Y BUFX3
XFILLER_58_522 VDD VSS FILLER4
X_20056_ clkload6/A _20056_/D _20057_/D _20069_/RB VDD VSS DFFRQX1
XFILLER_58_577 VDD VSS FILLER1
XFILLER_86_886 VSS VDD FILLER2
X_09867_ _18576_/Q _09947_/B VDD VSS _09867_/Y XOR2X1
X_09798_ _18470_/Q _09813_/B _09816_/D VDD VSS _09799_/E AO21X2
X_11760_ _19199_/Q _11760_/B _11760_/C VDD VSS _14456_/B XNOR3X1
XTAP_TAPCELL_ROW_71_726 VDD VSS WELLTAP
X_10711_ _18641_/Q _18803_/Q VDD VSS _10715_/B NAND2X1
XFILLER_13_157 VSS VDD FILLER2
X_11691_ _19224_/Q _14517_/B VDD VSS _11737_/B NOR2X1
X_10642_ _10642_/A _10642_/B _10642_/C _10642_/D VDD VSS _10718_/B AOI31X1
X_13430_ _13430_/A _13430_/B _13430_/C _13430_/D VDD VSS _13617_/A AOAI211X1
XFILLER_10_842 VSS VDD FILLER2
XFILLER_22_691 VSS VDD FILLER2
XFILLER_42_64 VDD VSS DECAPHV16
X_10573_ _18665_/Q _18773_/Q VDD VSS _10574_/A XNOR2X1
X_13361_ _13436_/A _13616_/D _13424_/C VDD VSS _13437_/C XNOR3X1
XFILLER_10_875 VDD VSS DECAPHV8
XFILLER_10_886 VDD VSS DECAPHV8
X_12312_ _12312_/A _14468_/B _14468_/C VDD VSS _12313_/D NOR3X1
X_13292_ _18913_/Q VDD VSS _13494_/A INVX1
X_16080_ _16074_/A _16080_/B _16080_/C VDD VSS _16104_/B AOI2B1X1
X_15100_ _15100_/A _15100_/B _15872_/B VDD VSS _15183_/A AOI21X1
XFILLER_108_763 VSS VDD FILLER2
X_12243_ _12307_/A _12373_/B _12373_/C VDD VSS _12471_/B XNOR3X1
X_15031_ _15037_/B _15031_/B VDD VSS _15683_/B XNOR2X1
XFILLER_107_273 VDD VSS FILLER4
XFILLER_123_700 VDD VSS DECAPHV16
XFILLER_107_295 VSS VDD FILLER2
XFILLER_123_755 VDD VSS DECAPHV16
XFILLER_69_809 VDD VSS DECAPHV8
X_12174_ _19180_/Q _14466_/B VDD VSS _12214_/C _14466_/C AND3X2
XFILLER_122_265 VDD VSS DECAPHV16
XFILLER_96_628 VDD VSS DECAPHV8
XTAP_TAPCELL_ROW_79_804 VDD VSS WELLTAP
X_11125_ _11272_/A _11125_/B VDD VSS _18574_/D NOR2X1
X_19770_ clkload4/A _19770_/D _19770_/Q VDD VSS DFFQX1
X_16982_ _19752_/Q VDD VSS _17151_/B INVX1
XFILLER_95_127 VSS VDD FILLER2
X_11056_ _11086_/B _11056_/B VDD VSS _18572_/D AND2X1
X_18721_ _18828_/CK _18721_/D _18721_/Q VDD VSS DFFQX1
X_15933_ _19612_/Q _16764_/B VDD VSS _15948_/B XOR2X1
XFILLER_103_490 VDD VSS FILLER1
X_10007_ _18601_/Q _10010_/B VDD VSS _10008_/B XOR2X1
XFILLER_18_920 VDD VSS FILLER4
XFILLER_36_205 VSS VDD FILLER2
XFILLER_37_739 VDD VSS FILLER4
XFILLER_92_812 VDD VSS FILLER1
XFILLER_92_823 VDD VSS DECAPHV8
XTAP_TAPCELL_ROW_87_881 VDD VSS WELLTAP
X_18652_ _19958_/CK _18652_/D _18652_/Q VDD VSS DFFQX1
X_15864_ _15867_/A _15864_/B VDD VSS _19473_/D NOR2X1
X_18583_ _18595_/CK _18583_/D _18583_/Q VDD VSS DFFQX1
X_17603_ _17606_/C _17604_/B _17654_/C VDD VSS _17604_/C OAI21X1
X_15795_ _15849_/A _15795_/B VDD VSS _19413_/D AND2X1
X_14815_ _14865_/A _14817_/C VDD VSS _15832_/B XNOR2X1
XFILLER_33_923 VDD VSS FILLER4
XFILLER_45_772 VDD VSS FILLER1
XFILLER_51_208 VDD VSS FILLER1
X_17534_ _19866_/Q _19834_/Q _17535_/C VDD VSS _17536_/B AOI21X1
X_14746_ _14746_/A _14746_/B _14746_/C _14746_/D VDD VSS _14872_/B AOAI211X1
XFILLER_33_945 VDD VSS FILLER1
XFILLER_45_794 VDD VSS FILLER4
XFILLER_60_720 VSS VDD FILLER2
XFILLER_83_82 VDD VSS DECAPHV8
X_11958_ _11962_/A _11962_/B _11958_/C VDD VSS _14336_/B XNOR3X1
XFILLER_60_764 VDD VSS FILLER4
X_10909_ _10927_/C _10909_/B _10909_/C _10909_/D VDD VSS _10910_/D OAI211X1
X_11889_ _11981_/C _11980_/B _11980_/C VDD VSS _12048_/B XNOR3X1
X_14677_ _14710_/A _14710_/B VDD VSS _14683_/B NOR2X1
X_19204_ _19234_/CK _19204_/D _19204_/Q VDD VSS DFFQX1
X_17465_ _17468_/A _17465_/B _17465_/C VDD VSS _19851_/D AOI21X1
XFILLER_20_617 VSS VDD FILLER2
XFILLER_20_639 VDD VSS DECAPHV8
XTAP_TAPCELL_ROW_14_152 VDD VSS WELLTAP
X_13628_ _13716_/A _13716_/B VDD VSS _13643_/B NOR2X1
X_17396_ _17675_/A _17396_/B VDD VSS _19837_/D NOR2X1
X_16416_ _16409_/A _16416_/B VDD VSS _16437_/B NOR2BX1
XFILLER_12_190 VSS VDD FILLER2
XFILLER_13_691 VDD VSS DECAPHV8
X_13559_ _14482_/A _14482_/B _13559_/C VDD VSS _13637_/C AOI21X1
X_19135_ _19137_/CK _19135_/D _19135_/Q VDD VSS DFFQX1
X_16347_ _16348_/A _16348_/B _16348_/D _16348_/C VDD VSS _16390_/B AOAI211X1
XFILLER_9_695 VDD VSS DECAPHV8
X_19066_ _19124_/CK _19066_/D _19066_/Q VDD VSS DFFQX1
X_18017_ _18049_/B VDD VSS _18045_/B BUFX3
X_16278_ _16278_/A _16278_/B _16850_/B VDD VSS _16299_/A MIN3X1
X_15229_ _19484_/Q _15876_/B VDD VSS _15243_/D NAND2X1
XFILLER_99_422 VSS VDD FILLER2
XFILLER_101_405 VSS VDD FILLER2
XFILLER_141_552 VSS VDD FILLER2
XFILLER_59_308 VSS VDD FILLER2
XFILLER_99_488 VDD VSS FILLER1
XFILLER_86_138 VDD VSS FILLER1
X_09721_ _20110_/A _20126_/A _09776_/A VDD VSS _09722_/C MUX2X1
X_19968_ _19986_/CK _19968_/D _19968_/Q VDD VSS DFFQX1
XFILLER_83_801 VDD VSS FILLER4
XFILLER_95_650 VDD VSS FILLER1
X_19899_ _19928_/CK _19899_/D _19899_/Q VDD VSS DFFQX1
Xclkbuf_2_0__f__000_ clkbuf_0__000_/Y VDD VSS clkload77/A BUFX12
X_18919_ _19004_/CK _18919_/D _18919_/Q VDD VSS DFFQX1
XFILLER_68_886 VDD VSS DECAPHV8
XFILLER_95_672 VDD VSS FILLER4
XFILLER_95_694 VDD VSS FILLER4
X_09652_ _18413_/Q VDD VSS _20168_/A INVX1
XFILLER_82_333 VDD VSS DECAPHV8
X_09583_ _18457_/Q VDD VSS _20099_/A INVX1
XFILLER_55_569 VDD VSS FILLER4
XFILLER_35_282 VSS VDD FILLER2
XFILLER_11_639 VDD VSS DECAPHV8
XFILLER_50_274 VSS VDD FILLER2
XFILLER_109_538 VDD VSS FILLER4
XFILLER_137_836 VDD VSS FILLER1
XFILLER_88_49 VSS VDD FILLER2
XFILLER_105_766 VDD VSS DECAPHV8
XFILLER_132_552 VDD VSS FILLER1
XFILLER_104_276 VDD VSS DECAPHV8
XFILLER_104_298 VDD VSS DECAPHV8
XFILLER_144_44 VDD VSS FILLER1
X_20108_ _20108_/A VDD VSS _20108_/Y BUFX3
XFILLER_59_875 VDD VSS DECAPHV8
X_09919_ _09944_/A _09919_/B VDD VSS _09920_/C NAND2X1
XFILLER_18_216 VDD VSS FILLER4
XFILLER_46_503 VDD VSS FILLER1
XFILLER_46_514 VDD VSS DECAPHV16
XFILLER_85_160 VDD VSS DECAPHV8
X_12930_ _19161_/Q VDD VSS _13028_/A INVX1
X_20039_ _20043_/CK _20039_/D _20039_/Q _20043_/RB VDD VSS DFFRQX1
XFILLER_37_53 VDD VSS FILLER4
X_12861_ _12932_/A _12932_/B _12932_/C VDD VSS _12925_/C OAI21X1
XFILLER_61_506 VDD VSS FILLER4
XFILLER_73_366 VDD VSS FILLER1
XTAP_TAPCELL_ROW_84_851 VDD VSS WELLTAP
X_11812_ _19090_/Q _11864_/B _11816_/C VDD VSS _14334_/B XNOR3X1
X_14600_ _19495_/Q _15888_/B VDD VSS _14624_/A AND2X1
XTAP_TAPCELL_ROW_28_299 VDD VSS WELLTAP
XTAP_TAPCELL_ROW_56_575 VDD VSS WELLTAP
X_12792_ _18909_/Q VDD VSS _12886_/A INVX1
X_15580_ _19410_/Q _15791_/B VDD VSS _15597_/B NOR2X1
XFILLER_14_455 VDD VSS FILLER4
XFILLER_42_742 VDD VSS DECAPHV16
X_11743_ _11769_/A _11769_/B VDD VSS _14520_/B XNOR2X1
X_14531_ _14522_/Y _14531_/B _14531_/C VDD VSS _19237_/D AND3BX1
XFILLER_42_786 VDD VSS FILLER4
X_11674_ _17812_/A VDD VSS _16704_/B BUFX3
X_14462_ _14490_/A _14462_/B _14462_/C VDD VSS _19176_/D NOR3X1
X_17250_ _17252_/B _17250_/B VDD VSS _17251_/B XOR2X1
XTAP_TAPCELL_ROW_11_122 VDD VSS WELLTAP
X_10625_ _10625_/A VDD VSS _11120_/A BUFX3
X_13413_ _14323_/B _14322_/C _19052_/Q VDD VSS _13415_/C AO21X2
X_17181_ _19791_/Q _19759_/Q VDD VSS _17183_/B XOR2X1
X_16201_ _16201_/A _16201_/B _16847_/B VDD VSS _16219_/A MIN3X1
XFILLER_127_313 VSS VDD FILLER2
X_14393_ _14393_/A _14393_/B VDD VSS _19115_/D NOR2X1
X_16132_ _19619_/Q VDD VSS _16133_/A INVX1
XFILLER_127_357 VDD VSS FILLER1
X_10556_ _10556_/A _10556_/B _10556_/C _10556_/D VDD VSS _10633_/B AOAI211X1
X_13344_ _13345_/A _13345_/B _13345_/D _13345_/C VDD VSS _14544_/A OA211X2
XFILLER_127_379 VDD VSS FILLER1
XTAP_TAPCELL_ROW_136_1379 VDD VSS WELLTAP
X_10487_ _10521_/A _10521_/B _10521_/C _10487_/D VDD VSS _10496_/B AOAI211X1
X_13275_ _13406_/A _13406_/B VDD VSS _14292_/B XNOR2X1
X_16063_ _19553_/Q _19905_/Q VDD VSS _16064_/B XNOR2X1
XFILLER_108_593 VDD VSS FILLER1
XFILLER_142_349 VDD VSS FILLER4
X_12226_ _12329_/A _12329_/B _12329_/E VDD VSS _12303_/B OAI21X1
X_15014_ _19504_/Q _15898_/B VDD VSS _15017_/A NOR2BX1
X_12157_ _12158_/A _12158_/B _12158_/D _12158_/C VDD VSS _12401_/B OAOI211X1
X_19822_ _19828_/CK _19822_/D _19822_/Q VDD VSS DFFQX1
XFILLER_110_213 VDD VSS FILLER4
XFILLER_111_747 VSS VDD FILLER2
XFILLER_68_105 VDD VSS FILLER4
XFILLER_96_425 VSS VDD FILLER2
XFILLER_97_948 VSS VDD FILLER2
X_11108_ _18680_/Q _18788_/Q VDD VSS _11132_/D NOR2X1
XFILLER_110_235 VDD VSS DECAPHV8
XFILLER_96_469 VSS VDD FILLER2
X_12088_ _12149_/A _12149_/B VDD VSS _12119_/B NOR2X1
X_19753_ _19830_/CK _19753_/D _19753_/Q VDD VSS DFFQX1
X_16965_ _16971_/A _16968_/C _17081_/C VDD VSS _16966_/C OAI21X1
XFILLER_110_268 VDD VSS DECAPHV8
X_11039_ _11070_/C _11040_/B _11039_/C VDD VSS _11040_/C OAI21X1
X_19684_ _19737_/CK _19684_/D _19684_/Q VDD VSS DFFQX1
X_18704_ _18811_/CK _18704_/D _18704_/Q VDD VSS DFFQX1
X_16896_ _16899_/A _16896_/B VDD VSS _19731_/D AND2X1
X_15916_ _15923_/A _15923_/B VDD VSS _16728_/B XNOR2X1
XFILLER_49_396 VDD VSS FILLER1
XFILLER_76_171 VDD VSS FILLER1
X_18635_ _18799_/CK _18635_/D _18635_/Q VDD VSS DFFQX1
X_15847_ _16776_/A VDD VSS _15867_/A BUFX3
XFILLER_18_761 VDD VSS FILLER1
XFILLER_91_141 VSS VDD FILLER2
XFILLER_17_282 VDD VSS FILLER4
XFILLER_18_783 VDD VSS FILLER1
XFILLER_33_731 VDD VSS FILLER4
XFILLER_64_388 VDD VSS FILLER4
X_18566_ _18571_/CK _18566_/D _18566_/Q VDD VSS DFFQX1
X_15778_ _15780_/A _15778_/B VDD VSS _19399_/D NOR2X1
XFILLER_17_293 VDD VSS DECAPHV8
XTAP_TAPCELL_ROW_102_1036 VDD VSS WELLTAP
Xclkbuf_leaf_40__001_ clkbuf_leaf_5__001_/A VDD VSS _19182_/CK BUFX12
X_18497_ _18503_/CK _18518_/Q _20110_/A _18503_/RB VDD VSS DFFRQX1
X_17517_ _17517_/A _17517_/B _17517_/C VDD VSS _17522_/A OA21X2
X_14729_ _19417_/Q VDD VSS _14730_/A INVX1
XFILLER_21_948 VSS VDD FILLER2
XFILLER_33_786 VDD VSS FILLER1
XFILLER_60_572 VDD VSS FILLER4
X_17448_ _17448_/A _17450_/C _17448_/C VDD VSS _19848_/D AOI21X1
XFILLER_119_836 VDD VSS FILLER1
XFILLER_119_847 VDD VSS DECAPHV8
X_19118_ _19196_/CK _19118_/D _19118_/Q VDD VSS DFFQX1
X_17379_ _17379_/A _17379_/B VDD VSS _17380_/B XNOR2X1
XFILLER_118_357 VSS VDD FILLER2
XFILLER_9_481 VSS VDD FILLER2
XFILLER_118_379 VDD VSS DECAPHV16
X_19049_ _19096_/CK _19049_/D _19049_/Q VDD VSS DFFQX1
XTAP_TAPCELL_ROW_113_1143 VDD VSS WELLTAP
XFILLER_101_213 VDD VSS DECAPHV16
XFILLER_114_14 VDD VSS DECAPHV32
XFILLER_4_90 VDD VSS FILLER1
XFILLER_28_514 VDD VSS DECAPHV16
XFILLER_56_823 VSS VDD FILLER2
XTAP_TAPCELL_ROW_98_998 VDD VSS WELLTAP
X_09704_ _18384_/Q VDD VSS _20189_/A INVX1
XFILLER_74_29 VDD VSS DECAPHV16
X_09635_ _09635_/A _09635_/B _09635_/C VDD VSS _09636_/D OA21X2
XFILLER_43_517 VDD VSS FILLER1
XFILLER_71_848 VSS VDD FILLER2
XTAP_TAPCELL_ROW_81_821 VDD VSS WELLTAP
X_09566_ _18505_/Q _09630_/C _18506_/Q VDD VSS _09815_/B AND3BX1
XFILLER_23_241 VDD VSS DECAPHV8
XTAP_TAPCELL_ROW_53_545 VDD VSS WELLTAP
X_09497_ _18445_/D _09501_/B _09497_/C VDD VSS _18236_/D AOI21X1
XFILLER_12_926 VDD VSS FILLER4
XFILLER_23_274 VDD VSS FILLER4
XTAP_TAPCELL_ROW_25_269 VDD VSS WELLTAP
XFILLER_7_429 VDD VSS FILLER4
X_10410_ _18688_/Q _18742_/Q VDD VSS _10411_/A XNOR2X1
XFILLER_109_357 VDD VSS DECAPHV8
XFILLER_137_666 VDD VSS FILLER4
X_11390_ _18594_/Q _11390_/B VDD VSS _11392_/C NOR2BX1
XFILLER_136_154 VSS VDD FILLER2
X_10341_ _19938_/Q _18820_/Q VDD VSS _10343_/C AND2X1
XFILLER_124_349 VSS VDD FILLER2
XFILLER_3_646 VDD VSS FILLER4
X_10272_ _18551_/Q _10306_/A VDD VSS _10272_/Y NOR2X1
X_13060_ _13061_/B _13061_/C _19218_/Q VDD VSS _13131_/B AOI21X1
X_12011_ _19011_/Q VDD VSS _14239_/A INVX1
XFILLER_132_360 VDD VSS DECAPHV16
XFILLER_133_883 VSS VDD FILLER2
XFILLER_78_414 VDD VSS FILLER4
XFILLER_79_948 VSS VDD FILLER2
XTAP_TAPCELL_ROW_89_910 VDD VSS WELLTAP
XFILLER_120_533 VSS VDD FILLER2
XFILLER_132_393 VDD VSS DECAPHV8
XFILLER_59_650 VDD VSS FILLER1
XFILLER_93_428 VDD VSS DECAPHV16
X_13962_ _13965_/A _13965_/C _13965_/B _13962_/D VDD VSS _14302_/B AOAI211X1
X_16750_ _16759_/A _16750_/B VDD VSS _19599_/D NOR2X1
XFILLER_19_536 VDD VSS DECAPHV8
XFILLER_48_96 VDD VSS DECAPHV8
X_12913_ _12913_/A _14348_/B _12913_/C _12913_/D VDD VSS _13102_/A AOAI211X1
X_15701_ _15710_/A _15701_/B VDD VSS _19329_/D NOR2X1
XFILLER_0_37 VDD VSS DECAPHV8
XFILLER_47_889 VDD VSS FILLER1
X_13893_ _13921_/A _13921_/B _13921_/D _13921_/C VDD VSS _14198_/B OAOI211X1
X_18420_ _18420_/CK _18521_/Q _20175_/A _18452_/RB VDD VSS DFFRQX1
X_16681_ _16681_/A _16681_/B VDD VSS _16796_/B XNOR2X1
XFILLER_73_185 VDD VSS FILLER1
X_12844_ _12953_/A _14475_/B VDD VSS _13032_/B NOR2X1
X_15632_ _15635_/B _15632_/B VDD VSS _18174_/B XNOR2X1
XFILLER_64_95 VDD VSS DECAPHV8
X_12775_ _19104_/Q _12775_/B _12910_/D VDD VSS _12821_/C XNOR3X1
X_18351_ _18359_/CK _18351_/D _18351_/Q _18370_/RB VDD VSS DFFRQX1
X_15563_ _15563_/A _15697_/B VDD VSS _15564_/D OR2X2
XFILLER_15_797 VDD VSS FILLER1
X_11726_ _11751_/A _11778_/A _11769_/B VDD VSS _11745_/D XNOR3X1
X_14514_ _14491_/Y _14514_/B _14514_/C VDD VSS _19221_/D AND3BX1
X_18282_ _18291_/CK _18282_/D _18282_/Q VDD VSS DFFQX1
X_17302_ _17305_/C _17303_/B _17306_/C VDD VSS _17303_/C OAI21X1
XFILLER_120_90 VSS VDD FILLER2
XFILLER_14_285 VDD VSS FILLER1
XFILLER_30_734 VSS VDD FILLER2
X_17233_ _19802_/Q _19770_/Q _17233_/C VDD VSS _19802_/D AOI21X1
X_15494_ _19351_/Q _15725_/B VDD VSS _15504_/B XOR2X1
X_11657_ _18797_/Q _11658_/B VDD VSS _18824_/D AND2X1
X_14445_ _14456_/A _14445_/B VDD VSS _19161_/D NOR2X1
X_10608_ _18665_/Q _18773_/Q VDD VSS _10642_/A NAND2X1
X_11588_ _18734_/Q _11589_/B VDD VSS _18761_/D AND2X1
X_14376_ _14316_/Y _14376_/B _14376_/C VDD VSS _19099_/D AND3BX1
X_17164_ _17168_/A _17165_/B _17164_/C VDD VSS _17165_/C OAI21X1
X_10539_ _10843_/A _10844_/B _10844_/C _10960_/A VDD VSS _10548_/C AOI211X1
X_13327_ _14479_/B _14479_/C _19192_/Q VDD VSS _13331_/B AOI21X1
X_17095_ _17095_/A _17095_/B VDD VSS _19773_/D NOR2X1
X_16115_ _16134_/A _16736_/B VDD VSS _16116_/B XNOR2X1
X_16046_ _19680_/Q _16840_/B VDD VSS _16055_/C NOR2X1
XFILLER_43_4 VDD VSS FILLER1
X_13258_ _13347_/A _14513_/B VDD VSS _13263_/B NOR2X1
XFILLER_123_360 VDD VSS DECAPHV8
X_12209_ _19097_/Q _14374_/B VDD VSS _12300_/A NOR2BX1
X_13189_ _18940_/Q _14190_/B VDD VSS _13290_/D _14190_/C NAND3X1
XFILLER_69_447 VDD VSS DECAPHV8
XFILLER_85_918 VDD VSS DECAPHV8
X_19805_ _19843_/CK _19805_/D _19805_/Q VDD VSS DFFQX1
X_17997_ _18538_/Q _18539_/Q VDD VSS _18038_/B _18036_/B AND3X2
XFILLER_96_277 VDD VSS DECAPHV8
X_19736_ _19736_/CK _19736_/D _19736_/Q VDD VSS DFFQX1
X_16948_ _17114_/B _17062_/C _16948_/C VDD VSS _16953_/C MIN3X1
XFILLER_65_642 VSS VDD FILLER2
XTAP_TAPCELL_ROW_95_968 VDD VSS WELLTAP
XFILLER_38_878 VDD VSS FILLER4
X_19667_ _19696_/CK _19667_/D _19667_/Q VDD VSS DFFQX1
X_16879_ _16891_/A _16879_/B VDD VSS _19715_/D NOR2X1
XFILLER_18_580 VDD VSS FILLER4
XFILLER_25_528 VDD VSS FILLER1
XFILLER_80_623 VDD VSS FILLER1
X_09420_ output5/A _18201_/A VDD VSS _09421_/C NOR2X1
X_19598_ _19636_/CK _19598_/D _19598_/Q VDD VSS DFFQX1
X_18618_ _18622_/CK _18618_/D _18618_/Q VDD VSS DFFQX1
XFILLER_18_591 VDD VSS DECAPHV8
X_09351_ _09414_/D _09351_/B _09351_/C VDD VSS _09351_/Y NOR3X1
X_18549_ _18550_/CK _18549_/D _18549_/Q VDD VSS DFFQX1
XFILLER_33_561 VDD VSS FILLER4
XFILLER_61_870 VDD VSS FILLER1
XTAP_TAPCELL_ROW_50_515 VDD VSS WELLTAP
X_09282_ _09349_/B _18258_/Q VDD VSS _09283_/D NAND2X1
XFILLER_20_222 VSS VDD FILLER2
XTAP_TAPCELL_ROW_22_239 VDD VSS WELLTAP
XFILLER_20_266 VDD VSS DECAPHV8
XFILLER_109_14 VDD VSS DECAPHV16
XFILLER_107_828 VDD VSS DECAPHV8
XFILLER_118_154 VSS VDD FILLER2
XFILLER_134_603 VDD VSS FILLER1
XFILLER_134_614 VDD VSS FILLER4
XFILLER_109_69 VDD VSS FILLER1
XFILLER_119_699 VDD VSS FILLER4
Xclkload70 _18950_/CK VDD VSS clkload70/Y INVX1
Xclkload92 _19425_/CK VDD VSS clkload92/Y INVX2
Xclkload81 _19489_/CK VDD VSS clkload81/Y INVX2
XFILLER_114_371 VDD VSS FILLER1
XFILLER_115_883 VSS VDD FILLER2
XFILLER_88_712 VSS VDD FILLER2
XFILLER_114_393 VDD VSS DECAPHV8
XFILLER_125_57 VSS VDD FILLER2
XFILLER_130_853 VSS VDD FILLER2
XFILLER_76_918 VDD VSS FILLER4
XFILLER_88_767 VDD VSS FILLER4
XFILLER_130_886 VDD VSS DECAPHV8
XFILLER_87_266 VDD VSS FILLER1
XFILLER_87_288 VSS VDD FILLER2
XFILLER_29_845 VSS VDD FILLER2
XFILLER_28_366 VDD VSS FILLER4
XFILLER_83_483 VSS VDD FILLER2
X_09618_ _09618_/A _09618_/B VDD VSS _18282_/D NAND2X1
X_10890_ _19953_/Q _18835_/Q _10890_/C VDD VSS _10931_/A MIN3X1
XFILLER_71_667 VSS VDD FILLER2
XTAP_TAPCELL_ROW_38_394 VDD VSS WELLTAP
X_09549_ _20043_/Q _18201_/A VDD VSS _20044_/D NOR2BX1
XFILLER_34_32 VDD VSS DECAPHV8
XFILLER_12_745 VSS VDD FILLER2
XFILLER_24_594 VDD VSS DECAPHV8
XFILLER_34_87 VDD VSS FILLER1
X_12560_ _19184_/Q _14471_/B VDD VSS _12561_/A NAND2X1
XFILLER_8_705 VDD VSS DECAPHV16
XTAP_TAPCELL_ROW_5_69 VDD VSS WELLTAP
X_11511_ _18664_/Q _11519_/B VDD VSS _18691_/D AND2X1
X_12491_ _12566_/A _12566_/B _12566_/D VDD VSS _12503_/B OAI21X1
XFILLER_50_31 VDD VSS DECAPHV8
X_11442_ _19937_/Q _17990_/A VDD VSS _18630_/D AND2X1
X_14230_ _14136_/Y _14230_/B _14230_/C VDD VSS _18975_/D AND3BX1
XFILLER_4_911 VDD VSS DECAPHV16
X_11373_ _11379_/A _11373_/B _11379_/C _18592_/Q VDD VSS _11381_/A AOI211X1
X_14161_ _14197_/A _14161_/B VDD VSS _18915_/D AND2X1
Xwire168 wire168/A VDD VSS wire168/Y BUFX4
XFILLER_125_636 VDD VSS DECAPHV8
XTAP_TAPCELL_ROW_133_1349 VDD VSS WELLTAP
X_10324_ _11078_/A _18713_/Q VDD VSS _10325_/D NAND2X1
X_13112_ _19135_/Q _13315_/A _13315_/B VDD VSS _13113_/D XNOR3X1
XFILLER_106_861 VSS VDD FILLER2
XFILLER_125_669 VDD VSS FILLER1
X_14092_ _14093_/A _14093_/B _14093_/D _14093_/C VDD VSS _17975_/B OA211X2
XFILLER_140_628 VDD VSS DECAPHV8
X_10255_ _10315_/A _10315_/B _10315_/C _10315_/D VDD VSS _10655_/A NOR4X2
X_13043_ _19190_/Q _14477_/B VDD VSS _13138_/A NOR2BX1
X_17920_ _17920_/A _17920_/B VDD VSS _17921_/B NOR2X1
XFILLER_132_190 VSS VDD FILLER2
XFILLER_59_73 VDD VSS DECAPHV8
X_10186_ _13177_/A _11422_/C VDD VSS _18544_/D NOR2X1
X_17851_ _17853_/C _17851_/B _17851_/C VDD VSS _19938_/D AOI21X1
XFILLER_120_341 VSS VDD FILLER2
XFILLER_67_929 VDD VSS FILLER1
XFILLER_94_704 VSS VDD FILLER2
X_16802_ _16811_/A _16802_/B VDD VSS _19645_/D NOR2X1
XFILLER_115_90 VSS VDD FILLER2
XFILLER_93_247 VSS VDD FILLER2
X_17782_ _17785_/A _17785_/B _17828_/C VDD VSS _17783_/C OAI21X1
X_14994_ _15003_/A _15805_/B _14995_/C VDD VSS _15806_/B AOI21BX1
XFILLER_35_804 VDD VSS DECAPHV8
XFILLER_75_50 VDD VSS DECAPHV8
XFILLER_93_258 VSS VDD FILLER2
X_13945_ _18976_/Q _14231_/B VDD VSS _14001_/A NAND2X1
X_19521_ _19521_/CK _19521_/D _19521_/Q VDD VSS DFFQX1
X_16733_ _16735_/A _16733_/B VDD VSS _19584_/D NOR2X1
XFILLER_62_634 VSS VDD FILLER2
XTAP_TAPCELL_ROW_144_1456 VDD VSS WELLTAP
XTAP_TAPCELL_ROW_144_1467 VDD VSS WELLTAP
XTAP_TAPCELL_ROW_92_938 VDD VSS WELLTAP
X_13876_ _13876_/A _14131_/B _13876_/C VDD VSS _14133_/B AOI21X1
X_19452_ _19483_/CK _19452_/D _19452_/Q VDD VSS DFFQX1
X_16664_ _16670_/B _16664_/B VDD VSS _16901_/B XNOR2X1
XFILLER_50_807 VDD VSS DECAPHV8
XFILLER_61_111 VSS VDD FILLER2
XFILLER_61_133 VDD VSS FILLER1
X_12827_ _12827_/A _12827_/B _12827_/C _12827_/D VDD VSS _13036_/B AOAI211X1
X_19383_ _19385_/CK _19383_/D _19383_/Q VDD VSS DFFQX1
X_18403_ _18407_/CK _18403_/D _18403_/Q _18452_/RB VDD VSS DFFRQX1
X_15615_ _19355_/Q _15730_/B VDD VSS _15617_/B NOR2X1
XFILLER_15_561 VDD VSS DECAPHV16
XFILLER_22_509 VSS VDD FILLER2
XFILLER_61_155 VDD VSS DECAPHV16
XFILLER_62_689 VSS VDD FILLER2
X_18334_ _18343_/CK _18515_/Q _20088_/A _18373_/RB VDD VSS DFFRQX1
X_16595_ _16582_/A _16595_/B _16595_/C VDD VSS _16621_/B AOI2B1X1
X_12758_ _14537_/B _14537_/C _12759_/A VDD VSS _12835_/D OAI21X1
X_15546_ _19464_/Q _15853_/B _15546_/C VDD VSS _15574_/B AOI21X1
XFILLER_30_542 VDD VSS FILLER1
X_11709_ _19226_/Q _11709_/B _11724_/C VDD VSS _11768_/B XNOR3X1
X_12689_ _19075_/Q _12689_/B _12804_/D VDD VSS _12731_/C XNOR3X1
X_18265_ _18272_/CK _18265_/D _18265_/Q _18485_/RB VDD VSS DFFRQX1
X_15477_ _19518_/Q _15913_/B VDD VSS _15478_/B XNOR2X1
X_14428_ _14457_/A VDD VSS _14456_/A BUFX3
X_18196_ _18196_/A _18196_/B VDD VSS _20013_/D NOR2X1
X_17216_ _17536_/A _17216_/B _17217_/C VDD VSS _19798_/D NOR3X1
XFILLER_116_603 VDD VSS FILLER1
X_17147_ _19783_/Q _19751_/Q _17147_/C VDD VSS _17151_/C MIN3X1
XFILLER_116_625 VDD VSS DECAPHV8
X_14359_ _14415_/A _14359_/B VDD VSS _19083_/D AND2X1
XFILLER_116_658 VDD VSS FILLER1
XFILLER_6_292 VDD VSS FILLER1
X_17078_ _19769_/Q _17078_/B VDD VSS _17079_/B XNOR2X1
XFILLER_115_168 VDD VSS FILLER1
XFILLER_143_488 VDD VSS DECAPHV8
XTAP_TAPCELL_ROW_110_1113 VDD VSS WELLTAP
X_16029_ _19679_/Q _16838_/B VDD VSS _16030_/C NOR2X1
XFILLER_112_831 VDD VSS FILLER1
XFILLER_130_138 VDD VSS FILLER1
XFILLER_58_907 VDD VSS FILLER4
XFILLER_69_222 VSS VDD FILLER2
XFILLER_97_531 VDD VSS DECAPHV16
XFILLER_69_255 VSS VDD FILLER2
XFILLER_84_203 VSS VDD FILLER2
XFILLER_85_726 VDD VSS FILLER1
XFILLER_38_631 VDD VSS FILLER1
X_19719_ _19730_/CK _19719_/D _19719_/Q VDD VSS DFFQX1
XFILLER_53_634 VDD VSS FILLER4
XFILLER_65_461 VDD VSS FILLER4
XFILLER_52_133 VDD VSS FILLER1
XTAP_TAPCELL_ROW_108_1097 VDD VSS WELLTAP
X_09403_ _09387_/B _18629_/Q _11429_/B VDD VSS _11440_/B AOI2B1X1
XFILLER_25_369 VSS VDD FILLER2
XFILLER_41_818 VSS VDD FILLER2
XTAP_TAPCELL_ROW_35_364 VDD VSS WELLTAP
XFILLER_33_391 VSS VDD FILLER2
XFILLER_40_328 VDD VSS FILLER4
X_09334_ _09380_/B _09346_/B VDD VSS _09334_/Y NOR2BX1
X_09265_ _09354_/B _09296_/A _09265_/C VDD VSS _09273_/A OAI21X1
X_09196_ _18515_/Q VDD VSS _18446_/D INVX1
XFILLER_134_411 VSS VDD FILLER2
XFILLER_122_628 VDD VSS FILLER4
XFILLER_88_531 VSS VDD FILLER2
XFILLER_96_38 VDD VSS FILLER1
X_10040_ _18604_/Q VDD VSS _10053_/A INVX1
XFILLER_0_479 VDD VSS FILLER1
XFILLER_29_21 VSS VDD FILLER2
XFILLER_48_417 VDD VSS FILLER1
XFILLER_49_929 VDD VSS FILLER1
XFILLER_130_683 VSS VDD FILLER2
XFILLER_48_439 VDD VSS FILLER4
XFILLER_17_804 VDD VSS FILLER4
X_11991_ _19997_/Q _19261_/Q VDD VSS _12055_/C NAND2X1
XFILLER_17_848 VDD VSS FILLER4
XFILLER_43_100 VSS VDD FILLER2
X_10942_ _11078_/A _18729_/Q _10942_/C _10942_/D VDD VSS _10943_/C AO22X2
X_13730_ _14327_/B _14327_/C _13731_/A VDD VSS _13837_/B OAI21X1
XFILLER_17_859 VDD VSS FILLER4
XFILLER_44_645 VDD VSS DECAPHV32
XFILLER_71_420 VSS VDD FILLER2
XFILLER_71_431 VSS VDD FILLER2
XFILLER_72_943 VDD VSS FILLER1
X_10873_ _10873_/A _10899_/C _10873_/C VDD VSS _10874_/D OAI21X1
X_13661_ _13661_/A _14162_/B _14162_/C VDD VSS _13662_/D NOR3X1
X_15400_ _19543_/Q _15439_/B VDD VSS _15911_/B XOR2X1
X_12612_ _12612_/A _14117_/B _12612_/C VDD VSS _12613_/B MIN3X1
X_13592_ _18917_/Q VDD VSS _13672_/A INVX1
X_16380_ _19693_/Q _16854_/B VDD VSS _16388_/C XOR2X1
XFILLER_40_862 VSS VDD FILLER2
XFILLER_61_41 VSS VDD FILLER2
X_12543_ _12543_/A _14377_/B VDD VSS _12634_/A OR2X2
X_15331_ _15343_/A _15343_/B VDD VSS _15721_/B XNOR2X1
X_18050_ _18546_/Q _18052_/B VDD VSS _18051_/B XNOR2X1
X_15262_ _15262_/A _15262_/B VDD VSS _15305_/B NAND2X1
X_12474_ _12474_/A _12474_/B _12474_/C _12474_/D VDD VSS _12662_/A AO31X2
X_14213_ _14231_/A _14213_/B VDD VSS _18962_/D AND2X1
X_17001_ _19755_/Q _17011_/B VDD VSS _17006_/B XOR2X1
XANTENNA_7 _20132_/Y VDD VSS ANTENNA2
X_11425_ _18546_/D _11428_/B VDD VSS _18618_/D NOR2BX1
X_15193_ _15875_/B _15193_/B _15193_/C VDD VSS _15876_/B XNOR3X1
X_11356_ _11364_/A _11364_/C _11356_/C VDD VSS _11359_/A AOI21X1
X_14144_ _14522_/A VDD VSS _14154_/A BUFX3
XFILLER_98_328 VDD VSS DECAPHV8
X_10307_ _10298_/Y _10299_/Y _10306_/Y VDD VSS _10312_/C MUXI2X1
X_14075_ _14158_/A _17968_/B VDD VSS _18869_/D AND2X1
X_18952_ _19171_/CK _18952_/D _18952_/Q VDD VSS DFFQX1
X_11287_ _11379_/A _11308_/A VDD VSS _11292_/A NOR2X1
X_13026_ _13212_/A _14352_/B VDD VSS _13067_/B NOR2X1
X_17903_ _17903_/A _17905_/C _17903_/C VDD VSS _19948_/D AOI21X1
XFILLER_121_650 VDD VSS FILLER1
XFILLER_121_672 VDD VSS FILLER4
X_10238_ _10274_/B _10362_/D VDD VSS _10240_/C NOR2X1
X_18883_ _18908_/CK _18883_/D _18883_/Q VDD VSS DFFQX1
XFILLER_66_203 VDD VSS FILLER1
X_10169_ _18614_/Q _10174_/B VDD VSS _10172_/D XNOR2X1
X_17834_ _18132_/A _17834_/B _17836_/B VDD VSS _19933_/D NOR3X1
XFILLER_66_258 VDD VSS DECAPHV16
X_17765_ _17766_/A _17766_/B _17766_/D _17766_/C VDD VSS _17768_/C AOI211X1
X_14977_ _15045_/A _15045_/B VDD VSS _15774_/B XOR2X1
XFILLER_47_461 VDD VSS FILLER4
XFILLER_63_921 VSS VDD FILLER2
XTAP_TAPCELL_ROW_77_787 VDD VSS WELLTAP
X_13928_ _18892_/Q _14134_/B VDD VSS _13941_/A NAND2X1
X_19504_ _19533_/CK _19504_/D _19504_/Q VDD VSS DFFQX1
X_16716_ _19920_/Q _16726_/B VDD VSS _19568_/D AND2X1
XFILLER_19_185 VDD VSS FILLER1
X_17696_ _17806_/A _17696_/B VDD VSS _19901_/D NOR2X1
XFILLER_35_689 VDD VSS DECAPHV8
XFILLER_90_784 VDD VSS FILLER4
X_13859_ _14363_/A _14363_/B _19087_/Q VDD VSS _13860_/D OAI21X1
X_19435_ _19435_/CK _19435_/D _19435_/Q VDD VSS DFFQX1
X_16647_ _16636_/B _16647_/B _16647_/C VDD VSS _16672_/B AOI2B1X1
XFILLER_62_486 VDD VSS DECAPHV8
X_19366_ _19547_/CK _19366_/D _19366_/Q VDD VSS DFFQX1
X_16578_ _16578_/A _16599_/B VDD VSS _16596_/A XNOR2X1
XFILLER_31_840 VDD VSS DECAPHV16
XTAP_TAPCELL_ROW_32_334 VDD VSS WELLTAP
X_19297_ _19304_/CK _19297_/D _19297_/Q VDD VSS DFFQX1
X_18317_ _18327_/CK _18477_/D _18317_/Q _20065_/RB VDD VSS DFFRQX1
X_15529_ _19352_/Q _15727_/B VDD VSS _15539_/B XNOR2X1
X_18248_ _18255_/CK _18248_/D _18269_/D _18485_/RB VDD VSS DFFRQX1
XFILLER_117_901 VSS VDD FILLER2
X_18179_ _18179_/A _18179_/B _18179_/C VDD VSS _18185_/A MIN3X1
X_20210_ _20210_/A VDD VSS _20210_/Y BUFX3
X_09952_ _11208_/A _09952_/B VDD VSS _09953_/D NAND2X1
X_20141_ _20141_/A VDD VSS _20141_/Y BUFX3
XFILLER_131_425 VDD VSS DECAPHV8
XFILLER_131_458 VDD VSS FILLER4
XFILLER_100_812 VDD VSS DECAPHV16
XFILLER_85_501 VDD VSS DECAPHV8
X_09883_ _10966_/A _09909_/B VDD VSS _09884_/C NAND2X1
X_20072_ _20081_/CK _20072_/D _20072_/Q _20072_/RB VDD VSS DFFRQX1
XFILLER_100_845 VDD VSS DECAPHV8
XFILLER_112_683 VSS VDD FILLER2
XFILLER_58_759 VDD VSS DECAPHV16
XFILLER_97_383 VDD VSS FILLER4
XFILLER_100_878 VDD VSS FILLER4
XFILLER_73_718 VSS VDD FILLER2
XFILLER_66_781 VSS VDD FILLER2
XFILLER_53_464 VDD VSS FILLER1
XFILLER_80_283 VDD VSS FILLER4
XFILLER_40_136 VSS VDD FILLER2
X_09317_ _18291_/Q _18519_/Q _09299_/Y VDD VSS _09317_/Y MUXI2X1
X_09248_ _18465_/D VDD VSS _18337_/D INVX1
XFILLER_5_527 VDD VSS FILLER1
XTAP_TAPCELL_ROW_2_37 VDD VSS WELLTAP
XFILLER_107_433 VSS VDD FILLER2
XFILLER_119_293 VSS VDD FILLER2
XFILLER_31_88 VDD VSS FILLER1
X_11210_ _11179_/Y _11209_/Y _10984_/A VDD VSS _11244_/B MUXI2X1
X_12190_ _19041_/Q _12203_/B _12203_/C VDD VSS _14277_/B XNOR3X1
XFILLER_122_414 VDD VSS FILLER4
XTAP_TAPCELL_ROW_130_1319 VDD VSS WELLTAP
X_11141_ _18842_/Q VDD VSS _11142_/B INVX1
Xoutput33 _20117_/Y VDD VSS o_bias_cfg[19] BUFX3
Xoutput9 output9/A VDD VSS o_aux_ctrl[11] BUFX3
Xoutput22 _20091_/Y VDD VSS o_aux_ctrl[9] BUFX3
Xoutput11 _20095_/Y VDD VSS o_aux_ctrl[13] BUFX3
XFILLER_134_296 VDD VSS FILLER1
XFILLER_89_840 VDD VSS FILLER1
Xoutput44 _20127_/Y VDD VSS o_bias_cfg[29] BUFX3
Xoutput55 _20105_/Y VDD VSS o_bias_cfg[7] BUFX3
Xoutput66 _20150_/Y VDD VSS o_clk_cfg[17] BUFX3
XFILLER_0_254 VSS VDD FILLER2
XFILLER_103_661 VSS VDD FILLER2
XFILLER_122_458 VSS VDD FILLER2
X_11072_ _11072_/A _11072_/B _11095_/C VDD VSS _11076_/B AOI21X1
Xoutput77 _20152_/Y VDD VSS o_en_ctrl[0] BUFX3
Xoutput88 _20163_/Y VDD VSS o_lf_cfg[0] BUFX3
Xoutput99 _20168_/Y VDD VSS o_lf_cfg[5] BUFX3
XFILLER_103_683 VDD VSS DECAPHV16
XFILLER_130_480 VDD VSS FILLER1
XFILLER_49_737 VDD VSS FILLER1
X_10023_ _18006_/C VDD VSS _17172_/A BUFX3
X_15880_ _16795_/A VDD VSS _16768_/A BUFX3
X_14900_ _19337_/Q VDD VSS _14901_/A INVX1
XFILLER_102_182 VDD VSS FILLER4
X_14831_ _15015_/A _14881_/B VDD VSS _14918_/B XNOR2X1
XFILLER_56_63 VDD VSS DECAPHV16
X_17550_ _17675_/A _17550_/B VDD VSS _19870_/D NOR2X1
XTAP_TAPCELL_ROW_74_757 VDD VSS WELLTAP
X_11974_ _11987_/A _14462_/B _11987_/C VDD VSS _14463_/B OAI21X1
X_16501_ _16501_/A VDD VSS _16752_/B INVX1
X_14762_ _19334_/Q _15706_/B VDD VSS _14763_/B XNOR2X1
XTAP_TAPCELL_ROW_141_1426 VDD VSS WELLTAP
X_10925_ _10925_/A _10925_/B VDD VSS _10926_/C NOR2X1
X_13713_ _19141_/Q _13719_/A _13719_/B VDD VSS _13714_/D XOR3X1
X_14693_ _19360_/Q VDD VSS _14694_/A INVX1
X_17481_ _17484_/C _17482_/B _17509_/C VDD VSS _17482_/C OAI21X1
XFILLER_31_114 VDD VSS FILLER4
XFILLER_72_62 VDD VSS FILLER1
X_10856_ _10856_/A _10856_/B _10856_/C _10856_/D VDD VSS _10890_/C AOI31X1
X_13644_ _19057_/Q _13709_/B _13781_/B VDD VSS _13837_/C XNOR3X1
X_19220_ _19250_/CK _19220_/D _19220_/Q VDD VSS DFFQX1
X_16432_ _16433_/A _16433_/B _16433_/C VDD VSS _16459_/B OAI21X1
XFILLER_72_95 VDD VSS FILLER4
XFILLER_9_811 VDD VSS FILLER1
X_19151_ _19187_/CK _19151_/D _19151_/Q VDD VSS DFFQX1
X_16363_ _19628_/Q _16782_/B VDD VSS _16365_/A NAND2BX1
XFILLER_13_895 VSS VDD FILLER2
XFILLER_40_681 VDD VSS FILLER1
X_10787_ _19950_/Q _18832_/Q VDD VSS _10790_/D OR2X2
X_13575_ _18887_/Q _13575_/B _13575_/C VDD VSS _13660_/A MIN3X1
X_18102_ _19287_/Q _18102_/B VDD VSS _18109_/B NAND2BX1
X_15314_ _19541_/Q _15399_/C VDD VSS _15909_/B XNOR2X1
X_12526_ _12533_/A _12609_/B _14149_/B VDD VSS _12532_/B XNOR3X1
X_19082_ _19137_/CK _19082_/D _19082_/Q VDD VSS DFFQX1
X_16294_ _19658_/Q _16816_/B VDD VSS _16296_/C XNOR2X1
X_12457_ _12457_/A _12457_/B _12457_/C _12457_/D VDD VSS _14345_/B OAOI211X1
X_18033_ _18036_/B _18045_/B _18033_/C _18049_/D VDD VSS _19974_/D OAI31X1
X_15245_ _15281_/B _15843_/B _19457_/Q VDD VSS _15284_/C AOI2B1X1
XFILLER_114_904 VDD VSS FILLER1
XFILLER_138_591 VDD VSS DECAPHV8
X_11408_ _18530_/D _11428_/B VDD VSS _18602_/D NOR2BX1
X_15176_ _15176_/A _15176_/B _15748_/B VDD VSS _15220_/A MIN3X1
XFILLER_113_414 VDD VSS DECAPHV16
XFILLER_125_263 VSS VDD FILLER2
X_12388_ _12331_/A _14469_/B _14469_/C VDD VSS _12472_/C AND3BX1
X_14127_ _14142_/A _14127_/B VDD VSS _18886_/D NOR2X1
XFILLER_98_125 VSS VDD FILLER2
X_11339_ _11339_/A _11339_/B VDD VSS _11342_/B OR2X2
X_19984_ _19984_/CK _19984_/D _19984_/Q VDD VSS DFFQX1
XFILLER_141_778 VSS VDD FILLER2
XFILLER_97_81 VSS VDD FILLER2
XFILLER_97_92 VDD VSS FILLER1
X_14058_ _14058_/A _14058_/B _14058_/C _14058_/D VDD VSS _14139_/C OAI211X1
X_18935_ _18935_/CK _18935_/D _18935_/Q VDD VSS DFFQX1
XFILLER_140_288 VDD VSS DECAPHV8
X_13009_ _13097_/A _13097_/B VDD VSS _13070_/B NOR2X1
Xclkbuf_leaf_17_clk_regs clkload1/A VDD VSS clkload6/A BUFX12
X_18866_ _18950_/CK _18866_/D _18866_/Q VDD VSS DFFQX1
X_17817_ _17815_/B _17817_/B VDD VSS _17818_/C NOR2BX1
X_18797_ _18797_/CK _18797_/D _18797_/Q VDD VSS DFFQX1
X_17748_ _17748_/A _17748_/B _17748_/C VDD VSS _17754_/C MIN3X1
XFILLER_23_615 VDD VSS FILLER1
XFILLER_35_464 VDD VSS FILLER1
X_17679_ _19897_/Q _19865_/Q VDD VSS _17680_/B XNOR2X1
XFILLER_23_637 VDD VSS DECAPHV8
XFILLER_62_283 VDD VSS DECAPHV16
XTAP_TAPCELL_ROW_105_1067 VDD VSS WELLTAP
XTAP_TAPCELL_ROW_45_470 VDD VSS WELLTAP
X_19418_ _19492_/CK _19418_/D _19418_/Q VDD VSS DFFQX1
XTAP_TAPCELL_ROW_17_183 VDD VSS WELLTAP
X_19349_ _19362_/CK _19349_/D _19349_/Q VDD VSS DFFQX1
XFILLER_105_915 VDD VSS FILLER4
XFILLER_116_241 VDD VSS FILLER1
XFILLER_116_263 VDD VSS FILLER4
XFILLER_117_797 VDD VSS FILLER4
XFILLER_132_712 VSS VDD FILLER2
XTAP_TAPCELL_ROW_116_1174 VDD VSS WELLTAP
XTAP_TAPCELL_ROW_9_107 VDD VSS WELLTAP
XFILLER_104_436 VDD VSS DECAPHV16
XFILLER_105_948 VSS VDD FILLER2
XFILLER_104_469 VSS VDD FILLER2
XFILLER_132_789 VDD VSS FILLER1
X_09935_ _18598_/Q _09935_/B VDD VSS _11398_/A XOR2X1
X_20124_ _20124_/A VDD VSS _20124_/Y BUFX3
XFILLER_131_277 VSS VDD FILLER2
XFILLER_98_670 VDD VSS DECAPHV16
X_09866_ _18574_/Q _18575_/Q VDD VSS _09947_/B _09871_/B NAND3X1
X_20055_ clkload6/A _20192_/A _20056_/D _20069_/RB VDD VSS DFFRQX1
XFILLER_133_57 VDD VSS FILLER1
X_09797_ _18310_/Q _09797_/B _09797_/C _20211_/A _09797_/E VDD VSS _09803_/A AOI221X1
XFILLER_45_228 VDD VSS FILLER4
XFILLER_45_239 VDD VSS DECAPHV8
Xdelaybuf_2_sclk delaybuf_2_sclk/A VDD VSS delaybuf_3_sclk/A BUFX12
XFILLER_42_902 VDD VSS DECAPHV8
XTAP_TAPCELL_ROW_127_1281 VDD VSS WELLTAP
XFILLER_54_784 VDD VSS FILLER4
XTAP_TAPCELL_ROW_71_727 VDD VSS WELLTAP
X_10710_ _11263_/A _10785_/A VDD VSS _10740_/A NOR2X1
XFILLER_9_107 VDD VSS FILLER1
X_11690_ _11706_/A _11716_/B VDD VSS _14517_/B XNOR2X1
XFILLER_10_821 VDD VSS FILLER1
X_10641_ _18667_/Q _18775_/Q VDD VSS _10718_/A XOR2X1
XFILLER_139_355 VDD VSS DECAPHV8
X_10572_ _18664_/Q _18772_/Q VDD VSS _10576_/D AND2X1
X_13360_ _13432_/A _13432_/B _13432_/C VDD VSS _13424_/C OAI21X1
XFILLER_21_191 VDD VSS FILLER1
XFILLER_6_814 VDD VSS FILLER4
X_12311_ _12329_/A _12329_/B _12329_/E _12311_/D VDD VSS _14468_/C OAOI211X1
X_13291_ _13393_/B _13291_/B _18913_/Q VDD VSS _13385_/B AOI2B1X1
XFILLER_10_898 VDD VSS FILLER1
X_12242_ _12312_/A _12303_/B _12303_/C VDD VSS _12373_/C XNOR3X1
X_15030_ _19340_/Q _15714_/B VDD VSS _15031_/B XOR2X1
XFILLER_135_572 VDD VSS FILLER1
XFILLER_5_379 VSS VDD FILLER2
XFILLER_135_594 VDD VSS FILLER4
X_12173_ _19181_/Q _12329_/A _12218_/B VDD VSS _12214_/D XNOR3X1
XFILLER_96_607 VDD VSS DECAPHV8
XTAP_TAPCELL_ROW_79_805 VDD VSS WELLTAP
X_11124_ _11126_/B _11124_/B VDD VSS _11125_/B XNOR2X1
X_16981_ _16979_/Y _16981_/B _17986_/C VDD VSS _19751_/D AND3BX1
XFILLER_110_417 VDD VSS FILLER1
XFILLER_49_512 VSS VDD FILLER2
XFILLER_67_51 VDD VSS FILLER1
X_11055_ _11055_/A _11055_/B _11055_/C _11273_/A VDD VSS _11056_/B AOI31X1
X_18720_ _18801_/CK _18720_/D _18720_/Q VDD VSS DFFQX1
X_15932_ _19611_/Q _16763_/B _15950_/A VDD VSS _15948_/A MIN3X1
X_10006_ _11208_/A _10107_/B _10006_/C VDD VSS _10010_/B AOI21X1
XFILLER_64_504 VDD VSS FILLER1
XFILLER_76_386 VDD VSS FILLER1
XFILLER_92_835 VSS VDD FILLER2
XTAP_TAPCELL_ROW_87_882 VDD VSS WELLTAP
X_18651_ _19957_/CK _18651_/D _18651_/Q VDD VSS DFFQX1
X_15863_ _15879_/A _15863_/B VDD VSS _19472_/D AND2X1
XFILLER_29_291 VDD VSS FILLER1
X_18582_ _18582_/CK _18582_/D _18582_/Q VDD VSS DFFQX1
X_17602_ _17838_/A VDD VSS _17654_/C BUFX3
X_15794_ _16795_/A VDD VSS _15849_/A BUFX3
X_14814_ _19475_/Q _15866_/B VDD VSS _14817_/C XOR2X1
XFILLER_17_464 VDD VSS FILLER1
XFILLER_45_751 VSS VDD FILLER2
XFILLER_91_367 VDD VSS FILLER4
X_11957_ _19092_/Q VDD VSS _11962_/A INVX1
X_17533_ _19867_/Q _19835_/Q VDD VSS _17535_/C XOR2X1
X_14745_ _14785_/D VDD VSS _14746_/D INVX1
X_10908_ _10940_/A _10908_/B _10908_/C VDD VSS _10909_/D OAI21X1
X_17464_ _17468_/A _17465_/B _17509_/C VDD VSS _17465_/C OAI21X1
XFILLER_60_743 VSS VDD FILLER2
X_11888_ _19996_/Q _19260_/Q VDD VSS _11980_/C XOR2X1
X_14676_ _14676_/A _14676_/B _14676_/C _14676_/D VDD VSS _14710_/B OAOI211X1
X_19203_ _19234_/CK _19203_/D _19203_/Q VDD VSS DFFQX1
X_16415_ _19694_/Q _16855_/B VDD VSS _16437_/A NOR2X1
XTAP_TAPCELL_ROW_14_153 VDD VSS WELLTAP
XTAP_TAPCELL_ROW_42_440 VDD VSS WELLTAP
X_10839_ _11116_/A _10839_/B VDD VSS _10840_/C NAND2X1
X_13627_ _19112_/Q _14390_/B VDD VSS _13716_/A NOR2BX1
X_17395_ _17397_/B _17395_/B VDD VSS _17396_/B XOR2X1
X_13558_ _13559_/C _14482_/A VDD VSS _13637_/B _14482_/B NAND3X1
X_19134_ _19137_/CK _19134_/D _19134_/Q VDD VSS DFFQX1
X_16346_ _19660_/Q _16818_/B VDD VSS _16348_/C XNOR2X1
XFILLER_8_162 VSS VDD FILLER2
X_12509_ _19045_/Q _12630_/A _12803_/B VDD VSS _12510_/D XNOR3X1
X_19065_ _19124_/CK _19065_/D _19065_/Q VDD VSS DFFQX1
X_16277_ _19689_/Q VDD VSS _16278_/A INVX1
X_13489_ _18971_/Q _13594_/D _13489_/C VDD VSS _13516_/C XNOR3X1
X_18016_ _18056_/A _18016_/B _18056_/C VDD VSS _19966_/D OAI21X1
X_15228_ _15284_/A _15284_/B VDD VSS _15247_/A NAND2X1
XFILLER_114_712 VDD VSS FILLER4
XFILLER_126_561 VDD VSS FILLER1
XFILLER_113_211 VDD VSS FILLER4
X_15159_ _15200_/A _15200_/B VDD VSS _15811_/B XNOR2X1
XFILLER_113_233 VSS VDD FILLER2
XFILLER_114_756 VDD VSS FILLER1
XFILLER_99_456 VDD VSS FILLER1
X_19967_ _19986_/CK _19967_/D _19967_/Q VDD VSS DFFQX1
X_09720_ _20142_/A _20190_/A _09753_/A VDD VSS _09731_/B MUXI2X1
X_18918_ _18950_/CK _18918_/D _18918_/Q VDD VSS DFFQX1
X_19898_ _19928_/CK _19898_/D _19898_/Q VDD VSS DFFQX1
X_09651_ _18349_/Q VDD VSS _20217_/A INVX1
X_18849_ _18878_/CK _18849_/D _18849_/Q VDD VSS DFFQX1
XFILLER_94_194 VDD VSS FILLER1
X_09582_ _09753_/D _09582_/B _09582_/C VDD VSS _18280_/D OAI21X1
XFILLER_70_507 VDD VSS FILLER4
XFILLER_70_518 VDD VSS FILLER1
XFILLER_70_529 VSS VDD FILLER2
XFILLER_50_253 VSS VDD FILLER2
XFILLER_137_804 VSS VDD FILLER2
XFILLER_109_528 VDD VSS FILLER4
XFILLER_136_336 VDD VSS FILLER4
XFILLER_117_572 VSS VDD FILLER2
XFILLER_128_57 VDD VSS FILLER4
XFILLER_2_305 VSS VDD FILLER2
X_09918_ _09862_/B _09884_/Y _09928_/C VDD VSS _09919_/B MUXI2X1
X_20107_ _20107_/A VDD VSS _20107_/Y BUFX3
XFILLER_144_89 VDD VSS FILLER1
XFILLER_58_320 VDD VSS FILLER4
XTAP_TAPCELL_ROW_129_1310 VDD VSS WELLTAP
XFILLER_58_364 VSS VDD FILLER2
XFILLER_58_375 VSS VDD FILLER2
XFILLER_59_887 VDD VSS FILLER1
XFILLER_92_109 VDD VSS FILLER4
X_09849_ _18568_/Q _11039_/C _09849_/C _18569_/Q VDD VSS _09850_/B AOI211X1
X_20038_ _20043_/CK _20038_/D _20038_/Q _20043_/RB VDD VSS DFFRQX1
X_12860_ _19160_/Q _12860_/B VDD VSS _12932_/C _12860_/C NAND3X1
XTAP_TAPCELL_ROW_84_852 VDD VSS WELLTAP
X_11811_ _11865_/A _11865_/B _14397_/B VDD VSS _11816_/C XNOR3X1
XFILLER_54_570 VDD VSS DECAPHV8
XTAP_TAPCELL_ROW_56_576 VDD VSS WELLTAP
X_12791_ _18880_/Q _12791_/B _12791_/C VDD VSS _13181_/B MIN3X1
X_14530_ _14539_/A _14530_/B VDD VSS _19236_/D NOR2X1
XFILLER_53_42 VDD VSS DECAPHV8
X_11742_ _11742_/A _11742_/B _11742_/C _11742_/D VDD VSS _11769_/A AOAI211X1
XFILLER_30_916 VDD VSS DECAPHV8
X_11673_ _18811_/Q _14547_/B VDD VSS _18838_/D AND2X1
X_14461_ _14467_/A _14461_/B VDD VSS _19175_/D AND2X1
X_10624_ _11267_/A _10624_/B _10624_/C _10624_/D VDD VSS _10624_/Y AOI31X1
X_13412_ _13416_/B _13416_/C _19053_/Q VDD VSS _13420_/A AOI21X1
X_14392_ _14392_/A _14392_/B _15836_/C VDD VSS _19114_/D OA21X2
X_17180_ _17329_/B _17180_/B _17180_/C VDD VSS _17185_/C MIN3X1
X_16200_ _19686_/Q VDD VSS _16201_/A INVX1
XFILLER_139_152 VDD VSS FILLER4
XFILLER_139_174 VDD VSS DECAPHV8
XTAP_TAPCELL_ROW_11_123 VDD VSS WELLTAP
X_13343_ _13343_/A VDD VSS _13345_/B INVX1
X_16131_ _16120_/A _16131_/B _16131_/C VDD VSS _16144_/A AOI2B1X1
X_10555_ _10556_/A _10556_/B _10556_/D _10556_/C VDD VSS _10558_/B AO211X2
XFILLER_108_550 VDD VSS DECAPHV8
XFILLER_127_369 VSS VDD FILLER2
X_10486_ _10521_/A _10521_/B _10521_/C _10721_/D VDD VSS _10487_/D AOI31X1
X_13274_ _13274_/A _14290_/B _13274_/C _13274_/D VDD VSS _13406_/B AOAI211X1
X_16062_ _16062_/A _19904_/Q _16062_/C VDD VSS _16088_/C MIN3X1
XFILLER_142_328 VDD VSS FILLER1
X_12225_ _19209_/Q _14500_/B VDD VSS _12329_/E _14500_/C NAND3X1
X_15013_ _15013_/A _15013_/B _15013_/C _15013_/D VDD VSS _15108_/B AOAI211X1
XFILLER_111_704 VDD VSS DECAPHV8
XFILLER_123_542 VDD VSS FILLER4
XFILLER_69_618 VDD VSS FILLER4
X_12156_ _19180_/Q _14466_/B VDD VSS _12171_/C _14466_/C NAND3X1
X_19821_ _19828_/CK _19821_/D _19821_/Q VDD VSS DFFQX1
XFILLER_1_371 VDD VSS FILLER1
XFILLER_68_117 VDD VSS FILLER1
XFILLER_78_83 VDD VSS DECAPHV8
XFILLER_96_415 VSS VDD FILLER2
X_11107_ _11068_/B _11107_/B _11107_/C VDD VSS _11132_/A AOI2B1X1
X_12087_ _12087_/A _12087_/B _12087_/C _12254_/B VDD VSS _12149_/B OAOI211X1
X_19752_ _19830_/CK _19752_/D _19752_/Q VDD VSS DFFQX1
X_16964_ _16973_/A _16973_/D VDD VSS _16968_/C NAND2X1
XFILLER_49_364 VDD VSS DECAPHV8
XFILLER_49_375 VDD VSS FILLER4
XFILLER_77_662 VDD VSS FILLER1
X_11038_ _19958_/Q _18840_/Q VDD VSS _11040_/B XOR2X1
X_19683_ _19730_/CK _19683_/D _19683_/Q VDD VSS DFFQX1
X_18703_ _18785_/CK _18703_/D _18703_/Q VDD VSS DFFQX1
X_16895_ _16976_/A _16895_/B VDD VSS _19730_/D NOR2X1
X_15915_ _19547_/Q _19899_/Q VDD VSS _15923_/B XNOR2X1
XFILLER_37_526 VDD VSS DECAPHV8
XTAP_TAPCELL_ROW_19_201 VDD VSS WELLTAP
X_18634_ _19940_/CK _18634_/D _18634_/Q VDD VSS DFFQX1
X_15846_ _17906_/C VDD VSS _16776_/A BUFX3
XFILLER_24_209 VDD VSS FILLER1
XFILLER_64_356 VDD VSS FILLER1
XFILLER_92_665 VDD VSS FILLER1
XFILLER_73_890 VDD VSS DECAPHV8
X_12989_ _18938_/Q _12992_/B _12989_/C VDD VSS _13076_/C XNOR3X1
X_18565_ _18565_/CK _18565_/D _18565_/Q VDD VSS DFFQX1
X_15777_ _15793_/A _15777_/B VDD VSS _19398_/D AND2X1
XFILLER_21_905 VSS VDD FILLER2
XFILLER_33_765 VDD VSS FILLER4
XFILLER_91_197 VSS VDD FILLER2
X_18496_ _18503_/CK _18496_/D _20109_/A _18496_/RB VDD VSS DFFRQX1
X_17516_ _19862_/Q _19830_/Q VDD VSS _17517_/C NAND2X1
X_14728_ _19361_/Q _14728_/B _15736_/B VDD VSS _14800_/B MIN3X1
XTAP_TAPCELL_ROW_102_1037 VDD VSS WELLTAP
X_14659_ _14708_/A _14659_/B VDD VSS _15862_/B NOR2BX1
X_17447_ _17448_/A _17450_/C _17452_/C VDD VSS _17448_/C OAI21X1
XFILLER_119_804 VDD VSS FILLER4
XFILLER_9_460 VDD VSS FILLER4
X_19117_ _19172_/CK _19117_/D _19117_/Q VDD VSS DFFQX1
X_17378_ _19833_/Q _19801_/Q VDD VSS _17379_/B XNOR2X1
X_16329_ _16332_/B _16329_/B VDD VSS _16330_/B XOR2X1
XFILLER_106_509 VSS VDD FILLER2
XFILLER_133_317 VDD VSS FILLER1
X_19048_ _19096_/CK _19048_/D _19048_/Q VDD VSS DFFQX1
XFILLER_0_809 VDD VSS FILLER1
XFILLER_102_704 VDD VSS FILLER1
XFILLER_114_553 VDD VSS DECAPHV16
XFILLER_126_391 VDD VSS FILLER4
XFILLER_142_862 VDD VSS FILLER4
XTAP_TAPCELL_ROW_113_1144 VDD VSS WELLTAP
XFILLER_87_404 VDD VSS FILLER4
XFILLER_88_949 VDD VSS FILLER1
XFILLER_28_504 VDD VSS FILLER4
XFILLER_68_684 VDD VSS DECAPHV8
XTAP_TAPCELL_ROW_98_999 VDD VSS WELLTAP
X_09703_ _18448_/Q VDD VSS _20160_/A INVX1
X_09634_ _18238_/Q _09818_/B _09716_/B _18263_/Q _09634_/E VDD VSS _09635_/C AOI221X1
XFILLER_55_356 VDD VSS FILLER4
XFILLER_71_805 VSS VDD FILLER2
XFILLER_82_142 VDD VSS FILLER1
XFILLER_83_654 VSS VDD FILLER2
XFILLER_36_570 VSS VDD FILLER2
XFILLER_70_304 VDD VSS FILLER1
XTAP_TAPCELL_ROW_124_1251 VDD VSS WELLTAP
XTAP_TAPCELL_ROW_81_822 VDD VSS WELLTAP
X_09565_ _09767_/B VDD VSS _09788_/B BUFX3
XTAP_TAPCELL_ROW_53_546 VDD VSS WELLTAP
X_09496_ _19986_/Q _09496_/B _09496_/C VDD VSS _09497_/C AOI21X1
XFILLER_12_949 VDD VSS FILLER1
XFILLER_137_645 VDD VSS FILLER4
X_10340_ _19939_/Q _18821_/Q VDD VSS _10343_/D XOR2X1
X_10271_ _10538_/A _10550_/A _10585_/C VDD VSS _10306_/A NOR3X1
XFILLER_133_840 VDD VSS FILLER4
XFILLER_3_658 VDD VSS FILLER1
XFILLER_3_669 VSS VDD FILLER2
X_12010_ _12010_/A _12010_/B _14238_/B VDD VSS _12072_/B MIN3X1
XFILLER_132_350 VSS VDD FILLER2
XFILLER_78_426 VSS VDD FILLER2
XFILLER_78_437 VSS VDD FILLER2
XFILLER_19_504 VDD VSS DECAPHV32
XFILLER_48_64 VDD VSS FILLER4
XFILLER_48_86 VDD VSS FILLER4
XFILLER_65_109 VDD VSS FILLER1
XFILLER_93_418 VDD VSS FILLER4
X_13961_ _19061_/Q _14333_/B VDD VSS _13962_/D NAND2X1
XFILLER_47_835 VSS VDD FILLER2
XFILLER_58_161 VDD VSS FILLER1
XFILLER_86_492 VSS VDD FILLER2
X_12912_ _19104_/Q _14382_/B VDD VSS _12913_/D _14382_/C NAND3X1
X_16680_ _19609_/Q _16761_/B VDD VSS _16681_/B XNOR2X1
X_15700_ _15710_/A _15700_/B VDD VSS _19328_/D NOR2X1
X_13892_ _18976_/Q _13998_/A _13998_/B VDD VSS _13921_/C XNOR3X1
XFILLER_15_721 VDD VSS FILLER1
XFILLER_61_304 VDD VSS FILLER1
X_12843_ _12843_/A _12843_/B _12843_/C _12843_/D VDD VSS _14475_/B OAOI211X1
X_15631_ _19328_/Q _15700_/B VDD VSS _15632_/B XNOR2X1
X_12774_ _19132_/Q _12932_/A _12822_/B VDD VSS _12910_/D XNOR3X1
X_18350_ _18356_/CK _18350_/D _18350_/Q _18492_/RB VDD VSS DFFRQX1
X_15562_ _15674_/A _18155_/B VDD VSS _19297_/D AND2X1
XFILLER_9_14 VDD VSS FILLER1
XFILLER_9_25 VDD VSS DECAPHV8
X_11725_ _19991_/Q _19255_/Q VDD VSS _11769_/B XOR2X1
X_14513_ _15806_/A _14513_/B _14513_/C VDD VSS _19220_/D NOR3X1
X_18281_ _18295_/CK _18281_/D _18281_/Q VDD VSS DFFQX1
X_17301_ _19817_/Q _19785_/Q VDD VSS _17303_/B XOR2X1
X_15493_ _15541_/B _15493_/B VDD VSS _15725_/B NOR2BX1
XFILLER_70_893 VDD VSS FILLER4
XFILLER_9_58 VDD VSS FILLER4
X_14444_ _14449_/A _14444_/B _14444_/C VDD VSS _19160_/D NOR3X1
X_17232_ _19802_/Q _19770_/Q _17306_/C VDD VSS _17233_/C OAI21X1
X_11656_ _18796_/Q _11658_/B VDD VSS _18823_/D AND2X1
XFILLER_127_122 VDD VSS FILLER4
XFILLER_7_920 VSS VDD FILLER2
X_10607_ _10633_/A _10633_/B _10607_/C _10607_/D VDD VSS _10619_/B AO31X2
X_11587_ _18733_/Q _11589_/B VDD VSS _18760_/D AND2X1
X_14375_ _14410_/A _14375_/B _14375_/C VDD VSS _19098_/D NOR3X1
Xclkbuf_1_0__f__002_ clkbuf_0__002_/Y VDD VSS clkload17/A BUFX12
X_17163_ _17168_/C _17168_/B VDD VSS _17165_/B NAND2BX1
XFILLER_109_870 VDD VSS FILLER1
XFILLER_127_166 VSS VDD FILLER2
XFILLER_6_441 VDD VSS FILLER1
X_10538_ _10538_/A VDD VSS _10960_/A BUFX3
X_13326_ _19165_/Q VDD VSS _13356_/A INVX1
X_17094_ _17097_/B _17094_/B VDD VSS _17095_/B XOR2X1
X_16114_ _16137_/C _16114_/B VDD VSS _16736_/B XNOR2X1
XFILLER_127_177 VSS VDD FILLER2
XFILLER_6_496 VDD VSS DECAPHV8
X_13257_ _13339_/A _14543_/B VDD VSS _13347_/A NOR2X1
X_16045_ _16057_/A _16057_/B VDD VSS _16840_/B XNOR2X1
XFILLER_97_702 VDD VSS DECAPHV16
X_10469_ _10503_/C _10469_/B VDD VSS _10474_/B XNOR2X1
X_12208_ wire159/Y _12208_/B VDD VSS _14374_/B XOR2X1
XFILLER_69_415 VDD VSS FILLER4
XFILLER_96_212 VDD VSS FILLER4
X_13188_ _13295_/A _13295_/C _13295_/B VDD VSS _14190_/C AO21X2
XFILLER_111_545 VDD VSS FILLER1
X_12139_ _12210_/A _12447_/B VDD VSS _12140_/C XNOR2X1
X_19804_ _19903_/CK _19804_/D _19804_/Q VDD VSS DFFQX1
X_17996_ _18537_/Q _18032_/B VDD VSS _18036_/B AND2X1
XFILLER_97_779 VDD VSS FILLER1
X_19735_ _19736_/CK _19735_/D _19735_/Q VDD VSS DFFQX1
X_16947_ wire163/Y VDD VSS _17062_/C INVX1
XFILLER_38_824 VDD VSS FILLER1
XFILLER_38_835 VDD VSS DECAPHV16
XFILLER_49_161 VDD VSS FILLER4
XFILLER_65_610 VDD VSS FILLER1
XFILLER_77_492 VSS VDD FILLER2
XFILLER_96_289 VDD VSS FILLER1
XFILLER_53_805 VDD VSS DECAPHV16
XFILLER_64_131 VSS VDD FILLER2
XTAP_TAPCELL_ROW_95_969 VDD VSS WELLTAP
X_19666_ _19696_/CK _19666_/D _19666_/Q VDD VSS DFFQX1
X_16878_ _16891_/A _16878_/B VDD VSS _19714_/D NOR2X1
XFILLER_52_315 VSS VDD FILLER2
XFILLER_80_613 VDD VSS DECAPHV8
X_19597_ _19604_/CK _19597_/D _19597_/Q VDD VSS DFFQX1
X_18617_ _18622_/CK _18617_/D _18617_/Q VDD VSS DFFQX1
X_15829_ _15830_/A _15829_/B VDD VSS _19444_/D NOR2X1
X_09350_ _18509_/Q VDD VSS _09369_/B INVX1
X_18548_ _18550_/CK _18548_/D _18548_/Q VDD VSS DFFQX1
X_09281_ _09362_/AB _09349_/B VDD VSS _09281_/Y NOR2BX1
XTAP_TAPCELL_ROW_50_516 VDD VSS WELLTAP
X_18479_ _18479_/CK _18516_/Q _20124_/A _18496_/RB VDD VSS DFFRQX1
XFILLER_21_768 VDD VSS DECAPHV8
XFILLER_119_634 VDD VSS FILLER1
XFILLER_109_48 VDD VSS FILLER1
XFILLER_134_648 VDD VSS FILLER4
Xclkload71 _18917_/CK VDD VSS clkload71/Y BUFX12
Xclkload60 _19124_/CK VDD VSS clkload60/Y INVX1
XFILLER_115_862 VDD VSS FILLER1
Xclkload93 _19707_/CK VDD VSS clkload93/Y BUFX12
Xclkload82 _19483_/CK VDD VSS clkload82/Y INVX1
XFILLER_0_606 VDD VSS FILLER1
XFILLER_125_25 VSS VDD FILLER2
XFILLER_130_821 VDD VSS FILLER4
XFILLER_133_169 VDD VSS FILLER1
XFILLER_88_735 VDD VSS FILLER1
XFILLER_102_523 VSS VDD FILLER2
XFILLER_102_567 VDD VSS FILLER1
XFILLER_68_470 VDD VSS FILLER4
XFILLER_141_24 VSS VDD FILLER2
XFILLER_18_45 VDD VSS FILLER1
XFILLER_28_345 VDD VSS FILLER1
XTAP_TAPCELL_ROW_66_671 VDD VSS WELLTAP
X_09617_ _18262_/Q _09818_/C _09617_/C _09788_/B _09617_/E VDD VSS _09618_/B AOI221X1
XTAP_TAPCELL_ROW_38_395 VDD VSS WELLTAP
X_09548_ _20042_/Q _18201_/A VDD VSS _20043_/D NOR2BX1
X_09964__234 _20079_/CK VDD VSS _18511_/CK INVX1
XFILLER_52_882 VDD VSS FILLER1
XFILLER_70_156 VDD VSS FILLER4
XFILLER_70_167 VSS VDD FILLER2
XFILLER_140_4 VDD VSS DECAPHV16
XFILLER_51_370 VSS VDD FILLER2
X_09479_ _18405_/D _09483_/B _09479_/C VDD VSS _18244_/D AOI21X1
X_11510_ _18663_/Q _11519_/B VDD VSS _18690_/D AND2X1
XFILLER_138_910 VSS VDD FILLER2
X_12490_ _19212_/Q _14504_/B VDD VSS _12566_/D _14504_/C NAND3X1
XFILLER_11_278 VDD VSS FILLER1
X_11441_ _16273_/A VDD VSS _17990_/A BUFX3
XFILLER_50_43 VSS VDD FILLER2
X_11372_ _11379_/A _11373_/B _11379_/C _18592_/Q VDD VSS _11381_/C AOAI211X1
X_14160_ _15383_/A VDD VSS _14197_/A BUFX3
Xwire158 wire158/A VDD VSS wire158/Y BUFX4
XFILLER_124_103 VSS VDD FILLER2
XFILLER_125_626 VDD VSS FILLER1
X_10323_ _10323_/A _10323_/B _10323_/C _10323_/D VDD VSS _10381_/C OAOI211X1
X_13111_ _13111_/A _13111_/B _13111_/C _13111_/D VDD VSS _13315_/A AOAI211X1
XFILLER_140_607 VDD VSS FILLER4
X_14091_ _18897_/Q _14140_/B VDD VSS _14093_/C _14140_/C NAND3X1
XFILLER_112_309 VSS VDD FILLER2
XFILLER_3_488 VDD VSS DECAPHV8
XFILLER_59_41 VDD VSS DECAPHV16
XFILLER_78_201 VDD VSS DECAPHV8
XFILLER_79_702 VDD VSS FILLER1
X_10254_ _11436_/C _11431_/B _10269_/D _10258_/D VDD VSS _10315_/D OA211X2
X_13042_ _13141_/A _13042_/B VDD VSS _14477_/B XNOR2X1
XFILLER_105_394 VDD VSS FILLER1
XFILLER_79_768 VDD VSS DECAPHV16
X_10185_ _10188_/A _10188_/B VDD VSS _11422_/C XNOR2X1
X_17850_ _17853_/C _17851_/B _17917_/C VDD VSS _17851_/C OAI21X1
XFILLER_59_96 VDD VSS DECAPHV8
X_16801_ _16811_/A _16801_/B VDD VSS _19644_/D NOR2X1
XFILLER_66_429 VDD VSS FILLER4
X_19520_ _19521_/CK _19520_/D _19520_/Q VDD VSS DFFQX1
X_17781_ _19919_/Q _19887_/Q _17781_/C VDD VSS _17785_/B MIN3X1
X_14993_ _19450_/Q _15835_/B VDD VSS _15003_/A NAND2X1
XFILLER_46_142 VDD VSS FILLER1
XFILLER_75_62 VSS VDD FILLER2
X_13944_ _14020_/A _14135_/B VDD VSS _13974_/B NOR2X1
X_16732_ _16735_/A _16732_/B VDD VSS _19583_/D NOR2X1
XFILLER_90_911 VDD VSS DECAPHV16
XFILLER_90_933 VDD VSS FILLER1
XTAP_TAPCELL_ROW_144_1457 VDD VSS WELLTAP
XTAP_TAPCELL_ROW_144_1468 VDD VSS WELLTAP
XTAP_TAPCELL_ROW_92_939 VDD VSS WELLTAP
X_13875_ _18892_/Q _13938_/A _13981_/B VDD VSS _13929_/D XNOR3X1
X_19451_ _19483_/CK _19451_/D _19451_/Q VDD VSS DFFQX1
X_16663_ _19704_/Q _16669_/A VDD VSS _16664_/B XOR2X1
X_12826_ _12827_/A _12827_/B _12827_/D _12827_/C VDD VSS _14475_/C AOI211X1
X_19382_ _19385_/CK _19382_/D _19382_/Q VDD VSS DFFQX1
X_18402_ _18407_/CK _18519_/Q _20143_/A _18452_/RB VDD VSS DFFRQX1
X_15614_ _15611_/A _15614_/B _15614_/C VDD VSS _15635_/B AOI2B1X1
XFILLER_15_540 VDD VSS DECAPHV16
X_18333_ _18342_/CK _18477_/D _20087_/A _18373_/RB VDD VSS DFFRQX1
X_16594_ _19669_/Q _16828_/B VDD VSS _16595_/C NOR2X1
XFILLER_15_595 VDD VSS FILLER1
X_12757_ _12763_/A _12763_/B _12763_/D _12763_/C VDD VSS _14537_/C OAOI211X1
X_15545_ _15545_/A _15545_/B VDD VSS _15552_/B AND2X1
X_11708_ _19990_/Q _19254_/Q VDD VSS _11724_/C XOR2X1
X_12688_ _19103_/Q _12819_/A _12910_/B VDD VSS _12804_/D XNOR3X1
X_18264_ _18275_/CK _18264_/D _18264_/Q _20079_/RB VDD VSS DFFRQX1
X_15476_ _19545_/Q _15476_/B VDD VSS _15913_/B XOR2X1
XFILLER_30_576 VSS VDD FILLER2
X_11639_ _18780_/Q _11647_/B VDD VSS _18807_/D AND2X1
X_14427_ _14467_/A _14427_/B VDD VSS _19145_/D AND2X1
X_18195_ _19304_/Q _18195_/B _18195_/C VDD VSS _18196_/B MIN3X1
X_17215_ _17214_/B _17215_/B VDD VSS _17217_/C NOR2BX1
XFILLER_11_790 VSS VDD FILLER2
X_14358_ _14410_/A _14358_/B _14358_/C VDD VSS _19082_/D NOR3X1
X_17146_ _19784_/Q _19752_/Q VDD VSS _17149_/A XNOR2X1
XFILLER_144_935 VDD VSS DECAPHV8
X_13309_ _14221_/A _14221_/B _14221_/C _13309_/D VDD VSS _13511_/A OAOI211X1
X_14289_ _14311_/A _14289_/B VDD VSS _19022_/D NOR2X1
X_17077_ _19768_/Q _17078_/B _17077_/C VDD VSS _17079_/A AOI21X1
XFILLER_131_618 VDD VSS FILLER1
X_16028_ _16028_/A _16028_/B _16028_/C VDD VSS _16051_/A AOI21X1
XFILLER_97_521 VDD VSS FILLER4
XTAP_TAPCELL_ROW_110_1114 VDD VSS WELLTAP
XFILLER_27_0 VSS VDD FILLER2
X_17979_ _17987_/A _17980_/B _18187_/C VDD VSS _17980_/C OAI21X1
XFILLER_84_259 VDD VSS FILLER1
X_19718_ _19730_/CK _19718_/D _19718_/Q VDD VSS DFFQX1
XFILLER_26_838 VSS VDD FILLER2
XFILLER_52_101 VDD VSS DECAPHV8
XFILLER_81_911 VDD VSS FILLER1
X_19649_ _19711_/CK _19649_/D _19649_/Q VDD VSS DFFQX1
XFILLER_111_27 VDD VSS FILLER1
XFILLER_80_443 VDD VSS FILLER4
XTAP_TAPCELL_ROW_108_1098 VDD VSS WELLTAP
X_09402_ _18087_/D VDD VSS _13283_/A BUFX3
XFILLER_80_465 VDD VSS FILLER1
XFILLER_80_476 VDD VSS DECAPHV16
XTAP_TAPCELL_ROW_121_1221 VDD VSS WELLTAP
XTAP_TAPCELL_ROW_63_641 VDD VSS WELLTAP
X_09333_ _18446_/D _09332_/Y _09302_/A VDD VSS _18515_/D MUXI2X1
XTAP_TAPCELL_ROW_35_365 VDD VSS WELLTAP
XFILLER_139_729 VDD VSS FILLER4
XFILLER_21_565 VSS VDD FILLER2
X_09264_ _18279_/Q _18278_/Q VDD VSS _09296_/A NOR2X1
X_09195_ _18516_/Q VDD VSS _18447_/D INVX1
XFILLER_107_604 VDD VSS DECAPHV16
XFILLER_119_453 VDD VSS DECAPHV8
XFILLER_119_486 VDD VSS FILLER1
XFILLER_135_924 VDD VSS FILLER4
XFILLER_107_659 VDD VSS FILLER1
XFILLER_134_456 VDD VSS FILLER1
XFILLER_20_68 VDD VSS DECAPHV8
XFILLER_122_607 VDD VSS FILLER4
XFILLER_136_68 VSS VDD FILLER2
XFILLER_88_510 VDD VSS FILLER1
Xclkbuf_leaf_1_sclk clkbuf_leaf_3_sclk/A VDD VSS _18234_/CK BUFX12
XFILLER_49_908 VSS VDD FILLER2
XFILLER_96_28 VDD VSS DECAPHV8
XFILLER_102_375 VDD VSS DECAPHV16
XFILLER_75_226 VDD VSS DECAPHV8
XFILLER_88_598 VSS VDD FILLER2
XFILLER_29_654 VDD VSS FILLER1
XFILLER_29_665 VDD VSS FILLER1
XFILLER_75_248 VDD VSS FILLER1
X_11990_ _12099_/A _12099_/B VDD VSS _12038_/B NOR2X1
XFILLER_16_304 VDD VSS FILLER1
XFILLER_28_142 VDD VSS DECAPHV16
X_10941_ _11229_/D _10978_/C VDD VSS _10942_/D NOR2X1
XFILLER_16_337 VDD VSS FILLER1
XFILLER_45_32 VDD VSS FILLER1
XFILLER_45_65 VSS VDD FILLER2
X_13660_ _13660_/A _13660_/B _13660_/C _13660_/D VDD VSS _17920_/B OAOI211X1
XFILLER_44_679 VDD VSS FILLER1
X_10872_ _10873_/A _10899_/C _11226_/A VDD VSS _10873_/C AOI21X1
X_12611_ _18876_/Q _12611_/B _12611_/C VDD VSS _12612_/C MIN3X1
XFILLER_31_329 VSS VDD FILLER2
XFILLER_43_189 VSS VDD FILLER2
X_13591_ _13591_/A _13591_/B _13591_/C _13591_/D VDD VSS _13807_/A AOAI211X1
XFILLER_61_20 VDD VSS FILLER4
X_12542_ _19073_/Q VDD VSS _12625_/A INVX1
X_15330_ _19375_/Q _15752_/B VDD VSS _15343_/B XNOR2X1
XFILLER_129_239 VSS VDD FILLER2
XFILLER_8_514 VDD VSS DECAPHV32
X_12473_ _19183_/Q _12474_/B _12473_/C VDD VSS _12483_/B XNOR3X1
X_15261_ _19401_/Q _15781_/B VDD VSS _15305_/A NAND2X1
XFILLER_126_902 VDD VSS FILLER1
X_11424_ _14163_/A _11429_/B _11424_/C VDD VSS _18617_/D NOR3X1
X_14212_ _14218_/A _14212_/B VDD VSS _18961_/D NOR2X1
X_17000_ _16998_/B _17000_/B VDD VSS _17006_/A NOR2BX1
XANTENNA_8 _20137_/Y VDD VSS ANTENNA2
X_15192_ _15275_/A _15275_/C VDD VSS _15193_/C NAND2X1
X_11355_ _18589_/Q _11355_/B _11355_/C VDD VSS _11367_/B MIN3X1
X_14143_ _14158_/A _14143_/B VDD VSS _18900_/D AND2X1
XFILLER_141_927 VSS VDD FILLER2
XFILLER_141_949 VDD VSS FILLER1
X_10306_ _10306_/A _10595_/A VDD VSS _10306_/Y NAND2X1
X_11286_ _11286_/A _11286_/B VDD VSS _11308_/A AND2X1
X_14074_ _14093_/A _17964_/C VDD VSS _17968_/B XNOR2X1
X_18951_ _19171_/CK _18951_/D _18951_/Q VDD VSS DFFQX1
XFILLER_140_437 VDD VSS FILLER1
X_10237_ _10313_/B _10237_/B _18624_/Q _11436_/C VDD VSS _10538_/A OAOI211X1
X_13025_ _13101_/A _14384_/B VDD VSS _13212_/A NOR2X1
X_17902_ _17903_/A _17905_/C _17917_/C VDD VSS _17903_/C OAI21X1
XFILLER_121_640 VDD VSS FILLER4
XFILLER_121_662 VDD VSS FILLER1
XFILLER_94_502 VSS VDD FILLER2
X_18882_ _18908_/CK _18882_/D _18882_/Q VDD VSS DFFQX1
XFILLER_121_695 VSS VDD FILLER2
XFILLER_86_61 VSS VDD FILLER2
X_10168_ _10071_/Y _10167_/Y _10224_/A VDD VSS _10174_/B MUXI2X1
X_17833_ _19930_/Q _19931_/Q _19932_/Q _19933_/Q VDD VSS _17836_/B AND4X2
XFILLER_120_194 VDD VSS DECAPHV16
XFILLER_19_120 VDD VSS FILLER4
XFILLER_82_708 VDD VSS DECAPHV16
XFILLER_86_94 VSS VDD FILLER2
X_10099_ _10099_/A _10101_/C VDD VSS _11414_/C XNOR2X1
X_17764_ _19916_/Q _19884_/Q VDD VSS _17766_/D XNOR2X1
X_14976_ _19423_/Q _14976_/B _14995_/C VDD VSS _15045_/B XNOR3X1
XFILLER_81_218 VSS VDD FILLER2
XTAP_TAPCELL_ROW_77_788 VDD VSS WELLTAP
X_13927_ _13978_/A _17940_/B _13978_/C VDD VSS _17937_/A OAI21X1
X_19503_ _19533_/CK _19503_/D _19503_/Q VDD VSS DFFQX1
X_16715_ _16715_/A _16724_/B VDD VSS _19567_/D NOR2X1
XFILLER_19_197 VDD VSS FILLER1
XFILLER_47_484 VSS VDD FILLER2
XFILLER_47_495 VSS VDD FILLER2
X_19434_ _19461_/CK _19434_/D _19434_/Q VDD VSS DFFQX1
X_17695_ _17697_/B _17695_/B VDD VSS _17696_/B XOR2X1
XFILLER_62_443 VDD VSS FILLER1
XFILLER_62_465 VDD VSS FILLER1
X_13858_ _19087_/Q _14363_/A _14363_/B VDD VSS _13860_/C NOR3X1
X_16646_ _19671_/Q _16830_/B VDD VSS _16647_/C NOR2X1
XFILLER_50_649 VSS VDD FILLER2
XFILLER_62_498 VSS VDD FILLER2
XTAP_TAPCELL_ROW_60_611 VDD VSS WELLTAP
X_12809_ _12809_/A _14380_/B VDD VSS _12913_/A OR2X2
X_13789_ _19115_/Q _14393_/B VDD VSS _13857_/D XNOR2X1
X_19365_ _19393_/CK _19365_/D _19365_/Q VDD VSS DFFQX1
X_16577_ _19605_/Q _16756_/B VDD VSS _16599_/B XNOR2X1
XTAP_TAPCELL_ROW_32_335 VDD VSS WELLTAP
XTAP_TAPCELL_ROW_6_80 VDD VSS WELLTAP
X_19296_ _19304_/CK _19296_/D _19296_/Q VDD VSS DFFQX1
X_18316_ _18327_/CK _18513_/Q _18316_/Q _18453_/RB VDD VSS DFFRQX1
X_15528_ _15528_/A _15541_/C VDD VSS _15727_/B XNOR2X1
XFILLER_31_896 VSS VDD FILLER2
X_18247_ _18255_/CK _18247_/D _18270_/D _20080_/RB VDD VSS DFFRQX1
XFILLER_30_395 VSS VDD FILLER2
X_15459_ _15498_/B _15459_/B VDD VSS _18143_/B XNOR2X1
XFILLER_117_924 VDD VSS FILLER4
XFILLER_144_710 VSS VDD FILLER2
X_18178_ _18196_/A _18178_/B VDD VSS _20009_/D NOR2X1
XFILLER_144_754 VSS VDD FILLER2
X_17129_ _17132_/A _17132_/B _17164_/C VDD VSS _17130_/C OAI21X1
XFILLER_104_607 VDD VSS DECAPHV16
XFILLER_116_467 VDD VSS DECAPHV8
XFILLER_144_776 VDD VSS FILLER4
XFILLER_144_798 VDD VSS DECAPHV8
X_09951_ _09946_/Y _09950_/Y _09938_/A VDD VSS _09952_/B MUXI2X1
X_20140_ _20140_/A VDD VSS _20140_/Y BUFX3
XFILLER_106_49 VDD VSS FILLER4
X_09882_ _18567_/Q _09882_/B VDD VSS _09909_/B XOR2X1
X_20071_ clkload6/A _20071_/D _20071_/Q _20071_/RB VDD VSS DFFRQX1
XTAP_TAPCELL_ROW_68_700 VDD VSS WELLTAP
XFILLER_85_557 VDD VSS FILLER1
XFILLER_81_741 VSS VDD FILLER2
XFILLER_26_679 VDD VSS FILLER4
XFILLER_41_605 VDD VSS FILLER4
X_09316_ _18452_/RB _09346_/B VDD VSS _09316_/Y NOR2BX1
X_09247_ _18498_/D VDD VSS _18338_/D INVX1
XFILLER_108_902 VDD VSS DECAPHV8
XFILLER_21_395 VDD VSS FILLER4
XFILLER_31_12 VSS VDD FILLER2
XTAP_TAPCELL_ROW_2_38 VDD VSS WELLTAP
XFILLER_107_478 VDD VSS FILLER4
X_11140_ _19960_/Q VDD VSS _11469_/A INVX1
Xoutput34 _20099_/Y VDD VSS o_bias_cfg[1] BUFX3
Xoutput23 _20098_/Y VDD VSS o_bias_cfg[0] BUFX3
Xoutput12 _20096_/Y VDD VSS o_aux_ctrl[14] BUFX3
XFILLER_123_949 VDD VSS FILLER1
XFILLER_89_830 VDD VSS FILLER1
Xoutput45 _20100_/Y VDD VSS o_bias_cfg[2] BUFX3
Xoutput56 _20106_/Y VDD VSS o_bias_cfg[8] BUFX3
Xoutput67 _20151_/Y VDD VSS o_clk_cfg[18] BUFX3
XFILLER_1_756 VSS VDD FILLER2
X_11071_ _11072_/A _11072_/B VDD VSS _11093_/C NOR2X1
Xoutput78 _20162_/Y VDD VSS o_en_ctrl[10] BUFX3
Xoutput89 _20173_/Y VDD VSS o_lf_cfg[10] BUFX3
XFILLER_0_277 VSS VDD FILLER2
XFILLER_102_161 VDD VSS FILLER4
XFILLER_1_789 VSS VDD FILLER2
XFILLER_49_727 VDD VSS DECAPHV8
X_10022_ _10022_/A _10022_/B _10022_/C VDD VSS _10026_/C OAI21X1
XFILLER_76_546 VDD VSS DECAPHV8
X_14830_ _15015_/B VDD VSS _14881_/B INVX1
XFILLER_29_484 VDD VSS DECAPHV16
XFILLER_44_421 VDD VSS FILLER4
XFILLER_57_793 VDD VSS FILLER4
XFILLER_63_229 VDD VSS FILLER1
XTAP_TAPCELL_ROW_74_758 VDD VSS WELLTAP
X_11973_ _11973_/A _11973_/B _11973_/C _11973_/D VDD VSS _12031_/B OAOI211X1
X_16500_ _19602_/Q _16753_/B VDD VSS _16503_/A XNOR2X1
X_14761_ _14800_/B _14761_/B VDD VSS _15706_/B XNOR2X1
XTAP_TAPCELL_ROW_141_1427 VDD VSS WELLTAP
X_10924_ _18647_/Q _18809_/Q VDD VSS _10925_/B NOR2X1
X_13712_ _19140_/Q _14422_/B VDD VSS _13714_/C _14422_/C NAND3X1
X_14692_ _19332_/Q _15704_/B VDD VSS _14727_/B NOR2X1
X_17480_ _19855_/Q _19823_/Q VDD VSS _17482_/B XOR2X1
XFILLER_32_627 VDD VSS FILLER1
XFILLER_32_649 VDD VSS DECAPHV16
XFILLER_60_925 VDD VSS FILLER1
XFILLER_60_947 VSS VDD FILLER2
X_10855_ _19953_/Q _18835_/Q VDD VSS _10857_/A XOR2X1
X_13643_ _19085_/Q _13643_/B _13716_/C VDD VSS _13781_/B XNOR3X1
X_16431_ _19663_/Q _16821_/B VDD VSS _16433_/C XNOR2X1
XFILLER_31_137 VDD VSS DECAPHV8
X_13574_ _14118_/A _17914_/B VDD VSS _18860_/D NOR2X1
X_19150_ _19187_/CK _19150_/D _19150_/Q VDD VSS DFFQX1
X_16362_ _16390_/A _16390_/B VDD VSS _16379_/A NAND2X1
X_10786_ _19950_/Q _18832_/Q VDD VSS _10790_/B AND2X1
X_12525_ _18933_/Q _12534_/B _14181_/B VDD VSS _14149_/B XNOR3X1
X_18101_ _19287_/Q _18102_/B VDD VSS _18109_/C NOR2BX1
X_15313_ _19540_/Q _15313_/B VDD VSS _15399_/C NOR2BX1
X_19081_ _19137_/CK _19081_/D _19081_/Q VDD VSS DFFQX1
X_16293_ _16320_/B _16293_/B VDD VSS _16816_/B NAND2BX1
XFILLER_138_581 VDD VSS FILLER4
X_12456_ _12543_/A _12593_/A _12456_/C VDD VSS _12457_/D XNOR3X1
X_18032_ _18537_/Q _18032_/B VDD VSS _18033_/C NOR2X1
X_15244_ _15281_/B _15843_/B _19457_/Q VDD VSS _15284_/D NAND3BX1
X_11407_ _11422_/A _17990_/B _11407_/C VDD VSS _18601_/D NOR3X1
X_12387_ _12474_/A _12474_/C _12474_/B VDD VSS _14469_/C AO21X2
X_15175_ _19371_/Q VDD VSS _15176_/A INVX1
XFILLER_98_104 VDD VSS FILLER4
X_11338_ _11370_/A _11341_/B VDD VSS _11340_/A NOR2X1
X_14126_ _14142_/A _14126_/B VDD VSS _18885_/D NOR2X1
XFILLER_114_949 VDD VSS FILLER1
X_19983_ _19984_/CK _19983_/D _19983_/Q VDD VSS DFFQX1
X_11269_ _11269_/A _11276_/B VDD VSS _11274_/B XOR2X1
X_14057_ _14058_/A _14058_/B _14058_/D _14058_/C VDD VSS _14078_/B OAOI211X1
X_18934_ _18936_/CK _18934_/D _18934_/Q VDD VSS DFFQX1
X_13008_ _13008_/A _13008_/B _13008_/C _13008_/D VDD VSS _13097_/B OAOI211X1
X_18865_ _18917_/CK _18865_/D _18865_/Q VDD VSS DFFQX1
X_17816_ _18173_/A _17816_/B VDD VSS _19927_/D NOR2X1
XFILLER_55_719 VSS VDD FILLER2
X_18796_ _18799_/CK _18796_/D _18796_/Q VDD VSS DFFQX1
X_17747_ _17747_/A _17748_/C _17747_/C VDD VSS _19912_/D AOI21X1
X_14959_ _14959_/A _14959_/B _14959_/C _14959_/D VDD VSS _14995_/B OAOI211X1
XFILLER_23_605 VDD VSS DECAPHV8
X_17678_ _17678_/A _17678_/B _17678_/C VDD VSS _17680_/A OA21X2
XFILLER_35_476 VDD VSS DECAPHV8
XFILLER_51_947 VSS VDD FILLER2
XFILLER_63_785 VDD VSS FILLER1
XFILLER_63_796 VDD VSS DECAPHV8
XTAP_TAPCELL_ROW_105_1068 VDD VSS WELLTAP
X_19417_ _19492_/CK _19417_/D _19417_/Q VDD VSS DFFQX1
X_16629_ _19607_/Q _16758_/B VDD VSS _16631_/C XOR2X1
XFILLER_23_649 VSS VDD FILLER2
XFILLER_94_0 VSS VDD FILLER2
XTAP_TAPCELL_ROW_17_184 VDD VSS WELLTAP
X_19348_ _19362_/CK _19348_/D _19348_/Q VDD VSS DFFQX1
XFILLER_22_159 VSS VDD FILLER2
XFILLER_31_693 VSS VDD FILLER2
X_19279_ _19290_/CK _19279_/D _19279_/Q VDD VSS DFFQX1
XFILLER_129_581 VDD VSS FILLER1
XFILLER_117_743 VDD VSS FILLER1
XFILLER_105_927 VSS VDD FILLER2
XFILLER_144_551 VDD VSS FILLER4
XFILLER_144_573 VDD VSS DECAPHV8
XTAP_TAPCELL_ROW_116_1175 VDD VSS WELLTAP
XTAP_TAPCELL_ROW_9_108 VDD VSS WELLTAP
XFILLER_104_415 VSS VDD FILLER2
XFILLER_132_735 VSS VDD FILLER2
X_09934_ _11396_/A _11396_/B VDD VSS _11398_/C AND2X1
X_20123_ _20123_/A VDD VSS _20123_/Y BUFX3
XFILLER_97_170 VDD VSS DECAPHV8
X_09865_ _18573_/Q _09872_/B VDD VSS _09871_/B NOR2BX1
X_20054_ _20054_/CK _20054_/D _20054_/Q _20065_/RB VDD VSS DFFRQX1
XFILLER_85_365 VDD VSS FILLER4
XFILLER_86_888 VDD VSS FILLER1
X_09796_ _18342_/Q _09810_/B VDD VSS _09797_/E NOR2X1
XFILLER_85_387 VDD VSS FILLER4
XFILLER_54_752 VDD VSS FILLER4
XTAP_TAPCELL_ROW_127_1282 VDD VSS WELLTAP
XFILLER_13_104 VDD VSS FILLER4
XFILLER_41_413 VDD VSS FILLER4
XFILLER_42_947 VSS VDD FILLER2
XTAP_TAPCELL_ROW_71_728 VDD VSS WELLTAP
X_10640_ _10640_/A _10687_/C _10803_/A VDD VSS _10645_/B OAI21X1
XFILLER_13_159 VDD VSS FILLER1
XFILLER_42_33 VDD VSS FILLER1
XFILLER_42_44 VSS VDD FILLER2
XFILLER_10_844 VDD VSS FILLER1
XFILLER_139_367 VDD VSS FILLER4
X_10571_ _10638_/B _10571_/B _10927_/C VDD VSS _10578_/C OR3BX1
XFILLER_127_518 VDD VSS DECAPHV8
XFILLER_6_837 VSS VDD FILLER2
X_12310_ _12329_/A _12329_/B _12311_/D _12329_/E VDD VSS _14468_/B OA211X2
X_13290_ _13290_/A _13290_/B _13290_/C _13290_/D VDD VSS _13291_/B OAI211X1
XFILLER_108_721 VDD VSS FILLER1
XFILLER_108_743 VDD VSS FILLER4
X_12241_ _19210_/Q _14501_/B VDD VSS _12303_/C XNOR2X1
XFILLER_107_297 VDD VSS FILLER1
XFILLER_108_798 VSS VDD FILLER2
X_12172_ _19209_/Q _12172_/B _12224_/C VDD VSS _12218_/B XNOR3X1
XFILLER_122_245 VDD VSS DECAPHV8
XFILLER_123_779 VSS VDD FILLER2
XTAP_TAPCELL_ROW_79_806 VDD VSS WELLTAP
X_11123_ _11126_/A _11126_/C VDD VSS _11124_/B XNOR2X1
X_16980_ _19750_/Q _17049_/B _16984_/A _16984_/B VDD VSS _16981_/B AOAI211X1
XFILLER_107_81 VDD VSS FILLER1
XFILLER_110_407 VDD VSS DECAPHV8
XFILLER_77_833 VDD VSS FILLER4
X_11054_ _11055_/A _11055_/B _11055_/C VDD VSS _11086_/B AO21X2
X_15931_ _19610_/Q _16762_/B VDD VSS _15950_/A AND2X1
X_10005_ _10034_/A _10005_/B _10005_/C _11208_/A VDD VSS _10006_/C AOI211X1
X_18650_ _19957_/CK _18650_/D _18650_/Q VDD VSS DFFQX1
X_17601_ _19881_/Q _19849_/Q VDD VSS _17604_/B XOR2X1
X_15862_ _15879_/A _15862_/B VDD VSS _19471_/D AND2X1
XTAP_TAPCELL_ROW_87_883 VDD VSS WELLTAP
X_18581_ _18582_/CK _18581_/D _18581_/Q VDD VSS DFFQX1
X_15793_ _15793_/A _15793_/B VDD VSS _19412_/D AND2X1
X_14813_ _14813_/A _14813_/B _15802_/B VDD VSS _14911_/A MIN3X1
XFILLER_83_40 VDD VSS DECAPHV8
XFILLER_91_346 VDD VSS FILLER1
X_11956_ _12023_/B _12018_/B VDD VSS _11960_/B XNOR2X1
X_17532_ _19866_/Q _19834_/Q _17532_/C VDD VSS _19866_/D AOI21X1
X_14744_ _19501_/Q _15894_/B VDD VSS _14785_/D XOR2X1
XFILLER_17_476 VSS VDD FILLER2
XFILLER_60_700 VDD VSS DECAPHV16
XFILLER_60_722 VDD VSS FILLER1
XFILLER_72_560 VDD VSS FILLER1
X_10907_ _10940_/A _10908_/B _11229_/D VDD VSS _10908_/C AOI21X1
X_17463_ _17468_/C _17468_/B VDD VSS _17465_/B NAND2BX1
XFILLER_44_295 VSS VDD FILLER2
XFILLER_72_593 VDD VSS DECAPHV8
X_11887_ _11933_/A _14525_/B VDD VSS _11980_/B NAND2X1
X_14675_ _19498_/Q _15891_/B VDD VSS _14710_/A NOR2BX1
X_19202_ _19202_/CK _19202_/D _19202_/Q VDD VSS DFFQX1
X_16414_ _16411_/A _16414_/B _16414_/C VDD VSS _16442_/B AOI2B1X1
XFILLER_60_799 VDD VSS FILLER4
XTAP_TAPCELL_ROW_14_154 VDD VSS WELLTAP
X_10838_ _11039_/C _10838_/B _10838_/C _10838_/D VDD VSS _10840_/B AO211X2
X_13626_ _13721_/A _13721_/B VDD VSS _14390_/B XNOR2X1
X_17394_ _19837_/Q _19805_/Q VDD VSS _17395_/B XOR2X1
X_10769_ _10794_/A _10769_/B VDD VSS _10771_/B XNOR2X1
X_13557_ _13557_/A _13557_/B _13557_/C VDD VSS _14482_/B OR3X2
X_19133_ _19187_/CK _19133_/D _19133_/Q VDD VSS DFFQX1
X_16345_ _16345_/A _16364_/B VDD VSS _16818_/B XNOR2X1
XFILLER_118_518 VDD VSS FILLER4
XFILLER_118_529 VDD VSS FILLER4
XFILLER_12_192 VDD VSS FILLER1
XFILLER_9_664 VDD VSS FILLER4
X_12508_ _19073_/Q _12625_/B _12625_/C VDD VSS _12803_/B XNOR3X1
X_13488_ _14158_/A _17911_/B VDD VSS _18859_/D AND2X1
X_19064_ _19064_/CK _19064_/D _19064_/Q VDD VSS DFFQX1
X_16276_ _19721_/Q _16885_/B VDD VSS _16302_/A NOR2X1
XFILLER_8_185 VSS VDD FILLER2
X_12439_ _18961_/Q VDD VSS _12535_/A INVX1
X_18015_ _18529_/Q _18015_/B VDD VSS _18016_/B XOR2X1
X_15227_ _15201_/B _15227_/B VDD VSS _15284_/B NAND2BX1
XFILLER_5_881 VSS VDD FILLER2
X_15158_ _19455_/Q _15158_/B _15198_/C VDD VSS _15200_/B XNOR3X1
XFILLER_99_468 VDD VSS FILLER4
X_14109_ _17983_/B _17983_/C _18127_/B VDD VSS _18871_/D OA21X2
X_19966_ _19984_/CK _19966_/D _19966_/Q VDD VSS DFFQX1
X_15089_ _15089_/A _15809_/B _15809_/C VDD VSS _15090_/A NOR3X1
XFILLER_101_407 VDD VSS FILLER1
XFILLER_68_800 VDD VSS DECAPHV8
X_18917_ _18917_/CK _18917_/D _18917_/Q VDD VSS DFFQX1
XFILLER_79_170 VDD VSS DECAPHV16
X_09650_ _09812_/C _09650_/B _09650_/C _09650_/D VDD VSS _18284_/D OAI211X1
X_19897_ clkload9/A _19897_/D _19897_/Q VDD VSS DFFQX1
XFILLER_55_505 VDD VSS FILLER1
XFILLER_94_151 VSS VDD FILLER2
X_18848_ _18878_/CK _18848_/D _18848_/Q VDD VSS DFFQX1
XFILLER_55_538 VDD VSS FILLER4
XFILLER_82_324 VDD VSS FILLER1
X_09581_ _09581_/A _09581_/B _09818_/C _18260_/Q _09581_/E VDD VSS _09582_/C AOI221X1
X_18779_ _18779_/CK _18779_/D _18779_/Q VDD VSS DFFQX1
XFILLER_24_947 VSS VDD FILLER2
XFILLER_50_276 VDD VSS FILLER1
XFILLER_88_18 VDD VSS DECAPHV8
XFILLER_105_713 VSS VDD FILLER2
XFILLER_144_370 VDD VSS DECAPHV32
XFILLER_132_598 VDD VSS FILLER4
X_09917_ _09874_/B _09861_/B _09928_/C VDD VSS _09990_/B MUXI2X1
X_20106_ _20106_/A VDD VSS _20106_/Y BUFX3
XFILLER_144_68 VDD VSS FILLER1
XFILLER_74_825 VSS VDD FILLER2
XFILLER_86_663 VDD VSS DECAPHV16
XFILLER_86_685 VDD VSS DECAPHV8
X_09848_ _09848_/A VDD VSS _09855_/B INVX1
X_20037_ _20043_/CK _20037_/D _20037_/Q _20043_/RB VDD VSS DFFRQX1
XFILLER_46_538 VDD VSS FILLER1
XFILLER_85_184 VSS VDD FILLER2
X_09779_ _18341_/Q VDD VSS _20095_/A INVX1
XFILLER_27_763 VDD VSS FILLER4
XFILLER_73_357 VDD VSS FILLER1
XTAP_TAPCELL_ROW_84_853 VDD VSS WELLTAP
X_11810_ _11854_/B _11820_/B VDD VSS _14397_/B XOR2X1
X_12790_ _12790_/A _12790_/B _14120_/B VDD VSS _12791_/B MIN3X1
XFILLER_42_700 VSS VDD FILLER2
XTAP_TAPCELL_ROW_56_577 VDD VSS WELLTAP
X_11741_ _19990_/Q _19254_/Q VDD VSS _11742_/D NAND2X1
XFILLER_30_906 VSS VDD FILLER2
XFILLER_41_221 VSS VDD FILLER2
XFILLER_53_21 VDD VSS FILLER4
Xclkbuf_leaf_2_clk_regs clkbuf_leaf_9_clk_regs/A VDD VSS clkload9/A BUFX12
XFILLER_42_766 VDD VSS FILLER4
X_11672_ _18810_/Q _14547_/B VDD VSS _18837_/D AND2X1
X_14460_ _14421_/Y _14460_/B _14460_/C VDD VSS _19174_/D AND3BX1
XFILLER_139_120 VDD VSS FILLER1
X_10623_ _10655_/A _10746_/B _10746_/C _11267_/A VDD VSS _10624_/D AOI211X1
X_13411_ _14323_/A _14323_/B VDD VSS _13416_/B _14323_/C NAND3X1
X_14391_ _14410_/A _14391_/B _14391_/C VDD VSS _19113_/D NOR3X1
XFILLER_127_315 VDD VSS FILLER1
XFILLER_128_838 VSS VDD FILLER2
XTAP_TAPCELL_ROW_11_124 VDD VSS WELLTAP
X_10554_ _19944_/Q _18826_/Q VDD VSS _10556_/C AND2X1
X_13342_ _13466_/A _13466_/B _13466_/E VDD VSS _13449_/B AOI21X1
X_16130_ _19651_/Q _16808_/B VDD VSS _16131_/C NOR2X1
XFILLER_10_696 VDD VSS FILLER1
XFILLER_139_197 VDD VSS FILLER4
XFILLER_108_562 VSS VDD FILLER2
XFILLER_6_678 VSS VDD FILLER2
X_10485_ _18663_/Q _18771_/Q VDD VSS _10521_/C XNOR2X1
X_13273_ _19052_/Q _14323_/B VDD VSS _13274_/D _14322_/C NAND3X1
X_16061_ _19552_/Q VDD VSS _16062_/A INVX1
X_12224_ _12401_/A _12401_/B _12224_/C VDD VSS _14500_/C OAI21X1
X_15012_ _15056_/D VDD VSS _15013_/D INVX1
XFILLER_123_554 VDD VSS FILLER4
X_12155_ _12155_/A _14433_/B _12155_/C _12155_/D VDD VSS _12171_/B OAOI211X1
X_19820_ _19892_/CK _19820_/D _19820_/Q VDD VSS DFFQX1
XFILLER_111_738 VDD VSS FILLER4
X_11106_ _18679_/Q _18787_/Q VDD VSS _11107_/C AND2X1
X_19751_ _19792_/CK _19751_/D _19751_/Q VDD VSS DFFQX1
Xclkbuf_2_1__f_sclk_regs clkbuf_0_sclk_regs/Y VDD VSS _20054_/CK BUFX12
XFILLER_78_95 VSS VDD FILLER2
X_12086_ _19123_/Q _14402_/B VDD VSS _12149_/A NOR2BX1
X_18702_ _18785_/CK _18702_/D _18702_/Q VDD VSS DFFQX1
X_16963_ _19746_/Q _19747_/Q _16978_/B VDD VSS _16973_/D OAI21X1
XFILLER_65_825 VDD VSS FILLER4
X_11037_ _11037_/A _11037_/B _11037_/C VDD VSS _11070_/C OAI21X1
X_19682_ _19730_/CK _19682_/D _19682_/Q VDD VSS DFFQX1
X_16894_ _16976_/A _16894_/B VDD VSS _19729_/D NOR2X1
X_15914_ _19898_/Q _19546_/Q VDD VSS _15923_/A NAND2BX1
XFILLER_37_538 VDD VSS FILLER1
XTAP_TAPCELL_ROW_19_202 VDD VSS WELLTAP
X_18633_ _19940_/CK _18633_/D _18633_/Q VDD VSS DFFQX1
X_15845_ _15849_/A _15845_/B VDD VSS _19459_/D AND2X1
XFILLER_91_143 VDD VSS FILLER1
XFILLER_92_655 VDD VSS FILLER1
X_18564_ _18565_/CK _18564_/D _18564_/Q VDD VSS DFFQX1
XFILLER_73_880 VDD VSS FILLER4
X_12988_ _18883_/Q VDD VSS _13183_/A INVX1
X_17515_ _17517_/A _17517_/B _17515_/C VDD VSS _19862_/D AOI21X1
X_15776_ _15806_/A _15776_/B _15776_/C VDD VSS _19397_/D NOR3X1
X_11939_ _19121_/Q _11969_/A _11973_/D VDD VSS _12022_/B XNOR3X1
X_18495_ _18503_/CK _18516_/Q _20108_/A _18496_/RB VDD VSS DFFRQX1
X_14727_ _14727_/A _14727_/B _15705_/B VDD VSS _14770_/B MIN3X1
XTAP_TAPCELL_ROW_102_1038 VDD VSS WELLTAP
XTAP_TAPCELL_ROW_27_290 VDD VSS WELLTAP
X_14658_ _14658_/A _14658_/B _14739_/B _14658_/D VDD VSS _14659_/B AOI22X1
X_17446_ _19847_/Q _19815_/Q _17446_/C VDD VSS _17450_/C MIN3X1
X_13609_ _14226_/A wire155/Y _14226_/C _13609_/D VDD VSS _13768_/A OAOI211X1
X_17377_ _17377_/A _17377_/B _17377_/C VDD VSS _17379_/A OA21X2
XFILLER_118_304 VSS VDD FILLER2
X_14589_ _15887_/B _15887_/C _19494_/Q VDD VSS _14601_/D AOI21X1
X_19116_ _19172_/CK _19116_/D _19116_/Q VDD VSS DFFQX1
X_16328_ _19723_/Q _16887_/B VDD VSS _16329_/B XNOR2X1
XFILLER_118_359 VDD VSS FILLER1
XFILLER_133_307 VDD VSS DECAPHV8
X_19047_ _19096_/CK _19047_/D _19047_/Q VDD VSS DFFQX1
X_16259_ _19561_/Q _19913_/Q VDD VSS _16260_/B XNOR2X1
XFILLER_114_521 VDD VSS DECAPHV32
XFILLER_57_0 VDD VSS FILLER4
XFILLER_88_906 VDD VSS DECAPHV16
XFILLER_99_254 VSS VDD FILLER2
XTAP_TAPCELL_ROW_113_1145 VDD VSS WELLTAP
XFILLER_114_587 VDD VSS FILLER1
XFILLER_87_416 VDD VSS DECAPHV8
XFILLER_99_276 VSS VDD FILLER2
X_19949_ _19949_/CK _19949_/D _19949_/Q VDD VSS DFFQX1
XFILLER_114_49 VDD VSS FILLER4
XFILLER_68_652 VSS VDD FILLER2
X_09702_ _18352_/Q VDD VSS _20220_/A INVX1
XFILLER_28_538 VDD VSS FILLER4
XFILLER_68_696 VDD VSS FILLER1
X_09633_ _20184_/A _09753_/A _09633_/C VDD VSS _09634_/E AOI2B1X1
XFILLER_82_121 VDD VSS FILLER1
X_09564_ _09630_/C _18505_/Q _18506_/Q VDD VSS _09767_/B NOR3BX1
XFILLER_83_699 VDD VSS DECAPHV8
XTAP_TAPCELL_ROW_124_1252 VDD VSS WELLTAP
XTAP_TAPCELL_ROW_81_823 VDD VSS WELLTAP
XFILLER_63_390 VSS VDD FILLER2
XTAP_TAPCELL_ROW_53_547 VDD VSS WELLTAP
X_09495_ _18444_/D _09501_/B _09495_/C VDD VSS _18237_/D AOI21X1
XFILLER_23_298 VSS VDD FILLER2
XFILLER_137_613 VDD VSS FILLER1
XFILLER_139_24 VSS VDD FILLER2
XFILLER_109_326 VDD VSS DECAPHV16
XFILLER_136_112 VDD VSS FILLER4
XTAP_TAPCELL_ROW_135_1370 VDD VSS WELLTAP
X_10270_ _10346_/A _10655_/A VDD VSS _10585_/C _10349_/B _10346_/B NAND4X2
XFILLER_117_392 VDD VSS DECAPHV8
XFILLER_133_885 VDD VSS FILLER1
XTAP_TAPCELL_ROW_89_901 VDD VSS WELLTAP
XFILLER_120_535 VDD VSS FILLER1
XFILLER_120_557 VDD VSS DECAPHV16
XFILLER_120_579 VDD VSS FILLER4
XFILLER_47_814 VSS VDD FILLER2
X_13960_ _14004_/A _14004_/B VDD VSS _13970_/B NOR2X1
XFILLER_74_622 VSS VDD FILLER2
X_12911_ _14382_/B _14382_/C _19104_/Q VDD VSS _12913_/C AOI21X1
XFILLER_46_357 VDD VSS FILLER4
XFILLER_64_20 VDD VSS FILLER1
XFILLER_73_143 VDD VSS FILLER1
X_13891_ _13891_/A _13891_/B _13891_/C _13891_/D VDD VSS _13998_/A AOAI211X1
X_15630_ _15637_/A _15637_/B VDD VSS _15700_/B XNOR2X1
XFILLER_62_828 VDD VSS DECAPHV16
XFILLER_73_176 VSS VDD FILLER2
X_12842_ _12945_/A _12968_/A _12951_/B VDD VSS _12843_/D XNOR3X1
XFILLER_15_733 VSS VDD FILLER2
X_12773_ _12936_/A _12940_/B _12773_/C VDD VSS _12822_/B XNOR3X1
X_15561_ _15561_/A _15564_/C VDD VSS _18155_/B XNOR2X1
XFILLER_42_563 VDD VSS DECAPHV16
X_11724_ _11724_/A _11724_/B _11724_/C _11724_/D VDD VSS _11778_/A OAOI211X1
X_14512_ _14539_/A _14512_/B VDD VSS _19219_/D NOR2X1
X_18280_ _18291_/CK _18280_/D _18280_/Q VDD VSS DFFQX1
X_17300_ _17450_/B _17300_/B _17300_/C VDD VSS _17305_/C MIN3X1
X_15492_ _15492_/A _15492_/B _15492_/C VDD VSS _15493_/B NOR3X1
XFILLER_120_81 VSS VDD FILLER2
XFILLER_120_92 VDD VSS FILLER1
XFILLER_30_736 VDD VSS FILLER1
XFILLER_42_596 VDD VSS DECAPHV8
XFILLER_9_37 VDD VSS FILLER1
XTAP_TAPCELL_ROW_24_260 VDD VSS WELLTAP
X_11655_ _18795_/Q _11658_/B VDD VSS _18822_/D AND2X1
X_14443_ _14449_/A _14443_/B _14443_/C VDD VSS _19159_/D NOR3X1
X_17231_ _17838_/A VDD VSS _17306_/C BUFX3
XFILLER_30_758 VDD VSS FILLER1
X_10606_ _10633_/A _10633_/B _10607_/C _10686_/D VDD VSS _10607_/D AOAI211X1
X_11586_ _18732_/Q _11589_/B VDD VSS _18759_/D AND2X1
X_14374_ _14393_/A _14374_/B VDD VSS _19097_/D NOR2X1
X_17162_ _19787_/Q _19755_/Q VDD VSS _17168_/B NAND2X1
X_10537_ _10843_/A _10701_/C VDD VSS _10844_/C NOR2X1
X_13325_ _19110_/Q VDD VSS _13436_/A INVX1
X_17093_ _19773_/Q _19741_/Q VDD VSS _17094_/B XOR2X1
X_16113_ _19555_/Q _19907_/Q VDD VSS _16114_/B XNOR2X1
XFILLER_127_189 VDD VSS FILLER4
X_10468_ _10503_/A _10503_/B _10595_/A VDD VSS _10469_/B OAI21X1
X_13256_ _13260_/A _13343_/A VDD VSS _14543_/B XNOR2X1
X_16044_ _19648_/Q _16805_/B VDD VSS _16057_/B XOR2X1
XFILLER_124_830 VDD VSS DECAPHV8
X_12207_ _12283_/A _12283_/B _14342_/B VDD VSS _12512_/B MIN3X1
XFILLER_111_502 VDD VSS FILLER4
X_10399_ _10399_/A _10399_/B _10399_/C _10399_/D VDD VSS _10441_/B AOAI211X1
X_13187_ _13295_/A _13295_/B VDD VSS _14190_/B _13295_/C NAND3X1
XFILLER_123_395 VDD VSS FILLER1
XFILLER_96_235 VSS VDD FILLER2
XFILLER_97_747 VDD VSS DECAPHV8
X_12138_ _12284_/A _12284_/B _14339_/B VDD VSS _12188_/A MIN3X1
X_19803_ clkload4/A _19803_/D _19803_/Q VDD VSS DFFQX1
X_17995_ _18535_/Q _18536_/Q VDD VSS _18032_/B _18030_/B AND3X2
X_12069_ _18927_/Q _14175_/B VDD VSS _12129_/B NOR2X1
X_19734_ _19736_/CK _19734_/D _19734_/Q VDD VSS DFFQX1
X_16946_ _19744_/Q VDD VSS _17114_/B INVX1
X_19665_ _19696_/CK _19665_/D _19665_/Q VDD VSS DFFQX1
XFILLER_65_666 VSS VDD FILLER2
X_18616_ _18622_/CK _18616_/D _18616_/Q VDD VSS DFFQX1
X_16877_ _17391_/A VDD VSS _16891_/A BUFX3
XFILLER_25_508 VDD VSS FILLER1
X_19596_ _19636_/CK _19596_/D _19596_/Q VDD VSS DFFQX1
X_15828_ _15830_/A _15828_/B VDD VSS _19443_/D NOR2X1
X_18547_ _18550_/CK _18547_/D _18547_/Q VDD VSS DFFQX1
X_15759_ _15770_/A _15759_/B VDD VSS _19382_/D AND2X1
XFILLER_33_541 VSS VDD FILLER2
X_09280_ _09362_/AB _09349_/B VDD VSS _09280_/Y NOR2BX1
X_18478_ _18479_/CK _18478_/D _18478_/Q _18496_/RB VDD VSS DFFRQX1
XFILLER_20_224 VDD VSS FILLER1
XFILLER_21_747 VDD VSS DECAPHV8
XTAP_TAPCELL_ROW_50_517 VDD VSS WELLTAP
X_17429_ _17431_/A _17431_/B _17429_/C VDD VSS _19844_/D AOI21X1
XFILLER_107_819 VSS VDD FILLER2
XFILLER_109_38 VSS VDD FILLER2
XFILLER_133_115 VSS VDD FILLER2
Xclkload61 _19196_/CK VDD VSS clkload61/Y INVX1
Xclkload50 _19215_/CK VDD VSS clkload50/Y INVX2
Xclkload94 _19737_/CK VDD VSS clkload94/Y BUFX12
Xclkload83 _19466_/CK VDD VSS clkload83/Y INVX1
Xclkload72 _18878_/CK VDD VSS clkload72/Y INVX2
XFILLER_0_629 VDD VSS FILLER1
XFILLER_115_885 VDD VSS FILLER1
XFILLER_102_557 VSS VDD FILLER2
XFILLER_130_877 VDD VSS FILLER1
XFILLER_18_24 VDD VSS DECAPHV8
XFILLER_84_920 VDD VSS FILLER1
XFILLER_56_688 VDD VSS DECAPHV8
XFILLER_83_485 VDD VSS FILLER1
XTAP_TAPCELL_ROW_66_672 VDD VSS WELLTAP
X_09616_ _18426_/Q _09696_/B _09616_/C _09776_/A VDD VSS _09617_/E OAOI211X1
XTAP_TAPCELL_ROW_38_396 VDD VSS WELLTAP
X_09547_ _20041_/Q _09547_/B VDD VSS _20042_/D NOR2BX1
XFILLER_24_541 VDD VSS DECAPHV8
XFILLER_71_669 VDD VSS FILLER1
X_09478_ _19978_/Q _09490_/B _09482_/C VDD VSS _09479_/C AOI21X1
XFILLER_133_4 VDD VSS FILLER1
XFILLER_8_729 VSS VDD FILLER2
XFILLER_137_421 VDD VSS FILLER1
XTAP_TAPCELL_ROW_21_230 VDD VSS WELLTAP
X_11440_ _13177_/A _11440_/B VDD VSS _18629_/D NOR2X1
Xclkload0 _231_/CK VDD VSS clkload0/Y INVX1
XFILLER_109_156 VDD VSS FILLER4
X_11371_ _11365_/B _11371_/B VDD VSS _11379_/C NOR2BX1
Xwire159 wire159/A VDD VSS wire159/Y BUFX4
XFILLER_109_189 VDD VSS FILLER4
XFILLER_137_487 VDD VSS FILLER4
X_10322_ _18659_/Q _18767_/Q VDD VSS _10323_/D XNOR2X1
X_13110_ _19162_/Q _14446_/B VDD VSS _13111_/D _14446_/C NAND3X1
X_14090_ _18898_/Q _14096_/A _14104_/B VDD VSS _14093_/D XNOR3X1
X_13041_ _13041_/A _14413_/B _13041_/C _13041_/D VDD VSS _13316_/A OAOI211X1
XFILLER_106_863 VDD VSS FILLER1
X_10253_ _18623_/Q _18624_/Q _11436_/C VDD VSS _10269_/D OAI21X1
XFILLER_120_321 VDD VSS FILLER4
XFILLER_133_693 VDD VSS DECAPHV8
XFILLER_78_235 VSS VDD FILLER2
XFILLER_79_747 VDD VSS FILLER4
X_10184_ _10184_/A _10184_/B _10184_/C VDD VSS _10188_/B AOI21X1
XFILLER_120_343 VDD VSS FILLER1
XFILLER_132_192 VDD VSS FILLER1
XFILLER_94_706 VDD VSS FILLER1
X_17780_ _19920_/Q _19888_/Q VDD VSS _17785_/A XNOR2X1
X_16800_ _16811_/A _16800_/B VDD VSS _19643_/D NOR2X1
XFILLER_59_482 VSS VDD FILLER2
X_16731_ _16735_/A _16731_/B VDD VSS _19582_/D NOR2X1
X_14992_ _19367_/Q _14992_/B _15743_/B VDD VSS _15039_/B MIN3X1
XFILLER_115_92 VDD VSS FILLER1
XFILLER_46_132 VSS VDD FILLER2
X_13943_ _18921_/Q _14168_/B VDD VSS _14020_/A AND2X1
XFILLER_75_96 VDD VSS DECAPHV8
XTAP_TAPCELL_ROW_144_1458 VDD VSS WELLTAP
XTAP_TAPCELL_ROW_144_1469 VDD VSS WELLTAP
X_13874_ _14132_/A _14132_/B _14132_/C _13874_/D VDD VSS _13938_/A OAOI211X1
X_19450_ _19483_/CK _19450_/D _19450_/Q VDD VSS DFFQX1
X_16662_ _16672_/B _16662_/B VDD VSS _16669_/A XNOR2X1
XFILLER_61_113 VDD VSS FILLER1
XFILLER_62_636 VDD VSS FILLER1
X_12825_ _19133_/Q VDD VSS _12938_/A INVX1
X_19381_ _19385_/CK _19381_/D _19381_/Q VDD VSS DFFQX1
X_18401_ _18407_/CK _18465_/D _20142_/A _18452_/RB VDD VSS DFFRQX1
X_16593_ _16620_/A _16620_/B VDD VSS _16613_/A NAND2X1
X_15613_ _19327_/Q _15699_/B VDD VSS _15614_/C AND2X1
XFILLER_131_80 VDD VSS FILLER1
X_18332_ _18342_/CK _18513_/Q _20086_/A _18373_/RB VDD VSS DFFRQX1
X_15544_ _19436_/Q _15821_/B VDD VSS _15552_/A NOR2BX1
XFILLER_15_585 VSS VDD FILLER2
XFILLER_42_382 VDD VSS DECAPHV16
XFILLER_43_894 VDD VSS DECAPHV8
XFILLER_61_179 VDD VSS FILLER4
X_12756_ _12763_/A _12763_/B _12763_/C _12763_/D VDD VSS _14537_/B OA211X2
X_11707_ _11724_/A _11724_/B VDD VSS _11709_/B NOR2X1
X_12687_ _19131_/Q _12813_/B _12813_/C VDD VSS _12910_/B XNOR3X1
X_18263_ _18272_/CK _18263_/D _18263_/Q _20079_/RB VDD VSS DFFRQX1
X_15475_ _19544_/Q _15475_/B VDD VSS _15476_/B NAND2X1
XFILLER_128_421 VSS VDD FILLER2
X_11638_ _18779_/Q _11647_/B VDD VSS _18806_/D AND2X1
X_14426_ _14426_/A _14426_/B VDD VSS _19144_/D NOR2X1
X_18194_ _18194_/A VDD VSS _18195_/B INVX1
X_17214_ _17215_/B _17214_/B VDD VSS _17216_/B NOR2BX1
XFILLER_144_903 VDD VSS DECAPHV32
X_14357_ _17566_/A VDD VSS _14410_/A BUFX3
X_17145_ _17147_/C _17145_/B _17145_/C VDD VSS _19783_/D AOI21X1
XFILLER_116_616 VDD VSS FILLER1
XFILLER_143_402 VDD VSS DECAPHV8
XFILLER_7_795 VDD VSS DECAPHV8
X_11569_ _18716_/Q _11578_/B VDD VSS _18743_/D AND2X1
X_13308_ _13308_/A _14259_/B _14259_/C VDD VSS _13309_/D NOR3X1
X_14288_ _14457_/A VDD VSS _14311_/A BUFX3
X_17076_ _17077_/C _17469_/B _17076_/C VDD VSS _19768_/D AND3BX1
XFILLER_143_468 VSS VDD FILLER2
XFILLER_69_202 VDD VSS DECAPHV16
X_13239_ _13339_/A _13345_/A _13343_/A VDD VSS _13240_/D XNOR3X1
X_16027_ _16100_/A _16027_/B VDD VSS _19519_/D NOR2X1
XFILLER_69_224 VDD VSS FILLER1
XTAP_TAPCELL_ROW_110_1115 VDD VSS WELLTAP
XFILLER_111_332 VDD VSS FILLER1
XFILLER_112_855 VSS VDD FILLER2
XFILLER_69_257 VDD VSS FILLER1
XFILLER_97_555 VSS VDD FILLER2
XFILLER_38_600 VDD VSS FILLER4
XFILLER_66_920 VSS VDD FILLER2
XFILLER_78_780 VDD VSS DECAPHV8
XFILLER_97_588 VDD VSS FILLER4
X_17978_ _18871_/Q _17978_/B _17978_/C VDD VSS _17980_/B XNOR3X1
XFILLER_26_806 VDD VSS FILLER4
X_19717_ _19730_/CK _19717_/D _19717_/Q VDD VSS DFFQX1
X_16929_ _19741_/Q _17078_/B VDD VSS _16931_/B XOR2X1
X_19648_ _19678_/CK _19648_/D _19648_/Q VDD VSS DFFQX1
XFILLER_37_198 VSS VDD FILLER2
X_09401_ _18006_/C VDD VSS _18087_/D BUFX3
X_19579_ _19643_/CK _19579_/D _19579_/Q VDD VSS DFFQX1
XFILLER_52_146 VSS VDD FILLER2
XFILLER_53_669 VSS VDD FILLER2
XTAP_TAPCELL_ROW_108_1099 VDD VSS WELLTAP
XTAP_TAPCELL_ROW_121_1222 VDD VSS WELLTAP
XTAP_TAPCELL_ROW_63_642 VDD VSS WELLTAP
X_09332_ _18286_/Q _18477_/D _09354_/B VDD VSS _09332_/Y MUXI2X1
XFILLER_21_511 VDD VSS FILLER1
XTAP_TAPCELL_ROW_35_366 VDD VSS WELLTAP
XFILLER_60_190 VDD VSS FILLER1
X_09263_ _09299_/A VDD VSS _09354_/B BUFX3
X_09194_ _18517_/Q VDD VSS _18448_/D INVX1
XFILLER_134_413 VDD VSS FILLER1
XFILLER_106_126 VDD VSS DECAPHV8
XFILLER_107_649 VSS VDD FILLER2
XFILLER_134_446 VDD VSS DECAPHV8
XFILLER_103_811 VDD VSS FILLER4
XFILLER_1_916 VDD VSS DECAPHV8
XTAP_TAPCELL_ROW_132_1340 VDD VSS WELLTAP
XFILLER_102_310 VDD VSS FILLER1
XFILLER_114_181 VDD VSS FILLER4
XFILLER_1_938 VDD VSS DECAPHV8
XFILLER_88_522 VDD VSS FILLER4
XFILLER_88_533 VDD VSS FILLER1
XFILLER_0_448 VSS VDD FILLER2
XFILLER_29_12 VDD VSS FILLER1
XFILLER_29_23 VDD VSS FILLER1
XFILLER_29_67 VDD VSS DECAPHV8
XFILLER_76_728 VSS VDD FILLER2
XFILLER_17_817 VSS VDD FILLER2
XFILLER_90_219 VDD VSS FILLER4
X_10940_ _10940_/A _10940_/B _10940_/C _10940_/D VDD VSS _10978_/C AOI211X1
XFILLER_45_44 VDD VSS FILLER4
XFILLER_71_422 VDD VSS FILLER1
XFILLER_83_282 VDD VSS DECAPHV8
XFILLER_43_157 VDD VSS FILLER1
XFILLER_45_99 VDD VSS FILLER4
X_10871_ _10871_/A _10871_/B _10871_/C _10871_/D VDD VSS _10899_/C AOI31X1
X_12610_ _12610_/A _12610_/B _14115_/B VDD VSS _12611_/B MIN3X1
X_13590_ _18916_/Q _14162_/B _14162_/C VDD VSS _13591_/D OR3BX1
XFILLER_40_853 VSS VDD FILLER2
XFILLER_61_32 VDD VSS FILLER4
XFILLER_61_43 VDD VSS FILLER1
X_12541_ _12632_/A _12632_/B VDD VSS _12598_/B NOR2X1
XFILLER_40_886 VDD VSS FILLER4
X_12472_ _12472_/A _12472_/B _12472_/C _12472_/D VDD VSS _14439_/B AOAI211X1
X_15260_ _19373_/Q _15260_/B _15750_/B VDD VSS _15303_/B MIN3X1
X_11423_ _17812_/A VDD VSS _14163_/A BUFX3
X_14211_ _14231_/A _14211_/B VDD VSS _18960_/D AND2X1
XANTENNA_9 input4/Y VDD VSS ANTENNA2
XFILLER_126_947 VSS VDD FILLER2
Xdelaybuf_6_clk delaybuf_6_clk/A VDD VSS delaybuf_7_clk/A BUFX12
X_15191_ _15191_/A _15191_/B _15191_/C _15191_/D VDD VSS _15275_/C OAI211X1
XFILLER_125_424 VDD VSS FILLER4
X_11354_ _11383_/A _11354_/B VDD VSS _18589_/D NOR2X1
X_14142_ _14142_/A _14142_/B VDD VSS _18899_/D NOR2X1
XFILLER_125_468 VDD VSS FILLER4
XFILLER_4_776 VDD VSS FILLER1
X_10305_ _10546_/A _10546_/B VDD VSS _10595_/A NAND2X1
X_11285_ _11285_/A _11285_/B _11285_/C VDD VSS _11296_/B OAI21X1
X_14073_ _18897_/Q _14073_/B _14078_/C VDD VSS _17964_/C XNOR3X1
X_18950_ _18950_/CK _18950_/D _18950_/Q VDD VSS DFFQX1
XFILLER_140_427 VDD VSS DECAPHV8
XFILLER_79_533 VSS VDD FILLER2
X_10236_ _18623_/Q _11435_/B VDD VSS _10237_/B NOR2BX1
X_13024_ _13314_/A _13314_/B VDD VSS _14384_/B XNOR2X1
X_18881_ _18908_/CK _18881_/D _18881_/Q VDD VSS DFFQX1
X_17901_ _18857_/Q _17901_/B _17901_/C VDD VSS _17905_/C MIN3X1
XFILLER_39_408 VDD VSS DECAPHV16
X_17832_ _19930_/Q _19931_/Q _19932_/Q _19933_/Q VDD VSS _17834_/B AOI31X1
XFILLER_94_514 VDD VSS DECAPHV8
X_10167_ _10167_/A _10167_/B _10167_/C VDD VSS _10167_/Y OAI21X1
X_10098_ _18607_/Q _10098_/B _10098_/C VDD VSS _10101_/C OAI21X1
X_17763_ _17766_/A _17763_/B _17763_/C VDD VSS _19915_/D AOI21X1
X_14975_ _19451_/Q _14975_/B _15000_/C VDD VSS _14995_/C XNOR3X1
XTAP_TAPCELL_ROW_77_789 VDD VSS WELLTAP
X_13926_ _18893_/Q _13931_/B _13981_/D VDD VSS _13978_/C XNOR3X1
X_19502_ _19533_/CK _19502_/D _19502_/Q VDD VSS DFFQX1
X_17694_ _19901_/Q _19869_/Q VDD VSS _17695_/B XOR2X1
X_16714_ _17776_/A _16724_/B VDD VSS _19566_/D NOR2X1
XFILLER_35_647 VDD VSS FILLER1
X_19433_ _19461_/CK _19433_/D _19433_/Q VDD VSS DFFQX1
X_16645_ _16638_/B _16645_/B _16645_/C VDD VSS _16670_/B AOI2B1X1
X_13857_ _13857_/A _13857_/B _13857_/C _13857_/D VDD VSS _14363_/B OAOI211X1
XFILLER_31_820 VDD VSS DECAPHV16
XFILLER_50_628 VDD VSS DECAPHV8
XTAP_TAPCELL_ROW_60_612 VDD VSS WELLTAP
X_12808_ _12821_/A _12821_/B _12821_/C VDD VSS _14349_/B OAI21X1
X_13788_ _13791_/A _13791_/C _13791_/B _13788_/D VDD VSS _14393_/B OAOI211X1
X_19364_ _19393_/CK _19364_/D _19364_/Q VDD VSS DFFQX1
X_16576_ _16602_/C _16576_/B VDD VSS _16756_/B XNOR2X1
XFILLER_31_864 VDD VSS FILLER4
XFILLER_42_190 VSS VDD FILLER2
XTAP_TAPCELL_ROW_32_336 VDD VSS WELLTAP
X_12739_ _12747_/A _12739_/B _12739_/C VDD VSS _12816_/C XNOR3X1
X_19295_ _19322_/CK _19295_/D _19295_/Q VDD VSS DFFQX1
X_18315_ _18327_/CK _18512_/Q _18315_/Q _18453_/RB VDD VSS DFFRQX1
X_15527_ _15540_/A _15757_/B VDD VSS _15541_/C XNOR2X1
X_18246_ _18255_/CK _18246_/D _18271_/D _18485_/RB VDD VSS DFFRQX1
X_15458_ _19322_/Q _15693_/B VDD VSS _15459_/B XNOR2X1
X_14409_ _14410_/A _14409_/B _14409_/C VDD VSS _19130_/D NOR3X1
XFILLER_128_262 VDD VSS FILLER1
X_18177_ _18179_/C _18177_/B VDD VSS _18178_/B XNOR2X1
X_15389_ _15389_/A _15389_/B _15389_/C VDD VSS _15427_/A OAI21X1
XFILLER_117_947 VSS VDD FILLER2
X_17128_ _19779_/Q _19747_/Q _17128_/C VDD VSS _17132_/B MIN3X1
XFILLER_116_457 VSS VDD FILLER2
X_09950_ _09897_/Y _09949_/Y _10032_/A VDD VSS _09950_/Y MUXI2X1
X_17059_ _17208_/B _17062_/C _17059_/C VDD VSS _17060_/B MIN3X1
X_20070_ clkload6/A _20070_/D _20070_/Q _20071_/RB VDD VSS DFFRQX1
XFILLER_112_663 VSS VDD FILLER2
X_09881_ _18566_/Q _09881_/B VDD VSS _09882_/B NAND2X1
XFILLER_111_140 VSS VDD FILLER2
XFILLER_112_696 VDD VSS FILLER1
XFILLER_98_886 VDD VSS DECAPHV8
XFILLER_57_227 VDD VSS FILLER1
XFILLER_122_27 VSS VDD FILLER2
XFILLER_66_750 VSS VDD FILLER2
Xclkbuf_2_3__f__001_ clkbuf_0__001_/Y VDD VSS clkbuf_2_3__f__001_/Y BUFX12
XFILLER_122_49 VDD VSS DECAPHV8
XTAP_TAPCELL_ROW_48_491 VDD VSS WELLTAP
XFILLER_41_628 VDD VSS DECAPHV8
XFILLER_40_138 VDD VSS FILLER1
X_09315_ _18404_/D _09314_/Y _09302_/Y VDD VSS _18521_/D MUXI2X1
XFILLER_22_886 VSS VDD FILLER2
X_09246_ _18499_/D VDD VSS _18339_/D INVX1
XFILLER_119_262 VDD VSS DECAPHV16
XTAP_TAPCELL_ROW_2_39 VDD VSS WELLTAP
XFILLER_107_468 VSS VDD FILLER2
XFILLER_123_928 VSS VDD FILLER2
XFILLER_135_777 VDD VSS FILLER4
XFILLER_1_702 VSS VDD FILLER2
Xoutput24 _20108_/Y VDD VSS o_bias_cfg[10] BUFX3
Xoutput13 _20097_/Y VDD VSS o_aux_ctrl[15] BUFX3
XFILLER_122_438 VDD VSS DECAPHV16
X_11070_ _19958_/Q _18840_/Q _11070_/C VDD VSS _11072_/B MIN3X1
Xoutput35 _20118_/Y VDD VSS o_bias_cfg[20] BUFX3
Xoutput46 _20128_/Y VDD VSS o_bias_cfg[30] BUFX3
Xoutput57 _20107_/Y VDD VSS o_bias_cfg[9] BUFX3
X_10021_ _10022_/A _10022_/B _10022_/C VDD VSS _10021_/Y NOR3X1
Xoutput68 _20134_/Y VDD VSS o_clk_cfg[1] BUFX3
Xoutput79 _20153_/Y VDD VSS o_en_ctrl[1] BUFX3
XFILLER_0_256 VDD VSS FILLER1
XFILLER_76_514 VDD VSS DECAPHV32
X_20199_ _20199_/A VDD VSS _20199_/Y BUFX3
XFILLER_56_21 VDD VSS FILLER1
XFILLER_76_558 VDD VSS DECAPHV16
X_14760_ _19362_/Q _15737_/B VDD VSS _14761_/B XNOR2X1
XFILLER_17_647 VDD VSS FILLER4
XFILLER_44_400 VSS VDD FILLER2
XFILLER_84_591 VDD VSS FILLER4
XFILLER_91_539 VDD VSS FILLER1
X_11972_ _19149_/Q _14432_/B VDD VSS _12031_/A NOR2BX1
X_13711_ _14422_/B _14422_/C _19140_/Q VDD VSS _13714_/B AOI21X1
XFILLER_44_455 VDD VSS FILLER1
XFILLER_72_775 VDD VSS FILLER4
XTAP_TAPCELL_ROW_141_1428 VDD VSS WELLTAP
XTAP_TAPCELL_ROW_74_759 VDD VSS WELLTAP
X_10923_ _18648_/Q _18810_/Q VDD VSS _10962_/A XNOR2X1
X_14691_ _14694_/B _14691_/B VDD VSS _15704_/B XNOR2X1
X_10854_ _11127_/A _10921_/A VDD VSS _10882_/A NAND2X1
X_13642_ _19113_/Q _13642_/B _13710_/C VDD VSS _13716_/C XNOR3X1
X_16430_ _16447_/B _16430_/B VDD VSS _16821_/B NOR2BX1
X_13573_ _13869_/A _13869_/B VDD VSS _17914_/B XNOR2X1
X_16361_ _19660_/Q _16818_/B VDD VSS _16390_/A NAND2BX1
X_10785_ _10785_/A _10785_/B _10816_/B _11263_/A VDD VSS _10811_/A AOI31X1
X_12524_ _12535_/A _12535_/B _14212_/B VDD VSS _14181_/B XNOR3X1
X_19080_ _19121_/CK _19080_/D _19080_/Q VDD VSS DFFQX1
X_18100_ _19286_/Q _18100_/B _18100_/C VDD VSS _18105_/A MIN3X1
X_15312_ _15359_/A _15359_/B VDD VSS _15318_/B NOR2X1
XFILLER_13_897 VDD VSS FILLER1
X_18031_ _18032_/B _18045_/B _18031_/C _18049_/D VDD VSS _19973_/D OAI31X1
X_16292_ _16292_/A _16292_/B VDD VSS _16293_/B _16292_/C NAND3X1
X_12455_ _19100_/Q VDD VSS _12543_/A INVX1
X_15243_ _15243_/A _15243_/B _15243_/C _15243_/D VDD VSS _15843_/B OAI211X1
X_11406_ _17812_/A VDD VSS _11422_/A BUFX3
X_12386_ _12474_/A _12474_/B VDD VSS _14469_/B _12474_/C NAND3X1
X_15174_ _19344_/Q VDD VSS _15218_/A INVX1
XFILLER_125_265 VDD VSS FILLER1
XFILLER_126_788 VSS VDD FILLER2
XFILLER_99_617 VDD VSS DECAPHV16
X_11337_ _11334_/B _11337_/B _11337_/C VDD VSS _11352_/A AOI2B1X1
X_14125_ _14142_/A _14125_/B VDD VSS _18884_/D NOR2X1
XFILLER_125_298 VSS VDD FILLER2
XFILLER_140_202 VDD VSS DECAPHV16
XFILLER_141_747 VDD VSS FILLER1
X_19982_ _19986_/CK _19982_/D _19982_/Q VDD VSS DFFQX1
XFILLER_140_235 VDD VSS FILLER1
XFILLER_141_769 VSS VDD FILLER2
X_11268_ _11081_/Y _11349_/B _11289_/A VDD VSS _11276_/B MUXI2X1
X_14056_ _18924_/Q wire153/Y _14061_/B VDD VSS _14058_/C XOR3X1
X_18933_ _18935_/CK _18933_/D _18933_/Q VDD VSS DFFQX1
XFILLER_67_525 VDD VSS FILLER4
XFILLER_94_311 VDD VSS FILLER4
X_10219_ _18620_/Q _10219_/B _10219_/C VDD VSS _10229_/A AOI21X1
X_11199_ _11225_/C _11199_/B VDD VSS _11208_/B XNOR2X1
X_13007_ _13007_/A _14289_/B VDD VSS _13097_/A NOR2X1
X_18864_ _18917_/CK _18864_/D _18864_/Q VDD VSS DFFQX1
XFILLER_79_396 VDD VSS FILLER4
XFILLER_94_322 VSS VDD FILLER2
X_18795_ _18799_/CK _18795_/D _18795_/Q VDD VSS DFFQX1
X_17815_ _17817_/B _17815_/B VDD VSS _17816_/B XOR2X1
XFILLER_48_772 VSS VDD FILLER2
XFILLER_94_355 VDD VSS DECAPHV8
X_17746_ _17747_/A _17748_/C _17746_/C VDD VSS _17747_/C OAI21X1
X_14958_ _19450_/Q _15835_/B VDD VSS _14995_/A AND2X1
XFILLER_35_433 VDD VSS FILLER4
XFILLER_63_742 VSS VDD FILLER2
X_13909_ _19060_/Q VDD VSS _13912_/D INVX1
X_17677_ _19896_/Q _19864_/Q VDD VSS _17678_/C NAND2X1
X_14889_ _14904_/B _14889_/B VDD VSS _15740_/B XNOR2X1
XFILLER_35_499 VSS VDD FILLER2
XTAP_TAPCELL_ROW_105_1069 VDD VSS WELLTAP
XTAP_TAPCELL_ROW_45_461 VDD VSS WELLTAP
X_19416_ _19492_/CK _19416_/D _19416_/Q VDD VSS DFFQX1
X_16628_ _16652_/C _16628_/B VDD VSS _16758_/B XNOR2X1
XFILLER_16_691 VDD VSS FILLER1
XTAP_TAPCELL_ROW_17_185 VDD VSS WELLTAP
X_19347_ _19362_/CK _19347_/D _19347_/Q VDD VSS DFFQX1
X_16559_ _19700_/Q _16862_/B VDD VSS _16561_/C XNOR2X1
XFILLER_87_0 VSS VDD FILLER2
X_19278_ _19290_/CK _19278_/D _19278_/Q VDD VSS DFFQX1
XFILLER_117_711 VDD VSS FILLER4
X_18229_ _18232_/CK _18229_/E _18229_/ECK VDD VSS CGX3
XFILLER_144_530 VDD VSS FILLER4
XFILLER_116_254 VDD VSS FILLER4
XFILLER_144_563 VSS VDD FILLER2
XFILLER_7_92 VDD VSS FILLER1
XTAP_TAPCELL_ROW_9_109 VDD VSS WELLTAP
XFILLER_131_213 VSS VDD FILLER2
XTAP_TAPCELL_ROW_116_1176 VDD VSS WELLTAP
X_20122_ _20122_/A VDD VSS _20122_/Y BUFX3
X_09933_ _18597_/Q _09933_/B VDD VSS _11396_/B XNOR2X1
XFILLER_58_503 VDD VSS FILLER4
XFILLER_58_514 VDD VSS DECAPHV8
X_09864_ _18572_/Q _09864_/B VDD VSS _09872_/B NAND2X1
X_20053_ _20054_/CK _20053_/D _20054_/D _20065_/RB VDD VSS DFFRQX1
XFILLER_100_644 VSS VDD FILLER2
XFILLER_112_482 VDD VSS FILLER4
XFILLER_133_26 VDD VSS FILLER1
XFILLER_85_333 VDD VSS FILLER4
XFILLER_86_845 VDD VSS FILLER4
XFILLER_86_856 VDD VSS FILLER4
XFILLER_100_677 VDD VSS FILLER1
XFILLER_27_901 VDD VSS FILLER1
XFILLER_86_878 VDD VSS FILLER4
X_09795_ _20115_/A _20131_/A _18508_/Q VDD VSS _09805_/B MUXI2X1
XFILLER_38_271 VDD VSS DECAPHV32
XFILLER_85_399 VDD VSS FILLER1
XFILLER_26_35 VSS VDD FILLER2
XFILLER_53_230 VDD VSS FILLER4
XTAP_TAPCELL_ROW_127_1283 VDD VSS WELLTAP
XFILLER_26_477 VDD VSS FILLER1
XFILLER_41_403 VSS VDD FILLER2
XFILLER_81_561 VSS VDD FILLER2
XTAP_TAPCELL_ROW_71_729 VDD VSS WELLTAP
XFILLER_41_436 VDD VSS FILLER1
X_10570_ _10570_/A _10570_/B _10570_/C _10570_/D VDD VSS _10571_/B AOI211X1
XFILLER_108_700 VSS VDD FILLER2
XFILLER_21_182 VDD VSS FILLER4
X_09229_ _18474_/D VDD VSS _18362_/D INVX1
X_12240_ _12391_/A _12391_/B VDD VSS _14501_/B XNOR2X1
XFILLER_107_232 VSS VDD FILLER2
XFILLER_107_243 VDD VSS FILLER4
XFILLER_108_755 VDD VSS DECAPHV8
X_12171_ _12171_/A _12171_/B _12171_/C _12171_/D VDD VSS _14436_/B OAOI211X1
XFILLER_107_265 VDD VSS DECAPHV8
XFILLER_122_224 VSS VDD FILLER2
XTAP_TAPCELL_ROW_79_807 VDD VSS WELLTAP
X_11122_ _11122_/A _11128_/B VDD VSS _11126_/C XOR2X1
X_11053_ _18572_/Q _11057_/B VDD VSS _11055_/C XNOR2X1
X_15930_ _19578_/Q _16727_/B VDD VSS _16762_/B XOR2X1
XFILLER_49_536 VDD VSS DECAPHV8
XFILLER_77_856 VSS VDD FILLER2
XFILLER_88_171 VDD VSS FILLER4
X_10004_ _10034_/A _10004_/B VDD VSS _10005_/C NOR2X1
X_15861_ _15867_/A _15861_/B VDD VSS _19470_/D NOR2X1
X_17600_ _17748_/B _17600_/B _17600_/C VDD VSS _17606_/C MIN3X1
X_14812_ _19419_/Q VDD VSS _14813_/A INVX1
XFILLER_91_314 VDD VSS DECAPHV32
XFILLER_92_837 VDD VSS FILLER1
XTAP_TAPCELL_ROW_87_884 VDD VSS WELLTAP
X_18580_ _18582_/CK _18580_/D _18580_/Q VDD VSS DFFQX1
X_15792_ _15800_/A _15792_/B VDD VSS _19411_/D NOR2X1
XFILLER_83_52 VSS VDD FILLER2
X_11955_ _19037_/Q _11955_/B _11955_/C VDD VSS _12076_/B MIN3X1
X_17531_ _19866_/Q _19834_/Q _17597_/C VDD VSS _17532_/C OAI21X1
X_14743_ _14877_/C _14821_/C VDD VSS _15894_/B OR2X2
XFILLER_33_915 VDD VSS DECAPHV8
XFILLER_83_96 VDD VSS FILLER4
X_10906_ _10940_/D _10940_/B VDD VSS _10908_/B NAND2BX1
X_14674_ _19471_/Q _14700_/B _15862_/B VDD VSS _14737_/A MIN3X1
X_17462_ _19851_/Q _19819_/Q VDD VSS _17468_/B NAND2X1
XFILLER_32_425 VDD VSS FILLER1
XFILLER_60_756 VDD VSS DECAPHV8
X_11886_ _19995_/Q _19259_/Q VDD VSS _11933_/A NAND2X1
X_13625_ _13728_/A _13728_/B _13728_/C _13625_/D VDD VSS _13709_/B OAOI211X1
X_19201_ _19202_/CK _19201_/D _19201_/Q VDD VSS DFFQX1
X_16413_ _19726_/Q _16890_/B VDD VSS _16414_/C NOR2X1
XFILLER_13_650 VDD VSS FILLER1
XTAP_TAPCELL_ROW_14_155 VDD VSS WELLTAP
XTAP_TAPCELL_ROW_42_431 VDD VSS WELLTAP
X_10837_ _11078_/A _18726_/Q _10837_/C _10837_/D VDD VSS _10838_/D AO211X2
X_19132_ _19182_/CK _19132_/D _19132_/Q VDD VSS DFFQX1
X_17393_ _19836_/Q _19804_/Q _17393_/C VDD VSS _17397_/B AOI21X1
XFILLER_13_672 VDD VSS FILLER1
X_10768_ _10794_/C _10794_/B VDD VSS _10769_/B NOR2BX1
X_13556_ _13557_/A _13557_/C _13557_/B VDD VSS _14482_/A OAI21X1
X_16344_ _19628_/Q _16782_/B VDD VSS _16364_/B XNOR2X1
XFILLER_9_654 VDD VSS FILLER4
X_12507_ _19101_/Q _12546_/B _12546_/C VDD VSS _12625_/C XNOR3X1
X_13487_ _13497_/A _13575_/B _13575_/C VDD VSS _17911_/B XNOR3X1
X_19063_ _19064_/CK _19063_/D _19063_/Q VDD VSS DFFQX1
X_16275_ _16302_/B _17469_/B _16275_/C VDD VSS _19529_/D AND3BX1
XFILLER_8_164 VDD VSS FILLER1
X_10699_ _10746_/B _10698_/Y _10947_/A VDD VSS _10699_/Y MUX2X1
X_12438_ _12438_/A _12438_/B _14180_/B VDD VSS _12534_/B MIN3X1
X_18014_ _18528_/Q _18527_/Q VDD VSS _18015_/B NAND2X1
X_15226_ _19456_/Q _15842_/B VDD VSS _15284_/A NAND2X1
X_12369_ _12380_/A _14375_/B _12380_/C VDD VSS _14376_/C OR3X2
X_15157_ _19483_/Q _15157_/B _15157_/C VDD VSS _15198_/C XOR3X1
XFILLER_113_224 VSS VDD FILLER2
XFILLER_114_769 VSS VDD FILLER2
X_14108_ _17172_/A VDD VSS _18127_/B BUFX3
X_19965_ _19984_/CK _19965_/D _19965_/Q VDD VSS DFFQX1
X_15088_ _15088_/A _15088_/B VDD VSS _15809_/C AND2X1
X_14039_ _19007_/Q _14269_/B VDD VSS _14041_/A NOR2X1
X_18916_ _19004_/CK _18916_/D _18916_/Q VDD VSS DFFQX1
XFILLER_110_931 VDD VSS FILLER1
XFILLER_68_867 VDD VSS FILLER1
X_19896_ clkload9/A _19896_/D _19896_/Q VDD VSS DFFQX1
XFILLER_83_826 VDD VSS FILLER4
X_18847_ _18878_/CK _18847_/D _18847_/Q VDD VSS DFFQX1
XFILLER_67_399 VDD VSS FILLER4
X_09580_ _09812_/C _18296_/Q _09812_/B VDD VSS _09581_/E OA21X2
X_18778_ _18779_/CK _18778_/D _18778_/Q VDD VSS DFFQX1
X_17729_ _19908_/Q _19876_/Q VDD VSS _17730_/C NAND2X1
XFILLER_36_797 VDD VSS FILLER1
XFILLER_23_436 VDD VSS FILLER1
XFILLER_50_255 VDD VSS FILLER1
XFILLER_51_767 VDD VSS FILLER4
XFILLER_132_522 VSS VDD FILLER2
XFILLER_2_307 VDD VSS FILLER1
XFILLER_132_544 VDD VSS DECAPHV8
XFILLER_120_739 VDD VSS FILLER1
XFILLER_59_823 VSS VDD FILLER2
X_09916_ _18597_/Q _09933_/B VDD VSS _11398_/B NOR2BX1
X_20105_ _20105_/A VDD VSS _20105_/Y BUFX3
XFILLER_59_856 VDD VSS FILLER1
XFILLER_86_620 VDD VSS FILLER4
XTAP_TAPCELL_ROW_129_1301 VDD VSS WELLTAP
X_20036_ _20043_/CK _20036_/D _20036_/Q _20043_/RB VDD VSS DFFRQX1
XFILLER_58_366 VDD VSS FILLER1
XFILLER_74_804 VDD VSS DECAPHV16
X_09847_ _18570_/Q _09848_/A VDD VSS _09902_/B XNOR2X1
XFILLER_18_208 VDD VSS DECAPHV8
X_09778_ _18405_/Q VDD VSS _20146_/A INVX1
XTAP_TAPCELL_ROW_84_854 VDD VSS WELLTAP
XTAP_TAPCELL_ROW_56_578 VDD VSS WELLTAP
X_11740_ _19199_/Q _11760_/B _11760_/C VDD VSS _11797_/A MIN3X1
XFILLER_14_425 VDD VSS FILLER1
X_11671_ _18809_/Q _14547_/B VDD VSS _18836_/D AND2X1
X_10622_ _10655_/A _10622_/B _10622_/C VDD VSS _10746_/C NOR3X1
X_13410_ _19054_/Q _14325_/B VDD VSS _13533_/A AND2X1
X_14390_ _14393_/A _14390_/B VDD VSS _19112_/D NOR2X1
XTAP_TAPCELL_ROW_11_125 VDD VSS WELLTAP
X_10553_ _10553_/A VDD VSS _10556_/D INVX1
X_13341_ _19221_/Q _14514_/B VDD VSS _13466_/E _14514_/C AND3X2
X_16060_ _19584_/Q _16060_/B _16733_/B VDD VSS _16085_/B MIN3X1
X_10484_ _18662_/Q _18770_/Q VDD VSS _10521_/A NAND2X1
X_13272_ _14323_/B _14322_/C _19052_/Q VDD VSS _13274_/C AOI21X1
X_15011_ _19507_/Q _15901_/B VDD VSS _15056_/D XOR2X1
XFILLER_5_156 VSS VDD FILLER2
XFILLER_5_189 VDD VSS DECAPHV16
X_12223_ _12239_/A _12401_/B _12224_/C VDD VSS _14500_/B OR3BX1
X_12154_ _12154_/A _14465_/B _14465_/C VDD VSS _12155_/D NOR3X1
XFILLER_111_728 VSS VDD FILLER2
XFILLER_96_417 VDD VSS FILLER1
XFILLER_97_929 VDD VSS FILLER1
X_11105_ _11229_/A _11105_/B _11105_/C _11229_/D VDD VSS _11114_/B OAI22X1
X_19750_ _19833_/CK _19750_/D _19750_/Q VDD VSS DFFQX1
XFILLER_123_599 VDD VSS DECAPHV8
XFILLER_89_480 VSS VDD FILLER2
XFILLER_89_491 VDD VSS DECAPHV16
X_12085_ _12147_/A _12181_/B VDD VSS _14402_/B XNOR2X1
X_18701_ _18782_/CK _18701_/D _18701_/Q VDD VSS DFFQX1
X_16962_ _16962_/A _16962_/B VDD VSS _16973_/A NAND2X1
XFILLER_76_130 VSS VDD FILLER2
XFILLER_76_152 VSS VDD FILLER2
XFILLER_92_601 VSS VDD FILLER2
X_11036_ _19957_/Q _18839_/Q VDD VSS _11037_/C NAND2X1
X_19681_ _19716_/CK _19681_/D _19681_/Q VDD VSS DFFQX1
X_16893_ _17391_/A VDD VSS _16976_/A BUFX3
X_15913_ _16100_/A _15913_/B VDD VSS _19518_/D NOR2X1
XFILLER_18_720 VDD VSS FILLER4
XTAP_TAPCELL_ROW_19_203 VDD VSS WELLTAP
X_18632_ _19940_/CK _18632_/D _18632_/Q VDD VSS DFFQX1
X_15844_ _17010_/A _15844_/B _15844_/C VDD VSS _19458_/D NOR3X1
XFILLER_18_731 VSS VDD FILLER2
XFILLER_52_509 VSS VDD FILLER2
X_18563_ _18565_/CK _18563_/D _18563_/Q VDD VSS DFFQX1
X_15775_ _15780_/A _15775_/B VDD VSS _19396_/D NOR2X1
XFILLER_18_775 VDD VSS DECAPHV8
XFILLER_92_689 VDD VSS DECAPHV8
X_12987_ _13177_/A _17885_/B VDD VSS _18854_/D NOR2X1
X_17514_ _17517_/A _17517_/B _17597_/C VDD VSS _17515_/C OAI21X1
X_14726_ _19333_/Q VDD VSS _14727_/A INVX1
XFILLER_32_200 VDD VSS DECAPHV8
XFILLER_33_723 VDD VSS FILLER1
XFILLER_45_594 VSS VDD FILLER2
XFILLER_91_199 VDD VSS FILLER1
X_11938_ _19149_/Q wire162/Y _12029_/B VDD VSS _11973_/D XNOR3X1
X_18494_ _18494_/CK _18515_/Q _20107_/A _18496_/RB VDD VSS DFFRQX1
XTAP_TAPCELL_ROW_102_1039 VDD VSS WELLTAP
X_11869_ _11869_/A _11874_/D VDD VSS _14430_/B XNOR2X1
X_14657_ _14658_/A _14658_/B VDD VSS _14708_/A _14739_/B _14658_/D NAND4X2
X_17445_ _19848_/Q _19816_/Q VDD VSS _17448_/A XNOR2X1
XFILLER_20_417 VDD VSS FILLER1
X_13608_ _13840_/B _14262_/C _19000_/Q VDD VSS _13609_/D AND3BX1
X_14588_ _19494_/Q _15887_/B VDD VSS _14601_/A _15887_/C NAND3X1
X_17376_ _19832_/Q _19800_/Q VDD VSS _17377_/C NAND2X1
X_13539_ _13620_/A _14388_/B _13614_/C VDD VSS _14389_/C OR3BX1
X_19115_ _19115_/CK _19115_/D _19115_/Q VDD VSS DFFQX1
X_16327_ _16352_/B _16327_/B VDD VSS _16887_/B NAND2BX1
XFILLER_9_473 VDD VSS FILLER1
X_19046_ _19096_/CK _19046_/D _19046_/Q VDD VSS DFFQX1
X_16258_ _19560_/Q _17748_/A _16258_/C VDD VSS _16285_/C MIN3X1
X_16189_ _19622_/Q _16204_/A VDD VSS _16190_/B XNOR2X1
X_15209_ _19372_/Q _15749_/B VDD VSS _15220_/B XNOR2X1
XTAP_TAPCELL_ROW_113_1146 VDD VSS WELLTAP
XFILLER_142_886 VDD VSS FILLER1
XFILLER_87_428 VSS VDD FILLER2
X_09701_ _18336_/Q VDD VSS _20090_/A INVX1
X_19948_ _19948_/CK _19948_/D _19948_/Q VDD VSS DFFQX1
X_19879_ clkload9/A _19879_/D _19879_/Q VDD VSS DFFQX1
XFILLER_67_185 VDD VSS FILLER1
X_09632_ _09753_/A _20136_/A _09813_/C VDD VSS _09633_/C OAI21X1
XFILLER_55_347 VDD VSS FILLER4
XFILLER_71_807 VDD VSS FILLER1
XFILLER_83_656 VDD VSS FILLER1
X_09563_ _18241_/Q _09770_/B _09770_/C _20082_/A _09563_/E VDD VSS _09569_/B AOI221X1
XFILLER_70_328 VDD VSS DECAPHV8
XTAP_TAPCELL_ROW_124_1253 VDD VSS WELLTAP
XTAP_TAPCELL_ROW_53_548 VDD VSS WELLTAP
XTAP_TAPCELL_ROW_81_824 VDD VSS WELLTAP
X_09494_ _19985_/Q _09496_/B _09496_/C VDD VSS _09495_/C AOI21X1
XFILLER_23_266 VDD VSS DECAPHV8
XFILLER_137_636 VDD VSS FILLER4
XFILLER_136_146 VDD VSS FILLER1
XFILLER_137_658 VDD VSS FILLER4
XFILLER_3_616 VSS VDD FILLER2
XFILLER_79_907 VDD VSS FILLER1
XFILLER_105_566 VDD VSS DECAPHV16
XFILLER_120_503 VDD VSS FILLER1
XFILLER_120_514 VSS VDD FILLER2
XFILLER_132_352 VDD VSS FILLER1
XFILLER_133_875 VDD VSS DECAPHV8
XTAP_TAPCELL_ROW_89_902 VDD VSS WELLTAP
XFILLER_47_804 VDD VSS FILLER4
XTAP_TAPCELL_ROW_97_990 VDD VSS WELLTAP
X_12910_ _12910_/A _12910_/B _12910_/C _12910_/D VDD VSS _14382_/B AOAI211X1
X_13890_ _19003_/Q _14265_/B VDD VSS _13891_/D _14265_/C NAND3X1
X_20019_ _20020_/CK _20019_/D _20019_/Q _20031_/RB VDD VSS DFFRQX1
X_12841_ _19215_/Q _12841_/B VDD VSS _12843_/C _12841_/C NAND3X1
XFILLER_27_561 VDD VSS DECAPHV8
XFILLER_64_43 VSS VDD FILLER2
XFILLER_27_583 VSS VDD FILLER2
X_12772_ _12940_/A _12940_/C VDD VSS _12773_/C AND2X1
X_15560_ _15563_/A _15697_/B VDD VSS _15564_/C XNOR2X1
XFILLER_30_704 VSS VDD FILLER2
X_11723_ _19990_/Q _19254_/Q VDD VSS _11724_/D AND2X1
X_14511_ _15806_/A _14511_/B _14511_/C VDD VSS _19218_/D NOR3X1
X_15491_ _15492_/A _15492_/B _15492_/C VDD VSS _15541_/B OAI21X1
XFILLER_15_789 VSS VDD FILLER2
X_11654_ _18794_/Q _11658_/B VDD VSS _18821_/D AND2X1
X_14442_ _14456_/A _14442_/B VDD VSS _19158_/D NOR2X1
X_17230_ _17230_/A _17230_/B _17230_/C VDD VSS _19801_/D AOI21X1
XFILLER_128_603 VDD VSS FILLER1
XFILLER_14_299 VSS VDD FILLER2
X_10605_ _10633_/D _10633_/C VDD VSS _10607_/C NAND2BX1
X_17161_ _19787_/Q _19755_/Q VDD VSS _17168_/C NOR2X1
XFILLER_7_922 VDD VSS FILLER1
XFILLER_80_97 VDD VSS FILLER1
X_11585_ _18731_/Q _11589_/B VDD VSS _18758_/D AND2X1
X_14373_ _14316_/Y _14373_/B _14373_/C VDD VSS _19096_/D AND3BX1
X_16112_ _16112_/A _19906_/Q _16112_/C VDD VSS _16137_/C MIN3X1
XFILLER_127_157 VSS VDD FILLER2
XFILLER_128_669 VDD VSS FILLER1
XFILLER_13_80 VDD VSS FILLER1
XFILLER_13_91 VSS VDD FILLER2
X_10536_ _11255_/A _10622_/B _10622_/C _10536_/D VDD VSS _10844_/B OAI31X1
X_13324_ _13437_/A _13437_/B VDD VSS _13418_/B NOR2X1
X_17092_ _19772_/Q _19740_/Q _17092_/C VDD VSS _17097_/B AOI21X1
XFILLER_127_168 VDD VSS FILLER1
XFILLER_143_628 VDD VSS FILLER4
X_10467_ _10538_/A _10467_/B VDD VSS _10503_/C NOR2X1
X_13255_ _13255_/A _13255_/B _13255_/C _13255_/D VDD VSS _13260_/A AO31X2
X_16043_ _16059_/B _16043_/B VDD VSS _16805_/B XNOR2X1
XFILLER_89_62 VSS VDD FILLER2
X_12206_ _12206_/A _12257_/D VDD VSS _14342_/B XNOR2X1
XFILLER_123_341 VDD VSS DECAPHV8
XFILLER_124_886 VDD VSS DECAPHV16
XFILLER_97_726 VSS VDD FILLER2
X_10398_ _18633_/Q _18795_/Q VDD VSS _10399_/D NAND2X1
X_13186_ _18912_/Q _13286_/B _13286_/C VDD VSS _13494_/B MIN3X1
X_19802_ clkload4/A _19802_/D _19802_/Q VDD VSS DFFQX1
XFILLER_111_514 VDD VSS FILLER4
XFILLER_96_225 VDD VSS FILLER1
XFILLER_97_759 VDD VSS FILLER1
X_12137_ _12255_/A _12255_/B _12137_/C VDD VSS _14339_/B XNOR3X1
X_17994_ _18534_/Q _18026_/B VDD VSS _18030_/B AND2X1
X_12068_ _12070_/A _12070_/B _14206_/B VDD VSS _14175_/B XNOR3X1
X_19733_ _19736_/CK _19733_/D _19733_/Q VDD VSS DFFQX1
X_16945_ _16945_/A _16948_/C _16945_/C VDD VSS _19744_/D AOI21X1
XFILLER_49_152 VSS VDD FILLER2
XFILLER_93_921 VSS VDD FILLER2
X_11019_ _11364_/A _11019_/B _11019_/C VDD VSS _11026_/C OAI21X1
X_19664_ _19696_/CK _19664_/D _19664_/Q VDD VSS DFFQX1
XFILLER_65_634 VDD VSS DECAPHV8
XFILLER_77_494 VDD VSS FILLER1
X_18615_ _18622_/CK _18615_/D _18615_/Q VDD VSS DFFQX1
X_16876_ _16876_/A _16876_/B VDD VSS _19713_/D NOR2X1
XFILLER_52_317 VDD VSS FILLER1
XFILLER_64_166 VDD VSS FILLER4
XFILLER_92_486 VDD VSS DECAPHV16
X_19595_ _19636_/CK _19595_/D _19595_/Q VDD VSS DFFQX1
X_15827_ _15830_/A _15827_/B VDD VSS _19442_/D NOR2X1
XFILLER_18_572 VDD VSS DECAPHV8
XFILLER_52_328 VDD VSS FILLER1
XFILLER_80_659 VDD VSS FILLER4
X_18546_ _18550_/CK _18546_/D _18546_/Q VDD VSS DFFQX1
X_15758_ _15758_/A _15758_/B VDD VSS _19381_/D NOR2X1
XFILLER_21_704 VDD VSS DECAPHV16
XFILLER_60_350 VDD VSS FILLER4
X_18477_ _18479_/CK _18477_/D _20122_/A _18496_/RB VDD VSS DFFRQX1
X_15689_ _15693_/A _15689_/B VDD VSS _19318_/D NOR2X1
X_14709_ _14739_/D VDD VSS _14710_/D INVX1
XTAP_TAPCELL_ROW_50_518 VDD VSS WELLTAP
X_17428_ _17431_/A _17431_/B _17452_/C VDD VSS _17429_/C OAI21X1
XFILLER_20_247 VSS VDD FILLER2
XFILLER_21_759 VSS VDD FILLER2
X_17359_ _17362_/C _17360_/B _17363_/C VDD VSS _17360_/C OAI21X1
XFILLER_118_124 VSS VDD FILLER2
XFILLER_134_639 VSS VDD FILLER2
Xclkload62 _19202_/CK VDD VSS clkload62/Y INVX2
Xclkload51 _19242_/CK VDD VSS clkload51/Y INVX2
Xclkload40 _19949_/CK VDD VSS clkload40/Y INVX8
X_19029_ _19085_/CK _19029_/D _19029_/Q VDD VSS DFFQX1
XFILLER_127_691 VDD VSS DECAPHV16
Xclkload95 _19711_/CK VDD VSS clkload95/Y BUFX12
Xclkload84 _19492_/CK VDD VSS clkload84/Y INVX1
Xclkload73 _18908_/CK VDD VSS clkload73/Y INVX1
XFILLER_0_619 VSS VDD FILLER2
XFILLER_102_525 VDD VSS FILLER1
XFILLER_102_536 VDD VSS DECAPHV8
XFILLER_87_258 VDD VSS FILLER4
XFILLER_110_591 VDD VSS FILLER1
XFILLER_141_26 VDD VSS FILLER1
X_09615_ _20199_/A _09811_/C _09770_/C _20084_/A _09615_/E VDD VSS _09616_/C AOI221X1
XTAP_TAPCELL_ROW_66_673 VDD VSS WELLTAP
XTAP_TAPCELL_ROW_94_960 VDD VSS WELLTAP
XFILLER_24_520 VSS VDD FILLER2
XFILLER_71_648 VSS VDD FILLER2
XFILLER_71_659 VDD VSS DECAPHV8
XTAP_TAPCELL_ROW_38_397 VDD VSS WELLTAP
X_09546_ _20040_/Q _09547_/B VDD VSS _20041_/D NOR2BX1
XFILLER_70_169 VDD VSS FILLER1
X_09477_ _18404_/D _09483_/B _09477_/C VDD VSS _18245_/D AOI21X1
XFILLER_34_57 VDD VSS FILLER1
XFILLER_137_411 VDD VSS FILLER1
Xclkload1 clkload1/A VDD VSS clkload1/Y INVX8
XFILLER_109_135 VDD VSS FILLER1
XFILLER_50_45 VDD VSS FILLER1
X_11370_ _11370_/A _11370_/B _11370_/C VDD VSS _11373_/B OAI21X1
XFILLER_124_105 VDD VSS FILLER1
X_10321_ _18658_/Q _18766_/Q VDD VSS _10323_/C NAND2X1
XFILLER_106_820 VSS VDD FILLER2
XFILLER_106_853 VDD VSS DECAPHV8
XFILLER_3_424 VDD VSS FILLER1
X_13040_ _13138_/B _14446_/C _19162_/Q VDD VSS _13041_/D AND3BX1
XFILLER_133_650 VDD VSS FILLER1
XFILLER_3_468 VDD VSS FILLER1
XFILLER_59_21 VDD VSS FILLER4
X_10252_ _18623_/Q _10721_/D _11432_/D VDD VSS _10315_/C NOR3X1
XFILLER_133_683 VSS VDD FILLER2
X_10183_ _18616_/Q _10189_/B VDD VSS _10188_/A XNOR2X1
XFILLER_120_333 VDD VSS FILLER1
X_14991_ _14991_/A _14991_/B _15713_/B VDD VSS _15037_/B MIN3X1
XFILLER_19_303 VDD VSS FILLER4
XFILLER_59_472 VSS VDD FILLER2
X_13942_ _13993_/A _13949_/B VDD VSS _14168_/B XNOR2X1
X_16730_ _16735_/A _16730_/B VDD VSS _19581_/D NOR2X1
XFILLER_101_580 VDD VSS FILLER4
XFILLER_47_634 VDD VSS FILLER1
XFILLER_59_494 VDD VSS FILLER4
XFILLER_93_239 VDD VSS DECAPHV8
XFILLER_19_369 VSS VDD FILLER2
XFILLER_35_818 VDD VSS DECAPHV16
XFILLER_74_453 VSS VDD FILLER2
XFILLER_75_86 VSS VDD FILLER2
XTAP_TAPCELL_ROW_144_1459 VDD VSS WELLTAP
X_13873_ _13873_/A _14166_/B _14166_/C VDD VSS _13874_/D NOR3X1
X_16661_ _19672_/Q _16671_/A VDD VSS _16662_/B XNOR2X1
XFILLER_15_520 VDD VSS FILLER4
XFILLER_61_103 VDD VSS DECAPHV8
XFILLER_62_648 VDD VSS DECAPHV8
X_12824_ _12939_/A _12939_/B VDD VSS _12863_/B NOR2X1
X_19380_ _19385_/CK _19380_/D _19380_/Q VDD VSS DFFQX1
X_18400_ _18400_/CK _18517_/Q _20141_/A _09380_/B VDD VSS DFFRQX1
X_16592_ _19701_/Q _16863_/B VDD VSS _16620_/A NAND2BX1
X_15612_ _15674_/A _18169_/B VDD VSS _19299_/D AND2X1
XFILLER_43_840 VSS VDD FILLER2
X_12755_ _12755_/A _12755_/B _12755_/C _12755_/D VDD VSS _14506_/B OAOI211X1
X_18331_ _18343_/CK _18512_/Q _20085_/A _18373_/RB VDD VSS DFFRQX1
X_15543_ _19408_/Q _15543_/B _15543_/C VDD VSS _15569_/A MIN3X1
XFILLER_70_681 VDD VSS FILLER1
XFILLER_91_74 VDD VSS DECAPHV8
X_11706_ _11706_/A _11706_/B _11706_/C _11736_/B VDD VSS _11724_/B OAOI211X1
X_18262_ _18272_/CK _18262_/D _18262_/Q _18485_/RB VDD VSS DFFRQX1
XFILLER_129_901 VDD VSS FILLER1
XFILLER_91_96 VDD VSS DECAPHV8
X_12686_ _19159_/Q _12739_/B _12739_/C VDD VSS _12813_/C XNOR3X1
X_15474_ _15474_/A _15474_/B _15474_/C VDD VSS _15514_/B OA21X2
XFILLER_129_923 VDD VSS FILLER4
XFILLER_30_567 VSS VDD FILLER2
X_11637_ _18778_/Q _11647_/B VDD VSS _18805_/D AND2X1
X_14425_ _14467_/A _14425_/B VDD VSS _19143_/D AND2X1
X_18193_ _18196_/A _18193_/B VDD VSS _20012_/D NOR2X1
X_17213_ _19798_/Q _19766_/Q VDD VSS _17214_/B XOR2X1
XFILLER_11_792 VDD VSS FILLER1
X_11568_ _11648_/A VDD VSS _11578_/B BUFX3
X_14356_ _14368_/A _14356_/B VDD VSS _19081_/D NOR2X1
X_17144_ _17147_/C _17145_/B _17164_/C VDD VSS _17145_/C OAI21X1
XFILLER_144_948 VSS VDD FILLER2
XFILLER_6_251 VDD VSS FILLER1
X_10519_ _18664_/Q _18772_/Q VDD VSS _10576_/A XOR2X1
X_13307_ _13373_/A _13373_/B _13373_/E _13307_/D VDD VSS _14259_/C OAOI211X1
X_17075_ _17075_/A _17075_/B VDD VSS _17076_/C NAND2X1
XFILLER_109_691 VDD VSS FILLER1
X_11499_ _18653_/Q _11508_/B VDD VSS _18680_/D AND2X1
X_14287_ _14294_/A _14287_/B _14287_/C VDD VSS _19021_/D NOR3X1
X_16026_ _16026_/A _16028_/B VDD VSS _16027_/B XOR2X1
XFILLER_112_801 VDD VSS FILLER4
XFILLER_41_4 VDD VSS FILLER1
X_13238_ _19248_/Q VDD VSS _13339_/A INVX1
XFILLER_112_845 VSS VDD FILLER2
XFILLER_130_119 VDD VSS FILLER4
XTAP_TAPCELL_ROW_110_1116 VDD VSS WELLTAP
X_13169_ _18967_/Q VDD VSS _13171_/D INVX1
XFILLER_112_878 VDD VSS FILLER4
XFILLER_27_2 VDD VSS FILLER1
XFILLER_111_366 VDD VSS FILLER4
X_19716_ _19716_/CK _19716_/D _19716_/Q VDD VSS DFFQX1
X_17977_ _17977_/A _17977_/B VDD VSS _17978_/C NOR2X1
XFILLER_37_100 VSS VDD FILLER2
XFILLER_38_656 VSS VDD FILLER2
XFILLER_93_751 VSS VDD FILLER2
X_16928_ _16928_/A _16928_/B _16928_/C VDD VSS _16933_/C OAI21X1
XFILLER_25_306 VDD VSS FILLER1
XFILLER_65_475 VDD VSS FILLER1
XFILLER_93_773 VDD VSS FILLER4
X_19647_ _19678_/CK _19647_/D _19647_/Q VDD VSS DFFQX1
X_16859_ _16859_/A _16859_/B VDD VSS _19698_/D AND2X1
XFILLER_111_18 VDD VSS FILLER1
XFILLER_18_380 VDD VSS DECAPHV8
XFILLER_19_892 VDD VSS DECAPHV8
XFILLER_52_125 VDD VSS FILLER1
XTAP_TAPCELL_ROW_91_930 VDD VSS WELLTAP
X_09400_ _09400_/A VDD VSS _18006_/C BUFX3
X_19578_ _19643_/CK _19578_/D _19578_/Q VDD VSS DFFQX1
XTAP_TAPCELL_ROW_121_1223 VDD VSS WELLTAP
XTAP_TAPCELL_ROW_63_643 VDD VSS WELLTAP
X_09331_ _20079_/RB _09346_/B VDD VSS _09331_/Y NOR2BX1
X_18529_ _18543_/CK _18529_/D _18529_/Q VDD VSS DFFQX1
XFILLER_21_501 VSS VDD FILLER2
XTAP_TAPCELL_ROW_35_367 VDD VSS WELLTAP
XFILLER_21_556 VSS VDD FILLER2
X_09262_ _20043_/RB _09349_/B VDD VSS _09262_/Y NOR2BX1
XFILLER_21_589 VDD VSS FILLER1
X_09193_ _18518_/Q VDD VSS _18449_/D INVX1
XFILLER_134_436 VSS VDD FILLER2
XFILLER_102_300 VDD VSS DECAPHV8
X_09970__240 _20081_/CK VDD VSS _18517_/CK INVX1
XFILLER_57_910 VDD VSS DECAPHV8
XFILLER_69_770 VDD VSS FILLER4
XFILLER_72_924 VDD VSS DECAPHV8
XFILLER_44_637 VDD VSS FILLER1
XFILLER_71_412 VDD VSS DECAPHV8
XFILLER_83_261 VDD VSS FILLER1
X_10870_ _18672_/Q _18780_/Q VDD VSS _10871_/D NOR2X1
XFILLER_25_840 VDD VSS DECAPHV16
X_09529_ _20024_/Q _18199_/A VDD VSS _20025_/D NOR2BX1
XFILLER_25_873 VDD VSS FILLER4
XFILLER_12_523 VSS VDD FILLER2
XFILLER_40_832 VDD VSS FILLER1
X_12540_ _12540_/A _12540_/B _12540_/C _12540_/D VDD VSS _12632_/B OAOI211X1
X_12471_ _12471_/A _12471_/B _12471_/C _12471_/D VDD VSS _14406_/B AOAI211X1
X_11422_ _11422_/A _11429_/B _11422_/C VDD VSS _18616_/D NOR3X1
X_14210_ _14218_/A _14210_/B VDD VSS _18959_/D NOR2X1
X_15190_ _15275_/D _15275_/B VDD VSS _15193_/B NAND2BX1
XFILLER_117_0 VSS VDD FILLER2
XFILLER_126_926 VDD VSS FILLER4
XFILLER_4_700 VDD VSS DECAPHV16
X_14141_ _14158_/A _14141_/B VDD VSS _18898_/D AND2X1
X_11353_ _11353_/A _11355_/C VDD VSS _11354_/B XOR2X1
XFILLER_141_929 VDD VSS FILLER1
XFILLER_4_766 VSS VDD FILLER2
X_10304_ _10383_/A _10304_/B _10304_/C _10304_/D VDD VSS _10546_/B AOI211X1
X_11284_ _18582_/Q _11284_/B VDD VSS _11285_/C NAND2X1
X_14072_ _18925_/Q _14086_/D _14072_/C VDD VSS _14078_/C XOR3X1
X_10235_ _13177_/A _11429_/C VDD VSS _18550_/D NOR2X1
X_13023_ _13023_/A _14382_/B _13023_/C _13023_/D VDD VSS _13314_/A AOAI211X1
X_18880_ _18908_/CK _18880_/D _18880_/Q VDD VSS DFFQX1
X_17900_ _17905_/A _17905_/B VDD VSS _17903_/A XNOR2X1
XFILLER_105_182 VDD VSS FILLER4
XFILLER_105_193 VDD VSS FILLER1
XFILLER_79_556 VSS VDD FILLER2
X_17831_ _19930_/Q _19931_/Q _19932_/Q _17831_/D VDD VSS _19932_/D AOI31X1
XFILLER_121_697 VDD VSS FILLER1
XFILLER_94_504 VDD VSS FILLER1
X_10166_ _10190_/B _10166_/B _10166_/C _10166_/D VDD VSS _10167_/C AO211X2
XFILLER_120_174 VDD VSS FILLER4
XFILLER_66_228 VDD VSS FILLER4
XFILLER_86_96 VDD VSS FILLER1
X_10097_ _10097_/A _10097_/B VDD VSS _10098_/C NAND2X1
X_17762_ _17766_/A _17763_/B _17828_/C VDD VSS _17763_/C OAI21X1
X_14974_ _19479_/Q _15052_/A _15052_/B VDD VSS _15000_/C XNOR3X1
XFILLER_19_155 VSS VDD FILLER2
XFILLER_47_453 VDD VSS DECAPHV8
X_13925_ _18921_/Q _13993_/A _13949_/B VDD VSS _13981_/D XNOR3X1
X_19501_ _19521_/CK _19501_/D _19501_/Q VDD VSS DFFQX1
X_17693_ _19900_/Q _19868_/Q _17693_/C VDD VSS _17697_/B AOI21X1
X_16713_ _19918_/Q VDD VSS _17776_/A INVX1
XFILLER_19_177 VDD VSS DECAPHV8
XFILLER_34_114 VDD VSS FILLER4
X_13856_ _13857_/A _13857_/B _13857_/D _13857_/C VDD VSS _14363_/A OA211X2
X_19432_ _19461_/CK _19432_/D _19432_/Q VDD VSS DFFQX1
X_16644_ _19703_/Q _16865_/B VDD VSS _16645_/C NOR2X1
XFILLER_50_607 VDD VSS FILLER4
X_12807_ _12807_/A _14315_/B _12807_/C _12807_/D VDD VSS _12916_/A AOAI211X1
XFILLER_15_350 VSS VDD FILLER2
XTAP_TAPCELL_ROW_60_613 VDD VSS WELLTAP
X_10999_ _10999_/A _11030_/C VDD VSS _11014_/B XNOR2X1
X_13787_ _19142_/Q _14424_/B VDD VSS _13788_/D NOR2BX1
X_19363_ _19393_/CK _19363_/D _19363_/Q VDD VSS DFFQX1
X_16575_ _19573_/Q _19925_/Q VDD VSS _16576_/B XOR2X1
XTAP_TAPCELL_ROW_32_337 VDD VSS WELLTAP
XTAP_TAPCELL_ROW_6_71 VDD VSS WELLTAP
X_12738_ _19159_/Q VDD VSS _12747_/A INVX1
X_19294_ _19322_/CK _19294_/D _19294_/Q VDD VSS DFFQX1
X_18314_ _18327_/CK _18511_/Q _18314_/Q _18453_/RB VDD VSS DFFRQX1
X_15526_ _15526_/A _15543_/C VDD VSS _15757_/B XNOR2X1
XFILLER_30_353 VSS VDD FILLER2
X_12669_ _12832_/A _12832_/B VDD VSS _14507_/B NAND2X1
X_18245_ _18255_/CK _18245_/D _18272_/D _18485_/RB VDD VSS DFFRQX1
X_15457_ _15457_/A _15462_/B VDD VSS _15693_/B XOR2X1
XFILLER_129_742 VSS VDD FILLER2
XFILLER_30_397 VDD VSS FILLER1
X_14408_ _14426_/A _14408_/B VDD VSS _19129_/D NOR2X1
X_18176_ _18179_/A _18179_/B VDD VSS _18177_/B XNOR2X1
X_15388_ _15425_/A _15425_/B VDD VSS _15413_/A NAND2X1
XFILLER_128_274 VDD VSS DECAPHV16
XFILLER_144_734 VDD VSS DECAPHV16
X_14339_ _14339_/A _14339_/B VDD VSS _19067_/D NOR2X1
X_17127_ _19780_/Q _19748_/Q VDD VSS _17132_/A XNOR2X1
XFILLER_143_244 VSS VDD FILLER2
X_17058_ _17062_/B _17073_/B VDD VSS _17064_/D XNOR2X1
XFILLER_124_480 VDD VSS DECAPHV8
X_09880_ _09880_/A _09880_/B VDD VSS _09884_/B XOR2X1
X_16009_ _19678_/Q _16837_/B VDD VSS _16010_/A XNOR2X1
XFILLER_106_29 VSS VDD FILLER2
XFILLER_98_865 VSS VDD FILLER2
XFILLER_97_375 VDD VSS DECAPHV8
XFILLER_111_185 VDD VSS FILLER1
XFILLER_85_537 VDD VSS DECAPHV16
Xclkbuf_2_3__f__000_ clkbuf_0__000_/Y VDD VSS clkload79/A BUFX12
XFILLER_93_570 VDD VSS FILLER1
XFILLER_53_456 VDD VSS DECAPHV8
XFILLER_81_743 VDD VSS FILLER1
XTAP_TAPCELL_ROW_48_492 VDD VSS WELLTAP
XFILLER_34_670 VDD VSS FILLER1
XFILLER_53_489 VDD VSS FILLER4
XFILLER_34_692 VDD VSS FILLER4
X_09314_ _18292_/Q _18499_/D _09299_/Y VDD VSS _09314_/Y MUXI2X1
X_09245_ _18500_/D VDD VSS _18340_/D INVX1
XFILLER_31_14 VDD VSS FILLER1
XFILLER_31_36 VDD VSS FILLER1
XFILLER_5_519 VDD VSS DECAPHV8
XFILLER_135_756 VDD VSS FILLER1
XFILLER_135_767 VDD VSS FILLER4
Xoutput25 _20109_/Y VDD VSS o_bias_cfg[11] BUFX3
Xoutput14 _20083_/Y VDD VSS o_aux_ctrl[1] BUFX3
Xoutput36 _20119_/Y VDD VSS o_bias_cfg[21] BUFX3
Xoutput47 _20129_/Y VDD VSS o_bias_cfg[31] BUFX3
Xoutput58 _20133_/Y VDD VSS o_clk_cfg[0] BUFX3
XFILLER_115_480 VSS VDD FILLER2
XFILLER_115_491 VDD VSS FILLER1
XFILLER_1_758 VDD VSS FILLER1
XFILLER_49_707 VDD VSS FILLER4
X_10020_ _18602_/Q _10026_/B VDD VSS _10022_/C XNOR2X1
Xoutput69 _20135_/Y VDD VSS o_clk_cfg[2] BUFX3
XFILLER_0_279 VDD VSS FILLER1
X_20198_ _20198_/A VDD VSS _20198_/Y BUFX3
XFILLER_57_773 VDD VSS FILLER4
XFILLER_91_518 VDD VSS FILLER1
X_11971_ wire162/Y _12029_/B VDD VSS _14432_/B XNOR2X1
X_10922_ _11127_/A _10958_/A VDD VSS _10951_/A NAND2X1
X_13710_ _13721_/A _13721_/B _13710_/C _13721_/E VDD VSS _14391_/B AOI211X1
XFILLER_71_220 VDD VSS DECAPHV16
XTAP_TAPCELL_ROW_141_1429 VDD VSS WELLTAP
X_14690_ _19360_/Q _15735_/B VDD VSS _14691_/B XNOR2X1
XFILLER_31_106 VDD VSS DECAPHV8
XFILLER_32_607 VDD VSS DECAPHV16
XFILLER_60_949 VDD VSS FILLER1
XFILLER_72_32 VDD VSS FILLER4
X_10853_ _10853_/A _10853_/B VDD VSS _10921_/A NAND2X1
X_13641_ _19141_/Q _13719_/A _13719_/B VDD VSS _13710_/C XNOR3X1
XFILLER_13_832 VDD VSS FILLER4
X_10784_ _10784_/A _10784_/B VDD VSS _10814_/B NOR2X1
X_13572_ _18888_/Q _13572_/B _13662_/C VDD VSS _13869_/B XNOR3X1
X_16360_ _16388_/A _16388_/B VDD VSS _16381_/A NAND2X1
XFILLER_40_651 VDD VSS FILLER4
XFILLER_40_662 VSS VDD FILLER2
XFILLER_72_87 VDD VSS DECAPHV8
X_12523_ _18989_/Q _12537_/B _14249_/B VDD VSS _14212_/B XNOR3X1
X_16291_ _16292_/A _16292_/B _16292_/C VDD VSS _16320_/B AOI21X1
X_15311_ _15311_/A _15311_/B _15311_/C _15311_/D VDD VSS _15359_/B OAOI211X1
X_18030_ _18535_/Q _18030_/B _18536_/Q VDD VSS _18031_/C AOI21X1
X_15242_ _15243_/A _15243_/B _15243_/D _15243_/C VDD VSS _15281_/B OAOI211X1
X_12454_ _19099_/Q _14376_/B VDD VSS _12457_/C _14376_/C NAND3X1
X_11405_ _18528_/D _11428_/B VDD VSS _18600_/D NOR2BX1
X_12385_ _12553_/A _12553_/B VDD VSS _12462_/B NOR2X1
X_15173_ _19343_/Q _15173_/B _15717_/B VDD VSS _15218_/B MIN3X1
XFILLER_125_255 VDD VSS DECAPHV8
XFILLER_4_541 VDD VSS DECAPHV16
X_11336_ _18587_/Q _11336_/B VDD VSS _11337_/C AND2X1
X_14124_ _14142_/A _14124_/B VDD VSS _18883_/D NOR2X1
X_19981_ _19984_/CK _19981_/D _19981_/Q VDD VSS DFFQX1
XFILLER_125_277 VSS VDD FILLER2
X_14055_ _18923_/Q _14170_/B _14170_/C VDD VSS _14058_/D OR3BX1
X_18932_ _18935_/CK _18932_/D _18932_/Q VDD VSS DFFQX1
XFILLER_79_320 VSS VDD FILLER2
X_11267_ _11267_/A _11267_/B _11298_/C VDD VSS _11349_/B AOI21BX1
X_13006_ _13270_/A _13270_/B VDD VSS _14289_/B XNOR2X1
XFILLER_79_375 VDD VSS FILLER1
X_10218_ _10219_/C _16273_/A _10218_/C VDD VSS _18548_/D AND3BX1
X_11198_ _19963_/Q _18845_/Q VDD VSS _11199_/B XOR2X1
X_18863_ _18917_/CK _18863_/D _18863_/Q VDD VSS DFFQX1
XFILLER_94_334 VDD VSS FILLER1
X_10149_ _10150_/A _10150_/B _10150_/D _10150_/C VDD VSS _10151_/B OAOI211X1
X_18794_ _18820_/CK _18794_/D _18794_/Q VDD VSS DFFQX1
X_17814_ _19927_/Q _19895_/Q VDD VSS _17815_/B XOR2X1
XFILLER_54_209 VSS VDD FILLER2
XFILLER_94_367 VSS VDD FILLER2
XFILLER_95_879 VDD VSS FILLER1
X_17745_ _19911_/Q _19879_/Q _17745_/C VDD VSS _17748_/C MIN3X1
XFILLER_35_412 VDD VSS FILLER4
X_14957_ wire161/Y _14957_/B VDD VSS _15835_/B XNOR2X1
XFILLER_47_294 VDD VSS FILLER1
XFILLER_62_242 VDD VSS FILLER1
X_13908_ _19061_/Q _14333_/B VDD VSS _13965_/B XNOR2X1
X_17676_ _17812_/A VDD VSS _17806_/A BUFX3
X_14888_ _19393_/Q _15771_/B VDD VSS _14889_/B XNOR2X1
XFILLER_51_927 VSS VDD FILLER2
XTAP_TAPCELL_ROW_45_462 VDD VSS WELLTAP
X_13839_ _13839_/A _14297_/B _14297_/C VDD VSS _13840_/D NOR3X1
X_19415_ _19466_/CK _19415_/D _19415_/Q VDD VSS DFFQX1
X_16627_ _19575_/Q _19927_/Q VDD VSS _16628_/B XOR2X1
XFILLER_51_949 VDD VSS FILLER1
XTAP_TAPCELL_ROW_17_186 VDD VSS WELLTAP
X_19346_ _19362_/CK _19346_/D _19346_/Q VDD VSS DFFQX1
X_16558_ _16558_/A _16569_/B VDD VSS _16862_/B XOR2X1
X_15509_ _15509_/A _15509_/B _15820_/B VDD VSS _15545_/A MIN3X1
XFILLER_30_172 VSS VDD FILLER2
XFILLER_31_695 VDD VSS FILLER1
X_19277_ _20013_/CK _19277_/D _19277_/Q VDD VSS DFFQX1
X_16489_ _16512_/A _16489_/B VDD VSS _19537_/D NOR2X1
X_18228_ _18228_/CK _18228_/E _18228_/ECK VDD VSS CGX3
X_18159_ _18159_/A _18159_/B VDD VSS _18162_/B NOR2X1
XFILLER_105_907 VDD VSS DECAPHV8
XFILLER_132_704 VSS VDD FILLER2
XFILLER_104_417 VDD VSS FILLER1
XFILLER_105_929 VDD VSS FILLER1
XFILLER_117_28 VDD VSS FILLER1
XFILLER_132_737 VDD VSS FILLER1
XTAP_TAPCELL_ROW_116_1177 VDD VSS WELLTAP
X_09932_ _18596_/Q _09932_/B VDD VSS _11396_/A NOR2BX1
X_20121_ _20121_/A VDD VSS _20121_/Y BUFX3
X_09863_ _11435_/A _11196_/A VDD VSS _09885_/A NOR2X1
X_20052_ _20054_/CK output5/A _20053_/D _20065_/RB VDD VSS DFFRQX1
Xclkbuf_1_1__f__09186_ clkbuf_0__09186_/Y VDD VSS _18468_/CK BUFX12
XFILLER_100_612 VDD VSS DECAPHV16
XFILLER_85_312 VDD VSS FILLER1
X_09794_ _18342_/Q VDD VSS _20096_/A INVX1
XFILLER_66_581 VSS VDD FILLER2
XFILLER_26_25 VDD VSS FILLER4
XTAP_TAPCELL_ROW_127_1284 VDD VSS WELLTAP
XFILLER_54_776 VDD VSS DECAPHV8
XFILLER_13_128 VSS VDD FILLER2
XFILLER_42_949 VDD VSS FILLER1
XFILLER_139_325 VDD VSS DECAPHV16
X_09228_ _18477_/D VDD VSS _18365_/D INVX1
XTAP_TAPCELL_ROW_138_1391 VDD VSS WELLTAP
X_12170_ _19181_/Q _12329_/A _12329_/B VDD VSS _12171_/D XNOR3X1
XFILLER_107_277 VSS VDD FILLER2
XFILLER_135_586 VDD VSS DECAPHV8
X_11121_ _10845_/B _11119_/Y _11289_/A VDD VSS _11128_/B MUXI2X1
Xclkbuf_1_0__f_sclk clkbuf_0_sclk/Y VDD VSS clkload116/A BUFX12
XTAP_TAPCELL_ROW_79_808 VDD VSS WELLTAP
X_11052_ _11052_/A _11090_/B VDD VSS _11057_/B XNOR2X1
XFILLER_76_323 VSS VDD FILLER2
X_10003_ _09899_/Y _10058_/B _10034_/A VDD VSS _10107_/B MUXI2X1
X_15860_ _15867_/A _15860_/B VDD VSS _19469_/D NOR2X1
X_14811_ _14811_/A _14811_/B _15769_/B VDD VSS _14858_/B MIN3X1
XFILLER_123_71 VSS VDD FILLER2
XFILLER_18_924 VDD VSS FILLER1
XFILLER_76_378 VDD VSS DECAPHV8
XFILLER_85_890 VSS VDD FILLER2
XTAP_TAPCELL_ROW_87_885 VDD VSS WELLTAP
X_15791_ _15793_/A _15791_/B VDD VSS _19410_/D AND2X1
XFILLER_17_434 VDD VSS FILLER4
XFILLER_45_743 VDD VSS FILLER1
X_11954_ _11954_/A _11954_/B _14304_/B VDD VSS _11955_/B MIN3X1
X_17530_ _17675_/A _17530_/B VDD VSS _19865_/D NOR2X1
X_14742_ _19526_/Q _19527_/Q _14742_/C _19528_/Q VDD VSS _14821_/C AOI31X1
XFILLER_17_478 VDD VSS FILLER1
XFILLER_33_927 VSS VDD FILLER2
X_10905_ _18701_/Q _18755_/Q VDD VSS _10940_/B NAND2X1
X_11885_ _19232_/Q VDD VSS _11981_/C INVX1
X_14673_ _19443_/Q _14673_/B _14673_/C VDD VSS _14733_/B MIN3X1
X_17461_ _19851_/Q _19819_/Q VDD VSS _17468_/C NOR2X1
XFILLER_44_297 VDD VSS FILLER1
XFILLER_60_735 VSS VDD FILLER2
X_10836_ _10866_/A _10866_/B _10836_/C _10836_/D VDD VSS _10837_/D AOI31X1
X_13624_ _13716_/B _14360_/C _19084_/Q VDD VSS _13625_/D AND3BX1
X_19200_ _19202_/CK _19200_/D _19200_/Q VDD VSS DFFQX1
X_16412_ _16512_/A _16412_/B VDD VSS _19534_/D NOR2X1
XFILLER_13_662 VDD VSS FILLER1
XFILLER_60_768 VDD VSS FILLER1
XTAP_TAPCELL_ROW_42_432 VDD VSS WELLTAP
X_19131_ _19182_/CK _19131_/D _19131_/Q VDD VSS DFFQX1
X_17392_ _17389_/B _17392_/B VDD VSS _17393_/C NOR2BX1
XTAP_TAPCELL_ROW_14_156 VDD VSS WELLTAP
X_10767_ _18697_/Q _18751_/Q VDD VSS _10794_/B AND2X1
X_13555_ _13634_/A _14483_/B VDD VSS _13637_/D XNOR2X1
X_16343_ _16366_/B _16343_/B VDD VSS _16782_/B XNOR2X1
X_10698_ _11116_/A _10733_/B _10698_/C VDD VSS _10698_/Y OAI21X1
X_12506_ _19129_/Q _14408_/B VDD VSS _12546_/C XNOR2X1
X_13486_ _13486_/A _13486_/B _14127_/B VDD VSS _13575_/C MIN3X1
X_19062_ _19064_/CK _19062_/D _19062_/Q VDD VSS DFFQX1
X_16274_ _16274_/A _16274_/B VDD VSS _16275_/C NAND2X1
XFILLER_139_892 VDD VSS FILLER1
XFILLER_32_90 VDD VSS DECAPHV8
XTAP_TAPCELL_ROW_3_50 VDD VSS WELLTAP
X_12437_ _18904_/Q _12527_/B _12527_/C VDD VSS _12609_/B MIN3X1
X_18013_ _18056_/A _18013_/B _18056_/C VDD VSS _19965_/D OAI21X1
X_15225_ _15206_/A _15225_/B _15225_/C VDD VSS _15265_/B AOI2B1X1
XFILLER_126_553 VDD VSS DECAPHV8
X_15156_ _15183_/C _15183_/D VDD VSS _15157_/C NAND2X1
XFILLER_5_883 VDD VSS FILLER1
XFILLER_99_415 VSS VDD FILLER2
X_12368_ _12380_/A _14375_/B _12380_/C VDD VSS _14376_/B OAI21X1
X_14107_ _17977_/A _17978_/B _17977_/B VDD VSS _17983_/C NOR3X1
X_11319_ _11319_/A _11319_/B VDD VSS _11322_/B AND2X1
X_12299_ _12299_/A _14375_/B _14375_/C VDD VSS _12300_/D NOR3X1
X_19964_ clkload5/A _19964_/D output5/A VDD VSS DFFQX1
X_15087_ _15088_/A _15088_/B VDD VSS _15809_/B NOR2X1
X_14038_ _14038_/A _14169_/B _14054_/C _14038_/D VDD VSS wire153/A OAOI211X1
X_19895_ clkload8/A _19895_/D _19895_/Q VDD VSS DFFQX1
X_18915_ _18936_/CK _18915_/D _18915_/Q VDD VSS DFFQX1
XFILLER_68_835 VDD VSS FILLER4
XFILLER_79_161 VDD VSS FILLER1
X_18846_ _18878_/CK _18846_/D _18846_/Q VDD VSS DFFQX1
XFILLER_95_654 VDD VSS FILLER1
XFILLER_94_186 VDD VSS DECAPHV8
XFILLER_95_698 VSS VDD FILLER2
X_18777_ _19948_/CK _18777_/D _18777_/Q VDD VSS DFFQX1
X_15989_ _15989_/A _15989_/B _15989_/C VDD VSS _16031_/B OA21X2
X_17728_ _17730_/A _17730_/B _17728_/C VDD VSS _19908_/D AOI21X1
X_17659_ _17838_/A VDD VSS _17746_/C BUFX3
XFILLER_24_949 VDD VSS FILLER1
XFILLER_50_223 VDD VSS FILLER4
XFILLER_90_370 VSS VDD FILLER2
XFILLER_31_470 VDD VSS FILLER1
X_19329_ _19358_/CK _19329_/D _19329_/Q VDD VSS DFFQX1
XFILLER_31_492 VDD VSS FILLER1
XFILLER_128_27 VSS VDD FILLER2
XFILLER_136_317 VDD VSS DECAPHV8
XFILLER_136_328 VDD VSS FILLER1
XFILLER_128_49 VDD VSS DECAPHV8
XFILLER_105_726 VSS VDD FILLER2
XFILLER_104_247 VSS VDD FILLER2
XFILLER_144_48 VDD VSS DECAPHV16
X_09915_ _11039_/C _09915_/B _09915_/C _09915_/D VDD VSS _09933_/B AOI22X1
X_20104_ _20104_/A VDD VSS _20104_/Y BUFX3
XFILLER_101_921 VSS VDD FILLER2
XFILLER_58_312 VDD VSS DECAPHV8
XFILLER_98_470 VDD VSS FILLER4
XTAP_TAPCELL_ROW_129_1302 VDD VSS WELLTAP
X_09846_ _18568_/Q _11039_/C _09849_/C _18569_/Q VDD VSS _09848_/A AOAI211X1
X_20035_ _20043_/CK _20035_/D _20035_/Q _20043_/RB VDD VSS DFFRQX1
Xclkbuf_1_1__f__09169_ clkbuf_0__09169_/Y VDD VSS _18375_/CK BUFX12
X_09777_ _18357_/Q VDD VSS _20225_/A INVX1
XTAP_TAPCELL_ROW_84_855 VDD VSS WELLTAP
XFILLER_82_882 VDD VSS FILLER1
XTAP_TAPCELL_ROW_56_579 VDD VSS WELLTAP
XFILLER_14_459 VSS VDD FILLER2
XFILLER_30_908 VDD VSS FILLER1
X_11670_ _16273_/A VDD VSS _14547_/B BUFX3
XFILLER_41_267 VDD VSS FILLER4
X_10621_ _11116_/A _10621_/B _10621_/C VDD VSS _10746_/B OA21X2
XFILLER_10_643 VSS VDD FILLER2
XFILLER_139_144 VDD VSS DECAPHV8
XFILLER_6_603 VDD VSS FILLER1
XTAP_TAPCELL_ROW_11_126 VDD VSS WELLTAP
X_10552_ _19945_/Q _18827_/Q VDD VSS _10553_/A XNOR2X1
X_13340_ _13447_/A _14513_/B _13347_/C VDD VSS _14514_/C OR3BX1
XFILLER_127_328 VDD VSS FILLER4
X_13271_ _13271_/A _13271_/B _13271_/C _13271_/D VDD VSS _14322_/C AOAI211X1
XFILLER_6_669 VSS VDD FILLER2
X_10483_ _10803_/A _10483_/B _10483_/C _10483_/D VDD VSS _10496_/A AOI31X1
X_12222_ _12222_/A _14530_/B VDD VSS _12239_/A OR2X2
X_15010_ _19534_/Q _15058_/B VDD VSS _15901_/B XOR2X1
XFILLER_108_575 VDD VSS DECAPHV8
XFILLER_5_179 VDD VSS FILLER4
XFILLER_78_20 VSS VDD FILLER2
X_12153_ _14465_/B _14465_/C _12154_/A VDD VSS _12155_/C OAI21X1
XFILLER_123_589 VSS VDD FILLER2
XFILLER_2_875 VDD VSS FILLER4
XFILLER_68_109 VDD VSS FILLER1
X_11104_ _11146_/C _11104_/B VDD VSS _11105_/C XNOR2X1
X_12084_ _19095_/Q _12084_/B _12137_/C VDD VSS _12210_/A MIN3X1
X_16961_ _19748_/Q _16978_/B VDD VSS _16971_/A XOR2X1
XFILLER_2_886 VDD VSS FILLER1
X_11035_ _11067_/C _11041_/B _11226_/A VDD VSS _11041_/C AOI21X1
X_18700_ _18782_/CK _18700_/D _18700_/Q VDD VSS DFFQX1
X_15912_ _16100_/A _15912_/B VDD VSS _19517_/D NOR2X1
XFILLER_77_654 VDD VSS FILLER1
X_19680_ _19711_/CK _19680_/D _19680_/Q VDD VSS DFFQX1
X_16892_ _16899_/A _16892_/B VDD VSS _19728_/D AND2X1
XTAP_TAPCELL_ROW_19_204 VDD VSS WELLTAP
X_18631_ _19937_/CK _18631_/D _18631_/Q VDD VSS DFFQX1
X_15843_ _15281_/B _15843_/B _17986_/C VDD VSS _19457_/D AND3BX1
X_12986_ _13077_/A _13077_/B _13182_/C VDD VSS _17885_/B XNOR3X1
X_18562_ _18571_/CK _18562_/D _18562_/Q VDD VSS DFFQX1
X_15774_ _15793_/A _15774_/B VDD VSS _19395_/D AND2X1
X_17513_ _17838_/A VDD VSS _17597_/C BUFX3
X_14725_ _19305_/Q _15673_/B VDD VSS _14768_/A NOR2X1
XFILLER_17_286 VSS VDD FILLER2
XFILLER_72_381 VDD VSS FILLER1
XFILLER_91_189 VDD VSS DECAPHV8
X_11937_ _19177_/Q _11937_/B _11987_/C VDD VSS _12029_/B XNOR3X1
X_18493_ _18494_/CK _18493_/D _18493_/Q _18496_/RB VDD VSS DFFRQX1
XFILLER_33_757 VDD VSS DECAPHV8
XFILLER_60_554 VSS VDD FILLER2
XTAP_TAPCELL_ROW_27_281 VDD VSS WELLTAP
X_11868_ _19120_/Q VDD VSS _11968_/A INVX1
X_14656_ _14676_/A _14676_/B _14676_/D _14676_/C VDD VSS _14658_/D OAI211X1
X_17444_ _17446_/C _17444_/B _17444_/C VDD VSS _19847_/D AOI21X1
XFILLER_32_289 VSS VDD FILLER2
XFILLER_60_576 VDD VSS FILLER1
X_10819_ _10856_/A _10856_/B VDD VSS _10823_/A NAND2X1
X_11799_ _11804_/A _11804_/B _11804_/C VDD VSS _14523_/B OAI21X1
X_13607_ _13607_/A _13607_/B _13607_/C _13607_/D VDD VSS _14262_/C OAI211X1
X_14587_ _19520_/Q _19519_/Q _19521_/Q VDD VSS _15887_/C AO21X2
X_17375_ _17390_/A _17375_/B VDD VSS _19832_/D NOR2X1
XFILLER_118_306 VDD VSS FILLER1
XFILLER_9_452 VDD VSS DECAPHV8
X_13538_ _19138_/Q _14419_/B VDD VSS _13620_/A NAND2X1
X_19114_ _19196_/CK _19114_/D _19114_/Q VDD VSS DFFQX1
X_16326_ _16326_/A _16326_/B VDD VSS _16327_/B _16326_/C NAND3X1
XFILLER_118_328 VSS VDD FILLER2
XFILLER_71_4 VDD VSS FILLER4
X_19045_ _19045_/CK _19045_/D _19045_/Q VDD VSS DFFQX1
X_13469_ _19167_/Q _13637_/A _13549_/B VDD VSS _13617_/D XOR3X1
X_16257_ _19912_/Q VDD VSS _17748_/A INVX1
XFILLER_114_501 VDD VSS FILLER1
XFILLER_127_884 VDD VSS FILLER4
X_16188_ _16206_/B _16188_/B VDD VSS _16204_/A XNOR2X1
X_15208_ _15223_/A _15223_/B VDD VSS _15749_/B XNOR2X1
XTAP_TAPCELL_ROW_113_1147 VDD VSS WELLTAP
X_15139_ _15139_/A _15139_/B _15139_/C _15139_/D VDD VSS _15200_/A AOAI211X1
XFILLER_99_278 VDD VSS FILLER1
X_19947_ _19947_/CK _19947_/D _19947_/Q VDD VSS DFFQX1
XFILLER_141_375 VDD VSS DECAPHV8
X_09700_ _09700_/A _09700_/B VDD VSS _18287_/D NAND2X1
X_19878_ clkload9/A _19878_/D _19878_/Q VDD VSS DFFQX1
XFILLER_55_315 VSS VDD FILLER2
X_09631_ _09814_/C VDD VSS _09813_/C BUFX3
X_18829_ _19947_/CK _18829_/D _18829_/Q VDD VSS DFFQX1
XFILLER_82_134 VDD VSS FILLER4
X_09562_ _18424_/Q _09673_/C VDD VSS _09563_/E NOR2X1
XFILLER_24_746 VDD VSS FILLER4
XFILLER_82_189 VDD VSS DECAPHV8
XTAP_TAPCELL_ROW_124_1254 VDD VSS WELLTAP
XTAP_TAPCELL_ROW_81_825 VDD VSS WELLTAP
X_09493_ _18443_/D _09501_/B _09493_/C VDD VSS _18238_/D AOI21X1
XFILLER_63_392 VDD VSS FILLER1
XTAP_TAPCELL_ROW_53_549 VDD VSS WELLTAP
XFILLER_23_278 VDD VSS FILLER1
Xclkbuf_leaf_10_clk_regs clkbuf_leaf_9_clk_regs/A VDD VSS _19828_/CK BUFX12
XFILLER_137_626 VDD VSS FILLER4
XFILLER_136_136 VSS VDD FILLER2
XFILLER_133_810 VDD VSS FILLER1
XTAP_TAPCELL_ROW_135_1361 VDD VSS WELLTAP
XFILLER_105_556 VSS VDD FILLER2
XTAP_TAPCELL_ROW_89_903 VDD VSS WELLTAP
XFILLER_58_142 VSS VDD FILLER2
XFILLER_59_654 VSS VDD FILLER2
XFILLER_47_816 VDD VSS FILLER1
XFILLER_58_175 VDD VSS FILLER4
XFILLER_74_624 VDD VSS FILLER1
XFILLER_86_473 VDD VSS FILLER4
X_09829_ _11435_/A _11438_/A VDD VSS _10313_/B OR2X2
X_20018_ _20020_/CK _20018_/D _20018_/Q _20031_/RB VDD VSS DFFRQX1
XFILLER_74_657 VDD VSS FILLER4
X_12840_ _12840_/A _12840_/B _12840_/C _12840_/D VDD VSS _12843_/B OAOI211X1
XFILLER_104_95 VDD VSS DECAPHV8
XFILLER_15_735 VDD VSS FILLER1
XFILLER_27_573 VSS VDD FILLER2
XFILLER_42_510 VDD VSS FILLER1
XFILLER_73_189 VDD VSS FILLER1
X_12771_ _12771_/A _12771_/B _14474_/B _12771_/D _12771_/E VDD VSS _12940_/C OAI221X1
X_11722_ _19227_/Q VDD VSS _11751_/A INVX1
X_14510_ _14491_/Y _14510_/B _14510_/C VDD VSS _19217_/D AND3BX1
X_15490_ _19379_/Q _15756_/B VDD VSS _15492_/C XOR2X1
XFILLER_120_61 VDD VSS DECAPHV8
XFILLER_30_727 VSS VDD FILLER2
XFILLER_80_32 VSS VDD FILLER2
XTAP_TAPCELL_ROW_24_251 VDD VSS WELLTAP
X_11653_ _18793_/Q _11658_/B VDD VSS _18820_/D AND2X1
X_14441_ _14449_/A _14441_/B _14441_/C VDD VSS _19157_/D NOR3X1
X_10604_ _19946_/Q _18828_/Q VDD VSS _10633_/C NAND2X1
X_14372_ _14393_/A _14372_/B VDD VSS _19095_/D NOR2X1
X_17160_ _17160_/A _17160_/B _17160_/C VDD VSS _17168_/A OA21X2
XFILLER_80_76 VSS VDD FILLER2
X_11584_ _18730_/Q _11589_/B VDD VSS _18757_/D AND2X1
X_13323_ _13365_/A _13365_/B _13365_/D _13365_/C VDD VSS _13437_/B OAOI211X1
X_16111_ _19554_/Q VDD VSS _16112_/A INVX1
XFILLER_109_840 VSS VDD FILLER2
X_10535_ _10579_/D _10535_/B _10535_/C _11255_/A VDD VSS _10536_/D AOAI211X1
X_17091_ _17089_/B _17091_/B VDD VSS _17092_/C NOR2BX1
XFILLER_143_618 VDD VSS FILLER4
X_10466_ _10511_/A _10624_/B _10624_/C _10466_/D VDD VSS _10467_/B AOI31X1
X_13254_ _13254_/A _14478_/B _13254_/C _13254_/D VDD VSS _13457_/A OAOI211X1
X_16042_ _19616_/Q _16768_/B VDD VSS _16043_/B XNOR2X1
XFILLER_108_383 VDD VSS FILLER1
XFILLER_89_74 VSS VDD FILLER2
X_12205_ _19097_/Q wire159/Y _12208_/B VDD VSS _12257_/D XNOR3X1
X_13185_ _13290_/A _13290_/B VDD VSS _13286_/C XOR2X1
XFILLER_123_353 VSS VDD FILLER2
XFILLER_89_96 VDD VSS FILLER1
X_10397_ _10476_/A VDD VSS _10441_/A INVX1
X_12136_ _19095_/Q VDD VSS _12255_/A INVX1
X_19801_ _19833_/CK _19801_/D _19801_/Q VDD VSS DFFQX1
XFILLER_96_204 VDD VSS DECAPHV8
XFILLER_96_237 VDD VSS FILLER1
X_17993_ _18532_/Q _18533_/Q VDD VSS _18026_/B _18024_/B AND3X2
XFILLER_77_440 VSS VDD FILLER2
XFILLER_93_900 VDD VSS FILLER4
XFILLER_96_259 VDD VSS FILLER4
X_12067_ _18983_/Q _12072_/B _12072_/C VDD VSS _14206_/B XNOR3X1
X_19732_ _19736_/CK _19732_/D _19732_/Q VDD VSS DFFQX1
X_16944_ _16945_/A _16948_/C _17081_/C VDD VSS _16945_/C OAI21X1
XFILLER_77_462 VSS VDD FILLER2
X_11018_ _11364_/A _11018_/B VDD VSS _11019_/C NAND2X1
X_19663_ _19696_/CK _19663_/D _19663_/Q VDD VSS DFFQX1
X_16875_ _16876_/A _16875_/B VDD VSS _19712_/D NOR2X1
XFILLER_64_112 VDD VSS DECAPHV8
X_18614_ _18622_/CK _18614_/D _18614_/Q VDD VSS DFFQX1
X_15826_ _15830_/A _15826_/B VDD VSS _19441_/D NOR2X1
XFILLER_65_668 VDD VSS FILLER1
XFILLER_92_465 VDD VSS FILLER4
X_19594_ _19671_/CK _19594_/D _19594_/Q VDD VSS DFFQX1
XFILLER_18_584 VSS VDD FILLER2
XFILLER_45_370 VSS VDD FILLER2
XFILLER_46_882 VDD VSS FILLER1
X_12969_ _13133_/A _13133_/B VDD VSS _12970_/C AND2X1
X_18545_ _18550_/CK _18545_/D _18545_/Q VDD VSS DFFQX1
X_15757_ _15758_/A _15757_/B VDD VSS _19380_/D NOR2X1
X_18476_ _18479_/CK _18513_/Q _20121_/A _20078_/RB VDD VSS DFFRQX1
X_15688_ _15693_/A _15688_/B VDD VSS _19317_/D NOR2X1
X_14708_ _14708_/A _14708_/B _14708_/C VDD VSS _14781_/A NOR3X1
XTAP_TAPCELL_ROW_50_519 VDD VSS WELLTAP
X_14639_ _14639_/A _14639_/B _15826_/B VDD VSS _14640_/B MIN3X1
X_17427_ _19843_/Q _19811_/Q _17427_/C VDD VSS _17431_/B MIN3X1
XFILLER_119_615 VSS VDD FILLER2
X_17358_ _19829_/Q _19797_/Q VDD VSS _17360_/B XOR2X1
XFILLER_119_648 VSS VDD FILLER2
X_17289_ _17289_/A _17289_/B _17289_/C _17289_/D VDD VSS _17290_/C AOAI211X1
X_16309_ _19626_/Q _16780_/B VDD VSS _16320_/A NOR2X1
XFILLER_134_607 VDD VSS FILLER1
XFILLER_134_618 VDD VSS FILLER1
Xclkload52 _19064_/CK VDD VSS clkload52/Y INVX2
Xclkload41 clkload41/A VDD VSS clkload41/Y BUFX12
Xclkload30 _18797_/CK VDD VSS clkload30/Y BUFX12
X_19028_ _19085_/CK _19028_/D _19028_/Q VDD VSS DFFQX1
Xclkbuf_leaf_19__002_ clkload17/A VDD VSS _19951_/CK BUFX12
Xclkload96 _19716_/CK VDD VSS clkload96/Y INVX1
Xclkload85 _19495_/CK VDD VSS clkload85/Y BUFX12
Xclkload74 _18970_/CK VDD VSS clkload74/Y INVX1
Xclkload63 _19234_/CK VDD VSS clkload63/Y INVX1
XFILLER_102_504 VDD VSS FILLER4
XFILLER_130_813 VDD VSS DECAPHV8
XFILLER_142_640 VSS VDD FILLER2
XFILLER_87_215 VDD VSS FILLER4
XFILLER_102_559 VDD VSS FILLER1
XFILLER_68_440 VSS VDD FILLER2
XFILLER_56_602 VSS VDD FILLER2
XFILLER_141_16 VDD VSS DECAPHV8
XFILLER_55_112 VDD VSS DECAPHV8
X_09614_ _18298_/Q _09797_/B _09766_/C _20100_/A VDD VSS _09615_/E AO22X2
XFILLER_71_616 VDD VSS FILLER4
XFILLER_24_510 VDD VSS FILLER1
XFILLER_37_893 VSS VDD FILLER2
XFILLER_43_318 VDD VSS FILLER1
XFILLER_64_690 VDD VSS FILLER4
XTAP_TAPCELL_ROW_66_674 VDD VSS WELLTAP
X_09545_ _20039_/Q _09547_/B VDD VSS _20040_/D NOR2BX1
XFILLER_51_340 VDD VSS FILLER4
XTAP_TAPCELL_ROW_38_398 VDD VSS WELLTAP
X_09476_ _19977_/Q _09490_/B _09476_/C VDD VSS _09477_/C AOI21X1
XFILLER_12_727 VSS VDD FILLER2
XFILLER_138_902 VDD VSS DECAPHV8
XTAP_TAPCELL_ROW_21_221 VDD VSS WELLTAP
Xclkload2 clkload2/A VDD VSS clkload2/Y INVX1
XFILLER_137_445 VDD VSS DECAPHV16
XFILLER_20_793 VSS VDD FILLER2
XFILLER_119_4 VDD VSS FILLER4
XFILLER_125_607 VDD VSS FILLER4
X_10320_ _18658_/Q _18766_/Q VDD VSS _10323_/B NOR2X1
X_10251_ _18624_/Q _11436_/C VDD VSS _11432_/D OR2X2
XFILLER_105_386 VDD VSS DECAPHV8
XFILLER_78_226 VDD VSS FILLER1
X_10182_ _11226_/D _10182_/B _10145_/C _11435_/B VDD VSS _10189_/B OAI2B2BX1
XFILLER_78_237 VDD VSS FILLER1
X_14990_ _19339_/Q VDD VSS _14991_/A INVX1
XFILLER_47_613 VDD VSS FILLER4
X_13941_ _13941_/A _13941_/B _13941_/C _13941_/D VDD VSS _17945_/B AOAI211X1
XFILLER_59_484 VDD VSS FILLER1
XFILLER_74_421 VDD VSS DECAPHV8
XTAP_TAPCELL_ROW_29_310 VDD VSS WELLTAP
XFILLER_19_359 VSS VDD FILLER2
XFILLER_46_134 VDD VSS FILLER1
X_13872_ _13872_/A _13872_/B _13872_/C _13872_/D VDD VSS _17924_/B AOAI211X1
X_16660_ _16674_/B _16660_/B VDD VSS _16671_/A XNOR2X1
XFILLER_28_893 VDD VSS FILLER1
X_12823_ _19132_/Q _14411_/B VDD VSS _12939_/A AND2X1
X_16591_ _19733_/Q _16898_/B VDD VSS _16616_/A NOR2X1
X_15611_ _15611_/A _15614_/B VDD VSS _18169_/B XNOR2X1
X_12754_ _19242_/Q _14536_/B VDD VSS _12835_/A AND2X1
X_18330_ _18342_/CK _18474_/D _20084_/A _18373_/RB VDD VSS DFFRQX1
X_15542_ _15789_/B VDD VSS _15543_/B INVX1
XFILLER_30_502 VSS VDD FILLER2
X_11705_ _19989_/Q _19253_/Q VDD VSS _11736_/B XNOR2X1
X_18261_ _18275_/CK _18261_/D _18261_/Q _20079_/RB VDD VSS DFFRQX1
X_12685_ _19187_/Q _14474_/B VDD VSS _12739_/C XNOR2X1
X_17212_ _19797_/Q _19765_/Q _17212_/C VDD VSS _17215_/B MIN3X1
X_15473_ _15473_/A _15912_/B VDD VSS _15474_/C OR2X2
X_11636_ _11648_/A VDD VSS _11647_/B BUFX3
X_14424_ _14426_/A _14424_/B VDD VSS _19142_/D NOR2X1
X_18192_ _18192_/A _18195_/C VDD VSS _18193_/B XNOR2X1
XFILLER_11_782 VDD VSS FILLER4
X_11567_ _18715_/Q _11567_/B VDD VSS _18742_/D AND2X1
X_14355_ _14355_/A _14355_/B VDD VSS _14356_/B NAND2X1
X_17143_ _19783_/Q _19751_/Q VDD VSS _17145_/B XOR2X1
XFILLER_116_607 VDD VSS FILLER1
XFILLER_128_478 VDD VSS FILLER4
X_10518_ _10927_/C _10518_/B _10518_/C VDD VSS _10579_/A OA21X2
X_13306_ _13373_/A _13373_/B _13307_/D _13373_/E VDD VSS _14259_/B OA211X2
X_14286_ _14294_/A _14286_/B _14286_/C VDD VSS _19020_/D NOR3X1
X_17074_ _17075_/A _17075_/B VDD VSS _17077_/C NOR2X1
X_11498_ _16860_/A VDD VSS _11508_/B BUFX3
X_13237_ _19219_/Q _14512_/B VDD VSS _13254_/A NOR2BX1
X_16025_ _19710_/Q _16873_/B _16025_/C VDD VSS _16028_/B MIN3X1
XFILLER_143_459 VSS VDD FILLER2
X_10449_ _10530_/B _11095_/C _10449_/C VDD VSS _10462_/B OR3BX1
XTAP_TAPCELL_ROW_110_1117 VDD VSS WELLTAP
X_13168_ _18968_/Q _13168_/B _13192_/D VDD VSS _13295_/B XNOR3X1
XFILLER_112_857 VDD VSS FILLER1
XFILLER_123_183 VSS VDD FILLER2
XFILLER_2_491 VDD VSS FILLER4
XFILLER_97_557 VDD VSS FILLER1
X_12119_ _19096_/Q _12119_/B _12149_/C VDD VSS _12447_/B XNOR3X1
X_13099_ _19051_/Q _14321_/B VDD VSS _13415_/A NOR2BX1
X_17976_ _17976_/A _17976_/B _17976_/C _17976_/D VDD VSS _17987_/A OAOI211X1
XFILLER_111_356 VSS VDD FILLER2
X_19715_ _19716_/CK _19715_/D _19715_/Q VDD VSS DFFQX1
X_16927_ _19740_/Q wire163/Y VDD VSS _16928_/C NAND2X1
XFILLER_37_123 VSS VDD FILLER2
XFILLER_38_624 VSS VDD FILLER2
XFILLER_65_454 VSS VDD FILLER2
X_19646_ _19678_/CK _19646_/D _19646_/Q VDD VSS DFFQX1
X_16858_ _16865_/A _16858_/B VDD VSS _19697_/D NOR2X1
XFILLER_37_189 VSS VDD FILLER2
XFILLER_53_638 VDD VSS FILLER1
X_19577_ _19606_/CK _19577_/D _19577_/Q VDD VSS DFFQX1
X_16789_ _16794_/A _16789_/B VDD VSS _19635_/D NOR2X1
X_15809_ _17010_/A _15809_/B _15809_/C VDD VSS _19425_/D NOR3X1
XFILLER_34_863 VDD VSS DECAPHV16
XFILLER_52_148 VDD VSS FILLER1
XTAP_TAPCELL_ROW_121_1224 VDD VSS WELLTAP
XTAP_TAPCELL_ROW_63_644 VDD VSS WELLTAP
X_09330_ _18447_/D _09329_/Y _09302_/Y VDD VSS _18516_/D MUXI2X1
X_18528_ _18543_/CK _18528_/D _18528_/Q VDD VSS DFFQX1
XTAP_TAPCELL_ROW_35_368 VDD VSS WELLTAP
X_09261_ _09351_/B _09265_/C _09261_/C VDD VSS _18279_/D AOI2B1X1
X_18459_ _18471_/CK _18512_/Q _18459_/Q _20075_/RB VDD VSS DFFRQX1
X_09192_ _18519_/Q VDD VSS _18450_/D INVX1
XFILLER_135_905 VSS VDD FILLER2
XFILLER_20_16 VSS VDD FILLER2
Xclkload130 _18423_/CK VDD VSS clkload130/Y INVX2
XFILLER_106_106 VDD VSS FILLER4
XFILLER_135_949 VDD VSS FILLER1
XTAP_TAPCELL_ROW_132_1331 VDD VSS WELLTAP
XFILLER_114_172 VSS VDD FILLER2
XFILLER_102_323 VSS VDD FILLER2
XFILLER_103_868 VSS VDD FILLER2
XFILLER_102_356 VDD VSS DECAPHV8
XFILLER_29_47 VDD VSS DECAPHV16
XFILLER_56_421 VDD VSS DECAPHV8
XFILLER_17_808 VSS VDD FILLER2
XFILLER_29_679 VDD VSS FILLER1
XFILLER_16_318 VDD VSS FILLER4
XFILLER_25_830 VDD VSS FILLER4
XFILLER_71_446 VSS VDD FILLER2
XFILLER_71_468 VSS VDD FILLER2
XFILLER_83_295 VDD VSS FILLER4
X_09528_ _20023_/Q _18201_/A VDD VSS _20024_/D NOR2X1
XFILLER_52_671 VSS VDD FILLER2
XFILLER_40_855 VDD VSS FILLER1
XFILLER_52_693 VDD VSS FILLER4
X_09459_ _19969_/Q _09467_/B _09476_/C VDD VSS _09460_/C AOI21X1
XFILLER_101_96 VDD VSS FILLER1
X_12470_ _12593_/A _12593_/B _12593_/E VDD VSS _12546_/B OA21X2
XFILLER_61_78 VDD VSS FILLER1
X_11421_ _11422_/A _11429_/B _11421_/C VDD VSS _18615_/D NOR3X1
XFILLER_125_404 VSS VDD FILLER2
XFILLER_138_765 VSS VDD FILLER2
XFILLER_138_787 VSS VDD FILLER2
X_11352_ _11352_/A _11352_/B _11352_/C VDD VSS _11355_/C AOI21X1
X_14140_ _14136_/Y _14140_/B _14140_/C VDD VSS _18897_/D AND3BX1
XFILLER_126_949 VDD VSS FILLER1
XFILLER_137_297 VDD VSS FILLER4
XFILLER_3_211 VSS VDD FILLER2
X_10303_ _11196_/A _11430_/B _11435_/A VDD VSS _10304_/D AND3BX1
XFILLER_141_919 VDD VSS DECAPHV8
X_11283_ _11383_/A _11283_/B VDD VSS _18582_/D NOR2X1
X_14071_ wire153/Y _14086_/B _14086_/C VDD VSS _14072_/C OAI21X1
X_10234_ _10234_/A _10234_/B VDD VSS _11429_/C XOR2X1
X_13022_ _19133_/Q _14413_/B _14413_/C VDD VSS _13023_/D OR3BX1
XFILLER_121_632 VDD VSS DECAPHV8
XFILLER_126_60 VDD VSS FILLER1
XFILLER_79_568 VDD VSS FILLER4
X_10165_ _10190_/B _10165_/B VDD VSS _10166_/C NOR2X1
X_17830_ _19930_/Q _19931_/Q _19932_/Q _18087_/D VDD VSS _17831_/D AOAI211X1
XFILLER_121_676 VSS VDD FILLER2
XFILLER_48_911 VDD VSS FILLER4
XFILLER_79_579 VSS VDD FILLER2
XFILLER_86_86 VDD VSS DECAPHV8
X_10096_ _18607_/Q _10098_/B VDD VSS _10097_/B NAND2X1
X_19500_ _19521_/CK _19500_/D _19500_/Q VDD VSS DFFQX1
X_17761_ _17766_/C _17766_/B VDD VSS _17763_/B NAND2BX1
X_14973_ _15013_/A _14973_/B VDD VSS _15052_/B XNOR2X1
XFILLER_75_752 VDD VSS FILLER4
X_13924_ _13924_/A _13924_/B _13924_/C _13924_/D VDD VSS _13949_/B AOAI211X1
X_17692_ _17690_/B _17692_/B VDD VSS _17693_/C NOR2BX1
X_16712_ _19917_/Q _16726_/B VDD VSS _19565_/D AND2X1
XFILLER_19_189 VDD VSS DECAPHV8
XFILLER_47_476 VDD VSS DECAPHV8
XFILLER_74_284 VSS VDD FILLER2
XFILLER_90_733 VDD VSS DECAPHV8
X_13855_ _19088_/Q _14364_/B VDD VSS _13910_/A XOR2X1
X_19431_ _19461_/CK _19431_/D _19431_/Q VDD VSS DFFQX1
X_16643_ _16643_/A _16643_/B _16643_/C _16643_/D VDD VSS _16668_/B OAOI211X1
XFILLER_16_841 VSS VDD FILLER2
X_12806_ _19075_/Q _14348_/B VDD VSS _12807_/D _14348_/C NAND3X1
X_19362_ _19362_/CK _19362_/D _19362_/Q VDD VSS DFFQX1
XFILLER_43_671 VDD VSS FILLER1
XFILLER_90_788 VSS VDD FILLER2
XTAP_TAPCELL_ROW_107_1090 VDD VSS WELLTAP
XTAP_TAPCELL_ROW_60_614 VDD VSS WELLTAP
X_10998_ _18649_/Q _18811_/Q _10998_/C VDD VSS _11030_/C MIN3X1
X_13786_ _13860_/A _14329_/B VDD VSS _13831_/B AND2X1
X_18313_ _18327_/CK _18510_/Q _18313_/Q _18453_/RB VDD VSS DFFRQX1
X_16574_ _19572_/Q _19924_/Q _16574_/C VDD VSS _16602_/C AOI2B1X1
XFILLER_15_395 VSS VDD FILLER2
XTAP_TAPCELL_ROW_32_338 VDD VSS WELLTAP
XTAP_TAPCELL_ROW_6_72 VDD VSS WELLTAP
X_12737_ _12737_/A _14442_/B VDD VSS _12816_/A OR2X2
X_19293_ _19322_/CK _19293_/D _19293_/Q VDD VSS DFFQX1
X_15525_ _15525_/A _15525_/B _15525_/C VDD VSS _15543_/C OAI21X1
XFILLER_42_192 VDD VSS FILLER1
X_12668_ _12837_/A _12837_/B _12837_/D _12837_/C VDD VSS _12832_/B AOAI211X1
X_18244_ _18255_/CK _18244_/D _18273_/D _20080_/RB VDD VSS DFFRQX1
X_15456_ _15456_/A _15456_/B _15456_/C VDD VSS _15462_/B OAI21X1
XFILLER_128_220 VDD VSS DECAPHV8
X_11619_ _18762_/Q _11624_/B VDD VSS _18789_/D AND2X1
X_14407_ _14381_/Y _14407_/B _14407_/C VDD VSS _19128_/D AND3BX1
X_18175_ _19301_/Q VDD VSS _18179_/A INVX1
XFILLER_129_787 VDD VSS FILLER4
XFILLER_144_702 VSS VDD FILLER2
X_12599_ _12600_/B _12600_/C _19017_/Q VDD VSS _12894_/B AOI21X1
X_17126_ _17128_/C _17126_/B _17126_/C VDD VSS _19779_/D AOI21X1
X_15387_ _19376_/Q _15753_/B VDD VSS _15425_/A NAND2X1
XFILLER_117_949 VDD VSS FILLER1
XFILLER_143_201 VSS VDD FILLER2
X_14338_ _14339_/A _14338_/B VDD VSS _19066_/D NOR2X1
XFILLER_144_768 VDD VSS DECAPHV8
X_14269_ _14270_/A _14269_/B VDD VSS _19007_/D AND2X1
X_17057_ _19765_/Q VDD VSS _17062_/B INVX1
XFILLER_124_470 VSS VDD FILLER2
XFILLER_143_267 VDD VSS FILLER4
X_16008_ _16028_/C _16028_/A VDD VSS _16026_/A NAND2BX1
XFILLER_106_19 VSS VDD FILLER2
XFILLER_111_120 VDD VSS DECAPHV16
XFILLER_112_632 VSS VDD FILLER2
XFILLER_124_492 VDD VSS FILLER1
XFILLER_97_332 VSS VDD FILLER2
XFILLER_112_665 VDD VSS FILLER1
XFILLER_25_0 VDD VSS FILLER4
X_17959_ _17959_/A wire152/Y VDD VSS _17960_/B NOR2X1
XFILLER_122_29 VDD VSS FILLER1
XFILLER_54_914 VDD VSS FILLER1
XFILLER_66_752 VDD VSS FILLER1
XFILLER_81_733 VDD VSS DECAPHV8
XTAP_TAPCELL_ROW_76_780 VDD VSS WELLTAP
X_19629_ _19696_/CK _19629_/D _19629_/Q VDD VSS DFFQX1
XFILLER_81_755 VDD VSS FILLER4
XTAP_TAPCELL_ROW_48_493 VDD VSS WELLTAP
X_09313_ _20051_/RB _09346_/B VDD VSS _09313_/Y NOR2BX1
XFILLER_80_298 VDD VSS DECAPHV16
XFILLER_21_354 VDD VSS FILLER4
X_09244_ _18522_/Q VDD VSS _18341_/D INVX1
XFILLER_21_387 VDD VSS DECAPHV8
XFILLER_107_404 VDD VSS FILLER4
X_18210__255 _18259_/CK VDD VSS _18277_/CK INVX1
XFILLER_108_949 VDD VSS FILLER1
Xoutput15 _20084_/Y VDD VSS o_aux_ctrl[2] BUFX3
XFILLER_122_429 VDD VSS FILLER4
Xoutput26 _20110_/Y VDD VSS o_bias_cfg[12] BUFX3
Xoutput37 _20120_/Y VDD VSS o_bias_cfg[22] BUFX3
Xoutput48 _20130_/Y VDD VSS o_bias_cfg[32] BUFX3
XFILLER_88_343 VSS VDD FILLER2
XFILLER_89_866 VSS VDD FILLER2
Xoutput59 _20143_/Y VDD VSS o_clk_cfg[10] BUFX3
XFILLER_0_269 VDD VSS FILLER1
XFILLER_102_131 VDD VSS DECAPHV8
XFILLER_102_153 VDD VSS DECAPHV8
XFILLER_88_365 VDD VSS FILLER4
X_20197_ _20197_/A VDD VSS _20197_/Y BUFX3
XFILLER_102_186 VSS VDD FILLER2
XFILLER_130_495 VDD VSS FILLER4
XFILLER_57_730 VSS VDD FILLER2
XFILLER_56_34 VDD VSS FILLER1
XFILLER_56_45 VDD VSS FILLER1
X_11970_ _19121_/Q _12022_/A _14400_/B VDD VSS _12087_/A MIN3X1
XFILLER_44_402 VDD VSS FILLER1
XFILLER_57_785 VDD VSS DECAPHV8
XFILLER_72_722 VSS VDD FILLER2
X_10921_ _10921_/A _10921_/B _10921_/C VDD VSS _10958_/A OR3X2
XFILLER_112_84 VDD VSS FILLER1
XFILLER_25_671 VDD VSS FILLER1
XFILLER_72_788 VSS VDD FILLER2
X_10852_ _11378_/A _10852_/B _10885_/B VDD VSS _18566_/D NOR3X1
X_13640_ _13640_/A _13640_/B _13640_/C _13640_/D VDD VSS _13719_/B OAOI211X1
XFILLER_12_321 VDD VSS FILLER4
XFILLER_71_298 VDD VSS DECAPHV16
X_10783_ _11272_/A _10783_/B VDD VSS _18564_/D NOR2X1
X_13571_ _18916_/Q _13580_/B _13580_/C VDD VSS _13662_/C XNOR3X1
X_12522_ _19017_/Q _12894_/A _14283_/B VDD VSS _14249_/B XOR3X1
X_16290_ _19626_/Q _16780_/B VDD VSS _16292_/C XNOR2X1
X_15310_ _19513_/Q _15908_/B VDD VSS _15359_/A NOR2BX1
XFILLER_9_859 VSS VDD FILLER2
X_15241_ _19485_/Q _15307_/A _15307_/B VDD VSS _15243_/C XNOR3X1
X_12453_ _14376_/B _14376_/C _19099_/Q VDD VSS _12457_/B AOI21X1
XFILLER_138_573 VDD VSS DECAPHV8
X_09977__247 _20081_/CK VDD VSS _18524_/CK INVX1
X_11404_ _11429_/B VDD VSS _11428_/B BUFX3
X_12384_ _12467_/A _14438_/B VDD VSS _12553_/A NOR2X1
X_15172_ _15172_/A VDD VSS _15173_/B INVX1
XFILLER_125_223 VDD VSS FILLER1
X_11335_ _11383_/A _11335_/B VDD VSS _18587_/D NOR2X1
X_14123_ _14142_/A _14123_/B VDD VSS _18882_/D NOR2X1
X_19980_ _19986_/CK _19980_/D _19980_/Q VDD VSS DFFQX1
XFILLER_21_92 VDD VSS FILLER1
XFILLER_97_41 VSS VDD FILLER2
X_11266_ _11267_/A _11379_/B VDD VSS _11298_/C OR2X2
X_14054_ _14054_/A _14054_/B _14054_/C VDD VSS _14058_/B XNOR3X1
X_18931_ _18935_/CK _18931_/D _18931_/Q VDD VSS DFFQX1
XFILLER_140_226 VDD VSS FILLER4
X_10217_ _10217_/A _10217_/B _10217_/C _10217_/D VDD VSS _10218_/C AOAI211X1
X_13005_ _13005_/A _13005_/B _13005_/C _13005_/D VDD VSS _13270_/A AO31X2
XFILLER_94_302 VDD VSS FILLER4
XFILLER_97_96 VDD VSS FILLER4
X_11197_ _19962_/Q _18844_/Q _11197_/C VDD VSS _11225_/C AOI21X1
X_18862_ _18917_/CK _18862_/D _18862_/Q VDD VSS DFFQX1
XFILLER_121_473 VSS VDD FILLER2
XFILLER_121_495 VDD VSS DECAPHV8
XFILLER_94_324 VDD VSS FILLER1
XFILLER_95_847 VDD VSS DECAPHV32
X_10148_ _18612_/Q _10152_/B VDD VSS _10150_/C XOR2X1
X_18793_ _18820_/CK _18793_/D _18793_/Q VDD VSS DFFQX1
X_17813_ _19926_/Q _19894_/Q _17813_/C VDD VSS _17817_/B AOI21X1
XFILLER_48_752 VDD VSS DECAPHV16
X_10079_ _18583_/Q _18584_/Q VDD VSS _10089_/B _10079_/C NAND3X1
X_17744_ _19912_/Q _19880_/Q VDD VSS _17747_/A XNOR2X1
X_14956_ _14956_/A _14956_/B _14956_/C _14956_/D VDD VSS _15045_/A AOAI211X1
X_13907_ _13907_/A _13910_/B _13907_/C VDD VSS _14333_/B OAI21X1
X_19414_ _19466_/CK _19414_/D _19414_/Q VDD VSS DFFQX1
X_17675_ _17675_/A _17675_/B VDD VSS _19896_/D NOR2X1
X_14887_ _14887_/A _14911_/D VDD VSS _15771_/B XOR2X1
XFILLER_35_468 VDD VSS FILLER4
XFILLER_90_552 VDD VSS DECAPHV16
XTAP_TAPCELL_ROW_45_463 VDD VSS WELLTAP
XTAP_TAPCELL_ROW_73_750 VDD VSS WELLTAP
X_13838_ _14297_/B _14297_/C _13839_/A VDD VSS _13840_/C OAI21X1
X_16626_ _16626_/A _19926_/Q _16626_/C VDD VSS _16652_/C MIN3X1
XFILLER_22_129 VSS VDD FILLER2
XFILLER_50_449 VDD VSS FILLER4
XTAP_TAPCELL_ROW_17_187 VDD VSS WELLTAP
X_13769_ _13830_/A _13830_/B _13830_/D _13830_/C VDD VSS _14229_/C AOI211X1
X_19345_ _19393_/CK _19345_/D _19345_/Q VDD VSS DFFQX1
X_16557_ _19668_/Q _16826_/B VDD VSS _16569_/B XOR2X1
XFILLER_43_490 VDD VSS FILLER1
X_19276_ _20013_/CK _19276_/D _19276_/Q VDD VSS DFFQX1
X_15508_ _19435_/Q VDD VSS _15509_/A INVX1
XFILLER_30_151 VDD VSS FILLER1
X_18227_ _18228_/CK _18227_/E _18227_/ECK VDD VSS CGX3
X_16488_ _16490_/B _16488_/B VDD VSS _16489_/B XOR2X1
X_15439_ _19543_/Q _15439_/B VDD VSS _15440_/C XNOR2X1
XFILLER_7_61 VDD VSS FILLER1
X_18158_ _18173_/A _18158_/B VDD VSS _20005_/D NOR2X1
XFILLER_105_919 VSS VDD FILLER2
XFILLER_116_223 VSS VDD FILLER2
XFILLER_144_543 VDD VSS DECAPHV8
X_18089_ _19284_/Q _18089_/B VDD VSS _18090_/D NAND2X1
X_17109_ _19776_/Q _19744_/Q VDD VSS _17112_/B XNOR2X1
XFILLER_116_267 VSS VDD FILLER2
XFILLER_131_215 VDD VSS FILLER1
XTAP_TAPCELL_ROW_116_1178 VDD VSS WELLTAP
X_09931_ _11039_/C _10048_/B _09931_/C VDD VSS _09932_/B AOI21X1
X_20120_ _20120_/A VDD VSS _20120_/Y BUFX3
XFILLER_131_237 VDD VSS DECAPHV16
XFILLER_100_602 VSS VDD FILLER2
XFILLER_98_652 VDD VSS FILLER4
X_09862_ _10190_/B _09862_/B _09862_/C VDD VSS _09876_/B AOI21X1
X_20051_ clkload3/A _20051_/D _20051_/Q _20051_/RB VDD VSS DFFRQX1
Xclkbuf_1_1__f__09185_ clkbuf_0__09185_/Y VDD VSS _18487_/CK BUFX12
XFILLER_140_793 VDD VSS DECAPHV8
XFILLER_58_538 VSS VDD FILLER2
X_09793_ _18406_/Q VDD VSS _20147_/A INVX1
XFILLER_39_741 VSS VDD FILLER2
XFILLER_85_379 VDD VSS DECAPHV8
XFILLER_53_210 VDD VSS FILLER4
XTAP_TAPCELL_ROW_127_1285 VDD VSS WELLTAP
XFILLER_41_405 VDD VSS FILLER1
XFILLER_42_917 VSS VDD FILLER2
XFILLER_54_788 VSS VDD FILLER2
XFILLER_22_630 VDD VSS FILLER4
XFILLER_42_25 VDD VSS DECAPHV8
X_09227_ _18516_/Q VDD VSS _18367_/D INVX1
XTAP_TAPCELL_ROW_138_1392 VDD VSS WELLTAP
XFILLER_123_716 VSS VDD FILLER2
XFILLER_135_598 VDD VSS FILLER1
XTAP_TAPCELL_ROW_8_100 VDD VSS WELLTAP
X_11120_ _11120_/A VDD VSS _11289_/A BUFX3
XFILLER_122_226 VDD VSS FILLER1
XFILLER_1_534 VSS VDD FILLER2
XFILLER_89_641 VSS VDD FILLER2
XTAP_TAPCELL_ROW_79_809 VDD VSS WELLTAP
X_11051_ _10776_/Y _11050_/Y _11120_/A VDD VSS _11090_/B MUXI2X1
XFILLER_67_66 VDD VSS DECAPHV16
X_10002_ _09949_/Y _10001_/Y _10032_/A VDD VSS _10058_/B MUXI2X1
XFILLER_76_368 VSS VDD FILLER2
X_14810_ _19363_/Q _15738_/B _14810_/C VDD VSS _14857_/B MIN3X1
XFILLER_17_413 VDD VSS DECAPHV8
XTAP_TAPCELL_ROW_87_886 VDD VSS WELLTAP
X_15790_ _15793_/A _15790_/B VDD VSS _19409_/D AND2X1
X_11953_ _11959_/A _11959_/B _11953_/C VDD VSS _14304_/B XNOR3X1
X_14741_ _19526_/Q _19527_/Q _19528_/Q _14742_/C VDD VSS _14877_/C AND4X2
XFILLER_17_468 VDD VSS DECAPHV8
XFILLER_72_574 VDD VSS FILLER4
XFILLER_83_54 VDD VSS FILLER1
XFILLER_83_76 VSS VDD FILLER2
X_10904_ _18701_/Q _18755_/Q VDD VSS _10940_/D NOR2X1
X_11884_ _11884_/A _11884_/B _11884_/C _11884_/D VDD VSS _12048_/A AOAI211X1
X_14672_ _14672_/A _14672_/B _15827_/B VDD VSS _14673_/B MIN3X1
X_17460_ _17460_/A _17460_/B _17460_/C VDD VSS _17468_/A OA21X2
XTAP_TAPCELL_ROW_70_720 VDD VSS WELLTAP
X_10835_ _10866_/A _10866_/B _10836_/C _11014_/A VDD VSS _10836_/D AOAI211X1
X_13623_ _13623_/A _13623_/B _13623_/C _13623_/D VDD VSS _14360_/C OAI211X1
X_17391_ _17391_/A VDD VSS _17675_/A BUFX3
X_16411_ _16411_/A _16414_/B VDD VSS _16412_/B XOR2X1
XFILLER_13_630 VDD VSS FILLER1
XFILLER_25_490 VDD VSS FILLER1
XFILLER_9_601 VDD VSS FILLER1
XTAP_TAPCELL_ROW_104_1060 VDD VSS WELLTAP
XTAP_TAPCELL_ROW_42_433 VDD VSS WELLTAP
X_19130_ _19182_/CK _19130_/D _19130_/Q VDD VSS DFFQX1
X_16342_ _19596_/Q _16746_/B VDD VSS _16343_/B XOR2X1
XFILLER_13_685 VDD VSS FILLER1
XTAP_TAPCELL_ROW_14_157 VDD VSS WELLTAP
X_10766_ _18697_/Q _18751_/Q VDD VSS _10794_/C OR2X2
X_13554_ _13557_/A _13557_/C _13557_/B _13554_/D VDD VSS _14483_/B OAOI211X1
X_10697_ _11116_/A _10697_/B VDD VSS _10698_/C NAND2X1
X_12505_ _12643_/A _12643_/B VDD VSS _14408_/B XNOR2X1
X_13485_ _13578_/A _13578_/B VDD VSS _14127_/B XNOR2X1
X_19061_ _19115_/CK _19061_/D _19061_/Q VDD VSS DFFQX1
X_16273_ _16273_/A VDD VSS _17469_/B BUFX3
X_12436_ _12438_/A _12438_/B _14180_/B VDD VSS _12527_/B XNOR3X1
X_18012_ _18049_/D VDD VSS _18056_/C BUFX3
X_15224_ _19429_/Q VDD VSS _15265_/A INVX1
XFILLER_5_840 VDD VSS DECAPHV16
X_15155_ _15155_/A _15155_/B _15155_/C _15155_/D VDD VSS _15183_/D AOAI211X1
XFILLER_141_502 VSS VDD FILLER2
X_12367_ _19072_/Q VDD VSS _12460_/A INVX1
X_14106_ _17977_/A _17977_/B _17978_/B VDD VSS _17983_/B OA21X2
XFILLER_113_215 VSS VDD FILLER2
X_11318_ _11356_/C _11318_/B VDD VSS _11325_/B NOR2X1
X_12298_ wire159/Y _12298_/B _12298_/C _12298_/D VDD VSS _14375_/C OA211X2
X_19963_ _19963_/CK _19963_/D _19963_/Q VDD VSS DFFQX1
X_15086_ _19453_/Q _15838_/B VDD VSS _15088_/B XNOR2X1
X_11249_ _18578_/Q _11249_/B _11249_/C VDD VSS _11253_/B OAI21X1
X_14037_ _18951_/Q _14202_/B _14202_/C VDD VSS _14038_/D NOR3BX1
X_19894_ clkload8/A _19894_/D _19894_/Q VDD VSS DFFQX1
X_18914_ _19001_/CK _18914_/D _18914_/Q VDD VSS DFFQX1
XFILLER_122_793 VSS VDD FILLER2
XFILLER_67_324 VDD VSS FILLER4
XFILLER_94_110 VDD VSS FILLER1
X_18845_ _19963_/CK _18845_/D _18845_/Q VDD VSS DFFQX1
XFILLER_95_644 VDD VSS FILLER4
X_18776_ _19948_/CK _18776_/D _18776_/Q VDD VSS DFFQX1
X_15988_ _15988_/A _16803_/B VDD VSS _15989_/C NAND2X1
X_17727_ _17730_/A _17730_/B _17746_/C VDD VSS _17728_/C OAI21X1
X_14939_ _14956_/D _14956_/C VDD VSS _14940_/B NOR2BX1
XFILLER_36_788 VSS VDD FILLER2
X_17658_ _19893_/Q _19861_/Q VDD VSS _17661_/B XOR2X1
X_16609_ _16622_/A _16622_/B VDD VSS _16829_/B XNOR2X1
XFILLER_50_235 VDD VSS FILLER4
X_19328_ _19358_/CK _19328_/D _19328_/Q VDD VSS DFFQX1
X_17589_ _17589_/A _17589_/B _17589_/C _17589_/D VDD VSS _17590_/C AOAI211X1
XFILLER_50_268 VDD VSS FILLER1
X_19259_ _19999_/CK _19259_/D _19259_/Q VDD VSS DFFQX1
XFILLER_117_543 VSS VDD FILLER2
XFILLER_104_215 VDD VSS FILLER4
XFILLER_101_900 VDD VSS FILLER1
X_09914_ _09938_/A _10004_/B VDD VSS _09915_/D NAND2X1
X_20103_ _20103_/A VDD VSS _20103_/Y BUFX3
XFILLER_112_270 VDD VSS DECAPHV16
XFILLER_58_324 VDD VSS FILLER1
XFILLER_59_825 VDD VSS FILLER1
XTAP_TAPCELL_ROW_129_1303 VDD VSS WELLTAP
X_09845_ _09880_/A _09880_/B VDD VSS _09849_/C NOR2X1
X_20034_ _20043_/CK _20034_/D _20034_/Q _20043_/RB VDD VSS DFFRQX1
XFILLER_100_421 VDD VSS FILLER4
XFILLER_140_590 VDD VSS FILLER4
XFILLER_59_869 VDD VSS FILLER1
Xclkbuf_1_1__f__09168_ clkbuf_0__09168_/Y VDD VSS _18391_/CK BUFX12
X_09776_ _09776_/A _09776_/B _09776_/C _09776_/D VDD VSS _18292_/D OAI211X1
XFILLER_66_390 VDD VSS FILLER1
XTAP_TAPCELL_ROW_84_856 VDD VSS WELLTAP
XFILLER_26_287 VSS VDD FILLER2
XFILLER_42_758 VDD VSS DECAPHV8
XFILLER_139_112 VDD VSS DECAPHV8
X_10620_ _11116_/A _10656_/B VDD VSS _10621_/C NAND2X1
XFILLER_139_156 VDD VSS FILLER1
XTAP_TAPCELL_ROW_11_127 VDD VSS WELLTAP
X_10551_ _10579_/D VDD VSS _10945_/A BUFX3
XFILLER_139_189 VDD VSS DECAPHV8
X_10482_ _11078_/A _18717_/Q VDD VSS _10483_/D AND2X1
X_13270_ _13270_/A _13270_/B _13270_/C _13270_/D VDD VSS _14290_/B AOAI211X1
X_12221_ _19182_/Q VDD VSS _12312_/A INVX1
XFILLER_136_874 VDD VSS FILLER4
XFILLER_5_158 VDD VSS FILLER1
XFILLER_123_546 VDD VSS FILLER1
XFILLER_78_32 VSS VDD FILLER2
X_12152_ _14466_/B _14466_/C _19180_/Q VDD VSS _12171_/A AOI21X1
X_11103_ _18707_/Q _18761_/Q VDD VSS _11104_/B XOR2X1
X_12083_ _12083_/A _12083_/B _14371_/B VDD VSS _12084_/B MIN3X1
X_16960_ _16958_/Y _16960_/B _17986_/C VDD VSS _19747_/D AND3BX1
XFILLER_104_793 VDD VSS FILLER1
XFILLER_1_375 VDD VSS FILLER1
XFILLER_89_482 VDD VSS FILLER1
X_11034_ _18678_/Q _18786_/Q VDD VSS _11041_/B XOR2X1
X_15911_ _16100_/A _15911_/B VDD VSS _19516_/D NOR2X1
XFILLER_134_71 VDD VSS FILLER1
XFILLER_77_644 VSS VDD FILLER2
X_18630_ _19937_/CK _18630_/D _18630_/Q VDD VSS DFFQX1
X_16891_ _16891_/A _16891_/B VDD VSS _19727_/D NOR2X1
XFILLER_18_700 VDD VSS FILLER1
XFILLER_49_379 VSS VDD FILLER2
XFILLER_65_817 VDD VSS DECAPHV8
XFILLER_76_154 VDD VSS FILLER1
XFILLER_92_603 VDD VSS FILLER1
X_15842_ _15849_/A _15842_/B VDD VSS _19456_/D AND2X1
XFILLER_18_733 VDD VSS FILLER1
XTAP_TAPCELL_ROW_19_205 VDD VSS WELLTAP
X_12985_ _18910_/Q _13076_/B _14154_/B VDD VSS _13182_/C XNOR3X1
X_18561_ _18565_/CK _18561_/D _18561_/Q VDD VSS DFFQX1
X_15773_ _15793_/A _15773_/B VDD VSS _19394_/D AND2X1
XFILLER_18_788 VSS VDD FILLER2
XFILLER_73_872 VDD VSS DECAPHV8
XFILLER_91_168 VSS VDD FILLER2
X_11936_ _19205_/Q _11936_/B _12048_/D VDD VSS _11987_/C XNOR3X1
X_18492_ _18494_/CK _18513_/Q _20105_/A _18492_/RB VDD VSS DFFRQX1
X_17512_ _19861_/Q _19829_/Q _17512_/C VDD VSS _17517_/B MIN3X1
X_14724_ _14727_/B _14724_/B VDD VSS _15673_/B XNOR2X1
XFILLER_45_574 VDD VSS DECAPHV16
XFILLER_45_596 VDD VSS FILLER1
X_17443_ _17446_/C _17444_/B _17452_/C VDD VSS _17444_/C OAI21X1
XFILLER_32_235 VDD VSS FILLER1
XFILLER_33_769 VDD VSS FILLER1
XTAP_TAPCELL_ROW_27_282 VDD VSS WELLTAP
X_11867_ _19091_/Q _11867_/B _11867_/C VDD VSS _11962_/B MIN3X1
X_14655_ _19497_/Q _14655_/B VDD VSS _14676_/C NAND2X1
XFILLER_32_268 VDD VSS FILLER1
X_10818_ _19951_/Q _18833_/Q VDD VSS _10856_/A NAND2X1
X_11798_ _11830_/A _11830_/B VDD VSS _11808_/B NOR2X1
X_13606_ _13607_/A _13607_/B _13607_/D _13607_/C VDD VSS _13840_/B OAOI211X1
X_14586_ _19522_/Q _19495_/Q _15887_/B VDD VSS _14615_/B XOR3X1
X_17374_ _17377_/A _17377_/B VDD VSS _17375_/B XNOR2X1
XFILLER_119_808 VSS VDD FILLER2
X_10749_ _10749_/A _10749_/B VDD VSS _10790_/A NAND2X1
X_13537_ _13548_/A _14388_/B _13614_/C VDD VSS _14389_/B OAI21X1
X_19113_ _19196_/CK _19113_/D _19113_/Q VDD VSS DFFQX1
X_16325_ _16326_/A _16326_/B _16326_/C VDD VSS _16352_/B AOI21X1
XFILLER_40_290 VDD VSS FILLER1
XFILLER_9_464 VDD VSS FILLER1
X_19044_ _19045_/CK _19044_/D _19044_/Q VDD VSS DFFQX1
X_16256_ _19592_/Q _16256_/B _16742_/B VDD VSS _16283_/B MIN3X1
XFILLER_64_4 VDD VSS FILLER4
X_13468_ _13559_/C _13557_/B _13468_/C VDD VSS _13549_/B XNOR3X1
X_15207_ _19400_/Q _15779_/A VDD VSS _15223_/B XNOR2X1
X_12419_ _12460_/A _12419_/B _12544_/D VDD VSS _12517_/C XNOR3X1
X_13399_ _13400_/B _13400_/C _18969_/Q VDD VSS _13402_/B AOI21X1
X_16187_ _19590_/Q _16740_/B VDD VSS _16188_/B XOR2X1
XFILLER_5_692 VDD VSS FILLER1
X_15138_ _15138_/A _15138_/B _15810_/B VDD VSS _15180_/B MIN3X1
XFILLER_142_866 VDD VSS FILLER1
XTAP_TAPCELL_ROW_113_1148 VDD VSS WELLTAP
X_19946_ _19951_/CK _19946_/D _19946_/Q VDD VSS DFFQX1
X_15069_ _15069_/A _15069_/B VDD VSS _15776_/C _15069_/C AND3X2
XFILLER_101_229 VSS VDD FILLER2
X_19877_ _19907_/CK _19877_/D _19877_/Q VDD VSS DFFQX1
XFILLER_110_774 VDD VSS FILLER4
XFILLER_28_508 VSS VDD FILLER2
X_09630_ _18506_/Q _18505_/Q _09630_/C VDD VSS _09814_/C NOR3BX1
X_18828_ _18828_/CK _18828_/D _18828_/Q VDD VSS DFFQX1
X_09561_ _09815_/C VDD VSS _09770_/C BUFX3
X_18759_ _18785_/CK _18759_/D _18759_/Q VDD VSS DFFQX1
XFILLER_48_390 VDD VSS FILLER1
XFILLER_23_213 VDD VSS FILLER1
XFILLER_63_382 VDD VSS DECAPHV8
XTAP_TAPCELL_ROW_124_1255 VDD VSS WELLTAP
XTAP_TAPCELL_ROW_81_826 VDD VSS WELLTAP
X_09492_ _19984_/Q _09496_/B _09507_/B VDD VSS _09493_/C AOI21X1
XFILLER_23_257 VDD VSS FILLER1
XFILLER_51_566 VDD VSS FILLER4
XFILLER_139_16 VDD VSS DECAPHV8
XFILLER_137_649 VSS VDD FILLER2
XTAP_TAPCELL_ROW_135_1362 VDD VSS WELLTAP
XFILLER_105_524 VDD VSS DECAPHV16
XFILLER_132_332 VSS VDD FILLER2
XTAP_TAPCELL_ROW_89_904 VDD VSS WELLTAP
XFILLER_120_516 VDD VSS FILLER1
XFILLER_132_376 VDD VSS FILLER4
XFILLER_100_251 VDD VSS FILLER1
XFILLER_48_68 VSS VDD FILLER2
XTAP_TAPCELL_ROW_97_981 VDD VSS WELLTAP
X_09828_ _09828_/A VDD VSS _09944_/A BUFX3
X_20017_ _20022_/CK _20017_/D _20017_/Q _20031_/RB VDD VSS DFFRQX1
XFILLER_64_12 VDD VSS FILLER1
X_09759_ _09759_/A _09759_/B _09776_/A VDD VSS _09760_/E AOI21X1
XFILLER_64_45 VDD VSS FILLER1
XFILLER_70_831 VDD VSS DECAPHV8
X_12770_ _12771_/D _14474_/B VDD VSS _12940_/A NAND2X1
XFILLER_14_246 VSS VDD FILLER2
XFILLER_15_747 VDD VSS DECAPHV16
XFILLER_15_769 VDD VSS DECAPHV16
X_11721_ _11745_/A _11745_/B _11745_/C VDD VSS _14486_/A OAI21X1
XFILLER_70_897 VDD VSS FILLER1
XTAP_TAPCELL_ROW_101_1030 VDD VSS WELLTAP
XTAP_TAPCELL_ROW_24_252 VDD VSS WELLTAP
X_11652_ _18792_/Q _11658_/B VDD VSS _18819_/D AND2X1
X_14440_ _14440_/A _14440_/B _14440_/C VDD VSS _14441_/C NOR3X1
XFILLER_80_66 VSS VDD FILLER2
X_10603_ _19946_/Q _18828_/Q VDD VSS _10633_/D NOR2X1
X_14371_ _14393_/A _14371_/B VDD VSS _19094_/D NOR2X1
X_11583_ _18729_/Q _11589_/B VDD VSS _18756_/D AND2X1
X_13322_ _19109_/Q _13616_/A _13322_/C VDD VSS _13365_/C XNOR3X1
X_16110_ _19587_/Q VDD VSS _16134_/A INVX1
XFILLER_128_649 VSS VDD FILLER2
X_10534_ _10579_/A _10579_/B _10579_/C _10581_/A VDD VSS _10622_/C AOI31X1
X_17090_ _17095_/A _17090_/B VDD VSS _19772_/D NOR2X1
XFILLER_108_340 VSS VDD FILLER2
XFILLER_124_811 VDD VSS FILLER1
XFILLER_89_20 VSS VDD FILLER2
X_10465_ _10511_/A _10465_/B VDD VSS _10466_/D NOR2X1
X_13253_ _13253_/A _14513_/B _14513_/C VDD VSS _13254_/D NOR3X1
X_16041_ _16060_/B _16041_/B VDD VSS _16768_/B XNOR2X1
XFILLER_135_170 VSS VDD FILLER2
XFILLER_89_64 VDD VSS FILLER1
X_10396_ _18634_/Q _18796_/Q VDD VSS _10476_/A XNOR2X1
X_12204_ _19069_/Q VDD VSS _12283_/A INVX1
X_13184_ _18884_/Q _13184_/B _13184_/C VDD VSS _13495_/B MIN3X1
X_12135_ _19067_/Q VDD VSS _12284_/A INVX1
X_19800_ _19833_/CK _19800_/D _19800_/Q VDD VSS DFFQX1
XFILLER_96_216 VSS VDD FILLER2
X_17992_ _18531_/Q _18020_/B VDD VSS _18024_/B AND2X1
XFILLER_2_695 VSS VDD FILLER2
X_12066_ _14239_/A _14240_/A _14274_/B VDD VSS _12072_/C XNOR3X1
X_19731_ _19736_/CK _19731_/D _19731_/Q VDD VSS DFFQX1
X_16943_ _19743_/Q wire163/Y _16943_/C VDD VSS _16948_/C MIN3X1
X_11017_ _10878_/Y _11016_/Y _11118_/A VDD VSS _11019_/B MUXI2X1
X_19662_ _19696_/CK _19662_/D _19662_/Q VDD VSS DFFQX1
X_16874_ _16876_/A _16874_/B VDD VSS _19711_/D NOR2X1
XFILLER_65_658 VDD VSS DECAPHV8
X_19593_ _19671_/CK _19593_/D _19593_/Q VDD VSS DFFQX1
X_18613_ _18622_/CK _18613_/D _18613_/Q VDD VSS DFFQX1
X_15825_ _15849_/A _15825_/B VDD VSS _19440_/D AND2X1
XFILLER_46_894 VDD VSS FILLER4
X_12968_ _12968_/A _12968_/B _14539_/B _12968_/D _12968_/E VDD VSS _13133_/B OAI221X1
X_18544_ _18550_/CK _18544_/D _18544_/Q VDD VSS DFFQX1
X_15756_ _15770_/A _15756_/B VDD VSS _19379_/D AND2X1
XFILLER_33_533 VSS VDD FILLER2
X_11919_ _19176_/Q VDD VSS _12034_/A INVX1
X_12899_ _12899_/A _14286_/B _14286_/C VDD VSS _12900_/D NOR3X1
X_18475_ _18479_/CK _18512_/Q _20120_/A _20078_/RB VDD VSS DFFRQX1
X_15687_ _15693_/A _15687_/B VDD VSS _19316_/D NOR2X1
X_14707_ _14710_/A _14739_/B _14739_/C VDD VSS _14708_/C AND3BX1
XFILLER_21_728 VDD VSS FILLER1
X_14638_ _19469_/Q _14638_/B _14638_/C VDD VSS _15826_/B XNOR3X1
X_17426_ _19844_/Q _19812_/Q VDD VSS _17431_/A XNOR2X1
XFILLER_60_396 VDD VSS FILLER4
X_17357_ _17507_/B _17357_/B _17357_/C VDD VSS _17362_/C MIN3X1
XFILLER_119_605 VSS VDD FILLER2
XFILLER_13_290 VDD VSS FILLER4
XFILLER_20_249 VDD VSS FILLER1
X_14569_ _20008_/Q _14569_/B VDD VSS _19272_/D AND2X1
X_16308_ _19658_/Q _16816_/B _16308_/C VDD VSS _16348_/A OAI21X1
XFILLER_118_126 VDD VSS FILLER1
Xclkload20 _19958_/CK VDD VSS clkload20/Y BUFX12
X_17288_ _17289_/A _17289_/B _17289_/D _17289_/C VDD VSS _17291_/C AOI211X1
Xclkload53 _19050_/CK VDD VSS clkload53/Y INVX2
Xclkload42 _20006_/CK VDD VSS clkload42/Y INVX2
Xclkload31 _18799_/CK VDD VSS clkload31/Y INVX2
X_19027_ _19064_/CK _19027_/D _19027_/Q VDD VSS DFFQX1
X_16239_ _16256_/B _16239_/B VDD VSS _16778_/B XNOR2X1
XFILLER_55_0 VSS VDD FILLER2
Xclkbuf_leaf_19__001_ clkbuf_2_3__f__001_/Y VDD VSS _18888_/CK BUFX12
Xclkload86 _19551_/CK VDD VSS clkload86/Y INVX6
Xclkload75 _19001_/CK VDD VSS clkload75/Y INVX1
Xclkload64 _19992_/CK VDD VSS clkload64/Y INVX2
Xclkload97 _19730_/CK VDD VSS clkload97/Y INVX2
XFILLER_114_365 VDD VSS FILLER4
XFILLER_68_430 VDD VSS FILLER4
XFILLER_87_238 VDD VSS FILLER1
X_19929_ clkload9/A _19929_/D _19929_/Q VDD VSS DFFQX1
XFILLER_29_806 VSS VDD FILLER2
XFILLER_18_49 VDD VSS FILLER4
XFILLER_95_282 VDD VSS FILLER1
X_09613_ _20103_/A _20119_/A _09776_/A VDD VSS _09617_/C MUX2X1
XFILLER_83_444 VDD VSS FILLER4
XTAP_TAPCELL_ROW_94_951 VDD VSS WELLTAP
XTAP_TAPCELL_ROW_66_675 VDD VSS WELLTAP
X_09544_ _20038_/Q _09547_/B VDD VSS _20039_/D NOR2BX1
XTAP_TAPCELL_ROW_38_399 VDD VSS WELLTAP
X_09475_ _18451_/D _09483_/B _09475_/C VDD VSS _18246_/D AOI21X1
XFILLER_11_216 VDD VSS FILLER4
XTAP_TAPCELL_ROW_21_222 VDD VSS WELLTAP
Xclkload3 clkload3/A VDD VSS clkload3/Y INVX1
XFILLER_4_927 VDD VSS FILLER1
X_10250_ _11435_/B _11438_/A _11435_/A VDD VSS _10721_/D OR3BX2
XFILLER_106_899 VDD VSS FILLER4
XFILLER_133_685 VDD VSS FILLER1
X_10181_ _14522_/A VDD VSS _13177_/A BUFX3
XFILLER_121_847 VDD VSS FILLER4
XFILLER_121_869 VDD VSS FILLER1
XFILLER_115_73 VDD VSS FILLER1
X_13940_ _18893_/Q _14135_/B _14135_/C VDD VSS _13941_/D OR3BX1
XFILLER_19_327 VDD VSS DECAPHV8
XFILLER_46_113 VDD VSS FILLER1
XFILLER_86_260 VSS VDD FILLER2
X_13871_ _18890_/Q _14131_/B VDD VSS _13872_/D _14131_/C NAND3X1
X_15610_ _19327_/Q _15699_/B VDD VSS _15614_/B XOR2X1
XFILLER_27_360 VDD VSS FILLER1
XFILLER_27_371 VDD VSS FILLER1
X_12822_ _12932_/A _12822_/B VDD VSS _14411_/B XNOR2X1
X_16590_ _16616_/B _16590_/B VDD VSS _19541_/D NOR2X1
XFILLER_131_72 VDD VSS DECAPHV8
XFILLER_43_842 VDD VSS FILLER1
X_12753_ _12827_/A _12827_/B _12827_/C VDD VSS _12768_/B AOI21X1
X_15541_ _15541_/A _15541_/B _15541_/C _15541_/D VDD VSS _15568_/A AOAI211X1
XFILLER_15_577 VDD VSS DECAPHV8
XFILLER_43_864 VSS VDD FILLER2
XFILLER_91_43 VDD VSS DECAPHV16
X_11704_ _19988_/Q _19252_/Q VDD VSS _11706_/C NAND2X1
X_18260_ _18272_/CK _18260_/D _18260_/Q _18485_/RB VDD VSS DFFRQX1
X_15472_ _15472_/A _15472_/B VDD VSS _15515_/A NOR2X1
X_12684_ _12827_/A _12827_/B VDD VSS _14474_/B XNOR2X1
X_14423_ _14467_/A _14423_/B VDD VSS _19141_/D AND2X1
X_17211_ _17212_/C _17211_/B _17211_/C VDD VSS _19797_/D AOI21X1
XFILLER_11_761 VDD VSS FILLER1
XFILLER_30_569 VDD VSS FILLER1
X_11635_ _18777_/Q _11635_/B VDD VSS _18804_/D AND2X1
X_18191_ _19303_/Q _18191_/B _18191_/C VDD VSS _18195_/C MIN3X1
XFILLER_129_947 VSS VDD FILLER2
XFILLER_7_721 VDD VSS FILLER4
X_11566_ _18714_/Q _11567_/B VDD VSS _18741_/D AND2X1
X_14354_ _14415_/A _14354_/B VDD VSS _19080_/D AND2X1
X_17142_ _19782_/Q _19750_/Q _17142_/C VDD VSS _17147_/C AO21X2
XFILLER_109_660 VDD VSS FILLER1
XFILLER_6_231 VDD VSS FILLER1
X_10517_ _18628_/Q _18718_/Q VDD VSS _10518_/C NAND2X1
X_13305_ _19025_/Q _13406_/A _13406_/B VDD VSS _13307_/D XNOR3X1
X_14285_ _14285_/A _14285_/B VDD VSS _19019_/D NOR2X1
X_17073_ _19767_/Q _17073_/B _17073_/C VDD VSS _17075_/B MIN3X1
XFILLER_143_427 VDD VSS FILLER4
X_11497_ _11497_/A _11641_/B VDD VSS _18679_/D NOR2X1
X_13236_ _13354_/A _14416_/B VDD VSS _13266_/B NOR2X1
X_16024_ _16024_/A _16024_/B _16024_/C VDD VSS _16025_/C MIN3X1
X_10448_ _10448_/A _10448_/B _10448_/C _10448_/D VDD VSS _10449_/C AOI211X1
XFILLER_111_302 VDD VSS FILLER1
XFILLER_123_162 VSS VDD FILLER2
XFILLER_97_525 VSS VDD FILLER2
XTAP_TAPCELL_ROW_110_1118 VDD VSS WELLTAP
X_10379_ _10406_/D _10406_/C VDD VSS _10381_/D NOR2BX1
X_13167_ _18996_/Q _13373_/A _13195_/B VDD VSS _13192_/D XNOR3X1
XFILLER_112_847 VDD VSS FILLER1
XFILLER_97_547 VDD VSS DECAPHV8
X_12118_ _19124_/Q _12118_/B _12147_/D VDD VSS _12149_/C XOR3X1
X_13098_ _13271_/A _13098_/B VDD VSS _14321_/B XOR2X1
X_17975_ _17975_/A _17975_/B _17975_/C VDD VSS _17976_/D NOR3X1
X_12049_ _12055_/A _12055_/B _12050_/D _12055_/C VDD VSS _14528_/A OA211X2
X_19714_ _19716_/CK _19714_/D _19714_/Q VDD VSS DFFQX1
X_16926_ _16928_/A _16928_/B _16926_/C VDD VSS _19740_/D AOI21X1
XFILLER_120_880 VSS VDD FILLER2
XFILLER_38_636 VDD VSS DECAPHV16
XFILLER_77_282 VSS VDD FILLER2
XFILLER_93_753 VDD VSS FILLER1
X_19645_ _19678_/CK _19645_/D _19645_/Q VDD VSS DFFQX1
X_16857_ _16859_/A _16857_/B VDD VSS _19696_/D AND2X1
XFILLER_1_96 VDD VSS FILLER1
XFILLER_65_499 VDD VSS FILLER4
XFILLER_80_414 VDD VSS FILLER4
XFILLER_81_948 VSS VDD FILLER2
XTAP_TAPCELL_ROW_91_921 VDD VSS WELLTAP
X_19576_ _19606_/CK _19576_/D _19576_/Q VDD VSS DFFQX1
X_16788_ _16794_/A _16788_/B VDD VSS _19634_/D NOR2X1
X_15808_ _17566_/A VDD VSS _17010_/A BUFX3
XFILLER_80_447 VDD VSS FILLER1
XTAP_TAPCELL_ROW_63_645 VDD VSS WELLTAP
X_18527_ _18543_/CK _18527_/D _18527_/Q VDD VSS DFFQX1
X_15739_ _15739_/A _15739_/B VDD VSS _19364_/D NOR2X1
XFILLER_21_503 VDD VSS FILLER1
XFILLER_34_886 VDD VSS FILLER4
XTAP_TAPCELL_ROW_121_1225 VDD VSS WELLTAP
XTAP_TAPCELL_ROW_35_369 VDD VSS WELLTAP
X_09260_ _09265_/C _09408_/C _18279_/Q VDD VSS _09261_/C AOI21X1
XFILLER_34_897 VDD VSS DECAPHV8
X_18458_ _18468_/CK _18474_/D _20100_/A _18465_/RB VDD VSS DFFRQX1
X_09191_ _18499_/D VDD VSS _18451_/D INVX1
X_18389_ _18390_/CK _18469_/D _20194_/A _20065_/RB VDD VSS DFFRQX1
X_17409_ _19840_/Q _19808_/Q VDD VSS _17411_/B XNOR2X1
XFILLER_119_468 VDD VSS DECAPHV16
XFILLER_135_928 VSS VDD FILLER2
Xclkload131 _18438_/CK VDD VSS clkload131/Y INVX2
Xclkload120 _18471_/CK VDD VSS clkload120/Y INVX2
XFILLER_134_438 VDD VSS FILLER1
XFILLER_136_17 VDD VSS DECAPHV16
XTAP_TAPCELL_ROW_132_1332 VDD VSS WELLTAP
XFILLER_103_803 VDD VSS DECAPHV8
XFILLER_88_514 VDD VSS DECAPHV8
XFILLER_142_493 VDD VSS FILLER1
XFILLER_29_37 VDD VSS FILLER4
XFILLER_111_891 VSS VDD FILLER2
XFILLER_28_113 VDD VSS FILLER4
XFILLER_68_260 VSS VDD FILLER2
XFILLER_110_390 VDD VSS FILLER1
XFILLER_56_433 VDD VSS FILLER1
XFILLER_84_775 VDD VSS DECAPHV8
XFILLER_45_36 VDD VSS DECAPHV8
XTAP_TAPCELL_ROW_143_1450 VDD VSS WELLTAP
X_09527_ _18197_/D _09527_/B _09527_/C VDD VSS _20022_/D NOR3X1
XFILLER_101_20 VDD VSS FILLER1
XFILLER_12_503 VSS VDD FILLER2
XFILLER_101_64 VSS VDD FILLER2
XFILLER_12_514 VSS VDD FILLER2
XFILLER_12_525 VDD VSS FILLER1
XFILLER_24_385 VDD VSS FILLER4
XFILLER_61_24 VSS VDD FILLER2
X_09458_ _18443_/D _09468_/B _09458_/C VDD VSS _18254_/D AOI21X1
XFILLER_138_700 VDD VSS DECAPHV8
X_09389_ _19932_/Q _19934_/Q _09389_/C VDD VSS _09390_/B NOR3X1
X_11420_ _18542_/D _11428_/B VDD VSS _18614_/D NOR2BX1
X_11351_ _18589_/Q _11355_/B VDD VSS _11353_/A XNOR2X1
XFILLER_117_2 VDD VSS FILLER1
XFILLER_125_416 VDD VSS DECAPHV8
XFILLER_4_724 VDD VSS FILLER1
X_10302_ _10266_/D _11438_/A _11432_/D VDD VSS _10304_/C AND3BX1
XFILLER_118_490 VDD VSS FILLER1
XFILLER_4_768 VDD VSS FILLER1
X_11282_ _11285_/A _11285_/B VDD VSS _11283_/B XNOR2X1
X_14070_ _14203_/A _14203_/B _18952_/Q VDD VSS _14086_/C OAI21X1
XFILLER_105_140 VDD VSS FILLER1
X_10233_ _18622_/Q _10233_/B VDD VSS _10234_/B XNOR2X1
X_13021_ _13021_/A _13021_/B _13091_/C _13021_/D VDD VSS _13215_/A OAOI211X1
XFILLER_120_110 VDD VSS DECAPHV8
XFILLER_121_644 VSS VDD FILLER2
X_10164_ _18591_/Q _10203_/B VDD VSS _10165_/B XOR2X1
X_10095_ _10101_/A _10101_/B VDD VSS _10099_/A XNOR2X1
X_17760_ _19915_/Q _19883_/Q VDD VSS _17766_/B NAND2X1
X_14972_ _15056_/C _15013_/B VDD VSS _14973_/B NAND2X1
XFILLER_19_124 VSS VDD FILLER2
X_13923_ _18948_/Q _14001_/B VDD VSS _13924_/D _13923_/C NAND3X1
X_17691_ _17806_/A _17691_/B VDD VSS _19900_/D NOR2X1
X_16711_ _16711_/A _16724_/B VDD VSS _19564_/D NOR2X1
XFILLER_63_948 VSS VDD FILLER2
XFILLER_74_263 VDD VSS DECAPHV16
X_13854_ _13854_/A _14393_/B _13854_/C VDD VSS _14364_/B MIN3X1
X_19430_ _19461_/CK _19430_/D _19430_/Q VDD VSS DFFQX1
X_16642_ _19735_/Q _16900_/B VDD VSS _16643_/D NOR2X1
XFILLER_34_138 VDD VSS FILLER1
X_12805_ _14348_/B _14348_/C _19075_/Q VDD VSS _12807_/C AOI21X1
X_19361_ _19362_/CK _19361_/D _19361_/Q VDD VSS DFFQX1
X_16573_ _16573_/A _16573_/B VDD VSS _16574_/C NOR2X1
XFILLER_16_886 VDD VSS FILLER4
XFILLER_31_812 VDD VSS FILLER4
XFILLER_43_650 VDD VSS FILLER1
X_10997_ _18650_/Q _18812_/Q VDD VSS _10999_/A XOR2X1
X_13785_ _19086_/Q _14362_/B VDD VSS _13860_/A NAND2X1
Xclkbuf_leaf_18__002_ clkload17/A VDD VSS _19957_/CK BUFX12
X_18312_ _18324_/CK _18525_/Q _18312_/Q _09380_/B VDD VSS DFFRQX1
X_15524_ _19408_/Q _15789_/B VDD VSS _15526_/A XNOR2X1
XFILLER_42_182 VDD VSS DECAPHV8
XTAP_TAPCELL_ROW_60_615 VDD VSS WELLTAP
X_12736_ _19131_/Q VDD VSS _12813_/A INVX1
X_19292_ _19304_/CK _19292_/D _19292_/Q VDD VSS DFFQX1
XFILLER_31_856 VDD VSS DECAPHV8
XTAP_TAPCELL_ROW_32_339 VDD VSS WELLTAP
XTAP_TAPCELL_ROW_6_73 VDD VSS WELLTAP
X_12667_ _19242_/Q _14536_/B VDD VSS _12832_/A NAND2X1
X_18243_ _18255_/CK _18243_/D _18274_/D _20080_/RB VDD VSS DFFRQX1
X_15455_ _19350_/Q _15724_/B VDD VSS _15457_/A XOR2X1
X_11618_ _18761_/Q _11624_/B VDD VSS _18788_/D AND2X1
X_14406_ _14381_/Y _14406_/B _14406_/C VDD VSS _19127_/D AND3BX1
X_18174_ _19300_/Q _18174_/B _18174_/C VDD VSS _18179_/C MIN3X1
X_15386_ _19348_/Q _15386_/B _15722_/B VDD VSS _15456_/A MIN3X1
XFILLER_117_928 VSS VDD FILLER2
XFILLER_128_243 VDD VSS FILLER4
X_12598_ _19018_/Q _12598_/B _12632_/C VDD VSS _12717_/A XNOR3X1
X_14337_ _14339_/A _14337_/B VDD VSS _19065_/D NOR2X1
X_17125_ _17128_/C _17126_/B _17164_/C VDD VSS _17126_/C OAI21X1
XFILLER_117_939 VDD VSS DECAPHV8
X_11549_ _18698_/Q _11555_/B VDD VSS _18725_/D AND2X1
XFILLER_143_246 VDD VSS FILLER1
XFILLER_7_595 VDD VSS FILLER4
X_14268_ _14268_/A _14268_/B _15836_/C VDD VSS _19006_/D OA21X2
X_17056_ _17095_/A _17056_/B VDD VSS _19764_/D NOR2X1
X_13219_ _13219_/A _13219_/B _13231_/C VDD VSS _13365_/B XNOR3X1
X_14199_ _14219_/A _14199_/B _14199_/C VDD VSS _18949_/D NOR3X1
X_16007_ _19711_/Q _16874_/B VDD VSS _16028_/A NAND2X1
XFILLER_100_828 VDD VSS FILLER1
XFILLER_97_399 VSS VDD FILLER2
X_17958_ _17958_/A _17958_/B _17958_/C _17958_/D VDD VSS _17966_/A OAOI211X1
XFILLER_18_0 VDD VSS FILLER1
XFILLER_66_742 VDD VSS DECAPHV8
X_17889_ _18856_/Q VDD VSS _17894_/A INVX1
X_16909_ _20068_/Q _16909_/B _16909_/C VDD VSS _16912_/B AOI21X1
XFILLER_38_488 VDD VSS FILLER4
XFILLER_93_561 VSS VDD FILLER2
X_19628_ _19636_/CK _19628_/D _19628_/Q VDD VSS DFFQX1
XFILLER_25_116 VSS VDD FILLER2
XFILLER_93_594 VDD VSS DECAPHV8
XTAP_TAPCELL_ROW_48_494 VDD VSS WELLTAP
X_09312_ _18405_/D _09311_/Y _09302_/Y VDD VSS _18522_/D MUXI2X1
X_19559_ _19591_/CK _19559_/D _19559_/Q VDD VSS DFFQX1
XFILLER_21_333 VDD VSS FILLER1
XFILLER_22_878 VSS VDD FILLER2
X_09243_ _18470_/D VDD VSS _18342_/D INVX1
XFILLER_108_917 VDD VSS DECAPHV32
XFILLER_107_427 VDD VSS FILLER1
XFILLER_135_736 VDD VSS DECAPHV8
XFILLER_134_235 VDD VSS FILLER4
XFILLER_89_801 VDD VSS DECAPHV8
Xoutput27 _20111_/Y VDD VSS o_bias_cfg[13] BUFX3
Xoutput38 _20121_/Y VDD VSS o_bias_cfg[23] BUFX3
Xoutput49 _20131_/Y VDD VSS o_bias_cfg[33] BUFX3
Xoutput16 _20085_/Y VDD VSS o_aux_ctrl[3] BUFX3
XFILLER_0_248 VSS VDD FILLER2
XFILLER_76_506 VDD VSS FILLER4
X_20196_ _20196_/A VDD VSS _20196_/Y BUFX3
XFILLER_102_165 VSS VDD FILLER2
XFILLER_103_699 VDD VSS DECAPHV8
XFILLER_56_230 VSS VDD FILLER2
XFILLER_57_742 VSS VDD FILLER2
XFILLER_44_414 VDD VSS FILLER4
XFILLER_56_57 VSS VDD FILLER2
XFILLER_56_79 VDD VSS DECAPHV8
X_10920_ _11272_/A _10920_/B VDD VSS _18568_/D NOR2X1
XFILLER_44_436 VSS VDD FILLER2
XFILLER_56_296 VSS VDD FILLER2
XFILLER_71_211 VSS VDD FILLER2
XFILLER_25_650 VDD VSS FILLER1
XFILLER_71_266 VDD VSS FILLER1
X_10851_ _10851_/A _10851_/B _10885_/A _10851_/D VDD VSS _10885_/B AOI211X1
XFILLER_72_56 VDD VSS FILLER4
X_10782_ _10784_/A _10782_/B VDD VSS _10783_/B XOR2X1
X_13570_ _18944_/Q _14194_/B VDD VSS _13580_/C XNOR2X1
XFILLER_52_491 VDD VSS FILLER1
X_12521_ _12600_/B _12600_/C VDD VSS _14283_/B NAND2X1
Xclkbuf_leaf_5_clk_regs clkload1/A VDD VSS _19843_/CK BUFX12
X_12452_ _12452_/A _12452_/B _12452_/C _12452_/D VDD VSS _12461_/B OAOI211X1
X_15240_ _15274_/A _15240_/B VDD VSS _15307_/B XNOR2X1
X_11403_ _17827_/B _17990_/B _11403_/C VDD VSS _18599_/D NOR3X1
X_12383_ _12472_/A _12472_/B VDD VSS _14438_/B XNOR2X1
X_15171_ _19315_/Q _15171_/B _15686_/B VDD VSS _15217_/B MIN3X1
XFILLER_4_521 VSS VDD FILLER2
X_11334_ _11337_/B _11334_/B VDD VSS _11335_/B XOR2X1
X_14122_ _14142_/A _14122_/B VDD VSS _18881_/D NOR2X1
XFILLER_4_565 VSS VDD FILLER2
X_11265_ _11379_/A _11276_/A VDD VSS _11269_/A NOR2X1
X_14053_ _18196_/A _17963_/B _17963_/C VDD VSS _18868_/D AND3BX1
X_18930_ _18935_/CK _18930_/D _18930_/Q VDD VSS DFFQX1
XFILLER_106_493 VDD VSS DECAPHV16
XFILLER_79_322 VDD VSS FILLER1
XFILLER_97_53 VSS VDD FILLER2
X_10216_ _10217_/A _10217_/B _10217_/D _10217_/C VDD VSS _10219_/C AOI211X1
X_13004_ _13004_/A _13004_/B _13004_/C _13004_/D VDD VSS _13192_/A AOAI211X1
X_11196_ _11196_/A _18737_/Q VDD VSS _11229_/E NAND2X1
X_18861_ _18888_/CK _18861_/D _18861_/Q VDD VSS DFFQX1
XFILLER_121_485 VDD VSS FILLER1
XFILLER_79_388 VDD VSS DECAPHV8
X_10147_ _10047_/B _10146_/Y _10224_/A VDD VSS _10152_/B MUXI2X1
X_18792_ _18820_/CK _18792_/D _18792_/Q VDD VSS DFFQX1
X_17812_ _17812_/A VDD VSS _18173_/A BUFX3
XFILLER_0_793 VDD VSS DECAPHV8
XFILLER_82_509 VSS VDD FILLER2
XFILLER_94_369 VDD VSS FILLER1
X_10078_ _18606_/Q _10078_/B _10076_/B VDD VSS _10097_/A AOI21BX1
X_17743_ _17806_/A _17743_/B VDD VSS _19911_/D NOR2X1
X_14955_ _19394_/Q _14955_/B _15773_/B VDD VSS _15026_/A MIN3X1
XFILLER_75_583 VDD VSS FILLER1
X_13906_ _19088_/Q _14364_/B VDD VSS _13907_/C NAND2X1
X_19413_ _19495_/CK _19413_/D _19413_/Q VDD VSS DFFQX1
X_17674_ _17678_/A _17678_/B VDD VSS _17675_/B XNOR2X1
X_14886_ _19421_/Q _14959_/A _14909_/B VDD VSS _14911_/D XNOR3X1
XFILLER_51_929 VDD VSS FILLER1
X_13837_ _13837_/A _13837_/B _13837_/C _13837_/D VDD VSS _14297_/C AOI211X1
X_16625_ _19574_/Q VDD VSS _16626_/A INVX1
XFILLER_43_480 VSS VDD FILLER2
XFILLER_62_299 VDD VSS DECAPHV8
XTAP_TAPCELL_ROW_45_464 VDD VSS WELLTAP
X_13768_ _13768_/A _13768_/B _13768_/C _13768_/D VDD VSS _14229_/B OAOI211X1
X_19344_ _19393_/CK _19344_/D _19344_/Q VDD VSS DFFQX1
X_16556_ _16571_/B _16556_/B VDD VSS _16826_/B XNOR2X1
XTAP_TAPCELL_ROW_17_188 VDD VSS WELLTAP
X_09960__230 _18259_/CK VDD VSS _18507_/CK INVX1
X_12719_ _12719_/A _14347_/B VDD VSS _12807_/A OR2X2
Xclkbuf_0_clk clk VDD VSS clkbuf_0_clk/Y BUFX12
X_19275_ _20013_/CK _19275_/D _19275_/Q VDD VSS DFFQX1
X_16487_ _19729_/Q _16894_/B VDD VSS _16488_/B XOR2X1
X_15507_ _19380_/Q VDD VSS _15540_/A INVX1
XFILLER_31_664 VDD VSS DECAPHV16
X_13699_ _13727_/A _14326_/B _13699_/C _13699_/D VDD VSS _13781_/A AOAI211X1
X_18226_ _18234_/CK _18226_/E _18226_/ECK VDD VSS CGX3
X_15438_ _15473_/A _15912_/B VDD VSS _15474_/A XNOR2X1
X_18157_ _18159_/A _18157_/B VDD VSS _18158_/B XOR2X1
X_15369_ _15391_/B _15369_/B VDD VSS _15785_/B XNOR2X1
XFILLER_116_235 VDD VSS FILLER4
XFILLER_116_246 VDD VSS FILLER1
XFILLER_117_747 VDD VSS FILLER1
X_18088_ _18090_/A _18090_/B _18090_/C _18088_/D VDD VSS _19992_/D AOI31X1
X_17108_ _19775_/Q _19743_/Q _17108_/C VDD VSS _17114_/C AOI21X1
XFILLER_131_205 VDD VSS DECAPHV8
XFILLER_132_706 VDD VSS FILLER1
XFILLER_144_588 VDD VSS DECAPHV32
XFILLER_89_108 VSS VDD FILLER2
XTAP_TAPCELL_ROW_116_1179 VDD VSS WELLTAP
X_09930_ _09944_/A _09930_/B _09930_/C VDD VSS _09931_/C OA21X2
X_17039_ _17566_/A VDD VSS _17536_/A BUFX3
X_20050_ clkload4/A _20050_/D _20051_/D _20051_/RB VDD VSS DFFRQX1
X_09861_ _09928_/C _09861_/B VDD VSS _09862_/C NOR2X1
Xclkbuf_1_1__f__09184_ clkbuf_0__09184_/Y VDD VSS _18503_/CK BUFX12
XFILLER_140_783 VSS VDD FILLER2
XFILLER_86_826 VDD VSS FILLER4
X_09792_ _18454_/Q VDD VSS _20179_/A INVX1
XFILLER_27_926 VDD VSS FILLER4
XFILLER_38_263 VDD VSS FILLER1
XFILLER_39_775 VDD VSS FILLER1
XFILLER_85_369 VSS VDD FILLER2
XFILLER_26_436 VDD VSS FILLER1
XFILLER_27_948 VSS VDD FILLER2
XFILLER_53_222 VDD VSS DECAPHV8
XFILLER_54_756 VDD VSS FILLER1
XTAP_TAPCELL_ROW_127_1286 VDD VSS WELLTAP
XFILLER_26_49 VDD VSS DECAPHV8
XTAP_TAPCELL_ROW_140_1420 VDD VSS WELLTAP
XFILLER_41_417 VSS VDD FILLER2
XFILLER_22_642 VDD VSS DECAPHV8
XFILLER_34_480 VDD VSS DECAPHV8
XFILLER_10_826 VDD VSS DECAPHV16
XFILLER_139_316 VDD VSS FILLER1
X_09226_ _18500_/D VDD VSS _18372_/D INVX1
XFILLER_139_349 VDD VSS FILLER1
XFILLER_108_747 VSS VDD FILLER2
XTAP_TAPCELL_ROW_138_1393 VDD VSS WELLTAP
XFILLER_135_577 VDD VSS FILLER4
XFILLER_104_931 VDD VSS FILLER4
XFILLER_107_41 VDD VSS FILLER1
XFILLER_122_216 VDD VSS DECAPHV8
XFILLER_123_739 VDD VSS FILLER4
XFILLER_89_620 VDD VSS FILLER1
X_11050_ _10912_/Y _11049_/Y _11118_/A VDD VSS _11050_/Y MUXI2X1
XFILLER_103_463 VSS VDD FILLER2
XFILLER_103_474 VDD VSS DECAPHV16
XFILLER_107_96 VDD VSS DECAPHV8
XFILLER_67_45 VDD VSS FILLER4
XFILLER_76_303 VDD VSS FILLER4
XFILLER_88_163 VDD VSS DECAPHV8
X_10001_ _09986_/Y _10000_/Y _11178_/C VDD VSS _10001_/Y MUX2X1
X_20179_ _20179_/A VDD VSS _20179_/Y BUFX3
XFILLER_29_252 VSS VDD FILLER2
XTAP_TAPCELL_ROW_87_887 VDD VSS WELLTAP
X_14740_ _19500_/Q _15893_/B VDD VSS _14746_/C NOR2BX1
XFILLER_44_200 VSS VDD FILLER2
XFILLER_44_222 VSS VDD FILLER2
XFILLER_84_380 VSS VDD FILLER2
X_11952_ _19064_/Q VDD VSS _11959_/A INVX1
XFILLER_33_929 VDD VSS FILLER1
XFILLER_44_244 VDD VSS FILLER4
XFILLER_45_778 VDD VSS DECAPHV16
X_10903_ _18700_/Q _18754_/Q _10903_/C VDD VSS _10940_/A MIN3X1
X_11883_ _19231_/Q _14525_/B VDD VSS _11884_/D _14525_/C NAND3X1
X_14671_ _14671_/A _14671_/B _14671_/C VDD VSS _15827_/B XNOR3X1
XFILLER_16_60 VDD VSS FILLER4
XFILLER_44_266 VDD VSS FILLER1
XFILLER_60_737 VDD VSS FILLER1
X_10834_ _18645_/Q _18807_/Q VDD VSS _10836_/C XNOR2X1
X_13622_ _13623_/A _13623_/B _13623_/D _13623_/C VDD VSS _13716_/B OAOI211X1
X_17390_ _17390_/A _17390_/B VDD VSS _19836_/D NOR2X1
X_16410_ _19726_/Q _16890_/B VDD VSS _16414_/B XOR2X1
XTAP_TAPCELL_ROW_42_434 VDD VSS WELLTAP
X_13553_ _19223_/Q _14516_/B VDD VSS _13554_/D AND2X1
X_16341_ _16368_/A _16368_/B VDD VSS _16746_/B XNOR2X1
XFILLER_40_461 VDD VSS FILLER4
XTAP_TAPCELL_ROW_14_158 VDD VSS WELLTAP
X_10765_ _10765_/A _10765_/B _10765_/C _10765_/D VDD VSS _10794_/A OAI31X1
X_12504_ _19157_/Q _12504_/B _14440_/C VDD VSS _12643_/B XNOR3X1
X_19060_ _19115_/CK _19060_/D _19060_/Q VDD VSS DFFQX1
XFILLER_139_861 VDD VSS FILLER4
X_10696_ _11226_/A _10696_/B _10696_/C _10696_/D VDD VSS _10733_/B OAI211X1
X_13484_ _13492_/A _13578_/D VDD VSS _13575_/B XNOR2X1
X_16272_ _16274_/A _16274_/B VDD VSS _16302_/B NOR2X1
XTAP_TAPCELL_ROW_3_41 VDD VSS WELLTAP
X_12435_ _18932_/Q VDD VSS _12438_/A INVX1
X_18011_ _18011_/A VDD VSS _18049_/D BUFX3
X_15223_ _15223_/A _15223_/B _15223_/C VDD VSS _15262_/A OAI21X1
XFILLER_66_8 VSS VDD FILLER2
X_12366_ _12512_/B _12366_/B _12366_/C _12366_/D VDD VSS _12517_/B AOAI211X1
X_15154_ _15154_/A VDD VSS _15155_/D INVX1
XFILLER_113_205 VSS VDD FILLER2
X_11317_ _11370_/A _11317_/B VDD VSS _11318_/B NOR2X1
X_14105_ _18899_/Q _14142_/B VDD VSS _17978_/B XNOR2X1
XFILLER_141_525 VDD VSS FILLER4
X_12297_ wire159/Y _12298_/B _12298_/D _12298_/C VDD VSS _14375_/B OAOI211X1
X_19962_ _19963_/CK _19962_/D _19962_/Q VDD VSS DFFQX1
X_15085_ _15112_/A _15085_/B VDD VSS _15838_/B XNOR2X1
X_11248_ _18579_/Q _11252_/B VDD VSS _11253_/C XNOR2X1
X_14036_ _14036_/A _14036_/B _14036_/C _14036_/D VDD VSS _14202_/C OAOI211X1
X_19893_ clkload8/A _19893_/D _19893_/Q VDD VSS DFFQX1
X_18913_ _18936_/CK _18913_/D _18913_/Q VDD VSS DFFQX1
XFILLER_122_783 VSS VDD FILLER2
XFILLER_95_612 VSS VDD FILLER2
X_11179_ _11179_/A _11179_/B VDD VSS _11179_/Y NAND2X1
X_18844_ _19963_/CK _18844_/D _18844_/Q VDD VSS DFFQX1
XFILLER_67_336 VSS VDD FILLER2
XFILLER_94_122 VSS VDD FILLER2
XFILLER_76_881 VSS VDD FILLER2
X_18775_ _18828_/CK _18775_/D _18775_/Q VDD VSS DFFQX1
X_15987_ _19678_/Q _16837_/B _16010_/B VDD VSS _16030_/A MIN3X1
XFILLER_63_531 VDD VSS FILLER4
XFILLER_75_391 VDD VSS DECAPHV8
X_17726_ _19907_/Q _19875_/Q _17726_/C VDD VSS _17730_/B MIN3X1
X_14938_ _15805_/B _15805_/C _19422_/Q VDD VSS _14956_/C AOI21X1
XFILLER_63_542 VSS VDD FILLER2
X_17657_ _17803_/B _17657_/B _17657_/C VDD VSS _17663_/C MIN3X1
X_14869_ _19476_/Q _15867_/B VDD VSS _14920_/A NOR2BX1
XFILLER_91_884 VSS VDD FILLER2
X_16608_ _19638_/Q _16792_/B VDD VSS _16622_/B XOR2X1
X_19327_ _19358_/CK _19327_/D _19327_/Q VDD VSS DFFQX1
X_17588_ _17589_/A _17589_/B _17589_/D _17589_/C VDD VSS _17591_/C AOI211X1
X_16539_ _19731_/Q _16896_/B VDD VSS _16543_/B XNOR2X1
X_19258_ _19999_/CK _19258_/D _19258_/Q VDD VSS DFFQX1
XFILLER_117_500 VDD VSS FILLER4
XFILLER_117_511 VDD VSS FILLER1
X_19189_ _19250_/CK _19189_/D _19189_/Q VDD VSS DFFQX1
XFILLER_128_29 VDD VSS FILLER1
XFILLER_144_330 VDD VSS FILLER1
XFILLER_105_728 VDD VSS FILLER1
XFILLER_132_503 VDD VSS FILLER1
XFILLER_144_363 VSS VDD FILLER2
XFILLER_132_514 VDD VSS DECAPHV8
XFILLER_104_249 VDD VSS FILLER1
XFILLER_132_569 VDD VSS DECAPHV16
X_09913_ _09928_/C _09939_/B _09913_/C VDD VSS _10004_/B OAI21X1
X_20102_ _20102_/A VDD VSS _20102_/Y BUFX3
XFILLER_59_815 VDD VSS DECAPHV8
XFILLER_86_612 VDD VSS DECAPHV8
XTAP_TAPCELL_ROW_129_1304 VDD VSS WELLTAP
X_09844_ _18568_/Q _10686_/D VDD VSS _09880_/B XNOR2X1
X_20033_ _20043_/CK _20033_/D _20033_/Q _20043_/RB VDD VSS DFFRQX1
Xclkbuf_1_1__f__09167_ clkbuf_0__09167_/Y VDD VSS _18407_/CK BUFX12
XFILLER_112_293 VDD VSS DECAPHV16
XFILLER_140_580 VDD VSS FILLER4
XFILLER_86_634 VDD VSS FILLER4
XFILLER_39_550 VSS VDD FILLER2
X_09775_ _09791_/A _20193_/A _09775_/C _09813_/C VDD VSS _09776_/D AOAI211X1
XFILLER_100_488 VDD VSS FILLER4
XFILLER_54_520 VDD VSS FILLER4
XFILLER_27_767 VDD VSS FILLER1
XFILLER_54_553 VSS VDD FILLER2
XTAP_TAPCELL_ROW_84_857 VDD VSS WELLTAP
XFILLER_14_417 VDD VSS FILLER1
XFILLER_15_929 VDD VSS FILLER1
XFILLER_26_266 VDD VSS FILLER1
XFILLER_54_586 VDD VSS FILLER4
XFILLER_81_361 VDD VSS FILLER4
XFILLER_50_770 VDD VSS FILLER4
XTAP_TAPCELL_ROW_11_128 VDD VSS WELLTAP
X_10550_ _10550_/A VDD VSS _11267_/A BUFX3
XFILLER_6_616 VDD VSS DECAPHV32
X_09209_ _18510_/Q VDD VSS _18425_/D INVX1
X_10481_ _18635_/Q _18797_/Q _10481_/C _10481_/D VDD VSS _10483_/C AOAI211X1
X_12220_ _12382_/A _12382_/B VDD VSS _12373_/B NAND2X1
XFILLER_135_363 VDD VSS FILLER4
XFILLER_136_886 VDD VSS DECAPHV16
XFILLER_123_514 VDD VSS FILLER1
X_12151_ _12160_/A _14465_/B _12160_/C VDD VSS _14466_/C OR3X2
XFILLER_123_569 VDD VSS FILLER1
XFILLER_78_44 VSS VDD FILLER2
X_11102_ _18706_/Q _18760_/Q _11102_/C VDD VSS _11146_/C AO21X2
X_12082_ _19122_/Q _12087_/A _14401_/B VDD VSS _14371_/B XNOR3X1
XFILLER_77_623 VDD VSS DECAPHV16
X_11033_ _18677_/Q _18785_/Q _11033_/C VDD VSS _11067_/C AO21X2
X_15910_ _16100_/A _15910_/B VDD VSS _19515_/D NOR2X1
XFILLER_103_282 VDD VSS FILLER4
XFILLER_134_61 VSS VDD FILLER2
XFILLER_49_347 VDD VSS FILLER4
X_16890_ _16891_/A _16890_/B VDD VSS _19726_/D NOR2X1
XFILLER_134_94 VDD VSS FILLER4
XFILLER_49_358 VSS VDD FILLER2
XFILLER_65_829 VSS VDD FILLER2
X_15841_ _17010_/A _15841_/B _15841_/C VDD VSS _19455_/D NOR3X1
XFILLER_18_712 VSS VDD FILLER2
XFILLER_94_65 VDD VSS FILLER4
XTAP_TAPCELL_ROW_19_206 VDD VSS WELLTAP
X_12984_ _12992_/A _12992_/B _12989_/C VDD VSS _14154_/B XNOR3X1
X_18560_ _18565_/CK _18560_/D _18560_/Q VDD VSS DFFQX1
X_15772_ _16795_/A VDD VSS _15793_/A BUFX3
XFILLER_73_840 VDD VSS DECAPHV8
XFILLER_94_98 VSS VDD FILLER2
X_11935_ _19233_/Q _11988_/A _12055_/B VDD VSS _12048_/D XNOR3X1
X_18491_ _18494_/CK _18512_/Q _20104_/A _18492_/RB VDD VSS DFFRQX1
X_17511_ _19862_/Q _19830_/Q VDD VSS _17517_/A XNOR2X1
X_14723_ _19333_/Q _15705_/B VDD VSS _14724_/B XNOR2X1
XFILLER_17_277 VSS VDD FILLER2
XFILLER_17_288 VDD VSS FILLER1
XFILLER_27_92 VDD VSS FILLER1
XFILLER_73_884 VSS VDD FILLER2
XTAP_TAPCELL_ROW_55_570 VDD VSS WELLTAP
X_14654_ _19498_/Q _15891_/B VDD VSS _14676_/D XOR2X1
X_17442_ _19847_/Q _19815_/Q VDD VSS _17444_/B XOR2X1
XFILLER_60_556 VDD VSS FILLER1
XTAP_TAPCELL_ROW_27_283 VDD VSS WELLTAP
X_11866_ _11967_/B _11866_/B VDD VSS _11867_/C XNOR2X1
X_13605_ _19028_/Q _13837_/A _13610_/B VDD VSS _13607_/C XNOR3X1
X_10817_ _11263_/A _10853_/A VDD VSS _10846_/A NOR2X1
X_11797_ _11797_/A _11797_/B _11797_/C _11851_/B VDD VSS _11830_/B OAOI211X1
X_14585_ _19520_/Q _19519_/Q VDD VSS _15887_/B _19521_/Q NAND3X1
X_17373_ _19831_/Q _19799_/Q _17373_/C VDD VSS _17377_/B MIN3X1
X_10748_ _19949_/Q _18831_/Q VDD VSS _10749_/A NAND2X1
X_13536_ _13728_/A _13728_/B VDD VSS _13565_/B NOR2X1
X_19112_ _19196_/CK _19112_/D _19112_/Q VDD VSS DFFQX1
X_16324_ _19691_/Q _16852_/B VDD VSS _16326_/C XNOR2X1
XFILLER_118_319 VDD VSS FILLER4
X_13467_ _13557_/A _13557_/C VDD VSS _13468_/C NOR2X1
X_19043_ _19045_/CK _19043_/D _19043_/Q VDD VSS DFFQX1
X_16255_ _16255_/A _16255_/B _16778_/B VDD VSS _16264_/A MIN3X1
XFILLER_127_853 VDD VSS FILLER4
X_10679_ _10679_/A _10679_/B VDD VSS _10696_/B XOR2X1
X_12418_ _19100_/Q _12593_/A _12456_/C VDD VSS _12544_/D XNOR3X1
X_15206_ _15206_/A _15225_/B VDD VSS _15779_/A XNOR2X1
XFILLER_142_801 VSS VDD FILLER2
X_13398_ _14221_/A _14221_/B _14221_/C VDD VSS _13400_/B OAI21X1
X_16186_ _16208_/A _16208_/B VDD VSS _16740_/B XNOR2X1
XFILLER_141_322 VDD VSS FILLER4
X_12349_ _12349_/A _12349_/B _14114_/B VDD VSS _12352_/B MIN3X1
X_15137_ _15137_/A _15137_/B _15137_/C VDD VSS _15178_/A OAI21X1
XTAP_TAPCELL_ROW_113_1149 VDD VSS WELLTAP
X_19945_ _19949_/CK _19945_/D _19945_/Q VDD VSS DFFQX1
X_15068_ _15069_/A _15069_/B _15069_/C VDD VSS _15776_/B AOI21X1
XFILLER_96_910 VSS VDD FILLER2
X_14019_ _14019_/A _14169_/B _14169_/C VDD VSS _14020_/D NOR3X1
XFILLER_67_122 VDD VSS FILLER1
X_19876_ _19907_/CK _19876_/D _19876_/Q VDD VSS DFFQX1
X_18827_ _19947_/CK _18827_/D _18827_/Q VDD VSS DFFQX1
XFILLER_83_637 VSS VDD FILLER2
X_09560_ _09630_/C _09578_/B VDD VSS _09815_/C NOR2X2
X_18758_ _18785_/CK _18758_/D _18758_/Q VDD VSS DFFQX1
X_09491_ _18442_/D _09501_/B _09491_/C VDD VSS _18239_/D AOI21X1
X_17709_ _19904_/Q _19872_/Q VDD VSS _17711_/B XNOR2X1
XTAP_TAPCELL_ROW_124_1256 VDD VSS WELLTAP
XTAP_TAPCELL_ROW_81_827 VDD VSS WELLTAP
X_18689_ _18797_/CK _18689_/D _18689_/Q VDD VSS DFFQX1
XFILLER_51_578 VSS VDD FILLER2
XFILLER_136_138 VDD VSS FILLER1
XTAP_TAPCELL_ROW_135_1363 VDD VSS WELLTAP
XTAP_TAPCELL_ROW_89_905 VDD VSS WELLTAP
XFILLER_58_122 VDD VSS DECAPHV16
XFILLER_98_280 VDD VSS FILLER1
X_09827_ _09907_/A _10247_/A VDD VSS _09828_/A OR2X2
X_20016_ clkload6/A _20016_/D _20016_/Q _20069_/RB VDD VSS DFFRQX1
XFILLER_104_53 VDD VSS FILLER4
XFILLER_46_317 VSS VDD FILLER2
XFILLER_74_637 VDD VSS FILLER4
XTAP_TAPCELL_ROW_97_982 VDD VSS WELLTAP
X_09758_ _18435_/Q _09811_/B _09811_/C _20208_/A _09758_/E VDD VSS _09759_/B AOI221X1
XFILLER_55_840 VDD VSS FILLER4
XFILLER_15_726 VSS VDD FILLER2
X_09689_ _18415_/Q _09696_/B _09787_/B _18351_/Q VDD VSS _09690_/D OAI22X1
X_11720_ _19226_/Q _14519_/B VDD VSS _11745_/C _14519_/C NAND3X1
XFILLER_42_556 VSS VDD FILLER2
XFILLER_80_23 VDD VSS FILLER1
XTAP_TAPCELL_ROW_24_253 VDD VSS WELLTAP
XTAP_TAPCELL_ROW_52_540 VDD VSS WELLTAP
X_11651_ _18791_/Q _11658_/B VDD VSS _18818_/D AND2X1
X_10602_ _19945_/Q _18827_/Q VDD VSS _10633_/A NAND2X1
X_11582_ _18728_/Q _11589_/B VDD VSS _18755_/D AND2X1
X_14370_ _14393_/A _14370_/B VDD VSS _19093_/D NOR2X1
XFILLER_80_78 VDD VSS FILLER1
X_10533_ _10556_/A _10556_/B _10533_/C VDD VSS _10579_/C AO21X2
X_13321_ _19109_/Q _14387_/B VDD VSS _13437_/A NOR2BX1
X_16040_ _19584_/Q _16733_/B VDD VSS _16041_/B XOR2X1
XFILLER_124_801 VDD VSS FILLER4
XFILLER_127_149 VDD VSS DECAPHV8
XFILLER_129_61 VDD VSS FILLER4
X_10464_ _10579_/D _10535_/B _10535_/C _10655_/A VDD VSS _10624_/C AOAI211X1
X_13252_ _13443_/A _13443_/B _13443_/C VDD VSS _13356_/B AOI21X1
XFILLER_136_672 VDD VSS FILLER1
XFILLER_89_76 VDD VSS FILLER1
X_10395_ _10581_/A _10395_/B VDD VSS _10499_/A _10395_/C _10395_/D NAND4X2
X_12203_ _19041_/Q _12203_/B _12203_/C VDD VSS _12513_/B MIN3X1
X_13183_ _13183_/A _14124_/B _13183_/C VDD VSS _13184_/B MIN3X1
XFILLER_124_878 VDD VSS FILLER4
XFILLER_135_182 VDD VSS FILLER4
XFILLER_97_718 VDD VSS DECAPHV8
XTAP_TAPCELL_ROW_0_20 VDD VSS WELLTAP
X_12134_ _19012_/Q _12134_/B _12134_/C VDD VSS _14244_/A MIN3X1
XFILLER_111_506 VSS VDD FILLER2
X_19730_ _19730_/CK _19730_/D _19730_/Q VDD VSS DFFQX1
X_17991_ _18528_/Q _18527_/Q _18529_/Q _18530_/Q VDD VSS _18020_/B AND4X2
XFILLER_77_431 VSS VDD FILLER2
X_12065_ _12285_/A _12285_/B _12077_/C VDD VSS _14274_/B XNOR3X1
X_16942_ _19744_/Q _17049_/B VDD VSS _16945_/A XNOR2X1
XFILLER_37_306 VSS VDD FILLER2
XFILLER_77_442 VDD VSS FILLER1
XFILLER_77_464 VDD VSS FILLER1
X_11016_ _10946_/Y _11015_/Y _10947_/Y VDD VSS _11016_/Y MUXI2X1
X_19661_ _19696_/CK _19661_/D _19661_/Q VDD VSS DFFQX1
X_16873_ _16876_/A _16873_/B VDD VSS _19710_/D NOR2X1
XFILLER_37_328 VDD VSS FILLER4
XFILLER_64_103 VDD VSS FILLER4
XFILLER_65_648 VSS VDD FILLER2
XFILLER_92_434 VDD VSS FILLER4
X_19592_ _19673_/CK _19592_/D _19592_/Q VDD VSS DFFQX1
X_18612_ _18622_/CK _18612_/D _18612_/Q VDD VSS DFFQX1
X_15824_ _15830_/A _15824_/B VDD VSS _19439_/D NOR2X1
XFILLER_18_542 VDD VSS FILLER4
XFILLER_46_862 VDD VSS DECAPHV16
XFILLER_64_158 VDD VSS DECAPHV8
XFILLER_80_607 VDD VSS FILLER1
X_18543_ _18543_/CK _18543_/D _18543_/Q VDD VSS DFFQX1
XFILLER_33_501 VDD VSS DECAPHV8
X_12967_ _14538_/A _14538_/B _12967_/C VDD VSS _12968_/E AO21X2
X_15755_ _15758_/A _15755_/B VDD VSS _19378_/D NOR2X1
XFILLER_73_692 VDD VSS DECAPHV8
X_11918_ _11918_/A _11918_/B _11918_/C _11918_/D VDD VSS _14462_/C OA211X2
X_12898_ _14286_/B _14286_/C _12899_/A VDD VSS _12900_/C OAI21X1
X_18474_ _18479_/CK _18474_/D _20119_/A _20078_/RB VDD VSS DFFRQX1
X_15686_ _15706_/A _15686_/B VDD VSS _19315_/D AND2X1
X_14706_ _14739_/A _14739_/B _14739_/C VDD VSS _14708_/B AOI21X1
X_11849_ _19146_/Q VDD VSS _11854_/A INVX1
X_14637_ _19441_/Q VDD VSS _14639_/A INVX1
X_17425_ _17427_/C _17425_/B _17425_/C VDD VSS _19843_/D AOI21X1
XFILLER_20_239 VDD VSS FILLER1
X_14568_ _20007_/Q _14569_/B VDD VSS _19271_/D AND2X1
X_17356_ _19828_/Q VDD VSS _17507_/B INVX1
XFILLER_119_617 VDD VSS FILLER1
XFILLER_9_240 VDD VSS DECAPHV16
X_16307_ _16299_/A _16307_/B VDD VSS _16326_/B NAND2BX1
XFILLER_118_138 VDD VSS FILLER1
X_13519_ _14226_/A wire155/Y VDD VSS _13568_/B NOR2X1
X_14499_ _14491_/Y _14499_/B _14499_/C VDD VSS _19208_/D AND3BX1
Xclkload10 _19863_/CK VDD VSS clkload10/Y INVX1
X_17287_ _19814_/Q _19782_/Q VDD VSS _17289_/D XNOR2X1
XFILLER_127_650 VDD VSS FILLER1
Xclkload43 _20008_/CK VDD VSS clkload43/Y INVX2
Xclkload32 _18773_/CK VDD VSS clkload32/Y INVX4
Xclkload21 _19957_/CK VDD VSS clkload21/Y BUFX12
X_19026_ _19064_/CK _19026_/D _19026_/Q VDD VSS DFFQX1
X_16238_ _19592_/Q _16742_/B VDD VSS _16239_/B XOR2X1
Xclkbuf_leaf_19__000_ clkload79/A VDD VSS _19604_/CK BUFX12
Xclkload87 _19337_/CK VDD VSS clkload87/Y INVX2
Xclkload76 _19085_/CK VDD VSS clkload76/Y INVX1
Xclkload65 _19988_/CK VDD VSS clkload65/Y INVX1
Xclkload54 _19037_/CK VDD VSS clkload54/Y INVX1
X_16169_ _16175_/B _16169_/B VDD VSS _16881_/B XNOR2X1
XFILLER_114_333 VDD VSS DECAPHV32
XFILLER_115_856 VSS VDD FILLER2
XFILLER_142_642 VDD VSS FILLER1
XFILLER_48_0 VSS VDD FILLER2
Xclkload98 _19736_/CK VDD VSS clkload98/Y BUFX12
XFILLER_114_377 VDD VSS DECAPHV16
X_19928_ _19928_/CK _19928_/D _19928_/Q VDD VSS DFFQX1
XFILLER_68_442 VDD VSS FILLER1
XFILLER_96_773 VDD VSS FILLER1
X_19859_ _19892_/CK _19859_/D _19859_/Q VDD VSS DFFQX1
XFILLER_18_39 VDD VSS FILLER4
X_09612_ _18239_/Q _09818_/B _09612_/C _09791_/A _09612_/E VDD VSS _09618_/A AOI221X1
XTAP_TAPCELL_ROW_94_952 VDD VSS WELLTAP
X_09543_ _20037_/Q _09547_/B VDD VSS _20038_/D NOR2BX1
XFILLER_37_895 VDD VSS FILLER1
XFILLER_70_117 VSS VDD FILLER2
XTAP_TAPCELL_ROW_66_676 VDD VSS WELLTAP
X_09474_ _19976_/Q _09490_/B _09476_/C VDD VSS _09475_/C AOI21X1
XFILLER_12_729 VDD VSS FILLER1
XFILLER_34_49 VDD VSS DECAPHV8
XFILLER_52_876 VDD VSS FILLER4
XFILLER_51_375 VSS VDD FILLER2
XFILLER_20_751 VDD VSS FILLER4
XFILLER_50_15 VDD VSS DECAPHV16
XTAP_TAPCELL_ROW_21_223 VDD VSS WELLTAP
Xclkload4 clkload4/A VDD VSS clkload4/Y BUFX12
XFILLER_20_784 VSS VDD FILLER2
XFILLER_106_801 VDD VSS FILLER1
XFILLER_105_333 VSS VDD FILLER2
XFILLER_133_631 VSS VDD FILLER2
XFILLER_79_718 VSS VDD FILLER2
X_10180_ _10180_/A _11421_/C VDD VSS _18543_/D NOR2X1
XFILLER_120_369 VSS VDD FILLER2
XFILLER_59_442 VSS VDD FILLER2
XFILLER_59_464 VDD VSS FILLER1
XFILLER_101_561 VDD VSS FILLER4
XFILLER_101_572 VDD VSS DECAPHV8
XFILLER_74_412 VSS VDD FILLER2
XFILLER_75_23 VDD VSS DECAPHV16
XFILLER_86_283 VSS VDD FILLER2
XTAP_TAPCELL_ROW_29_301 VDD VSS WELLTAP
X_13870_ _14131_/B _14131_/C _18890_/Q VDD VSS _13872_/C AOI21X1
XFILLER_46_158 VDD VSS FILLER1
XFILLER_62_607 VDD VSS FILLER4
XFILLER_75_78 VDD VSS DECAPHV8
X_12821_ _12821_/A _12821_/B _12821_/C _12821_/D VDD VSS _13017_/A OAOI211X1
XFILLER_90_927 VSS VDD FILLER2
XFILLER_90_949 VDD VSS FILLER1
XFILLER_55_692 VDD VSS FILLER4
X_12752_ _14508_/B _12841_/C _19215_/Q VDD VSS _12827_/C AND3BX1
X_15540_ _15540_/A _15757_/B VDD VSS _15541_/D OR2X2
XFILLER_15_556 VSS VDD FILLER2
X_11703_ _19988_/Q _19252_/Q VDD VSS _11706_/B NOR2X1
X_12683_ _12683_/A _14472_/B _12683_/C _12683_/D VDD VSS _12827_/B AOAI211X1
X_15471_ _15471_/A _15471_/B _15883_/B VDD VSS _15512_/B MIN3X1
XFILLER_42_375 VSS VDD FILLER2
X_11634_ _18776_/Q _11635_/B VDD VSS _18803_/D AND2X1
X_14422_ _14421_/Y _14422_/B _14422_/C VDD VSS _19140_/D AND3BX1
X_17210_ _17212_/C _17211_/B _17229_/C VDD VSS _17211_/C OAI21X1
XFILLER_128_403 VSS VDD FILLER2
XFILLER_129_915 VDD VSS DECAPHV8
XFILLER_7_700 VSS VDD FILLER2
X_18190_ _18190_/A VDD VSS _18191_/B INVX1
X_11565_ _18713_/Q _11567_/B VDD VSS _18740_/D AND2X1
X_14353_ _14316_/Y _14353_/B _14353_/C VDD VSS _19079_/D AND3BX1
X_17141_ _17142_/C _17469_/B _17141_/C VDD VSS _19782_/D AND3BX1
XFILLER_10_283 VSS VDD FILLER2
XFILLER_6_243 VDD VSS FILLER4
X_10516_ _10570_/A _10516_/B VDD VSS _10518_/B XNOR2X1
X_11496_ _18651_/Q _11496_/B VDD VSS _18678_/D AND2X1
X_13304_ _13391_/A _13391_/B _13391_/C VDD VSS _13377_/B AOI21X1
X_14284_ _14255_/Y _14284_/B _14284_/C VDD VSS _19018_/D AND3BX1
X_17072_ _19768_/Q _17073_/B VDD VSS _17075_/A XNOR2X1
XFILLER_108_160 VDD VSS FILLER4
X_10447_ _10448_/A _10448_/B _10448_/D _10448_/C VDD VSS _10530_/B AOAI211X1
X_13235_ _13355_/A _14448_/B VDD VSS _13354_/A NOR2X1
X_16023_ _19708_/Q _16871_/B _16023_/C VDD VSS _16024_/C MIN3X1
XFILLER_112_815 VSS VDD FILLER2
XTAP_TAPCELL_ROW_110_1119 VDD VSS WELLTAP
X_10378_ _18660_/Q _18768_/Q VDD VSS _10406_/C NOR2X1
X_13166_ _19024_/Q _13201_/B _13208_/C VDD VSS _13195_/B XNOR3X1
XFILLER_112_837 VDD VSS DECAPHV8
XFILLER_123_185 VDD VSS FILLER1
X_12117_ _19152_/Q _12214_/A _12214_/B VDD VSS _12147_/D XNOR3X1
X_13097_ _13097_/A _13097_/B _13097_/C _13097_/D VDD VSS _13373_/A OAOI211X2
X_17974_ _17975_/B _17975_/C _17975_/A VDD VSS _17976_/C OAI21X1
XFILLER_111_358 VDD VSS FILLER1
XFILLER_77_250 VSS VDD FILLER2
X_12048_ _12048_/A _12048_/B _12048_/C _12048_/D VDD VSS _14494_/B AOAI211X1
X_19713_ _19716_/CK _19713_/D _19713_/Q VDD VSS DFFQX1
X_16925_ _16928_/A _16928_/B _17081_/C VDD VSS _16926_/C OAI21X1
X_19644_ _19678_/CK _19644_/D _19644_/Q VDD VSS DFFQX1
XFILLER_19_840 VDD VSS FILLER1
XFILLER_81_905 VDD VSS FILLER4
XFILLER_93_765 VDD VSS DECAPHV8
X_16856_ _16859_/A _16856_/B VDD VSS _19695_/D AND2X1
XFILLER_37_169 VDD VSS FILLER1
XFILLER_92_253 VDD VSS FILLER1
XTAP_TAPCELL_ROW_91_922 VDD VSS WELLTAP
X_13999_ _14232_/B _14232_/C _18977_/Q VDD VSS _14001_/C AOI21X1
X_19575_ _19606_/CK _19575_/D _19575_/Q VDD VSS DFFQX1
X_16787_ _16794_/A _16787_/B VDD VSS _19633_/D NOR2X1
X_15807_ _15816_/A _15807_/B VDD VSS _19424_/D NOR2X1
XFILLER_46_681 VDD VSS FILLER1
XTAP_TAPCELL_ROW_63_646 VDD VSS WELLTAP
X_18526_ _18526_/CK _18526_/D _18526_/Q _09295_/Y VDD VSS DFFRQX1
X_15738_ _15743_/A _15738_/B VDD VSS _19363_/D AND2X1
XTAP_TAPCELL_ROW_121_1226 VDD VSS WELLTAP
X_18457_ _18471_/CK _18457_/D _18457_/Q _18471_/RB VDD VSS DFFRQX1
XFILLER_33_375 VDD VSS DECAPHV16
X_17408_ _19839_/Q _19807_/Q _17408_/C VDD VSS _17413_/C AOI21X1
X_15669_ _15672_/A _18190_/A VDD VSS _19303_/D NOR2X1
X_09190_ _18470_/D VDD VSS _18454_/D INVX1
X_18388_ _18391_/CK _18521_/Q _20193_/A _18444_/RB VDD VSS DFFRQX1
X_17339_ _19825_/Q _19793_/Q VDD VSS _17346_/C NOR2X1
XFILLER_135_907 VDD VSS FILLER1
Xclkload121 _18494_/CK VDD VSS clkload121/Y INVX2
Xclkload110 _18550_/CK VDD VSS clkload110/Y INVX2
Xclkload132 _18453_/CK VDD VSS clkload132/Y INVX2
X_19009_ _19037_/CK _19009_/D _19009_/Q VDD VSS DFFQX1
XTAP_TAPCELL_ROW_132_1333 VDD VSS WELLTAP
XFILLER_103_815 VSS VDD FILLER2
XFILLER_130_601 VSS VDD FILLER2
XFILLER_114_185 VDD VSS FILLER1
XFILLER_130_667 VDD VSS FILLER4
XFILLER_130_689 VSS VDD FILLER2
XFILLER_96_581 VDD VSS FILLER1
XFILLER_44_607 VSS VDD FILLER2
XFILLER_44_629 VDD VSS DECAPHV8
XFILLER_45_26 VDD VSS FILLER4
XFILLER_45_48 VSS VDD FILLER2
X_09526_ _20021_/Q _09526_/B _20022_/Q VDD VSS _09527_/C AOI21X1
XFILLER_101_32 VDD VSS DECAPHV8
XFILLER_25_865 VDD VSS DECAPHV8
X_09457_ _19968_/Q _09467_/B _09476_/C VDD VSS _09458_/C AOI21X1
XFILLER_40_824 VDD VSS DECAPHV8
XFILLER_52_673 VDD VSS FILLER1
XFILLER_101_87 VDD VSS FILLER4
X_09388_ _19930_/Q _19931_/Q _19933_/Q VDD VSS _09389_/C OR3X2
XFILLER_138_723 VDD VSS FILLER4
XFILLER_124_4 VSS VDD FILLER2
XFILLER_20_592 VDD VSS FILLER1
X_11350_ _11357_/A _11358_/B VDD VSS _11355_/B XNOR2X1
XFILLER_125_428 VSS VDD FILLER2
XFILLER_138_789 VDD VSS FILLER1
X_10301_ _10314_/C _11430_/B VDD VSS _10304_/B NOR2X1
XFILLER_4_758 VDD VSS DECAPHV8
X_11281_ _18582_/Q _11284_/B VDD VSS _11285_/B XNOR2X1
X_13020_ _13020_/A _14352_/B _14352_/C VDD VSS _13021_/D NOR3X1
XFILLER_105_152 VDD VSS FILLER4
XFILLER_106_686 VDD VSS FILLER4
XFILLER_3_257 VSS VDD FILLER2
X_10232_ _10167_/Y _10231_/Y _10224_/A VDD VSS _10233_/B MUXI2X1
XFILLER_126_73 VDD VSS DECAPHV16
X_10163_ _18589_/Q _18590_/Q VDD VSS _10203_/B _10163_/C NAND3X1
Xclkbuf_regs_0_clk delaybuf_7_clk/Y VDD VSS clkbuf_regs_0_clk/Y BUFX12
XFILLER_120_122 VDD VSS FILLER1
XFILLER_121_678 VDD VSS FILLER1
XFILLER_66_209 VDD VSS FILLER4
XFILLER_47_412 VDD VSS FILLER4
X_10094_ _09993_/B _10182_/B _10131_/A VDD VSS _10101_/B MUXI2X1
X_16710_ _16710_/A _16724_/B VDD VSS _19563_/D NOR2X1
X_14971_ _19506_/Q _15900_/B VDD VSS _15013_/B NAND2BX1
XFILLER_74_231 VDD VSS FILLER1
XFILLER_87_592 VDD VSS FILLER4
X_13922_ _14001_/B _13923_/C _18948_/Q VDD VSS _13924_/C AOI21X1
X_17690_ _17692_/B _17690_/B VDD VSS _17691_/B XOR2X1
XFILLER_28_670 VSS VDD FILLER2
XFILLER_35_629 VDD VSS FILLER4
X_13853_ _19115_/Q VDD VSS _13854_/A INVX1
X_16641_ _16643_/A _16643_/B _16643_/C _16641_/D VDD VSS _19543_/D OAOI211X1
XFILLER_90_746 VSS VDD FILLER2
X_12804_ _12804_/A _12804_/B _12804_/C _12804_/D VDD VSS _14348_/B AOAI211X1
X_19360_ _19362_/CK _19360_/D _19360_/Q VDD VSS DFFQX1
Xclkbuf_leaf_18__001_ clkbuf_2_3__f__001_/Y VDD VSS _18917_/CK BUFX12
X_16572_ _19604_/Q _16572_/B _16755_/B VDD VSS _16578_/A MIN3X1
XFILLER_90_768 VDD VSS FILLER1
XTAP_TAPCELL_ROW_107_1081 VDD VSS WELLTAP
X_10996_ _10996_/A _10996_/B _11263_/A VDD VSS _11020_/A AOI21X1
X_13784_ _13857_/A _13784_/B VDD VSS _14362_/B XNOR2X1
X_18311_ _18311_/CK _18471_/D _18311_/Q _18471_/RB VDD VSS DFFRQX1
X_15523_ _15545_/A _15545_/B VDD VSS _15789_/B XNOR2X1
XTAP_TAPCELL_ROW_60_616 VDD VSS WELLTAP
X_12735_ _12821_/A _12821_/B VDD VSS _12776_/B NOR2X1
X_19291_ _19304_/CK _19291_/D _19291_/Q VDD VSS DFFQX1
XFILLER_31_868 VSS VDD FILLER2
XTAP_TAPCELL_ROW_6_74 VDD VSS WELLTAP
X_12666_ _12666_/A _12678_/C VDD VSS _14536_/B XNOR2X1
X_18242_ _18255_/CK _18242_/D _18275_/D _20080_/RB VDD VSS DFFRQX1
X_15454_ _15464_/A _15464_/B VDD VSS _15724_/B XNOR2X1
XFILLER_128_211 VDD VSS FILLER4
X_11617_ _18760_/Q _11624_/B VDD VSS _18787_/D AND2X1
X_12597_ _19046_/Q _12597_/B _12803_/D VDD VSS _12632_/C XNOR3X1
X_14405_ _14426_/A _14405_/B VDD VSS _19126_/D NOR2X1
X_18173_ _18173_/A _18173_/B VDD VSS _20008_/D NOR2X1
X_15385_ _19320_/Q _15385_/B _15385_/C VDD VSS _15419_/A MIN3X1
XFILLER_144_704 VDD VSS FILLER1
X_11548_ _18697_/Q _11555_/B VDD VSS _18724_/D AND2X1
X_14336_ _14339_/A _14336_/B VDD VSS _19064_/D NOR2X1
X_17124_ _19779_/Q _19747_/Q VDD VSS _17126_/B XOR2X1
XFILLER_143_214 VSS VDD FILLER2
XFILLER_109_491 VSS VDD FILLER2
X_11479_ _18635_/Q _11484_/B VDD VSS _18662_/D AND2X1
X_14267_ _14285_/A _14267_/B VDD VSS _19005_/D NOR2X1
X_17055_ _17064_/C _17059_/C VDD VSS _17056_/B XOR2X1
XFILLER_112_601 VSS VDD FILLER2
X_13218_ _19108_/Q VDD VSS _13219_/A INVX1
X_14198_ _14219_/A _14198_/B _14198_/C VDD VSS _18948_/D NOR3X1
X_16006_ _19711_/Q _16874_/B VDD VSS _16028_/C NOR2X1
XFILLER_112_634 VDD VSS FILLER1
XFILLER_97_323 VDD VSS FILLER4
XFILLER_98_835 VDD VSS FILLER4
X_13149_ _20010_/Q _19274_/Q VDD VSS _13150_/C NOR2X1
XFILLER_78_570 VDD VSS FILLER1
X_17957_ _17957_/A wire152/Y _17957_/C VDD VSS _17958_/D NOR3X1
XFILLER_38_445 VDD VSS FILLER4
XFILLER_65_220 VDD VSS FILLER4
X_17888_ _17891_/C _17888_/B _17888_/C VDD VSS _19945_/D AOI21X1
X_16908_ _16907_/Y _20015_/Q _16908_/C VDD VSS _16909_/C AND3BX1
XFILLER_65_275 VDD VSS FILLER1
XTAP_TAPCELL_ROW_76_771 VDD VSS WELLTAP
X_19627_ _19636_/CK _19627_/D _19627_/Q VDD VSS DFFQX1
X_16839_ _17391_/A VDD VSS _16865_/A BUFX3
XFILLER_54_949 VDD VSS FILLER1
XTAP_TAPCELL_ROW_48_495 VDD VSS WELLTAP
X_19558_ _19591_/CK _19558_/D _19558_/Q VDD VSS DFFQX1
XFILLER_80_267 VDD VSS DECAPHV16
XFILLER_81_768 VDD VSS DECAPHV8
X_09311_ _18293_/Q _18521_/Q _09299_/Y VDD VSS _09311_/Y MUXI2X1
X_18509_ _18509_/CK _18509_/D _18509_/Q _09349_/Y VDD VSS DFFRQX1
XFILLER_40_109 VDD VSS FILLER4
X_19489_ _19489_/CK _19489_/D _19489_/Q VDD VSS DFFQX1
XFILLER_139_509 VSS VDD FILLER2
XFILLER_21_323 VDD VSS FILLER4
X_09242_ _18524_/Q VDD VSS _18343_/D INVX1
XFILLER_135_704 VDD VSS DECAPHV32
XFILLER_89_813 VSS VDD FILLER2
Xoutput28 _20112_/Y VDD VSS o_bias_cfg[14] BUFX3
Xoutput39 _20122_/Y VDD VSS o_bias_cfg[24] BUFX3
Xoutput17 _20086_/Y VDD VSS o_aux_ctrl[4] BUFX3
XFILLER_102_100 VDD VSS FILLER1
XFILLER_115_472 VDD VSS DECAPHV8
XFILLER_89_879 VDD VSS FILLER4
X_20195_ _20195_/A VDD VSS _20195_/Y BUFX3
XFILLER_130_464 VSS VDD FILLER2
XFILLER_69_581 VDD VSS DECAPHV8
XFILLER_57_732 VDD VSS FILLER1
XFILLER_84_540 VSS VDD FILLER2
XFILLER_17_618 VDD VSS FILLER4
XFILLER_56_253 VDD VSS FILLER4
XFILLER_45_949 VDD VSS FILLER1
XFILLER_56_286 VSS VDD FILLER2
XFILLER_72_724 VDD VSS FILLER1
XFILLER_72_746 VDD VSS FILLER4
XFILLER_84_595 VSS VDD FILLER2
X_10850_ _10885_/A _10851_/D _10851_/A _10851_/B VDD VSS _10852_/B OA211X2
XFILLER_13_802 VDD VSS FILLER4
XFILLER_72_779 VSS VDD FILLER2
X_09509_ _20071_/Q _20070_/Q _20015_/Q VDD VSS _09510_/C OAI21X1
X_10781_ _10814_/A _10784_/B VDD VSS _10782_/B NOR2X1
X_12520_ _12540_/A _12540_/B _12540_/D _12540_/C VDD VSS _12600_/C OAI211X1
X_12451_ _19070_/Q _12451_/B VDD VSS _12452_/C _12451_/C NAND3X1
X_11402_ _11429_/B VDD VSS _17990_/B BUFX3
X_15170_ _15672_/A _18102_/B VDD VSS _19287_/D NOR2X1
X_12382_ _12382_/A _12382_/B _12382_/C _12382_/D VDD VSS _12472_/A AOAI211X1
X_14121_ _14142_/A _14121_/B VDD VSS _18880_/D NOR2X1
XFILLER_21_72 VDD VSS FILLER4
XFILLER_4_533 VSS VDD FILLER2
X_11333_ _11333_/A _11333_/B _11333_/C VDD VSS _11334_/B OAI21X1
XFILLER_97_10 VDD VSS FILLER1
X_11264_ _11264_/A _11264_/B _11264_/C VDD VSS _11276_/A NOR3X1
X_14052_ _14101_/A wire152/Y _17960_/C VDD VSS _17963_/C OR3BX1
XFILLER_106_472 VDD VSS DECAPHV16
XFILLER_4_588 VSS VDD FILLER2
XFILLER_4_599 VDD VSS FILLER4
XFILLER_79_301 VDD VSS DECAPHV8
XFILLER_97_43 VDD VSS FILLER1
X_10215_ _18620_/Q _10219_/B VDD VSS _10217_/D XNOR2X1
X_13003_ _18994_/Q _14256_/B VDD VSS _13004_/D _14256_/C NAND3X1
X_18860_ _18888_/CK _18860_/D _18860_/Q VDD VSS DFFQX1
XFILLER_121_453 VDD VSS FILLER4
X_11195_ _11195_/A _11195_/B VDD VSS _11209_/A NAND2X1
X_17811_ _18132_/A _17811_/B _17813_/C VDD VSS _19926_/D NOR3X1
XFILLER_121_475 VDD VSS FILLER1
XFILLER_67_529 VSS VDD FILLER2
XFILLER_88_890 VSS VDD FILLER2
XFILLER_94_315 VSS VDD FILLER2
XFILLER_95_827 VSS VDD FILLER2
X_10146_ _10166_/D _10146_/B _10146_/C VDD VSS _10146_/Y AOI21X1
X_18791_ _18817_/CK _18791_/D _18791_/Q VDD VSS DFFQX1
XTAP_TAPCELL_ROW_109_1110 VDD VSS WELLTAP
X_10077_ _18010_/A VDD VSS _17812_/A BUFX3
X_17742_ _17745_/C _17742_/B VDD VSS _17743_/B XNOR2X1
X_14954_ _14954_/A _14954_/B _15742_/B VDD VSS _14992_/B MIN3X1
XFILLER_35_404 VDD VSS DECAPHV8
XFILLER_36_916 VDD VSS FILLER4
XFILLER_47_242 VDD VSS FILLER4
XFILLER_47_264 VDD VSS FILLER1
X_13905_ _19088_/Q _14364_/B VDD VSS _13907_/A NOR2X1
X_17673_ _19895_/Q _19863_/Q _17673_/C VDD VSS _17678_/B MIN3X1
XFILLER_35_426 VSS VDD FILLER2
XFILLER_35_437 VSS VDD FILLER2
XFILLER_47_286 VDD VSS DECAPHV8
XFILLER_90_510 VDD VSS FILLER1
X_19412_ _19466_/CK _19412_/D _19412_/Q VDD VSS DFFQX1
X_16624_ _19606_/Q _16757_/B VDD VSS _16631_/A NOR2X1
X_14885_ _19449_/Q _14885_/B _14920_/C VDD VSS _14909_/B XNOR3X1
XFILLER_63_779 VDD VSS FILLER4
XTAP_TAPCELL_ROW_73_741 VDD VSS WELLTAP
X_13836_ _13921_/A _13921_/B _13921_/D VDD VSS _13865_/B OAI21X1
XFILLER_90_576 VSS VDD FILLER2
XFILLER_90_598 VDD VSS FILLER4
XTAP_TAPCELL_ROW_45_465 VDD VSS WELLTAP
X_10979_ _18703_/Q _18757_/Q VDD VSS _10980_/B XOR2X1
X_13767_ _19002_/Q _13889_/A _13889_/B VDD VSS _13768_/D XNOR3X1
X_19343_ _19393_/CK _19343_/D _19343_/Q VDD VSS DFFQX1
X_16555_ _19636_/Q _16790_/B VDD VSS _16556_/B XNOR2X1
XTAP_TAPCELL_ROW_17_189 VDD VSS WELLTAP
X_12718_ _12731_/A _12731_/B _12731_/C VDD VSS _14317_/B OAI21X1
X_19274_ _20013_/CK _19274_/D _19274_/Q VDD VSS DFFQX1
X_16486_ _16492_/B _16486_/B VDD VSS _16894_/B XOR2X1
X_15506_ _15541_/A _15541_/B VDD VSS _15528_/A NAND2X1
X_13698_ _19084_/Q _14360_/B VDD VSS _13699_/D _14360_/C NAND3X1
X_18225_ _18234_/CK _18225_/E _18225_/ECK VDD VSS CGX3
X_15437_ _19544_/Q _15475_/B VDD VSS _15912_/B XNOR2X1
XFILLER_129_553 VDD VSS FILLER1
X_12649_ _19186_/Q _12649_/B _12663_/C VDD VSS _12771_/B XNOR3X1
XFILLER_116_203 VDD VSS DECAPHV16
XFILLER_117_715 VSS VDD FILLER2
XFILLER_129_575 VDD VSS FILLER4
X_18156_ _18162_/A _18159_/B VDD VSS _18157_/B NOR2X1
X_15368_ _19432_/Q _15816_/B VDD VSS _15369_/B XNOR2X1
XFILLER_144_534 VDD VSS FILLER1
X_14319_ _14352_/A _14319_/B _14319_/C VDD VSS _19049_/D NOR3X1
X_18087_ _18090_/A _18090_/B _18090_/C _18087_/D VDD VSS _18088_/D AOAI211X1
X_17107_ _17105_/B _17107_/B VDD VSS _17108_/C NOR2BX1
X_15299_ _15294_/A _15299_/B VDD VSS _15300_/C NOR2BX1
XFILLER_116_258 VDD VSS FILLER1
XFILLER_116_269 VDD VSS FILLER1
X_17038_ _17095_/A _17038_/B VDD VSS _19761_/D NOR2X1
XFILLER_113_910 VSS VDD FILLER2
XFILLER_113_943 VDD VSS FILLER4
X_09860_ _09857_/Y _09901_/B _11229_/A VDD VSS _09861_/B MUXI2X1
XFILLER_112_453 VSS VDD FILLER2
XFILLER_124_291 VDD VSS DECAPHV16
XFILLER_30_0 VSS VDD FILLER2
Xclkbuf_1_1__f__09183_ clkbuf_0__09183_/Y VDD VSS _18550_/CK BUFX12
XFILLER_112_486 VSS VDD FILLER2
XFILLER_39_710 VDD VSS DECAPHV8
XFILLER_97_153 VDD VSS FILLER4
X_09791_ _09791_/A _09791_/B _09791_/C _09791_/D VDD VSS _18293_/D OAI211X1
X_18989_ _19037_/CK _18989_/D _18989_/Q VDD VSS DFFQX1
XFILLER_100_659 VSS VDD FILLER2
XFILLER_39_743 VDD VSS FILLER1
XFILLER_85_337 VSS VDD FILLER2
XFILLER_66_573 VDD VSS DECAPHV8
XFILLER_94_882 VDD VSS FILLER1
XFILLER_26_17 VDD VSS FILLER4
XFILLER_39_798 VDD VSS FILLER1
XFILLER_42_919 VDD VSS FILLER1
XFILLER_53_234 VSS VDD FILLER2
XFILLER_54_768 VSS VDD FILLER2
XTAP_TAPCELL_ROW_127_1287 VDD VSS WELLTAP
XFILLER_53_278 VDD VSS FILLER1
XFILLER_53_289 VDD VSS DECAPHV8
XFILLER_139_306 VSS VDD FILLER2
XFILLER_10_805 VDD VSS DECAPHV16
XFILLER_22_676 VDD VSS DECAPHV8
X_09225_ _18522_/Q VDD VSS _18373_/D INVX1
XFILLER_6_809 VDD VSS FILLER1
XFILLER_108_715 VDD VSS FILLER1
XTAP_TAPCELL_ROW_138_1394 VDD VSS WELLTAP
XFILLER_101_6 VSS VDD FILLER2
XFILLER_107_247 VSS VDD FILLER2
XFILLER_123_718 VDD VSS FILLER1
XFILLER_104_910 VDD VSS FILLER4
Xclkbuf_leaf_17__002_ clkload17/A VDD VSS _19958_/CK BUFX12
XFILLER_77_805 VDD VSS FILLER4
XFILLER_88_142 VSS VDD FILLER2
XFILLER_89_643 VDD VSS FILLER1
X_10000_ _18579_/Q _10013_/B VDD VSS _10000_/Y XOR2X1
X_09989_ _10034_/A _09989_/B VDD VSS _09990_/C NAND2X1
X_20178_ _20178_/A VDD VSS _20178_/Y BUFX3
XFILLER_92_808 VDD VSS FILLER4
XFILLER_17_404 VSS VDD FILLER2
XFILLER_29_231 VDD VSS FILLER1
XFILLER_29_264 VDD VSS FILLER4
XFILLER_57_573 VDD VSS FILLER4
XTAP_TAPCELL_ROW_87_888 VDD VSS WELLTAP
XFILLER_123_85 VSS VDD FILLER2
XFILLER_29_275 VDD VSS FILLER4
XFILLER_83_23 VDD VSS FILLER1
XFILLER_85_882 VDD VSS DECAPHV8
X_11951_ _19036_/Q VDD VSS _11954_/A INVX1
XFILLER_33_908 VDD VSS FILLER1
XFILLER_45_768 VDD VSS FILLER4
XFILLER_72_554 VDD VSS FILLER4
X_10902_ _10936_/C _10902_/B _10902_/C VDD VSS _10909_/C OAI21X1
X_11882_ _14525_/B _14525_/C _19231_/Q VDD VSS _11884_/C AOI21X1
X_14670_ _19444_/Q VDD VSS _14733_/A INVX1
XFILLER_60_716 VDD VSS FILLER4
XFILLER_60_727 VDD VSS DECAPHV8
XTAP_TAPCELL_ROW_70_711 VDD VSS WELLTAP
X_10833_ _18644_/Q _18806_/Q VDD VSS _10866_/A NAND2X1
X_13621_ _19112_/Q _13721_/A _13721_/B VDD VSS _13623_/C XNOR3X1
XFILLER_13_621 VSS VDD FILLER2
XTAP_TAPCELL_ROW_104_1051 VDD VSS WELLTAP
XTAP_TAPCELL_ROW_42_435 VDD VSS WELLTAP
X_10764_ _18696_/Q _18750_/Q VDD VSS _10765_/D NAND2X1
X_13552_ _19196_/Q VDD VSS _13634_/A INVX1
X_16340_ _19563_/Q _16710_/A _16340_/C VDD VSS _16368_/B MIN3X1
XFILLER_12_142 VSS VDD FILLER2
XTAP_TAPCELL_ROW_14_159 VDD VSS WELLTAP
X_12503_ _19185_/Q _12503_/B _12566_/C VDD VSS _14440_/C XNOR3X1
XFILLER_40_484 VSS VDD FILLER2
XFILLER_40_495 VDD VSS FILLER1
X_10695_ _18628_/Q _18722_/Q _10803_/A _10695_/D _10695_/E VDD VSS _10696_/D AOI221X1
X_13483_ _18915_/Q _13656_/A _13498_/B VDD VSS _13578_/D XNOR3X1
X_18010_ _18010_/A _18054_/A VDD VSS _18011_/A OR2X2
X_16271_ _19721_/Q _16885_/B VDD VSS _16274_/B XNOR2X1
XFILLER_139_884 VDD VSS DECAPHV8
XTAP_TAPCELL_ROW_3_42 VDD VSS WELLTAP
X_12434_ _18905_/Q VDD VSS _12533_/A INVX1
X_15222_ _19400_/Q _15779_/A VDD VSS _15223_/C NAND2X1
X_12365_ _12421_/A _14344_/B VDD VSS _12517_/A OR2X2
X_15153_ _19509_/Q _15903_/B VDD VSS _15155_/C NOR2BX1
XFILLER_141_504 VDD VSS FILLER1
XFILLER_99_407 VSS VDD FILLER2
X_11316_ _11316_/A _11316_/B _11316_/C VDD VSS _11333_/A OAI21X1
X_14104_ _14104_/A _14104_/B _14104_/C VDD VSS _14142_/B OA21X2
X_19961_ _19963_/CK _19961_/D _19961_/Q VDD VSS DFFQX1
X_15084_ _19426_/Q VDD VSS _15138_/A INVX1
XFILLER_141_537 VSS VDD FILLER2
X_12296_ _19126_/Q _12471_/A _12471_/B VDD VSS _12298_/C XNOR3X1
X_14035_ _18979_/Q _14043_/A _14043_/B VDD VSS _14036_/D XNOR3X1
X_18912_ _18936_/CK _18912_/D _18912_/Q VDD VSS DFFQX1
XFILLER_79_131 VDD VSS FILLER1
X_11247_ _11247_/A _11264_/B VDD VSS _11252_/B XNOR2X1
X_19892_ _19892_/CK _19892_/D _19892_/Q VDD VSS DFFQX1
XFILLER_110_902 VDD VSS FILLER1
XFILLER_68_827 VDD VSS DECAPHV8
XFILLER_79_153 VDD VSS DECAPHV8
XTAP_TAPCELL_ROW_78_800 VDD VSS WELLTAP
X_11178_ _11196_/A _18736_/Q _11178_/C _11178_/D _11178_/E VDD VSS _11179_/B AOI221X1
X_18843_ _19963_/CK _18843_/D _18843_/Q VDD VSS DFFQX1
X_10129_ _10190_/B _10129_/B _10175_/B _10166_/D VDD VSS _10130_/C AOI211X1
X_18774_ _18801_/CK _18774_/D _18774_/Q VDD VSS DFFQX1
XFILLER_48_551 VDD VSS FILLER1
X_17725_ _19908_/Q _19876_/Q VDD VSS _17730_/A XNOR2X1
X_15986_ _16012_/A _15986_/B _16013_/A VDD VSS _16010_/B MIN3X1
XFILLER_48_584 VDD VSS DECAPHV16
XFILLER_76_893 VSS VDD FILLER2
X_14937_ _19422_/Q _15805_/B VDD VSS _14956_/D _15805_/C NAND3X1
X_17656_ _19892_/Q VDD VSS _17803_/B INVX1
X_14868_ _14918_/A _14918_/B VDD VSS _15867_/B XNOR2X1
XFILLER_23_407 VDD VSS FILLER1
XFILLER_63_576 VDD VSS FILLER1
XFILLER_63_598 VDD VSS FILLER4
X_13819_ _13918_/A _13918_/B _13918_/D _13918_/C VDD VSS _14166_/C AOI211X1
X_17587_ _19878_/Q _19846_/Q VDD VSS _17589_/D XNOR2X1
X_16607_ _16631_/B _16607_/B VDD VSS _16792_/B OR2X2
X_19326_ _19358_/CK _19326_/D _19326_/Q VDD VSS DFFQX1
X_16538_ _16561_/B _16538_/B VDD VSS _16896_/B AND2X1
X_14799_ _19362_/Q VDD VSS _14800_/A INVX1
XFILLER_31_440 VDD VSS FILLER1
X_19257_ _19992_/CK _19257_/D _19257_/Q VDD VSS DFFQX1
X_16469_ _16469_/A _16469_/B _16469_/C _16469_/D VDD VSS _16492_/B AOAI211X1
XFILLER_78_0 VDD VSS FILLER4
X_19188_ _19215_/CK _19188_/D _19188_/Q VDD VSS DFFQX1
X_18208_ input3/Y hold259/Y VDD VSS _18208_/Y NOR2BX1
X_18139_ _18139_/A _18139_/B VDD VSS _18143_/C NAND2X1
XFILLER_105_718 VDD VSS DECAPHV8
XFILLER_117_589 VDD VSS DECAPHV16
X_20101_ _20101_/A VDD VSS _20101_/Y BUFX3
XFILLER_113_751 VDD VSS FILLER1
X_09912_ _11014_/A _09912_/B _09912_/C _09928_/C VDD VSS _09913_/C OAI211X1
XFILLER_101_913 VDD VSS DECAPHV8
XFILLER_86_624 VSS VDD FILLER2
XFILLER_98_462 VDD VSS DECAPHV8
X_09843_ _18566_/Q _18567_/Q VDD VSS _09880_/A _09881_/B NAND3X1
X_20032_ _20043_/CK _20032_/D _20032_/Q _20043_/RB VDD VSS DFFRQX1
Xclkbuf_1_1__f__09166_ clkbuf_0__09166_/Y VDD VSS _18420_/CK BUFX12
XFILLER_58_348 VSS VDD FILLER2
XFILLER_85_134 VDD VSS FILLER4
XTAP_TAPCELL_ROW_129_1305 VDD VSS WELLTAP
XFILLER_100_456 VDD VSS DECAPHV32
XFILLER_37_38 VDD VSS FILLER1
X_09774_ _09791_/A _18404_/Q VDD VSS _09775_/C NOR2X1
XFILLER_27_724 VDD VSS FILLER4
XFILLER_85_189 VDD VSS DECAPHV16
XTAP_TAPCELL_ROW_84_858 VDD VSS WELLTAP
X_09967__237 _20054_/CK VDD VSS _18514_/CK INVX1
XFILLER_26_289 VDD VSS FILLER1
XFILLER_23_941 VDD VSS FILLER1
XFILLER_10_602 VSS VDD FILLER2
XFILLER_41_259 VDD VSS DECAPHV8
XFILLER_50_793 VDD VSS FILLER1
XFILLER_10_668 VSS VDD FILLER2
XTAP_TAPCELL_ROW_11_129 VDD VSS WELLTAP
X_09208_ _18474_/D VDD VSS _18426_/D INVX1
X_10480_ _10514_/A _10481_/C _10481_/D VDD VSS _10483_/B OR3BX1
XFILLER_136_865 VDD VSS FILLER4
X_12150_ _12160_/A _14465_/B _12160_/C VDD VSS _14466_/B OAI21X1
XFILLER_123_526 VDD VSS DECAPHV16
XFILLER_135_375 VDD VSS FILLER1
XFILLER_135_397 VDD VSS FILLER4
X_11101_ _11136_/C _11101_/B VDD VSS _11105_/B XNOR2X1
XFILLER_104_751 VDD VSS FILLER1
XFILLER_78_34 VDD VSS FILLER1
XFILLER_89_440 VSS VDD FILLER2
X_12081_ _19067_/Q _12081_/B _12284_/C VDD VSS _12448_/B MIN3X1
XFILLER_89_462 VSS VDD FILLER2
X_11032_ _11074_/C _11032_/B VDD VSS _11047_/B XNOR2X1
XFILLER_76_123 VSS VDD FILLER2
X_15840_ _15198_/B _15840_/B _17986_/C VDD VSS _19454_/D AND3BX1
XFILLER_57_370 VSS VDD FILLER2
XFILLER_58_882 VDD VSS FILLER1
XFILLER_91_104 VDD VSS FILLER4
XFILLER_92_638 VDD VSS DECAPHV8
XTAP_TAPCELL_ROW_19_207 VDD VSS WELLTAP
X_12983_ _18966_/Q _13171_/A _14217_/B VDD VSS _12989_/C XNOR3X1
X_15771_ _15780_/A _15771_/B VDD VSS _19393_/D NOR2X1
XFILLER_17_245 VDD VSS FILLER4
XFILLER_18_757 VDD VSS FILLER4
X_11934_ _11934_/A VDD VSS _12055_/B BUFX3
X_18490_ _18494_/CK _18490_/D _18490_/Q _18496_/RB VDD VSS DFFRQX1
X_17510_ _17512_/C _17510_/B _17510_/C VDD VSS _19861_/D AOI21X1
X_14722_ _14728_/B _14722_/B VDD VSS _15705_/B XNOR2X1
XFILLER_33_705 VDD VSS FILLER1
X_14653_ _19497_/Q _14655_/B VDD VSS _14676_/B XNOR2X1
X_17441_ _19846_/Q _19814_/Q _17441_/C VDD VSS _17446_/C AO21X2
XFILLER_32_226 VSS VDD FILLER2
XFILLER_60_546 VDD VSS DECAPHV8
XTAP_TAPCELL_ROW_27_284 VDD VSS WELLTAP
X_11865_ _11865_/A _11865_/B _14397_/B VDD VSS _11967_/B MIN3X1
X_13604_ _13604_/A _13604_/B _13604_/C _13604_/D VDD VSS _13837_/A AOAI211X1
X_10816_ _10745_/B _10816_/B _10816_/C VDD VSS _10853_/A AND3BX1
X_11796_ _19201_/Q _14489_/B VDD VSS _11830_/A NOR2BX1
X_14584_ _14601_/B _14584_/B _14584_/C VDD VSS _14615_/A NOR3BX1
Xclkbuf_1_0__f__09186_ clkbuf_0__09186_/Y VDD VSS _18471_/CK BUFX12
X_19111_ _19196_/CK _19111_/D _19111_/Q VDD VSS DFFQX1
X_17372_ _17372_/A VDD VSS _17373_/C INVX1
XFILLER_13_484 VSS VDD FILLER2
XFILLER_43_92 VDD VSS FILLER1
X_10747_ _10747_/A _10747_/B _10747_/C _10945_/A VDD VSS _10774_/A AOI31X1
X_13535_ _19083_/Q _14359_/B VDD VSS _13728_/A AND2X1
X_16323_ _16348_/A _16348_/B VDD VSS _16852_/B XNOR2X1
X_10678_ _10718_/D _10721_/A VDD VSS _10679_/B NAND2X1
X_13466_ _13466_/A _13466_/B _14515_/B _19222_/Q _13466_/E VDD VSS _13557_/C AOI221X1
X_19042_ _19045_/CK _19042_/D _19042_/Q VDD VSS DFFQX1
X_16254_ _19624_/Q VDD VSS _16255_/A INVX1
XFILLER_126_320 VDD VSS FILLER4
XFILLER_127_821 VDD VSS FILLER4
X_12417_ _19128_/Q _12462_/B _12553_/C VDD VSS _12456_/C XNOR3X1
X_15205_ _15225_/C _15205_/B VDD VSS _15225_/B NOR2X1
XFILLER_127_876 VDD VSS DECAPHV8
X_13397_ _18970_/Q _14224_/B VDD VSS _13586_/A NOR2BX1
X_16185_ _19557_/Q _16703_/A _16185_/C VDD VSS _16208_/B MIN3X1
X_12348_ _18902_/Q _12348_/B _12348_/C VDD VSS _14114_/B XNOR3X1
X_15136_ _19398_/Q _15777_/B VDD VSS _15137_/C NAND2X1
X_12279_ _19015_/Q VDD VSS _12357_/A INVX1
X_19944_ _19957_/CK _19944_/D _19944_/Q VDD VSS DFFQX1
X_15067_ _15089_/A _15088_/A _15092_/D VDD VSS _15069_/C XNOR3X1
X_14018_ _14018_/A _14018_/B _14018_/C _14018_/D VDD VSS wire152/A OAOI211X1
XFILLER_4_97 VDD VSS FILLER1
X_19875_ _19907_/CK _19875_/D _19875_/Q VDD VSS DFFQX1
XFILLER_67_167 VSS VDD FILLER2
XFILLER_83_616 VSS VDD FILLER2
XFILLER_95_476 VSS VDD FILLER2
X_18826_ _19947_/CK _18826_/D _18826_/Q VDD VSS DFFQX1
XFILLER_110_798 VDD VSS DECAPHV16
XFILLER_67_189 VSS VDD FILLER2
X_18757_ _18785_/CK _18757_/D _18757_/Q VDD VSS DFFQX1
X_15969_ _15969_/A VDD VSS _15970_/B INVX1
XFILLER_64_852 VDD VSS FILLER4
X_09490_ _19983_/Q _09490_/B _09507_/B VDD VSS _09491_/C AOI21X1
X_18688_ _18797_/CK _18688_/D _18688_/Q VDD VSS DFFQX1
X_17708_ _19903_/Q _19871_/Q _17708_/C VDD VSS _17712_/C AOI21X1
XFILLER_24_716 VSS VDD FILLER2
XFILLER_51_513 VDD VSS DECAPHV8
XFILLER_63_351 VDD VSS FILLER1
XTAP_TAPCELL_ROW_124_1257 VDD VSS WELLTAP
XTAP_TAPCELL_ROW_81_828 VDD VSS WELLTAP
X_17639_ _19889_/Q _19857_/Q VDD VSS _17646_/C NOR2X1
XFILLER_36_598 VDD VSS FILLER4
XFILLER_90_192 VSS VDD FILLER2
XFILLER_20_944 VSS VDD FILLER2
XFILLER_31_270 VDD VSS DECAPHV8
XFILLER_32_793 VDD VSS DECAPHV8
X_19309_ _19322_/CK _19309_/D _19309_/Q VDD VSS DFFQX1
XFILLER_117_320 VDD VSS DECAPHV8
XFILLER_133_802 VDD VSS DECAPHV8
XFILLER_105_515 VSS VDD FILLER2
XFILLER_133_824 VSS VDD FILLER2
XTAP_TAPCELL_ROW_135_1364 VDD VSS WELLTAP
XFILLER_132_323 VSS VDD FILLER2
XFILLER_144_183 VDD VSS DECAPHV32
XTAP_TAPCELL_ROW_89_906 VDD VSS WELLTAP
XFILLER_101_721 VSS VDD FILLER2
XFILLER_58_112 VSS VDD FILLER2
XFILLER_59_624 VSS VDD FILLER2
XFILLER_86_421 VDD VSS FILLER4
XFILLER_86_432 VDD VSS FILLER1
X_20015_ clkload6/A _20015_/D _20015_/Q _20069_/RB VDD VSS DFFRQX1
XFILLER_47_808 VSS VDD FILLER2
XFILLER_59_679 VSS VDD FILLER2
X_09826_ _11435_/A _11435_/B _11438_/A VDD VSS _10247_/A AO21X2
XFILLER_104_32 VDD VSS FILLER1
XTAP_TAPCELL_ROW_97_983 VDD VSS WELLTAP
X_09757_ _18339_/Q _09810_/B VDD VSS _09758_/E NOR2X1
XFILLER_104_87 VSS VDD FILLER2
XFILLER_64_36 VDD VSS FILLER4
XFILLER_67_690 VSS VDD FILLER2
XFILLER_42_502 VDD VSS DECAPHV8
XFILLER_55_885 VDD VSS FILLER4
X_09688_ _18447_/Q _09816_/B VDD VSS _09690_/C NOR2X1
XFILLER_14_226 VSS VDD FILLER2
XFILLER_14_248 VDD VSS FILLER1
XFILLER_30_719 VDD VSS DECAPHV8
XFILLER_42_579 VSS VDD FILLER2
XTAP_TAPCELL_ROW_101_1021 VDD VSS WELLTAP
X_11650_ _18790_/Q _11658_/B VDD VSS _18817_/D AND2X1
XTAP_TAPCELL_ROW_24_254 VDD VSS WELLTAP
X_10601_ _10649_/A _10649_/B _10601_/C _10601_/D VDD VSS _10619_/A AOAI211X1
X_11581_ _18727_/Q _11589_/B VDD VSS _18754_/D AND2X1
XFILLER_128_607 VDD VSS FILLER1
X_10532_ _10556_/A _10556_/B _10686_/D VDD VSS _10533_/C OAI21X1
X_13320_ _13616_/A _13322_/C VDD VSS _14387_/B XNOR2X1
XFILLER_109_810 VDD VSS DECAPHV8
XFILLER_108_342 VDD VSS FILLER1
XFILLER_89_22 VDD VSS FILLER1
X_10463_ _10581_/A _10463_/B _10463_/C _10463_/D VDD VSS _10535_/C AND4X2
X_13251_ _19192_/Q _14479_/B VDD VSS _13443_/C _14479_/C AND3X2
X_10394_ _10390_/B _18554_/Q VDD VSS _10431_/A NAND2BX1
X_12202_ _14243_/A _14244_/A _14277_/B VDD VSS _12280_/B MIN3X1
X_13182_ _18882_/Q _13182_/B _13182_/C VDD VSS _13183_/C MIN3X1
XTAP_TAPCELL_ROW_0_10 VDD VSS WELLTAP
X_12133_ _19013_/Q VDD VSS _14243_/A INVX1
X_17990_ _17990_/A _17990_/B VDD VSS _19964_/D AND2X1
XFILLER_111_518 VSS VDD FILLER2
X_12064_ _19067_/Q _12284_/B _12284_/C VDD VSS _12077_/C XNOR3X1
X_16941_ _17073_/B VDD VSS _17049_/B BUFX3
XFILLER_96_229 VSS VDD FILLER2
X_11015_ _10983_/B _11014_/Y _10984_/A VDD VSS _11015_/Y MUX2X1
XFILLER_77_454 VDD VSS DECAPHV8
X_19660_ _19724_/CK _19660_/D _19660_/Q VDD VSS DFFQX1
X_16872_ _16876_/A _16872_/B VDD VSS _19709_/D NOR2X1
XFILLER_38_81 VSS VDD FILLER2
XFILLER_49_189 VDD VSS DECAPHV16
X_19591_ _19591_/CK _19591_/D _19591_/Q VDD VSS DFFQX1
X_18611_ _18622_/CK _18611_/D _18611_/Q VDD VSS DFFQX1
X_15823_ _15830_/A _15823_/B VDD VSS _19438_/D NOR2X1
X_18542_ _18550_/CK _18542_/D _18542_/Q VDD VSS DFFQX1
X_15754_ _15758_/A _15754_/B VDD VSS _19377_/D NOR2X1
XFILLER_45_340 VDD VSS DECAPHV8
XFILLER_73_671 VDD VSS FILLER4
X_12966_ _19244_/Q _12966_/B _12966_/C VDD VSS _12968_/B XNOR3X1
X_14705_ _19498_/Q _14742_/C _14705_/C VDD VSS _14739_/A OR3BX1
X_11917_ _11918_/A _11918_/B _11918_/D _11918_/C VDD VSS _14462_/B OAOI211X2
X_12897_ _19020_/Q VDD VSS _12899_/A INVX1
X_18473_ _18479_/CK _18510_/Q _20118_/A _20078_/RB VDD VSS DFFRQX1
X_15685_ _15693_/A _15685_/B VDD VSS _19314_/D NOR2X1
X_11848_ _19147_/Q _11869_/A _11874_/D VDD VSS _11966_/A XNOR3X1
X_14636_ _19443_/Q VDD VSS _14701_/A INVX1
X_17424_ _17427_/C _17425_/B _17452_/C VDD VSS _17425_/C OAI21X1
XFILLER_14_771 VDD VSS DECAPHV16
X_14567_ _20006_/Q _14569_/B VDD VSS _19270_/D AND2X1
X_17355_ _17355_/A _17357_/C _17355_/C VDD VSS _19828_/D AOI21X1
XFILLER_9_230 VDD VSS FILLER4
X_11779_ _11804_/A _11804_/B VDD VSS _11781_/B NOR2X1
X_13518_ _18999_/Q _14261_/B VDD VSS _14226_/A AND2X1
Xclkbuf_1_0__f__09169_ clkbuf_0__09169_/Y VDD VSS _18367_/CK BUFX12
X_16306_ _19690_/Q _16851_/B VDD VSS _16326_/A NAND2BX1
X_14498_ _14539_/A _14498_/B VDD VSS _19207_/D NOR2X1
X_19025_ _19064_/CK _19025_/D _19025_/Q VDD VSS DFFQX1
X_17286_ _17289_/A _17286_/B _17286_/C VDD VSS _19813_/D AOI21X1
X_13449_ _19194_/Q _13449_/B _13457_/D VDD VSS _13459_/C XNOR3X1
Xclkload44 _20013_/CK VDD VSS clkload44/Y INVX1
Xclkload33 _18801_/CK VDD VSS clkload33/Y INVX4
Xclkload22 _19951_/CK VDD VSS clkload22/Y INVX4
Xclkload11 _19892_/CK VDD VSS clkload11/Y INVX2
X_16237_ _16237_/A _16258_/C VDD VSS _16742_/B XNOR2X1
XFILLER_55_2 VDD VSS FILLER1
Xclkload77 clkload77/A VDD VSS clkload77/Y INVX8
Xclkload66 _19197_/CK VDD VSS clkload66/Y INVX1
Xclkload55 _19040_/CK VDD VSS clkload55/Y INVX1
X_16168_ _19685_/Q _16846_/B VDD VSS _16169_/B XNOR2X1
XFILLER_142_632 VDD VSS DECAPHV8
XFILLER_88_708 VDD VSS FILLER4
Xclkload99 _19703_/CK VDD VSS clkload99/Y BUFX12
Xclkload88 _19304_/CK VDD VSS clkload88/Y INVX2
X_15119_ _15137_/A _15119_/B VDD VSS _15747_/B XOR2X1
XFILLER_115_879 VDD VSS FILLER4
XFILLER_69_922 VSS VDD FILLER2
X_16099_ _16099_/A _16103_/B VDD VSS _16100_/B XOR2X1
XFILLER_130_849 VDD VSS FILLER4
XFILLER_68_421 VDD VSS FILLER4
X_19927_ clkload9/A _19927_/D _19927_/Q VDD VSS DFFQX1
XFILLER_68_454 VDD VSS DECAPHV16
X_19858_ _19892_/CK _19858_/D _19858_/Q VDD VSS DFFQX1
XFILLER_83_413 VDD VSS FILLER1
X_09611_ _09753_/A _18394_/Q _09611_/C _09753_/D VDD VSS _09612_/E OAOI211X1
X_18809_ _18809_/CK _18809_/D _18809_/Q VDD VSS DFFQX1
XTAP_TAPCELL_ROW_94_953 VDD VSS WELLTAP
X_09542_ _20036_/Q _09547_/B VDD VSS _20037_/D NOR2BX1
X_19789_ _19795_/CK _19789_/D _19789_/Q VDD VSS DFFQX1
XFILLER_36_351 VDD VSS DECAPHV8
XFILLER_83_468 VSS VDD FILLER2
XTAP_TAPCELL_ROW_66_677 VDD VSS WELLTAP
XFILLER_52_822 VDD VSS FILLER4
XFILLER_64_682 VDD VSS FILLER1
X_09473_ _18450_/D _09483_/B _09473_/C VDD VSS _18247_/D AOI21X1
XTAP_TAPCELL_ROW_21_224 VDD VSS WELLTAP
Xclkload5 clkload5/A VDD VSS clkload5/Y INVX4
XFILLER_138_949 VDD VSS FILLER1
XFILLER_50_49 VSS VDD FILLER2
XFILLER_118_651 VDD VSS DECAPHV16
XFILLER_106_813 VSS VDD FILLER2
XFILLER_106_835 VSS VDD FILLER2
XFILLER_133_610 VDD VSS FILLER4
XFILLER_105_312 VSS VDD FILLER2
XFILLER_118_695 VSS VDD FILLER2
XFILLER_133_654 VDD VSS FILLER1
XFILLER_59_25 VSS VDD FILLER2
XFILLER_121_827 VSS VDD FILLER2
XFILLER_132_153 VDD VSS DECAPHV8
XFILLER_132_186 VDD VSS FILLER4
Xfanout220 _20081_/RB VDD VSS _20078_/RB BUFX3
XFILLER_115_42 VDD VSS FILLER4
XFILLER_47_605 VDD VSS DECAPHV8
XFILLER_101_584 VDD VSS FILLER1
XFILLER_115_86 VDD VSS FILLER4
XFILLER_59_498 VSS VDD FILLER2
XFILLER_75_925 VDD VSS FILLER4
XFILLER_86_262 VDD VSS FILLER1
XTAP_TAPCELL_ROW_29_302 VDD VSS WELLTAP
X_09809_ _20116_/A _20132_/A _18508_/Q VDD VSS _09819_/B MUXI2X1
X_12820_ _12939_/B _14382_/C _19104_/Q VDD VSS _12821_/D AND3BX1
XFILLER_131_41 VDD VSS FILLER4
XFILLER_55_671 VDD VSS FILLER1
XFILLER_74_479 VSS VDD FILLER2
XFILLER_15_524 VDD VSS FILLER1
XFILLER_54_170 VDD VSS FILLER1
XFILLER_61_129 VDD VSS FILLER4
X_12751_ _12832_/A _12832_/B VDD VSS _12841_/C _12832_/C NAND3X1
XFILLER_131_96 VDD VSS DECAPHV16
XFILLER_91_67 VSS VDD FILLER2
XTAP_TAPCELL_ROW_37_390 VDD VSS WELLTAP
X_11702_ _11742_/A VDD VSS _11724_/A INVX1
X_12682_ _19214_/Q _12832_/B VDD VSS _12683_/D _12682_/C NAND3X1
X_15470_ _19490_/Q VDD VSS _15471_/A INVX1
XFILLER_42_398 VSS VDD FILLER2
X_11633_ _18775_/Q _11635_/B VDD VSS _18802_/D AND2X1
X_14421_ _14522_/A VDD VSS _14421_/Y BUFX3
XFILLER_11_730 VSS VDD FILLER2
XFILLER_129_927 VSS VDD FILLER2
X_17140_ _17140_/A _17140_/B _17140_/C _17140_/D VDD VSS _17141_/C AOAI211X1
XFILLER_129_949 VDD VSS FILLER1
XFILLER_7_712 VSS VDD FILLER2
X_11564_ _18712_/Q _11567_/B VDD VSS _18739_/D AND2X1
X_14352_ _14352_/A _14352_/B _14352_/C VDD VSS _19078_/D NOR3X1
X_10515_ _18637_/Q _18799_/Q VDD VSS _10516_/B XOR2X1
X_11495_ _11495_/A _11641_/B VDD VSS _18677_/D NOR2X1
X_13303_ _14222_/B _13400_/C _18969_/Q VDD VSS _13391_/C AND3BX1
X_14283_ _14285_/A _14283_/B VDD VSS _19017_/D NOR2X1
X_17071_ _17095_/A _17071_/B VDD VSS _19767_/D NOR2X1
X_10446_ _10446_/A VDD VSS _10448_/C INVX1
X_13234_ _13443_/A _13443_/B VDD VSS _14448_/B XNOR2X1
X_16022_ _16022_/A _16022_/B _16022_/C _16022_/D VDD VSS _16023_/C AOAI211X1
XFILLER_108_183 VSS VDD FILLER2
XFILLER_124_643 VSS VDD FILLER2
XFILLER_112_805 VSS VDD FILLER2
XFILLER_124_665 VDD VSS FILLER4
X_10377_ _18660_/Q _18768_/Q VDD VSS _10406_/D NAND2X1
X_13165_ _19052_/Q _13271_/D _13165_/C VDD VSS _13208_/C XOR3X1
XFILLER_123_175 VDD VSS DECAPHV8
XFILLER_123_197 VDD VSS FILLER1
XFILLER_2_483 VDD VSS DECAPHV8
XFILLER_69_218 VDD VSS FILLER4
X_12116_ _12116_/A _12116_/B _12116_/C _12116_/D VDD VSS _12214_/B AOAI211X1
X_13096_ _13415_/B _14290_/C _19023_/Q VDD VSS _13097_/D AND3BX1
X_17973_ _18870_/Q VDD VSS _17975_/A INVX1
X_12047_ _12113_/A _12113_/B _12113_/D VDD VSS _12059_/B OAI21X1
X_19712_ _19716_/CK _19712_/D _19712_/Q VDD VSS DFFQX1
X_16924_ _19740_/Q wire163/Y VDD VSS _16928_/B XNOR2X1
XFILLER_120_882 VDD VSS FILLER1
X_19643_ _19643_/CK _19643_/D _19643_/Q VDD VSS DFFQX1
X_16855_ _16865_/A _16855_/B VDD VSS _19694_/D NOR2X1
XFILLER_19_830 VSS VDD FILLER2
XFILLER_37_148 VDD VSS FILLER4
XFILLER_65_446 VDD VSS DECAPHV8
XFILLER_77_284 VDD VSS FILLER1
X_15806_ _15806_/A _15806_/B _15806_/C VDD VSS _19423_/D NOR3X1
XFILLER_93_777 VSS VDD FILLER2
X_13998_ _13998_/A _13998_/B _13998_/C _13998_/D VDD VSS _14232_/B AOAI211X1
X_19574_ _19606_/CK _19574_/D _19574_/Q VDD VSS DFFQX1
X_16786_ _16794_/A _16786_/B VDD VSS _19632_/D NOR2X1
XFILLER_18_395 VSS VDD FILLER2
XFILLER_33_321 VDD VSS DECAPHV8
XFILLER_52_118 VSS VDD FILLER2
XFILLER_52_129 VDD VSS FILLER4
XFILLER_65_90 VSS VDD FILLER2
XFILLER_80_427 VDD VSS DECAPHV16
XTAP_TAPCELL_ROW_91_923 VDD VSS WELLTAP
X_12949_ _13108_/A _13108_/B _13108_/C VDD VSS _12972_/B AOI21X1
X_18525_ _18525_/CK _18525_/D _18525_/Q _09298_/Y VDD VSS DFFRQX1
X_15737_ _15739_/A _15737_/B VDD VSS _19362_/D NOR2X1
XTAP_TAPCELL_ROW_121_1227 VDD VSS WELLTAP
XTAP_TAPCELL_ROW_63_647 VDD VSS WELLTAP
X_18456_ _18468_/CK _18456_/D _18456_/Q _20072_/RB VDD VSS DFFRQX1
X_15668_ _15668_/A _15671_/C VDD VSS _18190_/A XNOR2X1
X_14619_ _14645_/A _14645_/B _14645_/C VDD VSS _15858_/A AOI21X1
X_17407_ _17405_/B _17407_/B VDD VSS _17408_/C NOR2BX1
XFILLER_60_184 VDD VSS FILLER4
X_18387_ _18391_/CK _18520_/Q _20192_/A _20065_/RB VDD VSS DFFRQX1
X_15599_ _15599_/A _15599_/B _15599_/C _15599_/D VDD VSS _15622_/B AOAI211X1
XFILLER_119_437 VDD VSS DECAPHV16
X_17338_ _17338_/A _17338_/B _17338_/C VDD VSS _17346_/A OA21X2
Xclkload122 _18257_/CK VDD VSS clkload122/Y INVX2
Xclkload111 _18582_/CK VDD VSS clkload111/Y INVX2
Xclkload100 _19724_/CK VDD VSS clkload100/Y INVX1
X_17269_ _17270_/B _17269_/B VDD VSS _17271_/B NOR2BX1
XFILLER_134_407 VDD VSS FILLER4
XFILLER_60_0 VSS VDD FILLER2
X_19008_ _19037_/CK _19008_/D _19008_/Q VDD VSS DFFQX1
XTAP_TAPCELL_ROW_132_1334 VDD VSS WELLTAP
XFILLER_114_142 VDD VSS FILLER4
XFILLER_114_153 VDD VSS FILLER4
XFILLER_130_646 VDD VSS FILLER1
XFILLER_130_679 VDD VSS FILLER4
XFILLER_69_741 VSS VDD FILLER2
XFILLER_29_627 VSS VDD FILLER2
XFILLER_68_262 VDD VSS FILLER1
XFILLER_69_774 VDD VSS FILLER1
XFILLER_84_700 VSS VDD FILLER2
XFILLER_110_381 VSS VDD FILLER2
XFILLER_29_649 VSS VDD FILLER2
XFILLER_25_800 VDD VSS DECAPHV8
XFILLER_72_939 VDD VSS FILLER4
XFILLER_71_427 VDD VSS FILLER4
XTAP_TAPCELL_ROW_143_1441 VDD VSS WELLTAP
X_09525_ _20021_/Q _09526_/B _18202_/B VDD VSS _20021_/D OA21X2
XFILLER_24_343 VDD VSS FILLER4
XFILLER_52_663 VDD VSS DECAPHV8
X_09456_ _09482_/C VDD VSS _09476_/C BUFX3
XFILLER_101_66 VDD VSS FILLER1
XFILLER_12_505 VDD VSS FILLER1
XFILLER_52_685 VDD VSS DECAPHV8
XTAP_TAPCELL_ROW_34_360 VDD VSS WELLTAP
XFILLER_61_26 VDD VSS FILLER1
X_09387_ _18629_/Q _09387_/B _18163_/A VDD VSS _18232_/E AO21X2
XFILLER_138_757 VSS VDD FILLER2
XFILLER_138_779 VSS VDD FILLER2
XFILLER_137_278 VDD VSS FILLER1
XFILLER_137_289 VDD VSS DECAPHV8
X_10300_ _18623_/Q _10686_/D VDD VSS _10546_/A _10314_/C NAND3X1
X_11280_ _11280_/A _11286_/B VDD VSS _11284_/B XNOR2X1
X_10231_ _18595_/Q _10231_/B VDD VSS _10231_/Y XNOR2X1
XFILLER_79_516 VSS VDD FILLER2
XFILLER_10_85 VSS VDD FILLER2
X_10162_ _10180_/A _11419_/C VDD VSS _18541_/D NOR2X1
XFILLER_0_943 VSS VDD FILLER2
XFILLER_120_145 VSS VDD FILLER2
XFILLER_86_45 VDD VSS FILLER1
X_10093_ _10045_/Y _10146_/B _10167_/A VDD VSS _10182_/B MUX2X1
X_14970_ _19533_/Q _14970_/B VDD VSS _15900_/B XOR2X1
XFILLER_19_104 VSS VDD FILLER2
X_13921_ _13921_/A _13921_/B _13921_/C _13921_/D VDD VSS _13923_/C OAI211X1
XFILLER_19_126 VDD VSS FILLER1
XFILLER_48_947 VSS VDD FILLER2
XFILLER_63_917 VDD VSS FILLER4
X_13852_ _13912_/A _13912_/B _13912_/E VDD VSS _13862_/B OA21X2
X_16640_ _16643_/A _16643_/B _16643_/C _18087_/D VDD VSS _16641_/D OAI31X1
XFILLER_16_833 VDD VSS DECAPHV8
XFILLER_62_449 VDD VSS DECAPHV16
X_12803_ _12803_/A _12803_/B _12803_/C _12803_/D VDD VSS _14315_/B AOAI211X1
X_13783_ _13783_/A _14297_/B _13783_/C _13783_/D VDD VSS _13912_/A OAOI211X2
Xclkbuf_leaf_18__000_ clkbuf_leaf_9__000_/A VDD VSS _19671_/CK BUFX12
X_16571_ _16571_/A _16571_/B _16790_/B VDD VSS _16597_/B MIN3X1
XTAP_TAPCELL_ROW_107_1082 VDD VSS WELLTAP
X_10995_ _11026_/B VDD VSS _10996_/B INVX1
X_12734_ _12809_/A _14380_/B VDD VSS _12821_/A NOR2X1
X_19290_ _19290_/CK _19290_/D _19290_/Q VDD VSS DFFQX1
X_18310_ _18310_/CK _18470_/D _18310_/Q _18465_/RB VDD VSS DFFRQX1
X_15522_ _19436_/Q _15821_/B VDD VSS _15545_/B XNOR2X1
XFILLER_31_836 VDD VSS FILLER1
XTAP_TAPCELL_ROW_60_617 VDD VSS WELLTAP
X_18241_ _18241_/CK _18241_/D _18241_/Q _20078_/RB VDD VSS DFFRQX1
XFILLER_70_493 VDD VSS FILLER1
XTAP_TAPCELL_ROW_6_75 VDD VSS WELLTAP
X_12665_ _12771_/A _12771_/B _12771_/E VDD VSS _12739_/B OA21X2
X_15453_ _19378_/Q _15755_/B VDD VSS _15464_/B XNOR2X1
X_11616_ _11616_/A _11641_/B VDD VSS _18786_/D NOR2X1
X_12596_ _19074_/Q wire158/Y _12804_/B VDD VSS _12803_/D XNOR3X1
X_14404_ _14381_/Y _14404_/B _14404_/C VDD VSS _19125_/D AND3BX1
X_18172_ _18174_/C _18172_/B VDD VSS _18173_/B XNOR2X1
X_15384_ _15691_/B VDD VSS _15385_/C INVX1
XFILLER_117_908 VDD VSS DECAPHV16
XFILLER_129_779 VDD VSS DECAPHV8
X_11547_ _18696_/Q _11555_/B VDD VSS _18723_/D AND2X1
X_14335_ _14339_/A _14335_/B VDD VSS _19063_/D NOR2X1
X_17123_ _19778_/Q _19746_/Q _17123_/C VDD VSS _17128_/C AO21X2
XFILLER_144_727 VSS VDD FILLER2
X_17054_ _17064_/A _17064_/B _17062_/D VDD VSS _17059_/C AOI21BX1
X_11478_ _18634_/Q _11484_/B VDD VSS _18661_/D AND2X1
X_14266_ _14294_/A _14266_/B _14266_/C VDD VSS _19004_/D NOR3X1
X_16005_ _16030_/A _16030_/B VDD VSS _16874_/B XNOR2X1
X_10429_ _18555_/Q _10503_/A _10433_/B VDD VSS _10431_/C XOR3X1
X_13217_ _14323_/A _14323_/B VDD VSS _13269_/B NAND2X1
X_14197_ _14197_/A _14197_/B VDD VSS _18947_/D AND2X1
XFILLER_111_112 VDD VSS FILLER4
XFILLER_112_624 VDD VSS DECAPHV8
X_13148_ _13150_/D _13255_/C _13255_/A VDD VSS _13152_/B NAND3BX1
XFILLER_32_4 VDD VSS FILLER4
XFILLER_97_357 VDD VSS DECAPHV8
XFILLER_112_679 VDD VSS FILLER4
X_13079_ _13283_/A _17891_/B VDD VSS _18855_/D AND2X1
X_17956_ wire152/Y _17957_/C _17957_/A VDD VSS _17958_/C OAI21X1
XFILLER_111_189 VDD VSS FILLER1
XFILLER_120_690 VDD VSS FILLER1
X_17887_ _17891_/C _17888_/B _17917_/C VDD VSS _17888_/C OAI21X1
X_16907_ _20016_/Q _16906_/Y _20065_/Q VDD VSS _16907_/Y MUXI2X1
XFILLER_38_468 VDD VSS FILLER4
XFILLER_54_906 VDD VSS DECAPHV8
XFILLER_65_254 VDD VSS FILLER1
XFILLER_66_777 VDD VSS FILLER4
X_19626_ _19671_/CK _19626_/D _19626_/Q VDD VSS DFFQX1
X_16838_ _16838_/A _16838_/B VDD VSS _19679_/D NOR2X1
XFILLER_81_747 VDD VSS DECAPHV8
XTAP_TAPCELL_ROW_76_772 VDD VSS WELLTAP
X_19557_ _19591_/CK _19557_/D _19557_/Q VDD VSS DFFQX1
X_16769_ _16775_/A _16769_/B VDD VSS _19617_/D NOR2X1
XFILLER_18_192 VDD VSS FILLER1
XFILLER_34_641 VSS VDD FILLER2
XFILLER_80_235 VDD VSS DECAPHV32
XTAP_TAPCELL_ROW_48_496 VDD VSS WELLTAP
X_09310_ _20080_/RB _09346_/B VDD VSS _09310_/Y NOR2BX1
X_18508_ _18508_/CK _18508_/D _18508_/Q _09353_/Y VDD VSS DFFRQX1
XFILLER_21_302 VSS VDD FILLER2
XFILLER_22_825 VDD VSS FILLER1
XFILLER_34_696 VDD VSS FILLER1
X_19488_ _19489_/CK _19488_/D _19488_/Q VDD VSS DFFQX1
X_09241_ _18525_/Q VDD VSS _18344_/D INVX1
X_18439_ _18439_/CK _18524_/Q _18439_/Q _18465_/RB VDD VSS DFFRQX1
XTAP_TAPCELL_ROW_31_330 VDD VSS WELLTAP
XFILLER_119_223 VDD VSS DECAPHV16
XFILLER_119_278 VDD VSS FILLER1
XFILLER_134_204 VDD VSS FILLER4
XFILLER_119_289 VDD VSS FILLER4
Xoutput29 _20113_/Y VDD VSS o_bias_cfg[15] BUFX3
Xoutput18 _20087_/Y VDD VSS o_aux_ctrl[5] BUFX3
XFILLER_0_228 VDD VSS FILLER1
XFILLER_88_324 VDD VSS FILLER1
XFILLER_89_858 VDD VSS DECAPHV8
X_20194_ _20194_/A VDD VSS _20194_/Y BUFX3
XFILLER_130_421 VDD VSS DECAPHV16
XFILLER_88_335 VDD VSS DECAPHV8
XFILLER_88_357 VDD VSS DECAPHV8
XFILLER_111_690 VDD VSS FILLER4
XFILLER_56_210 VDD VSS FILLER1
XFILLER_56_26 VDD VSS DECAPHV8
XFILLER_57_755 VDD VSS FILLER1
XFILLER_45_928 VSS VDD FILLER2
XFILLER_56_243 VSS VDD FILLER2
XFILLER_57_777 VSS VDD FILLER2
XFILLER_44_438 VDD VSS FILLER1
XFILLER_56_298 VDD VSS FILLER1
X_09508_ _20015_/Q _20070_/Q VDD VSS _20070_/D NOR2BX1
XFILLER_112_98 VDD VSS DECAPHV16
XFILLER_72_36 VSS VDD FILLER2
X_10780_ _18564_/Q _10780_/B VDD VSS _10784_/B NOR2X1
XFILLER_13_836 VDD VSS FILLER1
X_09439_ _18505_/Q _09630_/C _18506_/Q VDD VSS _09787_/B NAND3BX1
XFILLER_40_655 VDD VSS FILLER1
XFILLER_40_677 VDD VSS FILLER4
X_12450_ _12451_/B _12451_/C _19070_/Q VDD VSS _12452_/B AOI21X1
X_11401_ _17566_/A VDD VSS _17827_/B BUFX3
X_12381_ _19182_/Q _14468_/B _14468_/C VDD VSS _12382_/D OR3BX1
X_14120_ _14142_/A _14120_/B VDD VSS _18879_/D NOR2X1
X_11332_ _18587_/Q _11336_/B VDD VSS _11337_/B XOR2X1
XFILLER_108_0 VSS VDD FILLER2
X_11263_ _11263_/A VDD VSS _11379_/A BUFX3
X_14051_ _18895_/Q _14138_/B VDD VSS _14101_/A NAND2X1
XFILLER_140_218 VDD VSS DECAPHV8
XFILLER_79_313 VSS VDD FILLER2
X_10214_ _10146_/Y _10213_/Y _10224_/A VDD VSS _10219_/B MUXI2X1
X_11194_ _11224_/C _11194_/B VDD VSS _11195_/B XNOR2X1
X_13002_ _14256_/B _14256_/C _18994_/Q VDD VSS _13004_/C AOI21X1
XFILLER_97_66 VDD VSS FILLER1
X_10145_ _10190_/B _10145_/B _10145_/C _10166_/D VDD VSS _10146_/C AOI211X1
X_17810_ _17809_/B _17810_/B VDD VSS _17813_/C NOR2BX1
XFILLER_0_751 VDD VSS FILLER4
XFILLER_48_700 VDD VSS FILLER1
XFILLER_79_368 VDD VSS FILLER4
X_18790_ _18817_/CK _18790_/D _18790_/Q VDD VSS DFFQX1
XFILLER_48_744 VDD VSS FILLER4
X_10076_ _10074_/Y _10076_/B _17172_/A VDD VSS _18534_/D AND3BX1
X_17741_ _19911_/Q _19879_/Q VDD VSS _17742_/B XOR2X1
X_14953_ _19366_/Q VDD VSS _14954_/A INVX1
X_13904_ _19033_/Q VDD VSS _13967_/C INVX1
X_17672_ _17672_/A VDD VSS _17673_/C INVX1
X_14884_ _19477_/Q _14884_/B _14884_/C VDD VSS _14920_/C XNOR3X1
XFILLER_35_416 VSS VDD FILLER2
XFILLER_63_747 VSS VDD FILLER2
X_13835_ _18975_/Q _14230_/B VDD VSS _13921_/D _14230_/C NAND3X1
X_19411_ _19466_/CK _19411_/D _19411_/Q VDD VSS DFFQX1
X_16623_ _19638_/Q _16792_/B _16623_/C VDD VSS _16649_/B OAI21X1
XFILLER_62_257 VSS VDD FILLER2
XTAP_TAPCELL_ROW_73_742 VDD VSS WELLTAP
XFILLER_15_151 VDD VSS DECAPHV16
XFILLER_16_674 VDD VSS FILLER4
XFILLER_43_460 VDD VSS FILLER4
XTAP_TAPCELL_ROW_45_466 VDD VSS WELLTAP
X_10978_ _18702_/Q _18756_/Q _10978_/C VDD VSS _11001_/C AO21X2
X_13766_ _19030_/Q _13766_/B _13783_/C VDD VSS _13889_/A XNOR3X1
X_19342_ _19551_/CK _19342_/D _19342_/Q VDD VSS DFFQX1
X_16554_ _16572_/B _16554_/B VDD VSS _16790_/B XNOR2X1
XFILLER_43_482 VDD VSS FILLER1
X_12717_ _12717_/A _12717_/B _12717_/C _12717_/D VDD VSS _12801_/B AOAI211X1
X_13697_ _14360_/B _14360_/C _19084_/Q VDD VSS _13699_/C AOI21X1
X_19273_ _20008_/CK _19273_/D _19273_/Q VDD VSS DFFQX1
X_16485_ _19697_/Q _16858_/B VDD VSS _16486_/B XNOR2X1
X_15505_ _19379_/Q _15756_/B VDD VSS _15541_/A NAND2X1
X_12648_ _12839_/A _12648_/B _12837_/C VDD VSS _12663_/C XNOR3X1
X_18224_ _18234_/CK _18224_/E _18224_/ECK VDD VSS CGX3
X_15436_ _19543_/Q _15439_/B VDD VSS _15475_/B NOR2BX1
XFILLER_8_840 VDD VSS FILLER1
X_18155_ _19297_/Q _18155_/B VDD VSS _18159_/B NOR2X1
XFILLER_30_198 VDD VSS DECAPHV8
X_12579_ _12583_/A _12677_/B _12583_/B VDD VSS _14535_/C NOR3X1
X_17106_ _17390_/A _17106_/B VDD VSS _19775_/D NOR2X1
X_15367_ _15393_/A _15393_/B VDD VSS _15816_/B XNOR2X1
X_14318_ _14339_/A _14318_/B VDD VSS _19048_/D NOR2X1
X_18086_ _19284_/Q _18089_/B VDD VSS _18090_/C XNOR2X1
X_15298_ _19319_/Q VDD VSS _15340_/A INVX1
XFILLER_125_760 VDD VSS DECAPHV8
X_14249_ _14270_/A _14249_/B VDD VSS _18989_/D AND2X1
X_17037_ _17040_/B _17037_/B VDD VSS _17038_/B XOR2X1
XFILLER_125_793 VSS VDD FILLER2
XFILLER_112_421 VDD VSS DECAPHV8
XFILLER_86_806 VDD VSS FILLER4
X_09790_ _20079_/Q _09818_/B VDD VSS _09791_/D NAND2X1
X_18988_ _19037_/CK _18988_/D _18988_/Q VDD VSS DFFQX1
X_17939_ _17940_/B _17940_/C _17940_/A VDD VSS _17941_/C OAI21X1
XFILLER_38_243 VDD VSS FILLER1
XFILLER_66_552 VDD VSS FILLER4
XFILLER_81_511 VDD VSS FILLER1
XFILLER_93_371 VDD VSS FILLER1
X_19609_ _19673_/CK _19609_/D _19609_/Q VDD VSS DFFQX1
XFILLER_19_490 VDD VSS FILLER4
XFILLER_81_555 VSS VDD FILLER2
XTAP_TAPCELL_ROW_127_1288 VDD VSS WELLTAP
XTAP_TAPCELL_ROW_140_1411 VDD VSS WELLTAP
Xclkbuf_0__002_ _232_/ECK VDD VSS clkbuf_0__002_/Y BUFX12
XFILLER_41_419 VDD VSS FILLER1
XFILLER_81_599 VDD VSS DECAPHV8
XFILLER_22_622 VSS VDD FILLER2
XFILLER_42_39 VDD VSS FILLER1
X_09224_ _18496_/D VDD VSS _18384_/D INVX1
XFILLER_21_165 VDD VSS FILLER1
Xclkbuf_leaf_13_clk_regs clkbuf_leaf_9_clk_regs/A VDD VSS _19792_/CK BUFX12
XFILLER_108_749 VDD VSS FILLER1
XFILLER_135_513 VDD VSS FILLER4
XTAP_TAPCELL_ROW_138_1395 VDD VSS WELLTAP
XFILLER_135_568 VDD VSS FILLER4
XFILLER_116_771 VSS VDD FILLER2
XFILLER_116_793 VDD VSS DECAPHV8
Xclkbuf_leaf_17__001_ clkbuf_2_3__f__001_/Y VDD VSS _18950_/CK BUFX12
XFILLER_103_443 VDD VSS FILLER4
XFILLER_115_270 VDD VSS FILLER4
XFILLER_1_548 VSS VDD FILLER2
XFILLER_88_132 VDD VSS FILLER4
XFILLER_130_262 VDD VSS FILLER1
XFILLER_67_25 VDD VSS FILLER1
XFILLER_77_817 VDD VSS DECAPHV16
X_09988_ _10017_/B _09987_/Y _10032_/A VDD VSS _09989_/B MUXI2X1
X_20177_ _20177_/A VDD VSS _20177_/Y BUFX3
XFILLER_131_796 VDD VSS FILLER1
XFILLER_29_221 VDD VSS DECAPHV8
XFILLER_69_390 VDD VSS FILLER1
XFILLER_29_254 VDD VSS FILLER1
XFILLER_57_552 VDD VSS FILLER4
XTAP_TAPCELL_ROW_87_889 VDD VSS WELLTAP
X_11950_ _11950_/A _11950_/B _14271_/B VDD VSS _12012_/B MIN3X1
XFILLER_44_202 VDD VSS FILLER1
XFILLER_45_714 VDD VSS FILLER4
XFILLER_84_360 VDD VSS DECAPHV16
X_10901_ _10936_/C _10902_/B _11226_/A VDD VSS _10902_/C AOI21X1
XFILLER_17_438 VSS VDD FILLER2
XFILLER_44_224 VDD VSS FILLER1
XFILLER_44_235 VSS VDD FILLER2
XFILLER_45_747 VDD VSS FILLER4
X_11881_ wire165/Y _11881_/B _11881_/C _11881_/D VDD VSS _14525_/C AOAI211X1
XFILLER_16_51 VDD VSS FILLER1
XFILLER_44_279 VDD VSS DECAPHV16
XFILLER_72_566 VDD VSS DECAPHV8
XTAP_TAPCELL_ROW_70_712 VDD VSS WELLTAP
X_10832_ _10871_/A _10871_/B _10832_/C _10832_/D VDD VSS _10837_/C AOI31X1
X_13620_ _13620_/A _13620_/B _13620_/C _13620_/D VDD VSS _13721_/A AOAI211X1
XFILLER_16_95 VDD VSS FILLER1
XFILLER_53_791 VDD VSS FILLER4
XTAP_TAPCELL_ROW_104_1052 VDD VSS WELLTAP
XTAP_TAPCELL_ROW_42_436 VDD VSS WELLTAP
X_10763_ _10763_/A VDD VSS _11229_/D BUFX3
X_13551_ _13640_/A _13640_/B VDD VSS _13562_/B NOR2X1
X_12502_ _12659_/A _12755_/A _12837_/B VDD VSS _12566_/C XNOR3X1
X_16270_ _16278_/B _16270_/B VDD VSS _16885_/B XNOR2X1
XFILLER_13_699 VSS VDD FILLER2
XFILLER_9_648 VSS VDD FILLER2
X_10694_ _10692_/Y _10694_/B wire170/A VDD VSS _10695_/E AND3BX1
X_13482_ _18943_/Q _13490_/B _13586_/C VDD VSS _13498_/B XNOR3X1
X_15221_ _15221_/A _15749_/B _15221_/C VDD VSS _15260_/B OAI21X1
XFILLER_32_61 VSS VDD FILLER2
XFILLER_32_72 VSS VDD FILLER2
XTAP_TAPCELL_ROW_3_43 VDD VSS WELLTAP
X_12433_ _18877_/Q VDD VSS _12612_/A INVX1
XFILLER_126_535 VDD VSS FILLER4
X_12364_ _12544_/A _12544_/B VDD VSS _14344_/B XNOR2X1
X_15152_ _15191_/A _15191_/B _15154_/A _15191_/D VDD VSS _15183_/C OAI211X1
XFILLER_126_579 VDD VSS FILLER4
X_11315_ _18585_/Q _11315_/B VDD VSS _11316_/C NAND2X1
X_14103_ _17964_/B _17964_/C _14141_/B _18898_/Q _14103_/E VDD VSS _17977_/B AOI221X1
X_19960_ _19963_/CK _19960_/D _19960_/Q VDD VSS DFFQX1
X_15083_ _15072_/A _15083_/B _15083_/C VDD VSS _15137_/A AOI2B1X1
XFILLER_107_793 VDD VSS FILLER1
XTAP_TAPCELL_ROW_115_1170 VDD VSS WELLTAP
X_12295_ _12512_/B _12366_/B _12366_/C VDD VSS _12360_/A AOI21X1
X_14034_ _18978_/Q _14233_/B VDD VSS _14036_/C _14233_/C NAND3X1
X_18911_ _18936_/CK _18911_/D _18911_/Q VDD VSS DFFQX1
XFILLER_106_281 VDD VSS FILLER1
XFILLER_4_397 VDD VSS FILLER1
X_11246_ _11019_/B _11330_/B _11289_/A VDD VSS _11264_/B MUXI2X1
X_19891_ clkload8/A _19891_/D _19891_/Q VDD VSS DFFQX1
XFILLER_68_839 VSS VDD FILLER2
X_11177_ _11226_/D _11177_/B _11197_/C VDD VSS _11178_/E NOR3X1
X_18842_ _19963_/CK _18842_/D _18842_/Q VDD VSS DFFQX1
XFILLER_94_124 VDD VSS FILLER1
X_10128_ _11435_/A _11196_/A _10154_/B VDD VSS _10175_/B NOR3X1
X_18773_ _18773_/CK _18773_/D _18773_/Q VDD VSS DFFQX1
X_15985_ _19676_/Q _16835_/B _15985_/C VDD VSS _16013_/A OAI21X1
X_10059_ _10167_/A _10059_/B _10059_/C VDD VSS _10159_/B AOI21X1
X_17724_ _17726_/C _17724_/B _17724_/C VDD VSS _19907_/D AOI21X1
X_14936_ _14959_/A _14959_/B _14959_/D _14959_/C VDD VSS _15805_/C OAI211X1
XFILLER_63_511 VDD VSS FILLER4
XFILLER_35_235 VDD VSS FILLER1
XFILLER_63_544 VDD VSS FILLER1
XTAP_TAPCELL_ROW_58_591 VDD VSS WELLTAP
X_17655_ _17655_/A _17657_/C _17655_/C VDD VSS _19892_/D AOI21X1
X_14867_ _14867_/A _14867_/B _14867_/C _14867_/D VDD VSS _14959_/A OAOI211X1
XFILLER_91_886 VDD VSS FILLER1
X_13818_ _13818_/A _13818_/B _13818_/C _13818_/D VDD VSS _14166_/B OAOI211X1
X_17586_ _17589_/A _17586_/B _17586_/C VDD VSS _19877_/D AOI21X1
X_16606_ _16606_/A _16606_/B _16606_/C VDD VSS _16607_/B NOR3X1
X_14798_ _19363_/Q _15738_/B VDD VSS _14801_/A XOR2X1
XFILLER_16_482 VDD VSS FILLER4
XFILLER_32_920 VSS VDD FILLER2
XFILLER_90_396 VDD VSS FILLER1
X_13749_ _18918_/Q _13918_/A _13918_/B VDD VSS _13751_/C XNOR3X1
X_19325_ _19358_/CK _19325_/D _19325_/Q VDD VSS DFFQX1
X_16537_ _16537_/A _16537_/B VDD VSS _16538_/B _16537_/C NAND3X1
X_19256_ _19992_/CK _19256_/D _19256_/Q VDD VSS DFFQX1
X_16468_ _19696_/Q _16857_/B VDD VSS _16469_/D NAND2BX1
X_19187_ _19187_/CK _19187_/D _19187_/Q VDD VSS DFFQX1
X_16399_ _16420_/B _16399_/B VDD VSS _16784_/B XNOR2X1
X_15419_ _15419_/A _15422_/B VDD VSS _18138_/B XNOR2X1
X_18138_ _19293_/Q _18138_/B VDD VSS _18139_/A NAND2X1
XFILLER_144_343 VDD VSS DECAPHV16
X_18069_ _18069_/A _18069_/B _18069_/C VDD VSS _18074_/A AO21X2
X_09911_ _11014_/A _09911_/B VDD VSS _09912_/C NAND2X1
X_20100_ _20100_/A VDD VSS _20100_/Y BUFX3
XFILLER_98_441 VSS VDD FILLER2
XFILLER_98_474 VDD VSS FILLER1
X_09842_ _18565_/Q _09878_/B VDD VSS _09881_/B NOR2BX1
X_20031_ _20045_/CK _20031_/D _20031_/Q _20031_/RB VDD VSS DFFRQX1
Xclkbuf_1_1__f__09165_ clkbuf_0__09165_/Y VDD VSS _18439_/CK BUFX12
XTAP_TAPCELL_ROW_129_1306 VDD VSS WELLTAP
X_09773_ _20129_/A _09788_/B _09773_/C _09776_/A VDD VSS _09776_/C AOAI211X1
XFILLER_39_552 VDD VSS FILLER1
XFILLER_73_308 VDD VSS FILLER1
XFILLER_85_168 VSS VDD FILLER2
XFILLER_82_831 VDD VSS FILLER4
XFILLER_66_382 VDD VSS DECAPHV8
XFILLER_81_341 VDD VSS FILLER4
XFILLER_82_853 VDD VSS FILLER4
XTAP_TAPCELL_ROW_84_859 VDD VSS WELLTAP
XFILLER_136_800 VDD VSS FILLER1
XFILLER_6_607 VDD VSS FILLER4
X_09207_ _18512_/Q VDD VSS _18427_/D INVX1
XFILLER_5_106 VDD VSS FILLER1
X_11100_ _18653_/Q _18815_/Q VDD VSS _11101_/B XOR2X1
XFILLER_104_730 VDD VSS DECAPHV8
XFILLER_116_590 VDD VSS FILLER1
X_12080_ _12080_/A _12080_/B _14338_/B VDD VSS _12081_/B MIN3X1
XFILLER_2_879 VDD VSS FILLER1
X_11031_ _18651_/Q _18813_/Q VDD VSS _11032_/B XOR2X1
XFILLER_131_571 VDD VSS DECAPHV8
XFILLER_134_63 VDD VSS FILLER1
XFILLER_58_894 VDD VSS FILLER1
XTAP_TAPCELL_ROW_19_208 VDD VSS WELLTAP
X_12982_ _12994_/B _12994_/C VDD VSS _14217_/B AND2X1
X_15770_ _15770_/A _15770_/B VDD VSS _19392_/D AND2X1
XFILLER_57_393 VDD VSS FILLER1
X_11933_ _11933_/A _14525_/B _11933_/C _11933_/D VDD VSS _11934_/A AO31X2
X_14721_ _19361_/Q _15736_/B VDD VSS _14722_/B XOR2X1
XFILLER_60_514 VDD VSS FILLER1
XFILLER_72_352 VDD VSS FILLER1
XTAP_TAPCELL_ROW_55_561 VDD VSS WELLTAP
X_11864_ _11864_/A _11864_/B _14366_/B VDD VSS _11867_/B MIN3X1
X_14652_ _14652_/A _14652_/B _14652_/C _14652_/D VDD VSS _14739_/B AOAI211X1
X_17440_ _17441_/C _17469_/B _17440_/C VDD VSS _19846_/D AND3BX1
XFILLER_14_920 VSS VDD FILLER2
XTAP_TAPCELL_ROW_27_285 VDD VSS WELLTAP
X_10815_ _10813_/Y _10851_/B _11431_/A VDD VSS _18565_/D AND3BX1
X_13603_ _19055_/Q _14326_/B VDD VSS _13604_/D _14326_/C NAND3X1
X_17371_ _19832_/Q _19800_/Q VDD VSS _17377_/A XNOR2X1
X_11795_ _11828_/A _11828_/B VDD VSS _14489_/B XNOR2X1
X_14583_ _19493_/Q _15886_/B VDD VSS _14601_/B NAND2X1
Xclkbuf_1_0__f__09185_ clkbuf_0__09185_/Y VDD VSS _18479_/CK BUFX12
X_19110_ _19137_/CK _19110_/D _19110_/Q VDD VSS DFFQX1
X_16322_ _19659_/Q _16817_/B VDD VSS _16348_/B XOR2X1
X_10746_ _10947_/A _10746_/B _10746_/C VDD VSS _10746_/Y AOI21X1
X_13534_ _13623_/A _13696_/B VDD VSS _14359_/B XNOR2X1
XFILLER_71_8 VSS VDD FILLER2
X_10677_ _18668_/Q _18776_/Q VDD VSS _10721_/A NAND2X1
X_13465_ _19222_/Q _14515_/B VDD VSS _13557_/A NOR2X1
X_19041_ _19096_/CK _19041_/D _19041_/Q VDD VSS DFFQX1
X_16253_ _16243_/A _16253_/B VDD VSS _16267_/B NOR2BX1
X_12416_ _19156_/Q _12416_/B _12472_/D VDD VSS _12553_/C XNOR3X1
X_16184_ _19909_/Q VDD VSS _16703_/A INVX1
X_15204_ _15812_/B _15812_/C _15204_/C VDD VSS _15205_/B OA21X2
XFILLER_126_332 VDD VSS FILLER1
XFILLER_126_354 VSS VDD FILLER2
X_13396_ _13594_/A _13401_/C VDD VSS _14224_/B XNOR2X1
X_15135_ _19398_/Q _15777_/B VDD VSS _15137_/B NOR2X1
XFILLER_127_888 VSS VDD FILLER2
X_12347_ _18874_/Q VDD VSS _12349_/A INVX1
XFILLER_4_43 VSS VDD FILLER2
X_12278_ _12278_/A _12278_/B _14246_/B VDD VSS _12356_/B MIN3X1
X_19943_ _19957_/CK _19943_/D _19943_/Q VDD VSS DFFQX1
X_15066_ _19453_/Q _15112_/A _15085_/B VDD VSS _15092_/D XNOR3X1
XFILLER_68_603 VDD VSS FILLER1
X_11229_ _11229_/A _11229_/B _11229_/C _11229_/D _11229_/E VDD VSS _11230_/B OAI221X1
X_14017_ _18895_/Q _14085_/A _14085_/B VDD VSS _14018_/D XNOR3X1
X_19874_ _19907_/CK _19874_/D _19874_/Q VDD VSS DFFQX1
X_18825_ _19947_/CK _18825_/D _18825_/Q VDD VSS DFFQX1
XFILLER_68_658 VSS VDD FILLER2
XFILLER_64_820 VSS VDD FILLER2
XFILLER_83_639 VDD VSS FILLER1
X_18756_ _18785_/CK _18756_/D _18756_/Q VDD VSS DFFQX1
X_15968_ _19614_/Q _16766_/B VDD VSS _15971_/A XNOR2X1
XFILLER_82_138 VDD VSS FILLER1
X_18687_ _18797_/CK _18687_/D _18687_/Q VDD VSS DFFQX1
X_17707_ _17705_/B _17707_/B VDD VSS _17708_/C NOR2BX1
X_15899_ _15906_/A _15899_/B VDD VSS _19505_/D NOR2X1
X_14919_ _19477_/Q _15868_/B _15868_/C VDD VSS _14920_/D NOR3BX1
XFILLER_36_566 VDD VSS FILLER4
XFILLER_36_577 VSS VDD FILLER2
XFILLER_91_650 VDD VSS FILLER1
XTAP_TAPCELL_ROW_124_1258 VDD VSS WELLTAP
XTAP_TAPCELL_ROW_81_829 VDD VSS WELLTAP
X_17638_ _17638_/A _17638_/B _17638_/C VDD VSS _17646_/A OA21X2
XFILLER_23_19 VDD VSS FILLER4
XFILLER_90_0 VDD VSS FILLER4
Xclkbuf_leaf_16__002_ clkload17/A VDD VSS _18817_/CK BUFX12
X_17569_ _17570_/B _17569_/B VDD VSS _17571_/B NOR2BX1
X_19308_ _19322_/CK _19308_/D _19308_/Q VDD VSS DFFQX1
XFILLER_31_282 VDD VSS FILLER4
X_19239_ _19242_/CK _19239_/D _19239_/Q VDD VSS DFFQX1
XFILLER_118_833 VDD VSS FILLER1
XFILLER_117_332 VDD VSS FILLER1
XFILLER_117_343 VDD VSS FILLER1
XFILLER_118_855 VDD VSS DECAPHV8
XTAP_TAPCELL_ROW_135_1365 VDD VSS WELLTAP
XFILLER_133_858 VDD VSS FILLER1
XFILLER_87_912 VSS VDD FILLER2
XTAP_TAPCELL_ROW_89_907 VDD VSS WELLTAP
XFILLER_86_400 VSS VDD FILLER2
X_09825_ _11039_/C VDD VSS _11208_/A BUFX3
X_20014_ clkload6/A _20014_/D _20014_/Q _20031_/RB VDD VSS DFFRQX1
XFILLER_104_44 VSS VDD FILLER2
XFILLER_39_371 VDD VSS FILLER1
XFILLER_46_319 VDD VSS FILLER1
XFILLER_58_179 VDD VSS FILLER1
XFILLER_86_477 VSS VDD FILLER2
XTAP_TAPCELL_ROW_97_984 VDD VSS WELLTAP
X_09756_ _18307_/Q _09812_/B _09784_/B _18467_/Q VDD VSS _09759_/A AOI22X1
Xclkbuf_0__09179_ _18228_/ECK VDD VSS clkbuf_0__09179_/Y BUFX12
X_09687_ _18399_/Q VDD VSS _20140_/A INVX1
XFILLER_15_728 VDD VSS FILLER1
XFILLER_14_238 VDD VSS DECAPHV8
XFILLER_27_588 VDD VSS DECAPHV16
XFILLER_42_514 VDD VSS FILLER4
XFILLER_42_525 VDD VSS FILLER4
XFILLER_54_385 VDD VSS FILLER1
XFILLER_82_683 VDD VSS FILLER1
XFILLER_82_694 VSS VDD FILLER2
XTAP_TAPCELL_ROW_101_1022 VDD VSS WELLTAP
XTAP_TAPCELL_ROW_52_531 VDD VSS WELLTAP
XTAP_TAPCELL_ROW_24_255 VDD VSS WELLTAP
X_10600_ _10649_/A _10649_/B _10601_/C _10763_/A VDD VSS _10601_/D AOI31X1
X_11580_ _18726_/Q _11589_/B VDD VSS _18753_/D AND2X1
XFILLER_7_916 VDD VSS FILLER4
X_10531_ _19944_/Q _18826_/Q VDD VSS _10556_/B XOR2X1
XFILLER_13_74 VDD VSS FILLER4
XFILLER_7_949 VDD VSS FILLER1
X_13250_ _13329_/A _13329_/B VDD VSS _14479_/C _13329_/C NAND3X1
XFILLER_108_321 VDD VSS FILLER4
XFILLER_136_652 VDD VSS FILLER1
XFILLER_13_96 VDD VSS DECAPHV8
X_10462_ _10462_/A _10462_/B _10462_/C _10462_/D VDD VSS _10535_/B AND4X2
X_12201_ _18985_/Q _12201_/B _12201_/C VDD VSS _12278_/B MIN3X1
XFILLER_123_302 VDD VSS FILLER4
X_10393_ _11378_/A _10393_/B _10431_/B VDD VSS _18554_/D AND3BX1
X_13181_ _13181_/A _13181_/B _14122_/B VDD VSS _13182_/B MIN3X1
XFILLER_124_858 VSS VDD FILLER2
XTAP_TAPCELL_ROW_0_11 VDD VSS WELLTAP
X_12132_ _12132_/A _12132_/B _14242_/B VDD VSS _12201_/B MIN3X1
XFILLER_111_508 VDD VSS FILLER1
XFILLER_123_368 VDD VSS FILLER4
XTAP_TAPCELL_ROW_112_1140 VDD VSS WELLTAP
X_12063_ _19095_/Q _12255_/B _12137_/C VDD VSS _12284_/C XNOR3X1
X_16940_ _16976_/A _16940_/B VDD VSS _19743_/D NOR2X1
X_11014_ _11014_/A _11014_/B _11014_/C VDD VSS _11014_/Y AOI21X1
XFILLER_93_904 VDD VSS FILLER1
X_16871_ _16876_/A _16871_/B VDD VSS _19708_/D NOR2X1
XFILLER_77_488 VDD VSS FILLER4
X_19590_ _19673_/CK _19590_/D _19590_/Q VDD VSS DFFQX1
X_18610_ _18622_/CK _18610_/D _18610_/Q VDD VSS DFFQX1
X_15822_ _15849_/A _15822_/B VDD VSS _19437_/D AND2X1
X_12965_ _12968_/D _14539_/B VDD VSS _13133_/A NAND2X1
X_18541_ _18543_/CK _18541_/D _18541_/Q VDD VSS DFFQX1
X_15753_ _15770_/A _15753_/B VDD VSS _19376_/D AND2X1
XFILLER_46_886 VDD VSS DECAPHV8
XFILLER_92_469 VDD VSS FILLER1
X_11916_ _11916_/A _11916_/B _11916_/C _11916_/D VDD VSS _11922_/B AOAI211X1
X_14704_ _14737_/A _14737_/B _14737_/C VDD VSS _14775_/A OA21X2
XFILLER_18_599 VDD VSS FILLER4
XFILLER_33_525 VDD VSS FILLER1
XFILLER_45_396 VDD VSS FILLER1
X_12896_ _12896_/A _12896_/B _12896_/C _12896_/D VDD VSS _12900_/B OAOI211X1
X_18472_ _18479_/CK _18525_/Q _20117_/A _20078_/RB VDD VSS DFFRQX1
X_15684_ _15706_/A _15684_/B VDD VSS _19313_/D AND2X1
XFILLER_54_92 VDD VSS FILLER1
X_11847_ _19175_/Q _11918_/A _11918_/B VDD VSS _11874_/D XNOR3X1
X_14635_ _19414_/Q _14635_/B _14635_/C VDD VSS _14669_/B MIN3X1
X_17423_ _19843_/Q _19811_/Q VDD VSS _17425_/B XOR2X1
XFILLER_60_388 VDD VSS DECAPHV8
X_11778_ _11778_/A _11778_/B _11778_/C _11778_/D VDD VSS _11804_/B OAOI211X1
X_14566_ _20005_/Q _14569_/B VDD VSS _19269_/D AND2X1
X_17354_ _17355_/A _17357_/C _17363_/C VDD VSS _17355_/C OAI21X1
XFILLER_13_282 VDD VSS DECAPHV8
XFILLER_9_220 VSS VDD FILLER2
X_10729_ _18695_/Q _18749_/Q _10729_/C _10729_/D _10729_/E VDD VSS _10765_/C AOI221X1
X_13517_ _13607_/A _13683_/B VDD VSS _14261_/B XNOR2X1
Xclkbuf_1_0__f__09168_ clkbuf_0__09168_/Y VDD VSS _18390_/CK BUFX12
X_17285_ _17289_/A _17286_/B _17306_/C VDD VSS _17286_/C OAI21X1
X_16305_ _16305_/A _16305_/B VDD VSS _16332_/B NAND2X1
XFILLER_9_275 VDD VSS FILLER1
X_14497_ _15817_/A VDD VSS _14539_/A BUFX3
X_19024_ _19050_/CK _19024_/D _19024_/Q VDD VSS DFFQX1
X_16236_ _16236_/A _19911_/Q _16236_/C VDD VSS _16258_/C MIN3X1
XFILLER_62_4 VDD VSS DECAPHV16
X_13448_ _19222_/Q _13462_/B _13464_/B VDD VSS _13457_/D XNOR3X1
Xclkload34 _18828_/CK VDD VSS clkload34/Y INVX4
Xclkload23 _19963_/CK VDD VSS clkload23/Y INVX1
Xclkload12 _19828_/CK VDD VSS clkload12/Y INVX1
X_13379_ _13502_/A _13578_/B VDD VSS _13496_/C XNOR2X1
Xclkload78 clkload78/A VDD VSS clkload78/Y BUFX12
Xclkload67 _19171_/CK VDD VSS clkload67/Y INVX1
Xclkload56 _19045_/CK VDD VSS clkload56/Y INVX1
Xclkload45 _19250_/CK VDD VSS clkload45/Y INVX2
X_16167_ _16177_/A _16177_/B VDD VSS _16846_/B XNOR2X1
XFILLER_114_313 VDD VSS FILLER4
XFILLER_5_470 VDD VSS FILLER1
Xclkload89 _19385_/CK VDD VSS clkload89/Y INVX1
X_16098_ _19714_/Q _16878_/B VDD VSS _16103_/B XOR2X1
X_15118_ _19398_/Q _15777_/B VDD VSS _15119_/B XNOR2X1
XFILLER_102_508 VSS VDD FILLER2
XFILLER_130_806 VSS VDD FILLER2
XFILLER_48_2 VDD VSS FILLER1
X_19926_ clkload8/A _19926_/D _19926_/Q VDD VSS DFFQX1
X_15049_ _19452_/Q _15837_/B _15837_/C VDD VSS _15092_/C NOR3BX1
XFILLER_87_219 VDD VSS FILLER1
XFILLER_96_720 VDD VSS FILLER1
XFILLER_96_731 VDD VSS FILLER1
X_18206__252 _18259_/CK VDD VSS _18258_/CK INVX1
X_19857_ _19892_/CK _19857_/D _19857_/Q VDD VSS DFFQX1
XFILLER_56_628 VDD VSS FILLER1
XFILLER_68_499 VDD VSS FILLER4
X_09610_ _09816_/D _20183_/A VDD VSS _09611_/C NAND2X1
X_19788_ _19795_/CK _19788_/D _19788_/Q VDD VSS DFFQX1
X_18808_ _18809_/CK _18808_/D _18808_/Q VDD VSS DFFQX1
XTAP_TAPCELL_ROW_94_954 VDD VSS WELLTAP
X_09541_ _20035_/Q _09547_/B VDD VSS _20036_/D NOR2BX1
X_18739_ _18768_/CK _18739_/D _18739_/Q VDD VSS DFFQX1
XFILLER_36_341 VDD VSS FILLER4
XFILLER_48_190 VDD VSS FILLER1
XTAP_TAPCELL_ROW_66_678 VDD VSS WELLTAP
XFILLER_36_396 VDD VSS FILLER1
XFILLER_52_845 VDD VSS FILLER1
XFILLER_63_160 VDD VSS FILLER1
XFILLER_63_182 VDD VSS FILLER4
XFILLER_64_694 VSS VDD FILLER2
X_09472_ _19975_/Q _09490_/B _09476_/C VDD VSS _09473_/C AOI21X1
XFILLER_51_344 VSS VDD FILLER2
XFILLER_51_377 VDD VSS FILLER1
XFILLER_138_917 VDD VSS DECAPHV32
XTAP_TAPCELL_ROW_21_225 VDD VSS WELLTAP
XFILLER_50_39 VDD VSS FILLER4
Xclkload6 clkload6/A VDD VSS clkload6/Y INVX1
XFILLER_118_630 VSS VDD FILLER2
XFILLER_119_8 VSS VDD FILLER2
XFILLER_133_622 VDD VSS FILLER1
XFILLER_133_633 VDD VSS FILLER1
XFILLER_106_869 VDD VSS FILLER4
XFILLER_1_8 VDD VSS FILLER4
XFILLER_114_880 VSS VDD FILLER2
XFILLER_59_422 VSS VDD FILLER2
XFILLER_87_720 VSS VDD FILLER2
Xfanout221 _20081_/RB VDD VSS _18496_/RB BUFX3
Xfanout210 _20051_/RB VDD VSS _09362_/AB BUFX3
XFILLER_59_444 VDD VSS FILLER1
XFILLER_47_617 VSS VDD FILLER2
XFILLER_75_948 VSS VDD FILLER2
X_09808_ _18343_/Q VDD VSS _20097_/A INVX1
XFILLER_75_58 VDD VSS FILLER4
XTAP_TAPCELL_ROW_29_303 VDD VSS WELLTAP
X_09739_ _20111_/A _20127_/A _09776_/A VDD VSS _09740_/C MUXI2X1
XFILLER_43_801 VDD VSS FILLER1
XFILLER_27_385 VDD VSS DECAPHV16
XFILLER_28_897 VSS VDD FILLER2
XFILLER_82_480 VDD VSS FILLER4
X_12750_ _12832_/A _12832_/B _12832_/C VDD VSS _14508_/B AOI21X1
X_11701_ _19989_/Q _19253_/Q VDD VSS _11742_/A NAND2X1
X_12681_ _12832_/B _12682_/C _19214_/Q VDD VSS _12683_/C AOI21X1
X_11632_ _18774_/Q _11635_/B VDD VSS _18801_/D AND2X1
X_14420_ _14381_/Y _14420_/B _14420_/C VDD VSS _19139_/D AND3BX1
XFILLER_138_0 VDD VSS DECAPHV16
XFILLER_23_580 VDD VSS FILLER1
X_14351_ _14415_/A _14351_/B VDD VSS _19077_/D AND2X1
XFILLER_10_252 VDD VSS FILLER1
XFILLER_129_939 VDD VSS DECAPHV8
XFILLER_24_95 VDD VSS FILLER1
X_11563_ _18711_/Q _11567_/B VDD VSS _18738_/D AND2X1
X_13302_ _13395_/A _13395_/B VDD VSS _13400_/C _13395_/C NAND3X1
X_10514_ _10514_/A _10514_/B _10514_/C _10514_/D VDD VSS _10570_/A AOAI211X1
X_11494_ _18649_/Q _11496_/B VDD VSS _18676_/D AND2X1
X_14282_ _14334_/A _14282_/B VDD VSS _19016_/D AND2X1
X_17070_ _17073_/C _17070_/B VDD VSS _17071_/B XNOR2X1
XFILLER_124_611 VDD VSS FILLER1
X_10445_ _19942_/Q _18824_/Q VDD VSS _10446_/A XNOR2X1
X_13233_ _13233_/A _14446_/B _13233_/C _13233_/D VDD VSS _13443_/A AOAI211X1
X_16021_ _19707_/Q _16870_/B VDD VSS _16022_/D NAND2X1
X_13164_ _13271_/A _13271_/B _13271_/C VDD VSS _13165_/C AO21X2
X_10376_ _18659_/Q _18767_/Q VDD VSS _10406_/A NAND2X1
X_12115_ _19179_/Q _14465_/B _14465_/C VDD VSS _12116_/D OR3BX1
X_13095_ _13095_/A _13095_/B _13095_/C _13095_/D VDD VSS _14290_/C OAI211X1
X_17972_ _17970_/Y _17972_/B _17986_/C VDD VSS _19960_/D AND3BX1
X_12046_ _19206_/Q _14495_/B VDD VSS _12113_/D _14495_/C NAND3X1
X_19711_ _19711_/CK _19711_/D _19711_/Q VDD VSS DFFQX1
X_16923_ _19738_/Q _19739_/Q wire163/Y VDD VSS _16928_/A MIN3X1
XFILLER_120_872 VDD VSS DECAPHV8
X_19642_ _19643_/CK _19642_/D _19642_/Q VDD VSS DFFQX1
X_16854_ _16859_/A _16854_/B VDD VSS _19693_/D AND2X1
X_15805_ _14522_/Y _15805_/B _15805_/C VDD VSS _19422_/D AND3BX1
XFILLER_1_66 VSS VDD FILLER2
X_13997_ _14038_/A _14169_/B VDD VSS _14054_/B NOR2X1
X_19573_ _19606_/CK _19573_/D _19573_/Q VDD VSS DFFQX1
X_16785_ _16793_/A _16785_/B VDD VSS _19631_/D AND2X1
XFILLER_45_160 VDD VSS DECAPHV16
XFILLER_92_277 VDD VSS FILLER1
XTAP_TAPCELL_ROW_91_924 VDD VSS WELLTAP
X_12948_ _13032_/A _14476_/B _14476_/C VDD VSS _13108_/C NOR3X1
X_18524_ _18524_/CK _18524_/D _18524_/Q _09304_/Y VDD VSS DFFRQX1
X_15736_ _15743_/A _15736_/B VDD VSS _19361_/D AND2X1
XFILLER_33_344 VSS VDD FILLER2
XTAP_TAPCELL_ROW_121_1228 VDD VSS WELLTAP
XTAP_TAPCELL_ROW_63_648 VDD VSS WELLTAP
X_12879_ _12886_/A _13180_/B _14153_/B VDD VSS _12885_/C XNOR3X1
X_18455_ _18455_/CK _18455_/D _18455_/Q _18455_/RB VDD VSS DFFRQX1
X_15667_ _15660_/A _15667_/B _15667_/C VDD VSS _15671_/C AOI2B1X1
XFILLER_61_686 VSS VDD FILLER2
X_14618_ _19495_/Q _15888_/B VDD VSS _14645_/A NAND2X1
X_17406_ _17675_/A _17406_/B VDD VSS _19839_/D NOR2X1
XFILLER_14_580 VSS VDD FILLER2
XFILLER_14_591 VDD VSS FILLER1
X_18386_ _18391_/CK _18386_/D _18386_/Q _20064_/RB VDD VSS DFFRQX1
X_15598_ _15823_/B _19438_/Q VDD VSS _15599_/D NAND2BX1
X_14549_ _19989_/Q _14558_/B VDD VSS _19253_/D AND2X1
X_17337_ _19824_/Q _19792_/Q VDD VSS _17338_/C NAND2X1
Xclkload112 _18565_/CK VDD VSS clkload112/Y INVX4
Xclkload101 _19696_/CK VDD VSS clkload101/Y INVX1
X_17268_ _19810_/Q _19778_/Q VDD VSS _17269_/B XOR2X1
XFILLER_115_600 VDD VSS DECAPHV8
Xclkload123 _18275_/CK VDD VSS clkload123/Y INVX2
X_19007_ _19172_/CK _19007_/D _19007_/Q VDD VSS DFFQX1
X_17199_ _19794_/Q _19762_/Q _17199_/C VDD VSS _17204_/C AO21X2
X_16219_ _16219_/A _16227_/B VDD VSS _16883_/B XNOR2X1
XFILLER_115_633 VSS VDD FILLER2
XTAP_TAPCELL_ROW_132_1335 VDD VSS WELLTAP
XFILLER_115_666 VSS VDD FILLER2
XFILLER_130_603 VDD VSS FILLER1
XFILLER_142_452 VSS VDD FILLER2
XFILLER_29_29 VDD VSS DECAPHV8
XFILLER_68_230 VSS VDD FILLER2
X_19909_ clkload9/A _19909_/D _19909_/Q VDD VSS DFFQX1
XFILLER_111_883 VDD VSS DECAPHV8
XFILLER_29_606 VDD VSS DECAPHV16
XFILLER_56_403 VDD VSS FILLER1
XFILLER_57_948 VSS VDD FILLER2
XFILLER_37_650 VDD VSS FILLER1
XFILLER_56_458 VDD VSS FILLER4
XFILLER_83_255 VDD VSS FILLER4
XFILLER_25_812 VSS VDD FILLER2
XFILLER_25_834 VSS VDD FILLER2
XFILLER_37_694 VDD VSS FILLER1
XFILLER_64_480 VDD VSS FILLER4
XTAP_TAPCELL_ROW_143_1442 VDD VSS WELLTAP
X_09524_ _20021_/Q _09526_/B _18197_/D VDD VSS _18202_/B AOI21X1
XFILLER_25_856 VSS VDD FILLER2
XFILLER_36_182 VDD VSS DECAPHV8
XFILLER_36_193 VDD VSS DECAPHV8
X_09455_ _18442_/D _09468_/B _09455_/C VDD VSS _18255_/D AOI21X1
XFILLER_101_56 VDD VSS DECAPHV8
XFILLER_40_837 VDD VSS DECAPHV16
X_09386_ _17906_/C VDD VSS _18163_/A BUFX3
XFILLER_124_6 VDD VSS FILLER1
XFILLER_4_716 VDD VSS DECAPHV8
X_10230_ _18594_/Q _10230_/B VDD VSS _10231_/B NOR2BX1
XFILLER_10_64 VDD VSS FILLER1
XFILLER_133_452 VDD VSS FILLER4
X_10161_ _10172_/A _10161_/B VDD VSS _11419_/C XNOR2X1
XFILLER_102_850 VDD VSS DECAPHV8
XFILLER_126_97 VSS VDD FILLER2
X_10092_ _10069_/Y _10091_/Y _10155_/A VDD VSS _10146_/B MUXI2X1
XFILLER_48_915 VSS VDD FILLER2
XFILLER_86_57 VDD VSS FILLER4
X_13920_ _13987_/A _13987_/B _13987_/D _13987_/C VDD VSS _14001_/B AOAI211X1
XFILLER_101_371 VDD VSS FILLER1
XFILLER_142_41 VDD VSS FILLER1
XFILLER_59_285 VDD VSS DECAPHV8
XFILLER_74_211 VDD VSS FILLER1
XFILLER_75_756 VSS VDD FILLER2
XFILLER_90_715 VDD VSS FILLER1
X_13851_ _13849_/Y _19059_/Q _14331_/C VDD VSS _13912_/E NAND3BX1
XFILLER_142_96 VDD VSS FILLER1
XFILLER_15_311 VDD VSS FILLER1
XFILLER_62_417 VDD VSS FILLER1
X_10994_ _10990_/B _18570_/Q VDD VSS _11023_/D NOR2BX1
X_12802_ _19021_/Q VDD VSS _12906_/A INVX1
X_13782_ _19058_/Q _14329_/B VDD VSS _13783_/D _14329_/C AND3X2
X_16570_ _19636_/Q VDD VSS _16571_/A INVX1
XFILLER_16_856 VSS VDD FILLER2
XFILLER_35_50 VDD VSS FILLER4
XTAP_TAPCELL_ROW_107_1083 VDD VSS WELLTAP
X_12733_ _12910_/A _12910_/B VDD VSS _14380_/B XNOR2X1
Xclkbuf_2_3__f__09182_ clkbuf_0__09182_/Y VDD VSS _18571_/CK BUFX12
X_15521_ _15546_/C _15521_/B VDD VSS _15821_/B OR2X2
XFILLER_35_72 VSS VDD FILLER2
XTAP_TAPCELL_ROW_60_618 VDD VSS WELLTAP
X_18240_ _18240_/CK _18240_/D _18240_/Q _20079_/RB VDD VSS DFFRQX1
X_15452_ _15465_/A _15465_/B VDD VSS _15755_/B XNOR2X1
XTAP_TAPCELL_ROW_6_76 VDD VSS WELLTAP
X_12664_ _19186_/Q _14473_/B _14473_/C VDD VSS _12771_/E OR3BX1
X_14403_ _14410_/A _14403_/B _14403_/C VDD VSS _19124_/D NOR3X1
X_11615_ _18758_/Q _11624_/B VDD VSS _18785_/D AND2X1
X_12595_ _12640_/A _12732_/B _12724_/C VDD VSS _12804_/B XNOR3X1
X_18171_ _19300_/Q _18174_/B VDD VSS _18172_/B XOR2X1
X_15383_ _15383_/A VDD VSS _15674_/A BUFX3
XFILLER_128_235 VDD VSS DECAPHV8
XFILLER_129_747 VDD VSS DECAPHV32
X_11546_ _18695_/Q _11555_/B VDD VSS _18722_/D AND2X1
X_14334_ _14334_/A _14334_/B VDD VSS _19062_/D AND2X1
X_17122_ _17536_/A _17122_/B _17123_/C VDD VSS _19778_/D NOR3X1
X_14265_ _14255_/Y _14265_/B _14265_/C VDD VSS _19003_/D AND3BX1
X_17053_ _19762_/Q _19763_/Q _17073_/B VDD VSS _17062_/D OAI21X1
XFILLER_143_216 VDD VSS FILLER1
X_11477_ _18633_/Q _11484_/B VDD VSS _18660_/D AND2X1
X_13216_ _13422_/B VDD VSS _14323_/B BUFX3
X_16004_ _19679_/Q _16838_/B VDD VSS _16030_/B XOR2X1
X_10428_ _10595_/A _10503_/B VDD VSS _10433_/B NAND2X1
X_14196_ _14136_/Y _14196_/B _14196_/C VDD VSS _18946_/D AND3BX1
XFILLER_112_603 VDD VSS FILLER1
XFILLER_140_923 VDD VSS DECAPHV16
XFILLER_97_303 VDD VSS DECAPHV8
X_10359_ _10579_/D _10359_/B VDD VSS _10435_/A NOR2X1
X_13147_ _19248_/Q _13345_/A _13343_/A VDD VSS _13444_/D XNOR3X1
X_13078_ _13183_/A _13081_/B _13081_/C VDD VSS _17891_/B XNOR3X1
X_17955_ _17955_/A _17955_/B _17955_/C VDD VSS _19957_/D AOI21X1
XFILLER_85_509 VSS VDD FILLER2
X_12029_ wire162/Y _12029_/B _12029_/C _12029_/D VDD VSS _12116_/B AOAI211X1
X_16906_ _20067_/Q _20023_/Q _16906_/C VDD VSS _16906_/Y AOI21X1
XFILLER_38_425 VDD VSS FILLER1
XFILLER_39_948 VSS VDD FILLER2
X_17886_ _18855_/Q _17891_/B VDD VSS _17888_/B XOR2X1
XFILLER_19_650 VDD VSS FILLER1
XFILLER_81_715 VDD VSS FILLER4
XFILLER_93_542 VSS VDD FILLER2
X_19625_ _19671_/CK _19625_/D _19625_/Q VDD VSS DFFQX1
X_16837_ _16838_/A _16837_/B VDD VSS _19678_/D NOR2X1
XTAP_TAPCELL_ROW_76_773 VDD VSS WELLTAP
X_19556_ _19591_/CK _19556_/D _19556_/Q VDD VSS DFFQX1
X_16768_ _16768_/A _16768_/B VDD VSS _19616_/D AND2X1
XFILLER_46_491 VDD VSS DECAPHV8
XFILLER_81_759 VSS VDD FILLER2
XTAP_TAPCELL_ROW_48_497 VDD VSS WELLTAP
X_18507_ _18507_/CK _18507_/D _18507_/Q _09356_/Y VDD VSS DFFRQX1
X_15719_ _15725_/A _15719_/B VDD VSS _19345_/D AND2X1
X_09240_ _18510_/Q VDD VSS _18345_/D INVX1
X_19487_ _19533_/CK _19487_/D _19487_/Q VDD VSS DFFQX1
X_16699_ _16699_/A _16704_/B VDD VSS _19553_/D NOR2X1
X_18438_ _18438_/CK _18470_/D _18438_/Q _18471_/RB VDD VSS DFFRQX1
XFILLER_21_358 VDD VSS FILLER1
X_18369_ _18375_/CK _18465_/D _20206_/A _18465_/RB VDD VSS DFFRQX1
XFILLER_107_408 VDD VSS FILLER1
XFILLER_131_901 VDD VSS FILLER1
XFILLER_89_815 VDD VSS FILLER1
Xoutput19 _20088_/Y VDD VSS o_aux_ctrl[6] BUFX3
XFILLER_103_614 VDD VSS FILLER1
XFILLER_143_772 VSS VDD FILLER2
XFILLER_89_848 VSS VDD FILLER2
X_20193_ _20193_/A VDD VSS _20193_/Y BUFX3
XFILLER_102_113 VSS VDD FILLER2
XFILLER_103_636 VSS VDD FILLER2
XFILLER_131_945 VDD VSS FILLER4
XFILLER_88_369 VDD VSS FILLER1
XFILLER_130_499 VSS VDD FILLER2
XFILLER_29_425 VDD VSS DECAPHV8
XFILLER_56_49 VDD VSS DECAPHV8
XFILLER_84_597 VDD VSS FILLER1
XFILLER_112_77 VSS VDD FILLER2
XFILLER_37_480 VDD VSS FILLER1
XFILLER_71_236 VSS VDD FILLER2
XFILLER_71_258 VDD VSS DECAPHV8
X_09507_ _18524_/Q _09507_/B _09507_/C _20081_/Q VDD VSS _20081_/D AO22X2
XFILLER_24_196 VDD VSS FILLER1
XFILLER_25_697 VDD VSS FILLER4
X_09438_ _09446_/A _09753_/D VDD VSS _18217_/E NOR2X1
X_09369_ _18526_/Q _09369_/B _18507_/Q VDD VSS _09422_/B NOR3X1
X_11400_ _18010_/A VDD VSS _17566_/A BUFX3
X_12380_ _12380_/A _14375_/B _12380_/C _12380_/D VDD VSS _12593_/A OAOI211X2
X_11331_ _11331_/A _11339_/B VDD VSS _11336_/B XOR2X1
XFILLER_138_599 VDD VSS FILLER4
XFILLER_21_96 VDD VSS FILLER4
XFILLER_4_557 VDD VSS DECAPHV8
X_11262_ _18580_/Q _11262_/B _11262_/C VDD VSS _11271_/A MIN3X1
X_14050_ _17959_/A wire152/Y _17960_/C VDD VSS _17963_/B OAI21X1
XFILLER_134_783 VDD VSS FILLER4
XFILLER_137_96 VDD VSS FILLER1
X_10213_ _11384_/A _10213_/B VDD VSS _10213_/Y XNOR2X1
X_11193_ _18683_/Q _18791_/Q VDD VSS _11194_/B XOR2X1
X_13001_ _13008_/A _13008_/B _13008_/D _13008_/C VDD VSS _14256_/C OAI211X1
XFILLER_121_422 VDD VSS FILLER4
XFILLER_121_444 VDD VSS FILLER4
XFILLER_133_282 VDD VSS DECAPHV16
X_10144_ _10190_/B _10166_/B VDD VSS _10145_/C NOR2X1
XFILLER_0_774 VDD VSS FILLER1
XFILLER_67_509 VDD VSS DECAPHV16
XFILLER_88_881 VSS VDD FILLER2
XFILLER_95_829 VDD VSS FILLER1
XFILLER_47_222 VDD VSS FILLER4
XFILLER_75_531 VDD VSS FILLER1
XFILLER_94_328 VSS VDD FILLER2
XTAP_TAPCELL_ROW_109_1101 VDD VSS WELLTAP
X_10075_ _10075_/A _10075_/B _10075_/C _10075_/D VDD VSS _10076_/B OAI211X1
X_17740_ _19910_/Q _19878_/Q _17740_/C VDD VSS _17745_/C AO21X2
X_14952_ _19338_/Q _14952_/B _15711_/B VDD VSS _14991_/B MIN3X1
X_13903_ _13903_/A _13903_/B _13951_/C _13903_/D VDD VSS wire154/A OAOI211X1
X_17671_ _19896_/Q _19864_/Q VDD VSS _17678_/A XNOR2X1
X_14883_ _14966_/B _14918_/D VDD VSS _14884_/C AND2X1
XFILLER_35_428 VDD VSS FILLER1
XFILLER_62_203 VDD VSS FILLER4
XFILLER_62_214 VSS VDD FILLER2
X_13834_ _13891_/A _13891_/B VDD VSS _14230_/C _13891_/C NAND3X1
X_19410_ _19435_/CK _19410_/D _19410_/Q VDD VSS DFFQX1
X_16622_ _16622_/A _16622_/B VDD VSS _16623_/C NAND2X1
XFILLER_16_620 VDD VSS DECAPHV8
XFILLER_35_439 VDD VSS FILLER1
XFILLER_46_93 VDD VSS FILLER1
XTAP_TAPCELL_ROW_73_743 VDD VSS WELLTAP
X_19341_ _19551_/CK _19341_/D _19341_/Q VDD VSS DFFQX1
XFILLER_90_578 VDD VSS FILLER1
XTAP_TAPCELL_ROW_45_467 VDD VSS WELLTAP
X_10977_ _11004_/A _10977_/B VDD VSS _10981_/B XNOR2X1
X_13765_ _19001_/Q _14263_/B VDD VSS _13768_/C _14263_/C NAND3X1
X_16553_ _19604_/Q _16755_/B VDD VSS _16554_/B XOR2X1
XFILLER_43_472 VDD VSS DECAPHV8
X_12716_ _12892_/A _14285_/B VDD VSS _12801_/A OR2X2
X_13696_ _13696_/A _13696_/B _13696_/C _13696_/D VDD VSS _14360_/B AOAI211X1
X_19272_ _20008_/CK _19272_/D _19272_/Q VDD VSS DFFQX1
X_16484_ _16494_/A _16494_/B VDD VSS _16858_/B XNOR2X1
X_15504_ _15495_/A _15504_/B _15504_/C VDD VSS _15539_/A AOI2B1X1
X_12647_ _19214_/Q VDD VSS _12839_/A INVX1
X_18223_ _18223_/CK _18223_/E _18223_/ECK VDD VSS CGX3
X_15435_ _19517_/Q VDD VSS _15473_/A INVX1
X_18154_ _19297_/Q _18155_/B VDD VSS _18162_/A AND2X1
X_15366_ _19460_/Q _15848_/B VDD VSS _15393_/B XNOR2X1
X_12578_ _12673_/A _12673_/B _12673_/C VDD VSS _14535_/B NOR3X1
X_17105_ _17107_/B _17105_/B VDD VSS _17106_/B XOR2X1
X_11529_ _18681_/Q _11531_/B VDD VSS _18708_/D AND2X1
X_14317_ _14316_/Y _14317_/B _14317_/C VDD VSS _19047_/D AND3BX1
X_18085_ _18085_/A VDD VSS _18090_/A INVX1
X_15297_ _15297_/A _18123_/B VDD VSS _19290_/D AND2X1
X_14248_ _14251_/A _14248_/B VDD VSS _18988_/D NOR2X1
X_17036_ _19760_/Q _17078_/B _17036_/C VDD VSS _17037_/B MIN3X1
XFILLER_97_100 VSS VDD FILLER2
X_14179_ _14197_/A _14179_/B VDD VSS _18931_/D AND2X1
Xclkbuf_1_1__f__09181_ clkbuf_0__09181_/Y VDD VSS _18608_/CK BUFX12
XFILLER_30_2 VDD VSS FILLER1
XFILLER_98_656 VSS VDD FILLER2
XFILLER_112_455 VDD VSS FILLER1
XFILLER_85_306 VDD VSS FILLER1
XFILLER_98_689 VDD VSS DECAPHV8
X_18987_ _19037_/CK _18987_/D _18987_/Q VDD VSS DFFQX1
XFILLER_85_339 VDD VSS FILLER1
XFILLER_97_199 VDD VSS DECAPHV8
X_17938_ _17948_/A _17946_/B VDD VSS _17942_/B NOR2BX1
X_17869_ _17869_/A _17869_/B _17869_/C VDD VSS _17870_/C MIN3X1
XFILLER_53_214 VDD VSS FILLER1
X_19608_ _19673_/CK _19608_/D _19608_/Q VDD VSS DFFQX1
XTAP_TAPCELL_ROW_127_1289 VDD VSS WELLTAP
XTAP_TAPCELL_ROW_140_1412 VDD VSS WELLTAP
Xclkbuf_0__001_ _231_/ECK VDD VSS clkbuf_0__001_/Y BUFX12
XFILLER_34_461 VSS VDD FILLER2
X_19539_ _19737_/CK _19539_/D _19539_/Q VDD VSS DFFQX1
XFILLER_21_100 VSS VDD FILLER2
XFILLER_22_634 VSS VDD FILLER2
XFILLER_139_308 VDD VSS FILLER1
XTAP_TAPCELL_ROW_16_180 VDD VSS WELLTAP
X_09223_ _18519_/Q VDD VSS _18386_/D INVX1
XTAP_TAPCELL_ROW_138_1396 VDD VSS WELLTAP
Xclkbuf_leaf_17__000_ clkbuf_leaf_9__000_/A VDD VSS _19636_/CK BUFX12
XFILLER_103_411 VDD VSS DECAPHV16
XFILLER_104_945 VDD VSS FILLER4
XFILLER_115_282 VDD VSS FILLER4
XFILLER_131_731 VSS VDD FILLER2
XFILLER_107_77 VDD VSS FILLER4
XFILLER_130_230 VSS VDD FILLER2
XFILLER_88_144 VDD VSS FILLER1
XFILLER_89_667 VSS VDD FILLER2
X_09987_ _09948_/Y _09986_/Y _11178_/C VDD VSS _09987_/Y MUX2X1
X_20176_ _20176_/A VDD VSS _20176_/Y BUFX3
XFILLER_29_200 VDD VSS FILLER1
XFILLER_76_328 VDD VSS FILLER4
XFILLER_85_840 VDD VSS FILLER1
XFILLER_123_54 VDD VSS FILLER1
XFILLER_17_406 VDD VSS FILLER1
XFILLER_17_428 VDD VSS FILLER1
XFILLER_44_214 VDD VSS DECAPHV8
XFILLER_57_586 VDD VSS DECAPHV16
X_10900_ _18674_/Q _18782_/Q VDD VSS _10902_/B XNOR2X1
XFILLER_123_87 VDD VSS FILLER1
X_11880_ wire165/Y _11881_/B _11881_/D _11881_/C VDD VSS _14525_/B AO211X2
XFILLER_72_578 VSS VDD FILLER2
X_10831_ _10871_/A _10871_/B _10832_/C _11195_/A VDD VSS _10832_/D AOAI211X1
XFILLER_25_494 VDD VSS FILLER4
XTAP_TAPCELL_ROW_104_1053 VDD VSS WELLTAP
XTAP_TAPCELL_ROW_42_437 VDD VSS WELLTAP
XTAP_TAPCELL_ROW_70_713 VDD VSS WELLTAP
X_10762_ _10927_/C _10762_/B _10762_/C _11226_/A VDD VSS _10772_/C OAI22X1
X_13550_ _19167_/Q _14452_/B VDD VSS _13640_/A NOR2BX1
X_12501_ _19241_/Q _12677_/B _12677_/C VDD VSS _12837_/B XNOR3X1
X_13481_ _13585_/A _13594_/D _13489_/C VDD VSS _13586_/C XNOR3X1
XFILLER_13_678 VSS VDD FILLER2
XFILLER_40_486 VDD VSS FILLER1
X_10693_ _10729_/C _10729_/D _10729_/E _10693_/D VDD VSS _10694_/B AOAI211X1
X_12432_ _13177_/A _17853_/B VDD VSS _18848_/D NOR2X1
X_15220_ _15220_/A _15220_/B VDD VSS _15221_/C NAND2X1
XFILLER_32_51 VDD VSS FILLER1
XFILLER_138_396 VDD VSS FILLER1
XTAP_TAPCELL_ROW_3_44 VDD VSS WELLTAP
X_12363_ _12363_/A _12363_/B _12363_/C _12363_/D VDD VSS _12544_/A AOAI211X1
X_15151_ _15191_/C _15275_/A VDD VSS _15154_/A NAND2X1
X_11314_ _11383_/A _11314_/B VDD VSS _18585_/D NOR2X1
X_12294_ _12512_/A _12294_/B _12294_/C VDD VSS _12366_/C NOR3X1
X_14102_ _18897_/Q _14140_/B VDD VSS _14103_/E _14140_/C AND3X2
X_15082_ _15082_/A _15776_/B _15776_/C VDD VSS _15083_/C NOR3X1
X_11245_ _11151_/Y _11288_/B _11298_/A VDD VSS _11330_/B MUXI2X1
X_14033_ _14233_/B _14233_/C _18978_/Q VDD VSS _14036_/B AOI21X1
X_18910_ _18936_/CK _18910_/D _18910_/Q VDD VSS DFFQX1
XFILLER_106_271 VDD VSS DECAPHV8
XFILLER_141_539 VDD VSS FILLER1
XFILLER_79_122 VSS VDD FILLER2
X_19890_ _19892_/CK _19890_/D _19890_/Q VDD VSS DFFQX1
XFILLER_95_604 VDD VSS DECAPHV8
X_11176_ _11175_/B _11176_/B VDD VSS _11197_/C NOR2BX1
X_18841_ _19958_/CK _18841_/D _18841_/Q VDD VSS DFFQX1
XFILLER_0_571 VDD VSS FILLER1
XFILLER_110_948 VSS VDD FILLER2
XFILLER_95_648 VSS VDD FILLER2
X_10127_ _10127_/A _10127_/B VDD VSS _10154_/B NOR2X1
X_18772_ _18799_/CK _18772_/D _18772_/Q VDD VSS DFFQX1
X_15984_ _16015_/A _16015_/B VDD VSS _15985_/C NAND2X1
X_10058_ _10167_/A _10058_/B VDD VSS _10059_/C NOR2X1
X_17723_ _17726_/C _17724_/B _17746_/C VDD VSS _17724_/C OAI21X1
X_14935_ _19449_/Q _15834_/B VDD VSS _14959_/C _15834_/C NAND3X1
XFILLER_57_81 VDD VSS FILLER1
XFILLER_63_556 VSS VDD FILLER2
XTAP_TAPCELL_ROW_58_592 VDD VSS WELLTAP
X_17654_ _17655_/A _17657_/C _17654_/C VDD VSS _17655_/C OAI21X1
X_14866_ _14906_/C _15833_/B _15833_/C VDD VSS _14867_/D NOR3X1
XFILLER_16_450 VDD VSS FILLER1
X_13817_ _18947_/Q _13987_/A _13987_/B VDD VSS _13818_/D XNOR3X1
X_17585_ _17589_/A _17586_/B _17597_/C VDD VSS _17586_/C OAI21X1
X_16605_ _16606_/A _16606_/B _16606_/C VDD VSS _16631_/B OA21X2
X_14797_ _14811_/A _14811_/B _15769_/B VDD VSS _15738_/B XNOR3X1
X_13748_ _13748_/A _13748_/B _13748_/C _13748_/D VDD VSS _13918_/A AO31X2
X_19324_ _19358_/CK _19324_/D _19324_/Q VDD VSS DFFQX1
X_16536_ _16537_/A _16537_/B _16537_/C VDD VSS _16561_/B AO21X2
XFILLER_92_4 VDD VSS FILLER4
X_19255_ _19992_/CK _19255_/D _19255_/Q VDD VSS DFFQX1
XTAP_TAPCELL_ROW_13_150 VDD VSS WELLTAP
X_13679_ _18973_/Q _14228_/B VDD VSS _13771_/A AND2X1
X_16467_ _16467_/A _16467_/B _16892_/B VDD VSS _16490_/B MIN3X1
XFILLER_129_341 VDD VSS FILLER1
X_19186_ _19215_/CK _19186_/D _19186_/Q VDD VSS DFFQX1
X_16398_ _16398_/A _16398_/B _16398_/C VDD VSS _16399_/B OAI21X1
X_15418_ _19321_/Q _15692_/B VDD VSS _15422_/B XOR2X1
XFILLER_8_671 VDD VSS FILLER4
X_18137_ _18135_/Y _18139_/B _18168_/C VDD VSS _20001_/D AND3BX1
X_15349_ _19459_/Q _15845_/B VDD VSS _15351_/B NOR2X1
XFILLER_105_709 VDD VSS FILLER4
X_18068_ _19280_/Q _18068_/B VDD VSS _18069_/C AND2X1
XFILLER_104_219 VSS VDD FILLER2
XFILLER_99_910 VSS VDD FILLER2
X_09910_ _09910_/A _09910_/B VDD VSS _09912_/B XNOR2X1
X_17019_ _17019_/A _17019_/B _17019_/C _17019_/D VDD VSS _17024_/B AOI31X1
XFILLER_113_742 VSS VDD FILLER2
XFILLER_98_453 VDD VSS FILLER4
X_09841_ _18564_/Q _11195_/A _09841_/C VDD VSS _09878_/B AOI21X1
X_20030_ _20045_/CK _20030_/D _20030_/Q _20031_/RB VDD VSS DFFRQX1
Xclkbuf_1_1__f__09164_ clkbuf_0__09164_/Y VDD VSS _18455_/CK BUFX12
XFILLER_100_414 VDD VSS FILLER4
XFILLER_140_594 VDD VSS FILLER1
XFILLER_86_626 VDD VSS FILLER1
XTAP_TAPCELL_ROW_129_1307 VDD VSS WELLTAP
X_09772_ _18356_/Q _09772_/B _09772_/C _09772_/D VDD VSS _09773_/C OAI211X1
XFILLER_39_531 VDD VSS DECAPHV8
XFILLER_26_258 VDD VSS DECAPHV8
XFILLER_54_578 VSS VDD FILLER2
XFILLER_41_217 VDD VSS FILLER4
XFILLER_41_228 VDD VSS FILLER4
XFILLER_34_291 VSS VDD FILLER2
X_09206_ _18513_/Q VDD VSS _18428_/D INVX1
XFILLER_135_311 VDD VSS FILLER4
XFILLER_108_558 VDD VSS FILLER4
XFILLER_135_344 VDD VSS FILLER1
XFILLER_136_878 VDD VSS FILLER1
XFILLER_118_65 VDD VSS FILLER1
XFILLER_104_742 VSS VDD FILLER2
XFILLER_131_561 VDD VSS FILLER1
XFILLER_89_442 VDD VSS FILLER1
XFILLER_89_464 VDD VSS FILLER1
X_11030_ _11495_/A _11675_/A _11030_/C VDD VSS _11074_/C MIN3X1
XFILLER_103_274 VDD VSS FILLER4
XFILLER_131_583 VSS VDD FILLER2
XFILLER_134_31 VDD VSS DECAPHV8
XFILLER_134_53 VDD VSS DECAPHV8
X_20159_ _20159_/A VDD VSS _20159_/Y BUFX3
XFILLER_134_86 VDD VSS DECAPHV8
XFILLER_45_501 VSS VDD FILLER2
XFILLER_85_670 VSS VDD FILLER2
XTAP_TAPCELL_ROW_19_209 VDD VSS WELLTAP
X_12981_ _13004_/A _13198_/B _13198_/C VDD VSS _12994_/C OR3BX1
XFILLER_45_523 VDD VSS FILLER4
X_11932_ _19996_/Q _19260_/Q VDD VSS _11933_/D NOR2X1
X_14720_ _14758_/A _14758_/B _15767_/B VDD VSS _15736_/B XNOR3X1
X_11863_ _19118_/Q _11865_/B _14397_/B VDD VSS _14366_/B XNOR3X1
X_14651_ _19498_/Q _15891_/B VDD VSS _14652_/D XNOR2X1
XFILLER_32_228 VDD VSS FILLER1
XFILLER_73_898 VSS VDD FILLER2
XTAP_TAPCELL_ROW_27_286 VDD VSS WELLTAP
XTAP_TAPCELL_ROW_55_562 VDD VSS WELLTAP
X_10814_ _10814_/A _10814_/B _10814_/C VDD VSS _10851_/B OAI21X1
X_13602_ _14326_/B _14326_/C _19055_/Q VDD VSS _13604_/C AOI21X1
X_17370_ _17372_/A _17370_/B _17370_/C VDD VSS _19831_/D AOI21X1
XFILLER_13_442 VDD VSS FILLER4
XFILLER_41_751 VDD VSS FILLER1
X_11794_ _19173_/Q _11794_/B _11794_/C VDD VSS _11874_/A MIN3X1
X_14582_ _14594_/A _15856_/B VDD VSS _14616_/B AND2X1
Xclkbuf_1_0__f__09184_ clkbuf_0__09184_/Y VDD VSS _18494_/CK BUFX12
X_16321_ _16335_/C _16321_/B VDD VSS _16817_/B OR2X2
XFILLER_13_486 VDD VSS FILLER1
X_10745_ _11127_/A _10745_/B VDD VSS _10778_/A NAND2X1
X_13533_ _13533_/A _14293_/B _13599_/C _13533_/D VDD VSS _13733_/A OAOI211X1
X_10676_ _18668_/Q _18776_/Q VDD VSS _10718_/D OR2X2
X_13464_ _13464_/A _13464_/B VDD VSS _14515_/B XNOR2X1
X_19040_ _19040_/CK _19040_/D _19040_/Q VDD VSS DFFQX1
X_16252_ _19656_/Q _16814_/B VDD VSS _16267_/A NOR2X1
XTAP_TAPCELL_ROW_10_120 VDD VSS WELLTAP
X_12415_ _19184_/Q _12566_/A _12662_/B VDD VSS _12472_/D XNOR3X1
X_13395_ _13395_/A _13395_/B _13395_/C _13395_/D VDD VSS _13594_/A AOAI211X1
X_16183_ _19558_/Q _19910_/Q VDD VSS _16208_/A XNOR2X1
X_15203_ _15204_/C _15812_/B _15812_/C VDD VSS _15225_/C NOR3X1
XFILLER_5_641 VDD VSS FILLER4
X_12346_ _18876_/Q VDD VSS _12528_/A INVX1
X_15134_ _15134_/A _15134_/B _15134_/C VDD VSS _15176_/B OA21X2
XFILLER_141_347 VDD VSS FILLER4
X_12277_ _18958_/Q _12277_/B _14209_/B VDD VSS _12354_/B MIN3X1
X_19942_ _19947_/CK _19942_/D _19942_/Q VDD VSS DFFQX1
X_15065_ _19481_/Q _15873_/B VDD VSS _15085_/B XOR2X1
X_11228_ _18710_/Q _18764_/Q _11228_/C VDD VSS _11229_/C MIN3X1
X_14016_ _18923_/Q _14054_/B _14054_/C VDD VSS _14085_/B XNOR3X1
X_19873_ _19907_/CK _19873_/D _19873_/Q VDD VSS DFFQX1
XFILLER_68_615 VSS VDD FILLER2
XFILLER_95_423 VDD VSS DECAPHV16
X_11159_ _11159_/A _11159_/B VDD VSS _11221_/A OR2X2
X_18824_ _19947_/CK _18824_/D _18824_/Q VDD VSS DFFQX1
XFILLER_49_840 VDD VSS DECAPHV8
XFILLER_110_778 VDD VSS FILLER1
XFILLER_110_789 VDD VSS FILLER1
XFILLER_49_884 VDD VSS DECAPHV16
XFILLER_76_670 VDD VSS DECAPHV8
XFILLER_95_478 VDD VSS FILLER1
X_18755_ _18782_/CK _18755_/D _18755_/Q VDD VSS DFFQX1
X_15967_ _15993_/A _15993_/B VDD VSS _16766_/B XNOR2X1
XFILLER_36_534 VDD VSS DECAPHV32
X_18686_ _18768_/CK _18686_/D _18686_/Q VDD VSS DFFQX1
X_17706_ _17806_/A _17706_/B VDD VSS _19903_/D NOR2X1
X_15898_ _15906_/A _15898_/B VDD VSS _19504_/D NOR2X1
X_14918_ _14918_/A _14918_/B _14966_/B _14918_/D VDD VSS _15868_/C AOI22X1
XFILLER_24_707 VSS VDD FILLER2
XFILLER_24_718 VDD VSS FILLER1
XFILLER_84_90 VSS VDD FILLER2
X_17637_ _19888_/Q _19856_/Q VDD VSS _17638_/C NAND2X1
X_14849_ _19335_/Q VDD VSS _14850_/A INVX1
XFILLER_17_781 VSS VDD FILLER2
XFILLER_51_526 VDD VSS DECAPHV32
XTAP_TAPCELL_ROW_124_1259 VDD VSS WELLTAP
XFILLER_90_194 VDD VSS FILLER1
X_19307_ _19322_/CK _19307_/D _19307_/Q VDD VSS DFFQX1
Xclkbuf_leaf_16__001_ clkbuf_2_3__f__001_/Y VDD VSS _19004_/CK BUFX12
X_17568_ _19874_/Q _19842_/Q VDD VSS _17569_/B XOR2X1
X_17499_ _19859_/Q _19827_/Q VDD VSS _17501_/B XOR2X1
X_16519_ _19667_/Q VDD VSS _16545_/A INVX1
XFILLER_118_801 VSS VDD FILLER2
XFILLER_83_0 VSS VDD FILLER2
X_19238_ _19242_/CK _19238_/D _19238_/Q VDD VSS DFFQX1
XFILLER_117_311 VSS VDD FILLER2
X_19169_ _19196_/CK _19169_/D _19169_/Q VDD VSS DFFQX1
XFILLER_133_826 VDD VSS FILLER1
XTAP_TAPCELL_ROW_135_1366 VDD VSS WELLTAP
XFILLER_144_174 VDD VSS FILLER4
X_09973__243 _20054_/CK VDD VSS _18520_/CK INVX1
XTAP_TAPCELL_ROW_89_908 VDD VSS WELLTAP
XFILLER_113_561 VDD VSS DECAPHV8
XFILLER_58_114 VDD VSS FILLER1
XFILLER_59_626 VDD VSS FILLER1
X_09824_ _10686_/D VDD VSS _11039_/C BUFX3
X_20013_ _20013_/CK _20013_/D _20013_/Q VDD VSS DFFQX1
XFILLER_39_361 VDD VSS DECAPHV8
XFILLER_46_309 VDD VSS DECAPHV8
XFILLER_74_629 VDD VSS DECAPHV8
XTAP_TAPCELL_ROW_97_985 VDD VSS WELLTAP
X_09755_ _20112_/A _20128_/A _09776_/A VDD VSS _09760_/C MUX2X1
Xclkbuf_0__09178_ _18227_/ECK VDD VSS clkbuf_0__09178_/Y BUFX12
XFILLER_73_139 VDD VSS FILLER4
X_09686_ _18367_/Q VDD VSS _20204_/A INVX1
XFILLER_104_89 VDD VSS FILLER1
XFILLER_64_49 VDD VSS DECAPHV32
XFILLER_82_673 VDD VSS FILLER4
XFILLER_14_228 VDD VSS FILLER1
XFILLER_42_537 VSS VDD FILLER2
XFILLER_81_183 VSS VDD FILLER2
XFILLER_23_740 VDD VSS FILLER4
XTAP_TAPCELL_ROW_52_532 VDD VSS WELLTAP
XTAP_TAPCELL_ROW_101_1023 VDD VSS WELLTAP
XTAP_TAPCELL_ROW_24_256 VDD VSS WELLTAP
X_10530_ _10530_/A _10530_/B _10530_/C _10530_/D VDD VSS _10556_/A AOAI211X1
XFILLER_10_478 VDD VSS FILLER1
X_10461_ _10525_/B _10461_/B _10763_/A VDD VSS _10462_/D OR3BX1
XFILLER_108_311 VDD VSS FILLER1
X_12200_ _18986_/Q VDD VSS _12278_/A INVX1
XFILLER_136_664 VDD VSS DECAPHV8
X_10392_ _10392_/A _10392_/B VDD VSS _10431_/B OR2X2
X_13180_ _18909_/Q _13180_/B _14153_/B VDD VSS _14122_/B XNOR3X1
XFILLER_123_325 VDD VSS DECAPHV16
XFILLER_2_633 VDD VSS FILLER1
XTAP_TAPCELL_ROW_0_12 VDD VSS WELLTAP
X_12131_ _18956_/Q _12131_/B _14207_/B VDD VSS _12199_/B MIN3X1
XFILLER_1_121 VDD VSS FILLER1
X_12062_ _12254_/A _12254_/B VDD VSS _12137_/C XOR2X1
XFILLER_132_881 VSS VDD FILLER2
XFILLER_78_924 VDD VSS FILLER4
X_11013_ _11229_/D _11013_/B _11013_/C _11013_/D VDD VSS _11014_/C OAI211X1
XFILLER_131_391 VSS VDD FILLER2
X_16870_ _16876_/A _16870_/B VDD VSS _19707_/D NOR2X1
XFILLER_93_949 VDD VSS FILLER1
X_15821_ _15830_/A _15821_/B VDD VSS _19436_/D NOR2X1
XFILLER_92_426 VDD VSS DECAPHV8
X_12964_ _13054_/A _13054_/B VDD VSS _14539_/B XNOR2X1
X_18540_ _18543_/CK _18540_/D _18540_/Q VDD VSS DFFQX1
X_15752_ _15758_/A _15752_/B VDD VSS _19375_/D NOR2X1
X_11915_ _19175_/Q _11918_/A _11915_/C VDD VSS _11916_/D XNOR3X1
X_18471_ _18471_/CK _18471_/D _18471_/Q _18471_/RB VDD VSS DFFRQX1
X_14703_ _19472_/Q _15863_/B VDD VSS _14737_/C NAND2X1
XFILLER_45_375 VDD VSS FILLER1
XFILLER_61_824 VDD VSS FILLER4
XFILLER_72_150 VSS VDD FILLER2
XFILLER_72_172 VDD VSS DECAPHV8
X_12895_ _19018_/Q _14284_/B VDD VSS _12896_/C _14284_/C NAND3X1
X_17422_ _19842_/Q _19810_/Q _17422_/C VDD VSS _17427_/C AO21X2
X_15683_ _15693_/A _15683_/B VDD VSS _19312_/D NOR2X1
XFILLER_61_868 VSS VDD FILLER2
X_11846_ _19203_/Q _11871_/B _11979_/C VDD VSS _11918_/B XOR3X1
X_14634_ _19442_/Q _14672_/B _14640_/C VDD VSS _14635_/C XNOR3X1
XFILLER_14_762 VSS VDD FILLER2
X_11777_ _19992_/Q _19256_/Q VDD VSS _11804_/A AND2X1
X_14565_ _20004_/Q _14569_/B VDD VSS _19268_/D AND2X1
X_17353_ _19827_/Q _19795_/Q _17353_/C VDD VSS _17357_/C MIN3X1
XFILLER_13_294 VSS VDD FILLER2
X_10728_ _18696_/Q _18750_/Q VDD VSS _10765_/B XNOR2X1
X_13516_ _13516_/A _13516_/B _13516_/C _13516_/D VDD VSS _13675_/A AOAI211X1
Xclkbuf_1_0__f__09167_ clkbuf_0__09167_/Y VDD VSS _18400_/CK BUFX12
X_17284_ _17289_/C _17289_/B VDD VSS _17286_/B NAND2BX1
X_16304_ _19722_/Q _16886_/B VDD VSS _16305_/A NAND2BX1
X_14496_ _17906_/C VDD VSS _15817_/A BUFX3
X_19023_ _19050_/CK _19023_/D _19023_/Q VDD VSS DFFQX1
X_16235_ _19559_/Q VDD VSS _16236_/A INVX1
XFILLER_127_631 VDD VSS FILLER1
X_10659_ _11267_/A _10659_/B _10659_/C _10659_/D VDD VSS _10661_/B AOI31X1
X_13447_ _13447_/A _13447_/B _13447_/C _13447_/D VDD VSS _13462_/B AOAI211X1
Xclkload35 _19947_/CK VDD VSS clkload35/Y BUFX12
Xclkload24 _19984_/CK VDD VSS clkload24/Y INVX2
Xclkload13 _19830_/CK VDD VSS clkload13/Y BUFX12
X_09957__227 _18259_/CK VDD VSS _18504_/CK INVX1
X_13378_ _18914_/Q _13378_/B _13393_/C VDD VSS _13578_/B XNOR3X1
Xclkload68 _19172_/CK VDD VSS clkload68/Y INVX1
Xclkload57 _19096_/CK VDD VSS clkload57/Y INVX2
Xclkload46 _19194_/CK VDD VSS clkload46/Y INVX2
X_16166_ _19653_/Q _16810_/B VDD VSS _16177_/B XNOR2X1
X_12329_ _12329_/A _12329_/B _14501_/B _12329_/D _12329_/E VDD VSS _12474_/C OAI221X1
Xclkload79 clkload79/A VDD VSS clkload79/Y INVX14
X_16097_ _16104_/B _16097_/B VDD VSS _16878_/B XNOR2X1
X_15117_ _15138_/A _15138_/B _15810_/B VDD VSS _15777_/B XNOR3X1
XFILLER_114_369 VSS VDD FILLER2
XFILLER_69_902 VDD VSS FILLER1
X_19925_ _19928_/CK _19925_/D _19925_/Q VDD VSS DFFQX1
X_15048_ _15054_/A _15054_/B _15054_/C VDD VSS _15837_/C NOR3X1
XFILLER_69_924 VDD VSS FILLER1
XFILLER_68_434 VSS VDD FILLER2
X_19856_ _19892_/CK _19856_/D _19856_/Q VDD VSS DFFQX1
XFILLER_110_553 VDD VSS FILLER1
XFILLER_68_478 VDD VSS DECAPHV16
X_19787_ _19795_/CK _19787_/D _19787_/Q VDD VSS DFFQX1
X_18807_ _18809_/CK _18807_/D _18807_/Q VDD VSS DFFQX1
X_16999_ _17095_/A _16999_/B VDD VSS _19754_/D NOR2X1
XFILLER_36_320 VDD VSS FILLER4
XFILLER_83_448 VDD VSS FILLER1
XFILLER_84_949 VDD VSS FILLER1
XFILLER_95_286 VDD VSS FILLER1
X_09540_ _20034_/Q _09547_/B VDD VSS _20035_/D NOR2BX1
X_18738_ _18768_/CK _18738_/D _18738_/Q VDD VSS DFFQX1
XTAP_TAPCELL_ROW_66_679 VDD VSS WELLTAP
XTAP_TAPCELL_ROW_94_955 VDD VSS WELLTAP
X_09471_ _18449_/D _09483_/B _09471_/C VDD VSS _18248_/D AOI21X1
XFILLER_24_504 VDD VSS FILLER4
X_18669_ _19948_/CK _18669_/D _18669_/Q VDD VSS DFFQX1
XFILLER_91_492 VDD VSS FILLER4
XFILLER_20_732 VDD VSS FILLER4
XFILLER_32_581 VDD VSS FILLER4
XFILLER_32_592 VDD VSS DECAPHV8
XTAP_TAPCELL_ROW_21_226 VDD VSS WELLTAP
XFILLER_20_776 VDD VSS DECAPHV8
Xclkload7 clkload7/A VDD VSS clkload7/Y INVX1
XFILLER_106_815 VDD VSS FILLER1
XFILLER_105_314 VDD VSS FILLER1
XFILLER_105_325 VDD VSS DECAPHV8
XFILLER_133_667 VSS VDD FILLER2
XFILLER_78_209 VDD VSS FILLER1
XFILLER_121_829 VDD VSS FILLER1
Xfanout222 _20081_/RB VDD VSS _18485_/RB BUFX3
Xfanout211 _20075_/RB VDD VSS _18471_/RB BUFX3
Xfanout200 _20071_/RB VDD VSS _20069_/RB BUFX3
XFILLER_101_520 VSS VDD FILLER2
XFILLER_87_743 VDD VSS FILLER1
XFILLER_28_810 VDD VSS FILLER4
XFILLER_74_404 VDD VSS DECAPHV8
XFILLER_86_275 VDD VSS DECAPHV8
X_09807_ _18455_/Q VDD VSS _20180_/A INVX1
XFILLER_46_128 VDD VSS FILLER4
XTAP_TAPCELL_ROW_29_304 VDD VSS WELLTAP
X_09738_ _20143_/A _20191_/A _09753_/A VDD VSS _09740_/B MUXI2X1
XFILLER_28_865 VSS VDD FILLER2
XFILLER_43_835 VSS VDD FILLER2
XFILLER_55_684 VDD VSS DECAPHV8
X_09669_ _18414_/Q VDD VSS _20169_/A INVX1
XFILLER_42_323 VSS VDD FILLER2
XFILLER_70_643 VSS VDD FILLER2
XTAP_TAPCELL_ROW_37_381 VDD VSS WELLTAP
X_11700_ _19225_/Q _11700_/B _11700_/C VDD VSS _11745_/A MIN3X1
X_12680_ _12755_/A _12755_/B _12755_/D _12755_/C VDD VSS _12682_/C OAI211X1
Xclkbuf_2_2__f_sclk_regs clkbuf_0_sclk_regs/Y VDD VSS _20079_/CK BUFX12
XFILLER_42_356 VSS VDD FILLER2
XFILLER_91_69 VDD VSS FILLER1
X_11631_ _18773_/Q _11635_/B VDD VSS _18800_/D AND2X1
XFILLER_11_732 VDD VSS FILLER1
XFILLER_129_907 VSS VDD FILLER2
X_11562_ _18710_/Q _11567_/B VDD VSS _18737_/D AND2X1
X_14350_ _15383_/A VDD VSS _14415_/A BUFX3
X_232_ _232_/CK _232_/E _232_/ECK VDD VSS CGX3
XFILLER_10_231 VDD VSS FILLER1
XFILLER_129_929 VDD VSS FILLER1
X_10513_ _10579_/D _10582_/B VDD VSS _10622_/B NOR2X1
X_13301_ _13395_/A _13395_/B _13395_/C VDD VSS _14222_/B AOI21X1
Xclkbuf_leaf_8_clk_regs clkbuf_leaf_9_clk_regs/A VDD VSS _19863_/CK BUFX12
XFILLER_10_275 VDD VSS DECAPHV8
XFILLER_6_235 VDD VSS DECAPHV8
X_11493_ _18648_/Q _11496_/B VDD VSS _18675_/D AND2X1
X_14281_ _14285_/A _14281_/B VDD VSS _19015_/D NOR2X1
X_10444_ _19941_/Q _18823_/Q VDD VSS _10448_/D AND2X1
X_13232_ _19191_/Q _14478_/B _14478_/C VDD VSS _13233_/D OR3BX1
X_16020_ _16020_/A _16022_/B VDD VSS _16870_/B XNOR2X1
XFILLER_108_185 VDD VSS FILLER1
X_10375_ _10366_/Y _10375_/B _10375_/C _10375_/D VDD VSS _10395_/C AOI2B2X1
X_13163_ _14353_/B _14353_/C _19079_/Q VDD VSS _13271_/C AOI21X1
XFILLER_124_645 VDD VSS FILLER1
X_12114_ _14465_/B _14465_/C _12154_/A VDD VSS _12116_/C OA21X2
X_13094_ _13095_/A _13095_/B _13095_/D _13095_/C VDD VSS _13415_/B OAOI211X1
X_19710_ _19711_/CK _19710_/D _19710_/Q VDD VSS DFFQX1
Xclkbuf_leaf_15__002_ clkload17/A VDD VSS _18811_/CK BUFX12
X_17971_ _17976_/A _17976_/B _17971_/C VDD VSS _17972_/B OAI21X1
X_12045_ _12053_/A _12099_/B _12099_/C VDD VSS _14495_/C OR3BX1
X_16922_ _19738_/Q _16922_/B _16922_/C VDD VSS _19739_/D AOI21X1
XFILLER_1_12 VSS VDD FILLER2
XFILLER_38_607 VDD VSS FILLER1
XFILLER_38_629 VSS VDD FILLER2
XFILLER_65_415 VDD VSS FILLER4
XFILLER_66_916 VDD VSS FILLER4
X_19641_ _19673_/CK _19641_/D _19641_/Q VDD VSS DFFQX1
X_16853_ _16859_/A _16853_/B VDD VSS _19692_/D AND2X1
XFILLER_37_117 VSS VDD FILLER2
XFILLER_66_949 VDD VSS FILLER1
X_19572_ _19604_/CK _19572_/D _19572_/Q VDD VSS DFFQX1
X_15804_ _15816_/A _15804_/B VDD VSS _19421_/D NOR2X1
X_13996_ _18950_/Q _14201_/B VDD VSS _14038_/A AND2X1
X_18523_ _18523_/CK _18523_/D _18523_/Q _09307_/Y VDD VSS DFFRQX1
X_16784_ _16793_/A _16784_/B VDD VSS _19630_/D AND2X1
XFILLER_52_109 VSS VDD FILLER2
XFILLER_65_92 VDD VSS FILLER1
XTAP_TAPCELL_ROW_91_925 VDD VSS WELLTAP
X_12947_ _12953_/A _14475_/B _13032_/C VDD VSS _14476_/C NOR3X1
X_15735_ _15739_/A _15735_/B VDD VSS _19360_/D NOR2X1
XFILLER_18_397 VDD VSS FILLER1
XFILLER_45_183 VSS VDD FILLER2
XFILLER_45_194 VDD VSS FILLER4
XFILLER_61_643 VSS VDD FILLER2
XTAP_TAPCELL_ROW_121_1229 VDD VSS WELLTAP
XTAP_TAPCELL_ROW_63_649 VDD VSS WELLTAP
X_12878_ _18937_/Q _14185_/B _12888_/C VDD VSS _14153_/B XNOR3X1
X_18454_ _18455_/CK _18454_/D _18454_/Q _18455_/RB VDD VSS DFFRQX1
X_15666_ _15666_/A _15702_/B VDD VSS _15667_/C NOR2X1
XFILLER_34_879 VDD VSS FILLER4
XFILLER_60_142 VDD VSS FILLER4
X_11829_ _14490_/C _19202_/Q _11884_/B VDD VSS _11830_/D AND3BX1
X_14617_ _19469_/Q _14638_/B _14638_/C VDD VSS _14671_/B MIN3X1
X_18385_ _18390_/CK _18465_/D _20190_/A _20064_/RB VDD VSS DFFRQX1
X_17405_ _17407_/B _17405_/B VDD VSS _17406_/B XOR2X1
XFILLER_60_175 VSS VDD FILLER2
X_17336_ _17338_/A _17338_/B _17336_/C VDD VSS _19824_/D AOI21X1
X_15597_ _15597_/A _15597_/B _15597_/C VDD VSS _15625_/B OAI21X1
X_14548_ _16273_/A VDD VSS _14558_/B BUFX3
X_14479_ _14421_/Y _14479_/B _14479_/C VDD VSS _19192_/D AND3BX1
Xclkload113 _18571_/CK VDD VSS clkload113/Y INVX1
Xclkload102 _19636_/CK VDD VSS clkload102/Y BUFX12
X_17267_ _19809_/Q _19777_/Q _17267_/C VDD VSS _17270_/B MIN3X1
XFILLER_60_2 VDD VSS FILLER1
Xclkload124 _18311_/CK VDD VSS clkload124/Y INVX2
X_19006_ _19172_/CK _19006_/D _19006_/Q VDD VSS DFFQX1
X_17198_ _17199_/C _17469_/B _17198_/C VDD VSS _19794_/D AND3BX1
X_16218_ _19687_/Q _16848_/B VDD VSS _16227_/B XNOR2X1
XFILLER_127_472 VDD VSS DECAPHV32
X_16149_ _16512_/A _16149_/B VDD VSS _19524_/D NOR2X1
XFILLER_46_0 VDD VSS FILLER4
XTAP_TAPCELL_ROW_132_1336 VDD VSS WELLTAP
XFILLER_102_328 VSS VDD FILLER2
XFILLER_111_840 VDD VSS DECAPHV8
XFILLER_130_637 VSS VDD FILLER2
XFILLER_130_659 VDD VSS DECAPHV8
XFILLER_69_743 VDD VSS FILLER1
X_19908_ clkload9/A _19908_/D _19908_/Q VDD VSS DFFQX1
XFILLER_111_862 VDD VSS FILLER1
XFILLER_111_873 VSS VDD FILLER2
XFILLER_29_629 VDD VSS FILLER1
X_19839_ _19907_/CK _19839_/D _19839_/Q VDD VSS DFFQX1
XFILLER_110_361 VDD VSS DECAPHV16
XFILLER_28_117 VSS VDD FILLER2
XFILLER_84_746 VSS VDD FILLER2
XFILLER_83_278 VDD VSS FILLER1
XTAP_TAPCELL_ROW_143_1443 VDD VSS WELLTAP
X_09523_ _18197_/D _09526_/B _09523_/C VDD VSS _20020_/D NOR3X1
X_09454_ _19967_/Q _09467_/B _09483_/B VDD VSS _09455_/C AOI21X1
XFILLER_51_164 VSS VDD FILLER2
XTAP_TAPCELL_ROW_34_351 VDD VSS WELLTAP
X_09385_ _18010_/A VDD VSS _17906_/C BUFX3
XFILLER_24_389 VDD VSS FILLER1
XFILLER_51_197 VDD VSS FILLER1
XFILLER_20_551 VDD VSS FILLER1
XFILLER_138_759 VDD VSS FILLER1
XFILLER_118_461 VDD VSS FILLER4
XFILLER_4_739 VDD VSS FILLER4
XFILLER_106_645 VDD VSS DECAPHV8
XFILLER_10_87 VDD VSS FILLER1
XFILLER_133_486 VSS VDD FILLER2
XFILLER_79_518 VDD VSS FILLER1
X_10160_ _10172_/C _10172_/B VDD VSS _10161_/B NAND2BX1
X_10091_ _10080_/Y _10090_/Y _10127_/A VDD VSS _10091_/Y MUX2X1
XFILLER_102_862 VDD VSS FILLER1
XFILLER_120_147 VDD VSS FILLER1
XFILLER_47_404 VSS VDD FILLER2
XFILLER_59_264 VDD VSS FILLER1
XFILLER_101_383 VDD VSS FILLER1
XFILLER_47_437 VDD VSS DECAPHV16
XFILLER_48_949 VDD VSS FILLER1
XFILLER_75_724 VDD VSS FILLER4
XFILLER_87_584 VDD VSS DECAPHV8
XFILLER_19_96 VDD VSS DECAPHV8
XFILLER_28_651 VDD VSS DECAPHV8
XFILLER_75_779 VSS VDD FILLER2
X_13850_ _13860_/A _14329_/B VDD VSS _14331_/C _13850_/C NAND3X1
X_10993_ _10990_/B _18570_/Q VDD VSS _11023_/B NAND2BX1
X_12801_ _12801_/A _12801_/B _12801_/C _12801_/D VDD VSS _12996_/A AOAI211X1
X_13781_ _13781_/A _13781_/B _13781_/C _13781_/D VDD VSS _14329_/C AO211X2
XTAP_TAPCELL_ROW_107_1084 VDD VSS WELLTAP
X_12732_ _12732_/A _12732_/B _12732_/C _12732_/D VDD VSS _12910_/A AO31X2
X_15520_ _15520_/A _15520_/B _15520_/C VDD VSS _15521_/B NOR3X1
XFILLER_42_142 VDD VSS FILLER1
XFILLER_42_153 VDD VSS FILLER1
XTAP_TAPCELL_ROW_60_619 VDD VSS WELLTAP
X_15451_ _19406_/Q _15787_/B VDD VSS _15465_/B XNOR2X1
XFILLER_42_164 VDD VSS FILLER1
XTAP_TAPCELL_ROW_6_77 VDD VSS WELLTAP
X_12663_ _12683_/A _14472_/B _12663_/C VDD VSS _14473_/C AOI21X1
X_14402_ _14426_/A _14402_/B VDD VSS _19123_/D NOR2X1
XFILLER_129_726 VDD VSS DECAPHV16
X_11614_ _18757_/Q _11624_/B VDD VSS _18784_/D AND2X1
X_12594_ _12732_/A _12732_/C VDD VSS _12724_/C AND2X1
X_18170_ _18170_/A _18170_/B VDD VSS _18174_/C NAND2X1
X_15382_ _15672_/A _18133_/B VDD VSS _19292_/D NOR2X1
X_11545_ _18694_/Q _11555_/B VDD VSS _18721_/D AND2X1
X_14333_ _14334_/A _14333_/B VDD VSS _19061_/D AND2X1
X_17121_ _17120_/B _17121_/B VDD VSS _17123_/C NOR2BX1
XFILLER_128_258 VDD VSS FILLER4
X_11476_ _18632_/Q _11484_/B VDD VSS _18659_/D AND2X1
X_14264_ _14270_/A _14264_/B VDD VSS _19002_/D AND2X1
X_17052_ _17208_/B _17073_/B VDD VSS _17064_/C XNOR2X1
XFILLER_7_599 VDD VSS FILLER1
X_10427_ _10388_/C _10427_/B _10427_/C VDD VSS _10503_/B NAND3BX1
X_13215_ _13215_/A _13271_/B _13271_/D _13271_/C VDD VSS _13422_/B AO211X2
X_16003_ _16031_/B _16003_/B VDD VSS _16838_/B XNOR2X1
XFILLER_136_280 VSS VDD FILLER2
XTAP_TAPCELL_ROW_118_1191 VDD VSS WELLTAP
X_14195_ _14219_/A _14195_/B _14195_/C VDD VSS _18945_/D NOR3X1
XFILLER_112_615 VDD VSS FILLER4
XFILLER_98_827 VDD VSS DECAPHV8
X_10358_ _18625_/Q _10358_/B _10358_/C VDD VSS _10511_/A OA21X2
X_13146_ _20012_/Q _19276_/Q VDD VSS _13343_/A XOR2X1
XFILLER_111_136 VDD VSS FILLER4
XFILLER_112_659 VDD VSS FILLER4
XFILLER_124_497 VSS VDD FILLER2
X_10289_ _18658_/Q _18766_/Q VDD VSS _10405_/B XOR2X1
X_13077_ _13077_/A _13077_/B _14123_/B VDD VSS _13081_/C MIN3X1
X_17954_ _17955_/A _17955_/B _18187_/C VDD VSS _17955_/C OAI21X1
XFILLER_78_540 VDD VSS FILLER1
X_12028_ wire162/Y _12029_/B _12029_/D _12029_/C VDD VSS _14433_/C AOI211X1
X_16905_ _20067_/Q _20070_/Q _20071_/Q VDD VSS _16906_/C AND3BX1
XFILLER_38_437 VDD VSS DECAPHV8
X_17885_ _17885_/A _17885_/B _17885_/C VDD VSS _17891_/C MIN3X1
XFILLER_76_91 VDD VSS FILLER1
X_19624_ _19703_/CK _19624_/D _19624_/Q VDD VSS DFFQX1
X_16836_ _16838_/A _16836_/B VDD VSS _19677_/D NOR2X1
XFILLER_19_662 VDD VSS FILLER4
XFILLER_19_673 VDD VSS DECAPHV16
XFILLER_53_418 VDD VSS FILLER1
XFILLER_65_267 VDD VSS DECAPHV8
XTAP_TAPCELL_ROW_76_774 VDD VSS WELLTAP
X_13979_ _14020_/A _14135_/B _14020_/C VDD VSS _14137_/B OAI21X1
X_19555_ _19591_/CK _19555_/D _19555_/Q VDD VSS DFFQX1
X_16767_ _16768_/A _16767_/B VDD VSS _19615_/D AND2X1
XFILLER_18_172 VDD VSS FILLER4
XTAP_TAPCELL_ROW_48_498 VDD VSS WELLTAP
X_19486_ _19707_/CK _19486_/D _19486_/Q VDD VSS DFFQX1
X_18506_ _18506_/CK _18506_/D _18506_/Q _09358_/Y VDD VSS DFFRQX1
X_15718_ _15739_/A _15718_/B VDD VSS _19344_/D NOR2X1
XFILLER_61_462 VSS VDD FILLER2
X_18437_ _18438_/CK _18469_/D _18437_/Q _20075_/RB VDD VSS DFFRQX1
X_16698_ _17712_/A _16704_/B VDD VSS _19552_/D NOR2X1
XFILLER_15_890 VDD VSS FILLER1
XFILLER_33_197 VDD VSS FILLER4
XFILLER_61_495 VSS VDD FILLER2
X_15649_ _15652_/A _15652_/B VDD VSS _18179_/B XNOR2X1
XTAP_TAPCELL_ROW_31_321 VDD VSS WELLTAP
X_18368_ _18375_/CK _18496_/D _20205_/A _18465_/RB VDD VSS DFFRQX1
X_18299_ _18311_/CK _18512_/Q _18299_/Q _20075_/RB VDD VSS DFFRQX1
X_17319_ _17320_/C _17469_/B _17319_/C VDD VSS _19820_/D AND3BX1
XFILLER_119_247 VSS VDD FILLER2
XFILLER_115_431 VDD VSS FILLER1
XFILLER_134_239 VDD VSS FILLER1
XFILLER_88_304 VDD VSS FILLER1
X_20192_ _20192_/A VDD VSS _20192_/Y BUFX3
XFILLER_130_412 VDD VSS FILLER1
XFILLER_130_489 VDD VSS FILLER1
XTAP_TAPCELL_ROW_39_410 VDD VSS WELLTAP
XFILLER_56_245 VDD VSS FILLER1
XFILLER_72_705 VSS VDD FILLER2
XFILLER_72_738 VDD VSS DECAPHV8
XFILLER_37_492 VDD VSS FILLER1
X_09506_ _18523_/Q _09507_/B _09506_/C _20080_/Q VDD VSS _20080_/D AO22X2
XFILLER_25_654 VSS VDD FILLER2
XFILLER_72_38 VDD VSS FILLER1
XFILLER_24_175 VDD VSS FILLER1
XFILLER_40_613 VSS VDD FILLER2
XFILLER_9_809 VSS VDD FILLER2
X_09437_ _09447_/B _09753_/D VDD VSS _18216_/E NOR2X1
X_09368_ _09576_/B VDD VSS _09770_/B BUFX3
XFILLER_138_534 VSS VDD FILLER2
XFILLER_138_545 VSS VDD FILLER2
X_09299_ _09299_/A VDD VSS _09299_/Y BUFX3
XFILLER_122_4 VSS VDD FILLER2
XFILLER_21_31 VSS VDD FILLER2
X_11330_ _11370_/A _11330_/B _11370_/C VDD VSS _11339_/B OAI21X1
XFILLER_125_206 VDD VSS FILLER1
XFILLER_137_20 VSS VDD FILLER2
XFILLER_106_442 VDD VSS FILLER1
XFILLER_108_2 VDD VSS FILLER1
X_11261_ _11262_/B _11261_/B _11261_/C _11378_/A VDD VSS _18580_/D AOI211X1
XFILLER_122_913 VSS VDD FILLER2
XFILLER_122_924 VSS VDD FILLER2
X_10212_ _18592_/Q _10220_/C VDD VSS _10213_/B NAND2X1
X_11192_ _18682_/Q _18790_/Q _11169_/B VDD VSS _11224_/C AOI21BX1
X_13000_ _19021_/Q _14287_/B _14287_/C VDD VSS _13008_/C OR3BX1
X_10143_ _10153_/B _10190_/C _10127_/A VDD VSS _10166_/B MUXI2X1
XFILLER_48_713 VDD VSS FILLER4
XTAP_TAPCELL_ROW_109_1102 VDD VSS WELLTAP
X_10074_ _10075_/A _10075_/B _10075_/D _10075_/C VDD VSS _10074_/Y OAOI211X1
X_14951_ _14951_/A _14951_/B _15681_/B VDD VSS _14989_/B MIN3X1
XFILLER_48_768 VDD VSS FILLER4
X_13902_ _19032_/Q _14300_/B _14300_/C VDD VSS _13903_/D NOR3BX1
X_17670_ _17672_/A _17670_/B _17670_/C VDD VSS _19895_/D AOI21X1
X_14882_ _15015_/A _15015_/B _15015_/D _15015_/C VDD VSS _14918_/D OAI211X1
XFILLER_46_61 VSS VDD FILLER2
XFILLER_63_738 VDD VSS FILLER4
XFILLER_75_576 VSS VDD FILLER2
X_13833_ _19003_/Q _13833_/B _13843_/C VDD VSS _13891_/C XNOR3X1
X_16621_ _19670_/Q _16621_/B _16829_/B VDD VSS _16647_/B MIN3X1
XFILLER_44_930 VSS VDD FILLER2
XTAP_TAPCELL_ROW_73_744 VDD VSS WELLTAP
X_19340_ _19551_/CK _19340_/D _19340_/Q VDD VSS DFFQX1
X_16552_ _16573_/A _16573_/B VDD VSS _16755_/B XNOR2X1
XFILLER_62_259 VDD VSS FILLER1
XFILLER_90_568 VDD VSS DECAPHV8
XTAP_TAPCELL_ROW_45_468 VDD VSS WELLTAP
X_10976_ _11004_/C _11004_/B VDD VSS _10977_/B NAND2BX1
X_13764_ _14263_/B _14263_/C _19001_/Q VDD VSS _13768_/B AOI21X1
X_15503_ _19351_/Q _15725_/B VDD VSS _15504_/C AND2X1
XFILLER_15_175 VDD VSS FILLER4
XFILLER_16_687 VDD VSS FILLER4
XFILLER_30_112 VSS VDD FILLER2
XFILLER_71_782 VSS VDD FILLER2
X_12715_ _12868_/A _12868_/B VDD VSS _14285_/B XNOR2X1
X_13695_ _19030_/Q VDD VSS _13777_/A INVX1
X_19271_ _20008_/CK _19271_/D _19271_/Q VDD VSS DFFQX1
X_16483_ _19665_/Q _16823_/B VDD VSS _16494_/B XOR2X1
X_12646_ _19158_/Q VDD VSS _12737_/A INVX1
X_18222_ _18235_/CK _18222_/E _18222_/ECK VDD VSS CGX3
X_15434_ _15434_/A _15434_/B VDD VSS _15472_/A OR2X2
X_18153_ _19296_/Q _18153_/B _18153_/C VDD VSS _18159_/A MIN3X1
X_15365_ _15395_/C _15365_/B VDD VSS _15848_/B NAND2BX1
XFILLER_8_864 VDD VSS FILLER4
X_12577_ _12577_/A _12577_/B _12583_/A _12577_/D VDD VSS _12673_/C AOI211X1
X_14316_ _18163_/A VDD VSS _14316_/Y BUFX3
X_17104_ _19775_/Q _19743_/Q VDD VSS _17105_/B XOR2X1
XFILLER_7_88 VDD VSS FILLER4
XFILLER_8_886 VSS VDD FILLER2
X_11528_ _18680_/Q _11531_/B VDD VSS _18707_/D AND2X1
X_18084_ _19283_/Q _18084_/B VDD VSS _18085_/A AND2X1
X_15296_ _15335_/A _15296_/B VDD VSS _18123_/B XNOR2X1
XFILLER_116_239 VSS VDD FILLER2
XFILLER_144_559 VDD VSS FILLER4
X_11459_ _19952_/Q _11460_/B VDD VSS _18645_/D AND2X1
X_14247_ _14270_/A _14247_/B VDD VSS _18987_/D AND2X1
X_17035_ _19761_/Q _17047_/B VDD VSS _17040_/B XOR2X1
XFILLER_124_250 VDD VSS FILLER1
X_14178_ _14186_/A _14178_/B VDD VSS _18930_/D NOR2X1
Xclkbuf_1_1__f__09180_ clkbuf_0__09180_/Y VDD VSS _18626_/CK BUFX12
XFILLER_125_795 VDD VSS FILLER1
X_13129_ _13133_/A _13133_/C _13133_/B _13129_/D VDD VSS _13444_/A AO31X2
XFILLER_79_860 VSS VDD FILLER2
X_18986_ _19040_/CK _18986_/D _18986_/Q VDD VSS DFFQX1
XFILLER_39_724 VSS VDD FILLER2
XFILLER_97_178 VDD VSS FILLER1
X_17937_ _17937_/A _17937_/B _18865_/Q VDD VSS _17946_/B AOI21X1
X_17868_ _18849_/Q _17868_/B _17868_/C VDD VSS _17869_/C MIN3X1
XFILLER_94_874 VDD VSS DECAPHV8
X_19607_ _19673_/CK _19607_/D _19607_/Q VDD VSS DFFQX1
X_16819_ _16826_/A _16819_/B VDD VSS _19661_/D NOR2X1
XFILLER_81_557 VDD VSS FILLER1
Xclkbuf_0__000_ _230_/ECK VDD VSS clkbuf_0__000_/Y BUFX12
X_17799_ _19924_/Q _19892_/Q VDD VSS _17802_/A XNOR2X1
XTAP_TAPCELL_ROW_140_1413 VDD VSS WELLTAP
X_19538_ _19716_/CK _19538_/D _19538_/Q VDD VSS DFFQX1
XFILLER_62_793 VDD VSS DECAPHV8
X_19469_ _19495_/CK _19469_/D _19469_/Q VDD VSS DFFQX1
X_09222_ _18525_/Q VDD VSS _18392_/D INVX1
XFILLER_108_707 VDD VSS DECAPHV8
XFILLER_21_189 VSS VDD FILLER2
XTAP_TAPCELL_ROW_138_1397 VDD VSS WELLTAP
XFILLER_116_773 VDD VSS FILLER1
XFILLER_115_261 VDD VSS FILLER4
XFILLER_143_581 VDD VSS FILLER4
XFILLER_107_89 VDD VSS FILLER4
X_09986_ _18578_/Q _09986_/B VDD VSS _09986_/Y XOR2X1
X_20175_ _20175_/A VDD VSS _20175_/Y BUFX3
XFILLER_67_49 VSS VDD FILLER2
XFILLER_84_340 VSS VDD FILLER2
XFILLER_57_565 VDD VSS DECAPHV8
XFILLER_85_874 VDD VSS FILLER1
XFILLER_72_546 VDD VSS DECAPHV8
XFILLER_83_48 VDD VSS FILLER4
XFILLER_44_248 VDD VSS FILLER1
X_10830_ _18672_/Q _18780_/Q VDD VSS _10832_/C XNOR2X1
XFILLER_25_484 VDD VSS FILLER4
XFILLER_41_911 VDD VSS DECAPHV8
XFILLER_52_270 VDD VSS FILLER1
XFILLER_53_771 VDD VSS FILLER1
XTAP_TAPCELL_ROW_104_1054 VDD VSS WELLTAP
XTAP_TAPCELL_ROW_70_714 VDD VSS WELLTAP
X_10761_ _10801_/A _10761_/B VDD VSS _10762_/C XNOR2X1
XFILLER_13_646 VDD VSS FILLER4
XFILLER_40_421 VSS VDD FILLER2
XTAP_TAPCELL_ROW_42_438 VDD VSS WELLTAP
X_10692_ _10729_/C _10729_/D _10693_/D _10729_/E VDD VSS _10692_/Y AOI211X1
X_12500_ _12583_/A _12583_/B VDD VSS _12677_/C NOR2X1
X_13480_ _13511_/A _13511_/B _13511_/C VDD VSS _13489_/C OAI21X1
XFILLER_12_167 VSS VDD FILLER2
XFILLER_40_465 VSS VDD FILLER2
X_12431_ _12528_/A _12528_/B _12611_/C VDD VSS _17853_/B XNOR3X1
XFILLER_139_865 VSS VDD FILLER2
XFILLER_32_63 VDD VSS FILLER1
XFILLER_32_74 VDD VSS FILLER1
XTAP_TAPCELL_ROW_3_45 VDD VSS WELLTAP
X_12362_ _19098_/Q _14375_/B _14375_/C VDD VSS _12363_/D OR3BX1
X_15150_ _19510_/Q _15904_/B VDD VSS _15275_/A NAND2BX1
XFILLER_113_0 VSS VDD FILLER2
XFILLER_5_856 VDD VSS FILLER4
X_11313_ _11316_/A _11316_/B VDD VSS _11314_/B XNOR2X1
X_12293_ _12294_/B _12294_/C _12512_/A VDD VSS _12366_/B OAI21X1
X_14101_ _14101_/A _14101_/B _14101_/C _14101_/D VDD VSS _17964_/B AOAI211X1
X_15081_ _19369_/Q _15081_/B _15746_/B VDD VSS _15134_/A MIN3X1
XFILLER_141_529 VDD VSS FILLER1
XFILLER_4_355 VDD VSS FILLER4
XFILLER_5_867 VSS VDD FILLER2
XFILLER_5_889 VDD VSS DECAPHV8
XTAP_TAPCELL_ROW_115_1161 VDD VSS WELLTAP
X_11244_ _11255_/A _11244_/B _11255_/C VDD VSS _11288_/B AOI21X1
X_14032_ _14045_/A _14045_/B _14032_/C _14045_/E VDD VSS _14202_/B AOI211X1
XFILLER_122_754 VSS VDD FILLER2
XFILLER_68_808 VDD VSS FILLER1
X_11175_ _11176_/B _11175_/B VDD VSS _11177_/B NOR2BX1
X_18840_ _19958_/CK _18840_/D _18840_/Q VDD VSS DFFQX1
XFILLER_0_583 VSS VDD FILLER2
XFILLER_79_189 VSS VDD FILLER2
XFILLER_94_104 VDD VSS FILLER4
X_10126_ _10126_/A _10126_/B _10126_/C VDD VSS _10150_/A OAI21X1
X_18771_ _18799_/CK _18771_/D _18771_/Q VDD VSS DFFQX1
X_15983_ _19676_/Q _16835_/B VDD VSS _16015_/B XOR2X1
XFILLER_48_521 VDD VSS FILLER1
X_10057_ _10031_/Y _10056_/Y _10155_/A VDD VSS _10059_/B MUX2X1
X_17722_ _19907_/Q _19875_/Q VDD VSS _17724_/B XOR2X1
X_14934_ _19450_/Q wire161/Y _15000_/B VDD VSS _14959_/D XNOR3X1
XFILLER_91_800 VDD VSS DECAPHV16
X_17653_ _19891_/Q _19859_/Q _17653_/C VDD VSS _17657_/C MIN3X1
XTAP_TAPCELL_ROW_58_593 VDD VSS WELLTAP
XTAP_TAPCELL_ROW_86_880 VDD VSS WELLTAP
X_16604_ _19606_/Q _16757_/B VDD VSS _16606_/C XOR2X1
X_14865_ _14865_/A _14865_/B _14865_/C _14865_/D VDD VSS _15833_/C OA211X2
X_13816_ _13816_/A _13816_/B _13816_/C _13816_/D VDD VSS _13987_/A AOAI211X1
X_17584_ _17589_/C _17589_/B VDD VSS _17586_/B NAND2BX1
X_14796_ _19419_/Q _14813_/B _15802_/B VDD VSS _15769_/B XNOR3X1
XFILLER_44_793 VDD VSS FILLER1
X_10959_ _11263_/A _10996_/A VDD VSS _10989_/A NOR2X1
X_13747_ _18917_/Q _14163_/B _14163_/C VDD VSS _13751_/D OR3BX1
X_19323_ _19358_/CK _19323_/D _19323_/Q VDD VSS DFFQX1
X_16535_ _19699_/Q _16861_/B VDD VSS _16537_/C XOR2X1
X_19254_ _19988_/CK _19254_/D _19254_/Q VDD VSS DFFQX1
X_16466_ _19728_/Q VDD VSS _16467_/A INVX1
XFILLER_85_4 VSS VDD FILLER2
X_13678_ _13768_/A _13830_/B VDD VSS _14228_/B XNOR2X1
X_15417_ _15456_/A _15417_/B VDD VSS _15692_/B XNOR2X1
X_12629_ _12630_/A _12630_/B _12630_/D _12630_/C VDD VSS _12731_/B OAOI211X1
X_19185_ _19242_/CK _19185_/D _19185_/Q VDD VSS DFFQX1
X_16397_ _19598_/Q _16748_/B VDD VSS _16420_/B XOR2X1
XFILLER_129_386 VDD VSS DECAPHV32
X_18136_ _18136_/A _18136_/B _18136_/C VDD VSS _18139_/B OAI21X1
X_15348_ _15348_/A _15815_/B _15348_/C VDD VSS _15391_/B OA21X2
X_18067_ _18069_/A _18069_/B _18067_/C VDD VSS _19988_/D AOI21X1
X_15279_ _19486_/Q _15308_/A _15308_/B VDD VSS _15281_/C XOR3X1
X_17018_ _17009_/B _17018_/B VDD VSS _17019_/D NAND2BX1
XFILLER_113_710 VSS VDD FILLER2
XFILLER_112_242 VSS VDD FILLER2
X_09840_ _09910_/A _09910_/B VDD VSS _09841_/C NOR2X1
XFILLER_101_949 VDD VSS FILLER1
XFILLER_140_584 VDD VSS FILLER1
XTAP_TAPCELL_ROW_129_1308 VDD VSS WELLTAP
X_09771_ _20150_/A _09785_/B _09784_/C _20175_/A VDD VSS _09772_/D AOI22X1
X_18969_ _18970_/CK _18969_/D _18969_/Q VDD VSS DFFQX1
XFILLER_67_830 VDD VSS FILLER4
XFILLER_27_716 VDD VSS DECAPHV8
XFILLER_66_351 VDD VSS FILLER4
XFILLER_82_800 VDD VSS DECAPHV16
XFILLER_94_693 VDD VSS FILLER4
XFILLER_42_719 VDD VSS FILLER4
XFILLER_23_933 VDD VSS FILLER4
XFILLER_34_270 VDD VSS FILLER1
XFILLER_81_387 VDD VSS DECAPHV32
XFILLER_22_421 VDD VSS FILLER4
XFILLER_139_128 VDD VSS DECAPHV16
X_09205_ _18477_/D VDD VSS _18429_/D INVX1
XFILLER_108_526 VDD VSS FILLER1
XFILLER_135_301 VSS VDD FILLER2
XFILLER_136_824 VDD VSS FILLER1
XFILLER_136_857 VDD VSS DECAPHV8
XFILLER_118_44 VSS VDD FILLER2
XFILLER_2_815 VSS VDD FILLER2
XFILLER_2_848 VSS VDD FILLER2
XFILLER_104_787 VSS VDD FILLER2
XFILLER_89_476 VDD VSS FILLER4
X_20158_ _20158_/A VDD VSS _20158_/Y BUFX3
XFILLER_76_148 VDD VSS FILLER4
XFILLER_94_69 VDD VSS FILLER1
X_12980_ _18993_/Q _14254_/B VDD VSS _13004_/A NAND2X1
X_20089_ _20089_/A VDD VSS _20089_/Y BUFX3
XFILLER_27_41 VSS VDD FILLER2
XFILLER_73_855 VDD VSS FILLER4
X_11931_ _19996_/Q _19260_/Q VDD VSS _11933_/C NAND2X1
XFILLER_27_96 VDD VSS DECAPHV8
XFILLER_33_719 VDD VSS FILLER4
XFILLER_84_192 VDD VSS FILLER4
XTAP_TAPCELL_ROW_83_850 VDD VSS WELLTAP
X_11862_ _19090_/Q VDD VSS _11864_/A INVX1
X_14650_ _14742_/C _14705_/C VDD VSS _15891_/B OR2X2
XFILLER_13_410 VDD VSS DECAPHV32
XFILLER_14_922 VDD VSS FILLER1
XTAP_TAPCELL_ROW_55_563 VDD VSS WELLTAP
X_10813_ _10814_/A _10814_/B _10814_/C VDD VSS _10813_/Y NOR3X1
X_13601_ _13601_/A _13601_/B _13601_/C _13601_/D VDD VSS _14326_/B AOAI211X1
X_14581_ _14584_/B _14584_/C VDD VSS _15856_/B XNOR2X1
XFILLER_14_944 VDD VSS FILLER4
XTAP_TAPCELL_ROW_27_287 VDD VSS WELLTAP
X_11793_ _11793_/A _11793_/B _14458_/B VDD VSS _11794_/B MIN3X1
X_13532_ _13728_/B _14326_/C _19055_/Q VDD VSS _13533_/D AND3BX1
Xclkbuf_1_0__f__09183_ clkbuf_0__09183_/Y VDD VSS _18543_/CK BUFX12
X_16320_ _16320_/A _16320_/B _16320_/C VDD VSS _16321_/B NOR3X1
X_10744_ _10785_/A _10785_/B VDD VSS _10745_/B NAND2X1
XFILLER_43_84 VDD VSS DECAPHV8
X_10675_ _10718_/C _10675_/B VDD VSS _10679_/A NAND2BX1
X_13463_ _19223_/Q _14516_/B VDD VSS _13557_/B XOR2X1
X_16251_ _19688_/Q _16251_/B _16849_/B VDD VSS _16278_/B MIN3X1
X_12414_ _19212_/Q _12486_/B _12497_/C VDD VSS _12662_/B XNOR3X1
X_13394_ _18997_/Q _14259_/B _14259_/C VDD VSS _13395_/D OR3BX1
X_16182_ _16163_/A _16182_/B _16182_/C VDD VSS _16206_/B AOI2B1X1
X_15202_ _15201_/B _15227_/B VDD VSS _15812_/C NOR2BX1
XFILLER_138_172 VDD VSS FILLER1
X_12345_ _13283_/A _17847_/B VDD VSS _18847_/D AND2X1
X_15133_ _19342_/Q _15716_/B _15133_/C VDD VSS _15172_/A MIN3X1
XFILLER_126_356 VDD VSS FILLER1
XFILLER_126_367 VSS VDD FILLER2
XFILLER_107_581 VDD VSS FILLER1
X_12276_ _18959_/Q VDD VSS _12354_/A INVX1
X_19941_ _19949_/CK _19941_/D _19941_/Q VDD VSS DFFQX1
X_15064_ _15872_/B _15064_/B _15099_/C VDD VSS _15873_/B XNOR3X1
XFILLER_4_45 VDD VSS FILLER1
X_11227_ _18656_/Q _18818_/Q _11227_/C VDD VSS _11229_/B MIN3X1
X_14015_ _18951_/Q _14015_/B _14032_/C VDD VSS _14054_/C XNOR3X1
X_19872_ _19907_/CK _19872_/D _19872_/Q VDD VSS DFFQX1
XFILLER_68_81 VDD VSS DECAPHV16
XFILLER_96_925 VSS VDD FILLER2
X_11158_ _18575_/Q _11158_/B _11158_/C VDD VSS _11217_/A MIN3X1
X_18823_ _19940_/CK _18823_/D _18823_/Q VDD VSS DFFQX1
XFILLER_49_852 VSS VDD FILLER2
X_10109_ _10131_/A _10191_/B _10109_/C _18609_/Q VDD VSS _10122_/A AOAI211X1
XFILLER_95_468 VDD VSS DECAPHV8
X_11089_ _18574_/Q VDD VSS _11126_/A INVX1
X_18754_ _19947_/CK _18754_/D _18754_/Q VDD VSS DFFQX1
X_15966_ _19582_/Q _16731_/B VDD VSS _15993_/B XOR2X1
XFILLER_64_822 VDD VSS FILLER1
XFILLER_64_844 VDD VSS DECAPHV8
XFILLER_76_682 VDD VSS FILLER1
X_18685_ _18768_/CK _18685_/D _18685_/Q VDD VSS DFFQX1
X_17705_ _17707_/B _17705_/B VDD VSS _17706_/B XOR2X1
X_15897_ _15906_/A _15897_/B VDD VSS _19503_/D NOR2X1
X_14917_ _14918_/A _14918_/B _14966_/B _14918_/D VDD VSS _15868_/B AND4X2
XFILLER_91_641 VDD VSS FILLER1
X_17636_ _17638_/A _17638_/B _17636_/C VDD VSS _19888_/D AOI21X1
X_14848_ _19336_/Q _15709_/B VDD VSS _14851_/A XOR2X1
Xclkbuf_leaf_16__000_ clkbuf_leaf_9__000_/A VDD VSS _19696_/CK BUFX12
X_17567_ _19873_/Q _19841_/Q _17567_/C VDD VSS _17570_/B MIN3X1
X_19306_ _19322_/CK _19306_/D _19306_/Q VDD VSS DFFQX1
X_16518_ _19666_/Q _16518_/B _16824_/B VDD VSS _16545_/B MIN3X1
X_14779_ _14818_/A _14818_/B _14818_/C VDD VSS _14795_/A AOI21X1
XFILLER_31_251 VDD VSS DECAPHV8
X_17498_ _19858_/Q _19826_/Q _17498_/C VDD VSS _17503_/C AO21X2
X_19237_ _20005_/CK _19237_/D _19237_/Q VDD VSS DFFQX1
X_16449_ _19919_/Q VDD VSS _16715_/A INVX1
X_19168_ _19196_/CK _19168_/D _19168_/Q VDD VSS DFFQX1
XFILLER_8_491 VDD VSS DECAPHV8
X_18119_ _19290_/Q _18123_/B VDD VSS _18121_/C XOR2X1
XFILLER_133_816 VDD VSS DECAPHV8
XFILLER_144_142 VDD VSS DECAPHV32
XTAP_TAPCELL_ROW_135_1367 VDD VSS WELLTAP
X_19099_ _19126_/CK _19099_/D _19099_/Q VDD VSS DFFQX1
XTAP_TAPCELL_ROW_89_909 VDD VSS WELLTAP
XFILLER_58_104 VDD VSS FILLER1
XFILLER_59_616 VDD VSS DECAPHV8
XFILLER_98_251 VSS VDD FILLER2
X_09823_ _10266_/C VDD VSS _10686_/D BUFX3
X_20012_ _20013_/CK _20012_/D _20012_/Q VDD VSS DFFQX1
Xclkbuf_0__09177_ _18226_/ECK VDD VSS clkbuf_0__09177_/Y BUFX12
XFILLER_101_779 VSS VDD FILLER2
XFILLER_104_24 VDD VSS DECAPHV8
XFILLER_86_479 VDD VSS FILLER1
XTAP_TAPCELL_ROW_97_986 VDD VSS WELLTAP
X_09754_ _20077_/Q _09818_/B _09754_/C _09791_/A _09754_/E VDD VSS _09761_/A AOI221X1
XFILLER_104_57 VSS VDD FILLER2
XFILLER_104_79 VDD VSS DECAPHV8
XFILLER_27_513 VDD VSS FILLER1
XFILLER_55_844 VSS VDD FILLER2
XFILLER_67_682 VDD VSS DECAPHV8
XFILLER_82_630 VDD VSS FILLER1
X_09685_ _18447_/Q VDD VSS _20159_/A INVX1
XFILLER_64_28 VDD VSS FILLER1
XFILLER_14_218 VDD VSS DECAPHV8
XFILLER_27_579 VDD VSS FILLER4
XFILLER_70_814 VSS VDD FILLER2
XFILLER_81_173 VSS VDD FILLER2
XFILLER_82_696 VDD VSS FILLER1
XTAP_TAPCELL_ROW_52_533 VDD VSS WELLTAP
XTAP_TAPCELL_ROW_80_820 VDD VSS WELLTAP
XTAP_TAPCELL_ROW_101_1024 VDD VSS WELLTAP
XTAP_TAPCELL_ROW_24_257 VDD VSS WELLTAP
XFILLER_50_571 VSS VDD FILLER2
XFILLER_80_49 VDD VSS FILLER1
XFILLER_109_802 VDD VSS FILLER4
XFILLER_6_417 VDD VSS FILLER1
X_10460_ _10460_/A _10460_/B _10460_/C _10460_/D VDD VSS _10461_/B AOI211X1
XFILLER_108_356 VSS VDD FILLER2
XFILLER_124_805 VSS VDD FILLER2
XFILLER_135_131 VDD VSS DECAPHV8
XFILLER_135_153 VDD VSS FILLER1
X_10391_ _10392_/A _10392_/B VDD VSS _10393_/B NAND2X1
XFILLER_124_838 VDD VSS FILLER4
XTAP_TAPCELL_ROW_0_13 VDD VSS WELLTAP
X_12130_ _18957_/Q VDD VSS _12199_/A INVX1
XFILLER_2_667 VDD VSS FILLER1
XTAP_TAPCELL_ROW_112_1131 VDD VSS WELLTAP
X_12061_ _19123_/Q _12147_/A _12181_/B VDD VSS _12254_/B XNOR3X1
XFILLER_104_562 VSS VDD FILLER2
XFILLER_78_947 VSS VDD FILLER2
XFILLER_89_262 VSS VDD FILLER2
X_11012_ _11078_/A _18731_/Q VDD VSS _11013_/D NAND2X1
XFILLER_49_126 VDD VSS DECAPHV16
X_15820_ _15830_/A _15820_/B VDD VSS _19435_/D NOR2X1
XFILLER_64_107 VDD VSS FILLER1
XFILLER_77_468 VDD VSS FILLER4
XFILLER_92_405 VSS VDD FILLER2
XFILLER_38_73 VDD VSS FILLER1
XFILLER_58_693 VDD VSS FILLER4
XFILLER_92_438 VSS VDD FILLER2
X_12963_ _20009_/Q _19273_/Q VDD VSS _13054_/A XNOR2X1
X_15751_ _15758_/A _15751_/B VDD VSS _19374_/D NOR2X1
XFILLER_18_546 VDD VSS FILLER1
XFILLER_57_181 VDD VSS FILLER1
XFILLER_73_641 VDD VSS FILLER4
X_11914_ _19174_/Q _14460_/B VDD VSS _11916_/C _14460_/C AND3X2
X_18470_ _18471_/CK _18470_/D _18470_/Q _18471_/RB VDD VSS DFFRQX1
X_15682_ _15706_/A _15682_/B VDD VSS _19311_/D AND2X1
X_14702_ _19444_/Q _14702_/B _14702_/C VDD VSS _14776_/B MIN3X1
X_12894_ _12894_/A _12894_/B _12894_/C VDD VSS _12896_/B OA21X2
X_14633_ _19386_/Q _15764_/B VDD VSS _14667_/B NOR2X1
X_17421_ _17536_/A _17421_/B _17422_/C VDD VSS _19842_/D NOR3X1
X_11845_ _19231_/Q _11881_/D _11845_/C VDD VSS _11979_/C XNOR3X1
X_11776_ _11776_/A _11776_/B _11776_/C _11776_/D VDD VSS _11828_/A AOAI211X1
X_14564_ _20003_/Q _14569_/B VDD VSS _19267_/D AND2X1
Xclkbuf_1_0__f__09166_ clkbuf_0__09166_/Y VDD VSS _18423_/CK BUFX12
X_17352_ _19828_/Q _19796_/Q VDD VSS _17355_/A XNOR2X1
XFILLER_13_273 VDD VSS FILLER4
X_10727_ _18695_/Q _18749_/Q VDD VSS _10765_/A NOR2X1
X_13515_ _18971_/Q wire155/Y _14225_/C VDD VSS _13516_/D OR3BX1
X_14495_ _14491_/Y _14495_/B _14495_/C VDD VSS _19206_/D AND3BX1
X_17283_ _19813_/Q _19781_/Q VDD VSS _17289_/B NAND2X1
X_16303_ _16301_/Y _16305_/B _17986_/C VDD VSS _19530_/D AND3BX1
X_13446_ _14544_/A _14544_/B _19249_/Q VDD VSS _13447_/D OAI21X1
X_19022_ _19050_/CK _19022_/D _19022_/Q VDD VSS DFFQX1
X_16234_ _19560_/Q _19912_/Q VDD VSS _16237_/A XOR2X1
X_10658_ _11267_/A _10658_/B VDD VSS _10659_/D NOR2X1
Xclkload25 _19986_/CK VDD VSS clkload25/Y INVX4
Xclkload14 _19795_/CK VDD VSS clkload14/Y INVX1
XFILLER_126_142 VDD VSS FILLER4
X_10589_ _18559_/Q _10589_/B VDD VSS _10592_/D NOR2X1
X_13377_ _18942_/Q _13377_/B _13391_/D VDD VSS _13393_/C XNOR3X1
Xclkload69 _19004_/CK VDD VSS clkload69/Y INVX2
Xclkload58 _19126_/CK VDD VSS clkload58/Y INVX2
Xclkload47 _19137_/CK VDD VSS clkload47/Y BUFX12
Xclkload36 _19948_/CK VDD VSS clkload36/Y INVX1
X_16165_ _16179_/B _16165_/B VDD VSS _16810_/B XNOR2X1
XFILLER_142_624 VDD VSS FILLER1
X_12328_ _12329_/D _14501_/B VDD VSS _12474_/A NAND2X1
X_16096_ _19682_/Q _16842_/B VDD VSS _16097_/B XNOR2X1
X_15116_ _15116_/A _15116_/B VDD VSS _15810_/B XNOR2X1
XFILLER_130_808 VDD VSS FILLER1
X_12259_ _12363_/A _12363_/B VDD VSS _12451_/C _12363_/C NAND3X1
X_19924_ clkload7/A _19924_/D _19924_/Q VDD VSS DFFQX1
X_15047_ _15054_/A _15054_/B _15054_/C VDD VSS _15837_/B OA21X2
XFILLER_96_700 VSS VDD FILLER2
XFILLER_122_370 VDD VSS FILLER4
X_19855_ _19892_/CK _19855_/D _19855_/Q VDD VSS DFFQX1
X_19786_ _19830_/CK _19786_/D _19786_/Q VDD VSS DFFQX1
X_18806_ _18809_/CK _18806_/D _18806_/Q VDD VSS DFFQX1
X_16998_ _17000_/B _16998_/B VDD VSS _16999_/B XOR2X1
XFILLER_48_170 VDD VSS FILLER4
XFILLER_49_693 VDD VSS FILLER1
XFILLER_95_90 VSS VDD FILLER2
X_18737_ _18764_/CK _18737_/D _18737_/Q VDD VSS DFFQX1
X_15949_ _19611_/Q _16763_/B VDD VSS _15950_/B XNOR2X1
XTAP_TAPCELL_ROW_94_956 VDD VSS WELLTAP
X_09470_ _19974_/Q _09490_/B _09476_/C VDD VSS _09471_/C AOI21X1
XFILLER_52_814 VDD VSS DECAPHV8
XFILLER_64_696 VDD VSS FILLER1
X_18668_ _19948_/CK _18668_/D _18668_/Q VDD VSS DFFQX1
XFILLER_51_346 VDD VSS FILLER1
X_18599_ _18608_/CK _18599_/D _18599_/Q VDD VSS DFFQX1
X_17619_ _17620_/C _18127_/B _17619_/C VDD VSS _19884_/D AND3BX1
XFILLER_20_700 VDD VSS DECAPHV32
XFILLER_60_880 VSS VDD FILLER2
XFILLER_60_891 VDD VSS FILLER1
XTAP_TAPCELL_ROW_21_227 VDD VSS WELLTAP
Xclkload8 clkload8/A VDD VSS clkload8/Y INVX1
XFILLER_118_632 VDD VSS FILLER1
XFILLER_133_602 VDD VSS DECAPHV8
XFILLER_105_304 VDD VSS DECAPHV8
XFILLER_106_827 VDD VSS DECAPHV8
XFILLER_118_687 VDD VSS DECAPHV8
XFILLER_133_646 VDD VSS FILLER4
XFILLER_114_882 VDD VSS FILLER1
Xfanout223 _20081_/RB VDD VSS _18503_/RB BUFX3
Xfanout212 _20075_/RB VDD VSS _18464_/RB BUFX3
Xfanout201 _20071_/RB VDD VSS _20043_/RB BUFX3
XFILLER_101_510 VDD VSS FILLER1
XFILLER_59_424 VDD VSS FILLER1
XFILLER_99_593 VDD VSS DECAPHV8
XFILLER_101_543 VSS VDD FILLER2
XFILLER_101_565 VSS VDD FILLER2
XFILLER_59_457 VSS VDD FILLER2
XFILLER_86_243 VDD VSS FILLER1
X_09806_ _18423_/Q VDD VSS _20178_/A INVX1
XFILLER_74_449 VDD VSS FILLER4
XTAP_TAPCELL_ROW_29_305 VDD VSS WELLTAP
X_09737_ _18338_/Q _09810_/B _09737_/C _09737_/D VDD VSS _09745_/B OA211X2
XFILLER_43_814 VDD VSS DECAPHV16
XFILLER_55_696 VSS VDD FILLER2
X_09668_ _18350_/Q VDD VSS _20218_/A INVX1
XTAP_TAPCELL_ROW_37_382 VDD VSS WELLTAP
X_09599_ _09816_/D _18393_/Q _09599_/C _09753_/D VDD VSS _09600_/E OAOI211X1
XFILLER_91_59 VDD VSS DECAPHV8
X_11630_ _18772_/Q _11635_/B VDD VSS _18799_/D AND2X1
XFILLER_51_880 VDD VSS FILLER4
X_11561_ _18709_/Q _11567_/B VDD VSS _18736_/D AND2X1
X_231_ _231_/CK _231_/E _231_/ECK VDD VSS CGX3
XFILLER_10_243 VDD VSS FILLER1
XFILLER_11_755 VDD VSS FILLER4
X_10512_ _10512_/A VDD VSS _11255_/A BUFX3
X_13300_ _18997_/Q _13300_/B _13300_/C VDD VSS _13395_/C XNOR3X1
XFILLER_6_225 VDD VSS FILLER4
XFILLER_7_737 VSS VDD FILLER2
X_11492_ _18647_/Q _11496_/B VDD VSS _18674_/D AND2X1
X_14280_ _14285_/A _14280_/B VDD VSS _19014_/D NOR2X1
XFILLER_108_142 VDD VSS FILLER1
XFILLER_109_654 VDD VSS FILLER4
XFILLER_124_602 VSS VDD FILLER2
X_10443_ _10803_/A _10443_/B _10514_/B _10443_/D VDD VSS _10462_/A AOI31X1
X_13231_ _13231_/A _14385_/B _13231_/C _13231_/D VDD VSS _13432_/A OAOI211X1
XFILLER_108_164 VDD VSS FILLER1
XFILLER_124_635 VDD VSS DECAPHV8
XFILLER_136_462 VDD VSS FILLER4
XFILLER_136_495 VSS VDD FILLER2
XFILLER_3_921 VSS VDD FILLER2
XFILLER_40_74 VSS VDD FILLER2
X_10374_ _10399_/A _10399_/B _10399_/C _10927_/C VDD VSS _10375_/D AOI31X1
X_13162_ _19079_/Q _14353_/B VDD VSS _13271_/B _14353_/C NAND3X1
XFILLER_124_657 VDD VSS DECAPHV8
XFILLER_6_0 VDD VSS FILLER1
X_12113_ _12113_/A _12113_/B _12113_/C _12113_/D VDD VSS _14465_/C OA211X2
XFILLER_105_871 VSS VDD FILLER2
XFILLER_78_700 VDD VSS DECAPHV16
X_13093_ _19051_/Q _13271_/A _13098_/B VDD VSS _13095_/C XOR3X1
Xclkbuf_leaf_15__001_ clkload41/A VDD VSS _19115_/CK BUFX12
X_17970_ _17976_/A _17976_/B _17971_/C VDD VSS _17970_/Y NOR3X1
XFILLER_123_189 VDD VSS DECAPHV8
XFILLER_77_210 VDD VSS FILLER4
X_12044_ _19233_/Q _14527_/B VDD VSS _12053_/A NAND2X1
X_16921_ _19738_/Q _16922_/B _17081_/C VDD VSS _16922_/C OAI21X1
XFILLER_78_788 VSS VDD FILLER2
X_19640_ _19671_/CK _19640_/D _19640_/Q VDD VSS DFFQX1
X_16852_ _16865_/A _16852_/B VDD VSS _19691_/D NOR2X1
XFILLER_18_310 VSS VDD FILLER2
XFILLER_92_213 VSS VDD FILLER2
XFILLER_93_747 VDD VSS FILLER4
X_19571_ _19604_/CK _19571_/D _19571_/Q VDD VSS DFFQX1
X_16783_ _16794_/A _16783_/B VDD VSS _19629_/D NOR2X1
X_15803_ _15816_/A _15803_/B VDD VSS _19420_/D NOR2X1
XFILLER_1_68 VDD VSS FILLER1
XFILLER_65_60 VDD VSS FILLER1
XFILLER_81_909 VSS VDD FILLER2
X_13995_ _13995_/A _13995_/B _13995_/C _13995_/D VDD VSS _14085_/A AOAI211X1
X_18522_ _18522_/CK _18522_/D _18522_/Q _09310_/Y VDD VSS DFFRQX1
X_15734_ _15743_/A _15734_/B VDD VSS _19359_/D AND2X1
XFILLER_33_302 VSS VDD FILLER2
XFILLER_34_825 VDD VSS DECAPHV8
XFILLER_61_600 VDD VSS DECAPHV8
XTAP_TAPCELL_ROW_91_926 VDD VSS WELLTAP
X_12946_ _13036_/A _13036_/B _13032_/C VDD VSS _14476_/B AOI21BX1
XFILLER_33_346 VDD VSS FILLER1
XFILLER_73_493 VSS VDD FILLER2
X_12877_ _12877_/A _12877_/B _14184_/B VDD VSS _12888_/C MIN3X1
X_18453_ _18453_/CK _18469_/D _20151_/A _18453_/RB VDD VSS DFFRQX1
X_15665_ _15666_/A _15702_/B VDD VSS _15667_/B NAND2X1
XFILLER_61_688 VDD VSS FILLER1
X_11828_ _11828_/A _11828_/B _11828_/C _11828_/D VDD VSS _11884_/B AOAI211X1
X_14616_ _14616_/A _14616_/B _15857_/B VDD VSS _14638_/B MIN3X1
X_18384_ _18390_/CK _18384_/D _18384_/Q _20064_/RB VDD VSS DFFRQX1
X_17404_ _19839_/Q _19807_/Q VDD VSS _17405_/B XOR2X1
X_15596_ _15620_/A _15620_/B VDD VSS _15607_/A NAND2X1
XFILLER_14_582 VDD VSS FILLER1
XFILLER_61_699 VDD VSS FILLER1
X_14547_ _19988_/Q _14547_/B VDD VSS _19252_/D AND2X1
X_17335_ _17338_/A _17338_/B _17363_/C VDD VSS _17336_/C OAI21X1
X_11759_ _19171_/Q VDD VSS _11761_/A INVX1
XFILLER_119_429 VSS VDD FILLER2
X_14478_ _14490_/A _14478_/B _14478_/C VDD VSS _19191_/D NOR3X1
Xclkload103 _19671_/CK VDD VSS clkload103/Y BUFX12
X_17266_ _17267_/C _17266_/B _17266_/C VDD VSS _19809_/D AOI21X1
XFILLER_127_451 VDD VSS DECAPHV8
X_13429_ _19165_/Q _14449_/B _14449_/C VDD VSS _13430_/D OR3BX1
Xclkload125 _18324_/CK VDD VSS clkload125/Y INVX2
Xclkload114 _18608_/CK VDD VSS clkload114/Y INVX1
X_19005_ _19115_/CK _19005_/D _19005_/Q VDD VSS DFFQX1
X_17197_ _17197_/A _17197_/B _17197_/C _17197_/D VDD VSS _17198_/C AOAI211X1
X_16217_ _16228_/A _16217_/B VDD VSS _16848_/B XNOR2X1
XFILLER_143_922 VDD VSS DECAPHV8
XFILLER_143_933 VDD VSS DECAPHV16
XFILLER_6_770 VDD VSS DECAPHV8
X_16148_ _16150_/B _16148_/B VDD VSS _16149_/B XOR2X1
XFILLER_115_668 VDD VSS FILLER1
XFILLER_142_421 VSS VDD FILLER2
XTAP_TAPCELL_ROW_132_1337 VDD VSS WELLTAP
XFILLER_69_711 VDD VSS FILLER4
X_16079_ _16076_/A _16079_/B _16079_/C VDD VSS _16099_/A AOI2B1X1
XFILLER_69_755 VDD VSS FILLER4
X_19907_ _19907_/CK _19907_/D _19907_/Q VDD VSS DFFQX1
XFILLER_110_340 VDD VSS FILLER1
XFILLER_96_552 VDD VSS FILLER4
XFILLER_96_563 VDD VSS DECAPHV16
X_19838_ _19903_/CK _19838_/D _19838_/Q VDD VSS DFFQX1
XFILLER_56_438 VDD VSS FILLER4
Xinput1 data_in VDD VSS input1/Y BUFX3
XFILLER_45_19 VSS VDD FILLER2
X_09522_ _20018_/Q _20017_/Q _20019_/Q _20020_/Q VDD VSS _09523_/C AOI31X1
X_19769_ _19833_/CK _19769_/D _19769_/Q VDD VSS DFFQX1
XFILLER_25_814 VDD VSS FILLER1
XTAP_TAPCELL_ROW_143_1444 VDD VSS WELLTAP
XFILLER_25_836 VDD VSS FILLER1
X_09453_ _18457_/D _09468_/B _09453_/C VDD VSS _18256_/D AOI21X1
XFILLER_101_47 VSS VDD FILLER2
XFILLER_24_357 VDD VSS DECAPHV8
X_09384_ input3/Y _20051_/Q VDD VSS _18010_/A NAND2X1
XTAP_TAPCELL_ROW_34_352 VDD VSS WELLTAP
XFILLER_138_727 VSS VDD FILLER2
XFILLER_138_749 VDD VSS DECAPHV8
XFILLER_134_900 VDD VSS DECAPHV16
XFILLER_137_248 VDD VSS FILLER1
XFILLER_118_484 VDD VSS FILLER4
XFILLER_126_22 VDD VSS DECAPHV8
XFILLER_0_913 VSS VDD FILLER2
XFILLER_105_156 VSS VDD FILLER2
XFILLER_0_935 VDD VSS DECAPHV8
XFILLER_105_189 VDD VSS FILLER4
X_10090_ _18586_/Q _10113_/C VDD VSS _10090_/Y XNOR2X1
XFILLER_19_20 VDD VSS FILLER4
XFILLER_87_541 VSS VDD FILLER2
XFILLER_142_32 VSS VDD FILLER2
XFILLER_19_53 VDD VSS FILLER4
XFILLER_47_416 VSS VDD FILLER2
XFILLER_63_909 VDD VSS DECAPHV8
XFILLER_75_758 VDD VSS FILLER1
X_12800_ _19020_/Q _14286_/B _14286_/C VDD VSS _12801_/D OR3BX1
X_10992_ _11272_/A _10992_/B VDD VSS _18570_/D NOR2X1
X_13780_ _13781_/A _13781_/B _13781_/D _13781_/C VDD VSS _14329_/B AOAI211X1
XFILLER_16_858 VDD VSS FILLER1
XFILLER_28_696 VDD VSS FILLER1
XFILLER_35_30 VDD VSS DECAPHV8
X_12731_ _12731_/A _12731_/B _12731_/C _12731_/D VDD VSS _12915_/A OAOI211X1
XFILLER_31_806 VSS VDD FILLER2
XFILLER_70_452 VDD VSS FILLER1
XTAP_TAPCELL_ROW_107_1085 VDD VSS WELLTAP
X_12662_ _12662_/A _12662_/B _12662_/C _12662_/D VDD VSS _14472_/B AOAI211X1
X_15450_ _15448_/Y _15450_/B VDD VSS _15787_/B NOR2BX1
XFILLER_24_880 VSS VDD FILLER2
XFILLER_35_96 VSS VDD FILLER2
XFILLER_70_485 VDD VSS DECAPHV8
XTAP_TAPCELL_ROW_6_78 VDD VSS WELLTAP
X_11613_ _11648_/A VDD VSS _11624_/B BUFX3
X_14401_ _14426_/A _14401_/B VDD VSS _19122_/D NOR2X1
XFILLER_30_349 VDD VSS FILLER4
XFILLER_42_198 VDD VSS FILLER4
X_12593_ _12593_/A _12593_/B _14408_/B _12593_/D _12593_/E VDD VSS _12732_/C OAI221X1
X_17120_ _17121_/B _17120_/B VDD VSS _17122_/B NOR2BX1
X_15381_ _15385_/B _15381_/B VDD VSS _18133_/B XNOR2X1
X_11544_ _11648_/A VDD VSS _11555_/B BUFX3
X_14332_ _14339_/A _14332_/B VDD VSS _19060_/D NOR2X1
X_11475_ _18631_/Q _11484_/B VDD VSS _18658_/D AND2X1
X_14263_ _14255_/Y _14263_/B _14263_/C VDD VSS _19001_/D AND3BX1
X_17051_ _19764_/Q VDD VSS _17208_/B INVX1
XFILLER_125_933 VSS VDD FILLER2
X_10426_ _10550_/A _10738_/B _10738_/C _10538_/A VDD VSS _10503_/A OAOI211X1
X_13214_ _19080_/Q _14354_/B VDD VSS _14323_/A NAND2X1
X_16002_ _19647_/Q _16804_/B VDD VSS _16003_/B XNOR2X1
XFILLER_125_944 VDD VSS FILLER4
XTAP_TAPCELL_ROW_118_1192 VDD VSS WELLTAP
X_14194_ _14218_/A _14194_/B VDD VSS _18944_/D NOR2X1
XFILLER_124_454 VDD VSS FILLER4
XFILLER_3_762 VDD VSS FILLER1
XFILLER_98_839 VDD VSS FILLER1
X_10357_ _18553_/Q _10357_/B _10357_/C VDD VSS _10392_/A MIN3X1
X_13145_ _13255_/A _13255_/B _13255_/C _13255_/D VDD VSS _13345_/A AOI31X1
XFILLER_140_947 VSS VDD FILLER2
XFILLER_97_327 VSS VDD FILLER2
X_10288_ _18657_/Q _18765_/Q VDD VSS _10405_/A AND2X1
X_13076_ _18910_/Q _13076_/B _13076_/C VDD VSS _14123_/B XNOR3X1
X_17953_ _17957_/A _17953_/B VDD VSS _17955_/B XNOR2X1
X_12027_ _12087_/A _12087_/B _12087_/C VDD VSS _12254_/A OA21X2
X_16904_ _20016_/Q _16908_/C _20015_/Q _20065_/Q VDD VSS _16909_/B OAI211X1
X_19623_ _19673_/CK _19623_/D _19623_/Q VDD VSS DFFQX1
X_17884_ _17885_/C _17884_/B _17884_/C VDD VSS _19944_/D AOI21X1
XFILLER_38_449 VDD VSS FILLER1
XFILLER_65_224 VSS VDD FILLER2
XFILLER_66_769 VDD VSS DECAPHV8
X_16835_ _16838_/A _16835_/B VDD VSS _19676_/D NOR2X1
XFILLER_18_151 VDD VSS FILLER1
XTAP_TAPCELL_ROW_76_775 VDD VSS WELLTAP
X_13978_ _13978_/A _17940_/B _13978_/C _13978_/D VDD VSS _14018_/A OAOI211X1
X_19554_ _19591_/CK _19554_/D _19554_/Q VDD VSS DFFQX1
X_16766_ _16775_/A _16766_/B VDD VSS _19614_/D NOR2X1
XTAP_TAPCELL_ROW_48_499 VDD VSS WELLTAP
X_12929_ _13017_/A _13017_/B _13017_/C VDD VSS _12975_/B OAI21X1
X_19485_ _19643_/CK _19485_/D _19485_/Q VDD VSS DFFQX1
X_18505_ _18505_/CK _18505_/D _18505_/Q _09360_/Y VDD VSS DFFRQX1
X_16697_ _19904_/Q VDD VSS _17712_/A INVX1
X_15717_ _15725_/A _15717_/B VDD VSS _19343_/D AND2X1
XFILLER_61_452 VDD VSS FILLER4
X_18436_ _18439_/CK _18500_/D _18436_/Q _20078_/RB VDD VSS DFFRQX1
XFILLER_21_327 VDD VSS FILLER1
XFILLER_92_91 VSS VDD FILLER2
X_15648_ _19329_/Q _15701_/B VDD VSS _15652_/B XNOR2X1
XTAP_TAPCELL_ROW_31_322 VDD VSS WELLTAP
X_18367_ _18367_/CK _18367_/D _18367_/Q _18464_/RB VDD VSS DFFRQX1
X_15579_ _19410_/Q _15791_/B VDD VSS _15597_/C NAND2X1
XFILLER_119_204 VSS VDD FILLER2
X_18298_ _18310_/CK _18474_/D _18298_/Q _18465_/RB VDD VSS DFFRQX1
X_17318_ _17318_/A _17318_/B _17318_/C _17318_/D VDD VSS _17319_/C AOAI211X1
X_17249_ _19806_/Q _19774_/Q VDD VSS _17250_/B XOR2X1
XFILLER_116_922 VSS VDD FILLER2
XFILLER_115_454 VDD VSS FILLER4
XFILLER_88_316 VDD VSS DECAPHV8
XFILLER_89_828 VSS VDD FILLER2
X_20191_ _20191_/A VDD VSS _20191_/Y BUFX3
XFILLER_103_638 VDD VSS FILLER1
XFILLER_115_487 VDD VSS FILLER4
XFILLER_142_295 VDD VSS FILLER1
XFILLER_96_371 VDD VSS DECAPHV8
XFILLER_110_181 VDD VSS DECAPHV32
XFILLER_56_235 VDD VSS DECAPHV8
XFILLER_57_747 VDD VSS DECAPHV8
XFILLER_56_257 VDD VSS FILLER1
XFILLER_71_238 VDD VSS FILLER1
X_09505_ _18469_/D _09507_/B _09506_/C _20079_/Q VDD VSS _20079_/D AO22X2
XFILLER_112_79 VDD VSS FILLER1
XFILLER_13_806 VDD VSS FILLER1
XFILLER_52_430 VDD VSS FILLER1
XFILLER_52_441 VDD VSS FILLER4
XFILLER_80_750 VDD VSS DECAPHV16
X_09436_ _09783_/B VDD VSS _09753_/D BUFX3
XFILLER_40_669 VDD VSS DECAPHV8
X_09367_ _18506_/Q _18505_/Q _09630_/C VDD VSS _09576_/B NOR3X1
Xclkbuf_leaf_14__002_ clkbuf_leaf_9__002_/A VDD VSS _18785_/CK BUFX12
X_09298_ _09380_/B _09346_/B VDD VSS _09298_/Y NOR2BX1
XFILLER_138_568 VDD VSS FILLER1
XFILLER_107_933 VDD VSS FILLER1
XFILLER_118_270 VSS VDD FILLER2
XFILLER_21_76 VDD VSS FILLER1
X_11260_ _11262_/B _11261_/B VDD VSS _11261_/C NOR2X1
XFILLER_137_76 VDD VSS FILLER1
XFILLER_97_25 VDD VSS DECAPHV16
X_10211_ _18593_/Q VDD VSS _11384_/A INVX1
X_11191_ _11221_/A _11221_/B _11364_/B VDD VSS _11215_/A OAI21X1
XFILLER_122_947 VSS VDD FILLER2
XFILLER_97_58 VDD VSS DECAPHV8
X_10142_ _11367_/A _10142_/B VDD VSS _10190_/C XNOR2X1
Xdelaybuf_2_clk _231_/CK VDD VSS delaybuf_3_clk/A BUFX12
XFILLER_121_457 VDD VSS FILLER1
X_10073_ _18606_/Q _10078_/B VDD VSS _10075_/C XOR2X1
X_14950_ _19310_/Q VDD VSS _14951_/A INVX1
XFILLER_0_787 VSS VDD FILLER2
XFILLER_48_725 VSS VDD FILLER2
XFILLER_48_736 VDD VSS DECAPHV8
XFILLER_47_246 VSS VDD FILLER2
XTAP_TAPCELL_ROW_109_1103 VDD VSS WELLTAP
X_13901_ _13912_/A _13912_/B _13912_/E _13901_/D VDD VSS _14300_/C OAOI211X1
X_14881_ _14881_/A _14881_/B _14881_/C _14881_/D VDD VSS _14966_/B AOAI211X1
XFILLER_28_460 VDD VSS FILLER4
X_13832_ _19031_/Q _13912_/A _13912_/B VDD VSS _13843_/C XNOR3X1
X_16620_ _16620_/A _16620_/B _16620_/C _16620_/D VDD VSS _16645_/B AOAI211X1
XTAP_TAPCELL_ROW_73_745 VDD VSS WELLTAP
X_13763_ _13918_/A _13918_/B _13918_/C VDD VSS _13809_/B AOI21X1
X_16551_ _16551_/A _19923_/Q _16551_/C VDD VSS _16573_/B MIN3X1
XFILLER_16_666 VDD VSS DECAPHV8
XFILLER_43_452 VDD VSS DECAPHV8
XTAP_TAPCELL_ROW_45_469 VDD VSS WELLTAP
X_10975_ _19956_/Q _18838_/Q VDD VSS _11004_/B NAND2X1
X_12714_ _19047_/Q _12714_/B _12731_/C VDD VSS _12868_/B XOR3X1
X_15502_ _19323_/Q _15502_/B _15502_/C VDD VSS _15532_/A MIN3X1
X_13694_ _13830_/A _13830_/B _13830_/C VDD VSS _13760_/B AOI21X1
X_19270_ _20006_/CK _19270_/D _19270_/Q VDD VSS DFFQX1
X_16482_ _16495_/B _16482_/B VDD VSS _16823_/B XOR2X1
X_12645_ _12732_/A _12732_/B _12732_/C _12732_/D VDD VSS _12819_/A AOI31X1
X_18221_ _18235_/CK _18221_/E _18221_/ECK VDD VSS CGX3
X_15433_ _15405_/A _15433_/B _15433_/C VDD VSS _15471_/B AOI2B1X1
XFILLER_62_94 VDD VSS FILLER4
X_12576_ _20005_/Q _19269_/Q VDD VSS _12673_/B XNOR2X1
X_18152_ _18152_/A _18153_/C _18152_/C VDD VSS _20004_/D AOI21X1
X_15364_ _15364_/A _15364_/B _15364_/C _15364_/D VDD VSS _15365_/B OAI211X1
X_11527_ _18679_/Q _11531_/B VDD VSS _18706_/D AND2X1
X_14315_ _14255_/Y _14315_/B _14315_/C VDD VSS _19046_/D AND3BX1
X_18083_ _18083_/A _18083_/B _18083_/C _18083_/D VDD VSS _19991_/D AOI31X1
X_17103_ _19774_/Q _19742_/Q _17103_/C VDD VSS _17107_/B AOI21X1
XFILLER_129_579 VSS VDD FILLER2
X_17034_ _17040_/A _17036_/C _17034_/C VDD VSS _19760_/D AOI21X1
X_15295_ _19318_/Q _15689_/B VDD VSS _15296_/B XNOR2X1
X_11458_ _19951_/Q _11460_/B VDD VSS _18644_/D AND2X1
X_14246_ _14251_/A _14246_/B VDD VSS _18986_/D NOR2X1
XFILLER_124_240 VDD VSS DECAPHV8
X_10409_ _10454_/A _10454_/B _10409_/C VDD VSS _10463_/C OAI21X1
X_11389_ _18595_/Q _11390_/B VDD VSS _11392_/D XNOR2X1
X_14177_ _14197_/A _14177_/B VDD VSS _18929_/D AND2X1
XFILLER_113_947 VSS VDD FILLER2
XFILLER_97_102 VDD VSS FILLER1
XFILLER_98_636 VDD VSS DECAPHV16
X_13128_ _13316_/A _13316_/B _13316_/D VDD VSS _13157_/B OAI21X1
XFILLER_97_157 VDD VSS FILLER1
X_18985_ _19040_/CK _18985_/D _18985_/Q VDD VSS DFFQX1
X_13059_ _13133_/A _13133_/B _13133_/C VDD VSS _13061_/C AO21X2
X_17936_ _18865_/Q _17937_/A VDD VSS _17948_/A _17937_/B NAND3X1
XFILLER_39_747 VSS VDD FILLER2
XFILLER_66_544 VDD VSS DECAPHV8
X_17867_ _18850_/Q VDD VSS _17869_/A INVX1
XFILLER_81_503 VDD VSS DECAPHV8
XFILLER_94_886 VSS VDD FILLER2
X_19606_ _19606_/CK _19606_/D _19606_/Q VDD VSS DFFQX1
X_16818_ _16843_/A _16818_/B VDD VSS _19660_/D AND2X1
XFILLER_19_471 VDD VSS FILLER4
XFILLER_93_396 VDD VSS FILLER4
X_19537_ _19707_/CK _19537_/D _19537_/Q VDD VSS DFFQX1
X_17798_ _17806_/A _17798_/B VDD VSS _19923_/D NOR2X1
XFILLER_50_901 VDD VSS DECAPHV8
XTAP_TAPCELL_ROW_140_1414 VDD VSS WELLTAP
X_16749_ _16776_/A VDD VSS _16759_/A BUFX3
XFILLER_34_463 VDD VSS FILLER1
X_19468_ _19495_/CK _19468_/D _19468_/Q VDD VSS DFFQX1
XFILLER_50_945 VDD VSS FILLER1
XTAP_TAPCELL_ROW_16_171 VDD VSS WELLTAP
X_09221_ _18510_/Q VDD VSS _18393_/D INVX1
X_19399_ _19547_/CK _19399_/D _19399_/Q VDD VSS DFFQX1
X_18419_ _18420_/CK _18520_/Q _20174_/A _18452_/RB VDD VSS DFFRQX1
XTAP_TAPCELL_ROW_138_1398 VDD VSS WELLTAP
XFILLER_1_507 VDD VSS FILLER4
XFILLER_131_733 VDD VSS FILLER1
X_20174_ _20174_/A VDD VSS _20174_/Y BUFX3
XFILLER_103_435 VDD VSS FILLER4
XFILLER_103_468 VDD VSS FILLER1
XFILLER_107_68 VDD VSS FILLER4
XFILLER_130_243 VDD VSS FILLER1
XFILLER_131_755 VSS VDD FILLER2
XFILLER_131_766 VSS VDD FILLER2
X_09985_ _18577_/Q _09999_/C VDD VSS _09986_/B NAND2X1
XFILLER_130_254 VDD VSS DECAPHV8
XFILLER_69_371 VDD VSS FILLER1
XFILLER_57_522 VDD VSS FILLER4
XFILLER_45_706 VDD VSS DECAPHV8
XFILLER_72_503 VDD VSS FILLER1
XFILLER_85_864 VSS VDD FILLER2
XFILLER_45_739 VDD VSS FILLER4
XFILLER_16_43 VSS VDD FILLER2
XFILLER_72_558 VSS VDD FILLER2
XFILLER_52_260 VDD VSS DECAPHV8
XFILLER_53_783 VDD VSS DECAPHV8
XFILLER_80_580 VDD VSS DECAPHV16
XTAP_TAPCELL_ROW_104_1055 VDD VSS WELLTAP
XTAP_TAPCELL_ROW_70_715 VDD VSS WELLTAP
X_10760_ _10801_/D _10801_/B VDD VSS _10761_/B NOR2BX1
XFILLER_13_658 VDD VSS FILLER4
XFILLER_52_293 VDD VSS FILLER1
XFILLER_9_607 VDD VSS FILLER1
XTAP_TAPCELL_ROW_42_439 VDD VSS WELLTAP
X_09419_ _20014_/Q _09516_/B VDD VSS _09520_/D NOR2X1
X_10691_ _18694_/Q _18748_/Q VDD VSS _10729_/E AND2X1
XFILLER_40_455 VSS VDD FILLER2
X_12430_ _18904_/Q _14148_/B _12527_/C VDD VSS _12611_/C XNOR3X1
XFILLER_5_802 VSS VDD FILLER2
XTAP_TAPCELL_ROW_3_46 VDD VSS WELLTAP
X_12361_ _12361_/A _12361_/B _14311_/B VDD VSS _12510_/A MIN3X1
X_14100_ _18896_/Q _14139_/B VDD VSS _14101_/D _14139_/C NAND3X1
XFILLER_107_741 VSS VDD FILLER2
XFILLER_5_835 VSS VDD FILLER2
X_11312_ _11304_/A _11312_/B _11312_/C VDD VSS _11316_/B AOI2B1X1
X_12292_ _19070_/Q VDD VSS _12512_/A INVX1
X_15080_ _19313_/Q _15080_/B _15684_/B VDD VSS _15132_/B MIN3X1
XFILLER_106_0 VSS VDD FILLER2
XFILLER_122_700 VSS VDD FILLER2
X_11243_ _11255_/A _11379_/B VDD VSS _11255_/C NOR2X1
X_14031_ _14085_/A _14085_/B _14085_/C VDD VSS _14049_/B AOI21X1
XFILLER_134_571 VDD VSS DECAPHV16
XTAP_TAPCELL_ROW_115_1162 VDD VSS WELLTAP
X_11174_ _19962_/Q _18844_/Q VDD VSS _11175_/B XOR2X1
XFILLER_122_799 VDD VSS FILLER4
XFILLER_76_820 VSS VDD FILLER2
XFILLER_88_680 VDD VSS FILLER1
X_10125_ _18610_/Q VDD VSS _10126_/A INVX1
X_18770_ _18797_/CK _18770_/D _18770_/Q VDD VSS DFFQX1
X_15982_ _19675_/Q _16834_/B _16020_/A VDD VSS _16015_/A MIN3X1
X_10056_ _10043_/Y _10055_/Y _10127_/A VDD VSS _10056_/Y MUX2X1
X_17721_ _19906_/Q _19874_/Q _17721_/C VDD VSS _17726_/C AO21X2
X_14933_ _19478_/Q _15869_/B VDD VSS _15000_/B XNOR2X1
X_17652_ _19892_/Q _19860_/Q VDD VSS _17655_/A XNOR2X1
XFILLER_90_300 VDD VSS FILLER4
XFILLER_90_311 VSS VDD FILLER2
XTAP_TAPCELL_ROW_58_594 VDD VSS WELLTAP
X_16603_ _16603_/A _16626_/C VDD VSS _16757_/B XNOR2X1
X_14864_ _14865_/A _14865_/B _14865_/D _14865_/C VDD VSS _15833_/B OAOI211X1
XFILLER_90_366 VDD VSS FILLER4
XTAP_TAPCELL_ROW_126_1280 VDD VSS WELLTAP
X_13815_ _18974_/Q _14229_/B _14229_/C VDD VSS _13816_/D OR3BX1
X_17583_ _19877_/Q _19845_/Q VDD VSS _17589_/B NAND2X1
X_14795_ _14795_/A _14840_/D VDD VSS _15802_/B XNOR2X1
XFILLER_16_474 VDD VSS DECAPHV8
XFILLER_44_761 VDD VSS FILLER1
XFILLER_73_71 VDD VSS FILLER1
XFILLER_90_388 VDD VSS DECAPHV8
X_10958_ _10958_/A _10958_/B VDD VSS _10996_/A NOR2X1
X_13746_ _18917_/Q _13748_/B _13746_/C VDD VSS _13751_/B XNOR3X1
X_19322_ _19322_/CK _19322_/D _19322_/Q VDD VSS DFFQX1
X_16534_ _16545_/B _16534_/B VDD VSS _16861_/B XNOR2X1
XFILLER_43_271 VDD VSS FILLER1
X_13677_ _13748_/A _13748_/B _13748_/C _13748_/D VDD VSS _13818_/A AOI31X1
X_19253_ _19988_/CK _19253_/D _19253_/Q VDD VSS DFFQX1
X_16465_ _16467_/B _16465_/B _16465_/C VDD VSS _19536_/D AOI21X1
XTAP_TAPCELL_ROW_13_141 VDD VSS WELLTAP
X_10889_ _10921_/A _10921_/B _11127_/A VDD VSS _10915_/A OAI21X1
X_12628_ _12719_/A wire158/Y _12804_/B VDD VSS _12630_/C XNOR3X1
X_15416_ _15456_/C _15456_/B VDD VSS _15417_/B NOR2BX1
XFILLER_12_691 VDD VSS FILLER4
X_19184_ _19215_/CK _19184_/D _19184_/Q VDD VSS DFFQX1
X_16396_ _16421_/A _16421_/B VDD VSS _16748_/B XNOR2X1
XFILLER_117_527 VSS VDD FILLER2
X_12559_ _19102_/Q VDD VSS _12640_/A INVX1
X_18135_ _18136_/A _18136_/B _18136_/C VDD VSS _18135_/Y NOR3X1
X_15347_ _15347_/A _15347_/B _15347_/C _15347_/D VDD VSS _15348_/C AOAI211X1
X_18066_ _18069_/A _18069_/B _18187_/C VDD VSS _18067_/C OAI21X1
X_15278_ _15307_/C _15307_/D VDD VSS _15308_/B AND2X1
XFILLER_99_912 VDD VSS FILLER1
X_14229_ _14294_/A _14229_/B _14229_/C VDD VSS _18974_/D NOR3X1
X_17017_ _19756_/Q _19757_/Q _17047_/B VDD VSS _17018_/B OAI21X1
XFILLER_112_210 VSS VDD FILLER2
XFILLER_125_582 VDD VSS FILLER4
XFILLER_140_530 VDD VSS FILLER4
XFILLER_140_563 VDD VSS FILLER4
XFILLER_140_574 VDD VSS FILLER1
XFILLER_21_0 VDD VSS FILLER4
XFILLER_85_116 VSS VDD FILLER2
XFILLER_98_488 VDD VSS DECAPHV16
XTAP_TAPCELL_ROW_129_1309 VDD VSS WELLTAP
X_09770_ _18272_/Q _09770_/B _09770_/C _18324_/Q VDD VSS _09772_/C AOI22X1
X_18968_ _19050_/CK _18968_/D _18968_/Q VDD VSS DFFQX1
X_17919_ _18861_/Q _17919_/B _17919_/C VDD VSS _17927_/A MIN3X1
XFILLER_39_577 VDD VSS FILLER1
X_18899_ _19197_/CK _18899_/D _18899_/Q VDD VSS DFFQX1
XFILLER_54_536 VDD VSS FILLER4
XFILLER_81_311 VDD VSS FILLER4
XFILLER_82_823 VDD VSS DECAPHV8
XFILLER_23_901 VDD VSS FILLER1
X_09204_ _18515_/Q VDD VSS _18430_/D INVX1
XFILLER_10_639 VDD VSS FILLER4
XFILLER_108_505 VDD VSS FILLER4
XFILLER_104_700 VDD VSS FILLER4
XFILLER_103_221 VDD VSS FILLER4
XFILLER_103_243 VDD VSS DECAPHV8
X_20226_ _20226_/A VDD VSS _20226_/Y BUFX3
XFILLER_104_799 VDD VSS DECAPHV16
XFILLER_134_44 VSS VDD FILLER2
X_20157_ _20157_/A VDD VSS _20157_/Y BUFX3
XFILLER_58_886 VDD VSS DECAPHV8
XFILLER_73_812 VDD VSS FILLER4
XFILLER_91_108 VSS VDD FILLER2
X_09899_ _09897_/Y _09898_/Y _09928_/C VDD VSS _09899_/Y MUXI2X1
X_11930_ _19997_/Q _19261_/Q VDD VSS _11988_/A XOR2X1
X_20088_ _20088_/A VDD VSS _20088_/Y BUFX3
XFILLER_26_750 VDD VSS FILLER4
X_11861_ _19063_/Q _11861_/B _11861_/C VDD VSS _11959_/B MIN3X1
XFILLER_32_208 VSS VDD FILLER2
XTAP_TAPCELL_ROW_55_564 VDD VSS WELLTAP
X_10812_ _18565_/Q _10849_/B VDD VSS _10814_/C XOR2X1
X_11792_ _19200_/Q _11797_/A _14488_/B VDD VSS _14458_/B XNOR3X1
X_13600_ _19027_/Q _14294_/B _14294_/C VDD VSS _13607_/D OR3BX1
X_14580_ _19493_/Q _15886_/B VDD VSS _14584_/C NOR2X1
XFILLER_25_282 VDD VSS FILLER4
XFILLER_53_580 VDD VSS FILLER1
XTAP_TAPCELL_ROW_27_288 VDD VSS WELLTAP
X_10743_ _18563_/Q _10743_/B _10743_/C VDD VSS _10784_/A MIN3X1
X_13531_ _13531_/A _13531_/B _13531_/C _13531_/D VDD VSS _14326_/C OAI211X1
X_16250_ _16247_/B _16250_/B _16250_/C VDD VSS _16274_/A AOI2B1X1
XFILLER_139_641 VDD VSS FILLER1
XFILLER_41_797 VSS VDD FILLER2
XFILLER_43_96 VDD VSS FILLER4
X_10674_ _18667_/Q _18775_/Q VDD VSS _10718_/C AND2X1
X_13462_ _13462_/A _13462_/B _14545_/B VDD VSS _14516_/B MIN3X1
X_15201_ _15227_/B _15201_/B VDD VSS _15812_/B NOR2BX1
XFILLER_127_803 VDD VSS FILLER4
XFILLER_138_151 VDD VSS FILLER1
XTAP_TAPCELL_ROW_10_111 VDD VSS WELLTAP
X_12413_ _19240_/Q _12413_/B _12495_/D VDD VSS _12497_/C XNOR3X1
X_13393_ _13393_/A _13393_/B _13393_/C _13393_/D VDD VSS _13656_/A OAOI211X2
X_16181_ _16181_/A _16739_/B VDD VSS _16182_/C AND2X1
XFILLER_126_324 VDD VSS FILLER1
X_12344_ _12610_/A _12610_/B _14115_/B VDD VSS _17847_/B XNOR3X1
X_15132_ _15132_/A _15132_/B _15685_/B VDD VSS _15171_/B MIN3X1
XFILLER_126_346 VDD VSS DECAPHV8
X_19940_ _19940_/CK _19940_/D _19940_/Q VDD VSS DFFQX1
X_15063_ _15108_/D _15145_/C VDD VSS _15099_/C NAND2X1
XFILLER_5_676 VDD VSS DECAPHV16
XFILLER_99_219 VDD VSS FILLER4
X_12275_ _18902_/Q _12348_/B _12348_/C VDD VSS _12429_/B MIN3X1
X_14014_ _18979_/Q _14043_/A _14043_/B VDD VSS _14032_/C XOR3X1
XFILLER_122_530 VDD VSS FILLER4
X_11226_ _11226_/A _11226_/B _11226_/C _11226_/D VDD VSS _11230_/A OAI22X1
X_19871_ _19907_/CK _19871_/D _19871_/Q VDD VSS DFFQX1
XFILLER_68_617 VDD VSS FILLER1
XFILLER_96_948 VSS VDD FILLER2
X_11157_ _11272_/A _11157_/B VDD VSS _18575_/D NOR2X1
X_18822_ _19940_/CK _18822_/D _18822_/Q VDD VSS DFFQX1
XFILLER_110_747 VDD VSS FILLER1
XFILLER_49_831 VDD VSS FILLER4
X_10108_ _10131_/A _10191_/B _10109_/C _18609_/Q VDD VSS _10120_/B AO211X2
X_18753_ _18782_/CK _18753_/D _18753_/Q VDD VSS DFFQX1
XFILLER_83_609 VDD VSS FILLER1
X_11088_ _11084_/B _18573_/Q _11088_/C VDD VSS _11126_/B AOI2B1X1
X_17704_ _19903_/Q _19871_/Q VDD VSS _17705_/B XOR2X1
X_15965_ _15965_/A _15995_/B VDD VSS _16731_/B XOR2X1
XFILLER_36_514 VDD VSS FILLER4
XFILLER_64_834 VDD VSS FILLER4
XFILLER_76_694 VSS VDD FILLER2
XTAP_TAPCELL_ROW_18_200 VDD VSS WELLTAP
X_10039_ _10180_/A _11409_/C VDD VSS _18531_/D NOR2X1
X_18684_ _18820_/CK _18684_/D _18684_/Q VDD VSS DFFQX1
X_15896_ _16776_/A VDD VSS _15906_/A BUFX3
X_14916_ _19449_/Q _15834_/B VDD VSS _14931_/C _15834_/C AND3X2
XFILLER_24_709 VDD VSS FILLER1
XFILLER_63_333 VDD VSS DECAPHV8
XFILLER_84_81 VDD VSS FILLER1
X_17635_ _17638_/A _17638_/B _17654_/C VDD VSS _17636_/C OAI21X1
X_14847_ _14857_/B _14847_/B VDD VSS _15709_/B XNOR2X1
XFILLER_17_783 VDD VSS FILLER1
X_17566_ _17566_/A VDD VSS _18132_/A BUFX3
XFILLER_16_293 VDD VSS FILLER1
X_19305_ _19322_/CK _19305_/D _19305_/Q VDD VSS DFFQX1
X_16517_ _16509_/A _16517_/B VDD VSS _16537_/B NAND2BX1
X_14778_ _14778_/A _15831_/B _15831_/C VDD VSS _14818_/C NOR3X1
XFILLER_20_915 VDD VSS FILLER4
X_13729_ _19056_/Q VDD VSS _13731_/A INVX1
X_17497_ _17498_/C _18127_/B _17497_/C VDD VSS _19858_/D AND3BX1
XFILLER_83_2 VDD VSS FILLER1
X_19236_ _20006_/CK _19236_/D _19236_/Q VDD VSS DFFQX1
X_16448_ _19568_/Q _19920_/Q VDD VSS _16451_/A XNOR2X1
XFILLER_118_803 VDD VSS FILLER1
X_19167_ _19194_/CK _19167_/D _19167_/Q VDD VSS DFFQX1
X_16379_ _16379_/A _16390_/C VDD VSS _16854_/B XNOR2X1
XFILLER_69_0 VSS VDD FILLER2
X_18118_ _19289_/Q _18118_/B VDD VSS _18121_/A NOR2BX1
XTAP_TAPCELL_ROW_135_1368 VDD VSS WELLTAP
X_19098_ _19126_/CK _19098_/D _19098_/Q VDD VSS DFFQX1
XFILLER_117_379 VDD VSS FILLER1
XFILLER_126_891 VDD VSS FILLER4
X_18049_ _18052_/B _18049_/B _18049_/C _18049_/D VDD VSS _19982_/D OAI31X1
XFILLER_48_19 VDD VSS FILLER1
X_09822_ _11435_/A _11435_/B _11438_/A VDD VSS _10266_/C NOR3X1
X_20011_ _20013_/CK _20011_/D _20011_/Q VDD VSS DFFQX1
XFILLER_100_224 VDD VSS DECAPHV8
XFILLER_113_596 VSS VDD FILLER2
XFILLER_58_138 VDD VSS FILLER1
XFILLER_86_425 VSS VDD FILLER2
XFILLER_87_948 VSS VDD FILLER2
X_09753_ _09753_/A _18403_/Q _09753_/C _09753_/D VDD VSS _09754_/E OAOI211X1
Xclkbuf_0__09176_ _18225_/ECK VDD VSS clkbuf_0__09176_/Y BUFX12
XTAP_TAPCELL_ROW_97_987 VDD VSS WELLTAP
XFILLER_39_385 VDD VSS FILLER1
X_09684_ _18351_/Q VDD VSS _20219_/A INVX1
XFILLER_27_569 VDD VSS FILLER4
XFILLER_39_396 VSS VDD FILLER2
XFILLER_54_322 VSS VDD FILLER2
XFILLER_54_377 VDD VSS DECAPHV8
XFILLER_55_889 VDD VSS FILLER1
XFILLER_42_539 VDD VSS FILLER1
XFILLER_70_859 VDD VSS FILLER4
XFILLER_81_185 VDD VSS FILLER1
XTAP_TAPCELL_ROW_52_534 VDD VSS WELLTAP
XFILLER_11_915 VDD VSS FILLER4
XFILLER_80_28 VDD VSS FILLER4
XTAP_TAPCELL_ROW_101_1025 VDD VSS WELLTAP
XTAP_TAPCELL_ROW_24_258 VDD VSS WELLTAP
XFILLER_13_33 VDD VSS FILLER1
XFILLER_50_583 VDD VSS FILLER1
XFILLER_10_458 VDD VSS FILLER4
XFILLER_109_836 VDD VSS FILLER1
XFILLER_136_611 VDD VSS FILLER1
XFILLER_135_143 VSS VDD FILLER2
X_10390_ _18554_/Q _10390_/B VDD VSS _10392_/B XOR2X1
XFILLER_123_349 VDD VSS FILLER4
XFILLER_132_850 VDD VSS FILLER1
XFILLER_8_4 VSS VDD FILLER2
XTAP_TAPCELL_ROW_0_14 VDD VSS WELLTAP
XTAP_TAPCELL_ROW_112_1132 VDD VSS WELLTAP
X_12060_ _19151_/Q _12060_/B _12091_/C VDD VSS _12181_/B XNOR3X1
X_11011_ _11037_/A _11037_/B _11011_/C _11011_/D VDD VSS _11013_/C OAOI211X1
X_20209_ _20209_/A VDD VSS _20209_/Y BUFX3
XFILLER_131_371 VDD VSS FILLER1
XFILLER_1_189 VSS VDD FILLER2
XFILLER_18_514 VDD VSS FILLER1
X_12962_ _19245_/Q VDD VSS _12968_/D INVX1
X_15750_ _15770_/A _15750_/B VDD VSS _19373_/D AND2X1
XFILLER_46_878 VDD VSS FILLER4
X_11913_ _11973_/A _11973_/B _11973_/C VDD VSS _11969_/A OAI21X1
X_12893_ _14284_/B _14284_/C _19018_/Q VDD VSS _12896_/A AOI21X1
X_15681_ _15693_/A _15681_/B VDD VSS _19310_/D NOR2X1
X_14701_ _14701_/A _14701_/B _15828_/B VDD VSS _14702_/B MIN3X1
XFILLER_45_388 VDD VSS FILLER4
XFILLER_73_664 VDD VSS FILLER1
XFILLER_73_675 VSS VDD FILLER2
X_11844_ wire165/Y _11881_/B _11881_/C VDD VSS _11845_/C AOI21X1
X_14632_ _19414_/Q _14635_/B _15796_/B VDD VSS _15764_/B XNOR3X1
X_17420_ _17419_/B _17420_/B VDD VSS _17422_/C NOR2BX1
XTAP_TAPCELL_ROW_123_1250 VDD VSS WELLTAP
XFILLER_14_764 VDD VSS FILLER1
XFILLER_41_561 VSS VDD FILLER2
X_11775_ _19228_/Q _14521_/B VDD VSS _11776_/D _14521_/C NAND3X1
X_14563_ _20002_/Q _14569_/B VDD VSS _19266_/D AND2X1
Xclkbuf_1_0__f__09165_ clkbuf_0__09165_/Y VDD VSS _18438_/CK BUFX12
X_17351_ _17353_/C _17351_/B _17351_/C VDD VSS _19827_/D AOI21X1
XFILLER_13_263 VSS VDD FILLER2
XFILLER_9_212 VDD VSS DECAPHV8
XFILLER_9_234 VSS VDD FILLER2
X_10726_ _10757_/C _10726_/B _10749_/B _10726_/D VDD VSS _10747_/B AOI2B2X1
X_13514_ _13594_/A _13594_/B _13594_/D _13594_/C VDD VSS _14225_/C AOI211X1
X_14494_ _14491_/Y _14494_/B _14494_/C VDD VSS _19205_/D AND3BX1
X_17282_ _19813_/Q _19781_/Q VDD VSS _17289_/C NOR2X1
X_16302_ _16302_/A _16302_/B _16302_/C VDD VSS _16305_/B OAI21X1
XFILLER_13_296 VDD VSS FILLER1
XFILLER_9_256 VDD VSS DECAPHV8
XFILLER_9_267 VDD VSS DECAPHV8
X_10657_ _11255_/A _10734_/B _10657_/C VDD VSS _10658_/B OAI21X1
X_13445_ _19249_/Q _14544_/A _14544_/B VDD VSS _13447_/C NOR3X1
X_19021_ _19037_/CK _19021_/D _19021_/Q VDD VSS DFFQX1
X_16233_ _16233_/A _16233_/B _16233_/C VDD VSS _16256_/B AOI21X1
Xclkload26 _18764_/CK VDD VSS clkload26/Y INVX8
Xclkload15 _19792_/CK VDD VSS clkload15/Y INVX8
XFILLER_127_644 VDD VSS FILLER4
XFILLER_142_603 VDD VSS FILLER1
X_10588_ _18559_/Q _10589_/B VDD VSS _10594_/A AND2X1
X_13376_ _18970_/Q _13511_/A _13401_/C VDD VSS _13391_/D XNOR3X1
Xclkload59 _19129_/CK VDD VSS clkload59/Y INVX4
Xclkload48 _19187_/CK VDD VSS clkload48/Y INVX1
Xclkload37 _18779_/CK VDD VSS clkload37/Y INVX4
X_16164_ _19621_/Q _16774_/B VDD VSS _16165_/B XNOR2X1
XFILLER_114_305 VDD VSS DECAPHV8
X_12327_ _19210_/Q VDD VSS _12329_/D INVX1
X_16095_ _16106_/A _16106_/B VDD VSS _16842_/B XNOR2X1
X_15115_ _15139_/D _15139_/C VDD VSS _15116_/B NOR2BX1
XFILLER_107_390 VDD VSS FILLER1
XFILLER_141_113 VSS VDD FILLER2
XFILLER_142_669 VDD VSS FILLER1
X_12258_ _19098_/Q _12258_/B _12258_/C VDD VSS _12363_/C XNOR3X1
X_19923_ clkload7/A _19923_/D _19923_/Q VDD VSS DFFQX1
X_15046_ _19425_/Q VDD VSS _15089_/A INVX1
XFILLER_79_92 VDD VSS FILLER1
X_11209_ _11209_/A _11229_/E VDD VSS _11209_/Y _11209_/C NAND3X1
X_19854_ _19892_/CK _19854_/D _19854_/Q VDD VSS DFFQX1
XFILLER_96_745 VDD VSS FILLER4
X_12189_ _12189_/A _12189_/B _14308_/B VDD VSS _12203_/C MIN3X1
X_18805_ _18809_/CK _18805_/D _18805_/Q VDD VSS DFFQX1
XFILLER_110_544 VDD VSS FILLER1
X_19785_ _19830_/CK _19785_/D _19785_/Q VDD VSS DFFQX1
X_16997_ _19754_/Q _17011_/B VDD VSS _16998_/B XOR2X1
XFILLER_49_672 VDD VSS FILLER4
X_18736_ _19937_/CK _18736_/D _18736_/Q VDD VSS DFFQX1
X_15948_ _15948_/A _15948_/B VDD VSS _16801_/B XNOR2X1
XFILLER_48_182 VDD VSS DECAPHV8
XTAP_TAPCELL_ROW_94_957 VDD VSS WELLTAP
X_18667_ _18801_/CK _18667_/D _18667_/Q VDD VSS DFFQX1
XFILLER_36_366 VSS VDD FILLER2
XFILLER_37_889 VDD VSS FILLER4
XFILLER_52_837 VDD VSS DECAPHV8
XFILLER_63_152 VSS VDD FILLER2
X_17618_ _17618_/A _17618_/B _17618_/C _17618_/D VDD VSS _17619_/C AOAI211X1
X_15879_ _15879_/A _15879_/B VDD VSS _19487_/D AND2X1
XFILLER_36_388 VDD VSS DECAPHV8
X_18598_ _18608_/CK _18598_/D _18598_/Q VDD VSS DFFQX1
XFILLER_32_550 VSS VDD FILLER2
X_17549_ _17551_/B _17549_/B VDD VSS _17550_/B XOR2X1
XFILLER_118_600 VDD VSS FILLER4
XFILLER_137_419 VSS VDD FILLER2
XTAP_TAPCELL_ROW_21_228 VDD VSS WELLTAP
Xclkload9 clkload9/A VDD VSS clkload9/Y INVX1
X_19219_ _19250_/CK _19219_/D _19219_/Q VDD VSS DFFQX1
XFILLER_133_614 VDD VSS FILLER1
XFILLER_114_872 VSS VDD FILLER2
XFILLER_87_712 VDD VSS DECAPHV8
XFILLER_99_550 VDD VSS FILLER4
XFILLER_99_561 VDD VSS FILLER4
Xfanout213 _18370_/RB VDD VSS _20075_/RB BUFX3
Xfanout202 _20051_/RB VDD VSS _20071_/RB BUFX3
XFILLER_101_522 VDD VSS FILLER1
XFILLER_115_46 VSS VDD FILLER2
Xfanout224 _18370_/RB VDD VSS _20081_/RB BUFX3
XFILLER_75_929 VDD VSS FILLER1
X_09805_ _09819_/A _09805_/B _09805_/C VDD VSS _18294_/D OAI21X1
XTAP_TAPCELL_ROW_29_306 VDD VSS WELLTAP
X_09736_ _18466_/Q _09784_/B _09784_/C _18434_/Q VDD VSS _09737_/D AOI22X1
XFILLER_55_631 VDD VSS FILLER1
X_09667_ _18478_/Q VDD VSS _20123_/A INVX1
XFILLER_131_45 VSS VDD FILLER2
XFILLER_131_56 VDD VSS DECAPHV16
XFILLER_54_196 VDD VSS FILLER4
XFILLER_70_645 VDD VSS FILLER1
XTAP_TAPCELL_ROW_37_383 VDD VSS WELLTAP
XTAP_TAPCELL_ROW_65_670 VDD VSS WELLTAP
X_09598_ _09816_/D _20182_/A VDD VSS _09599_/C NAND2X1
XFILLER_23_550 VDD VSS FILLER4
XFILLER_42_358 VDD VSS FILLER1
XFILLER_129_909 VDD VSS FILLER1
XFILLER_24_54 VDD VSS DECAPHV32
X_11560_ _18708_/Q _11567_/B VDD VSS _18735_/D AND2X1
X_230_ _231_/CK _230_/E _230_/ECK VDD VSS CGX3
X_10511_ _10511_/A VDD VSS _10843_/A BUFX3
X_11491_ _18646_/Q _11496_/B VDD VSS _18673_/D AND2X1
X_13230_ _13230_/A _14416_/B _14416_/C VDD VSS _13231_/D NOR3X1
X_10442_ _11078_/A _18716_/Q VDD VSS _10443_/D AND2X1
X_10373_ _18633_/Q _18795_/Q VDD VSS _10399_/C XNOR2X1
X_13161_ _13161_/A _13161_/B VDD VSS _14353_/C _13161_/C NAND3X1
XFILLER_124_669 VSS VDD FILLER2
X_12112_ _19180_/Q _12112_/B _12160_/C VDD VSS _12214_/A XNOR3X1
X_13092_ _19050_/Q _14320_/B _14320_/C VDD VSS _13095_/D OR3BX1
X_12043_ _12099_/A _12099_/B _12099_/C VDD VSS _14495_/B OAI21X1
Xclkbuf_leaf_15__000_ clkbuf_leaf_9__000_/A VDD VSS _19724_/CK BUFX12
X_16920_ _17172_/A VDD VSS _17081_/C BUFX3
XFILLER_104_382 VDD VSS FILLER4
XFILLER_1_14 VDD VSS FILLER1
X_16851_ _16859_/A _16851_/B VDD VSS _19690_/D AND2X1
XFILLER_120_886 VDD VSS DECAPHV8
XFILLER_19_812 VSS VDD FILLER2
X_19570_ _19606_/CK _19570_/D _19570_/Q VDD VSS DFFQX1
X_16782_ _16793_/A _16782_/B VDD VSS _19628_/D AND2X1
X_15802_ _15816_/A _15802_/B VDD VSS _19419_/D NOR2X1
XFILLER_18_322 VSS VDD FILLER2
X_13994_ _18922_/Q _14169_/B _14169_/C VDD VSS _13995_/D OR3BX1
X_18521_ _18521_/CK _18521_/D _18521_/Q _09313_/Y VDD VSS DFFRQX1
X_15733_ _15743_/A _15733_/B VDD VSS _19358_/D AND2X1
XFILLER_45_130 VDD VSS FILLER4
XFILLER_46_675 VDD VSS FILLER1
XFILLER_73_472 VDD VSS FILLER1
XTAP_TAPCELL_ROW_91_927 VDD VSS WELLTAP
X_12945_ _12945_/A _14509_/B VDD VSS _13036_/A OR2X2
XFILLER_18_388 VDD VSS FILLER4
XFILLER_45_185 VDD VSS FILLER1
X_12876_ _18965_/Q _12891_/A _14216_/B VDD VSS _14185_/B XOR3X1
X_18452_ _18455_/CK _18521_/Q _20150_/A _18452_/RB VDD VSS DFFRQX1
X_15664_ _19330_/Q VDD VSS _15666_/A INVX1
XFILLER_21_509 VSS VDD FILLER2
XFILLER_61_678 VDD VSS DECAPHV8
X_09963__233 _20081_/CK VDD VSS _18510_/CK INVX1
X_11827_ _11828_/A _11828_/B _11828_/D _11828_/C VDD VSS _14490_/C AOI211X1
X_14615_ _14615_/A _14615_/B _14615_/C VDD VSS _15857_/B XOR3X1
X_18383_ _18390_/CK _18516_/Q _20188_/A _20064_/RB VDD VSS DFFRQX1
X_17403_ _19838_/Q _19806_/Q _17403_/C VDD VSS _17407_/B AOI21X1
X_15595_ _15584_/A _15595_/B VDD VSS _15620_/B NAND2BX1
XFILLER_60_166 VDD VSS FILLER4
XFILLER_60_188 VSS VDD FILLER2
XFILLER_81_60 VDD VSS DECAPHV8
X_11758_ _11758_/A _11758_/B _14426_/B VDD VSS _11818_/B MIN3X1
X_14546_ _19987_/Q _14547_/B VDD VSS _19251_/D AND2X1
X_17334_ _19823_/Q _19791_/Q _17334_/C VDD VSS _17338_/B MIN3X1
X_10709_ _10709_/A _10709_/B _10709_/C VDD VSS _10785_/A NOR3X1
X_11689_ _19988_/Q _19252_/Q VDD VSS _11716_/B XOR2X1
X_14477_ _14493_/A _14477_/B VDD VSS _19190_/D NOR2X1
Xclkload104 _19643_/CK VDD VSS clkload104/Y INVX2
X_19004_ _19004_/CK _19004_/D _19004_/Q VDD VSS DFFQX1
X_17265_ _17267_/C _17266_/B _17306_/C VDD VSS _17266_/C OAI21X1
XFILLER_139_290 VDD VSS DECAPHV16
X_13428_ _13601_/A _13601_/B _13601_/C VDD VSS _13473_/B AOI21X1
Xclkload126 _18343_/CK VDD VSS clkload126/Y INVX2
Xclkload115 _20043_/CK VDD VSS clkload115/Y INVX1
X_17196_ _17197_/A _17197_/B _17197_/D _17197_/C VDD VSS _17199_/C AOI211X1
X_16216_ _19655_/Q _16813_/B VDD VSS _16217_/B XNOR2X1
XFILLER_115_625 VDD VSS DECAPHV8
XFILLER_127_463 VSS VDD FILLER2
XFILLER_142_400 VSS VDD FILLER2
X_13359_ _19137_/Q _14417_/B VDD VSS _13432_/C _14417_/C NAND3X1
X_16147_ _16150_/A _16880_/B VDD VSS _16148_/B XNOR2X1
XFILLER_6_793 VDD VSS DECAPHV16
XTAP_TAPCELL_ROW_132_1338 VDD VSS WELLTAP
XFILLER_102_308 VSS VDD FILLER2
X_16078_ _19713_/Q _16876_/B VDD VSS _16079_/C NOR2X1
XFILLER_130_639 VDD VSS FILLER1
X_19906_ _19907_/CK _19906_/D _19906_/Q VDD VSS DFFQX1
X_15029_ _15039_/B _15029_/B VDD VSS _15714_/B XNOR2X1
XFILLER_111_875 VDD VSS FILLER1
XFILLER_57_918 VDD VSS FILLER1
X_19837_ _19903_/CK _19837_/D _19837_/Q VDD VSS DFFQX1
X_19768_ _19830_/CK _19768_/D _19768_/Q VDD VSS DFFQX1
Xinput2 mosi VDD VSS input2/Y BUFX3
XFILLER_110_396 VDD VSS FILLER4
XFILLER_37_642 VDD VSS DECAPHV8
X_09521_ _20018_/Q _20017_/Q _20019_/Q _09521_/D VDD VSS _20019_/D AOI31X1
X_18719_ _18801_/CK _18719_/D _18719_/Q VDD VSS DFFQX1
XFILLER_37_686 VDD VSS DECAPHV8
XFILLER_64_450 VSS VDD FILLER2
XTAP_TAPCELL_ROW_143_1445 VDD VSS WELLTAP
X_19699_ _19703_/CK _19699_/D _19699_/Q VDD VSS DFFQX1
XFILLER_36_174 VDD VSS FILLER4
XFILLER_51_100 VDD VSS DECAPHV8
XFILLER_64_494 VDD VSS DECAPHV8
X_09452_ _19966_/Q _09467_/B _09483_/B VDD VSS _09453_/C AOI21X1
XTAP_TAPCELL_ROW_62_640 VDD VSS WELLTAP
X_09383_ _11438_/A _11436_/C _10274_/B _09907_/A VDD VSS _09387_/B AND4X2
XTAP_TAPCELL_ROW_34_353 VDD VSS WELLTAP
Xclkbuf_leaf_16_clk_regs clkload1/A VDD VSS clkload5/A BUFX12
XFILLER_0_903 VSS VDD FILLER2
XFILLER_106_669 VDD VSS FILLER1
XFILLER_10_56 VDD VSS DECAPHV8
XFILLER_121_617 VSS VDD FILLER2
XFILLER_126_89 VDD VSS DECAPHV8
XFILLER_133_488 VDD VSS FILLER1
XFILLER_86_49 VDD VSS DECAPHV8
XFILLER_101_363 VDD VSS FILLER1
XFILLER_102_886 VSS VDD FILLER2
XFILLER_47_406 VDD VSS FILLER1
XFILLER_19_76 VSS VDD FILLER2
XFILLER_43_601 VDD VSS FILLER1
XFILLER_62_409 VDD VSS DECAPHV8
X_09719_ _18449_/Q VDD VSS _20161_/A INVX1
X_10991_ _11023_/A _10991_/B VDD VSS _10992_/B XOR2X1
XFILLER_16_848 VDD VSS DECAPHV8
XFILLER_35_42 VDD VSS DECAPHV8
XFILLER_55_472 VSS VDD FILLER2
XFILLER_71_921 VSS VDD FILLER2
X_12730_ _12821_/B _14348_/C _19075_/Q VDD VSS _12731_/D AND3BX1
XTAP_TAPCELL_ROW_107_1086 VDD VSS WELLTAP
X_12661_ _19213_/Q _12755_/A _12837_/B VDD VSS _12662_/D XNOR3X1
XFILLER_30_328 VDD VSS FILLER1
XTAP_TAPCELL_ROW_120_1220 VDD VSS WELLTAP
XTAP_TAPCELL_ROW_6_79 VDD VSS WELLTAP
X_11612_ _18756_/Q _11612_/B VDD VSS _18783_/D AND2X1
X_14400_ _14415_/A _14400_/B VDD VSS _19121_/D AND2X1
XFILLER_51_30 VDD VSS FILLER1
X_12592_ _12593_/D _14408_/B VDD VSS _12732_/A NAND2X1
X_15380_ _19320_/Q _15691_/B VDD VSS _15381_/B XNOR2X1
XFILLER_136_0 VDD VSS DECAPHV8
XFILLER_51_41 VDD VSS DECAPHV16
X_11543_ _18006_/C VDD VSS _11648_/A BUFX3
X_14331_ _13849_/Y _16726_/B _14331_/C VDD VSS _19059_/D AND3BX1
XFILLER_11_586 VSS VDD FILLER2
X_11474_ _16860_/A VDD VSS _11484_/B BUFX3
X_14262_ _14255_/Y _14262_/B _14262_/C VDD VSS _19000_/D AND3BX1
X_17050_ _17048_/Y _17050_/B _17986_/C VDD VSS _19763_/D AND3BX1
XFILLER_124_400 VDD VSS FILLER4
XFILLER_125_912 VDD VSS FILLER1
XFILLER_137_761 VDD VSS FILLER1
X_10425_ _10585_/C _10550_/A VDD VSS _10738_/C NAND2BX1
X_13213_ _13365_/A _13364_/B VDD VSS _14354_/B XNOR2X1
X_14193_ _14219_/A _14193_/B _14193_/C VDD VSS _18943_/D NOR3X1
X_16001_ _16033_/A _16033_/B VDD VSS _16804_/B XNOR2X1
XFILLER_136_282 VDD VSS FILLER1
XTAP_TAPCELL_ROW_118_1193 VDD VSS WELLTAP
X_13144_ _20011_/Q _19275_/Q VDD VSS _13255_/D AND2X1
XFILLER_140_904 VSS VDD FILLER2
X_10356_ _11272_/A _10356_/B VDD VSS _18553_/D NOR2X1
XFILLER_105_680 VDD VSS FILLER1
XFILLER_124_488 VDD VSS FILLER4
XFILLER_124_499 VDD VSS FILLER1
X_10287_ _10338_/A _10338_/B _10287_/C VDD VSS _10295_/B AOI21X1
X_13075_ _18911_/Q _13178_/B _13178_/C VDD VSS _13081_/B XNOR3X1
X_17952_ wire152/Y _17957_/C VDD VSS _17953_/B NOR2X1
X_12026_ _19122_/Q _12026_/B VDD VSS _12087_/C _12026_/C NAND3X1
X_17883_ _17885_/C _17884_/B _17917_/C VDD VSS _17884_/C OAI21X1
X_16903_ _19738_/Q _17827_/B VDD VSS _19738_/D NOR2X1
XFILLER_66_715 VDD VSS FILLER4
X_19622_ _19673_/CK _19622_/D _19622_/Q VDD VSS DFFQX1
X_16834_ _16838_/A _16834_/B VDD VSS _19675_/D NOR2X1
XFILLER_34_601 VSS VDD FILLER2
XFILLER_93_578 VDD VSS DECAPHV16
XTAP_TAPCELL_ROW_76_776 VDD VSS WELLTAP
X_13977_ _13977_/A _14135_/B _14135_/C VDD VSS _13978_/D NOR3X1
X_19553_ _19591_/CK _19553_/D _19553_/Q VDD VSS DFFQX1
X_16765_ _16775_/A _16765_/B VDD VSS _19613_/D NOR2X1
X_12928_ _19105_/Q _14383_/B VDD VSS _13017_/C _14383_/C NAND3X1
X_19484_ _19643_/CK _19484_/D _19484_/Q VDD VSS DFFQX1
X_18504_ _18504_/CK _18504_/D _18504_/Q _09362_/Y VDD VSS DFFRQX1
X_16696_ _16696_/A _16704_/B VDD VSS _19551_/D NOR2X1
X_15716_ _15725_/A _15716_/B VDD VSS _19342_/D AND2X1
X_18435_ _18439_/CK _18499_/D _18435_/Q _18465_/RB VDD VSS DFFRQX1
X_15647_ _15657_/B _15647_/B VDD VSS _15701_/B XNOR2X1
XFILLER_61_464 VDD VSS FILLER1
XFILLER_61_497 VDD VSS FILLER1
X_12859_ _12860_/B _12860_/C _19160_/Q VDD VSS _12932_/B AOI21X1
XFILLER_14_380 VDD VSS FILLER4
XTAP_TAPCELL_ROW_31_323 VDD VSS WELLTAP
X_18366_ _18375_/CK _18515_/Q _20203_/A _18465_/RB VDD VSS DFFRQX1
X_15578_ _15578_/A _15599_/C VDD VSS _15791_/B XNOR2X1
XFILLER_30_873 VDD VSS FILLER4
X_14529_ _14522_/Y _14529_/B _14529_/C VDD VSS _19235_/D AND3BX1
X_18297_ _18311_/CK _18510_/Q _18297_/Q _18471_/RB VDD VSS DFFRQX1
X_17317_ _17318_/A _17318_/B _17318_/D _17318_/C VDD VSS _17320_/C AOI211X1
X_17248_ _19805_/Q _19773_/Q _17248_/C VDD VSS _17252_/B AOI21X1
XFILLER_134_208 VDD VSS FILLER1
XFILLER_116_945 VDD VSS FILLER4
XFILLER_127_282 VSS VDD FILLER2
XFILLER_143_742 VSS VDD FILLER2
XFILLER_51_0 VDD VSS FILLER4
X_17179_ _19790_/Q VDD VSS _17329_/B INVX1
XFILLER_103_606 VDD VSS DECAPHV8
XFILLER_131_926 VDD VSS FILLER4
X_20190_ _20190_/A VDD VSS _20190_/Y BUFX3
XFILLER_111_683 VSS VDD FILLER2
XFILLER_57_726 VDD VSS FILLER4
XFILLER_69_597 VSS VDD FILLER2
XFILLER_97_895 VSS VDD FILLER2
XTAP_TAPCELL_ROW_39_401 VDD VSS WELLTAP
X_09504_ _18500_/D _09507_/B _09506_/C _20078_/Q VDD VSS _20078_/D AO22X2
XFILLER_112_69 VDD VSS DECAPHV8
XFILLER_52_453 VSS VDD FILLER2
X_09435_ _18506_/Q _18505_/Q _09630_/C VDD VSS _09783_/B OR3BX1
XFILLER_40_615 VDD VSS FILLER1
XFILLER_12_328 VDD VSS FILLER4
X_09366_ _18515_/Q VDD VSS _18478_/D INVX1
Xclkbuf_leaf_14__001_ clkload41/A VDD VSS _19172_/CK BUFX12
XANTENNA_40 _18173_/A VDD VSS ANTENNA2
XFILLER_138_536 VDD VSS FILLER1
XFILLER_21_873 VDD VSS DECAPHV16
X_09297_ _18526_/Q _09277_/A _09296_/Y VDD VSS _18526_/D MUX2X1
XFILLER_21_55 VSS VDD FILLER2
Xclkbuf_leaf_29__001_ clkbuf_2_1__f__001_/Y VDD VSS _18993_/CK BUFX12
XFILLER_137_44 VDD VSS FILLER4
X_10210_ _13177_/A _11426_/C VDD VSS _18547_/D NOR2X1
XFILLER_122_915 VDD VSS FILLER1
XFILLER_134_775 VDD VSS DECAPHV8
X_11190_ _18577_/Q VDD VSS _11220_/A INVX1
XFILLER_106_488 VDD VSS FILLER1
X_10141_ _18589_/Q _10163_/C VDD VSS _10142_/B NAND2X1
XFILLER_0_755 VSS VDD FILLER2
X_10072_ _09895_/B _10071_/Y _10131_/A VDD VSS _10078_/B MUXI2X1
X_13900_ _13912_/A _13912_/B _13901_/D _13912_/E VDD VSS _14300_/B OA211X2
XFILLER_87_383 VDD VSS FILLER1
XTAP_TAPCELL_ROW_109_1104 VDD VSS WELLTAP
X_14880_ _15015_/D VDD VSS _14881_/D INVX1
XFILLER_75_578 VDD VSS FILLER1
X_13831_ _19059_/Q _13831_/B _13850_/C VDD VSS _13912_/B XNOR3X1
XFILLER_46_63 VDD VSS FILLER1
XFILLER_90_537 VDD VSS FILLER1
X_10974_ _19956_/Q _18838_/Q VDD VSS _11004_/C NOR2X1
X_13762_ _18946_/Q _14196_/B VDD VSS _13918_/C _14196_/C AND3X2
X_16550_ _19571_/Q VDD VSS _16551_/A INVX1
XFILLER_15_111 VDD VSS FILLER1
XFILLER_43_420 VDD VSS DECAPHV16
XFILLER_71_751 VDD VSS FILLER1
XTAP_TAPCELL_ROW_73_746 VDD VSS WELLTAP
X_12713_ _18991_/Q _12713_/B _12713_/C VDD VSS _12903_/A MIN3X1
X_15501_ _15695_/B VDD VSS _15502_/B INVX1
XFILLER_16_678 VDD VSS FILLER1
XFILLER_43_464 VDD VSS FILLER1
XFILLER_71_784 VDD VSS FILLER1
X_13693_ _19001_/Q _14263_/B VDD VSS _13830_/C _14263_/C AND3X2
X_18220_ _18233_/CK _18220_/E _18220_/ECK VDD VSS CGX3
X_16481_ _19633_/Q _16787_/B VDD VSS _16482_/B XOR2X1
X_12644_ _14409_/C _19130_/Q _12816_/B VDD VSS _12732_/D AND3BX1
X_15432_ _19489_/Q _15882_/B VDD VSS _15433_/C NOR2BX1
X_12575_ _19241_/Q VDD VSS _12677_/A INVX1
X_18151_ _18152_/A _18153_/C _18187_/C VDD VSS _18152_/C OAI21X1
X_15363_ _15364_/A _15364_/B _15364_/D _15364_/C VDD VSS _15395_/C OAOI211X1
XFILLER_11_383 VDD VSS FILLER1
X_11526_ _18678_/Q _11531_/B VDD VSS _18705_/D AND2X1
X_14314_ _14334_/A _14314_/B VDD VSS _19045_/D AND2X1
X_18082_ _18168_/C _18090_/B VDD VSS _18083_/D NAND2X1
X_17102_ _17100_/B _17102_/B VDD VSS _17103_/C NOR2BX1
XFILLER_116_219 VDD VSS FILLER4
XFILLER_8_888 VDD VSS FILLER1
X_17033_ _17040_/A _17036_/C _17081_/C VDD VSS _17034_/C OAI21X1
X_15294_ _15294_/A _15299_/B VDD VSS _15689_/B XOR2X1
XFILLER_109_282 VSS VDD FILLER2
XFILLER_125_742 VSS VDD FILLER2
X_11457_ _19950_/Q _11460_/B VDD VSS _18643_/D AND2X1
X_14245_ _14251_/A _14245_/B VDD VSS _18985_/D NOR2X1
XFILLER_98_615 VDD VSS FILLER4
X_10408_ _10454_/A _10454_/B _10721_/D VDD VSS _10409_/C AOI21X1
X_11388_ _18594_/Q _11390_/B VDD VSS _11392_/B NAND2BX1
X_14176_ _14186_/A _14176_/B VDD VSS _18928_/D NOR2X1
X_10339_ _10927_/C _10339_/B _10402_/B VDD VSS _10345_/C NOR3X1
X_13127_ _19163_/Q _14447_/B VDD VSS _13316_/D _14447_/C NAND3X1
X_18984_ _19040_/CK _18984_/D _18984_/Q VDD VSS DFFQX1
X_13058_ _13133_/A _13133_/C VDD VSS _13061_/B _13133_/B NAND3X1
X_17935_ _17935_/A _17935_/B _17935_/C VDD VSS _19954_/D AOI21X1
XFILLER_78_372 VDD VSS FILLER4
X_12009_ _18954_/Q _14205_/B VDD VSS _12070_/B NOR2X1
XFILLER_120_480 VDD VSS FILLER1
XFILLER_66_523 VSS VDD FILLER2
XFILLER_78_383 VDD VSS DECAPHV16
X_17866_ _17866_/A _17866_/B _17866_/C VDD VSS _19941_/D AOI21X1
XFILLER_26_409 VDD VSS FILLER1
XFILLER_66_556 VDD VSS FILLER1
X_19605_ _19671_/CK _19605_/D _19605_/Q VDD VSS DFFQX1
X_17797_ _17800_/C _17797_/B VDD VSS _17798_/B XNOR2X1
X_16817_ _16826_/A _16817_/B VDD VSS _19659_/D NOR2X1
XFILLER_81_526 VSS VDD FILLER2
X_19536_ _19707_/CK _19536_/D _19536_/Q VDD VSS DFFQX1
X_16748_ _16748_/A _16748_/B VDD VSS _19598_/D NOR2X1
XFILLER_46_280 VDD VSS FILLER4
XFILLER_62_740 VDD VSS FILLER4
XTAP_TAPCELL_ROW_140_1415 VDD VSS WELLTAP
XFILLER_50_913 VDD VSS FILLER1
XFILLER_62_784 VDD VSS FILLER4
X_09220_ _18511_/Q VDD VSS _18394_/D INVX1
X_19467_ _19495_/CK _19467_/D _19467_/Q VDD VSS DFFQX1
X_16679_ _16679_/A _16679_/B VDD VSS _16761_/B XNOR2X1
XFILLER_34_497 VDD VSS DECAPHV8
XFILLER_99_0 VDD VSS DECAPHV8
XTAP_TAPCELL_ROW_16_172 VDD VSS WELLTAP
X_19398_ _19425_/CK _19398_/D _19398_/Q VDD VSS DFFQX1
X_18418_ _18420_/CK _18519_/Q _20173_/A _18452_/RB VDD VSS DFFRQX1
X_18349_ _18356_/CK _18349_/D _18349_/Q _18373_/RB VDD VSS DFFRQX1
XTAP_TAPCELL_ROW_0_0 VDD VSS WELLTAP
XFILLER_135_517 VSS VDD FILLER2
XTAP_TAPCELL_ROW_138_1399 VDD VSS WELLTAP
XFILLER_131_701 VDD VSS FILLER4
Xclkbuf_2_2__f__09182_ clkbuf_0__09182_/Y VDD VSS _18565_/CK BUFX12
XFILLER_115_274 VDD VSS FILLER1
X_20173_ _20173_/A VDD VSS _20173_/Y BUFX3
XFILLER_103_447 VSS VDD FILLER2
XFILLER_88_136 VSS VDD FILLER2
XFILLER_89_659 VDD VSS DECAPHV8
X_09984_ _11095_/C VDD VSS _11226_/D BUFX3
XFILLER_123_46 VDD VSS DECAPHV8
XFILLER_45_718 VDD VSS FILLER1
XFILLER_57_556 VSS VDD FILLER2
XFILLER_84_342 VDD VSS FILLER1
XFILLER_26_910 VSS VDD FILLER2
XFILLER_13_604 VDD VSS FILLER1
XFILLER_25_464 VDD VSS FILLER1
XTAP_TAPCELL_ROW_104_1056 VDD VSS WELLTAP
XTAP_TAPCELL_ROW_70_716 VDD VSS WELLTAP
XFILLER_40_423 VDD VSS FILLER1
XFILLER_53_795 VSS VDD FILLER2
X_09418_ _09421_/A _18201_/B _20057_/Q _20061_/D VDD VSS _18227_/E OAI211X1
X_10690_ _18695_/Q _18749_/Q VDD VSS _10693_/D XOR2X1
XFILLER_12_169 VDD VSS FILLER1
XFILLER_40_467 VDD VSS FILLER1
X_09349_ _09362_/AB _09349_/B VDD VSS _09349_/Y NOR2BX1
XFILLER_139_845 VDD VSS DECAPHV16
XFILLER_139_867 VDD VSS FILLER1
X_12360_ _12360_/A _12452_/D VDD VSS _14311_/B XNOR2X1
XFILLER_138_366 VDD VSS FILLER1
XFILLER_32_98 VDD VSS FILLER4
XTAP_TAPCELL_ROW_3_47 VDD VSS WELLTAP
X_11311_ _18585_/Q _11315_/B VDD VSS _11316_/A XNOR2X1
XFILLER_113_2 VDD VSS FILLER1
XFILLER_126_539 VDD VSS FILLER1
XFILLER_138_388 VDD VSS DECAPHV8
X_12291_ _12300_/A _12300_/B _12300_/C VDD VSS _12294_/C NOR3X1
X_11242_ _11364_/B _11264_/A VDD VSS _11247_/A NAND2X1
X_14030_ _14054_/A _14170_/B _14170_/C VDD VSS _14085_/C NOR3X1
XFILLER_79_103 VDD VSS FILLER4
XTAP_TAPCELL_ROW_115_1163 VDD VSS WELLTAP
X_11173_ _19961_/Q _18843_/Q _11173_/C VDD VSS _11176_/B MIN3X1
XFILLER_122_756 VDD VSS FILLER1
XFILLER_122_767 VDD VSS DECAPHV16
X_10124_ _17812_/A _10124_/B _10126_/C VDD VSS _18538_/D AND3BX1
XFILLER_67_309 VDD VSS DECAPHV8
X_15981_ _19674_/Q _16833_/B VDD VSS _16020_/A NOR2BX1
XFILLER_48_545 VDD VSS FILLER4
XFILLER_57_51 VSS VDD FILLER2
X_10055_ _18583_/Q _10079_/C VDD VSS _10055_/Y XNOR2X1
X_17720_ _18132_/A _17720_/B _17721_/C VDD VSS _19906_/D NOR3X1
X_14932_ _15834_/B _15834_/C _19449_/Q VDD VSS _14959_/B AOI21X1
XFILLER_75_331 VDD VSS FILLER1
XFILLER_76_865 VDD VSS FILLER1
X_17651_ _17653_/C _17651_/B _17651_/C VDD VSS _19891_/D AOI21X1
X_14863_ _19448_/Q VDD VSS _14906_/C INVX1
XFILLER_63_515 VDD VSS FILLER1
XFILLER_75_375 VDD VSS DECAPHV16
XFILLER_90_323 VSS VDD FILLER2
XFILLER_91_835 VSS VDD FILLER2
XTAP_TAPCELL_ROW_86_871 VDD VSS WELLTAP
X_13814_ _18946_/Q _14196_/B VDD VSS _13818_/C _14196_/C NAND3X1
X_16602_ _19573_/Q _16722_/A _16602_/C VDD VSS _16626_/C MIN3X1
XTAP_TAPCELL_ROW_58_595 VDD VSS WELLTAP
X_19321_ _19322_/CK _19321_/D _19321_/Q VDD VSS DFFQX1
Xdelaybuf_1_sclk sclk VDD VSS delaybuf_2_sclk/A BUFX12
X_17582_ _19877_/Q _19845_/Q VDD VSS _17589_/C NOR2X1
X_14794_ _19447_/Q _14865_/A _14865_/B VDD VSS _14840_/D XNOR3X1
XFILLER_71_570 VDD VSS DECAPHV16
XFILLER_73_83 VSS VDD FILLER2
X_10957_ _10957_/A _10957_/B _10957_/C VDD VSS _11023_/A OA21X2
X_13745_ _18196_/A _17925_/B _17925_/C VDD VSS _18862_/D AND3BX1
X_16533_ _16545_/A _16825_/B VDD VSS _16534_/B XNOR2X1
XFILLER_31_434 VDD VSS FILLER4
XFILLER_32_946 VDD VSS FILLER4
X_13676_ _14195_/C _18945_/Q _13816_/B VDD VSS _13748_/D AND3BX1
X_19252_ _19988_/CK _19252_/D _19252_/Q VDD VSS DFFQX1
X_16464_ _16467_/B _16465_/B _18168_/C VDD VSS _16465_/C OAI21X1
XFILLER_129_300 VDD VSS FILLER1
XTAP_TAPCELL_ROW_13_142 VDD VSS WELLTAP
X_10888_ _10888_/A _10888_/B VDD VSS _10954_/A NAND2X1
X_12627_ _19074_/Q VDD VSS _12719_/A INVX1
X_19183_ _19215_/CK _19183_/D _19183_/Q VDD VSS DFFQX1
X_18203_ _18200_/Y _20016_/Q _18202_/Y VDD VSS _20016_/D MUX2X1
X_15415_ _19349_/Q _15723_/B VDD VSS _15456_/B NOR2X1
XFILLER_8_630 VSS VDD FILLER2
X_18134_ _19293_/Q _18138_/B VDD VSS _18136_/C XOR2X1
X_16395_ _16395_/A _19917_/Q _16395_/C VDD VSS _16421_/B MIN3X1
XFILLER_11_191 VDD VSS FILLER1
XFILLER_144_303 VDD VSS FILLER4
XFILLER_8_663 VDD VSS DECAPHV8
X_12558_ _12558_/A _14345_/B _12625_/C _12558_/D VDD VSS wire158/A OAOI211X1
X_15346_ _19431_/Q VDD VSS _15348_/A INVX1
XFILLER_144_314 VDD VSS FILLER1
XFILLER_7_162 VDD VSS FILLER4
XFILLER_8_696 VDD VSS FILLER1
X_11509_ _16860_/A VDD VSS _11519_/B BUFX3
X_12489_ _12571_/A _14503_/B _12497_/C VDD VSS _14504_/C OR3BX1
X_18065_ _19280_/Q _18068_/B VDD VSS _18069_/B XOR2X1
X_15277_ _15311_/A _15311_/B _15311_/D _15311_/C VDD VSS _15307_/D OAI211X1
XFILLER_99_902 VDD VSS DECAPHV8
X_14228_ _14231_/A _14228_/B VDD VSS _18973_/D AND2X1
X_17016_ _17180_/B _17047_/B VDD VSS _17022_/B XNOR2X1
XFILLER_113_712 VDD VSS FILLER1
XFILLER_125_561 VDD VSS DECAPHV8
XFILLER_98_412 VDD VSS FILLER4
XFILLER_99_946 VDD VSS FILLER4
X_14159_ _14136_/Y _14159_/B _14159_/C VDD VSS _18914_/D AND3BX1
XFILLER_100_406 VDD VSS FILLER1
Xclkbuf_leaf_13__002_ clkbuf_leaf_9__002_/A VDD VSS _18782_/CK BUFX12
X_18967_ _18970_/CK _18967_/D _18967_/Q VDD VSS DFFQX1
X_18898_ _19197_/CK _18898_/D _18898_/Q VDD VSS DFFQX1
X_17918_ _17919_/C _17918_/B _17918_/C VDD VSS _19951_/D AOI21X1
XFILLER_94_640 VSS VDD FILLER2
X_17849_ _17853_/A _17853_/B VDD VSS _17851_/B XNOR2X1
XFILLER_26_228 VDD VSS FILLER4
XFILLER_82_835 VSS VDD FILLER2
XFILLER_35_751 VDD VSS FILLER1
XFILLER_82_857 VDD VSS FILLER1
XFILLER_23_924 VDD VSS FILLER4
X_19519_ _19521_/CK _19519_/D _19519_/Q VDD VSS DFFQX1
XFILLER_10_607 VDD VSS DECAPHV32
X_09203_ _18516_/Q VDD VSS _18431_/D INVX1
XFILLER_135_303 VDD VSS FILLER1
X_20225_ _20225_/A VDD VSS _20225_/Y BUFX3
XFILLER_104_789 VDD VSS FILLER1
X_20156_ _20156_/A VDD VSS _20156_/Y BUFX3
X_20087_ _20087_/A VDD VSS _20087_/Y BUFX3
XFILLER_57_342 VDD VSS FILLER1
X_09898_ _09872_/Y _09857_/Y _10966_/A VDD VSS _09898_/Y MUX2X1
XFILLER_57_375 VDD VSS FILLER1
XTAP_TAPCELL_ROW_83_841 VDD VSS WELLTAP
X_11860_ _19062_/Q _14334_/B VDD VSS _11861_/B OR2X2
XFILLER_26_784 VDD VSS FILLER1
XTAP_TAPCELL_ROW_55_565 VDD VSS WELLTAP
X_10811_ _10811_/A _10816_/C VDD VSS _10849_/B XNOR2X1
X_11791_ _19145_/Q _11818_/B _14427_/B VDD VSS _11854_/B MIN3X1
XFILLER_40_220 VDD VSS DECAPHV8
XFILLER_41_721 VDD VSS FILLER1
XFILLER_41_743 VDD VSS FILLER1
XFILLER_81_890 VSS VDD FILLER2
XTAP_TAPCELL_ROW_27_289 VDD VSS WELLTAP
X_10742_ _11272_/A _10742_/B VDD VSS _18563_/D NOR2X1
X_13530_ _13531_/A _13531_/B _13531_/D _13531_/C VDD VSS _13728_/B OAOI211X1
Xclkbuf_1_0__f__09181_ clkbuf_0__09181_/Y VDD VSS _18622_/CK BUFX12
X_10673_ _10721_/D VDD VSS _11226_/A BUFX3
X_13461_ _19250_/Q VDD VSS _13462_/A INVX1
X_15200_ _15200_/A _15200_/B _15200_/C VDD VSS _15201_/B AOI21X1
XTAP_TAPCELL_ROW_10_112 VDD VSS WELLTAP
X_12412_ _12673_/A _12583_/A VDD VSS _12495_/D NOR2X1
X_13392_ _14192_/C _18942_/Q _13516_/B VDD VSS _13393_/D AND3BX1
X_16180_ _19589_/Q VDD VSS _16181_/A INVX1
XFILLER_127_848 VSS VDD FILLER2
XFILLER_139_686 VDD VSS DECAPHV16
X_12343_ _18903_/Q _12429_/B _14147_/B VDD VSS _14115_/B XNOR3X1
X_15131_ _19314_/Q VDD VSS _15132_/A INVX1
XFILLER_126_369 VDD VSS FILLER1
X_12274_ _12341_/A _12341_/B _14178_/B VDD VSS _12348_/C XNOR3X1
X_15062_ _19508_/Q _15902_/B VDD VSS _15145_/C NAND2BX1
XFILLER_107_561 VSS VDD FILLER2
XFILLER_135_881 VDD VSS FILLER1
XFILLER_142_829 VSS VDD FILLER2
XFILLER_4_154 VSS VDD FILLER2
X_11225_ _19963_/Q _18845_/Q _11225_/C VDD VSS _11226_/C MIN3X1
X_14013_ _14013_/A _14232_/B _14013_/C _14013_/D VDD VSS _14043_/B AOAI211X1
XFILLER_107_594 VSS VDD FILLER2
XFILLER_134_391 VDD VSS DECAPHV16
X_19870_ _19903_/CK _19870_/D _19870_/Q VDD VSS DFFQX1
XFILLER_68_607 VDD VSS DECAPHV8
X_11156_ _11158_/B _11156_/B VDD VSS _11157_/B XOR2X1
X_18821_ _19940_/CK _18821_/D _18821_/Q VDD VSS DFFQX1
XFILLER_49_821 VDD VSS FILLER1
X_10107_ _10131_/A _10107_/B VDD VSS _10109_/C NOR2X1
X_11087_ _11085_/Y _11088_/C VDD VSS _18573_/D NOR2BX1
X_18752_ _18779_/CK _18752_/D _18752_/Q VDD VSS DFFQX1
X_15964_ _19550_/Q _19902_/Q VDD VSS _15995_/B XNOR2X1
X_10038_ _10050_/B _10038_/B VDD VSS _11409_/C XOR2X1
X_17703_ _19902_/Q _19870_/Q _17703_/C VDD VSS _17707_/B AOI21X1
X_14915_ _15834_/B _15834_/C _19449_/Q VDD VSS _14931_/B AO21X2
X_18683_ _18764_/CK _18683_/D _18683_/Q VDD VSS DFFQX1
X_15895_ _15895_/A _15895_/B VDD VSS _19502_/D NOR2X1
XFILLER_48_397 VDD VSS DECAPHV16
XFILLER_84_71 VDD VSS DECAPHV8
X_17634_ _19887_/Q _19855_/Q _17634_/C VDD VSS _17638_/B MIN3X1
X_14846_ _19364_/Q _15739_/B VDD VSS _14847_/B XNOR2X1
XFILLER_91_687 VDD VSS FILLER1
XFILLER_91_698 VDD VSS DECAPHV8
X_17565_ _17567_/C _17565_/B _17565_/C VDD VSS _19873_/D AOI21X1
X_14777_ _15831_/B _15831_/C _14778_/A VDD VSS _14818_/B OAI21X1
X_11989_ _19233_/Q _14527_/B VDD VSS _12099_/A AND2X1
X_13728_ _13728_/A _13728_/B _13728_/C VDD VSS _14327_/C NOR3X1
X_19304_ _19304_/CK _19304_/D _19304_/Q VDD VSS DFFQX1
X_16516_ _19698_/Q _16859_/B VDD VSS _16537_/A NAND2BX1
XFILLER_20_905 VSS VDD FILLER2
XFILLER_31_242 VDD VSS FILLER1
XFILLER_90_4 VSS VDD FILLER2
X_19235_ _20008_/CK _19235_/D _19235_/Q VDD VSS DFFQX1
X_17496_ _17496_/A _17496_/B _17496_/C _17496_/D VDD VSS _17497_/C AOAI211X1
XFILLER_31_286 VSS VDD FILLER2
X_13659_ _18889_/Q _13807_/A _13807_/B VDD VSS _13660_/D XNOR3X1
X_16447_ _16447_/A _16447_/B VDD VSS _16472_/B NAND2X1
X_19166_ _19194_/CK _19166_/D _19166_/Q VDD VSS DFFQX1
X_16378_ _19661_/Q _16819_/B VDD VSS _16390_/C XNOR2X1
XFILLER_117_303 VDD VSS FILLER4
XFILLER_129_185 VDD VSS FILLER1
XFILLER_8_471 VSS VDD FILLER2
X_19097_ _19126_/CK _19097_/D _19097_/Q VDD VSS DFFQX1
X_18117_ _18117_/A _18117_/B _18116_/Y VDD VSS _19997_/D AOI21BX1
X_15329_ _15345_/B _15329_/B VDD VSS _15752_/B XOR2X1
XTAP_TAPCELL_ROW_135_1369 VDD VSS WELLTAP
X_18048_ _18544_/Q _18048_/B _18545_/Q VDD VSS _18049_/C AOI21X1
XFILLER_132_328 VDD VSS FILLER4
XFILLER_99_721 VDD VSS FILLER1
XFILLER_98_253 VDD VSS FILLER1
X_09821_ _14522_/A VDD VSS _10180_/A BUFX3
X_20010_ _20013_/CK _20010_/D _20010_/Q VDD VSS DFFQX1
X_09752_ _09816_/D _20192_/A VDD VSS _09753_/C NAND2X1
X_19999_ _19999_/CK _19999_/D _19999_/Q VDD VSS DFFQX1
Xclkbuf_0__09175_ _18224_/ECK VDD VSS clkbuf_0__09175_/Y BUFX12
XFILLER_104_59 VDD VSS FILLER1
XFILLER_27_526 VDD VSS DECAPHV32
XFILLER_39_375 VSS VDD FILLER2
XFILLER_55_835 VSS VDD FILLER2
XTAP_TAPCELL_ROW_97_988 VDD VSS WELLTAP
X_09683_ _18415_/Q VDD VSS _20170_/A INVX1
XFILLER_54_345 VSS VDD FILLER2
XFILLER_55_846 VDD VSS FILLER1
XFILLER_42_518 VSS VDD FILLER2
XFILLER_42_529 VDD VSS FILLER1
XFILLER_82_665 VDD VSS DECAPHV8
XFILLER_63_890 VDD VSS FILLER1
XFILLER_81_175 VDD VSS FILLER1
XTAP_TAPCELL_ROW_52_535 VDD VSS WELLTAP
XTAP_TAPCELL_ROW_80_811 VDD VSS WELLTAP
XFILLER_120_69 VDD VSS FILLER1
XFILLER_22_220 VSS VDD FILLER2
XFILLER_22_231 VDD VSS FILLER1
XTAP_TAPCELL_ROW_101_1026 VDD VSS WELLTAP
XTAP_TAPCELL_ROW_24_259 VDD VSS WELLTAP
XFILLER_11_949 VDD VSS FILLER1
XFILLER_23_787 VSS VDD FILLER2
XFILLER_50_573 VDD VSS FILLER1
XFILLER_10_437 VDD VSS FILLER1
XFILLER_136_601 VSS VDD FILLER2
XFILLER_135_100 VSS VDD FILLER2
XFILLER_135_111 VDD VSS FILLER4
XFILLER_13_78 VSS VDD FILLER2
XFILLER_108_336 VDD VSS FILLER4
XFILLER_124_818 VDD VSS FILLER4
XFILLER_89_38 VDD VSS FILLER1
XFILLER_123_306 VSS VDD FILLER2
XFILLER_135_166 VDD VSS FILLER4
XFILLER_2_603 VDD VSS FILLER1
XTAP_TAPCELL_ROW_0_15 VDD VSS WELLTAP
XTAP_TAPCELL_ROW_112_1133 VDD VSS WELLTAP
XFILLER_104_542 VDD VSS FILLER1
XFILLER_104_575 VDD VSS DECAPHV8
XFILLER_132_873 VDD VSS DECAPHV8
XFILLER_89_264 VDD VSS FILLER1
XTAP_TAPCELL_ROW_88_900 VDD VSS WELLTAP
X_11010_ _11033_/C _11195_/A _11010_/C VDD VSS _11011_/D AND3BX1
X_20208_ _20208_/A VDD VSS _20208_/Y BUFX3
XFILLER_78_949 VDD VSS FILLER1
X_20139_ _20139_/A VDD VSS _20139_/Y BUFX3
XFILLER_58_640 VDD VSS FILLER1
XFILLER_92_407 VDD VSS FILLER1
XFILLER_18_526 VDD VSS DECAPHV16
XFILLER_73_621 VSS VDD FILLER2
X_12961_ _19246_/Q _13150_/A _13047_/C VDD VSS _13133_/C XNOR3X1
XFILLER_73_654 VSS VDD FILLER2
XFILLER_85_492 VDD VSS FILLER4
X_11912_ _19148_/Q _11912_/B VDD VSS _11973_/C _11912_/C NAND3X1
X_12892_ _12892_/A _14285_/B VDD VSS _12900_/A NOR2X1
X_15680_ _15706_/A _15680_/B VDD VSS _19309_/D AND2X1
X_14700_ _19471_/Q _14700_/B _15862_/B VDD VSS _15828_/B XNOR3X1
XFILLER_72_142 VDD VSS DECAPHV8
X_11843_ _19994_/Q _19258_/Q VDD VSS _11881_/C NOR2X1
X_14631_ _14672_/A _14672_/B _14640_/C VDD VSS _15796_/B XNOR3X1
X_17350_ _17353_/C _17351_/B _17363_/C VDD VSS _17351_/C OAI21X1
XFILLER_54_85 VDD VSS FILLER1
X_11774_ _14521_/B _14521_/C _19228_/Q VDD VSS _11776_/C AOI21X1
X_14562_ _20001_/Q _14569_/B VDD VSS _19265_/D AND2X1
Xclkbuf_1_0__f__09164_ clkbuf_0__09164_/Y VDD VSS _18453_/CK BUFX12
X_16301_ _16302_/A _16302_/B _16302_/C VDD VSS _16301_/Y NOR3X1
XFILLER_14_787 VSS VDD FILLER2
XFILLER_14_798 VDD VSS FILLER1
XFILLER_41_573 VDD VSS DECAPHV32
X_10725_ _10725_/A _10725_/B _10725_/C _11095_/C VDD VSS _10726_/D AOI31X1
X_13513_ _18998_/Q _14260_/B VDD VSS _13594_/C _14260_/C AND3X2
X_14493_ _14493_/A _14493_/B VDD VSS _19204_/D NOR2X1
X_17281_ _17281_/A _17281_/B _17281_/C VDD VSS _17289_/A OA21X2
XFILLER_127_601 VDD VSS DECAPHV16
X_10656_ _10945_/A _10656_/B _10656_/C _10947_/A VDD VSS _10657_/C AO211X2
X_13444_ _13444_/A _13444_/B _13444_/C _13444_/D VDD VSS _13447_/B AOAI211X1
X_19020_ _19040_/CK _19020_/D _19020_/Q VDD VSS DFFQX1
X_16232_ _19591_/Q _16741_/B VDD VSS _16233_/C NOR2X1
Xclkload16 _19928_/CK VDD VSS clkload16/Y INVX6
X_16163_ _16163_/A _16182_/B VDD VSS _16774_/B XNOR2X1
XFILLER_127_667 VDD VSS DECAPHV8
X_10587_ _10587_/A _10596_/B VDD VSS _10589_/B XNOR2X1
X_13375_ _18998_/Q _13509_/B _13375_/C VDD VSS _13401_/C XNOR3X1
Xclkload49 _19182_/CK VDD VSS clkload49/Y INVX2
Xclkload38 _18809_/CK VDD VSS clkload38/Y INVX4
Xclkload27 _19940_/CK VDD VSS clkload27/Y INVX4
X_15114_ _15198_/B _15840_/B _19454_/Q VDD VSS _15139_/C AOI2B1X1
XFILLER_114_317 VDD VSS FILLER1
X_12326_ _19211_/Q _12326_/B _12391_/D VDD VSS _12474_/B XNOR3X1
X_16094_ _19650_/Q _16807_/B VDD VSS _16106_/B XOR2X1
X_12257_ _12447_/A _12447_/B _12257_/C _12257_/D VDD VSS _12363_/B AOAI211X1
X_19922_ clkload7/A _19922_/D _19922_/Q VDD VSS DFFQX1
X_15045_ _15045_/A _15045_/B _15045_/C _15045_/D VDD VSS _15069_/B AOAI211X1
XFILLER_123_862 VDD VSS FILLER1
X_11208_ _11208_/A _11208_/B _11208_/C wire170/Y _11208_/E VDD VSS _11209_/C AOI221X1
X_12188_ _12188_/A _12286_/B VDD VSS _14308_/B XNOR2X1
X_19853_ _19892_/CK _19853_/D _19853_/Q VDD VSS DFFQX1
XFILLER_110_523 VDD VSS FILLER1
XFILLER_123_884 VDD VSS FILLER1
XFILLER_69_949 VDD VSS FILLER1
XFILLER_95_212 VSS VDD FILLER2
X_18804_ _19948_/CK _18804_/D _18804_/Q VDD VSS DFFQX1
X_11139_ _19961_/Q _18843_/Q VDD VSS _11143_/A XNOR2X1
X_19784_ _19830_/CK _19784_/D _19784_/Q VDD VSS DFFQX1
X_16996_ _16996_/A _16996_/B _16996_/C _16996_/D VDD VSS _17000_/B OA211X2
XFILLER_110_589 VSS VDD FILLER2
XFILLER_48_161 VDD VSS FILLER4
XFILLER_83_418 VDD VSS FILLER4
XFILLER_95_92 VDD VSS FILLER1
X_18735_ _19937_/CK _18735_/D _18735_/Q VDD VSS DFFQX1
X_15947_ _19645_/Q _16802_/B VDD VSS _15975_/B XNOR2X1
XFILLER_36_345 VSS VDD FILLER2
XFILLER_37_868 VSS VDD FILLER2
XFILLER_76_481 VDD VSS FILLER1
XTAP_TAPCELL_ROW_94_958 VDD VSS WELLTAP
X_18666_ _18801_/CK _18666_/D _18666_/Q VDD VSS DFFQX1
X_15878_ _14522_/Y _15878_/B _15878_/C VDD VSS _19486_/D AND3BX1
XFILLER_64_665 VDD VSS DECAPHV8
X_17617_ _17618_/A _17618_/B _17618_/D _17618_/C VDD VSS _17620_/C AOI211X1
X_14829_ _19503_/Q _15897_/B VDD VSS _15015_/B XOR2X1
XFILLER_91_484 VDD VSS DECAPHV8
X_18597_ _18608_/CK _18597_/D _18597_/Q VDD VSS DFFQX1
XFILLER_32_540 VDD VSS FILLER1
X_17548_ _19870_/Q _19838_/Q VDD VSS _17549_/B XOR2X1
XFILLER_32_573 VDD VSS DECAPHV8
XFILLER_60_882 VDD VSS FILLER1
X_17479_ _17629_/B _17479_/B _17479_/C VDD VSS _17484_/C MIN3X1
XFILLER_81_0 VSS VDD FILLER2
XTAP_TAPCELL_ROW_21_229 VDD VSS WELLTAP
X_19218_ _19250_/CK _19218_/D _19218_/Q VDD VSS DFFQX1
X_19149_ _19187_/CK _19149_/D _19149_/Q VDD VSS DFFQX1
XFILLER_118_667 VDD VSS FILLER4
XFILLER_117_177 VSS VDD FILLER2
XFILLER_114_840 VSS VDD FILLER2
XFILLER_132_136 VSS VDD FILLER2
XFILLER_133_659 VDD VSS DECAPHV8
XFILLER_114_862 VDD VSS FILLER4
Xfanout214 _18465_/RB VDD VSS _18373_/RB BUFX3
Xfanout203 _20065_/RB VDD VSS _20064_/RB BUFX3
X_09804_ _20080_/Q _09818_/B _09818_/C _18274_/Q _09804_/E VDD VSS _09805_/C AOI221X1
Xfanout225 _20051_/RB VDD VSS _18370_/RB BUFX3
XFILLER_86_256 VDD VSS FILLER4
XFILLER_87_779 VDD VSS DECAPHV8
XFILLER_28_802 VDD VSS DECAPHV8
XFILLER_46_109 VDD VSS FILLER4
XFILLER_74_429 VDD VSS FILLER1
XTAP_TAPCELL_ROW_29_307 VDD VSS WELLTAP
X_09735_ _18306_/Q _09812_/B _09797_/C _20207_/A VDD VSS _09737_/C AOI22X1
XFILLER_27_334 VDD VSS FILLER1
XFILLER_54_120 VDD VSS DECAPHV8
XFILLER_67_481 VDD VSS DECAPHV16
X_09666_ _09666_/A _09666_/B VDD VSS _18285_/D NAND2X1
XFILLER_42_315 VDD VSS DECAPHV8
XFILLER_54_175 VSS VDD FILLER2
XFILLER_55_698 VDD VSS FILLER1
XTAP_TAPCELL_ROW_37_384 VDD VSS WELLTAP
X_09597_ _18441_/Q _09751_/B _09772_/B _18345_/Q _09597_/E VDD VSS _09600_/C OAI221X1
XFILLER_50_370 VSS VDD FILLER2
X_10510_ _11272_/A _10510_/B VDD VSS _18557_/D NOR2X1
X_11490_ _18645_/Q _11496_/B VDD VSS _18672_/D AND2X1
XFILLER_108_100 VDD VSS FILLER4
XFILLER_7_739 VDD VSS FILLER1
X_10441_ _10441_/A _10441_/B _10441_/C _10441_/D VDD VSS _10514_/B AOAI211X1
XFILLER_40_43 VSS VDD FILLER2
XFILLER_124_626 VDD VSS FILLER1
X_10372_ _10372_/A _10372_/B _10372_/C _10372_/D VDD VSS _10399_/B AOAI211X1
X_13160_ _13212_/A _14352_/B _13212_/C VDD VSS _14353_/B OAI21X1
XFILLER_123_136 VDD VSS DECAPHV8
XFILLER_3_923 VDD VSS FILLER1
X_12111_ _19208_/Q _12111_/B _12158_/C VDD VSS _12160_/C XNOR3X1
X_13091_ _13091_/A _13091_/B _13091_/C VDD VSS _13095_/B XNOR3X1
XFILLER_105_873 VDD VSS FILLER1
XFILLER_49_30 VDD VSS DECAPHV8
X_12042_ _19179_/Q VDD VSS _12154_/A INVX1
XFILLER_104_361 VSS VDD FILLER2
XFILLER_49_63 VDD VSS FILLER1
XFILLER_78_746 VSS VDD FILLER2
X_16850_ _16859_/A _16850_/B VDD VSS _19689_/D AND2X1
XFILLER_77_278 VDD VSS FILLER1
XFILLER_92_215 VDD VSS FILLER1
X_13993_ _13993_/A _13993_/B _13993_/C _13993_/D VDD VSS _14169_/C OA211X2
X_16781_ _16793_/A _16781_/B VDD VSS _19627_/D AND2X1
X_15801_ _15817_/A VDD VSS _15816_/A BUFX3
XFILLER_18_312 VDD VSS FILLER1
XFILLER_46_621 VDD VSS FILLER1
X_12944_ _19189_/Q VDD VSS _13032_/A INVX1
X_18520_ _18520_/CK _18520_/D _18520_/Q _09316_/Y VDD VSS DFFRQX1
X_15732_ _15743_/A _15732_/B VDD VSS _19357_/D AND2X1
XTAP_TAPCELL_ROW_91_928 VDD VSS WELLTAP
X_18451_ _18455_/CK _18451_/D _18451_/Q _18455_/RB VDD VSS DFFRQX1
XFILLER_33_304 VDD VSS FILLER1
XFILLER_61_635 VDD VSS DECAPHV8
XFILLER_73_495 VDD VSS FILLER1
X_12875_ _13004_/B _12890_/C VDD VSS _14216_/B NAND2X1
X_17402_ _17400_/B _17402_/B VDD VSS _17403_/C NOR2BX1
X_15663_ _19331_/Q _15703_/B VDD VSS _15668_/A XOR2X1
X_11826_ _11874_/A _11874_/B _11874_/C VDD VSS _11869_/A OAI21X1
X_14614_ _19468_/Q VDD VSS _14616_/A INVX1
X_18382_ _18391_/CK _18515_/Q _20187_/A _20064_/RB VDD VSS DFFRQX1
X_15594_ _19382_/Q _15759_/B VDD VSS _15620_/A NAND2X1
XFILLER_42_882 VDD VSS FILLER1
X_11757_ _19116_/Q _14394_/B VDD VSS _11819_/B NOR2X1
X_14545_ _15672_/A _14545_/B VDD VSS _19250_/D NOR2X1
X_17333_ _19824_/Q _19792_/Q VDD VSS _17338_/A XNOR2X1
X_10708_ _10708_/A _10708_/B _10708_/C VDD VSS _10743_/B AO21X2
X_17264_ _19809_/Q _19777_/Q VDD VSS _17266_/B XOR2X1
X_11688_ _19987_/Q _19251_/Q VDD VSS _11706_/A NOR2X1
X_14476_ _14490_/A _14476_/B _14476_/C VDD VSS _19189_/D NOR3X1
X_19003_ _19085_/CK _19003_/D _19003_/Q VDD VSS DFFQX1
X_16215_ _16230_/A _16215_/B VDD VSS _16813_/B XOR2X1
X_10639_ _10640_/A _10687_/C VDD VSS _10639_/Y NAND2X1
X_13427_ _13427_/A _14358_/B _14358_/C VDD VSS _13601_/C NOR3X1
Xclkload127 _18359_/CK VDD VSS clkload127/Y INVX2
Xclkload116 clkload116/A VDD VSS clkload116/Y INVX6
Xclkload105 _19615_/CK VDD VSS clkload105/Y BUFX12
X_17195_ _19794_/Q _19762_/Q VDD VSS _17197_/D XNOR2X1
X_13358_ _14417_/B _14417_/C _19137_/Q VDD VSS _13432_/B AOI21X1
X_16146_ _16146_/A _16152_/B VDD VSS _16880_/B XNOR2X1
XFILLER_115_659 VSS VDD FILLER2
XFILLER_142_423 VDD VSS FILLER1
XFILLER_53_4 VDD VSS FILLER1
XTAP_TAPCELL_ROW_132_1339 VDD VSS WELLTAP
X_12309_ _19210_/Q _12391_/A _12391_/B VDD VSS _12311_/D XNOR3X1
X_16077_ _16100_/A _16077_/B VDD VSS _19521_/D NOR2X1
XFILLER_130_607 VSS VDD FILLER2
X_13289_ _13290_/A _13290_/B _13290_/D _13290_/C VDD VSS _13393_/B OAOI211X1
X_19905_ _19907_/CK _19905_/D _19905_/Q VDD VSS DFFQX1
X_15028_ _19368_/Q _15744_/B VDD VSS _15029_/B XNOR2X1
XFILLER_123_670 VDD VSS DECAPHV8
XFILLER_130_629 VDD VSS DECAPHV8
XFILLER_111_854 VDD VSS DECAPHV8
XFILLER_68_256 VDD VSS FILLER4
X_19836_ _19903_/CK _19836_/D _19836_/Q VDD VSS DFFQX1
XFILLER_56_429 VDD VSS FILLER4
X_19767_ _19830_/CK _19767_/D _19767_/Q VDD VSS DFFQX1
X_09520_ _20018_/Q _20017_/Q _20019_/Q _09520_/D VDD VSS _09521_/D AOAI211X1
Xinput3 rst_b VDD VSS input3/Y BUFX3
X_18718_ _18773_/CK _18718_/D _18718_/Q VDD VSS DFFQX1
X_16979_ _19750_/Q _17049_/B _16984_/A _16984_/B VDD VSS _16979_/Y AOI211X1
XFILLER_36_142 VDD VSS DECAPHV16
XFILLER_37_654 VDD VSS DECAPHV32
XFILLER_52_602 VSS VDD FILLER2
XFILLER_83_259 VSS VDD FILLER2
XTAP_TAPCELL_ROW_143_1446 VDD VSS WELLTAP
X_19698_ _19724_/CK _19698_/D _19698_/Q VDD VSS DFFQX1
XFILLER_51_112 VSS VDD FILLER2
XFILLER_52_635 VDD VSS FILLER1
X_09451_ _18456_/D _09468_/B _09451_/C VDD VSS _18257_/D AOI21X1
X_18649_ _19958_/CK _18649_/D _18649_/Q VDD VSS DFFQX1
XFILLER_101_49 VDD VSS FILLER1
XFILLER_40_808 VDD VSS FILLER4
X_09382_ _11435_/A _11435_/B VDD VSS _09907_/A NOR2X1
XFILLER_51_189 VDD VSS DECAPHV8
XTAP_TAPCELL_ROW_34_354 VDD VSS WELLTAP
XFILLER_20_510 VDD VSS FILLER1
XFILLER_106_615 VDD VSS FILLER4
XFILLER_134_924 VDD VSS FILLER4
XFILLER_134_946 VDD VSS FILLER4
XFILLER_105_136 VDD VSS FILLER4
XFILLER_133_456 VSS VDD FILLER2
XFILLER_0_948 VSS VDD FILLER2
XFILLER_102_821 VDD VSS FILLER1
XFILLER_113_180 VDD VSS FILLER1
XFILLER_59_223 VSS VDD FILLER2
XFILLER_87_543 VDD VSS FILLER1
XFILLER_101_375 VDD VSS DECAPHV8
XFILLER_19_109 VSS VDD FILLER2
XFILLER_47_418 VDD VSS FILLER1
XFILLER_59_256 VDD VSS DECAPHV8
XFILLER_142_34 VDD VSS FILLER1
X_09718_ _18337_/Q VDD VSS _20091_/A INVX1
XFILLER_16_816 VSS VDD FILLER2
X_10990_ _18570_/Q _10990_/B VDD VSS _10991_/B XNOR2X1
XFILLER_15_326 VDD VSS FILLER4
XFILLER_27_164 VSS VDD FILLER2
X_09649_ _09812_/C _20121_/A _09649_/C _09788_/B VDD VSS _09650_/D AOAI211X1
XFILLER_42_134 VDD VSS FILLER4
XTAP_TAPCELL_ROW_107_1087 VDD VSS WELLTAP
X_12660_ _12486_/A _14504_/B _14504_/C VDD VSS _12662_/C AND3BX1
XFILLER_24_882 VDD VSS FILLER1
XFILLER_35_98 VDD VSS FILLER1
X_11611_ _18755_/Q _11612_/B VDD VSS _18782_/D AND2X1
X_12591_ _19130_/Q _12591_/B _12643_/D VDD VSS _12732_/B XNOR3X1
X_14330_ _16273_/A VDD VSS _16726_/B BUFX3
XFILLER_11_554 VDD VSS FILLER4
XFILLER_128_228 VDD VSS FILLER4
X_11542_ _18693_/Q _11542_/B VDD VSS _18720_/D AND2X1
XFILLER_129_0 VDD VSS FILLER4
XFILLER_137_751 VDD VSS DECAPHV8
X_11473_ _18630_/Q _11473_/B VDD VSS _18657_/D AND2X1
X_14261_ _14270_/A _14261_/B VDD VSS _18999_/D AND2X1
XFILLER_109_453 VDD VSS FILLER4
XFILLER_109_464 VDD VSS FILLER1
X_10424_ _10655_/A _10499_/A _10499_/B _10424_/D VDD VSS _10738_/B AOI31X1
X_13212_ _13212_/A _14352_/B _13212_/C _13212_/D VDD VSS _13365_/A OAOI211X1
X_14192_ _14219_/A _14192_/B _14192_/C VDD VSS _18942_/D NOR3X1
X_16000_ _19615_/Q _16767_/B VDD VSS _16033_/B XNOR2X1
XFILLER_124_412 VDD VSS FILLER4
XTAP_TAPCELL_ROW_118_1194 VDD VSS WELLTAP
X_13143_ _20011_/Q _19275_/Q VDD VSS _13255_/B OR2X2
XFILLER_112_607 VDD VSS DECAPHV8
XFILLER_2_230 VSS VDD FILLER2
XFILLER_3_742 VSS VDD FILLER2
X_10355_ _18553_/Q _10357_/B _10357_/C VDD VSS _10356_/B XNOR3X1
Xclkbuf_leaf_0_sclk clkload116/A VDD VSS _18223_/CK BUFX12
XFILLER_140_949 VDD VSS FILLER1
XFILLER_2_252 VSS VDD FILLER2
XFILLER_3_775 VSS VDD FILLER2
X_10286_ _10338_/A _10338_/B _10803_/A VDD VSS _10287_/C OAI21X1
X_13074_ _18939_/Q _13086_/B _14189_/B VDD VSS _13178_/C XNOR3X1
X_17951_ _18867_/Q VDD VSS _17957_/A INVX1
XFILLER_39_908 VSS VDD FILLER2
X_12025_ _12026_/B _12026_/C _19122_/Q VDD VSS _12087_/B AOI21X1
X_17882_ _17885_/A _17885_/B VDD VSS _17884_/B XNOR2X1
X_16902_ _17990_/A _16902_/B VDD VSS _19737_/D AND2X1
XFILLER_65_204 VDD VSS DECAPHV16
X_19621_ _19737_/CK _19621_/D _19621_/Q VDD VSS DFFQX1
X_16833_ _16843_/A _16833_/B VDD VSS _19674_/D AND2X1
XFILLER_65_226 VDD VSS FILLER1
XFILLER_18_142 VDD VSS FILLER1
XFILLER_19_654 VSS VDD FILLER2
XFILLER_65_248 VDD VSS FILLER1
XTAP_TAPCELL_ROW_76_777 VDD VSS WELLTAP
X_13976_ _14118_/A _17949_/B VDD VSS _18866_/D NOR2X1
X_19552_ _19591_/CK _19552_/D _19552_/Q VDD VSS DFFQX1
X_16764_ _16775_/A _16764_/B VDD VSS _19612_/D NOR2X1
XFILLER_46_473 VSS VDD FILLER2
XFILLER_62_944 VSS VDD FILLER2
X_12927_ _14383_/B _14383_/C _19105_/Q VDD VSS _13017_/B AOI21X1
X_19483_ _19483_/CK _19483_/D _19483_/Q VDD VSS DFFQX1
X_18503_ _18503_/CK _18524_/Q _20116_/A _18503_/RB VDD VSS DFFRQX1
X_16695_ _19902_/Q _16702_/B VDD VSS _19550_/D AND2X1
X_15715_ _15739_/A _15715_/B VDD VSS _19341_/D NOR2X1
XFILLER_34_668 VSS VDD FILLER2
X_12858_ _12940_/A _12940_/C _12940_/B VDD VSS _12860_/C AO21X2
X_18434_ _18439_/CK _18498_/D _18434_/Q _20072_/RB VDD VSS DFFRQX1
X_15646_ _19357_/Q _15732_/B VDD VSS _15647_/B XOR2X1
XFILLER_15_860 VSS VDD FILLER2
XFILLER_15_871 VSS VDD FILLER2
XFILLER_61_487 VDD VSS DECAPHV8
XFILLER_92_82 VDD VSS FILLER1
X_11809_ _19146_/Q _11874_/A _11916_/B VDD VSS _11820_/B XNOR3X1
X_18365_ _18367_/CK _18365_/D _18365_/Q _18464_/RB VDD VSS DFFRQX1
XTAP_TAPCELL_ROW_31_324 VDD VSS WELLTAP
X_12789_ _12789_/A _12789_/B _12789_/C VDD VSS _14120_/B XNOR3X1
X_17316_ _19820_/Q _19788_/Q VDD VSS _17318_/D XNOR2X1
X_15577_ _19438_/Q _15823_/B VDD VSS _15599_/C XOR2X1
XFILLER_119_206 VDD VSS FILLER1
X_14528_ _14528_/A _14528_/B _15836_/C VDD VSS _19234_/D OA21X2
X_18296_ _18310_/CK _18525_/Q _18296_/Q _20072_/RB VDD VSS DFFRQX1
XFILLER_119_239 VDD VSS DECAPHV8
X_14459_ _14493_/A _14459_/B VDD VSS _19173_/D NOR2X1
X_17247_ _17245_/B _17247_/B VDD VSS _17248_/C NOR2BX1
XFILLER_116_924 VDD VSS FILLER1
X_17178_ _17178_/A _17180_/C _17178_/C VDD VSS _19790_/D AOI21X1
X_16129_ _16129_/A _16129_/B _16843_/B VDD VSS _16146_/A MIN3X1
XFILLER_142_231 VDD VSS FILLER1
XFILLER_44_0 VSS VDD FILLER2
XFILLER_131_949 VDD VSS FILLER1
XFILLER_130_437 VDD VSS FILLER4
XFILLER_130_448 VDD VSS DECAPHV16
XFILLER_97_830 VDD VSS FILLER4
XFILLER_111_662 VSS VDD FILLER2
X_19819_ _19863_/CK _19819_/D _19819_/Q VDD VSS DFFQX1
XFILLER_56_215 VDD VSS FILLER4
XFILLER_56_226 VDD VSS FILLER4
XTAP_TAPCELL_ROW_39_402 VDD VSS WELLTAP
XFILLER_84_568 VSS VDD FILLER2
XFILLER_24_101 VDD VSS DECAPHV8
XFILLER_37_462 VSS VDD FILLER2
XFILLER_52_410 VSS VDD FILLER2
X_09503_ _18499_/D _09507_/B _09506_/C _20077_/Q VDD VSS _20077_/D AO22X2
XFILLER_52_421 VDD VSS FILLER1
XTAP_TAPCELL_ROW_47_490 VDD VSS WELLTAP
X_09434_ _09446_/A _09696_/B VDD VSS _18215_/E NOR2X1
XFILLER_80_774 VDD VSS FILLER4
Xclkbuf_leaf_14__000_ clkbuf_leaf_9__000_/A VDD VSS _19703_/CK BUFX12
X_09365_ _18474_/D VDD VSS _18490_/D INVX1
XANTENNA_30 _18338_/Q VDD VSS ANTENNA2
XANTENNA_41 _18173_/A VDD VSS ANTENNA2
XFILLER_21_863 VSS VDD FILLER2
X_09296_ _09296_/A _09301_/B _09301_/A _09354_/B VDD VSS _09296_/Y AOI211X1
XFILLER_107_924 VDD VSS FILLER4
Xclkbuf_leaf_29__000_ clkload78/A VDD VSS _19385_/CK BUFX12
XFILLER_118_272 VDD VSS FILLER1
XFILLER_134_732 VSS VDD FILLER2
XFILLER_106_456 VSS VDD FILLER2
XFILLER_106_467 VDD VSS FILLER1
XFILLER_137_89 VDD VSS FILLER4
XFILLER_0_712 VDD VSS FILLER4
XFILLER_0_723 VDD VSS FILLER4
XFILLER_122_949 VDD VSS FILLER1
XFILLER_134_787 VSS VDD FILLER2
XFILLER_97_49 VDD VSS FILLER4
X_10140_ _18590_/Q VDD VSS _11367_/A INVX1
XFILLER_0_745 VSS VDD FILLER2
XFILLER_121_448 VDD VSS FILLER1
X_10071_ _10018_/B _10070_/Y _10167_/A VDD VSS _10071_/Y MUXI2X1
XFILLER_101_183 VSS VDD FILLER2
XFILLER_47_226 VSS VDD FILLER2
XTAP_TAPCELL_ROW_109_1105 VDD VSS WELLTAP
XFILLER_75_557 VDD VSS FILLER1
X_13830_ _13830_/A _13830_/B _13830_/C _13830_/D VDD VSS _13891_/B AOAI211X1
XFILLER_15_101 VDD VSS DECAPHV8
XFILLER_46_75 VSS VDD FILLER2
XFILLER_56_793 VSS VDD FILLER2
X_10973_ _19955_/Q _18837_/Q _10932_/C VDD VSS _11004_/A AOI21BX1
X_13761_ _13816_/A _13816_/B VDD VSS _14196_/C _13816_/C NAND3X1
XTAP_TAPCELL_ROW_73_747 VDD VSS WELLTAP
X_12712_ _12712_/A _12712_/B _14214_/B VDD VSS _12796_/B MIN3X1
X_16480_ _16502_/B _16480_/B VDD VSS _16787_/B XNOR2X1
X_15500_ _15674_/A _18149_/B VDD VSS _19295_/D AND2X1
XFILLER_15_167 VDD VSS DECAPHV8
X_13692_ _13840_/A _13840_/B _13692_/C VDD VSS _14263_/C OAI21X1
X_15431_ _19462_/Q VDD VSS _15469_/A INVX1
XFILLER_15_189 VDD VSS DECAPHV8
XFILLER_43_498 VDD VSS FILLER1
X_12643_ _12643_/A _12643_/B _12643_/C _12643_/D VDD VSS _12816_/B AOAI211X1
X_12574_ _12840_/A _12840_/B VDD VSS _12649_/B NOR2X1
X_18150_ _18150_/A _18150_/B _18150_/C VDD VSS _18153_/C OAI21X1
X_15362_ _19488_/Q _15881_/B VDD VSS _15364_/C XNOR2X1
XFILLER_8_856 VDD VSS DECAPHV8
X_11525_ _18677_/Q _11531_/B VDD VSS _18704_/D AND2X1
X_14313_ _14339_/A _14313_/B VDD VSS _19044_/D NOR2X1
X_18081_ _18083_/A _18083_/B _18083_/C VDD VSS _18090_/B AO21X2
X_17101_ _17390_/A _17101_/B VDD VSS _19774_/D NOR2X1
X_15293_ _19345_/Q _15293_/B _15719_/B VDD VSS _15299_/B MIN3X1
X_14244_ _14244_/A _14244_/B VDD VSS _14245_/B XNOR2X1
X_17032_ _17045_/A _17041_/A VDD VSS _17036_/C NAND2X1
XFILLER_137_592 VDD VSS DECAPHV16
X_11456_ _19949_/Q _11460_/B VDD VSS _18642_/D AND2X1
XFILLER_124_231 VDD VSS FILLER1
X_10407_ _18661_/Q _18769_/Q VDD VSS _10454_/B XOR2X1
X_11387_ _11392_/A _11387_/B _11387_/C VDD VSS _18594_/D AOI21X1
X_14175_ _14197_/A _14175_/B VDD VSS _18927_/D AND2X1
XFILLER_112_415 VSS VDD FILLER2
XFILLER_113_949 VDD VSS FILLER1
XFILLER_124_275 VDD VSS FILLER4
XFILLER_125_787 VSS VDD FILLER2
XFILLER_140_713 VDD VSS DECAPHV8
X_10338_ _10338_/A _10338_/B _10338_/C _10338_/D VDD VSS _10402_/B OAOI211X1
X_13126_ _13233_/A _14446_/B VDD VSS _14447_/C _13233_/C NAND3X1
X_18983_ _19040_/CK _18983_/D _18983_/Q VDD VSS DFFQX1
XFILLER_97_137 VDD VSS DECAPHV16
X_13057_ _19219_/Q _13240_/A _13139_/B VDD VSS _13141_/D XNOR3X1
X_17934_ _17935_/A _17935_/B _18187_/C VDD VSS _17935_/C OAI21X1
X_10269_ _11436_/C _10266_/Y _10269_/C _10269_/D VDD VSS _10346_/B AOI2BB2X1
X_12008_ _12010_/A _12010_/B _14238_/B VDD VSS _14205_/B XNOR3X1
Xclkbuf_leaf_1_clk_regs clkbuf_leaf_9_clk_regs/A VDD VSS clkload8/A BUFX12
X_17865_ _17866_/A _17866_/B _17917_/C VDD VSS _17866_/C OAI21X1
XFILLER_94_888 VDD VSS FILLER1
X_19604_ _19604_/CK _19604_/D _19604_/Q VDD VSS DFFQX1
X_17796_ _19923_/Q _19891_/Q VDD VSS _17797_/B XOR2X1
X_16816_ _16826_/A _16816_/B VDD VSS _19658_/D NOR2X1
X_13959_ _19005_/Q _14267_/B VDD VSS _14004_/A NOR2BX1
X_19535_ _19716_/CK _19535_/D _19535_/Q VDD VSS DFFQX1
X_16747_ _16748_/A _16747_/B VDD VSS _19597_/D NOR2X1
XTAP_TAPCELL_ROW_140_1416 VDD VSS WELLTAP
XFILLER_61_240 VSS VDD FILLER2
X_19466_ _19466_/CK _19466_/D _19466_/Q VDD VSS DFFQX1
X_16678_ _19929_/Q _19577_/Q VDD VSS _16679_/B XOR2X1
XTAP_TAPCELL_ROW_16_173 VDD VSS WELLTAP
XTAP_TAPCELL_ROW_44_460 VDD VSS WELLTAP
XTAP_TAPCELL_ROW_7_90 VDD VSS WELLTAP
X_19397_ _19425_/CK _19397_/D _19397_/Q VDD VSS DFFQX1
X_18417_ _18420_/CK _18465_/D _20172_/A _18452_/RB VDD VSS DFFRQX1
X_15629_ _19356_/Q _15731_/B VDD VSS _15637_/B XNOR2X1
X_18348_ _18356_/CK _18348_/D _18348_/Q _20072_/RB VDD VSS DFFRQX1
X_18279_ _18279_/CK _18279_/D _18279_/Q _09250_/Y VDD VSS DFFRQX1
XTAP_TAPCELL_ROW_0_1 VDD VSS WELLTAP
XFILLER_116_743 VSS VDD FILLER2
XFILLER_143_551 VDD VSS FILLER4
XFILLER_104_949 VDD VSS FILLER1
XFILLER_130_201 VSS VDD FILLER2
XFILLER_88_115 VDD VSS FILLER1
XFILLER_89_616 VDD VSS FILLER4
X_09983_ _10362_/D VDD VSS _11095_/C BUFX3
X_20172_ _20172_/A VDD VSS _20172_/Y BUFX3
XFILLER_123_36 VDD VSS FILLER1
XFILLER_85_866 VDD VSS FILLER1
XFILLER_38_793 VSS VDD FILLER2
XFILLER_72_527 VDD VSS FILLER4
XFILLER_84_376 VDD VSS FILLER4
XFILLER_16_45 VDD VSS FILLER1
XFILLER_52_251 VSS VDD FILLER2
XTAP_TAPCELL_ROW_104_1057 VDD VSS WELLTAP
XTAP_TAPCELL_ROW_70_717 VDD VSS WELLTAP
XFILLER_25_498 VSS VDD FILLER2
X_09417_ _20065_/Q _16908_/C VDD VSS _18201_/B NAND2X1
X_09348_ _18457_/D _09347_/Y _09302_/A VDD VSS _18510_/D MUXI2X1
XTAP_TAPCELL_ROW_3_48 VDD VSS WELLTAP
X_09279_ output6/A hold259/Y wire167/Y VDD VSS hold260/A AOI2B1X1
X_11310_ _11319_/A _11310_/B VDD VSS _11315_/B XNOR2X1
X_12290_ _12363_/A _12363_/B _12363_/C VDD VSS _12294_/B AOI21X1
XFILLER_107_743 VDD VSS FILLER1
XFILLER_134_540 VSS VDD FILLER2
X_11241_ _11241_/A _11241_/B VDD VSS _11264_/A NAND2X1
XFILLER_122_702 VDD VSS FILLER1
XTAP_TAPCELL_ROW_115_1164 VDD VSS WELLTAP
X_11172_ _11204_/A _11204_/B VDD VSS _11178_/D XOR2X1
XFILLER_0_520 VSS VDD FILLER2
XFILLER_134_595 VSS VDD FILLER2
XFILLER_79_137 VDD VSS DECAPHV16
X_10123_ _10123_/A _10123_/B _10123_/C VDD VSS _10126_/C OAI21X1
XFILLER_0_564 VDD VSS FILLER1
XFILLER_121_267 VSS VDD FILLER2
XFILLER_88_660 VDD VSS FILLER4
X_15980_ _19642_/Q _16797_/B VDD VSS _16833_/B XOR2X1
XFILLER_0_575 VDD VSS FILLER4
XFILLER_57_30 VDD VSS FILLER1
XFILLER_94_118 VDD VSS FILLER4
X_10054_ _18582_/Q _10054_/B VDD VSS _10079_/C NOR2BX1
X_14931_ _14931_/A _14931_/B _14931_/C _14931_/D VDD VSS _15805_/B AOAI211X1
XFILLER_76_877 VDD VSS FILLER4
X_17650_ _17653_/C _17651_/B _17654_/C VDD VSS _17651_/C OAI21X1
X_14862_ _14911_/A _14911_/B _14911_/C VDD VSS _14887_/A AOI21X1
XFILLER_17_922 VDD VSS FILLER1
XFILLER_91_847 VDD VSS FILLER1
XTAP_TAPCELL_ROW_86_872 VDD VSS WELLTAP
X_13813_ _14196_/B _14196_/C _18946_/Q VDD VSS _13818_/B AOI21X1
X_17581_ _17581_/A _17581_/B _17581_/C VDD VSS _17589_/A OA21X2
X_16601_ _19925_/Q VDD VSS _16722_/A INVX1
XFILLER_16_421 VDD VSS FILLER4
XFILLER_28_292 VDD VSS FILLER4
XFILLER_90_346 VSS VDD FILLER2
XTAP_TAPCELL_ROW_126_1271 VDD VSS WELLTAP
XTAP_TAPCELL_ROW_58_596 VDD VSS WELLTAP
X_19320_ _19322_/CK _19320_/D _19320_/Q VDD VSS DFFQX1
Xclkbuf_leaf_9__002_ clkbuf_leaf_9__002_/A VDD VSS _19947_/CK BUFX12
X_16532_ _16546_/B _16532_/B VDD VSS _16825_/B XNOR2X1
X_14793_ _19475_/Q _15866_/B VDD VSS _14865_/B XNOR2X1
XFILLER_73_62 VDD VSS FILLER1
X_10956_ _18569_/Q VDD VSS _10957_/A INVX1
X_13744_ _13872_/A _17920_/B _17921_/C VDD VSS _17925_/C OR3BX1
X_10887_ _18567_/Q _10887_/B VDD VSS _10888_/A NAND2X1
X_13675_ _13675_/A _13675_/B _13675_/C _13675_/D VDD VSS _13816_/B AOAI211X1
X_19251_ _19988_/CK _19251_/D _19251_/Q VDD VSS DFFQX1
X_16463_ _19728_/Q _16892_/B VDD VSS _16465_/B XNOR2X1
XFILLER_31_468 VSS VDD FILLER2
XTAP_TAPCELL_ROW_41_430 VDD VSS WELLTAP
X_12626_ _19073_/Q _14346_/B _14346_/C VDD VSS _12630_/D OR3BX1
X_19182_ _19182_/CK _19182_/D _19182_/Q VDD VSS DFFQX1
X_18202_ _18228_/E _18202_/B _18202_/C VDD VSS _18202_/Y OR3BX1
X_16394_ _19565_/Q VDD VSS _16395_/A INVX1
X_15414_ _19349_/Q _15723_/B VDD VSS _15456_/C NAND2X1
XFILLER_12_682 VSS VDD FILLER2
XTAP_TAPCELL_ROW_13_143 VDD VSS WELLTAP
X_18133_ _19292_/Q _18133_/B VDD VSS _18136_/A NOR2BX1
X_15345_ _19403_/Q _15345_/B _15345_/C VDD VSS _15389_/A MIN3X1
XFILLER_129_378 VDD VSS FILLER1
X_12557_ _12557_/A _14378_/B _14378_/C VDD VSS _12558_/D NOR3X1
XFILLER_144_326 VDD VSS FILLER4
XFILLER_8_675 VSS VDD FILLER2
X_11508_ _18662_/Q _11508_/B VDD VSS _18689_/D AND2X1
X_12488_ _19239_/Q _14533_/B VDD VSS _12571_/A NAND2X1
X_18064_ _18064_/A _18064_/B _18064_/C VDD VSS _18069_/A OAI21X1
X_15276_ _19512_/Q _15276_/B VDD VSS _15311_/B NOR2X1
XFILLER_144_359 VDD VSS FILLER1
X_11439_ _232_/E _11439_/B VDD VSS _18628_/D NOR2X1
X_14227_ _14294_/A _14227_/B _14227_/C VDD VSS _18972_/D NOR3X1
X_17015_ _19758_/Q VDD VSS _17180_/B INVX1
XFILLER_113_702 VDD VSS DECAPHV8
XFILLER_140_510 VDD VSS FILLER1
X_14158_ _14158_/A _14158_/B VDD VSS _18913_/D AND2X1
X_18209__254 _18259_/CK VDD VSS _18276_/CK INVX1
XFILLER_98_457 VDD VSS FILLER1
X_13109_ _14446_/B _14446_/C _19162_/Q VDD VSS _13111_/C AOI21X1
X_14089_ _14089_/A _14139_/B _14089_/C _14089_/D VDD VSS _14104_/B AOAI211X1
Xclkbuf_leaf_13__001_ clkload41/A VDD VSS _19171_/CK BUFX12
X_18966_ _18970_/CK _18966_/D _18966_/Q VDD VSS DFFQX1
XFILLER_39_513 VSS VDD FILLER2
X_18897_ _19171_/CK _18897_/D _18897_/Q VDD VSS DFFQX1
X_17917_ _17919_/C _17918_/B _17917_/C VDD VSS _17918_/C OAI21X1
XFILLER_39_546 VDD VSS FILLER4
XFILLER_67_855 VDD VSS DECAPHV16
X_17848_ _18848_/Q VDD VSS _17853_/A INVX1
XFILLER_54_505 VDD VSS FILLER4
XFILLER_19_270 VDD VSS FILLER4
XFILLER_54_549 VDD VSS FILLER4
XFILLER_93_184 VSS VDD FILLER2
Xclkbuf_leaf_28__001_ clkbuf_2_1__f__001_/Y VDD VSS _19050_/CK BUFX12
X_17779_ _17806_/A _17779_/B VDD VSS _19919_/D NOR2X1
X_19518_ _19533_/CK _19518_/D _19518_/Q VDD VSS DFFQX1
X_19449_ _19489_/CK _19449_/D _19449_/Q VDD VSS DFFQX1
X_09202_ _18525_/Q VDD VSS _18440_/D INVX1
XFILLER_30_490 VDD VSS FILLER1
XFILLER_118_14 VSS VDD FILLER2
XFILLER_135_315 VDD VSS FILLER1
XFILLER_135_359 VDD VSS FILLER1
XFILLER_2_807 VSS VDD FILLER2
X_20224_ _20224_/A VDD VSS _20224_/Y BUFX3
XFILLER_131_532 VSS VDD FILLER2
XFILLER_104_779 VDD VSS DECAPHV8
XFILLER_131_554 VDD VSS FILLER4
XFILLER_76_107 VDD VSS DECAPHV16
XFILLER_89_468 VDD VSS DECAPHV8
X_20155_ _20155_/A VDD VSS _20155_/Y BUFX3
XFILLER_100_930 VDD VSS FILLER1
XFILLER_103_278 VDD VSS FILLER1
X_09897_ _09869_/Y _09871_/Y _10966_/A VDD VSS _09897_/Y MUX2X1
X_20086_ _20086_/A VDD VSS _20086_/Y BUFX3
XFILLER_58_855 VDD VSS FILLER4
XFILLER_17_218 VSS VDD FILLER2
XFILLER_73_836 VDD VSS FILLER1
XTAP_TAPCELL_ROW_83_842 VDD VSS WELLTAP
XFILLER_72_379 VSS VDD FILLER2
XTAP_TAPCELL_ROW_55_566 VDD VSS WELLTAP
X_10810_ _10502_/B _10809_/Y _11120_/A VDD VSS _10816_/C MUXI2X1
X_11790_ _19117_/Q _11790_/B _11790_/C VDD VSS _11865_/B MIN3X1
Xclkbuf_1_0__f__09180_ clkbuf_0__09180_/Y VDD VSS _18628_/CK BUFX12
X_10741_ _18563_/Q _10743_/B _10743_/C VDD VSS _10742_/B XNOR3X1
XFILLER_13_446 VSS VDD FILLER2
XFILLER_40_243 VSS VDD FILLER2
X_13460_ _19195_/Q VDD VSS _13559_/C INVX1
XFILLER_40_254 VSS VDD FILLER2
X_10672_ _10709_/A _10709_/B _11127_/A VDD VSS _10703_/A OAI21X1
X_12411_ _20004_/Q _19268_/Q VDD VSS _12583_/A AND2X1
XTAP_TAPCELL_ROW_10_113 VDD VSS WELLTAP
X_13391_ _13391_/A _13391_/B _13391_/C _13391_/D VDD VSS _13516_/B AOAI211X1
X_12342_ _18931_/Q _14179_/B _12353_/C VDD VSS _14147_/B XNOR3X1
X_15130_ _15297_/A _18100_/B VDD VSS _19286_/D AND2X1
XFILLER_111_0 VSS VDD FILLER2
XFILLER_5_645 VSS VDD FILLER2
X_12273_ _18930_/Q VDD VSS _12341_/A INVX1
X_15061_ _19535_/Q _15146_/C VDD VSS _15902_/B XNOR2X1
XFILLER_135_860 VSS VDD FILLER2
X_11224_ _18683_/Q _18791_/Q _11224_/C VDD VSS _11226_/B MIN3X1
X_14012_ _14268_/A _14268_/B _19006_/Q VDD VSS _14013_/D OAI21X1
XFILLER_110_716 VSS VDD FILLER2
XFILLER_1_840 VDD VSS FILLER4
XFILLER_68_40 VDD VSS FILLER4
XFILLER_96_917 VDD VSS DECAPHV8
X_11155_ _18575_/Q _11158_/C VDD VSS _11156_/B XNOR2X1
X_18820_ _18820_/CK _18820_/D _18820_/Q VDD VSS DFFQX1
X_10106_ _10059_/B _10105_/Y _10167_/A VDD VSS _10191_/B MUXI2X1
X_11086_ _11086_/A _11086_/B _11086_/C VDD VSS _11088_/C AOI21X1
X_18751_ _18779_/CK _18751_/D _18751_/Q VDD VSS DFFQX1
X_15963_ _15963_/A _19901_/Q _15963_/C VDD VSS _15965_/A MIN3X1
XFILLER_48_321 VDD VSS FILLER4
XFILLER_49_866 VSS VDD FILLER2
XTAP_TAPCELL_ROW_128_1300 VDD VSS WELLTAP
X_10037_ _18603_/Q _10050_/C VDD VSS _10038_/B XNOR2X1
X_17702_ _17700_/B _17702_/B VDD VSS _17703_/C NOR2BX1
X_14914_ _14920_/A _15833_/B _14920_/C VDD VSS _15834_/C OR3X2
XFILLER_76_696 VDD VSS FILLER1
XFILLER_91_600 VDD VSS FILLER4
X_18682_ _18817_/CK _18682_/D _18682_/Q VDD VSS DFFQX1
X_15894_ _15895_/A _15894_/B VDD VSS _19501_/D NOR2X1
XFILLER_91_633 VDD VSS DECAPHV8
X_17633_ _19888_/Q _19856_/Q VDD VSS _17638_/A XNOR2X1
X_14845_ _14858_/B _14845_/B VDD VSS _15739_/B XNOR2X1
XFILLER_32_700 VSS VDD FILLER2
X_11988_ _11988_/A _12055_/B VDD VSS _14527_/B XNOR2X1
X_17564_ _17567_/C _17565_/B _17597_/C VDD VSS _17565_/C OAI21X1
X_14776_ _14776_/A _14776_/B _15830_/B VDD VSS _14818_/A MIN3X1
XFILLER_72_880 VSS VDD FILLER2
X_10939_ _10940_/A _10940_/B _10940_/D _10940_/C VDD VSS _10942_/C AOAI211X1
X_13727_ _13727_/A _14326_/B _13728_/C VDD VSS _14327_/B AOI21BX1
X_19303_ _19304_/CK _19303_/D _19303_/Q VDD VSS DFFQX1
X_16515_ _16511_/B _16515_/B _16515_/C VDD VSS _16540_/A AOI2B1X1
X_19234_ _19234_/CK _19234_/D _19234_/Q VDD VSS DFFQX1
X_17495_ _17496_/A _17496_/B _17496_/D _17496_/C VDD VSS _17498_/C AOI211X1
X_13658_ _13672_/A _13748_/B _13746_/C VDD VSS _13807_/B XNOR3X1
X_16446_ _19631_/Q _16785_/B VDD VSS _16447_/A NAND2BX1
X_12609_ _18905_/Q _12609_/B _14149_/B VDD VSS _14117_/B XNOR3X1
X_13589_ _13656_/A _13656_/B _13656_/E _13589_/D VDD VSS _14162_/C OAOI211X1
X_19165_ _19194_/CK _19165_/D _19165_/Q VDD VSS DFFQX1
X_16377_ _16392_/B _16377_/B VDD VSS _16819_/B XOR2X1
X_19096_ _19096_/CK _19096_/D _19096_/Q VDD VSS DFFQX1
X_18116_ _18163_/A _18121_/B VDD VSS _18116_/Y NOR2X1
X_15328_ _19403_/Q _15784_/B VDD VSS _15329_/B XOR2X1
XFILLER_69_2 VDD VSS FILLER1
X_18047_ _18056_/A _18047_/B _18056_/C VDD VSS _19981_/D OAI21X1
X_15259_ _19317_/Q _15259_/B _15259_/C VDD VSS _15335_/A MIN3X1
XFILLER_144_178 VSS VDD FILLER2
XFILLER_113_521 VDD VSS FILLER1
XFILLER_141_830 VSS VDD FILLER2
XFILLER_140_351 VSS VDD FILLER2
XFILLER_99_788 VDD VSS DECAPHV16
X_09820_ _17906_/C VDD VSS _14522_/A BUFX3
X_19998_ _19999_/CK _19998_/D _19998_/Q VDD VSS DFFQX1
XFILLER_141_896 VSS VDD FILLER2
XFILLER_86_427 VDD VSS FILLER1
X_09751_ _18451_/Q _09751_/B _09751_/C _09751_/D VDD VSS _09754_/C OAI211X1
Xclkbuf_0__09174_ _18223_/ECK VDD VSS clkbuf_0__09174_/Y BUFX12
X_18949_ _18950_/CK _18949_/D _18949_/Q VDD VSS DFFQX1
XFILLER_39_321 VDD VSS DECAPHV16
XFILLER_55_803 VSS VDD FILLER2
XTAP_TAPCELL_ROW_97_989 VDD VSS WELLTAP
X_09682_ _09753_/D _09682_/B _09682_/C _09819_/A _09682_/E VDD VSS _18286_/D OAI221X1
XFILLER_54_324 VDD VSS FILLER1
XFILLER_55_869 VDD VSS DECAPHV16
XFILLER_81_110 VDD VSS FILLER1
XFILLER_23_700 VDD VSS FILLER1
XFILLER_82_677 VDD VSS FILLER1
XFILLER_70_839 VDD VSS FILLER4
XTAP_TAPCELL_ROW_80_812 VDD VSS WELLTAP
XFILLER_23_755 VSS VDD FILLER2
XFILLER_62_390 VDD VSS DECAPHV8
XFILLER_80_19 VDD VSS FILLER4
XTAP_TAPCELL_ROW_101_1027 VDD VSS WELLTAP
XTAP_TAPCELL_ROW_52_536 VDD VSS WELLTAP
XFILLER_129_46 VSS VDD FILLER2
XFILLER_117_860 VDD VSS DECAPHV8
XFILLER_117_882 VDD VSS DECAPHV8
XFILLER_132_841 VSS VDD FILLER2
XFILLER_135_189 VDD VSS DECAPHV16
XFILLER_144_690 VDD VSS DECAPHV8
XFILLER_8_6 VDD VSS FILLER1
XTAP_TAPCELL_ROW_0_16 VDD VSS WELLTAP
Xmax_cap180 _18524_/Q VDD VSS _18471_/D BUFX12
XFILLER_131_351 VDD VSS DECAPHV16
XFILLER_78_928 VDD VSS FILLER1
XFILLER_89_254 VDD VSS DECAPHV8
XTAP_TAPCELL_ROW_112_1134 VDD VSS WELLTAP
X_20207_ _20207_/A VDD VSS _20207_/Y BUFX3
XFILLER_77_427 VDD VSS FILLER4
XFILLER_89_298 VDD VSS FILLER1
X_09949_ _09867_/Y _09948_/Y _11178_/C VDD VSS _09949_/Y MUX2X1
X_20138_ _20138_/A VDD VSS _20138_/Y BUFX3
Xclkbuf_regs_1_sclk delaybuf_4_sclk/Y VDD VSS clkbuf_regs_1_sclk/Y BUFX12
XFILLER_38_65 VDD VSS DECAPHV8
X_12960_ _13255_/A _13150_/B VDD VSS _13047_/C AND2X1
X_20069_ clkload6/A _20069_/D _20069_/Q _20069_/RB VDD VSS DFFRQX1
XFILLER_45_324 VSS VDD FILLER2
XFILLER_73_633 VDD VSS FILLER1
XTAP_TAPCELL_ROW_68_691 VDD VSS WELLTAP
X_11911_ _11912_/B _11912_/C _19148_/Q VDD VSS _11973_/B AOI21X1
X_12891_ _12891_/A _12891_/B _12891_/C VDD VSS _13171_/A OA21X2
XFILLER_61_828 VDD VSS FILLER1
X_11842_ _19994_/Q _19258_/Q VDD VSS _11881_/B NAND2X1
X_14630_ _19470_/Q _14671_/B _14671_/C VDD VSS _14640_/C XNOR3X1
XFILLER_14_700 VDD VSS DECAPHV8
XFILLER_54_42 VDD VSS FILLER4
XFILLER_60_338 VDD VSS DECAPHV8
XFILLER_72_187 VSS VDD FILLER2
XTAP_TAPCELL_ROW_123_1241 VDD VSS WELLTAP
X_14561_ _20000_/Q _14569_/B VDD VSS _19264_/D AND2X1
X_11773_ _11778_/A _11778_/B _11778_/D _11778_/C VDD VSS _14521_/C OAI211X1
X_13512_ _14260_/B _14260_/C _18998_/Q VDD VSS _13594_/B AO21X2
X_16300_ _19722_/Q _16886_/B VDD VSS _16302_/C XNOR2X1
X_10724_ _10725_/A _10725_/C _10725_/B VDD VSS _10749_/B AO21X2
X_14492_ _14491_/Y _14492_/B _14492_/C VDD VSS _19203_/D AND3BX1
X_17280_ _19812_/Q _19780_/Q VDD VSS _17281_/C NAND2X1
XFILLER_139_440 VDD VSS FILLER1
XFILLER_70_30 VSS VDD FILLER2
XFILLER_70_41 VDD VSS FILLER1
X_10655_ _10655_/A VDD VSS _10947_/A BUFX3
X_13443_ _13443_/A _13443_/B _13443_/C _13443_/D VDD VSS _13459_/B AOAI211X1
Xclkbuf_leaf_12__002_ clkbuf_leaf_9__002_/A VDD VSS _18809_/CK BUFX12
X_16231_ _19623_/Q _16231_/B _16777_/B VDD VSS _16255_/B MIN3X1
XFILLER_139_473 VDD VSS FILLER4
X_13374_ _13509_/A _13509_/C VDD VSS _13375_/C NAND2X1
Xclkload17 clkload17/A VDD VSS clkload17/Y INVX14
X_16162_ _19589_/Q _16739_/B VDD VSS _16182_/B XNOR2X1
X_10586_ _10625_/A _10880_/B _10586_/C VDD VSS _10596_/B AOI21X1
X_12325_ _19239_/Q _12577_/A _12499_/B VDD VSS _12391_/D XNOR3X1
Xclkload39 _18782_/CK VDD VSS clkload39/Y INVX4
Xclkload28 _18820_/CK VDD VSS clkload28/Y INVX6
X_15113_ _15198_/B _15840_/B _19454_/Q VDD VSS _15139_/D NAND3BX1
XFILLER_119_90 VSS VDD FILLER2
X_16093_ _16108_/B _16093_/B VDD VSS _16807_/B XNOR2X1
XFILLER_141_115 VDD VSS FILLER1
X_12256_ _19096_/Q _14373_/B VDD VSS _12257_/C _14373_/C AND3X2
X_19921_ clkload7/A _19921_/D _19921_/Q VDD VSS DFFQX1
X_15044_ _15044_/A _15807_/B VDD VSS _15069_/A OR2X2
XFILLER_141_148 VDD VSS FILLER1
X_11207_ _11229_/A _11207_/B VDD VSS _11208_/E NOR2X1
X_12187_ _19040_/Q VDD VSS _12189_/A INVX1
X_19852_ _19892_/CK _19852_/D _19852_/Q VDD VSS DFFQX1
XFILLER_110_502 VSS VDD FILLER2
X_11138_ _11138_/A _11138_/B _11229_/A VDD VSS _11144_/B AOI21X1
X_18803_ _19948_/CK _18803_/D _18803_/Q VDD VSS DFFQX1
X_19783_ _19833_/CK _19783_/D _19783_/Q VDD VSS DFFQX1
X_16995_ _19752_/Q _19753_/Q _17011_/B VDD VSS _16996_/C OAI21X1
XFILLER_0_191 VSS VDD FILLER2
XFILLER_64_611 VSS VDD FILLER2
XFILLER_76_460 VDD VSS FILLER1
XFILLER_76_471 VDD VSS DECAPHV8
XFILLER_95_82 VDD VSS DECAPHV8
X_11069_ _19959_/Q _18841_/Q VDD VSS _11072_/A XNOR2X1
X_18734_ _19937_/CK _18734_/D _18734_/Q VDD VSS DFFQX1
X_15946_ _15969_/A _15946_/B VDD VSS _16802_/B XNOR2X1
XFILLER_36_324 VDD VSS FILLER1
XTAP_TAPCELL_ROW_94_959 VDD VSS WELLTAP
X_18665_ _18773_/CK _18665_/D _18665_/Q VDD VSS DFFQX1
X_15877_ _15879_/A _15877_/B VDD VSS _19485_/D AND2X1
XFILLER_24_508 VSS VDD FILLER2
X_17616_ _19884_/Q _19852_/Q VDD VSS _17618_/D XNOR2X1
X_14828_ _19530_/Q _14828_/B VDD VSS _15897_/B XOR2X1
XFILLER_45_891 VDD VSS FILLER1
XFILLER_91_496 VDD VSS FILLER1
X_18596_ _18608_/CK _18596_/D _18596_/Q VDD VSS DFFQX1
X_17547_ _19869_/Q _19837_/Q _17547_/C VDD VSS _17551_/B AOI21X1
X_14759_ _14759_/A _14772_/C VDD VSS _15737_/B XNOR2X1
XFILLER_60_872 VDD VSS DECAPHV8
X_17478_ _19854_/Q VDD VSS _17629_/B INVX1
X_19217_ _20006_/CK _19217_/D _19217_/Q VDD VSS DFFQX1
X_16429_ _16429_/A _16429_/B _16429_/C VDD VSS _16430_/B NOR3X1
XFILLER_74_0 VSS VDD FILLER2
X_19148_ _19187_/CK _19148_/D _19148_/Q VDD VSS DFFQX1
XFILLER_117_112 VSS VDD FILLER2
XFILLER_133_627 VDD VSS FILLER4
X_19079_ _19121_/CK _19079_/D _19079_/Q VDD VSS DFFQX1
XFILLER_117_189 VSS VDD FILLER2
XFILLER_99_530 VDD VSS FILLER4
Xfanout204 _20051_/RB VDD VSS _20065_/RB BUFX3
XFILLER_113_362 VDD VSS FILLER4
XFILLER_87_747 VDD VSS DECAPHV32
X_09803_ _09803_/A _09803_/B _09802_/Y VDD VSS _09804_/E AOI21BX1
Xfanout226 input3/Y VDD VSS _20051_/RB BUFX3
Xfanout215 _18370_/RB VDD VSS _18465_/RB BUFX3
XFILLER_140_181 VDD VSS FILLER4
XFILLER_59_449 VDD VSS DECAPHV8
XFILLER_86_235 VDD VSS DECAPHV8
XFILLER_27_302 VSS VDD FILLER2
XFILLER_28_814 VSS VDD FILLER2
XTAP_TAPCELL_ROW_29_308 VDD VSS WELLTAP
X_09734_ _18450_/Q VDD VSS _20162_/A INVX1
X_09665_ _18236_/Q _09818_/B _09818_/C _18265_/Q _09665_/E VDD VSS _09666_/B AOI221X1
XFILLER_131_47 VDD VSS FILLER1
XTAP_TAPCELL_ROW_65_661 VDD VSS WELLTAP
X_09596_ _20164_/A _09784_/C _09815_/C _18313_/Q VDD VSS _09597_/E AOI22X1
XTAP_TAPCELL_ROW_37_385 VDD VSS WELLTAP
XFILLER_51_872 VDD VSS DECAPHV8
XFILLER_11_747 VDD VSS DECAPHV8
XFILLER_50_393 VSS VDD FILLER2
XFILLER_10_235 VDD VSS DECAPHV8
XFILLER_10_257 VDD VSS FILLER1
XFILLER_137_933 VDD VSS DECAPHV16
XFILLER_7_729 VDD VSS DECAPHV8
X_10440_ _10476_/D VDD VSS _10441_/D INVX1
XFILLER_136_454 VDD VSS DECAPHV8
X_10371_ _18632_/Q _18794_/Q VDD VSS _10399_/A NAND2X1
X_12110_ _12222_/A _12236_/A _12233_/C VDD VSS _12158_/C XNOR3X1
X_13090_ _13192_/A _13192_/B _13192_/C VDD VSS _13168_/B AOI21X1
X_12041_ _12155_/A _14433_/B VDD VSS _12060_/B NOR2X1
Xclkbuf_2_2__f__001_ clkbuf_0__001_/Y VDD VSS clkload41/A BUFX12
XFILLER_19_814 VDD VSS FILLER1
X_13992_ _13993_/A _13993_/B _13993_/D _13993_/C VDD VSS _14169_/B OAOI211X1
X_16780_ _16794_/A _16780_/B VDD VSS _19626_/D NOR2X1
X_15800_ _15800_/A _15800_/B VDD VSS _19418_/D NOR2X1
XFILLER_18_324 VDD VSS FILLER1
XFILLER_58_471 VDD VSS FILLER1
XFILLER_65_30 VDD VSS DECAPHV8
XFILLER_86_780 VDD VSS FILLER4
X_12943_ _13041_/A _14413_/B VDD VSS _12973_/B NOR2X1
X_15731_ _15739_/A _15731_/B VDD VSS _19356_/D NOR2X1
XFILLER_18_346 VDD VSS FILLER4
XFILLER_18_357 VSS VDD FILLER2
XFILLER_46_666 VSS VDD FILLER2
XFILLER_73_441 VDD VSS DECAPHV16
X_18450_ _18455_/CK _18450_/D _18450_/Q _18455_/RB VDD VSS DFFRQX1
XFILLER_65_96 VDD VSS FILLER4
XTAP_TAPCELL_ROW_91_929 VDD VSS WELLTAP
X_12874_ _12903_/A _12903_/B _12903_/D _12903_/C VDD VSS _12890_/C AOAI211X1
X_17401_ _17675_/A _17401_/B VDD VSS _19838_/D NOR2X1
X_15662_ _19358_/Q _15733_/B _15662_/C VDD VSS _15703_/B MIN3X1
XFILLER_60_146 VSS VDD FILLER2
X_11825_ _19174_/Q _14460_/B VDD VSS _11874_/C _14460_/C NAND3X1
X_14613_ _19441_/Q _14613_/B _14613_/C VDD VSS _14672_/B MIN3X1
X_18381_ _18390_/CK _18477_/D _20186_/A _20064_/RB VDD VSS DFFRQX1
X_15593_ _19354_/Q _15729_/B _15593_/C VDD VSS _15617_/A AOI21X1
XFILLER_121_91 VSS VDD FILLER2
XFILLER_42_872 VDD VSS FILLER4
X_11756_ _11758_/A _11758_/B _14426_/B VDD VSS _14394_/B XNOR3X1
X_14544_ _14544_/A _14544_/B _15836_/C VDD VSS _19249_/D OA21X2
X_17332_ _17334_/C _17332_/B _17332_/C VDD VSS _19823_/D AOI21X1
X_10707_ _18562_/Q _10707_/B VDD VSS _10708_/C AND2X1
X_14475_ _14490_/A _14475_/B _14475_/C VDD VSS _19188_/D NOR3X1
X_17263_ _17413_/B _17263_/B _17263_/C VDD VSS _17267_/C MIN3X1
X_11687_ _19144_/Q VDD VSS _11758_/A INVX1
X_13426_ _13437_/A _13437_/B _13437_/C VDD VSS _14358_/C NOR3X1
X_19002_ _19004_/CK _19002_/D _19002_/Q VDD VSS DFFQX1
X_16214_ _19623_/Q _16777_/B VDD VSS _16215_/B XNOR2X1
XFILLER_127_432 VDD VSS FILLER1
X_10638_ _10638_/A _10638_/B _10638_/C _10638_/D VDD VSS _10687_/C AOI31X1
Xclkload128 _18367_/CK VDD VSS clkload128/Y INVX2
Xclkload117 _20054_/CK VDD VSS clkload117/Y INVX8
Xclkload106 _19678_/CK VDD VSS clkload106/Y INVX1
X_17194_ _17197_/A _17194_/B _17194_/C VDD VSS _19793_/D AOI21X1
XFILLER_115_616 VDD VSS FILLER1
XFILLER_142_402 VDD VSS FILLER1
XFILLER_6_740 VDD VSS DECAPHV8
X_10569_ _10570_/A _10570_/B _10570_/D _10570_/C VDD VSS _10638_/B AOAI211X1
X_13357_ _13430_/A _13430_/B VDD VSS _14417_/C _13430_/C NAND3X1
X_16145_ _19684_/Q _16845_/B VDD VSS _16152_/B XNOR2X1
X_12308_ _12471_/A _12471_/B _12471_/C VDD VSS _12333_/B AOI21X1
X_13288_ _18885_/Q _13288_/B _13288_/C VDD VSS _13486_/B MIN3X1
X_16076_ _16076_/A _16079_/B VDD VSS _16077_/B XOR2X1
XFILLER_46_4 VDD VSS FILLER1
X_12239_ _12239_/A _14499_/B _12239_/C _12239_/D VDD VSS _12391_/B AOAI211X1
X_19904_ _19907_/CK _19904_/D _19904_/Q VDD VSS DFFQX1
X_15027_ _15041_/A _15041_/B VDD VSS _15744_/B XNOR2X1
XFILLER_96_500 VSS VDD FILLER2
XFILLER_96_522 VSS VDD FILLER2
XFILLER_122_181 VDD VSS FILLER1
XFILLER_68_235 VDD VSS DECAPHV8
XFILLER_69_747 VDD VSS DECAPHV8
X_19835_ clkload4/A _19835_/D _19835_/Q VDD VSS DFFQX1
X_19766_ _19828_/CK _19766_/D _19766_/Q VDD VSS DFFQX1
X_16978_ _19751_/Q _16978_/B VDD VSS _16984_/B XOR2X1
XFILLER_77_780 VSS VDD FILLER2
XFILLER_83_238 VDD VSS FILLER1
Xinput4 input4/A VDD VSS input4/Y BUFX3
X_18717_ _18773_/CK _18717_/D _18717_/Q VDD VSS DFFQX1
X_15929_ _15929_/A _15929_/B VDD VSS _16763_/B XNOR2X1
X_09450_ _19965_/Q _09467_/B _09483_/B VDD VSS _09451_/C AOI21X1
X_19697_ _19724_/CK _19697_/D _19697_/Q VDD VSS DFFQX1
XTAP_TAPCELL_ROW_143_1447 VDD VSS WELLTAP
X_18648_ _19958_/CK _18648_/D _18648_/Q VDD VSS DFFQX1
XFILLER_51_146 VSS VDD FILLER2
XTAP_TAPCELL_ROW_62_631 VDD VSS WELLTAP
X_09381_ _18624_/Q _18623_/Q VDD VSS _10274_/B NOR2BX1
X_18579_ _18582_/CK _18579_/D _18579_/Q VDD VSS DFFQX1
XFILLER_33_872 VSS VDD FILLER2
XFILLER_51_179 VSS VDD FILLER2
XTAP_TAPCELL_ROW_34_355 VDD VSS WELLTAP
XFILLER_60_691 VDD VSS FILLER1
XFILLER_118_421 VDD VSS FILLER1
XFILLER_118_465 VSS VDD FILLER2
XFILLER_118_476 VDD VSS DECAPHV8
XFILLER_120_118 VDD VSS FILLER4
XFILLER_121_619 VDD VSS FILLER1
XFILLER_19_12 VDD VSS DECAPHV8
XFILLER_87_555 VSS VDD FILLER2
XFILLER_102_888 VDD VSS FILLER1
XFILLER_19_45 VDD VSS DECAPHV8
XFILLER_19_67 VSS VDD FILLER2
XFILLER_19_78 VDD VSS FILLER1
XFILLER_19_89 VDD VSS FILLER4
XFILLER_28_622 VDD VSS DECAPHV16
XFILLER_74_227 VDD VSS FILLER4
X_09717_ _09776_/A _09717_/B _09717_/C _09717_/D VDD VSS _18288_/D OAI211X1
XFILLER_43_625 VDD VSS FILLER4
X_09648_ _20105_/A _09812_/C VDD VSS _09649_/C NOR2BX1
XFILLER_42_113 VDD VSS FILLER1
XFILLER_43_669 VSS VDD FILLER2
XTAP_TAPCELL_ROW_107_1088 VDD VSS WELLTAP
X_09579_ _09797_/B VDD VSS _09812_/B BUFX3
XTAP_TAPCELL_ROW_120_1211 VDD VSS WELLTAP
X_11610_ _18754_/Q _11612_/B VDD VSS _18781_/D AND2X1
X_12590_ _19158_/Q _12771_/A _12655_/C VDD VSS _12643_/D XNOR3X1
XFILLER_11_500 VDD VSS DECAPHV8
XFILLER_51_691 VDD VSS DECAPHV8
XFILLER_70_499 VDD VSS DECAPHV8
X_11541_ _18692_/Q _11542_/B VDD VSS _18719_/D AND2X1
XFILLER_50_190 VDD VSS FILLER1
XFILLER_109_410 VSS VDD FILLER2
XFILLER_109_432 VSS VDD FILLER2
XFILLER_11_588 VDD VSS FILLER1
XFILLER_51_87 VDD VSS FILLER1
X_11472_ _19963_/Q _11473_/B VDD VSS _18656_/D AND2X1
X_14260_ _14255_/Y _14260_/B _14260_/C VDD VSS _18998_/D AND3BX1
X_10423_ _10655_/A _10500_/B VDD VSS _10424_/D NOR2X1
X_13211_ _13211_/A _14385_/B _14385_/C VDD VSS _13212_/D NOR3X1
X_14191_ _14197_/A _14191_/B VDD VSS _18941_/D AND2X1
XFILLER_109_476 VSS VDD FILLER2
XFILLER_109_487 VDD VSS FILLER4
XFILLER_3_710 VDD VSS FILLER1
XTAP_TAPCELL_ROW_118_1195 VDD VSS WELLTAP
X_10354_ _10427_/C _10354_/B VDD VSS _10357_/C XOR2X1
X_13142_ _13329_/A _13329_/B VDD VSS _13155_/B NAND2X1
Xdelaybuf_5_clk delaybuf_5_clk/A VDD VSS delaybuf_6_clk/A BUFX12
XFILLER_140_906 VDD VSS FILLER1
XFILLER_98_809 VSS VDD FILLER2
XFILLER_112_619 VDD VSS FILLER1
XFILLER_140_939 VDD VSS DECAPHV8
X_10285_ _18631_/Q _18793_/Q VDD VSS _10338_/B XNOR2X1
X_13073_ _13083_/A _13083_/B VDD VSS _14189_/B XOR2X1
X_17950_ _17958_/A _17958_/B VDD VSS _17955_/A OR2X2
X_12024_ _19094_/Q _12024_/B _12079_/C VDD VSS _12255_/B MIN3X1
X_17881_ _18854_/Q VDD VSS _17885_/A INVX1
X_16901_ _16976_/A _16901_/B VDD VSS _19736_/D NOR2X1
X_19620_ _19737_/CK _19620_/D _19620_/Q VDD VSS DFFQX1
X_16832_ _16838_/A _16832_/B VDD VSS _19673_/D NOR2X1
XFILLER_120_696 VDD VSS FILLER1
XFILLER_76_73 VDD VSS FILLER4
X_19551_ _19551_/CK _19551_/D _19551_/Q VDD VSS DFFQX1
XFILLER_19_644 VDD VSS FILLER4
XFILLER_19_666 VSS VDD FILLER2
XFILLER_74_761 VDD VSS FILLER1
X_13975_ _17945_/B _17945_/C VDD VSS _17949_/B XNOR2X1
X_18502_ _18503_/CK _18523_/Q _20115_/A _18503_/RB VDD VSS DFFRQX1
X_16763_ _16775_/A _16763_/B VDD VSS _19611_/D NOR2X1
XFILLER_34_603 VDD VSS FILLER1
XTAP_TAPCELL_ROW_76_778 VDD VSS WELLTAP
X_12926_ _13023_/A _14382_/B VDD VSS _14383_/C _13023_/C NAND3X1
X_19482_ _19483_/CK _19482_/D _19482_/Q VDD VSS DFFQX1
X_16694_ _19901_/Q _16702_/B VDD VSS _19549_/D AND2X1
X_15714_ _15725_/A _15714_/B VDD VSS _19340_/D AND2X1
XFILLER_33_135 VSS VDD FILLER2
X_12857_ _12940_/A _12940_/B VDD VSS _12860_/B _12940_/C NAND3X1
X_18433_ _18439_/CK _18465_/D _18433_/Q _20075_/RB VDD VSS DFFRQX1
X_15645_ _15654_/A _15654_/B VDD VSS _15732_/B XNOR2X1
X_11808_ _19174_/Q _11808_/B _11830_/C VDD VSS _11916_/B XNOR3X1
X_18364_ _18367_/CK _18513_/Q _20201_/A _18464_/RB VDD VSS DFFRQX1
XFILLER_30_820 VDD VSS DECAPHV16
XTAP_TAPCELL_ROW_31_325 VDD VSS WELLTAP
X_12788_ _18879_/Q VDD VSS _12790_/A INVX1
X_17315_ _17318_/A _17315_/B _17315_/C VDD VSS _19819_/D AOI21X1
X_15576_ _15576_/A _15601_/B VDD VSS _15823_/B XNOR2X1
X_11739_ _11739_/A _11739_/B _14485_/B VDD VSS _11760_/B MIN3X1
X_14527_ _14766_/A _14527_/B VDD VSS _19233_/D AND2X1
X_18295_ _18295_/CK _18295_/D _18295_/Q VDD VSS DFFQX1
XFILLER_30_886 VDD VSS DECAPHV8
X_14458_ _14493_/A _14458_/B VDD VSS _19172_/D NOR2X1
X_17246_ _17390_/A _17246_/B VDD VSS _19805_/D NOR2X1
XFILLER_127_240 VDD VSS FILLER4
X_13409_ _13601_/A _13531_/B VDD VSS _14325_/B XNOR2X1
X_14389_ _14381_/Y _14389_/B _14389_/C VDD VSS _19111_/D AND3BX1
X_17177_ _17178_/A _17180_/C _17229_/C VDD VSS _17178_/C OAI21X1
XFILLER_127_273 VSS VDD FILLER2
XFILLER_127_284 VDD VSS FILLER1
XFILLER_128_785 VDD VSS FILLER4
X_16128_ _19683_/Q VDD VSS _16129_/A INVX1
XFILLER_115_446 VDD VSS DECAPHV8
XFILLER_89_809 VDD VSS FILLER4
X_16059_ _16059_/A _16059_/B _16768_/B VDD VSS _16083_/A MIN3X1
XFILLER_37_0 VSS VDD FILLER2
XFILLER_69_555 VSS VDD FILLER2
XFILLER_97_864 VDD VSS FILLER1
X_19818_ _19863_/CK _19818_/D _19818_/Q VDD VSS DFFQX1
XFILLER_111_685 VDD VSS FILLER1
XFILLER_69_599 VDD VSS FILLER1
XFILLER_84_514 VSS VDD FILLER2
XTAP_TAPCELL_ROW_39_403 VDD VSS WELLTAP
X_09502_ _18498_/D _09507_/B _09506_/C _20076_/Q VDD VSS _20076_/D AO22X2
X_19749_ _19833_/CK _19749_/D _19749_/Q VDD VSS DFFQX1
XFILLER_112_49 VDD VSS FILLER4
XFILLER_25_603 VDD VSS FILLER4
X_09433_ _09447_/B _09696_/B VDD VSS _18214_/E NOR2X1
X_09364_ _18477_/D VDD VSS _18493_/D INVX1
XFILLER_52_499 VSS VDD FILLER2
XANTENNA_20 _15836_/C VDD VSS ANTENNA2
XANTENNA_31 _18127_/B VDD VSS ANTENNA2
X_09295_ _09362_/AB _09349_/B VDD VSS _09295_/Y NOR2BX1
XANTENNA_42 _18173_/A VDD VSS ANTENNA2
XFILLER_20_363 VSS VDD FILLER2
XFILLER_134_700 VDD VSS DECAPHV8
XFILLER_107_947 VSS VDD FILLER2
XFILLER_119_796 VDD VSS DECAPHV8
XFILLER_134_755 VDD VSS FILLER4
XFILLER_133_298 VSS VDD FILLER2
X_10070_ _10044_/Y _10069_/Y _10155_/A VDD VSS _10070_/Y MUXI2X1
XFILLER_0_768 VSS VDD FILLER2
XFILLER_0_779 VDD VSS DECAPHV8
XFILLER_102_663 VSS VDD FILLER2
XFILLER_48_717 VDD VSS FILLER1
XFILLER_87_363 VSS VDD FILLER2
XFILLER_88_886 VDD VSS FILLER4
XFILLER_102_696 VDD VSS FILLER1
XFILLER_75_525 VDD VSS FILLER1
XTAP_TAPCELL_ROW_109_1106 VDD VSS WELLTAP
XFILLER_46_21 VDD VSS DECAPHV16
XFILLER_56_783 VSS VDD FILLER2
X_10972_ _11226_/A _10972_/B VDD VSS _10982_/B NOR2X1
X_13760_ _13770_/A _13760_/B _13830_/D VDD VSS _13816_/C XNOR3X1
XFILLER_43_444 VSS VDD FILLER2
XFILLER_55_271 VSS VDD FILLER2
XTAP_TAPCELL_ROW_73_748 VDD VSS WELLTAP
X_12711_ _18991_/Q _12713_/B _12713_/C VDD VSS _14214_/B XNOR3X1
X_13691_ _13736_/A _13840_/B _13692_/C VDD VSS _14263_/B OR3BX1
X_12642_ _12643_/A _12643_/B _12643_/D _12643_/C VDD VSS _14409_/C AOI211X1
X_15430_ _19461_/Q _15430_/B _15849_/B VDD VSS _15469_/B MIN3X1
XFILLER_141_0 VDD VSS DECAPHV16
XFILLER_15_179 VSS VDD FILLER2
XFILLER_43_488 VSS VDD FILLER2
XFILLER_30_149 VSS VDD FILLER2
X_12573_ _12659_/A _14505_/B VDD VSS _12840_/A NOR2X1
X_15361_ _15396_/A _15396_/B VDD VSS _15881_/B XOR2X1
X_11524_ _18676_/Q _11531_/B VDD VSS _18703_/D AND2X1
X_14312_ _14457_/A VDD VSS _14339_/A BUFX3
X_18080_ _19283_/Q _18084_/B VDD VSS _18083_/C XNOR2X1
X_17100_ _17102_/B _17100_/B VDD VSS _17101_/B XOR2X1
X_15292_ _19346_/Q _15720_/B VDD VSS _15294_/A XOR2X1
XFILLER_7_59 VSS VDD FILLER2
X_11455_ _19948_/Q _11460_/B VDD VSS _18641_/D AND2X1
X_14243_ _14243_/A _14277_/B VDD VSS _14244_/B XNOR2X1
X_17031_ _19758_/Q _19759_/Q _17047_/B VDD VSS _17041_/A OAI21X1
XFILLER_109_284 VDD VSS FILLER1
X_10406_ _10406_/A _10406_/B _10406_/C _10406_/D VDD VSS _10454_/A AOAI211X1
X_11386_ _11392_/A _11387_/B _11386_/C VDD VSS _11387_/C OAI21X1
X_14174_ _14174_/A _14174_/B _15836_/C VDD VSS _18926_/D OA21X2
XFILLER_113_917 VSS VDD FILLER2
XFILLER_113_928 VSS VDD FILLER2
X_10337_ _18632_/Q _18794_/Q VDD VSS _10338_/D XNOR2X1
X_13125_ _19191_/Q _13141_/D _13125_/C VDD VSS _13233_/C XNOR3X1
X_18982_ _19037_/CK _18982_/D _18982_/Q VDD VSS DFFQX1
XFILLER_112_449 VDD VSS FILLER4
XFILLER_3_595 VDD VSS FILLER1
XFILLER_87_50 VSS VDD FILLER2
X_10268_ _11436_/C _10268_/B _10763_/A VDD VSS _10269_/C OAI21X1
X_13056_ _13244_/A _13150_/D _13056_/C VDD VSS _13139_/B XNOR3X1
X_17933_ _17940_/A _17933_/B VDD VSS _17935_/B XNOR2X1
X_12007_ _19010_/Q _12012_/B _14273_/B VDD VSS _14238_/B XNOR3X1
XFILLER_38_216 VDD VSS FILLER1
XFILLER_93_322 VSS VDD FILLER2
X_10199_ _10200_/A _10200_/B _10200_/D _10200_/C VDD VSS _10199_/Y OAOI211X1
X_19603_ _19604_/CK _19603_/D _19603_/Q VDD VSS DFFQX1
X_17864_ _18851_/Q _17870_/B VDD VSS _17866_/B XNOR2X1
X_17795_ _19922_/Q _19890_/Q _17795_/C VDD VSS _17800_/C AO21X2
X_16815_ _16843_/A _16815_/B VDD VSS _19657_/D AND2X1
XFILLER_19_463 VSS VDD FILLER2
XFILLER_81_539 VDD VSS DECAPHV16
X_13958_ wire154/Y _13958_/B VDD VSS _14267_/B XOR2X1
X_19534_ _19543_/CK _19534_/D _19534_/Q VDD VSS DFFQX1
X_16746_ _16748_/A _16746_/B VDD VSS _19596_/D NOR2X1
XTAP_TAPCELL_ROW_140_1417 VDD VSS WELLTAP
X_12909_ _19076_/Q _14349_/B VDD VSS _12915_/C _14349_/C NAND3X1
X_19465_ _19466_/CK _19465_/D _19465_/Q VDD VSS DFFQX1
X_13889_ _13889_/A _13889_/B _13889_/C _13889_/D VDD VSS _14265_/B AOAI211X1
X_18416_ _18420_/CK _18517_/Q _20171_/A _18452_/RB VDD VSS DFFRQX1
X_16677_ _16677_/A _19928_/Q _16677_/C VDD VSS _16679_/A MIN3X1
XFILLER_21_105 VDD VSS FILLER1
XFILLER_34_488 VDD VSS FILLER4
XTAP_TAPCELL_ROW_16_174 VDD VSS WELLTAP
X_19396_ _19425_/CK _19396_/D _19396_/Q VDD VSS DFFQX1
X_15628_ _15644_/B _15628_/B VDD VSS _15731_/B XNOR2X1
XTAP_TAPCELL_ROW_99_1010 VDD VSS WELLTAP
X_18347_ _18356_/CK _18347_/D _18347_/Q _20072_/RB VDD VSS DFFRQX1
X_15559_ _15566_/A _15566_/B VDD VSS _15697_/B XNOR2X1
X_18278_ _18278_/CK _18278_/D _18278_/Q _09262_/Y VDD VSS DFFRQX1
XFILLER_135_519 VDD VSS FILLER1
XFILLER_30_694 VSS VDD FILLER2
XTAP_TAPCELL_ROW_0_2 VDD VSS WELLTAP
X_17229_ _17230_/A _17230_/B _17229_/C VDD VSS _17230_/C OAI21X1
XFILLER_115_265 VSS VDD FILLER2
XFILLER_143_585 VSS VDD FILLER2
X_09982_ _11435_/A _11435_/B _11438_/A VDD VSS _10362_/D OR3X2
X_20171_ _20171_/A VDD VSS _20171_/Y BUFX3
XFILLER_103_427 VDD VSS DECAPHV8
XFILLER_103_449 VDD VSS FILLER1
XFILLER_130_235 VDD VSS DECAPHV8
XFILLER_131_747 VDD VSS DECAPHV8
XFILLER_88_138 VDD VSS FILLER1
XFILLER_69_363 VDD VSS DECAPHV8
XFILLER_97_650 VDD VSS FILLER1
XFILLER_96_193 VDD VSS FILLER4
XFILLER_83_19 VDD VSS FILLER4
XFILLER_37_271 VSS VDD FILLER2
XFILLER_37_282 VDD VSS DECAPHV16
XFILLER_80_561 VDD VSS DECAPHV8
XTAP_TAPCELL_ROW_70_718 VDD VSS WELLTAP
X_09416_ _20064_/Q VDD VSS _16908_/C INVX1
XFILLER_12_105 VDD VSS FILLER4
XFILLER_25_488 VSS VDD FILLER2
XFILLER_40_414 VDD VSS FILLER4
XFILLER_52_285 VDD VSS DECAPHV8
XFILLER_53_797 VDD VSS FILLER1
XTAP_TAPCELL_ROW_104_1058 VDD VSS WELLTAP
X_09347_ _18281_/Q _18525_/Q _09354_/B VDD VSS _09347_/Y MUXI2X1
XFILLER_138_324 VDD VSS FILLER1
XFILLER_139_836 VDD VSS FILLER1
XFILLER_32_34 VDD VSS FILLER4
X_09278_ _18471_/D _09354_/B _09351_/C _09753_/A _09414_/D VDD VSS wire168/A AOI221X1
XFILLER_20_193 VSS VDD FILLER2
XTAP_TAPCELL_ROW_3_49 VDD VSS WELLTAP
XFILLER_126_519 VDD VSS DECAPHV16
X_11240_ _18578_/Q _11249_/B VDD VSS _11253_/A NAND2X1
XFILLER_4_359 VSS VDD FILLER2
XTAP_TAPCELL_ROW_115_1165 VDD VSS WELLTAP
X_11171_ _18654_/Q _18816_/Q _11171_/C VDD VSS _11204_/B AOI21X1
X_10122_ _10122_/A VDD VSS _10123_/A INVX1
XFILLER_0_543 VDD VSS DECAPHV8
XFILLER_110_909 VDD VSS FILLER1
XFILLER_94_108 VSS VDD FILLER2
XFILLER_0_598 VDD VSS DECAPHV8
XFILLER_102_471 VDD VSS FILLER1
XFILLER_75_311 VDD VSS FILLER1
X_10053_ _10053_/A _10053_/B _10053_/C VDD VSS _10075_/A MIN3X1
X_14930_ _19450_/Q wire161/Y _14957_/B VDD VSS _14931_/D XNOR3X1
X_14861_ _14861_/A _14861_/B _14861_/C VDD VSS _14911_/C NOR3X1
XFILLER_29_783 VDD VSS FILLER1
XFILLER_76_889 VDD VSS FILLER4
XTAP_TAPCELL_ROW_86_873 VDD VSS WELLTAP
X_13812_ _18891_/Q _13812_/B VDD VSS _13868_/C _13877_/B NAND3X1
X_17580_ _19876_/Q _19844_/Q VDD VSS _17581_/C NAND2X1
X_16600_ _19574_/Q _19926_/Q VDD VSS _16603_/A XNOR2X1
XFILLER_28_271 VDD VSS FILLER4
XFILLER_75_399 VSS VDD FILLER2
XTAP_TAPCELL_ROW_126_1272 VDD VSS WELLTAP
XTAP_TAPCELL_ROW_58_597 VDD VSS WELLTAP
Xclkbuf_leaf_9__001_ clkload41/A VDD VSS _19999_/CK BUFX12
X_16531_ _19635_/Q _16789_/B VDD VSS _16532_/B XOR2X1
X_14792_ _15865_/B _14792_/B _14872_/C VDD VSS _15866_/B XNOR3X1
XFILLER_113_92 VDD VSS FILLER1
XFILLER_32_904 VDD VSS FILLER1
XFILLER_71_561 VSS VDD FILLER2
XFILLER_90_358 VDD VSS DECAPHV8
X_10955_ _10953_/Y _10957_/C _11431_/A VDD VSS _18569_/D AND3BX1
X_13743_ _18889_/Q _14130_/B VDD VSS _13872_/A NAND2X1
XFILLER_16_499 VDD VSS FILLER4
XFILLER_73_85 VDD VSS FILLER1
X_10886_ _10884_/Y _10888_/B _11431_/A VDD VSS _18567_/D AND3BX1
X_13674_ _13675_/A _13675_/B _13675_/D _13675_/C VDD VSS _14195_/C AOI211X1
X_19250_ _19250_/CK _19250_/D _19250_/Q VDD VSS DFFQX1
X_16462_ _16462_/A _16469_/C VDD VSS _16892_/B XNOR2X1
X_12625_ _12625_/A _12625_/B _12625_/C VDD VSS _12630_/B XNOR3X1
X_19181_ _19215_/CK _19181_/D _19181_/Q VDD VSS DFFQX1
X_18201_ _18201_/A _18201_/B _18201_/C VDD VSS _18202_/C OAI21X1
X_16393_ _19566_/Q _19918_/Q VDD VSS _16421_/A XOR2X1
X_15413_ _15413_/A _15425_/C VDD VSS _15723_/B XNOR2X1
XTAP_TAPCELL_ROW_13_144 VDD VSS WELLTAP
X_12556_ _12593_/A _12593_/B _12593_/E _12556_/D VDD VSS _14378_/C OAOI211X1
X_18132_ _18132_/A _18132_/B _18136_/B VDD VSS _20000_/D NOR3X1
X_15344_ _15784_/B VDD VSS _15345_/C INVX1
X_11507_ _18661_/Q _11508_/B VDD VSS _18688_/D AND2X1
XFILLER_138_880 VSS VDD FILLER2
X_12487_ _12497_/A _14503_/B _12497_/C VDD VSS _14504_/B OAI21X1
X_18063_ _19279_/Q _18063_/B VDD VSS _18064_/C NAND2X1
X_15275_ _15275_/A _15275_/B _15275_/C _15275_/D VDD VSS _15311_/A AOI31X1
XTAP_TAPCELL_ROW_137_1390 VDD VSS WELLTAP
X_11438_ _11438_/A _11438_/B VDD VSS _11439_/B XNOR2X1
X_14226_ _14226_/A wire155/Y _14226_/C VDD VSS _14227_/C NOR3X1
X_17014_ _17095_/A _17014_/B VDD VSS _19757_/D NOR2X1
XFILLER_125_552 VDD VSS FILLER4
XFILLER_125_574 VDD VSS DECAPHV8
X_11369_ _11383_/A _11369_/B VDD VSS _18591_/D NOR2X1
X_14157_ _14186_/A _14157_/B VDD VSS _18912_/D NOR2X1
XFILLER_113_747 VDD VSS FILLER4
XFILLER_125_596 VSS VDD FILLER2
X_13108_ _13108_/A _13108_/B _13108_/C _13108_/D VDD VSS _14446_/B AOAI211X1
X_14088_ _14174_/B _14173_/B _18925_/Q VDD VSS _14089_/D OAI21X1
Xclkbuf_leaf_13__000_ clkbuf_leaf_9__000_/A VDD VSS _19736_/CK BUFX12
X_18965_ _18993_/CK _18965_/D _18965_/Q VDD VSS DFFQX1
XFILLER_67_834 VSS VDD FILLER2
X_13039_ _13039_/A _13039_/B _13039_/C _13039_/D VDD VSS _14446_/C OAI211X1
X_18896_ _19171_/CK _18896_/D _18896_/Q VDD VSS DFFQX1
X_17916_ _18861_/Q _17919_/B VDD VSS _17918_/B XOR2X1
XFILLER_66_322 VSS VDD FILLER2
XFILLER_67_878 VDD VSS DECAPHV8
X_17847_ _18847_/Q _17847_/B _17847_/C VDD VSS _17853_/C MIN3X1
XFILLER_66_355 VSS VDD FILLER2
XFILLER_81_303 VDD VSS DECAPHV8
XFILLER_82_837 VDD VSS FILLER1
XFILLER_93_141 VDD VSS DECAPHV16
XFILLER_35_720 VDD VSS DECAPHV8
X_19517_ _19533_/CK _19517_/D _19517_/Q VDD VSS DFFQX1
Xclkbuf_leaf_28__000_ clkload78/A VDD VSS _19358_/CK BUFX12
X_17778_ _17781_/C _17778_/B VDD VSS _17779_/B XNOR2X1
XFILLER_34_230 VSS VDD FILLER2
X_16729_ _16735_/A _16729_/B VDD VSS _19580_/D NOR2X1
XFILLER_22_425 VSS VDD FILLER2
XFILLER_23_937 VDD VSS FILLER1
X_19448_ _19489_/CK _19448_/D _19448_/Q VDD VSS DFFQX1
X_09201_ _18510_/Q VDD VSS _18441_/D INVX1
X_19379_ _19385_/CK _19379_/D _19379_/Q VDD VSS DFFQX1
XFILLER_50_789 VDD VSS FILLER1
XFILLER_8_91 VSS VDD FILLER2
XFILLER_131_500 VDD VSS DECAPHV32
XFILLER_144_883 VDD VSS DECAPHV16
X_20223_ _20223_/A VDD VSS _20223_/Y BUFX3
XFILLER_89_436 VDD VSS FILLER4
X_20154_ _20154_/A VDD VSS _20154_/Y BUFX3
X_09896_ _18598_/Q _09935_/B VDD VSS _09981_/A NAND2X1
X_20085_ _20085_/A VDD VSS _20085_/Y BUFX3
XFILLER_69_182 VDD VSS FILLER4
XFILLER_84_130 VDD VSS DECAPHV8
XFILLER_57_366 VDD VSS FILLER4
XFILLER_73_804 VDD VSS DECAPHV8
XFILLER_84_163 VDD VSS FILLER4
XFILLER_57_399 VDD VSS FILLER4
XFILLER_73_859 VSS VDD FILLER2
XFILLER_85_697 VDD VSS FILLER4
XTAP_TAPCELL_ROW_83_843 VDD VSS WELLTAP
XTAP_TAPCELL_ROW_55_567 VDD VSS WELLTAP
XFILLER_14_948 VSS VDD FILLER2
XFILLER_40_211 VSS VDD FILLER2
XFILLER_81_892 VDD VSS FILLER1
X_10740_ _10740_/A _10785_/B VDD VSS _10743_/C XNOR2X1
X_10671_ _10671_/A _10671_/B VDD VSS _10708_/A NAND2X1
X_12410_ _20004_/Q _19268_/Q VDD VSS _12673_/A NOR2X1
XFILLER_21_491 VDD VSS FILLER1
XFILLER_40_288 VSS VDD FILLER2
XTAP_TAPCELL_ROW_10_114 VDD VSS WELLTAP
X_13390_ _13391_/A _13391_/B _13391_/D _13391_/C VDD VSS _14192_/C AOI211X1
X_12341_ _12341_/A _12341_/B _14178_/B VDD VSS _12353_/C MIN3X1
XFILLER_126_338 VDD VSS FILLER1
XFILLER_4_101 VDD VSS FILLER1
X_12272_ _18874_/Q _12272_/B _12272_/C VDD VSS _12610_/B MIN3X1
X_15060_ _19508_/Q _15144_/B VDD VSS _15108_/D NAND2X1
XFILLER_104_0 VDD VSS FILLER1
X_11223_ _11263_/A _11241_/A VDD VSS _11236_/A NOR2X1
X_14011_ _19006_/Q _14268_/A _14268_/B VDD VSS _14013_/C NOR3X1
XFILLER_108_92 VDD VSS DECAPHV8
X_11154_ _11154_/A _11159_/B VDD VSS _11158_/C XNOR2X1
XFILLER_103_780 VSS VDD FILLER2
XFILLER_110_739 VDD VSS DECAPHV8
XFILLER_122_588 VSS VDD FILLER2
X_10105_ _10081_/Y _10129_/B _10155_/A VDD VSS _10105_/Y MUX2X1
X_11085_ _11086_/A _11086_/B _11086_/C _11273_/A VDD VSS _11085_/Y AOI31X1
X_18750_ _19948_/CK _18750_/D _18750_/Q VDD VSS DFFQX1
X_15962_ _19549_/Q VDD VSS _15963_/A INVX1
XFILLER_103_791 VSS VDD FILLER2
XFILLER_48_333 VDD VSS FILLER1
X_10036_ _10027_/Y _10035_/Y _11208_/A VDD VSS _10050_/C MUXI2X1
X_18681_ _18817_/CK _18681_/D _18681_/Q VDD VSS DFFQX1
X_17701_ _17806_/A _17701_/B VDD VSS _19902_/D NOR2X1
X_14913_ _14920_/A _15833_/B _14920_/C VDD VSS _15834_/B OAI21X1
XFILLER_48_366 VDD VSS FILLER1
X_17632_ _17634_/C _17632_/B _17632_/C VDD VSS _19887_/D AOI21X1
X_15893_ _15895_/A _15893_/B VDD VSS _19500_/D NOR2X1
XFILLER_63_314 VSS VDD FILLER2
XFILLER_90_111 VSS VDD FILLER2
X_14844_ _19392_/Q _15770_/B VDD VSS _14845_/B XOR2X1
XFILLER_91_678 VSS VDD FILLER2
X_11987_ _11987_/A _14462_/B _11987_/C _11987_/D VDD VSS _12113_/A OAOI211X2
X_17563_ _19873_/Q _19841_/Q VDD VSS _17565_/B XOR2X1
X_14775_ _14775_/A _14775_/B VDD VSS _15830_/B XNOR2X1
XFILLER_32_734 VSS VDD FILLER2
XFILLER_90_188 VDD VSS FILLER4
X_10938_ _18702_/Q _18756_/Q VDD VSS _10940_/C XNOR2X1
X_13726_ _13777_/A _13766_/B _13783_/C VDD VSS _13843_/A XNOR3X1
X_19302_ _19304_/CK _19302_/D _19302_/Q VDD VSS DFFQX1
X_17494_ _19858_/Q _19826_/Q VDD VSS _17496_/D XNOR2X1
X_16514_ _19730_/Q _16895_/B VDD VSS _16515_/C NOR2X1
XFILLER_20_907 VDD VSS FILLER1
XTAP_TAPCELL_ROW_26_280 VDD VSS WELLTAP
X_19233_ _19234_/CK _19233_/D _19233_/Q VDD VSS DFFQX1
X_16445_ _19663_/Q _16821_/B VDD VSS _16459_/A NAND2BX1
X_10869_ _18672_/Q _18780_/Q VDD VSS _10871_/C NAND2X1
X_13657_ _13748_/A _13748_/C VDD VSS _13746_/C AND2X1
X_12608_ _13177_/A _17869_/B VDD VSS _18850_/D NOR2X1
X_13588_ _13656_/A _13656_/B _13589_/D _13656_/E VDD VSS _14162_/B OA211X2
X_19164_ _19194_/CK _19164_/D _19164_/Q VDD VSS DFFQX1
X_16376_ _19629_/Q _16783_/B VDD VSS _16377_/B XNOR2X1
XFILLER_118_839 VDD VSS DECAPHV16
XFILLER_129_154 VDD VSS FILLER1
XFILLER_76_4 VSS VDD FILLER2
XFILLER_8_473 VDD VSS FILLER1
X_12539_ _19045_/Q _14314_/B VDD VSS _12632_/A AND2X1
X_19095_ _19124_/CK _19095_/D _19095_/Q VDD VSS DFFQX1
X_18115_ _18117_/A _18117_/B VDD VSS _18121_/B NOR2X1
X_15327_ _15347_/D _15327_/B VDD VSS _15784_/B XOR2X1
X_18046_ _18544_/Q _18048_/B VDD VSS _18047_/B XNOR2X1
X_15258_ _15688_/B VDD VSS _15259_/C INVX1
XFILLER_132_319 VDD VSS FILLER4
X_14209_ _14231_/A _14209_/B VDD VSS _18958_/D AND2X1
XFILLER_98_200 VSS VDD FILLER2
X_15189_ _19511_/Q _15905_/B VDD VSS _15275_/B NAND2BX1
XFILLER_140_330 VDD VSS FILLER1
X_19997_ _19999_/CK _19997_/D _19997_/Q VDD VSS DFFQX1
XFILLER_140_374 VDD VSS FILLER4
X_09750_ _18323_/Q _09769_/C VDD VSS _09751_/D NAND2X1
Xclkbuf_0__09173_ _18222_/ECK VDD VSS clkbuf_0__09173_/Y BUFX12
X_18948_ _18950_/CK _18948_/D _18948_/Q VDD VSS DFFQX1
XFILLER_100_249 VSS VDD FILLER2
XFILLER_95_940 VDD VSS DECAPHV8
X_09681_ _09681_/A _09681_/B VDD VSS _09682_/E NAND2X1
XFILLER_39_377 VDD VSS FILLER1
XFILLER_66_152 VDD VSS DECAPHV16
X_18879_ _18888_/CK _18879_/D _18879_/Q VDD VSS DFFQX1
XFILLER_94_494 VDD VSS DECAPHV8
XFILLER_54_347 VDD VSS FILLER1
XFILLER_63_870 VDD VSS FILLER1
XTAP_TAPCELL_ROW_80_813 VDD VSS WELLTAP
XFILLER_11_907 VDD VSS DECAPHV8
XFILLER_23_767 VDD VSS FILLER1
XTAP_TAPCELL_ROW_101_1028 VDD VSS WELLTAP
XTAP_TAPCELL_ROW_52_537 VDD VSS WELLTAP
XFILLER_23_789 VDD VSS FILLER1
XFILLER_135_102 VDD VSS FILLER1
XFILLER_136_603 VDD VSS FILLER1
XFILLER_123_308 VDD VSS FILLER1
Xclkbuf_leaf_8__002_ clkbuf_leaf_9__002_/A VDD VSS _18828_/CK BUFX12
XFILLER_132_820 VDD VSS FILLER1
XTAP_TAPCELL_ROW_0_17 VDD VSS WELLTAP
XTAP_TAPCELL_ROW_112_1135 VDD VSS WELLTAP
X_20206_ _20206_/A VDD VSS _20206_/Y BUFX3
Xmax_cap181 _18523_/Q VDD VSS _18470_/D BUFX12
XFILLER_89_277 VSS VDD FILLER2
X_09948_ _18577_/Q _09999_/C VDD VSS _09948_/Y XNOR2X1
X_20137_ _20137_/A VDD VSS _20137_/Y BUFX3
XFILLER_100_750 VSS VDD FILLER2
XFILLER_45_303 VDD VSS FILLER1
XFILLER_85_461 VDD VSS FILLER4
X_09879_ _09908_/B _09911_/B _10966_/A VDD VSS _09925_/B MUXI2X1
X_20068_ clkload6/A _20068_/D _20068_/Q _20069_/RB VDD VSS DFFRQX1
XFILLER_72_111 VSS VDD FILLER2
XFILLER_73_645 VDD VSS FILLER1
XTAP_TAPCELL_ROW_68_692 VDD VSS WELLTAP
X_11910_ _19120_/Q _11961_/B _11961_/C VDD VSS _11963_/A MIN3X1
X_12890_ _18965_/Q _13004_/B VDD VSS _12891_/C _12890_/C NAND3X1
XFILLER_33_509 VDD VSS FILLER1
XFILLER_73_656 VDD VSS FILLER1
X_11841_ _19995_/Q _19259_/Q VDD VSS _11881_/D XNOR2X1
XFILLER_54_65 VDD VSS FILLER4
XFILLER_60_317 VDD VSS FILLER1
XTAP_TAPCELL_ROW_123_1242 VDD VSS WELLTAP
X_11772_ _19991_/Q _19255_/Q VDD VSS _11778_/C NAND2X1
X_14560_ _19999_/Q _14569_/B VDD VSS _19263_/D AND2X1
XFILLER_13_211 VDD VSS DECAPHV8
XFILLER_53_391 VDD VSS FILLER1
X_10723_ _19949_/Q _18831_/Q VDD VSS _10725_/B XNOR2X1
X_13511_ _13511_/A _13511_/B _13511_/C _13511_/D VDD VSS wire155/A OAOI211X1
XFILLER_14_789 VDD VSS FILLER1
XFILLER_9_204 VDD VSS FILLER1
X_14491_ _14522_/A VDD VSS _14491_/Y BUFX3
XFILLER_13_277 VSS VDD FILLER2
XTAP_TAPCELL_ROW_23_250 VDD VSS WELLTAP
X_10654_ _10621_/B _10697_/B _10945_/A VDD VSS _10734_/B MUXI2X1
X_13442_ _19193_/Q _14480_/B VDD VSS _13459_/A NAND2X1
Xclkbuf_leaf_12__001_ clkload41/A VDD VSS _19197_/CK BUFX12
X_16230_ _16230_/A VDD VSS _16231_/B INVX1
XFILLER_127_625 VDD VSS FILLER4
X_10585_ _10625_/A _11267_/A _10585_/C VDD VSS _10586_/C NOR3X1
X_13373_ _13373_/A _13373_/B _14292_/B _13373_/D _13373_/E VDD VSS _13509_/C OAI221X1
X_16161_ _16185_/C _16161_/B VDD VSS _16739_/B XNOR2X1
XFILLER_126_113 VDD VSS DECAPHV16
XFILLER_127_636 VDD VSS DECAPHV8
X_12324_ _12407_/A _14531_/B _12407_/C _12407_/D VDD VSS _12499_/B AO31X2
Xclkload29 _18768_/CK VDD VSS clkload29/Y INVX2
Xclkload18 _18811_/CK VDD VSS clkload18/Y BUFX12
X_15112_ _15112_/A _15112_/B _15112_/C _15112_/D VDD VSS _15840_/B OAI211X1
XFILLER_126_146 VDD VSS FILLER1
XFILLER_5_443 VSS VDD FILLER2
Xclkbuf_leaf_27__001_ clkbuf_2_1__f__001_/Y VDD VSS _19064_/CK BUFX12
X_16092_ _19618_/Q _16107_/A VDD VSS _16093_/B XOR2X1
XTAP_TAPCELL_ROW_134_1360 VDD VSS WELLTAP
X_12255_ _12255_/A _12255_/B _14372_/B VDD VSS _12447_/A MIN3X1
X_19920_ clkload7/A _19920_/D _19920_/Q VDD VSS DFFQX1
X_15043_ _15092_/A _15092_/B VDD VSS _15807_/B XNOR2X1
XFILLER_122_330 VDD VSS FILLER1
XFILLER_122_341 VSS VDD FILLER2
XFILLER_134_190 VDD VSS FILLER1
XFILLER_79_84 VDD VSS FILLER1
X_11206_ _11227_/C _11206_/B VDD VSS _11207_/B XNOR2X1
X_12186_ _19069_/Q _12283_/B _12449_/C VDD VSS _12203_/B XNOR3X1
X_19851_ _19863_/CK _19851_/D _19851_/Q VDD VSS DFFQX1
XFILLER_122_363 VSS VDD FILLER2
XFILLER_96_737 VDD VSS DECAPHV8
X_11137_ _11138_/A _11138_/B VDD VSS _11171_/C NOR2X1
X_19782_ _19833_/CK _19782_/D _19782_/Q VDD VSS DFFQX1
X_18802_ _18828_/CK _18802_/D _18802_/Q VDD VSS DFFQX1
X_18733_ _19937_/CK _18733_/D _18733_/Q VDD VSS DFFQX1
X_16994_ _16994_/A _16994_/B VDD VSS _16996_/B NAND2X1
XFILLER_76_450 VDD VSS FILLER1
XFILLER_83_409 VDD VSS FILLER4
XFILLER_95_61 VDD VSS FILLER4
X_11068_ _11107_/B _11068_/B VDD VSS _11077_/B XOR2X1
X_15945_ _19613_/Q _16765_/B VDD VSS _15946_/B XOR2X1
XFILLER_48_174 VDD VSS FILLER1
X_10019_ _10012_/Y _10018_/Y _11208_/A VDD VSS _10026_/B MUXI2X1
X_18664_ _18799_/CK _18664_/D _18664_/Q VDD VSS DFFQX1
X_15876_ _15879_/A _15876_/B VDD VSS _19484_/D AND2X1
XFILLER_36_347 VDD VSS FILLER1
XFILLER_48_196 VDD VSS FILLER4
XFILLER_63_133 VDD VSS FILLER4
XFILLER_64_678 VDD VSS FILLER4
X_18595_ _18595_/CK _18595_/D _18595_/Q VDD VSS DFFQX1
X_17615_ _17618_/A _17615_/B _17615_/C VDD VSS _19883_/D AOI21X1
X_14827_ _19529_/Q _14877_/C VDD VSS _14828_/B NAND2X1
XFILLER_17_561 VDD VSS DECAPHV16
XFILLER_45_881 VDD VSS DECAPHV8
XFILLER_51_317 VDD VSS FILLER1
X_17546_ _17544_/B _17546_/B VDD VSS _17547_/C NOR2BX1
X_14758_ _14758_/A _14758_/B _15767_/B VDD VSS _14772_/C MIN3X1
X_13709_ _13779_/A _13709_/B _14361_/B VDD VSS _13725_/B MIN3X1
X_14689_ _14696_/B _14689_/B VDD VSS _15735_/B XNOR2X1
X_17477_ _17477_/A _17479_/C _17477_/C VDD VSS _19854_/D AOI21X1
XFILLER_81_2 VDD VSS FILLER1
X_19216_ _20006_/CK _19216_/D _19216_/Q VDD VSS DFFQX1
X_16428_ _16429_/A _16429_/B _16429_/C VDD VSS _16447_/B OAI21X1
X_19147_ _19202_/CK _19147_/D _19147_/Q VDD VSS DFFQX1
X_16359_ _19692_/Q _16853_/B VDD VSS _16388_/A NAND2BX1
X_19078_ _19121_/CK _19078_/D _19078_/Q VDD VSS DFFQX1
XFILLER_114_820 VDD VSS DECAPHV16
X_18029_ _18056_/A _18029_/B _18056_/C VDD VSS _19972_/D OAI21X1
XFILLER_114_842 VDD VSS FILLER1
XFILLER_132_138 VDD VSS FILLER1
Xfanout205 _20051_/RB VDD VSS _18444_/RB BUFX3
XFILLER_115_16 VSS VDD FILLER2
XFILLER_140_160 VSS VDD FILLER2
XFILLER_141_661 VDD VSS FILLER4
X_09802_ _18454_/Q _09816_/B _09802_/C _09816_/D VDD VSS _09802_/Y OAI211X1
Xfanout216 _18370_/RB VDD VSS _20072_/RB BUFX3
XFILLER_67_450 VDD VSS DECAPHV8
XFILLER_95_770 VDD VSS FILLER4
XTAP_TAPCELL_ROW_29_309 VDD VSS WELLTAP
X_09733_ _18338_/Q VDD VSS _20092_/A INVX1
XFILLER_28_837 VSS VDD FILLER2
XFILLER_39_185 VDD VSS FILLER1
XFILLER_83_921 VDD VSS FILLER4
XFILLER_94_280 VDD VSS DECAPHV8
X_09664_ _09664_/A _09664_/B _09664_/C _09812_/C VDD VSS _09665_/E AOI31X1
XFILLER_27_358 VSS VDD FILLER2
XFILLER_27_369 VSS VDD FILLER2
X_09595_ _09811_/B VDD VSS _09784_/C BUFX3
XFILLER_54_177 VDD VSS FILLER1
XTAP_TAPCELL_ROW_65_662 VDD VSS WELLTAP
XFILLER_23_542 VDD VSS DECAPHV8
XFILLER_24_24 VDD VSS FILLER1
XFILLER_51_840 VDD VSS DECAPHV8
XTAP_TAPCELL_ROW_37_386 VDD VSS WELLTAP
XFILLER_51_884 VSS VDD FILLER2
XFILLER_10_225 VDD VSS FILLER4
XFILLER_11_726 VDD VSS FILLER4
XFILLER_23_586 VDD VSS FILLER4
XFILLER_50_372 VDD VSS FILLER1
XFILLER_109_603 VDD VSS FILLER4
XFILLER_11_759 VSS VDD FILLER2
XFILLER_137_923 VDD VSS FILLER4
XFILLER_7_708 VDD VSS FILLER4
XTAP_TAPCELL_ROW_20_220 VDD VSS WELLTAP
XFILLER_109_658 VSS VDD FILLER2
XFILLER_40_45 VDD VSS FILLER1
XFILLER_6_229 VSS VDD FILLER2
XFILLER_108_135 VDD VSS FILLER4
X_10370_ _10402_/A _10402_/B _10402_/C VDD VSS _10375_/C OAI21X1
XFILLER_108_179 VDD VSS FILLER4
XFILLER_40_89 VSS VDD FILLER2
Xclkbuf_2_2__f__000_ clkbuf_0__000_/Y VDD VSS clkbuf_leaf_9__000_/A BUFX12
XFILLER_105_853 VSS VDD FILLER2
X_12040_ _12040_/A _12040_/B _12040_/C _12040_/D VDD VSS _14433_/B OAOI211X1
XFILLER_132_683 VSS VDD FILLER2
XFILLER_77_214 VSS VDD FILLER2
XFILLER_93_707 VDD VSS FILLER4
X_13991_ _13991_/A _14036_/A _14045_/B VDD VSS _13993_/C XNOR3X1
XFILLER_19_826 VDD VSS FILLER4
XFILLER_1_39 VSS VDD FILLER2
XFILLER_92_239 VSS VDD FILLER2
X_12942_ _13028_/A _14445_/B VDD VSS _13041_/A NOR2X1
X_15730_ _15743_/A _15730_/B VDD VSS _19355_/D AND2X1
XFILLER_45_122 VDD VSS DECAPHV8
X_15661_ _15674_/A _18181_/B VDD VSS _19302_/D AND2X1
XFILLER_65_86 VDD VSS FILLER4
X_12873_ _12903_/A _12903_/B _12903_/C _12903_/D VDD VSS _13004_/B AO211X2
X_14612_ _19440_/Q _15825_/B VDD VSS _14613_/B OR2X2
X_17400_ _17402_/B _17400_/B VDD VSS _17401_/B XOR2X1
XFILLER_60_136 VSS VDD FILLER2
X_11824_ _14460_/B _14460_/C _19174_/Q VDD VSS _11874_/B AOI21X1
X_18380_ _18390_/CK _18513_/Q _20185_/A _20064_/RB VDD VSS DFFRQX1
X_15592_ _15592_/A _15592_/B VDD VSS _15593_/C NOR2X1
XFILLER_60_158 VDD VSS DECAPHV8
X_11755_ _11793_/A _11793_/B _11762_/C VDD VSS _14426_/B XNOR3X1
X_14543_ _15672_/A _14543_/B VDD VSS _19248_/D NOR2X1
X_17331_ _17334_/C _17332_/B _17363_/C VDD VSS _17332_/C OAI21X1
XFILLER_81_96 VDD VSS DECAPHV8
X_10706_ _10708_/A _10708_/B _10706_/C _11378_/A VDD VSS _18562_/D AOI211X1
X_14474_ _14493_/A _14474_/B VDD VSS _19187_/D NOR2X1
X_17262_ _19808_/Q VDD VSS _17413_/B INVX1
X_11686_ _19009_/Q VDD VSS _11950_/A INVX1
X_13425_ _13528_/A _14355_/A _13528_/C VDD VSS _14358_/B AOI21X1
X_19001_ _19001_/CK _19001_/D _19001_/Q VDD VSS DFFQX1
X_16213_ _16233_/A _16233_/B VDD VSS _16777_/B XNOR2X1
XFILLER_128_945 VDD VSS FILLER4
XFILLER_139_282 VDD VSS FILLER1
X_10637_ _18639_/Q _18801_/Q VDD VSS _10638_/D NOR2X1
Xclkload118 _20079_/CK VDD VSS clkload118/Y INVX6
Xclkload107 _19606_/CK VDD VSS clkload107/Y BUFX12
X_17193_ _17197_/A _17194_/B _17229_/C VDD VSS _17194_/C OAI21X1
X_10568_ _10568_/A VDD VSS _10570_/C INVX1
X_13356_ _13356_/A _13356_/B _13443_/D VDD VSS _13430_/C XNOR3X1
Xclkload129 _18407_/CK VDD VSS clkload129/Y INVX2
X_16144_ _16144_/A _16154_/B VDD VSS _16845_/B XNOR2X1
XFILLER_108_680 VDD VSS FILLER1
X_10499_ _10499_/A _10499_/B _10655_/A VDD VSS _10659_/C AO21X2
X_12307_ _12307_/A _14437_/B _14437_/C VDD VSS _12471_/C NOR3X1
X_13287_ _13287_/A _13287_/B _14125_/B VDD VSS _13288_/B MIN3X1
X_16075_ _19713_/Q _16876_/B VDD VSS _16079_/B XOR2X1
XFILLER_114_138 VDD VSS FILLER1
XFILLER_130_609 VDD VSS FILLER1
X_12238_ _19237_/Q _14531_/B VDD VSS _12239_/D _14531_/C NAND3X1
X_19903_ _19903_/CK _19903_/D _19903_/Q VDD VSS DFFQX1
X_15026_ _15026_/A _15026_/B _15026_/C VDD VSS _15041_/B OAI21X1
XFILLER_123_650 VDD VSS FILLER1
XFILLER_39_4 VSS VDD FILLER2
XFILLER_69_715 VDD VSS FILLER1
XFILLER_110_322 VSS VDD FILLER2
XFILLER_68_214 VDD VSS FILLER4
X_12169_ _19209_/Q _12172_/B _12224_/C VDD VSS _12329_/B XOR3X1
X_19834_ _19903_/CK _19834_/D _19834_/Q VDD VSS DFFQX1
XFILLER_37_601 VDD VSS FILLER4
XFILLER_84_729 VDD VSS FILLER1
X_19765_ _19828_/CK _19765_/D _19765_/Q VDD VSS DFFQX1
X_16977_ _16975_/B _16977_/B VDD VSS _16984_/A NOR2BX1
X_19696_ _19696_/CK _19696_/D _19696_/Q VDD VSS DFFQX1
X_18716_ _18773_/CK _18716_/D _18716_/Q VDD VSS DFFQX1
X_15928_ _15936_/A _15936_/B VDD VSS _16764_/B XNOR2X1
XFILLER_64_431 VDD VSS FILLER1
XFILLER_80_902 VDD VSS FILLER4
XFILLER_92_740 VSS VDD FILLER2
X_18647_ _19951_/CK _18647_/D _18647_/Q VDD VSS DFFQX1
XFILLER_18_870 VDD VSS FILLER1
XFILLER_36_166 VDD VSS DECAPHV8
XTAP_TAPCELL_ROW_143_1448 VDD VSS WELLTAP
X_15859_ _15859_/A _15859_/B VDD VSS _15860_/B XNOR2X1
XFILLER_51_114 VDD VSS FILLER1
XTAP_TAPCELL_ROW_62_632 VDD VSS WELLTAP
X_09380_ _18526_/Q _09380_/B VDD VSS _18223_/E AND2X1
X_18578_ _18582_/CK _18578_/D _18578_/Q VDD VSS DFFQX1
XTAP_TAPCELL_ROW_34_356 VDD VSS WELLTAP
X_17529_ _17529_/A _17529_/B VDD VSS _17530_/B XNOR2X1
XFILLER_32_361 VDD VSS DECAPHV8
XFILLER_118_488 VSS VDD FILLER2
XFILLER_118_499 VDD VSS FILLER4
XFILLER_86_19 VSS VDD FILLER2
XFILLER_99_361 VDD VSS FILLER1
XFILLER_59_225 VDD VSS FILLER1
XFILLER_101_355 VDD VSS DECAPHV8
XFILLER_19_24 VDD VSS FILLER1
XFILLER_19_57 VSS VDD FILLER2
XFILLER_28_601 VSS VDD FILLER2
X_09716_ _18268_/Q _09716_/B _09716_/C _09813_/C _09716_/E VDD VSS _09717_/D AOI221X1
Xclkbuf_leaf_11__002_ clkbuf_leaf_9__002_/A VDD VSS _18779_/CK BUFX12
XFILLER_16_818 VDD VSS FILLER1
XFILLER_27_166 VDD VSS FILLER1
XFILLER_42_103 VDD VSS FILLER4
XFILLER_71_913 VDD VSS DECAPHV8
X_09647_ _18264_/Q _09716_/B _09647_/C _09812_/C _09647_/E VDD VSS _09650_/C AOI221X1
XFILLER_82_283 VSS VDD FILLER2
XTAP_TAPCELL_ROW_107_1089 VDD VSS WELLTAP
X_09578_ _18504_/Q _09578_/B VDD VSS _09797_/B NOR2BX1
XTAP_TAPCELL_ROW_120_1212 VDD VSS WELLTAP
XFILLER_143_4 VDD VSS DECAPHV32
X_11540_ _18691_/Q _11542_/B VDD VSS _18718_/D AND2X1
XFILLER_137_742 VSS VDD FILLER2
XFILLER_7_538 VDD VSS FILLER4
X_11471_ _19962_/Q _11473_/B VDD VSS _18655_/D AND2X1
XFILLER_136_230 VSS VDD FILLER2
X_10422_ _10579_/D _10463_/B VDD VSS _10499_/B _10463_/C _10463_/D NAND4X2
X_13210_ _13373_/A _13373_/B _13373_/E VDD VSS _13300_/B OAI21X1
X_14190_ _14136_/Y _14190_/B _14190_/C VDD VSS _18940_/D AND3BX1
XFILLER_125_926 VDD VSS FILLER4
XFILLER_125_948 VSS VDD FILLER2
XFILLER_3_700 VDD VSS FILLER1
X_10353_ _10595_/A _10388_/C VDD VSS _10354_/B NAND2X1
X_13141_ _13141_/A _13141_/B _13141_/C _13141_/D VDD VSS _13329_/B AOAI211X1
XFILLER_124_458 VSS VDD FILLER2
XTAP_TAPCELL_ROW_118_1196 VDD VSS WELLTAP
XTAP_TAPCELL_ROW_131_1330 VDD VSS WELLTAP
X_13072_ _18967_/Q _14218_/B VDD VSS _13083_/B XNOR2X1
XFILLER_105_661 VDD VSS DECAPHV8
XFILLER_2_254 VDD VSS FILLER1
X_10284_ _18630_/Q _18792_/Q VDD VSS _10338_/A NAND2X1
X_12023_ _12023_/A _12023_/B _14370_/B VDD VSS _12024_/B MIN3X1
X_16900_ _16976_/A _16900_/B VDD VSS _19735_/D NOR2X1
X_17880_ _18853_/Q _17880_/B _17880_/C VDD VSS _17885_/C MIN3X1
XFILLER_38_409 VSS VDD FILLER2
XFILLER_76_41 VDD VSS FILLER4
X_16831_ _16838_/A _16831_/B VDD VSS _19672_/D NOR2X1
XFILLER_93_537 VDD VSS FILLER1
X_19550_ _19551_/CK _19550_/D _19550_/Q VDD VSS DFFQX1
X_16762_ _16775_/A _16762_/B VDD VSS _19610_/D NOR2X1
XFILLER_19_656 VDD VSS FILLER1
XFILLER_46_431 VSS VDD FILLER2
X_13974_ _18894_/Q _13974_/B _14020_/C VDD VSS _17945_/C XNOR3X1
Xdelaybuf_4_sclk delaybuf_4_sclk/A VDD VSS delaybuf_4_sclk/Y BUFX12
X_18501_ _18503_/CK _18522_/Q _20114_/A _18503_/RB VDD VSS DFFRQX1
X_15713_ _15739_/A _15713_/B VDD VSS _19339_/D NOR2X1
XFILLER_46_453 VDD VSS DECAPHV8
XFILLER_46_475 VDD VSS FILLER1
XFILLER_73_261 VSS VDD FILLER2
XFILLER_74_784 VDD VSS FILLER1
XTAP_TAPCELL_ROW_76_779 VDD VSS WELLTAP
X_12925_ _19133_/Q _13107_/D _12925_/C VDD VSS _13023_/C XNOR3X1
X_19481_ _19483_/CK _19481_/D _19481_/Q VDD VSS DFFQX1
X_16693_ _16693_/A _16704_/B VDD VSS _19548_/D NOR2X1
XFILLER_15_840 VDD VSS DECAPHV16
X_12856_ _19161_/Q _13039_/A _13108_/B VDD VSS _13107_/D XNOR3X1
X_18432_ _18438_/CK _18496_/D _18432_/Q _18464_/RB VDD VSS DFFRQX1
X_15644_ _19384_/Q _15644_/B _15644_/C VDD VSS _15654_/B MIN3X1
XFILLER_15_862 VDD VSS FILLER1
XFILLER_61_456 VSS VDD FILLER2
X_11807_ _19202_/Q _11807_/B _11828_/D VDD VSS _11830_/C XNOR3X1
X_18363_ _18367_/CK _18512_/Q _20200_/A _18464_/RB VDD VSS DFFRQX1
X_15575_ _19466_/Q _15855_/B VDD VSS _15601_/B XNOR2X1
XFILLER_14_372 VDD VSS DECAPHV8
XFILLER_15_884 VDD VSS FILLER4
XFILLER_42_681 VDD VSS FILLER1
X_12787_ _13177_/A _17876_/B VDD VSS _18852_/D NOR2X1
X_14526_ _14526_/A _14526_/B _17827_/B VDD VSS _19232_/D AOI21X1
X_17314_ _17318_/A _17315_/B _17363_/C VDD VSS _17315_/C OAI21X1
XTAP_TAPCELL_ROW_31_326 VDD VSS WELLTAP
X_11738_ _11768_/A _11768_/B VDD VSS _14485_/B XNOR2X1
X_18294_ _18295_/CK _18294_/D _18294_/Q VDD VSS DFFQX1
XFILLER_128_720 VSS VDD FILLER2
X_11669_ _18808_/Q _11669_/B VDD VSS _18835_/D AND2X1
X_14457_ _14457_/A VDD VSS _14493_/A BUFX3
X_17245_ _17247_/B _17245_/B VDD VSS _17246_/B XOR2X1
X_13408_ _13509_/A _13509_/B _13509_/C _13509_/D VDD VSS _13607_/A AOI31X1
X_14388_ _14410_/A _14388_/B _14388_/C VDD VSS _19110_/D NOR3X1
X_17176_ _19789_/Q _19757_/Q _17176_/C VDD VSS _17180_/C MIN3X1
XFILLER_115_425 VDD VSS FILLER4
XFILLER_127_263 VSS VDD FILLER2
XFILLER_6_571 VDD VSS DECAPHV32
X_13339_ _13339_/A _14543_/B VDD VSS _13447_/A OR2X2
X_16127_ _19716_/Q VDD VSS _16150_/A INVX1
XFILLER_142_266 VDD VSS FILLER1
XFILLER_44_2 VDD VSS FILLER1
X_16058_ _19616_/Q VDD VSS _16059_/A INVX1
X_15009_ _19532_/Q _19533_/Q VDD VSS _15058_/B _15009_/C NAND3X1
XFILLER_57_707 VDD VSS FILLER1
X_19817_ _19863_/CK _19817_/D _19817_/Q VDD VSS DFFQX1
XFILLER_111_675 VDD VSS DECAPHV8
XFILLER_56_206 VDD VSS FILLER4
XFILLER_69_589 VDD VSS FILLER4
XTAP_TAPCELL_ROW_39_404 VDD VSS WELLTAP
XFILLER_37_442 VSS VDD FILLER2
X_09501_ _18465_/D _09501_/B _09506_/C _20075_/Q VDD VSS _20075_/D AO22X2
X_19748_ _19792_/CK _19748_/D _19748_/Q VDD VSS DFFQX1
XFILLER_37_464 VDD VSS FILLER1
XFILLER_64_261 VDD VSS FILLER4
X_19679_ _19711_/CK _19679_/D _19679_/Q VDD VSS DFFQX1
XFILLER_25_648 VSS VDD FILLER2
XTAP_TAPCELL_ROW_47_481 VDD VSS WELLTAP
X_09432_ _09673_/C VDD VSS _09696_/B BUFX3
XFILLER_52_445 VSS VDD FILLER2
X_09363_ _09630_/C _09753_/A _09354_/Y VDD VSS _18504_/D MUX2X1
XFILLER_80_798 VSS VDD FILLER2
XANTENNA_10 _18346_/Q VDD VSS ANTENNA2
XANTENNA_21 _15836_/C VDD VSS ANTENNA2
XANTENNA_32 _18127_/B VDD VSS ANTENNA2
XFILLER_21_865 VDD VSS FILLER1
X_09294_ _18199_/A _09294_/B VDD VSS _20023_/D NOR2X1
XFILLER_115_8 VDD VSS DECAPHV8
XFILLER_21_47 VDD VSS DECAPHV8
XFILLER_106_436 VDD VSS FILLER1
XFILLER_106_458 VDD VSS FILLER1
XFILLER_97_18 VSS VDD FILLER2
XFILLER_0_703 VDD VSS FILLER1
XFILLER_121_406 VDD VSS DECAPHV16
XFILLER_134_789 VDD VSS FILLER1
XFILLER_79_309 VDD VSS FILLER4
Xoutput150 _20205_/Y VDD VSS o_uwb_tx_cfg[8] BUFX3
XFILLER_87_320 VDD VSS FILLER1
XFILLER_101_141 VSS VDD FILLER2
XFILLER_87_331 VDD VSS DECAPHV8
XFILLER_29_921 VDD VSS FILLER4
XFILLER_87_375 VDD VSS FILLER1
XTAP_TAPCELL_ROW_109_1107 VDD VSS WELLTAP
XFILLER_101_185 VDD VSS FILLER1
XFILLER_46_77 VDD VSS FILLER1
X_10971_ _11007_/A _10971_/B VDD VSS _10972_/B XNOR2X1
XTAP_TAPCELL_ROW_73_749 VDD VSS WELLTAP
X_12710_ _12710_/A _12717_/D VDD VSS _12713_/B XNOR2X1
X_13690_ _19028_/Q _14295_/B VDD VSS _13736_/A NAND2X1
XFILLER_70_231 VDD VSS FILLER1
X_12641_ _12804_/A _12804_/B _12804_/C VDD VSS _12689_/B AOI21X1
XFILLER_102_94 VDD VSS FILLER4
XFILLER_62_32 VDD VSS FILLER1
XFILLER_62_76 VSS VDD FILLER2
X_12572_ _12837_/A _12837_/B VDD VSS _14505_/B XNOR2X1
X_15360_ _15360_/A _15398_/C VDD VSS _15396_/B XNOR2X1
XFILLER_11_375 VDD VSS DECAPHV8
XFILLER_134_0 VSS VDD FILLER2
X_11523_ _18675_/Q _11531_/B VDD VSS _18702_/D AND2X1
X_14311_ _14311_/A _14311_/B VDD VSS _19043_/D NOR2X1
X_15291_ _15303_/B _15291_/B VDD VSS _15720_/B XNOR2X1
X_11454_ _19947_/Q _11460_/B VDD VSS _18640_/D AND2X1
X_14242_ _14251_/A _14242_/B VDD VSS _18984_/D NOR2X1
X_17030_ _17030_/A _17030_/B VDD VSS _17045_/A OR2X2
XFILLER_109_274 VDD VSS FILLER1
XFILLER_7_379 VDD VSS DECAPHV8
X_10405_ _10405_/A _10405_/B _10405_/C _10405_/D VDD VSS _10406_/B AOAI211X1
X_11385_ _18594_/Q _11390_/B VDD VSS _11387_/B XNOR2X1
X_14173_ _14174_/B _14173_/B _15836_/C VDD VSS _18925_/D OA21X2
XFILLER_112_417 VDD VSS FILLER1
XFILLER_11_91 VSS VDD FILLER2
XFILLER_125_789 VDD VSS FILLER1
XFILLER_98_607 VDD VSS DECAPHV8
X_10336_ _18631_/Q _18793_/Q VDD VSS _10338_/C NAND2X1
X_13124_ _14477_/B _19190_/Q VDD VSS _13233_/A NAND2BX1
X_18981_ _19037_/CK _18981_/D _18981_/Q VDD VSS DFFQX1
XFILLER_140_748 VSS VDD FILLER2
X_10267_ _11438_/A _11435_/B _11435_/A VDD VSS _10763_/A NAND3BX2
X_13055_ _13255_/A _13255_/C VDD VSS _13056_/C NAND2X1
X_17932_ _17940_/B _17940_/C VDD VSS _17933_/B NOR2X1
XFILLER_39_718 VSS VDD FILLER2
XFILLER_94_802 VDD VSS FILLER1
X_12006_ _19038_/Q _12076_/B _12016_/C VDD VSS _14273_/B XNOR3X1
X_17863_ _18850_/Q _17863_/B _17863_/C VDD VSS _17866_/A MIN3X1
XFILLER_120_472 VDD VSS DECAPHV8
XFILLER_78_364 VDD VSS DECAPHV8
XFILLER_94_824 VSS VDD FILLER2
XFILLER_94_846 VDD VSS FILLER4
X_10198_ _18618_/Q _10202_/B VDD VSS _10200_/C XOR2X1
X_19602_ _19604_/CK _19602_/D _19602_/Q VDD VSS DFFQX1
XFILLER_38_239 VDD VSS FILLER4
XFILLER_94_857 VSS VDD FILLER2
X_17794_ _17795_/C _18127_/B _17794_/C VDD VSS _19922_/D AND3BX1
X_16814_ _16826_/A _16814_/B VDD VSS _19656_/D NOR2X1
XFILLER_19_475 VSS VDD FILLER2
XFILLER_35_924 VSS VDD FILLER2
X_13957_ _13957_/A _14198_/B _13957_/C _13957_/D VDD VSS _14036_/A OAOI211X1
X_19533_ _19533_/CK _19533_/D _19533_/Q VDD VSS DFFQX1
X_16745_ _16748_/A _16745_/B VDD VSS _19595_/D NOR2X1
XFILLER_46_272 VDD VSS DECAPHV8
XFILLER_62_732 VDD VSS DECAPHV8
XFILLER_74_570 VSS VDD FILLER2
XTAP_TAPCELL_ROW_140_1418 VDD VSS WELLTAP
X_12908_ _14349_/B _14349_/C _19076_/Q VDD VSS _12915_/B AOI21X1
X_19464_ _19466_/CK _19464_/D _19464_/Q VDD VSS DFFQX1
X_16676_ _19576_/Q VDD VSS _16677_/A INVX1
X_13888_ _18976_/Q _14231_/B VDD VSS _13957_/A AND2X1
X_18415_ _18423_/CK _18415_/D _18415_/Q _18444_/RB VDD VSS DFFRQX1
X_15627_ _19384_/Q _15762_/B VDD VSS _15628_/B XNOR2X1
XTAP_TAPCELL_ROW_44_451 VDD VSS WELLTAP
XTAP_TAPCELL_ROW_7_81 VDD VSS WELLTAP
X_12839_ _12839_/A _14506_/B _14506_/C VDD VSS _12840_/D NOR3X1
X_19395_ _19425_/CK _19395_/D _19395_/Q VDD VSS DFFQX1
XTAP_TAPCELL_ROW_16_175 VDD VSS WELLTAP
X_18346_ _18356_/CK _18346_/D _18346_/Q _20072_/RB VDD VSS DFFRQX1
X_15558_ _19353_/Q _15728_/B VDD VSS _15566_/B XNOR2X1
XFILLER_30_651 VDD VSS FILLER1
X_14509_ _14539_/A _14509_/B VDD VSS _19216_/D NOR2X1
X_18277_ _18277_/CK _18277_/D _18277_/Q _09270_/Y VDD VSS DFFRQX1
X_15489_ _15525_/A _15489_/B VDD VSS _15756_/B XNOR2X1
XTAP_TAPCELL_ROW_0_3 VDD VSS WELLTAP
X_17228_ _19801_/Q _19769_/Q VDD VSS _17230_/B XNOR2X1
XFILLER_128_561 VDD VSS FILLER1
XFILLER_115_233 VDD VSS DECAPHV16
XFILLER_143_531 VDD VSS FILLER1
X_09976__246 _20079_/CK VDD VSS _18523_/CK INVX1
X_17159_ _19786_/Q _19754_/Q VDD VSS _17160_/C NAND2X1
XFILLER_131_715 VDD VSS DECAPHV16
X_09981_ _09981_/A _11399_/C _09981_/C VDD VSS _09996_/B AOI21X1
X_20170_ _20170_/A VDD VSS _20170_/Y BUFX3
XFILLER_112_940 VDD VSS DECAPHV8
XFILLER_97_662 VDD VSS FILLER4
XFILLER_57_526 VSS VDD FILLER2
XFILLER_97_684 VSS VDD FILLER2
XFILLER_111_494 VDD VSS DECAPHV8
XFILLER_53_721 VDD VSS DECAPHV16
XFILLER_41_905 VSS VDD FILLER2
XFILLER_53_765 VDD VSS FILLER4
X_09415_ _20067_/Q _20015_/Q VDD VSS _09421_/A NAND2X1
XFILLER_41_949 VDD VSS FILLER1
XFILLER_80_573 VSS VDD FILLER2
XTAP_TAPCELL_ROW_104_1059 VDD VSS WELLTAP
XTAP_TAPCELL_ROW_70_719 VDD VSS WELLTAP
X_09346_ _20075_/RB _09346_/B VDD VSS _09346_/Y NOR2BX1
X_09277_ _09277_/A _09277_/B VDD VSS _09351_/C NAND2X1
XFILLER_138_336 VDD VSS FILLER4
XFILLER_32_57 VDD VSS FILLER4
XFILLER_134_542 VDD VSS FILLER1
XTAP_TAPCELL_ROW_115_1166 VDD VSS WELLTAP
X_11170_ _18655_/Q _18817_/Q VDD VSS _11204_/A XNOR2X1
XFILLER_0_522 VDD VSS FILLER1
XFILLER_106_299 VDD VSS FILLER4
XFILLER_134_597 VDD VSS FILLER1
X_10121_ _10122_/A _10123_/C _10123_/B VDD VSS _10124_/B OR3BX1
XFILLER_0_555 VDD VSS FILLER4
XFILLER_88_640 VDD VSS FILLER1
X_10052_ _10180_/A _11410_/C VDD VSS _18532_/D NOR2X1
XFILLER_0_588 VSS VDD FILLER2
XFILLER_121_269 VDD VSS FILLER1
XFILLER_87_161 VSS VDD FILLER2
X_14860_ _14861_/B _14861_/C _14861_/A VDD VSS _14911_/B OAI21X1
XFILLER_75_356 VDD VSS DECAPHV16
XFILLER_91_816 VSS VDD FILLER2
XFILLER_91_827 VDD VSS DECAPHV8
XTAP_TAPCELL_ROW_86_874 VDD VSS WELLTAP
X_13811_ _13812_/B _13877_/B _18891_/Q VDD VSS _13868_/B AOI21X1
X_14791_ _14872_/D _14826_/C VDD VSS _14872_/C NAND2X1
XFILLER_44_710 VDD VSS FILLER1
XFILLER_90_348 VDD VSS FILLER1
XTAP_TAPCELL_ROW_58_598 VDD VSS WELLTAP
X_13742_ _17920_/A _17920_/B _17921_/C VDD VSS _17925_/B OAI21X1
Xclkbuf_leaf_9__000_ clkbuf_leaf_9__000_/A VDD VSS _19737_/CK BUFX12
X_16530_ _16548_/A _16548_/B VDD VSS _16789_/B XNOR2X1
XFILLER_16_467 VSS VDD FILLER2
XTAP_TAPCELL_ROW_126_1273 VDD VSS WELLTAP
X_10954_ _10954_/A _10954_/B _10954_/C _10954_/D VDD VSS _10957_/C AOAI211X1
X_10885_ _10885_/A _10885_/B _10885_/C VDD VSS _10888_/B OAI21X1
X_13673_ _13807_/A _13807_/B _13807_/C VDD VSS _13741_/B AOI21X1
X_18200_ _20014_/Q _20016_/Q _18201_/A VDD VSS _18200_/Y AOI2B1X1
X_16461_ _19696_/Q _16857_/B VDD VSS _16469_/C XOR2X1
XTAP_TAPCELL_ROW_41_421 VDD VSS WELLTAP
X_12624_ _19019_/Q VDD VSS _12892_/A INVX1
X_19180_ _19215_/CK _19180_/D _19180_/Q VDD VSS DFFQX1
X_16392_ _16377_/B _16392_/B VDD VSS _16402_/B NAND2BX1
X_15412_ _19377_/Q _15754_/B VDD VSS _15425_/C XOR2X1
XFILLER_129_314 VDD VSS FILLER4
XTAP_TAPCELL_ROW_13_145 VDD VSS WELLTAP
X_12555_ _12593_/A _12593_/B _12556_/D _12593_/E VDD VSS _14378_/B OA211X2
X_18131_ _18131_/A _18131_/B _18131_/C VDD VSS _18136_/B OA21X2
X_15343_ _15343_/A _15343_/B VDD VSS _15376_/B AND2X1
XFILLER_129_347 VDD VSS DECAPHV8
XFILLER_12_684 VDD VSS FILLER1
XFILLER_12_695 VSS VDD FILLER2
XFILLER_7_121 VSS VDD FILLER2
X_11506_ _18660_/Q _11508_/B VDD VSS _18687_/D AND2X1
X_18062_ _18064_/A _18064_/B _18062_/C VDD VSS _19987_/D AOI21X1
XFILLER_7_143 VSS VDD FILLER2
XFILLER_8_688 VDD VSS DECAPHV8
X_12486_ _12486_/A _12486_/B _12497_/C VDD VSS _12566_/B XNOR3X1
X_17013_ _17019_/C _17013_/B VDD VSS _17014_/B XOR2X1
X_15274_ _15274_/A _15274_/B _15274_/C _15274_/D VDD VSS _15307_/C AOAI211X1
XFILLER_7_198 VSS VDD FILLER2
X_11437_ _232_/E _11438_/B _11437_/C VDD VSS _18627_/D NOR3X1
X_14225_ _14294_/A wire155/Y _14225_/C VDD VSS _18971_/D NOR3X1
XFILLER_99_938 VDD VSS DECAPHV8
X_11368_ _11368_/A _11375_/C VDD VSS _11369_/B XOR2X1
X_14156_ _14186_/A _14156_/B VDD VSS _18911_/D NOR2X1
XFILLER_125_586 VDD VSS FILLER1
XFILLER_4_894 VDD VSS FILLER4
X_10319_ _18657_/Q _18765_/Q VDD VSS _10323_/A NAND2X1
X_13107_ _13107_/A _13107_/B _13107_/C _13107_/D VDD VSS _13111_/B AOAI211X1
XFILLER_140_556 VSS VDD FILLER2
XFILLER_140_567 VSS VDD FILLER2
X_11299_ _11182_/Y _11370_/B _11370_/A VDD VSS _11308_/C MUX2X1
X_14087_ _18925_/Q _14174_/B _14173_/B VDD VSS _14089_/C NOR3X1
X_18964_ _18993_/CK _18964_/D _18964_/Q VDD VSS DFFQX1
XFILLER_39_515 VDD VSS FILLER1
XFILLER_66_312 VDD VSS FILLER4
X_13038_ _13039_/A _13039_/B _13039_/D _13039_/C VDD VSS _13138_/B OAOI211X1
X_18895_ _19197_/CK _18895_/D _18895_/Q VDD VSS DFFQX1
X_17915_ _17920_/B _17915_/B VDD VSS _17919_/B NOR2X1
XFILLER_78_172 VDD VSS DECAPHV16
XTAP_TAPCELL_ROW_49_510 VDD VSS WELLTAP
X_17846_ _17847_/C _17846_/B _17846_/C VDD VSS _19937_/D AOI21X1
XFILLER_26_209 VSS VDD FILLER2
XFILLER_81_315 VSS VDD FILLER2
XFILLER_93_197 VDD VSS FILLER4
X_19516_ _19543_/CK _19516_/D _19516_/Q VDD VSS DFFQX1
X_17777_ _19919_/Q _19887_/Q VDD VSS _17778_/B XOR2X1
X_14989_ _19311_/Q _14989_/B _15682_/B VDD VSS _15036_/B MIN3X1
X_16728_ _16735_/A _16728_/B VDD VSS _19579_/D NOR2X1
XFILLER_22_415 VSS VDD FILLER2
XFILLER_35_787 VSS VDD FILLER2
X_19447_ _19489_/CK _19447_/D _19447_/Q VDD VSS DFFQX1
X_16659_ _19640_/Q _16673_/A VDD VSS _16660_/B XNOR2X1
X_09200_ _18511_/Q VDD VSS _18442_/D INVX1
X_19378_ _19385_/CK _19378_/D _19378_/Q VDD VSS DFFQX1
X_18329_ _18342_/CK _18510_/Q _20083_/A _18373_/RB VDD VSS DFFRQX1
XFILLER_108_509 VSS VDD FILLER2
XFILLER_135_328 VDD VSS DECAPHV16
XFILLER_104_704 VSS VDD FILLER2
XFILLER_118_49 VDD VSS DECAPHV16
X_20222_ _20222_/A VDD VSS _20222_/Y BUFX3
XFILLER_103_225 VSS VDD FILLER2
XFILLER_1_319 VDD VSS FILLER1
X_20153_ _20153_/A VDD VSS _20153_/Y BUFX3
XFILLER_104_759 VDD VSS FILLER4
X_09895_ _11208_/A _09895_/B _09895_/C _09895_/D VDD VSS _09935_/B AOI211X1
X_20084_ _20084_/A VDD VSS _20084_/Y BUFX3
XFILLER_57_334 VDD VSS DECAPHV8
XFILLER_69_194 VSS VDD FILLER2
XFILLER_85_654 VDD VSS DECAPHV16
XFILLER_84_142 VDD VSS FILLER4
XFILLER_14_905 VSS VDD FILLER2
XFILLER_25_220 VDD VSS FILLER1
XTAP_TAPCELL_ROW_55_568 VDD VSS WELLTAP
XTAP_TAPCELL_ROW_83_844 VDD VSS WELLTAP
XFILLER_14_916 VDD VSS FILLER4
XFILLER_26_776 VDD VSS FILLER1
XFILLER_13_448 VDD VSS FILLER1
X_10670_ _18561_/Q _10670_/B VDD VSS _10671_/A NAND2X1
XFILLER_40_245 VDD VSS FILLER1
X_09329_ _18287_/Q _18515_/Q _09299_/Y VDD VSS _09329_/Y MUXI2X1
XFILLER_127_807 VSS VDD FILLER2
XTAP_TAPCELL_ROW_10_115 VDD VSS WELLTAP
X_12340_ _12354_/A _12354_/B _14210_/B VDD VSS _14179_/B XNOR3X1
XFILLER_119_391 VSS VDD FILLER2
XFILLER_126_328 VDD VSS FILLER4
XFILLER_135_840 VDD VSS DECAPHV16
XFILLER_5_625 VDD VSS DECAPHV16
X_12271_ _18873_/Q _14113_/B VDD VSS _12272_/B OR2X2
XFILLER_135_862 VDD VSS FILLER1
X_11222_ _11222_/A _11222_/B VDD VSS _11241_/A AND2X1
X_14010_ wire154/Y _14010_/B _14010_/C _14010_/D VDD VSS _14268_/B OAOI211X1
XFILLER_134_361 VDD VSS FILLER4
XFILLER_122_534 VSS VDD FILLER2
XFILLER_122_567 VSS VDD FILLER2
X_11153_ _10881_/B _11152_/Y _11289_/A VDD VSS _11159_/B MUXI2X1
XFILLER_0_363 VSS VDD FILLER2
XFILLER_1_875 VSS VDD FILLER2
X_10104_ _10090_/Y _10103_/Y _10127_/A VDD VSS _10129_/B MUX2X1
X_11084_ _18573_/Q _11084_/B VDD VSS _11086_/C XOR2X1
X_15961_ _19581_/Q _15961_/B _16730_/B VDD VSS _15993_/A MIN3X1
XFILLER_0_396 VDD VSS FILLER1
XFILLER_49_835 VSS VDD FILLER2
XFILLER_68_97 VDD VSS DECAPHV8
XFILLER_88_481 VDD VSS FILLER4
XFILLER_88_492 VDD VSS FILLER4
X_10035_ _09950_/Y _10033_/Y _10167_/A VDD VSS _10035_/Y MUXI2X1
X_18680_ _18817_/CK _18680_/D _18680_/Q VDD VSS DFFQX1
X_17700_ _17702_/B _17700_/B VDD VSS _17701_/B XOR2X1
X_15892_ _15895_/A _15892_/B VDD VSS _19499_/D NOR2X1
X_14912_ _14956_/A _14956_/B VDD VSS _14940_/A AND2X1
XFILLER_36_518 VSS VDD FILLER2
XFILLER_64_816 VDD VSS FILLER4
XFILLER_76_654 VDD VSS DECAPHV16
X_17631_ _17634_/C _17632_/B _17654_/C VDD VSS _17632_/C OAI21X1
X_14843_ _19420_/Q _14911_/A _15803_/B VDD VSS _15770_/B XNOR3X1
XFILLER_57_890 VDD VSS FILLER4
XFILLER_64_838 VDD VSS FILLER1
XFILLER_84_63 VDD VSS FILLER1
XFILLER_17_743 VDD VSS FILLER1
X_11986_ _12099_/B _14494_/C _19205_/Q VDD VSS _11987_/D AND3BX1
X_17562_ _17712_/B _17562_/B _17562_/C VDD VSS _17567_/C MIN3X1
X_14774_ _19418_/Q _14774_/B _14774_/C VDD VSS _14813_/B MIN3X1
XFILLER_17_90 VSS VDD FILLER2
XFILLER_32_702 VDD VSS FILLER1
XFILLER_72_882 VDD VSS FILLER1
X_10937_ _10937_/A _10967_/C VDD VSS _10943_/B XNOR2X1
X_13725_ _19058_/Q _13725_/B _13781_/C VDD VSS _13783_/C XOR3X1
Xclkbuf_2_1__f__09182_ clkbuf_0__09182_/Y VDD VSS _18595_/CK BUFX12
X_19301_ _19304_/CK _19301_/D _19301_/Q VDD VSS DFFQX1
X_17493_ _17496_/A _17493_/B _17493_/C VDD VSS _19857_/D AOI21X1
X_16513_ _16776_/A VDD VSS _16735_/A BUFX3
X_13656_ _13656_/A _13656_/B _14194_/B _13656_/D _13656_/E VDD VSS _13748_/C OAI221X1
X_19232_ _19234_/CK _19232_/D _19232_/Q VDD VSS DFFQX1
X_16444_ _16469_/A _16469_/B VDD VSS _16462_/A NAND2X1
XFILLER_20_919 VDD VSS FILLER1
X_10868_ _18673_/Q _18781_/Q VDD VSS _10873_/A XOR2X1
X_12607_ _17861_/A _17862_/A _17861_/B VDD VSS _17869_/B XNOR3X1
X_19163_ _19194_/CK _19163_/D _19163_/Q VDD VSS DFFQX1
XFILLER_31_278 VDD VSS FILLER1
X_10799_ _18671_/Q _18779_/Q VDD VSS _10801_/C XOR2X1
X_13587_ _13656_/D _13688_/A _13675_/B VDD VSS _13589_/D XNOR3X1
X_18114_ _18114_/A VDD VSS _18117_/B INVX1
X_16375_ _16398_/A _16375_/B VDD VSS _16783_/B XOR2X1
XFILLER_118_829 VDD VSS FILLER4
XTAP_TAPCELL_ROW_4_60 VDD VSS WELLTAP
X_12538_ _12630_/A _12803_/B VDD VSS _14314_/B XNOR2X1
X_19094_ _19124_/CK _19094_/D _19094_/Q VDD VSS DFFQX1
X_15326_ _15347_/A _15347_/B _15347_/C VDD VSS _15327_/B AOI21X1
XFILLER_117_328 VDD VSS FILLER4
X_12469_ _19128_/Q _14407_/B VDD VSS _12593_/E _14407_/C NAND3X1
X_18045_ _18048_/B _18045_/B _18045_/C _18049_/D VDD VSS _19980_/D OAI31X1
X_15257_ _15672_/A _18118_/B VDD VSS _19289_/D NOR2X1
X_14208_ _14218_/A _14208_/B VDD VSS _18957_/D NOR2X1
XFILLER_141_832 VDD VSS FILLER1
XFILLER_98_223 VSS VDD FILLER2
X_15188_ _19511_/Q _15905_/B VDD VSS _15275_/D NOR2BX1
XFILLER_113_534 VSS VDD FILLER2
XFILLER_113_556 VSS VDD FILLER2
XFILLER_99_779 VDD VSS FILLER1
X_14139_ _14136_/Y _14139_/B _14139_/C VDD VSS _18896_/D AND3BX1
X_19996_ _19999_/CK _19996_/D _19996_/Q VDD VSS DFFQX1
XFILLER_113_589 VSS VDD FILLER2
XFILLER_140_353 VDD VSS FILLER1
XFILLER_141_898 VDD VSS FILLER1
Xclkbuf_0__09172_ _18221_/ECK VDD VSS clkbuf_0__09172_/Y BUFX12
X_18947_ _19004_/CK _18947_/D _18947_/Q VDD VSS DFFQX1
X_09680_ _09680_/A _09680_/B VDD VSS _09681_/B _09680_/C NAND3X1
XFILLER_12_0 VSS VDD FILLER2
XFILLER_39_345 VDD VSS DECAPHV16
XFILLER_55_827 VDD VSS FILLER1
X_18878_ _18878_/CK _18878_/D _18878_/Q VDD VSS DFFQX1
XFILLER_54_337 VDD VSS DECAPHV8
XFILLER_94_473 VSS VDD FILLER2
XFILLER_94_484 VDD VSS FILLER4
X_17829_ _19930_/Q _19931_/Q _17829_/C VDD VSS _19931_/D AOI21X1
XFILLER_81_156 VDD VSS FILLER1
XFILLER_120_28 VDD VSS FILLER1
XFILLER_63_860 VDD VSS FILLER1
XFILLER_63_882 VDD VSS DECAPHV8
XFILLER_81_189 VDD VSS FILLER1
XTAP_TAPCELL_ROW_80_814 VDD VSS WELLTAP
XFILLER_22_212 VDD VSS DECAPHV8
XFILLER_50_543 VSS VDD FILLER2
XTAP_TAPCELL_ROW_101_1029 VDD VSS WELLTAP
XTAP_TAPCELL_ROW_52_538 VDD VSS WELLTAP
XFILLER_22_267 VSS VDD FILLER2
XFILLER_109_818 VDD VSS FILLER1
XFILLER_136_626 VDD VSS FILLER4
XFILLER_108_328 VDD VSS DECAPHV8
XFILLER_135_158 VDD VSS DECAPHV8
Xclkbuf_leaf_8__001_ clkload41/A VDD VSS _19234_/CK BUFX12
XTAP_TAPCELL_ROW_0_18 VDD VSS WELLTAP
Xmax_cap171 _10263_/A VDD VSS wire170/A BUFX6
Xmax_cap160 _12181_/A VDD VSS _12147_/A BUFX4
XFILLER_104_534 VDD VSS DECAPHV8
XFILLER_132_843 VDD VSS FILLER1
XTAP_TAPCELL_ROW_112_1136 VDD VSS WELLTAP
X_20205_ _20205_/A VDD VSS _20205_/Y BUFX3
Xmax_cap182 _18522_/Q VDD VSS _18469_/D BUFX8
XFILLER_131_375 VSS VDD FILLER2
X_09947_ _18576_/Q _09947_/B VDD VSS _09999_/C NOR2BX1
X_20136_ _20136_/A VDD VSS _20136_/Y BUFX3
XFILLER_38_45 VDD VSS FILLER1
X_20067_ clkload5/A _20067_/D _20067_/Q _20069_/RB VDD VSS DFFRQX1
XFILLER_100_762 VDD VSS FILLER4
X_09878_ _18565_/Q _09878_/B VDD VSS _09911_/B XNOR2X1
XFILLER_85_484 VDD VSS DECAPHV8
XTAP_TAPCELL_ROW_96_980 VDD VSS WELLTAP
XFILLER_45_348 VDD VSS FILLER1
XFILLER_72_134 VDD VSS FILLER4
XTAP_TAPCELL_ROW_68_693 VDD VSS WELLTAP
X_11840_ _11979_/A _14490_/B VDD VSS _11871_/B NOR2X1
XFILLER_26_573 VSS VDD FILLER2
XTAP_TAPCELL_ROW_123_1243 VDD VSS WELLTAP
X_11771_ _19992_/Q _19256_/Q VDD VSS _11778_/D XNOR2X1
XFILLER_14_746 VDD VSS DECAPHV16
X_10722_ _10722_/A _10722_/B VDD VSS _10725_/C OR2X2
X_13510_ _18999_/Q _13683_/A _13683_/B VDD VSS _13511_/D XNOR3X1
X_14490_ _14490_/A _14490_/B _14490_/C VDD VSS _19202_/D NOR3X1
XFILLER_139_420 VDD VSS DECAPHV16
X_10653_ _10686_/D _10653_/B _10653_/C _10653_/D VDD VSS _10697_/B AOI211X1
X_13441_ _19166_/Q VDD VSS _13542_/A INVX1
Xclkbuf_leaf_12__000_ clkbuf_leaf_9__000_/A VDD VSS _19730_/CK BUFX12
XFILLER_139_464 VDD VSS FILLER1
X_10584_ _11267_/A _10737_/B _10737_/C _10584_/D VDD VSS _10880_/B OAI31X1
X_13372_ _13373_/D _14292_/B VDD VSS _13509_/A NAND2X1
X_16160_ _19557_/Q _19909_/Q VDD VSS _16161_/B XNOR2X1
XFILLER_127_648 VSS VDD FILLER2
X_12323_ _20003_/Q _19267_/Q VDD VSS _12577_/A XOR2X1
Xclkload19 _18817_/CK VDD VSS clkload19/Y BUFX12
X_16091_ _16109_/B _16091_/B VDD VSS _16107_/A XNOR2X1
X_15111_ _15112_/A _15112_/B _15112_/D _15112_/C VDD VSS _15198_/B OAOI211X1
XFILLER_108_840 VDD VSS FILLER1
XFILLER_126_169 VDD VSS FILLER1
XFILLER_142_607 VDD VSS FILLER1
Xclkbuf_leaf_27__000_ clkload78/A VDD VSS _19304_/CK BUFX12
Xclkbuf_leaf_3_sclk clkbuf_leaf_3_sclk/A VDD VSS _18235_/CK BUFX12
X_15042_ _19397_/Q VDD VSS _15082_/A INVX1
XFILLER_119_92 VDD VSS FILLER1
XFILLER_135_670 VDD VSS FILLER4
XFILLER_79_41 VDD VSS DECAPHV8
X_12254_ _12254_/A _12254_/B VDD VSS _14372_/B XNOR2X1
X_11205_ _18656_/Q _18818_/Q VDD VSS _11206_/B XNOR2X1
X_12185_ _12206_/A _12210_/D VDD VSS _12449_/C XNOR2X1
X_19850_ _19863_/CK _19850_/D _19850_/Q VDD VSS DFFQX1
XFILLER_96_716 VDD VSS FILLER4
X_11136_ _18653_/Q _18815_/Q _11136_/C VDD VSS _11138_/B MIN3X1
X_19781_ _19833_/CK _19781_/D _19781_/Q VDD VSS DFFQX1
X_18801_ _18801_/CK _18801_/D _18801_/Q VDD VSS DFFQX1
XFILLER_122_397 VDD VSS FILLER4
XFILLER_96_749 VDD VSS FILLER1
X_18732_ _18785_/CK _18732_/D _18732_/Q VDD VSS DFFQX1
X_16993_ _17095_/A _16993_/B VDD VSS _19753_/D NOR2X1
XFILLER_48_120 VSS VDD FILLER2
XFILLER_49_654 VSS VDD FILLER2
XFILLER_49_676 VSS VDD FILLER2
X_11067_ _18678_/Q _18786_/Q _11067_/C VDD VSS _11068_/B MIN3X1
X_15944_ _15960_/A _15944_/B VDD VSS _16765_/B XOR2X1
XFILLER_64_613 VDD VSS FILLER1
X_10018_ _10034_/A _10018_/B _10018_/C VDD VSS _10018_/Y AO21X2
X_18663_ _18799_/CK _18663_/D _18663_/Q VDD VSS DFFQX1
X_15875_ _14522_/Y _15875_/B _15875_/C VDD VSS _19483_/D AND3BX1
XFILLER_36_359 VSS VDD FILLER2
X_18594_ _18595_/CK _18594_/D _18594_/Q VDD VSS DFFQX1
X_17614_ _17618_/A _17615_/B _17654_/C VDD VSS _17615_/C OAI21X1
X_14826_ _14826_/A _14826_/B _14826_/C _14826_/D VDD VSS _15015_/A OAOI211X1
X_17545_ _17675_/A _17545_/B VDD VSS _19869_/D NOR2X1
X_14757_ _19390_/Q _15768_/B VDD VSS _14759_/A XOR2X1
XFILLER_32_510 VDD VSS FILLER1
XFILLER_63_189 VSS VDD FILLER2
X_11969_ _11969_/A _11973_/D VDD VSS _14400_/B XNOR2X1
X_13708_ _13779_/B _13779_/C VDD VSS _14361_/B OR2X2
X_14688_ _19388_/Q _15766_/B VDD VSS _14689_/B XOR2X1
X_17476_ _17477_/A _17479_/C _17509_/C VDD VSS _17477_/C OAI21X1
X_13639_ _14453_/A _14453_/B _13639_/C VDD VSS _13640_/D AOI21X1
X_19215_ _19215_/CK _19215_/D _19215_/Q VDD VSS DFFQX1
X_16427_ _19631_/Q _16785_/B VDD VSS _16429_/C XNOR2X1
XFILLER_74_2 VDD VSS FILLER1
X_19146_ _19202_/CK _19146_/D _19146_/Q VDD VSS DFFQX1
X_16358_ _16355_/A _16358_/B _16358_/C VDD VSS _16383_/A AOI2B1X1
XFILLER_117_125 VDD VSS FILLER4
XFILLER_118_626 VDD VSS FILLER4
X_15309_ _19486_/Q _15878_/B _15878_/C _15844_/B VDD VSS _15364_/A AOI31X1
X_19077_ _19124_/CK _19077_/D _19077_/Q VDD VSS DFFQX1
X_16289_ _16289_/A _16311_/B VDD VSS _16780_/B XOR2X1
X_18028_ _18535_/Q _18030_/B VDD VSS _18029_/B XNOR2X1
XFILLER_114_854 VDD VSS DECAPHV8
XFILLER_5_82 VDD VSS FILLER4
XFILLER_101_504 VDD VSS FILLER4
XFILLER_59_429 VDD VSS DECAPHV8
XFILLER_87_727 VDD VSS DECAPHV16
XFILLER_99_565 VDD VSS FILLER1
X_09801_ _20226_/A _09811_/C _09815_/C _18326_/Q _09801_/E VDD VSS _09802_/C AOI221X1
Xfanout217 _18370_/RB VDD VSS _18492_/RB BUFX3
Xfanout206 _20051_/RB VDD VSS _18453_/RB BUFX3
X_09732_ _18354_/Q VDD VSS _20222_/A INVX1
X_19979_ _19986_/CK _19979_/D _19979_/Q VDD VSS DFFQX1
XFILLER_67_462 VSS VDD FILLER2
X_09663_ _18301_/Q _09797_/B _09813_/C _20138_/A _09663_/E VDD VSS _09664_/C AOI221X1
XFILLER_82_421 VDD VSS DECAPHV8
XTAP_TAPCELL_ROW_93_950 VDD VSS WELLTAP
X_09594_ _09812_/C _09594_/B VDD VSS _09601_/C NAND2BX1
XFILLER_36_882 VDD VSS FILLER1
XTAP_TAPCELL_ROW_65_663 VDD VSS WELLTAP
XFILLER_35_370 VSS VDD FILLER2
XTAP_TAPCELL_ROW_37_387 VDD VSS WELLTAP
XFILLER_23_554 VDD VSS FILLER1
XFILLER_24_36 VSS VDD FILLER2
XFILLER_11_738 VDD VSS FILLER1
XFILLER_23_576 VDD VSS FILLER4
XFILLER_10_248 VDD VSS FILLER4
XFILLER_109_626 VSS VDD FILLER2
XFILLER_124_607 VDD VSS FILLER4
XFILLER_105_810 VDD VSS FILLER4
XFILLER_3_948 VSS VDD FILLER2
Xhold260 hold260/A VDD VSS hold260/Y BUFX3
XFILLER_104_353 VDD VSS DECAPHV8
XFILLER_132_662 VSS VDD FILLER2
XFILLER_49_22 VSS VDD FILLER2
XFILLER_78_716 VDD VSS DECAPHV8
XFILLER_104_386 VDD VSS FILLER1
XFILLER_131_161 VDD VSS FILLER1
XFILLER_132_695 VSS VDD FILLER2
XFILLER_77_226 VDD VSS DECAPHV8
XFILLER_78_738 VDD VSS DECAPHV8
X_13990_ _13990_/A _14166_/B _13990_/C _13990_/D VDD VSS _13993_/B OAOI211X1
X_20119_ _20119_/A VDD VSS _20119_/Y BUFX3
XFILLER_100_581 VDD VSS FILLER4
XFILLER_46_635 VSS VDD FILLER2
XFILLER_86_771 VDD VSS FILLER4
X_12941_ _13108_/A _13108_/B VDD VSS _14445_/B XNOR2X1
XFILLER_18_359 VDD VSS FILLER1
XFILLER_46_668 VDD VSS FILLER1
XFILLER_65_76 VSS VDD FILLER2
X_12872_ _12779_/Y _12872_/B _18992_/Q VDD VSS _12903_/D AOI2B1X1
X_15660_ _15660_/A _15660_/B VDD VSS _18181_/B XNOR2X1
XFILLER_60_104 VDD VSS FILLER4
X_11823_ _11830_/A _11830_/B _11830_/C VDD VSS _14460_/C OR3X2
X_14611_ _19442_/Q VDD VSS _14672_/A INVX1
XFILLER_33_329 VSS VDD FILLER2
XFILLER_45_189 VDD VSS FILLER1
X_17330_ _19823_/Q _19791_/Q VDD VSS _17332_/B XOR2X1
X_15591_ _15591_/A _15591_/B _15591_/C VDD VSS _15611_/A AOI21X1
X_11754_ _19200_/Q _11797_/A _14488_/B VDD VSS _11762_/C XOR3X1
X_14542_ _15817_/A VDD VSS _15672_/A BUFX3
XFILLER_14_576 VDD VSS FILLER4
X_10705_ _10708_/A _10708_/B VDD VSS _10706_/C NOR2X1
X_11685_ _18982_/Q VDD VSS _12010_/A INVX1
X_14473_ _14490_/A _14473_/B _14473_/C VDD VSS _19186_/D NOR3X1
X_17261_ _17263_/C _17261_/B _17261_/C VDD VSS _19808_/D AOI21X1
X_10636_ _18639_/Q _18801_/Q VDD VSS _10638_/C NAND2X1
X_13424_ _19110_/Q _13616_/D _13424_/C VDD VSS _13528_/C XNOR3X1
X_19000_ _19085_/CK _19000_/D _19000_/Q VDD VSS DFFQX1
X_17192_ _17197_/C _17197_/B VDD VSS _17194_/B NAND2BX1
X_16212_ _19591_/Q _16741_/B VDD VSS _16233_/B XOR2X1
XFILLER_10_760 VDD VSS DECAPHV8
Xclkload119 _20081_/CK VDD VSS clkload119/Y INVX6
Xclkload108 _19673_/CK VDD VSS clkload108/Y INVX2
X_16143_ _19652_/Q _16809_/B VDD VSS _16154_/B XNOR2X1
XFILLER_10_793 VSS VDD FILLER2
X_10567_ _18638_/Q _18800_/Q VDD VSS _10568_/A XNOR2X1
X_13355_ _13355_/A _14448_/B VDD VSS _13430_/A OR2X2
XFILLER_143_949 VDD VSS FILLER1
X_10498_ _10581_/A _10582_/B _10582_/C _10655_/A VDD VSS _10659_/B OAI211X1
X_12306_ _12313_/A _14436_/B _12373_/C VDD VSS _14437_/C NOR3X1
X_13286_ _18912_/Q _13286_/B _13286_/C VDD VSS _14125_/B XNOR3X1
X_16074_ _16074_/A _16074_/B VDD VSS _16876_/B XNOR2X1
XFILLER_123_640 VSS VDD FILLER2
X_12237_ _14531_/B _14531_/C _19237_/Q VDD VSS _12239_/C AOI21X1
X_19902_ _19903_/CK _19902_/D _19902_/Q VDD VSS DFFQX1
X_15025_ _19396_/Q _15775_/B VDD VSS _15041_/A XNOR2X1
XFILLER_123_662 VDD VSS FILLER4
XFILLER_96_502 VDD VSS FILLER1
X_19833_ _19833_/CK _19833_/D _19833_/Q VDD VSS DFFQX1
XFILLER_111_835 VSS VDD FILLER2
XFILLER_96_524 VDD VSS FILLER1
X_12168_ _19237_/Q _12236_/D _12168_/C VDD VSS _12224_/C XNOR3X1
XFILLER_49_440 VSS VDD FILLER2
XFILLER_96_579 VSS VDD FILLER2
X_11119_ _11298_/A _11119_/B _11119_/C VDD VSS _11119_/Y OAI21X1
X_12099_ _12099_/A _12099_/B _12099_/C _12099_/D VDD VSS _12158_/A OAOI211X1
X_19764_ _19828_/CK _19764_/D _19764_/Q VDD VSS DFFQX1
X_16976_ _16976_/A _16976_/B VDD VSS _19750_/D NOR2X1
X_19695_ _19696_/CK _19695_/D _19695_/Q VDD VSS DFFQX1
X_18715_ _18797_/CK _18715_/D _18715_/Q VDD VSS DFFQX1
X_15927_ _19580_/Q _16729_/B VDD VSS _15936_/B XOR2X1
XFILLER_25_808 VDD VSS FILLER4
XFILLER_36_123 VDD VSS FILLER4
XFILLER_64_421 VDD VSS DECAPHV8
X_18646_ _19951_/CK _18646_/D _18646_/Q VDD VSS DFFQX1
XFILLER_25_819 VDD VSS FILLER1
XFILLER_91_262 VSS VDD FILLER2
XFILLER_92_774 VSS VDD FILLER2
XTAP_TAPCELL_ROW_143_1449 VDD VSS WELLTAP
X_15858_ _15858_/A _15858_/B VDD VSS _15859_/B OR2X2
XFILLER_18_882 VDD VSS FILLER1
XFILLER_91_295 VDD VSS DECAPHV8
XTAP_TAPCELL_ROW_62_633 VDD VSS WELLTAP
XTAP_TAPCELL_ROW_90_920 VDD VSS WELLTAP
Xclkbuf_leaf_7__002_ clkbuf_leaf_9__002_/A VDD VSS _18801_/CK BUFX12
X_18577_ _18582_/CK _18577_/D _18577_/Q VDD VSS DFFQX1
X_15789_ _15800_/A _15789_/B VDD VSS _19408_/D NOR2X1
X_14809_ _14809_/A _14809_/B _14809_/C VDD VSS _14896_/B OA21X2
XFILLER_60_660 VDD VSS DECAPHV8
XTAP_TAPCELL_ROW_34_357 VDD VSS WELLTAP
X_17528_ _19865_/Q _19833_/Q VDD VSS _17529_/B XNOR2X1
X_17459_ _19850_/Q _19818_/Q VDD VSS _17460_/C NAND2X1
XFILLER_118_412 VSS VDD FILLER2
XFILLER_106_607 VDD VSS DECAPHV8
XFILLER_118_467 VDD VSS FILLER1
XFILLER_134_916 VDD VSS DECAPHV8
X_19129_ _19129_/CK _19129_/D _19129_/Q VDD VSS DFFQX1
XFILLER_105_128 VDD VSS DECAPHV8
XFILLER_114_673 VDD VSS DECAPHV16
XFILLER_126_49 VDD VSS FILLER4
XFILLER_141_470 VDD VSS FILLER1
XFILLER_59_215 VDD VSS DECAPHV8
XFILLER_87_513 VDD VSS DECAPHV16
XFILLER_102_879 VDD VSS FILLER4
XFILLER_87_557 VDD VSS FILLER1
XFILLER_87_568 VDD VSS DECAPHV16
Xclkbuf_leaf_11__001_ clkload41/A VDD VSS _19988_/CK BUFX12
XFILLER_19_69 VDD VSS FILLER1
XFILLER_74_207 VDD VSS FILLER4
X_09715_ _09819_/A _09715_/B VDD VSS _09716_/E NOR2X1
XFILLER_55_443 VSS VDD FILLER2
XFILLER_83_741 VSS VDD FILLER2
X_09646_ _09753_/D _09646_/B VDD VSS _09647_/E NOR2X1
XFILLER_27_156 VDD VSS DECAPHV8
X_09577_ _09716_/B VDD VSS _09818_/C BUFX3
Xclkbuf_leaf_26__001_ clkbuf_2_3__f__001_/Y VDD VSS _19085_/CK BUFX12
XFILLER_35_68 VDD VSS FILLER4
XTAP_TAPCELL_ROW_120_1213 VDD VSS WELLTAP
XFILLER_23_351 VDD VSS DECAPHV16
XFILLER_109_401 VDD VSS FILLER1
XFILLER_137_710 VSS VDD FILLER2
X_11470_ _19961_/Q _11473_/B VDD VSS _18654_/D AND2X1
XFILLER_109_445 VDD VSS DECAPHV8
X_10421_ _10414_/Y _10421_/B _10419_/Y _10421_/D VDD VSS _10463_/D AOI2B2BX1
XFILLER_109_478 VDD VSS FILLER1
XFILLER_124_404 VSS VDD FILLER2
X_10352_ _10585_/C _10465_/B _10538_/A _10550_/A VDD VSS _10388_/C AOI211X1
X_13140_ _14512_/B _19219_/Q VDD VSS _13329_/A NAND2BX1
XTAP_TAPCELL_ROW_118_1197 VDD VSS WELLTAP
X_13071_ _13192_/A _13192_/B VDD VSS _14218_/B XNOR2X1
XFILLER_2_244 VDD VSS DECAPHV8
X_10283_ _10281_/Y _10283_/B _11438_/A _18712_/Q VDD VSS _10283_/Y AOI2B2X1
X_12022_ _12022_/A _12022_/B VDD VSS _14370_/B XNOR2X1
XFILLER_120_665 VDD VSS FILLER4
XFILLER_66_719 VDD VSS FILLER1
XFILLER_78_568 VSS VDD FILLER2
X_16830_ _16838_/A _16830_/B VDD VSS _19671_/D NOR2X1
XFILLER_59_793 VDD VSS DECAPHV16
X_13973_ _18922_/Q _13983_/B _13983_/C VDD VSS _14020_/C XNOR3X1
X_16761_ _16775_/A _16761_/B VDD VSS _19609_/D NOR2X1
XFILLER_46_421 VSS VDD FILLER2
X_12924_ _19132_/Q _14411_/B VDD VSS _13023_/A NAND2X1
X_18500_ _18503_/CK _18500_/D _20113_/A _18503_/RB VDD VSS DFFRQX1
X_15712_ _15817_/A VDD VSS _15739_/A BUFX3
XFILLER_19_668 VDD VSS FILLER1
XFILLER_73_251 VSS VDD FILLER2
X_19480_ _19483_/CK _19480_/D _19480_/Q VDD VSS DFFQX1
X_16692_ _16692_/A _16704_/B VDD VSS _19547_/D NOR2X1
XFILLER_15_830 VDD VSS FILLER4
XFILLER_34_649 VDD VSS FILLER4
XFILLER_92_41 VDD VSS FILLER4
X_12855_ _19189_/Q _13032_/B _13032_/C VDD VSS _13108_/B XNOR3X1
X_18431_ _18438_/CK _18431_/D _18431_/Q _18464_/RB VDD VSS DFFRQX1
X_15643_ _15762_/B VDD VSS _15644_/C INVX1
XFILLER_33_137 VDD VSS FILLER1
XFILLER_61_468 VDD VSS FILLER4
XFILLER_92_74 VDD VSS FILLER1
X_11806_ _19230_/Q wire165/Y _11838_/C VDD VSS _11828_/D XNOR3X1
X_12786_ _12884_/A _12884_/B _12791_/C VDD VSS _17876_/B XNOR3X1
X_18362_ _18367_/CK _18362_/D _18362_/Q _18464_/RB VDD VSS DFFRQX1
X_15574_ _15574_/A _15574_/B _15855_/B VDD VSS _15576_/A MIN3X1
XFILLER_30_800 VDD VSS FILLER4
X_11737_ _11737_/A _11737_/B _14518_/B VDD VSS _11768_/A MIN3X1
X_14525_ _14522_/Y _14525_/B _14525_/C VDD VSS _19231_/D AND3BX1
X_17313_ _17838_/A VDD VSS _17363_/C BUFX3
XFILLER_14_384 VSS VDD FILLER2
XTAP_TAPCELL_ROW_31_327 VDD VSS WELLTAP
X_18293_ _18295_/CK _18293_/D _18293_/Q VDD VSS DFFQX1
XFILLER_30_877 VDD VSS FILLER1
X_11668_ _18807_/Q _11669_/B VDD VSS _18834_/D AND2X1
X_14456_ _14456_/A _14456_/B VDD VSS _19171_/D NOR2X1
X_17244_ _19805_/Q _19773_/Q VDD VSS _17245_/B XOR2X1
X_10619_ _10619_/A _10619_/B _10619_/C _10619_/D VDD VSS _10621_/B AND4X2
X_11599_ _18744_/Q _11600_/B VDD VSS _18771_/D AND2X1
X_13407_ _14293_/C _19026_/Q _13604_/B VDD VSS _13509_/D AND3BX1
X_14387_ _14393_/A _14387_/B VDD VSS _19109_/D NOR2X1
X_17175_ _19790_/Q _19758_/Q VDD VSS _17178_/A XNOR2X1
XFILLER_116_949 VDD VSS FILLER1
XFILLER_128_798 VSS VDD FILLER2
X_13338_ _13347_/A _14513_/B _13347_/C VDD VSS _14514_/B OAI21X1
X_16126_ _19715_/Q _16126_/B _16879_/B VDD VSS _16150_/B MIN3X1
XFILLER_143_768 VDD VSS FILLER4
XFILLER_51_4 VDD VSS FILLER1
X_16057_ _16057_/A _16057_/B _16057_/C VDD VSS _16081_/B AOI21X1
X_13269_ _19053_/Q _13269_/B _14323_/C VDD VSS _13406_/A XNOR3X1
X_15008_ _19506_/Q _15018_/B VDD VSS _15013_/C AND2X1
XFILLER_111_621 VSS VDD FILLER2
XFILLER_37_2 VDD VSS FILLER1
XFILLER_97_822 VDD VSS DECAPHV8
XFILLER_111_654 VDD VSS DECAPHV8
XFILLER_69_557 VDD VSS FILLER1
XFILLER_97_888 VSS VDD FILLER2
X_19816_ _19833_/CK _19816_/D _19816_/Q VDD VSS DFFQX1
XFILLER_110_142 VDD VSS FILLER4
XFILLER_110_153 VDD VSS DECAPHV16
XFILLER_84_516 VDD VSS FILLER1
XTAP_TAPCELL_ROW_39_405 VDD VSS WELLTAP
X_19747_ clkload2/A _19747_/D _19747_/Q VDD VSS DFFQX1
X_09500_ _18496_/D _09501_/B _09506_/C _20074_/Q VDD VSS _20074_/D AO22X2
X_16959_ _19746_/Q _17049_/B _16962_/A _16962_/B VDD VSS _16960_/B AOAI211X1
XFILLER_37_476 VDD VSS FILLER4
X_19678_ _19678_/CK _19678_/D _19678_/Q VDD VSS DFFQX1
XTAP_TAPCELL_ROW_47_482 VDD VSS WELLTAP
X_09431_ _18506_/Q _18505_/Q _09630_/C VDD VSS _09673_/C NAND3BX1
X_18629_ clkload3/A _18629_/D _18629_/Q VDD VSS DFFQX1
XFILLER_80_766 VDD VSS DECAPHV8
X_09362_ _09362_/AB _09414_/D VDD VSS _09362_/Y NOR2BX1
XFILLER_33_660 VDD VSS FILLER1
XANTENNA_11 _17906_/C VDD VSS ANTENNA2
XANTENNA_22 _20114_/Y VDD VSS ANTENNA2
XFILLER_21_855 VDD VSS DECAPHV8
X_09293_ _20045_/Q _20040_/Q VDD VSS _09294_/B XOR2X1
XANTENNA_33 _18127_/B VDD VSS ANTENNA2
XFILLER_119_710 VDD VSS FILLER1
XFILLER_118_231 VDD VSS FILLER1
XFILLER_119_743 VDD VSS FILLER1
XFILLER_106_448 VDD VSS DECAPHV8
XFILLER_107_949 VDD VSS FILLER1
Xoutput151 _20206_/Y VDD VSS o_uwb_tx_cfg[9] BUFX3
Xoutput140 _20223_/Y VDD VSS o_uwb_tx_cfg[26] BUFX3
XFILLER_0_737 VDD VSS DECAPHV8
XFILLER_114_470 VDD VSS FILLER4
XFILLER_87_310 VDD VSS DECAPHV8
XFILLER_87_343 VSS VDD FILLER2
XFILLER_88_877 VDD VSS FILLER4
XFILLER_87_365 VDD VSS FILLER1
XTAP_TAPCELL_ROW_109_1108 VDD VSS WELLTAP
XFILLER_101_197 VSS VDD FILLER2
XFILLER_46_45 VDD VSS FILLER1
XFILLER_56_774 VSS VDD FILLER2
XFILLER_90_508 VSS VDD FILLER2
X_10970_ _11007_/C _11007_/B VDD VSS _10971_/B NAND2BX1
XFILLER_44_947 VSS VDD FILLER2
XFILLER_55_273 VDD VSS FILLER1
X_09629_ _20215_/A _09797_/C _09629_/C VDD VSS _09635_/B AOI21X1
XFILLER_43_446 VDD VSS FILLER1
XFILLER_70_254 VDD VSS FILLER4
X_12640_ _12640_/A _14379_/B _14379_/C VDD VSS _12804_/C NOR3X1
XFILLER_24_660 VDD VSS FILLER4
XFILLER_70_287 VSS VDD FILLER2
X_12571_ _12571_/A _12571_/B _12571_/C _12571_/D VDD VSS _12837_/A AOAI211X1
X_14310_ _14311_/A _14310_/B VDD VSS _19042_/D NOR2X1
X_11522_ _11522_/A _11641_/B VDD VSS _18701_/D NOR2X1
X_15290_ _19374_/Q _15751_/B VDD VSS _15291_/B XNOR2X1
X_11453_ _19946_/Q _11460_/B VDD VSS _18639_/D AND2X1
X_14241_ _14251_/A _14241_/B VDD VSS _18983_/D NOR2X1
XFILLER_125_724 VDD VSS FILLER1
X_10404_ _11078_/A _18715_/Q _10404_/C _10404_/D VDD VSS _10463_/B AOI22X1
X_14172_ _17172_/A VDD VSS _15836_/C BUFX3
X_11384_ _11384_/A _11390_/B _11384_/C VDD VSS _11392_/A MIN3X1
X_13123_ _13138_/A _13138_/B _13138_/C VDD VSS _14447_/B OAI21X1
XFILLER_124_267 VDD VSS DECAPHV8
XFILLER_125_768 VDD VSS FILLER1
XFILLER_98_619 VDD VSS FILLER1
X_10335_ _10372_/A _10372_/B _10372_/D _10372_/C VDD VSS _10339_/B AOI211X1
X_18980_ _19172_/CK _18980_/D _18980_/Q VDD VSS DFFQX1
XFILLER_87_52 VDD VSS FILLER1
X_10266_ _11438_/A _11432_/B _10266_/C _10266_/D VDD VSS _10266_/Y AOI22X1
X_13054_ _13054_/A _13054_/B _13150_/B _13054_/D VDD VSS _13255_/C OAI211X1
X_17931_ _18864_/Q VDD VSS _17940_/A INVX1
XFILLER_78_321 VDD VSS FILLER4
XFILLER_79_877 VDD VSS DECAPHV8
X_12005_ _19066_/Q _12080_/B _12075_/C VDD VSS _12016_/C XNOR3X1
X_17862_ _17862_/A _17862_/B VDD VSS _17863_/B XNOR2X1
XFILLER_78_376 VSS VDD FILLER2
X_10197_ _10117_/Y _10166_/C _10224_/A VDD VSS _10202_/B MUX2X1
X_19601_ _19604_/CK _19601_/D _19601_/Q VDD VSS DFFQX1
X_16813_ _16826_/A _16813_/B VDD VSS _19655_/D NOR2X1
XFILLER_120_495 VDD VSS DECAPHV8
XFILLER_47_741 VSS VDD FILLER2
X_17793_ _17793_/A _17793_/B _17793_/C _17793_/D VDD VSS _17794_/C AOAI211X1
X_13956_ _14004_/B _14232_/C _18977_/Q VDD VSS _13957_/D AND3BX1
X_19532_ _19533_/CK _19532_/D _19532_/Q VDD VSS DFFQX1
X_16744_ _16748_/A _16744_/B VDD VSS _19594_/D NOR2X1
XFILLER_46_284 VSS VDD FILLER2
X_12907_ _12996_/A _12996_/B _12996_/C VDD VSS _12978_/B AOI21X1
X_13887_ _13955_/A _13998_/B VDD VSS _14231_/B XNOR2X1
X_19463_ _19466_/CK _19463_/D _19463_/Q VDD VSS DFFQX1
X_16675_ _19608_/Q _16759_/B _16675_/C VDD VSS _16681_/A OAI21X1
XFILLER_34_457 VDD VSS FILLER4
XFILLER_62_766 VSS VDD FILLER2
XTAP_TAPCELL_ROW_140_1419 VDD VSS WELLTAP
X_12838_ _14506_/B _14506_/C _12839_/A VDD VSS _12840_/C OAI21X1
X_18414_ _18420_/CK _18414_/D _18414_/Q _09380_/B VDD VSS DFFRQX1
X_15626_ _15641_/A _15639_/A VDD VSS _15762_/B XNOR2X1
XFILLER_61_254 VDD VSS FILLER4
XFILLER_62_788 VSS VDD FILLER2
XTAP_TAPCELL_ROW_44_452 VDD VSS WELLTAP
XTAP_TAPCELL_ROW_7_82 VDD VSS WELLTAP
X_19394_ _19425_/CK _19394_/D _19394_/Q VDD VSS DFFQX1
XFILLER_14_181 VDD VSS DECAPHV8
XTAP_TAPCELL_ROW_16_176 VDD VSS WELLTAP
XTAP_TAPCELL_ROW_99_1001 VDD VSS WELLTAP
X_12769_ _19187_/Q VDD VSS _12771_/D INVX1
X_18345_ _18356_/CK _18345_/D _18345_/Q _18370_/RB VDD VSS DFFRQX1
X_15557_ _15568_/A _15568_/B VDD VSS _15728_/B XNOR2X1
XFILLER_30_674 VSS VDD FILLER2
X_14508_ _15806_/A _14508_/B _14508_/C VDD VSS _19215_/D NOR3X1
X_18276_ _18276_/CK _18276_/D _18276_/Q _09274_/Y VDD VSS DFFRQX1
X_15488_ _15525_/C _15525_/B VDD VSS _15489_/B NOR2BX1
XFILLER_30_696 VDD VSS FILLER1
XTAP_TAPCELL_ROW_0_4 VDD VSS WELLTAP
X_14439_ _14421_/Y _14439_/B _14439_/C VDD VSS _19156_/D AND3BX1
Xclkbuf_leaf_10__002_ clkbuf_leaf_9__002_/A VDD VSS _19948_/CK BUFX12
X_17227_ _17227_/A _17227_/B _17227_/C VDD VSS _17230_/A OA21X2
XFILLER_128_573 VDD VSS DECAPHV16
X_17158_ _17160_/A _17160_/B _17158_/C VDD VSS _19786_/D AOI21X1
XFILLER_42_0 VDD VSS DECAPHV8
X_09980_ _18599_/Q _09980_/B VDD VSS _09996_/A NOR2BX1
X_17089_ _17091_/B _17089_/B VDD VSS _17090_/B XOR2X1
X_16109_ _19586_/Q _16109_/B _16735_/B VDD VSS _16134_/B MIN3X1
XFILLER_88_107 VDD VSS DECAPHV8
XFILLER_85_803 VDD VSS FILLER4
XFILLER_123_28 VDD VSS DECAPHV8
XFILLER_29_229 VSS VDD FILLER2
XFILLER_96_173 VDD VSS FILLER4
XFILLER_37_240 VDD VSS FILLER4
XFILLER_38_774 VDD VSS FILLER4
XFILLER_37_273 VDD VSS FILLER1
XFILLER_93_891 VDD VSS FILLER4
XFILLER_80_530 VDD VSS FILLER4
X_09414_ _20047_/Q _09414_/B _18258_/Q _09414_/D VDD VSS _20047_/D OAI2B2BX1
XFILLER_25_468 VDD VSS DECAPHV16
XFILLER_80_596 VDD VSS DECAPHV8
X_09345_ _18442_/D _09344_/Y _09302_/A VDD VSS _18511_/D MUXI2X1
X_09276_ _09256_/C _20046_/Q _18258_/Q VDD VSS _09277_/B OR3BX1
XFILLER_20_195 VDD VSS FILLER1
XFILLER_107_724 VDD VSS FILLER4
XTAP_TAPCELL_ROW_115_1167 VDD VSS WELLTAP
XFILLER_122_727 VSS VDD FILLER2
XFILLER_134_587 VDD VSS DECAPHV8
XFILLER_79_118 VDD VSS FILLER4
X_10120_ _10120_/A _10120_/B VDD VSS _10123_/B AND2X1
XFILLER_115_790 VDD VSS DECAPHV8
XFILLER_88_652 VDD VSS DECAPHV8
X_10051_ _10051_/A _10053_/C VDD VSS _11410_/C XNOR2X1
XFILLER_88_696 VDD VSS FILLER1
XFILLER_130_793 VDD VSS FILLER4
XFILLER_48_549 VSS VDD FILLER2
XFILLER_76_869 VDD VSS DECAPHV8
XFILLER_29_763 VDD VSS FILLER1
XFILLER_44_700 VDD VSS DECAPHV8
XTAP_TAPCELL_ROW_86_875 VDD VSS WELLTAP
X_13810_ _13876_/A _14131_/B VDD VSS _13877_/B _13876_/C NAND3X1
X_14790_ _19502_/Q _15895_/B VDD VSS _14826_/C NAND2BX1
XFILLER_28_284 VDD VSS DECAPHV8
XFILLER_56_582 VDD VSS FILLER1
XFILLER_90_338 VDD VSS DECAPHV8
XTAP_TAPCELL_ROW_58_599 VDD VSS WELLTAP
X_10953_ _10954_/A _10954_/B _10954_/C _10954_/D VDD VSS _10953_/Y AOI211X1
X_13741_ _18890_/Q _13741_/B _13807_/D VDD VSS _17921_/C XNOR3X1
XFILLER_73_54 VDD VSS DECAPHV8
XTAP_TAPCELL_ROW_126_1274 VDD VSS WELLTAP
XFILLER_44_788 VSS VDD FILLER2
X_10884_ _10885_/A _10885_/B _10885_/C VDD VSS _10884_/Y NOR3X1
X_13672_ _13672_/A _14163_/B _14163_/C VDD VSS _13807_/C NOR3X1
X_16460_ _16470_/C _16460_/B VDD VSS _16857_/B AND2X1
XFILLER_31_438 VSS VDD FILLER2
XFILLER_43_287 VSS VDD FILLER2
XTAP_TAPCELL_ROW_41_422 VDD VSS WELLTAP
X_12623_ _12717_/A _12717_/B _12717_/C VDD VSS _12710_/A AOI21X1
X_16391_ _19629_/Q _16783_/B VDD VSS _16402_/A OR2X2
X_15411_ _15427_/A _15427_/B VDD VSS _15754_/B XNOR2X1
XTAP_TAPCELL_ROW_13_146 VDD VSS WELLTAP
X_12554_ _12593_/D _12656_/A _12643_/B VDD VSS _12556_/D XNOR3X1
X_18130_ _18131_/A _18131_/B _18131_/C VDD VSS _18132_/B NOR3X1
X_15342_ _19375_/Q _15752_/B VDD VSS _15376_/A NOR2BX1
XFILLER_12_674 VDD VSS DECAPHV8
X_11505_ _18659_/Q _11508_/B VDD VSS _18686_/D AND2X1
X_18061_ _18064_/A _18064_/B _18187_/C VDD VSS _18062_/C OAI21X1
X_15273_ _15311_/D VDD VSS _15274_/D INVX1
XFILLER_138_882 VDD VSS FILLER1
XFILLER_144_307 VSS VDD FILLER2
XFILLER_144_318 VDD VSS DECAPHV8
X_12485_ _19212_/Q VDD VSS _12486_/A INVX1
X_14224_ _14251_/A _14224_/B VDD VSS _18970_/D NOR2X1
X_17012_ _19756_/Q _17078_/B _17012_/C VDD VSS _17013_/B AOI21X1
XTAP_TAPCELL_ROW_137_1381 VDD VSS WELLTAP
X_11436_ _18626_/Q _18624_/Q _11436_/C _18627_/Q VDD VSS _11437_/C AOI31X1
X_11367_ _11367_/A _11367_/B _11367_/C VDD VSS _11375_/C MIN3X1
X_14155_ _14522_/A VDD VSS _14186_/A BUFX3
XFILLER_113_738 VDD VSS FILLER4
XFILLER_125_598 VDD VSS FILLER1
XFILLER_98_416 VSS VDD FILLER2
X_10318_ _10405_/A _10405_/B _10405_/D _10405_/C VDD VSS _10325_/B AOI211X1
X_13106_ _19134_/Q _14414_/B VDD VSS _13113_/C _14414_/C NAND3X1
X_14086_ wire153/Y _14086_/B _14086_/C _14086_/D VDD VSS _14173_/B OAOI211X1
X_18963_ _18993_/CK _18963_/D _18963_/Q VDD VSS DFFQX1
X_11298_ _11298_/A _11298_/B _11298_/C VDD VSS _11370_/B OAI21X1
X_13037_ _19190_/Q _13141_/A _13042_/B VDD VSS _13039_/C XNOR3X1
X_17914_ _17914_/A _17914_/B _17914_/C VDD VSS _17919_/C MIN3X1
XFILLER_39_505 VDD VSS DECAPHV8
X_10249_ _11436_/C _10362_/D _11431_/B VDD VSS _10315_/B NOR3X1
X_18894_ _18950_/CK _18894_/D _18894_/Q VDD VSS DFFQX1
XFILLER_120_270 VDD VSS FILLER4
XFILLER_66_324 VDD VSS FILLER1
XFILLER_67_836 VDD VSS FILLER1
X_17845_ _17847_/C _17846_/B _17917_/C VDD VSS _17846_/C OAI21X1
XFILLER_93_132 VSS VDD FILLER2
X_17776_ _17776_/A _17776_/B _17776_/C VDD VSS _17781_/C MIN3X1
XFILLER_19_262 VDD VSS DECAPHV8
X_19515_ _19543_/CK _19515_/D _19515_/Q VDD VSS DFFQX1
X_16727_ _16735_/A _16727_/B VDD VSS _19578_/D NOR2X1
X_14988_ _15297_/A _18084_/B VDD VSS _19283_/D AND2X1
XFILLER_19_295 VDD VSS DECAPHV8
X_13939_ _13981_/A _13981_/B _13981_/D _13981_/C VDD VSS _14135_/C AOI211X1
XFILLER_23_928 VSS VDD FILLER2
X_19446_ _19489_/CK _19446_/D _19446_/Q VDD VSS DFFQX1
X_16658_ _16675_/C _16658_/B VDD VSS _16673_/A AND2X1
XFILLER_22_427 VDD VSS FILLER1
XFILLER_50_736 VSS VDD FILLER2
X_19377_ _19385_/CK _19377_/D _19377_/Q VDD VSS DFFQX1
X_16589_ _16589_/A _16589_/B _18168_/C VDD VSS _16590_/B OAI21X1
X_15609_ _15617_/A _15609_/B VDD VSS _15699_/B XNOR2X1
X_18328_ _18343_/CK _18525_/Q _20082_/A _20072_/RB VDD VSS DFFRQX1
XFILLER_8_93 VDD VSS FILLER1
X_18259_ _18259_/CK hold260/Y output6/A _18208_/Y VDD VSS DFFRQX1
XFILLER_118_28 VDD VSS DECAPHV16
XFILLER_129_893 VDD VSS FILLER1
XFILLER_144_852 VSS VDD FILLER2
XFILLER_144_874 VDD VSS FILLER4
X_20221_ _20221_/A VDD VSS _20221_/Y BUFX3
XFILLER_104_738 VDD VSS FILLER4
X_20152_ _20152_/A VDD VSS _20152_/Y BUFX3
XFILLER_100_911 VDD VSS FILLER4
XFILLER_131_579 VDD VSS FILLER4
XFILLER_69_151 VDD VSS FILLER1
X_09894_ _10032_/A _09928_/A _09894_/C VDD VSS _09895_/D NOR3X1
X_20083_ _20083_/A VDD VSS _20083_/Y BUFX3
XFILLER_100_944 VDD VSS FILLER4
XFILLER_112_793 VDD VSS DECAPHV8
XFILLER_58_847 VDD VSS DECAPHV8
XFILLER_84_121 VSS VDD FILLER2
XFILLER_85_644 VSS VDD FILLER2
XFILLER_45_519 VDD VSS FILLER1
XFILLER_26_700 VDD VSS DECAPHV8
XFILLER_72_305 VDD VSS FILLER4
XFILLER_53_541 VDD VSS FILLER1
XTAP_TAPCELL_ROW_83_845 VDD VSS WELLTAP
XFILLER_25_265 VDD VSS FILLER1
XFILLER_26_788 VSS VDD FILLER2
XTAP_TAPCELL_ROW_55_569 VDD VSS WELLTAP
XFILLER_40_235 VDD VSS DECAPHV8
XFILLER_41_747 VDD VSS FILLER4
XFILLER_53_596 VDD VSS DECAPHV16
XFILLER_80_393 VDD VSS FILLER4
XFILLER_41_769 VDD VSS DECAPHV16
XFILLER_43_68 VDD VSS DECAPHV16
X_09328_ _20079_/RB _09346_/B VDD VSS _09328_/Y NOR2BX1
XTAP_TAPCELL_ROW_10_116 VDD VSS WELLTAP
X_09259_ _09277_/A _09301_/A VDD VSS _09265_/C NOR2BX1
XFILLER_107_510 VSS VDD FILLER2
X_12270_ _18875_/Q VDD VSS _12610_/A INVX1
XFILLER_107_554 VDD VSS FILLER4
XFILLER_5_659 VSS VDD FILLER2
X_11221_ _11221_/A _11221_/B VDD VSS _11222_/A NOR2X1
X_11152_ _11016_/Y _11151_/Y _11298_/A VDD VSS _11152_/Y MUXI2X1
XFILLER_1_854 VSS VDD FILLER2
XFILLER_68_32 VDD VSS DECAPHV8
X_10103_ _18587_/Q _10103_/B VDD VSS _10103_/Y XOR2X1
X_11083_ _11083_/A _11090_/C VDD VSS _11084_/B XOR2X1
X_15960_ _15960_/A VDD VSS _15961_/B INVX1
XFILLER_48_313 VDD VSS DECAPHV8
XFILLER_88_471 VDD VSS FILLER4
X_10034_ _10034_/A VDD VSS _10167_/A BUFX3
X_15891_ _15895_/A _15891_/B VDD VSS _19498_/D NOR2X1
X_14911_ _14911_/A _14911_/B _14911_/C _14911_/D VDD VSS _14956_/B AOAI211X1
X_17630_ _19887_/Q _19855_/Q VDD VSS _17632_/B XOR2X1
X_14842_ _14861_/B _14861_/C VDD VSS _15803_/B OR2X2
XFILLER_75_165 VDD VSS FILLER4
XFILLER_84_86 VDD VSS FILLER4
XFILLER_90_135 VDD VSS FILLER4
X_11985_ _11985_/A _11985_/B _11985_/C _11985_/D VDD VSS _14494_/C OAI211X1
X_19300_ _19304_/CK _19300_/D _19300_/Q VDD VSS DFFQX1
X_17561_ _19872_/Q VDD VSS _17712_/B INVX1
X_14773_ _19446_/Q _14840_/A _14773_/C VDD VSS _14774_/C XNOR3X1
XFILLER_44_574 VSS VDD FILLER2
X_10936_ _11522_/A _11641_/A _10936_/C VDD VSS _10967_/C MIN3X1
X_13724_ _19086_/Q _13857_/A _13784_/B VDD VSS _13781_/C XNOR3X1
X_17492_ _17496_/A _17493_/B _17509_/C VDD VSS _17493_/C OAI21X1
X_16512_ _16512_/A _16512_/B VDD VSS _19538_/D NOR2X1
XFILLER_32_736 VDD VSS FILLER1
XTAP_TAPCELL_ROW_26_271 VDD VSS WELLTAP
X_10867_ _10874_/A _10896_/C _11014_/A VDD VSS _10874_/C OAI21X1
X_13655_ _13656_/D _14194_/B VDD VSS _13748_/A NAND2X1
X_19231_ _19234_/CK _19231_/D _19231_/Q VDD VSS DFFQX1
X_16443_ _19695_/Q _16856_/B VDD VSS _16469_/A NAND2BX1
XTAP_TAPCELL_ROW_139_1410 VDD VSS WELLTAP
X_12606_ _18906_/Q _12701_/B _14150_/B VDD VSS _17861_/B XNOR3X1
X_19162_ _19187_/CK _19162_/D _19162_/Q VDD VSS DFFQX1
XFILLER_129_112 VDD VSS FILLER4
X_10798_ _10798_/A _10798_/B _10798_/C _10798_/D VDD VSS _10866_/B AO211X2
X_13586_ _13586_/A _14192_/B _13586_/C _13586_/D VDD VSS _13688_/A OAOI211X1
X_18113_ _19289_/Q _18118_/B VDD VSS _18114_/A XNOR2X1
X_16374_ _16398_/B _16398_/C VDD VSS _16375_/B NAND2BX1
XFILLER_117_307 VDD VSS FILLER1
X_12537_ _18989_/Q _12537_/B _14249_/B VDD VSS _12693_/B MIN3X1
X_19093_ _19124_/CK _19093_/D _19093_/Q VDD VSS DFFQX1
X_15325_ _19430_/Q _15814_/B VDD VSS _15347_/C NOR2BX1
XFILLER_129_189 VSS VDD FILLER2
X_12468_ _12480_/A _12553_/B _12553_/C VDD VSS _14407_/C OR3BX1
X_18044_ _18543_/Q _18044_/B VDD VSS _18045_/C NOR2X1
X_15256_ _15259_/B _15256_/B VDD VSS _18118_/B XNOR2X1
X_11419_ _11422_/A _17990_/B _11419_/C VDD VSS _18613_/D NOR3X1
X_14207_ _14231_/A _14207_/B VDD VSS _18956_/D AND2X1
X_15187_ _19538_/Q _15270_/C VDD VSS _15905_/B XNOR2X1
XFILLER_98_202 VDD VSS FILLER1
X_12399_ _14531_/B _14531_/C _19237_/Q VDD VSS _12401_/C AO21X2
X_14138_ _14158_/A _14138_/B VDD VSS _18895_/D AND2X1
XFILLER_140_343 VDD VSS DECAPHV8
X_19995_ _19999_/CK _19995_/D _19995_/Q VDD VSS DFFQX1
XFILLER_141_888 VDD VSS FILLER1
X_14069_ _18952_/Q _14203_/A _14203_/B VDD VSS _14086_/B NOR3X1
Xclkbuf_0__09171_ _18220_/ECK VDD VSS clkbuf_0__09171_/Y BUFX12
X_18946_ _19004_/CK _18946_/D _18946_/Q VDD VSS DFFQX1
XFILLER_39_302 VSS VDD FILLER2
XFILLER_95_920 VDD VSS DECAPHV8
X_18877_ _18878_/CK _18877_/D _18877_/Q VDD VSS DFFQX1
XFILLER_67_677 VDD VSS FILLER1
XFILLER_94_463 VDD VSS FILLER4
X_17828_ _19930_/Q _19931_/Q _17828_/C VDD VSS _17829_/C OAI21X1
XFILLER_54_316 VDD VSS FILLER1
XFILLER_66_187 VDD VSS DECAPHV16
XFILLER_82_636 VDD VSS FILLER1
X_17759_ _19915_/Q _19883_/Q VDD VSS _17766_/C NOR2X1
XTAP_TAPCELL_ROW_80_815 VDD VSS WELLTAP
XFILLER_23_725 VDD VSS DECAPHV8
XFILLER_23_747 VDD VSS DECAPHV8
XFILLER_90_680 VDD VSS FILLER1
XTAP_TAPCELL_ROW_52_539 VDD VSS WELLTAP
X_19429_ _19461_/CK _19429_/D _19429_/Q VDD VSS DFFQX1
XFILLER_22_235 VDD VSS DECAPHV32
XFILLER_108_307 VDD VSS FILLER4
Xclkbuf_leaf_8__000_ clkload79/A VDD VSS _19678_/CK BUFX12
XFILLER_144_682 VSS VDD FILLER2
XTAP_TAPCELL_ROW_0_19 VDD VSS WELLTAP
X_20204_ _20204_/A VDD VSS _20204_/Y BUFX3
XTAP_TAPCELL_ROW_112_1137 VDD VSS WELLTAP
Xmax_cap183 _18521_/Q VDD VSS _18500_/D BUFX8
Xmax_cap172 _09813_/B VDD VSS _09766_/C BUFX4
XFILLER_58_600 VDD VSS FILLER4
X_09946_ _09898_/Y _09902_/Y _10190_/B VDD VSS _09946_/Y MUXI2X1
X_20135_ _20135_/A VDD VSS _20135_/Y BUFX3
X_20066_ clkload6/A _20196_/A _20067_/D _20069_/RB VDD VSS DFFRQX1
XFILLER_100_752 VDD VSS FILLER1
XFILLER_85_441 VDD VSS DECAPHV8
X_09877_ _18566_/Q _09881_/B VDD VSS _09908_/B XOR2X1
XFILLER_54_12 VDD VSS FILLER4
XTAP_TAPCELL_ROW_68_694 VDD VSS WELLTAP
XFILLER_54_34 VDD VSS DECAPHV8
XTAP_TAPCELL_ROW_123_1244 VDD VSS WELLTAP
X_11770_ _19991_/Q _19255_/Q VDD VSS _11778_/B XNOR2X1
XFILLER_53_371 VDD VSS FILLER1
X_10721_ _10721_/A _10721_/B _10721_/C _10721_/D VDD VSS _10726_/B AOI31X1
X_13440_ _13548_/A _14388_/B VDD VSS _13614_/B NOR2X1
XTAP_TAPCELL_ROW_23_241 VDD VSS WELLTAP
X_10652_ _10763_/A _10652_/B _10652_/C VDD VSS _10653_/D OAI21X1
XFILLER_70_77 VDD VSS FILLER1
X_10583_ _10738_/B _11267_/A VDD VSS _10584_/D NAND2BX1
X_13371_ _19025_/Q VDD VSS _13373_/D INVX1
XFILLER_126_104 VSS VDD FILLER2
XFILLER_70_99 VSS VDD FILLER2
X_12322_ _12391_/A _12391_/B _12391_/C VDD VSS _12326_/B AOI21X1
X_16090_ _19586_/Q _16735_/B VDD VSS _16091_/B XOR2X1
X_15110_ _19482_/Q _15183_/A _15183_/B VDD VSS _15112_/C XNOR3X1
XFILLER_126_137 VSS VDD FILLER2
X_12253_ _14374_/B _19097_/Q VDD VSS _12363_/A NAND2BX1
X_15041_ _15041_/A _15041_/B _15041_/C VDD VSS _15072_/A AOI21X1
XFILLER_108_874 VSS VDD FILLER2
XFILLER_123_811 VDD VSS DECAPHV8
XTAP_TAPCELL_ROW_134_1351 VDD VSS WELLTAP
X_11204_ _11204_/A _11204_/B _11204_/C VDD VSS _11227_/C OA21X2
XFILLER_122_310 VDD VSS DECAPHV8
X_12184_ _19097_/Q wire159/Y _12208_/B VDD VSS _12210_/D XOR3X1
XFILLER_122_343 VDD VSS FILLER1
XFILLER_1_662 VDD VSS FILLER1
X_11135_ _18654_/Q _18816_/Q VDD VSS _11138_/A XNOR2X1
X_19780_ clkload2/A _19780_/D _19780_/Q VDD VSS DFFQX1
X_18800_ _18801_/CK _18800_/D _18800_/Q VDD VSS DFFQX1
X_16992_ _16994_/B _16992_/B VDD VSS _16993_/B XOR2X1
XFILLER_1_673 VSS VDD FILLER2
XFILLER_77_920 VSS VDD FILLER2
X_11066_ _18679_/Q _18787_/Q VDD VSS _11107_/B XOR2X1
X_18731_ _18785_/CK _18731_/D _18731_/Q VDD VSS DFFQX1
X_15943_ _19581_/Q _16730_/B VDD VSS _15944_/B XNOR2X1
X_10017_ _10032_/A _10017_/B _10017_/C _10034_/A VDD VSS _10018_/C AOI211X1
XFILLER_92_945 VDD VSS FILLER4
XFILLER_95_96 VDD VSS DECAPHV8
X_18662_ _18799_/CK _18662_/D _18662_/Q VDD VSS DFFQX1
X_15874_ _15879_/A _15874_/B VDD VSS _19482_/D AND2X1
X_18593_ _18595_/CK _18593_/D _18593_/Q VDD VSS DFFQX1
X_17613_ _17618_/C _17618_/B VDD VSS _17615_/B NAND2BX1
X_14825_ _14872_/D VDD VSS _14826_/D INVX1
XFILLER_45_861 VDD VSS DECAPHV8
X_17544_ _17546_/B _17544_/B VDD VSS _17545_/B XOR2X1
X_14756_ _19418_/Q _14774_/B _15800_/B VDD VSS _15768_/B XNOR3X1
XFILLER_32_522 VDD VSS FILLER4
X_11968_ _11968_/A _14399_/B _11968_/C VDD VSS _12022_/A MIN3X1
X_13707_ _13716_/A _13716_/B _13716_/C VDD VSS _13779_/C NOR3X1
X_10919_ _10954_/A _10919_/B VDD VSS _10920_/B XNOR2X1
X_11899_ _11899_/A _11899_/B _14398_/B VDD VSS _11961_/C MIN3X1
X_14687_ _19416_/Q _14698_/B _15798_/B VDD VSS _15766_/B XNOR3X1
X_19214_ _19215_/CK _19214_/D _19214_/Q VDD VSS DFFQX1
X_17475_ _19853_/Q _19821_/Q _17475_/C VDD VSS _17479_/C MIN3X1
XFILLER_60_886 VDD VSS FILLER1
X_13638_ _13639_/C _14453_/A VDD VSS _13640_/C _14453_/B NAND3X1
X_16426_ _16453_/B _16426_/B VDD VSS _16785_/B XNOR2X1
XFILLER_118_616 VDD VSS FILLER1
XFILLER_9_762 VSS VDD FILLER2
X_13569_ _13675_/A _13675_/B VDD VSS _14194_/B XNOR2X1
X_19145_ _19172_/CK _19145_/D _19145_/Q VDD VSS DFFQX1
X_16357_ _19724_/Q _16888_/B VDD VSS _16358_/C NOR2X1
X_19076_ _19124_/CK _19076_/D _19076_/Q VDD VSS DFFQX1
X_15308_ _15308_/A _15308_/B VDD VSS _15878_/C OR2X2
X_18027_ _18030_/B _18045_/B _18027_/C _18049_/D VDD VSS _19971_/D OAI31X1
X_16288_ _19594_/Q _16744_/B VDD VSS _16311_/B XOR2X1
X_15239_ _15311_/C _15274_/B VDD VSS _15240_/B NAND2X1
XFILLER_99_522 VDD VSS FILLER1
XFILLER_114_866 VDD VSS FILLER1
XFILLER_99_577 VDD VSS DECAPHV16
X_09800_ _20177_/A _09814_/B _09813_/C _20195_/A VDD VSS _09801_/E AO22X2
X_19978_ _19984_/CK _19978_/D _19978_/Q VDD VSS DFFQX1
Xfanout218 _20081_/RB VDD VSS _20080_/RB BUFX3
Xfanout207 _18455_/RB VDD VSS _09380_/B BUFX3
XFILLER_101_527 VDD VSS DECAPHV16
XFILLER_115_29 VDD VSS FILLER1
XFILLER_140_162 VDD VSS FILLER1
X_09731_ _09753_/D _09731_/B _09731_/C _09731_/D VDD VSS _18289_/D OAI211X1
X_18929_ _18935_/CK _18929_/D _18929_/Q VDD VSS DFFQX1
XFILLER_79_290 VDD VSS FILLER1
XFILLER_82_400 VSS VDD FILLER2
X_09662_ _18493_/Q _09819_/A _09673_/C _18429_/Q VDD VSS _09663_/E OAI22X1
XFILLER_131_28 VDD VSS DECAPHV8
XFILLER_39_198 VDD VSS FILLER4
XFILLER_55_669 VSS VDD FILLER2
XFILLER_82_433 VDD VSS FILLER1
X_09593_ _18457_/Q _09751_/B _09593_/C _09593_/D VDD VSS _09594_/B OAI211X1
XFILLER_36_850 VDD VSS FILLER1
XFILLER_54_157 VDD VSS FILLER4
XFILLER_54_168 VSS VDD FILLER2
XTAP_TAPCELL_ROW_65_664 VDD VSS WELLTAP
XFILLER_35_382 VSS VDD FILLER2
XTAP_TAPCELL_ROW_37_388 VDD VSS WELLTAP
XTAP_TAPCELL_ROW_20_211 VDD VSS WELLTAP
XFILLER_108_104 VSS VDD FILLER2
XFILLER_109_649 VSS VDD FILLER2
XFILLER_117_671 VDD VSS FILLER4
XFILLER_136_479 VDD VSS DECAPHV16
XFILLER_105_833 VDD VSS FILLER4
Xhold261 ss VDD VSS hold261/Y BUFX3
XFILLER_49_45 VSS VDD FILLER2
X_20118_ _20118_/A VDD VSS _20118_/Y BUFX3
X_09929_ _11178_/C _09929_/B _09929_/C _09944_/A VDD VSS _09930_/C AOAI211X1
X_12940_ _12940_/A _12940_/B _12940_/C _12940_/D VDD VSS _13108_/A AO31X2
X_20049_ clkload4/A _20049_/D _20050_/D _20051_/RB VDD VSS DFFRQX1
XFILLER_65_55 VDD VSS FILLER1
XTAP_TAPCELL_ROW_28_300 VDD VSS WELLTAP
X_12871_ _18993_/Q _12996_/A _12996_/B VDD VSS _12903_/C XNOR3X1
X_11822_ _11830_/A _11830_/B _11830_/C VDD VSS _14460_/B OAI21X1
X_14610_ _19413_/Q _15795_/B VDD VSS _14635_/B OR2X2
XFILLER_14_522 VDD VSS FILLER4
X_15590_ _19326_/Q _15698_/B VDD VSS _15591_/C NOR2BX1
XFILLER_121_83 VDD VSS DECAPHV8
XFILLER_14_544 VSS VDD FILLER2
XFILLER_42_853 VDD VSS FILLER1
XFILLER_60_138 VDD VSS FILLER1
X_11753_ _11764_/B _11764_/C VDD VSS _14488_/B NAND2X1
X_14541_ _15806_/A _14541_/B _14541_/C VDD VSS _19247_/D NOR3X1
XFILLER_42_886 VDD VSS DECAPHV16
XFILLER_81_76 VSS VDD FILLER2
X_10704_ _18562_/Q _10707_/B VDD VSS _10708_/B XOR2X1
X_11684_ _18955_/Q VDD VSS _12070_/A INVX1
X_14472_ _14421_/Y _14472_/B _14472_/C VDD VSS _19185_/D AND3BX1
X_17260_ _17263_/C _17261_/B _17306_/C VDD VSS _17261_/C OAI21X1
XFILLER_14_70 VSS VDD FILLER2
X_10635_ _18640_/Q _18802_/Q VDD VSS _10640_/A XOR2X1
X_13423_ _14387_/B _19109_/Q VDD VSS _13528_/A NAND2BX1
X_17191_ _19793_/Q _19761_/Q VDD VSS _17197_/B NAND2X1
X_16211_ _16236_/C _16211_/B VDD VSS _16741_/B XNOR2X1
X_13354_ _13354_/A _14416_/B _13354_/C VDD VSS _14417_/B OAI21X1
Xclkload109 _19591_/CK VDD VSS clkload109/Y INVX4
X_16142_ _16155_/B _16142_/B VDD VSS _16809_/B XNOR2X1
XFILLER_10_783 VDD VSS FILLER4
XFILLER_143_906 VDD VSS DECAPHV16
XFILLER_5_231 VDD VSS FILLER4
X_10566_ _18637_/Q _18799_/Q VDD VSS _10570_/D AND2X1
X_12305_ _19181_/Q _14467_/B VDD VSS _12313_/A AND2X1
X_10497_ _10535_/B _10581_/A VDD VSS _10582_/C NAND2BX1
X_13285_ _18886_/Q VDD VSS _13486_/A INVX1
X_16073_ _16080_/C _16080_/B VDD VSS _16074_/B NAND2BX1
X_12236_ _12236_/A _12236_/B _12236_/C _12236_/D VDD VSS _14531_/C AOAI211X1
X_19901_ _19903_/CK _19901_/D _19901_/Q VDD VSS DFFQX1
X_15024_ _15024_/A _15045_/D VDD VSS _15775_/B XOR2X1
X_12167_ _12236_/A _12236_/B _12236_/C VDD VSS _12168_/C AOI21X1
X_19832_ _19833_/CK _19832_/D _19832_/Q VDD VSS DFFQX1
XFILLER_110_324 VDD VSS FILLER1
XFILLER_96_514 VDD VSS DECAPHV8
XFILLER_96_536 VDD VSS DECAPHV16
X_11118_ _11118_/A _11118_/B VDD VSS _11119_/C NAND2X1
X_12098_ _14528_/A _14528_/B _19234_/Q VDD VSS _12099_/D OA21X2
X_19763_ _19795_/CK _19763_/D _19763_/Q VDD VSS DFFQX1
X_16975_ _16977_/B _16975_/B VDD VSS _16976_/B XOR2X1
X_11049_ _10984_/Y _11048_/Y _10947_/Y VDD VSS _11049_/Y MUXI2X1
X_19694_ _19724_/CK _19694_/D _19694_/Q VDD VSS DFFQX1
Xclkbuf_leaf_4_clk_regs clkload1/A VDD VSS _19903_/CK BUFX12
X_18714_ _18768_/CK _18714_/D _18714_/Q VDD VSS DFFQX1
X_15926_ _15939_/A _15939_/B VDD VSS _16729_/B XNOR2X1
XFILLER_92_742 VDD VSS FILLER1
X_18645_ _19951_/CK _18645_/D _18645_/Q VDD VSS DFFQX1
X_15857_ _15867_/A _15857_/B VDD VSS _19468_/D NOR2X1
X_14808_ _15297_/A _18063_/B VDD VSS _19279_/D AND2X1
XFILLER_17_371 VDD VSS FILLER1
XFILLER_17_382 VSS VDD FILLER2
Xclkbuf_leaf_7__001_ clkload41/A VDD VSS _19202_/CK BUFX12
X_18576_ _18582_/CK _18576_/D _18576_/Q VDD VSS DFFQX1
X_15788_ _15793_/A _15788_/B VDD VSS _19407_/D AND2X1
XTAP_TAPCELL_ROW_34_358 VDD VSS WELLTAP
XTAP_TAPCELL_ROW_62_634 VDD VSS WELLTAP
X_17527_ _17527_/A _17527_/B _17527_/C VDD VSS _17529_/A OA21X2
X_14739_ _14739_/A _14739_/B _14739_/C _14739_/D VDD VSS _14746_/A AOAI211X1
XFILLER_20_514 VDD VSS FILLER4
X_17458_ _17460_/A _17460_/B _17458_/C VDD VSS _19850_/D AOI21X1
XFILLER_20_525 VSS VDD FILLER2
X_16409_ _16409_/A _16416_/B VDD VSS _16890_/B XOR2X1
XFILLER_20_569 VDD VSS FILLER1
XFILLER_72_0 VDD VSS FILLER4
X_19128_ _19129_/CK _19128_/D _19128_/Q VDD VSS DFFQX1
X_17389_ _17392_/B _17389_/B VDD VSS _17390_/B XOR2X1
XFILLER_118_435 VDD VSS FILLER4
XFILLER_9_581 VDD VSS FILLER1
XFILLER_9_592 VSS VDD FILLER2
XFILLER_106_619 VDD VSS FILLER1
XFILLER_134_928 VSS VDD FILLER2
X_19059_ _19115_/CK _19059_/D _19059_/Q VDD VSS DFFQX1
XFILLER_0_919 VDD VSS DECAPHV16
XFILLER_101_302 VDD VSS FILLER1
XFILLER_102_836 VDD VSS FILLER4
XFILLER_102_858 VDD VSS FILLER4
XFILLER_59_238 VDD VSS DECAPHV8
Xclkbuf_leaf_11__000_ clkbuf_leaf_9__000_/A VDD VSS _19716_/CK BUFX12
XFILLER_28_603 VDD VSS FILLER1
XFILLER_56_912 VDD VSS DECAPHV8
XFILLER_68_772 VDD VSS FILLER4
X_09714_ _20109_/A _20125_/A _09776_/A VDD VSS _09715_/B MUXI2X1
XFILLER_56_945 VDD VSS FILLER1
XFILLER_67_282 VDD VSS FILLER1
XFILLER_67_293 VDD VSS DECAPHV16
X_09645_ _20137_/A _20185_/A _09816_/D VDD VSS _09646_/B MUXI2X1
XFILLER_43_617 VDD VSS DECAPHV8
XFILLER_55_488 VDD VSS FILLER1
XFILLER_71_948 VSS VDD FILLER2
X_09576_ _09753_/A _09576_/B VDD VSS _09716_/B AND2X1
Xclkbuf_leaf_26__000_ clkload78/A VDD VSS _19322_/CK BUFX12
XFILLER_42_138 VDD VSS FILLER1
XTAP_TAPCELL_ROW_120_1214 VDD VSS WELLTAP
XFILLER_11_514 VDD VSS FILLER1
XFILLER_24_886 VDD VSS DECAPHV8
XFILLER_50_182 VSS VDD FILLER2
XFILLER_51_24 VDD VSS FILLER4
XFILLER_129_4 VDD VSS FILLER1
XFILLER_51_57 VDD VSS DECAPHV8
XFILLER_51_79 VDD VSS DECAPHV8
X_10420_ _10448_/A _10448_/B VDD VSS _10421_/D NAND2X1
XFILLER_109_457 VSS VDD FILLER2
XFILLER_109_468 VDD VSS DECAPHV8
XFILLER_124_416 VSS VDD FILLER2
XFILLER_136_276 VDD VSS FILLER4
X_10351_ _10625_/A _10660_/B VDD VSS _10427_/C NAND2X1
XFILLER_2_201 VDD VSS FILLER4
XTAP_TAPCELL_ROW_118_1198 VDD VSS WELLTAP
XTAP_TAPCELL_ROW_131_1321 VDD VSS WELLTAP
X_10282_ _10329_/A _10329_/B _10763_/A VDD VSS _10283_/B AOI21X1
X_13070_ _18995_/Q _13070_/B _13097_/C VDD VSS _13192_/B XNOR3X1
XFILLER_105_641 VDD VSS FILLER4
X_12021_ _19093_/Q VDD VSS _12023_/A INVX1
XFILLER_132_471 VDD VSS FILLER1
XFILLER_132_482 VSS VDD FILLER2
XFILLER_78_514 VDD VSS FILLER1
XFILLER_116_94 VDD VSS DECAPHV16
XFILLER_76_65 VDD VSS DECAPHV8
XFILLER_93_517 VDD VSS DECAPHV8
X_13972_ _13991_/A _14201_/B VDD VSS _13983_/C XNOR2X1
X_16760_ _16776_/A VDD VSS _16775_/A BUFX3
XFILLER_101_891 VSS VDD FILLER2
XFILLER_18_124 VDD VSS FILLER4
XFILLER_46_433 VDD VSS FILLER1
X_12923_ _12939_/A _12939_/B _12939_/C VDD VSS _14383_/B OAI21X1
X_15711_ _15725_/A _15711_/B VDD VSS _19338_/D AND2X1
XFILLER_18_135 VDD VSS FILLER1
XFILLER_62_904 VDD VSS FILLER4
XFILLER_73_230 VDD VSS FILLER1
X_18430_ _18439_/CK _18430_/D _18430_/Q _18465_/RB VDD VSS DFFRQX1
X_16691_ _19898_/Q _16702_/B VDD VSS _19546_/D AND2X1
XFILLER_33_127 VDD VSS FILLER1
XFILLER_46_499 VDD VSS FILLER4
XFILLER_61_414 VSS VDD FILLER2
X_12854_ _19217_/Q _12854_/B _12951_/D VDD VSS _13032_/C XNOR3X1
X_15642_ _15655_/A _15653_/A VDD VSS _15654_/A XNOR2X1
XFILLER_92_64 VDD VSS FILLER4
X_11805_ _19994_/Q _19258_/Q VDD VSS _11838_/C XOR2X1
X_12785_ _18908_/Q _12883_/B _14152_/B VDD VSS _12791_/C XNOR3X1
X_18361_ _18367_/CK _18510_/Q _20198_/A _18464_/RB VDD VSS DFFRQX1
X_15573_ _19465_/Q VDD VSS _15574_/A INVX1
XFILLER_15_897 VDD VSS DECAPHV32
X_11736_ _11736_/A _11736_/B VDD VSS _14518_/B XNOR2X1
X_14524_ _14539_/A _14524_/B VDD VSS _19230_/D NOR2X1
X_18292_ _18295_/CK _18292_/D _18292_/Q VDD VSS DFFQX1
X_17312_ _17318_/C _17318_/B VDD VSS _17315_/B NAND2BX1
XTAP_TAPCELL_ROW_31_328 VDD VSS WELLTAP
X_17243_ _19804_/Q _19772_/Q _17243_/C VDD VSS _17247_/B AOI21X1
XFILLER_128_700 VDD VSS DECAPHV16
X_11667_ _18806_/Q _11669_/B VDD VSS _18833_/D AND2X1
X_14455_ _14467_/A _14455_/B VDD VSS _19170_/D AND2X1
XFILLER_127_210 VDD VSS DECAPHV16
X_10618_ _10616_/Y _10618_/B _18720_/Q _18628_/Q VDD VSS _10619_/D AOI2B2X1
X_11598_ _18743_/Q _11600_/B VDD VSS _18770_/D AND2X1
X_13406_ _13406_/A _13406_/B _13406_/C _13406_/D VDD VSS _13604_/B AOAI211X1
X_14386_ _14381_/Y _14386_/B _14386_/C VDD VSS _19108_/D AND3BX1
X_17174_ _17176_/C _17174_/B _17174_/C VDD VSS _19789_/D AOI21X1
XFILLER_127_265 VDD VSS FILLER1
XFILLER_128_777 VDD VSS DECAPHV8
X_10549_ _11263_/A _10596_/A VDD VSS _10587_/A NOR2X1
X_13337_ _13451_/A _14449_/B VDD VSS _13542_/B NOR2X1
X_16125_ _16512_/A _16125_/B VDD VSS _19523_/D NOR2X1
XFILLER_143_747 VSS VDD FILLER2
X_16056_ _19648_/Q _16805_/B VDD VSS _16057_/C NOR2X1
XFILLER_108_490 VDD VSS FILLER4
XFILLER_142_246 VSS VDD FILLER2
X_13268_ _19081_/Q _13268_/B _13364_/D VDD VSS _14323_/C XNOR3X1
X_15007_ _15052_/A _15052_/B VDD VSS _15021_/B NAND2X1
XFILLER_97_834 VSS VDD FILLER2
X_12219_ _19181_/Q _14467_/B VDD VSS _12382_/A NAND2X1
X_13199_ _14257_/B _14257_/C _18995_/Q VDD VSS _13203_/B AOI21X1
XFILLER_96_355 VDD VSS DECAPHV16
XFILLER_97_856 VDD VSS FILLER1
X_19815_ _19833_/CK _19815_/D _19815_/Q VDD VSS DFFQX1
XTAP_TAPCELL_ROW_39_406 VDD VSS WELLTAP
X_19746_ clkload2/A _19746_/D _19746_/Q VDD VSS DFFQX1
X_16958_ _19746_/Q _17049_/B _16962_/A _16962_/B VDD VSS _16958_/Y AOI211X1
XFILLER_49_282 VDD VSS FILLER4
XFILLER_65_742 VSS VDD FILLER2
X_15909_ _16100_/A _15909_/B VDD VSS _19514_/D NOR2X1
XFILLER_37_444 VDD VSS FILLER1
XFILLER_65_764 VDD VSS FILLER4
XFILLER_92_550 VDD VSS FILLER4
X_09430_ _09446_/A _09751_/B VDD VSS _18213_/E NOR2X1
X_19677_ _19711_/CK _19677_/D _19677_/Q VDD VSS DFFQX1
X_16889_ _16899_/A _16889_/B VDD VSS _19725_/D AND2X1
XTAP_TAPCELL_ROW_75_770 VDD VSS WELLTAP
X_18628_ _18628_/CK _18628_/D _18628_/Q VDD VSS DFFQX1
XFILLER_52_447 VDD VSS FILLER1
XFILLER_80_778 VDD VSS FILLER1
XTAP_TAPCELL_ROW_106_1080 VDD VSS WELLTAP
XTAP_TAPCELL_ROW_47_483 VDD VSS WELLTAP
X_09361_ _18505_/Q _09630_/C _09354_/Y VDD VSS _18505_/D MUX2X1
X_18559_ _18565_/CK _18559_/D _18559_/Q VDD VSS DFFQX1
X_09292_ _18201_/A VDD VSS _18199_/A BUFX3
XANTENNA_12 _17906_/C VDD VSS ANTENNA2
XANTENNA_23 _20115_/Y VDD VSS ANTENNA2
XFILLER_21_834 VSS VDD FILLER2
XANTENNA_34 _18127_/B VDD VSS ANTENNA2
XFILLER_20_355 VDD VSS DECAPHV8
XFILLER_119_755 VSS VDD FILLER2
XFILLER_21_27 VDD VSS FILLER1
XFILLER_107_928 VSS VDD FILLER2
XFILLER_107_939 VDD VSS DECAPHV8
XFILLER_106_416 VSS VDD FILLER2
Xclkbuf_2_3__f_sclk_regs clkbuf_0_sclk_regs/Y VDD VSS _20081_/CK BUFX12
XFILLER_122_909 VDD VSS FILLER4
Xoutput141 _20224_/Y VDD VSS o_uwb_tx_cfg[27] BUFX3
Xoutput130 _20214_/Y VDD VSS o_uwb_tx_cfg[17] BUFX3
XFILLER_0_727 VSS VDD FILLER2
XFILLER_88_812 VSS VDD FILLER2
XFILLER_88_845 VDD VSS FILLER1
XFILLER_102_655 VDD VSS DECAPHV8
XFILLER_114_493 VDD VSS DECAPHV8
XFILLER_99_193 VSS VDD FILLER2
XFILLER_75_517 VDD VSS DECAPHV8
XFILLER_56_742 VDD VSS DECAPHV8
XFILLER_68_591 VSS VDD FILLER2
XFILLER_75_539 VSS VDD FILLER2
XTAP_TAPCELL_ROW_109_1109 VDD VSS WELLTAP
XFILLER_46_57 VDD VSS FILLER4
XFILLER_16_628 VDD VSS FILLER4
X_09628_ _18443_/Q _09816_/B _09628_/C _09628_/D VDD VSS _09629_/C OAI211X1
XFILLER_15_138 VSS VDD FILLER2
XFILLER_43_436 VDD VSS DECAPHV8
X_09559_ _20098_/A _09784_/B _09812_/C VDD VSS _09569_/A AOI21X1
XFILLER_71_778 VDD VSS FILLER4
X_12570_ _14534_/A _14534_/B _19240_/Q VDD VSS _12571_/D OAI21X1
XFILLER_12_856 VDD VSS FILLER1
XFILLER_51_480 VSS VDD FILLER2
XFILLER_11_355 VDD VSS FILLER1
XFILLER_12_867 VDD VSS FILLER1
XFILLER_134_2 VDD VSS FILLER1
X_11521_ _18673_/Q _11531_/B VDD VSS _18700_/D AND2X1
X_11452_ _19945_/Q _11460_/B VDD VSS _18638_/D AND2X1
X_14240_ _14240_/A _14240_/B VDD VSS _14241_/B XNOR2X1
XFILLER_109_243 VSS VDD FILLER2
XFILLER_137_574 VSS VDD FILLER2
X_10403_ _10476_/A _10476_/B _10927_/C VDD VSS _10404_/D AOI21X1
X_11383_ _11383_/A _11383_/B VDD VSS _18593_/D NOR2X1
X_14171_ _14186_/A _14171_/B VDD VSS _18924_/D NOR2X1
X_10334_ _18631_/Q _18793_/Q VDD VSS _10372_/C AND2X1
X_13122_ _13122_/A _13122_/B _13138_/C VDD VSS _13316_/B XNOR3X1
XFILLER_140_706 VSS VDD FILLER2
XFILLER_105_460 VDD VSS FILLER4
XFILLER_78_300 VSS VDD FILLER2
X_10265_ _18623_/Q _18624_/Q VDD VSS _11432_/B NAND2BX1
X_13053_ _20011_/Q _19275_/Q VDD VSS _13150_/D XNOR2X1
Xclkbuf_leaf_6__002_ clkbuf_leaf_9__002_/A VDD VSS _18773_/CK BUFX12
X_17930_ _17941_/A _17941_/B VDD VSS _17935_/A OR2X2
XFILLER_79_856 VDD VSS FILLER4
X_10196_ _13177_/A _11424_/C VDD VSS _18545_/D NOR2X1
X_12004_ _19094_/Q _12083_/B _12079_/C VDD VSS _12075_/C XNOR3X1
X_17861_ _17861_/A _17861_/B VDD VSS _17862_/B XNOR2X1
X_19600_ _19636_/CK _19600_/D _19600_/Q VDD VSS DFFQX1
X_16812_ _17391_/A VDD VSS _16826_/A BUFX3
XFILLER_120_485 VSS VDD FILLER2
XFILLER_143_70 VDD VSS FILLER4
XFILLER_59_591 VDD VSS FILLER1
XFILLER_78_399 VSS VDD FILLER2
XFILLER_93_347 VDD VSS FILLER1
XFILLER_94_859 VDD VSS FILLER1
X_19531_ _19543_/CK _19531_/D _19531_/Q VDD VSS DFFQX1
X_17792_ _17793_/A _17793_/B _17793_/D _17793_/C VDD VSS _17795_/C AOI211X1
XFILLER_93_369 VSS VDD FILLER2
X_13955_ _13955_/A _13955_/B _13955_/C _13955_/D VDD VSS _14232_/C OAI211X1
X_16743_ _16748_/A _16743_/B VDD VSS _19593_/D NOR2X1
XFILLER_19_477 VDD VSS FILLER1
XFILLER_74_572 VDD VSS FILLER1
X_12906_ _12906_/A _14287_/B _14287_/C VDD VSS _12996_/C NOR3X1
X_13886_ _13981_/A _13981_/B _13981_/C VDD VSS _13931_/B AOI21X1
X_19462_ _19492_/CK _19462_/D _19462_/Q VDD VSS DFFQX1
X_16674_ _19640_/Q _16674_/B _16794_/B VDD VSS _16683_/A MIN3X1
XTAP_TAPCELL_ROW_72_740 VDD VSS WELLTAP
X_12837_ _12837_/A _12837_/B _12837_/C _12837_/D VDD VSS _14506_/C AOI211X1
X_19393_ _19393_/CK _19393_/D _19393_/Q VDD VSS DFFQX1
X_18413_ _18420_/CK _18413_/D _18413_/Q _09380_/B VDD VSS DFFRQX1
X_15625_ _19411_/Q _15625_/B _15625_/C VDD VSS _15639_/A MIN3X1
XTAP_TAPCELL_ROW_44_453 VDD VSS WELLTAP
XTAP_TAPCELL_ROW_7_83 VDD VSS WELLTAP
X_18344_ _18356_/CK _18344_/D _18344_/Q _20072_/RB VDD VSS DFFRQX1
XFILLER_42_480 VDD VSS FILLER1
XTAP_TAPCELL_ROW_16_177 VDD VSS WELLTAP
X_12768_ _19188_/Q _12768_/B _12827_/D VDD VSS _12940_/B XNOR3X1
X_15556_ _19381_/Q _15758_/B VDD VSS _15568_/B XNOR2X1
XFILLER_14_193 VDD VSS FILLER1
XTAP_TAPCELL_ROW_99_1002 VDD VSS WELLTAP
X_11719_ _14519_/B _14519_/C _19226_/Q VDD VSS _11745_/B AOI21X1
X_12699_ _13283_/A _17870_/B VDD VSS _18851_/D AND2X1
X_14507_ _12832_/C _14507_/B VDD VSS _14508_/C NOR2BX1
X_18275_ _18275_/CK _18275_/D _18275_/Q _20081_/RB VDD VSS DFFRQX1
X_15487_ _19407_/Q _15788_/B VDD VSS _15525_/B NOR2X1
XTAP_TAPCELL_ROW_0_5 VDD VSS WELLTAP
X_14438_ _14456_/A _14438_/B VDD VSS _19155_/D NOR2X1
Xclkbuf_leaf_10__001_ clkload41/A VDD VSS _19992_/CK BUFX12
X_17226_ _19800_/Q _19768_/Q VDD VSS _17227_/C NAND2X1
X_17157_ _17160_/A _17160_/B _17164_/C VDD VSS _17158_/C OAI21X1
XFILLER_6_370 VDD VSS DECAPHV8
X_14369_ _14457_/A VDD VSS _14393_/A BUFX3
X_16108_ _19618_/Q _16108_/B _16770_/B VDD VSS _16133_/B MIN3X1
XFILLER_107_19 VSS VDD FILLER2
XFILLER_143_555 VSS VDD FILLER2
XFILLER_89_609 VSS VDD FILLER2
X_17088_ _19772_/Q _19740_/Q VDD VSS _17089_/B XOR2X1
Xclkbuf_leaf_25__001_ clkbuf_2_3__f__001_/Y VDD VSS _19001_/CK BUFX12
X_16039_ _16039_/A _16062_/C VDD VSS _16733_/B XNOR2X1
XFILLER_57_506 VDD VSS DECAPHV16
XFILLER_84_303 VDD VSS FILLER4
XFILLER_38_731 VDD VSS DECAPHV16
XFILLER_57_528 VDD VSS FILLER1
XFILLER_85_848 VDD VSS DECAPHV16
X_19729_ _19730_/CK _19729_/D _19729_/Q VDD VSS DFFQX1
XFILLER_16_49 VSS VDD FILLER2
X_09413_ _09506_/C VDD VSS _18225_/E INVX1
XFILLER_40_406 VDD VSS DECAPHV8
XFILLER_80_575 VDD VSS FILLER1
XFILLER_139_806 VDD VSS FILLER1
X_09344_ _18282_/Q _18510_/Q _09354_/B VDD VSS _09344_/Y MUXI2X1
XFILLER_139_828 VDD VSS DECAPHV8
X_09275_ _09273_/A _09265_/C _18276_/Q VDD VSS _18276_/D MUXI2X1
XFILLER_119_541 VDD VSS FILLER1
XFILLER_106_235 VDD VSS DECAPHV32
XTAP_TAPCELL_ROW_115_1168 VDD VSS WELLTAP
XFILLER_0_502 VDD VSS FILLER4
XFILLER_0_513 VDD VSS FILLER1
XFILLER_106_279 VSS VDD FILLER2
XFILLER_115_780 VDD VSS FILLER4
XFILLER_121_216 VSS VDD FILLER2
XFILLER_0_535 VDD VSS FILLER1
X_10050_ _18603_/Q _10050_/B _10050_/C VDD VSS _10053_/C MIN3X1
XFILLER_102_452 VSS VDD FILLER2
XFILLER_75_325 VDD VSS FILLER4
XFILLER_113_40 VDD VSS FILLER1
XTAP_TAPCELL_ROW_86_876 VDD VSS WELLTAP
XFILLER_29_775 VDD VSS FILLER4
X_10952_ _18569_/Q _10957_/B VDD VSS _10954_/D XNOR2X1
X_13740_ _18918_/Q _13818_/A _13918_/B VDD VSS _13807_/D XNOR3X1
XFILLER_28_296 VDD VSS FILLER1
XFILLER_71_542 VDD VSS DECAPHV16
XTAP_TAPCELL_ROW_126_1275 VDD VSS WELLTAP
XFILLER_71_586 VSS VDD FILLER2
X_10883_ _18567_/Q _10887_/B VDD VSS _10885_/C XOR2X1
X_13671_ _13748_/A _13748_/C _13748_/B VDD VSS _14163_/C AOI21X1
X_15410_ _19405_/Q _15786_/B VDD VSS _15427_/B XNOR2X1
XFILLER_12_620 VSS VDD FILLER2
XFILLER_24_480 VSS VDD FILLER2
XTAP_TAPCELL_ROW_41_423 VDD VSS WELLTAP
X_12622_ _19018_/Q _14284_/B VDD VSS _12717_/C _14284_/C AND3X2
X_16390_ _16390_/A _16390_/B _16390_/C VDD VSS _16406_/B AOI21X1
XTAP_TAPCELL_ROW_13_147 VDD VSS WELLTAP
X_12553_ _12553_/A _12553_/B _12553_/C _12553_/D VDD VSS _12656_/A OAOI211X1
X_15341_ _15341_/A _15341_/B _15721_/B VDD VSS _15386_/B MIN3X1
X_11504_ _18658_/Q _11508_/B VDD VSS _18685_/D AND2X1
X_18060_ _19279_/Q _18063_/B VDD VSS _18064_/B XNOR2X1
X_15272_ _19513_/Q _15908_/B VDD VSS _15311_/D XOR2X1
XFILLER_7_145 VDD VSS FILLER1
X_12484_ _14440_/A _14440_/B VDD VSS _12504_/B NOR2X1
X_14223_ _14457_/A VDD VSS _14251_/A BUFX3
X_17011_ _19757_/Q _17011_/B VDD VSS _17019_/C XOR2X1
XFILLER_125_522 VDD VSS DECAPHV8
XFILLER_137_382 VDD VSS DECAPHV8
XTAP_TAPCELL_ROW_137_1382 VDD VSS WELLTAP
X_11435_ _11435_/A _11435_/B _18624_/Q _11436_/C VDD VSS _11438_/B AND4X2
XFILLER_4_841 VDD VSS DECAPHV16
XFILLER_98_41 VDD VSS FILLER4
XFILLER_99_918 VDD VSS FILLER1
X_11366_ _18591_/Q _11375_/B VDD VSS _11368_/A XNOR2X1
X_14154_ _14154_/A _14154_/B VDD VSS _18910_/D NOR2X1
XFILLER_140_514 VDD VSS DECAPHV16
XFILLER_4_863 VDD VSS FILLER4
X_10317_ _18658_/Q _18766_/Q VDD VSS _10405_/C AND2X1
X_11297_ _11308_/A _11308_/B _11379_/A VDD VSS _11300_/A AOI21X1
X_13105_ _14414_/B _14414_/C _19134_/Q VDD VSS _13113_/B AOI21X1
X_14085_ _14085_/A _14085_/B _14085_/C _14085_/D VDD VSS _14139_/B AOAI211X1
X_18962_ _18993_/CK _18962_/D _18962_/Q VDD VSS DFFQX1
XFILLER_79_631 VSS VDD FILLER2
XFILLER_98_96 VDD VSS DECAPHV8
X_10248_ _18623_/Q _18624_/Q VDD VSS _11431_/B XOR2X1
X_13036_ _13036_/A _13036_/B _13036_/C _13036_/D VDD VSS _13141_/A AOAI211X1
X_17913_ _18173_/A _17913_/B VDD VSS _19950_/D NOR2X1
XFILLER_78_152 VSS VDD FILLER2
XFILLER_79_686 VDD VSS DECAPHV16
XFILLER_94_601 VSS VDD FILLER2
X_18893_ _18950_/CK _18893_/D _18893_/Q VDD VSS DFFQX1
XFILLER_78_196 VDD VSS FILLER1
XTAP_TAPCELL_ROW_49_501 VDD VSS WELLTAP
X_10179_ _10184_/A _10179_/B VDD VSS _11421_/C XNOR2X1
X_17844_ _18847_/Q _17847_/B VDD VSS _17846_/B XOR2X1
XFILLER_54_509 VSS VDD FILLER2
X_17775_ _17775_/A _17776_/C _17775_/C VDD VSS _19918_/D AOI21X1
X_14987_ _14989_/B _14987_/B VDD VSS _18084_/B XNOR2X1
XFILLER_47_561 VDD VSS FILLER4
XFILLER_81_317 VDD VSS FILLER1
X_13938_ _13938_/A _13938_/B _13938_/C _13938_/D VDD VSS _14135_/B OAOI211X1
X_19514_ _19543_/CK _19514_/D _19514_/Q VDD VSS DFFQX1
X_16726_ _19929_/Q _16726_/B VDD VSS _19577_/D AND2X1
XFILLER_62_542 VDD VSS FILLER4
XFILLER_74_380 VDD VSS DECAPHV8
XFILLER_90_840 VDD VSS FILLER4
XFILLER_90_851 VDD VSS DECAPHV32
X_19445_ _19492_/CK _19445_/D _19445_/Q VDD VSS DFFQX1
XFILLER_22_417 VDD VSS FILLER1
XFILLER_34_266 VDD VSS FILLER4
X_13869_ _13869_/A _13869_/B _13869_/C _13869_/D VDD VSS _13872_/B AOAI211X1
X_16657_ _16657_/A _16657_/B VDD VSS _16658_/B _16657_/C NAND3X1
XTAP_TAPCELL_ROW_103_1050 VDD VSS WELLTAP
X_19376_ _19393_/CK _19376_/D _19376_/Q VDD VSS DFFQX1
X_16588_ _16589_/A _16589_/B VDD VSS _16616_/B AND2X1
X_15608_ _19355_/Q _15730_/B VDD VSS _15609_/B XOR2X1
X_18327_ _18327_/CK _18471_/D _18327_/Q _20065_/RB VDD VSS DFFRQX1
X_15539_ _15539_/A _15539_/B _15539_/C VDD VSS _15566_/A OAI21X1
X_18258_ _18258_/CK _18258_/D _18258_/Q _09281_/Y VDD VSS DFFRQX1
XFILLER_8_61 VDD VSS FILLER4
X_17209_ _19797_/Q _19765_/Q VDD VSS _17211_/B XOR2X1
XFILLER_135_319 VDD VSS FILLER4
X_18189_ _19304_/Q _18194_/A VDD VSS _18192_/A XOR2X1
XFILLER_144_864 VDD VSS FILLER4
X_20220_ _20220_/A VDD VSS _20220_/Y BUFX3
XFILLER_116_566 VDD VSS DECAPHV8
XFILLER_143_352 VDD VSS FILLER4
XFILLER_89_428 VDD VSS DECAPHV8
X_20151_ _20151_/A VDD VSS _20151_/Y BUFX3
X_09893_ _11178_/C _09893_/B VDD VSS _09894_/C NOR2X1
X_20082_ _20082_/A VDD VSS output7/A BUFX3
XFILLER_57_314 VDD VSS FILLER4
XFILLER_84_111 VSS VDD FILLER2
XFILLER_69_196 VDD VSS FILLER1
XFILLER_84_155 VDD VSS DECAPHV8
XFILLER_72_328 VDD VSS DECAPHV8
XFILLER_26_734 VDD VSS FILLER1
XFILLER_81_840 VSS VDD FILLER2
XTAP_TAPCELL_ROW_83_846 VDD VSS WELLTAP
XFILLER_41_726 VSS VDD FILLER2
XFILLER_43_25 VDD VSS DECAPHV8
X_09327_ _18448_/D _09326_/Y _09302_/Y VDD VSS _18517_/D MUXI2X1
XFILLER_5_605 VSS VDD FILLER2
XTAP_TAPCELL_ROW_10_117 VDD VSS WELLTAP
X_09258_ _09349_/B _09258_/B VDD VSS _09301_/A OR2X2
XFILLER_107_500 VDD VSS FILLER1
XFILLER_119_371 VDD VSS FILLER1
XFILLER_135_831 VDD VSS FILLER1
XFILLER_138_179 VDD VSS DECAPHV8
X_09189_ _18471_/D VDD VSS _18455_/D INVX1
XFILLER_119_393 VDD VSS FILLER1
X_11220_ _11220_/A _11220_/B _11220_/C VDD VSS _11249_/C MIN3X1
XFILLER_122_514 VDD VSS DECAPHV16
XFILLER_135_897 VSS VDD FILLER2
XFILLER_1_800 VSS VDD FILLER2
X_11151_ _11079_/Y _11150_/Y _10947_/Y VDD VSS _11151_/Y MUXI2X1
XFILLER_108_73 VSS VDD FILLER2
XFILLER_1_844 VDD VSS FILLER1
XFILLER_68_44 VSS VDD FILLER2
X_10102_ _18586_/Q _10113_/C VDD VSS _10103_/B NAND2X1
X_11082_ _10809_/Y _11081_/Y _11120_/A VDD VSS _11090_/C MUX2X1
XFILLER_103_772 VDD VSS DECAPHV8
XFILLER_49_848 VDD VSS FILLER1
XFILLER_75_111 VDD VSS FILLER4
X_10033_ _10001_/Y _10031_/Y _10155_/A VDD VSS _10033_/Y MUXI2X1
X_15890_ _15895_/A _15890_/B VDD VSS _19497_/D NOR2X1
X_14910_ _14910_/A _15804_/B VDD VSS _14956_/A OR2X2
XFILLER_36_509 VSS VDD FILLER2
XFILLER_48_347 VSS VDD FILLER2
XFILLER_76_678 VDD VSS FILLER4
XFILLER_91_604 VSS VDD FILLER2
X_14841_ _14867_/A _14867_/B _14867_/C VDD VSS _14861_/C NOR3X1
XFILLER_29_561 VSS VDD FILLER2
XFILLER_90_103 VDD VSS DECAPHV8
X_17560_ _17562_/C _17560_/B _17560_/C VDD VSS _19872_/D AOI21X1
XFILLER_91_648 VSS VDD FILLER2
X_09966__236 _18259_/CK VDD VSS _18513_/CK INVX1
X_11984_ _11985_/A _11985_/B _11985_/D _11985_/C VDD VSS _12099_/B OAOI211X1
X_16511_ _16515_/B _16511_/B VDD VSS _16512_/B XOR2X1
X_14772_ _19390_/Q _15768_/B _14772_/C VDD VSS _14811_/B MIN3X1
XFILLER_16_244 VDD VSS FILLER4
XFILLER_17_92 VDD VSS FILLER1
X_10935_ _18782_/Q VDD VSS _11641_/A INVX1
X_13723_ _19114_/Q _13791_/B _13723_/C VDD VSS _13784_/B XOR3X1
X_17491_ _17496_/C _17496_/B VDD VSS _17493_/B NAND2BX1
XFILLER_140_93 VDD VSS FILLER1
XFILLER_44_597 VSS VDD FILLER2
XFILLER_71_383 VDD VSS FILLER4
XTAP_TAPCELL_ROW_26_272 VDD VSS WELLTAP
X_10866_ _10866_/A _10866_/B _10866_/C _10866_/D VDD VSS _10896_/C AOI31X1
X_13654_ _18945_/Q _13654_/B _13675_/D VDD VSS _13748_/B XNOR3X1
Xclkbuf_leaf_24__002_ clkload17/A VDD VSS _18764_/CK BUFX12
X_19230_ _19234_/CK _19230_/D _19230_/Q VDD VSS DFFQX1
X_16442_ _19727_/Q _16442_/B _16891_/B VDD VSS _16467_/B MIN3X1
XFILLER_13_940 VDD VSS FILLER4
X_12605_ _18934_/Q _12617_/B _14182_/B VDD VSS _14150_/B XNOR3X1
X_19161_ _19187_/CK _19161_/D _19161_/Q VDD VSS DFFQX1
X_16373_ _19597_/Q _16747_/B VDD VSS _16398_/C NAND2X1
X_10797_ _10798_/A _10798_/B _10798_/D _10798_/C VDD VSS _10803_/B AOAI211X1
X_13585_ _13585_/A wire155/Y _14225_/C VDD VSS _13586_/D NOR3X1
X_18112_ _18112_/A _18112_/B _18112_/C VDD VSS _18117_/A OA21X2
X_15324_ _19430_/Q _15814_/B VDD VSS _15347_/B NAND2BX1
XFILLER_129_135 VDD VSS FILLER1
XFILLER_129_146 VDD VSS DECAPHV8
XFILLER_8_432 VDD VSS FILLER4
XTAP_TAPCELL_ROW_4_51 VDD VSS WELLTAP
X_12536_ _18990_/Q VDD VSS _12693_/A INVX1
X_19092_ _19121_/CK _19092_/D _19092_/Q VDD VSS DFFQX1
X_12467_ _12467_/A _14438_/B VDD VSS _12480_/A OR2X2
X_18043_ _18044_/B _18045_/B _18043_/C _18049_/D VDD VSS _19979_/D OAI31X1
X_15255_ _19317_/Q _15688_/B VDD VSS _15256_/B XNOR2X1
X_11418_ _18540_/D _11428_/B VDD VSS _18612_/D NOR2BX1
X_14206_ _14218_/A _14206_/B VDD VSS _18955_/D NOR2X1
X_15186_ _19537_/Q _15186_/B VDD VSS _15270_/C NOR2BX1
X_12398_ _19238_/Q _12402_/A _12402_/B VDD VSS _12405_/A NOR3X1
X_14137_ _14136_/Y _14137_/B _14137_/C VDD VSS _18894_/D AND3BX1
XFILLER_113_547 VDD VSS FILLER4
X_11349_ _11364_/A _11349_/B _11356_/C VDD VSS _11358_/B AOI21X1
X_19994_ _19999_/CK _19994_/D _19994_/Q VDD VSS DFFQX1
Xclkbuf_0__09170_ _18219_/ECK VDD VSS clkbuf_0__09170_/Y BUFX12
XFILLER_113_569 VDD VSS FILLER4
XFILLER_140_366 VDD VSS DECAPHV8
X_14068_ _14068_/A _14068_/B _14068_/C VDD VSS _14203_/B NOR3X1
X_18945_ _19001_/CK _18945_/D _18945_/Q VDD VSS DFFQX1
XFILLER_67_623 VDD VSS FILLER4
X_13019_ _13102_/A _13102_/B _13102_/D _13102_/C VDD VSS _14352_/C AOI211X1
X_18876_ _18908_/CK _18876_/D _18876_/Q VDD VSS DFFQX1
XFILLER_27_509 VDD VSS FILLER4
X_17827_ _19930_/Q _17827_/B VDD VSS _19930_/D NOR2X1
XFILLER_39_369 VSS VDD FILLER2
XFILLER_54_328 VSS VDD FILLER2
XFILLER_35_531 VSS VDD FILLER2
XFILLER_63_840 VDD VSS DECAPHV16
X_17758_ _17758_/A _17758_/B _17758_/C VDD VSS _17766_/A OA21X2
XTAP_TAPCELL_ROW_80_816 VDD VSS WELLTAP
X_17689_ _19900_/Q _19868_/Q VDD VSS _17690_/B XOR2X1
X_16709_ _19914_/Q _16726_/B VDD VSS _19562_/D AND2X1
XFILLER_22_225 VDD VSS FILLER4
X_19428_ _19547_/CK _19428_/D _19428_/Q VDD VSS DFFQX1
X_19359_ _19362_/CK _19359_/D _19359_/Q VDD VSS DFFQX1
XFILLER_129_691 VDD VSS DECAPHV8
XFILLER_135_149 VDD VSS FILLER4
XFILLER_104_514 VDD VSS FILLER1
XFILLER_116_374 VSS VDD FILLER2
X_20203_ _20203_/A VDD VSS _20203_/Y BUFX3
XFILLER_89_214 VDD VSS FILLER1
XTAP_TAPCELL_ROW_112_1138 VDD VSS WELLTAP
Xmax_cap184 _18520_/Q VDD VSS _18499_/D BUFX12
Xmax_cap173 _09813_/B VDD VSS _09785_/B BUFX3
XFILLER_104_558 VDD VSS FILLER4
X_09945_ _10032_/A _09945_/B _10166_/D VDD VSS _09953_/C OA21X2
X_20134_ _20134_/A VDD VSS _20134_/Y BUFX3
X_09876_ _09944_/A _09876_/B _09876_/C VDD VSS _09895_/B AOI21X1
X_20065_ clkload5/A _20065_/D _20065_/Q _20065_/RB VDD VSS DFFRQX1
XFILLER_85_453 VDD VSS FILLER1
XFILLER_18_509 VSS VDD FILLER2
XFILLER_57_177 VDD VSS FILLER4
XFILLER_72_103 VDD VSS DECAPHV8
XTAP_TAPCELL_ROW_96_971 VDD VSS WELLTAP
XTAP_TAPCELL_ROW_68_695 VDD VSS WELLTAP
XFILLER_26_553 VDD VSS FILLER4
XFILLER_60_309 VDD VSS DECAPHV8
XTAP_TAPCELL_ROW_123_1245 VDD VSS WELLTAP
XFILLER_26_575 VDD VSS FILLER1
XFILLER_81_670 VDD VSS FILLER4
X_10720_ _10721_/A _10721_/C _10721_/B VDD VSS _10757_/C AOI21X1
XFILLER_10_910 VSS VDD FILLER2
XTAP_TAPCELL_ROW_23_242 VDD VSS WELLTAP
X_10651_ _18628_/Q _18721_/Q VDD VSS _10652_/C NAND2X1
X_10582_ _11116_/A _10582_/B _10582_/C _11255_/A VDD VSS _10737_/C OA211X2
X_13370_ _19026_/Q _13370_/B _13406_/D VDD VSS _13509_/B XNOR3X1
XFILLER_127_617 VSS VDD FILLER2
XFILLER_6_925 VSS VDD FILLER2
X_12321_ _14532_/A _14532_/B _19238_/Q VDD VSS _12391_/C AOI21BX1
X_12252_ _12300_/A _12300_/B _12300_/C VDD VSS _12451_/B OAI21X1
X_15040_ _19396_/Q _15775_/B VDD VSS _15041_/C NOR2BX1
XFILLER_102_0 VSS VDD FILLER2
XFILLER_107_363 VSS VDD FILLER2
XFILLER_108_864 VDD VSS FILLER4
XFILLER_108_886 VDD VSS DECAPHV16
XFILLER_135_650 VDD VSS FILLER1
XFILLER_5_468 VSS VDD FILLER2
XTAP_TAPCELL_ROW_134_1352 VDD VSS WELLTAP
X_11203_ _18655_/Q _18817_/Q VDD VSS _11204_/C NAND2X1
XFILLER_107_396 VDD VSS DECAPHV8
X_12183_ _19125_/Q _12183_/B _12183_/C VDD VSS _12208_/B XNOR3X1
X_11134_ _11196_/A _18735_/Q _11134_/C _11134_/D VDD VSS _11149_/A AOI22X1
X_16991_ _19752_/Q _17078_/B _16991_/C VDD VSS _16992_/B MIN3X1
X_11065_ _11102_/C _11065_/B VDD VSS _11078_/C NOR2X1
X_18730_ _18785_/CK _18730_/D _18730_/Q VDD VSS DFFQX1
X_15942_ _15963_/C _15942_/B VDD VSS _16730_/B XNOR2X1
XFILLER_49_645 VDD VSS FILLER4
XFILLER_49_656 VDD VSS FILLER1
XFILLER_76_431 VDD VSS DECAPHV8
X_10016_ _09987_/Y _10015_/Y _10032_/A VDD VSS _10018_/B MUXI2X1
X_18661_ _18797_/CK _18661_/D _18661_/Q VDD VSS DFFQX1
X_15873_ _15879_/A _15873_/B VDD VSS _19481_/D AND2X1
XFILLER_63_125 VSS VDD FILLER2
X_18592_ _18595_/CK _18592_/D _18592_/Q VDD VSS DFFQX1
X_17612_ _19883_/Q _19851_/Q VDD VSS _17618_/B NAND2X1
X_14824_ _15865_/B _14824_/B _14824_/C VDD VSS _14918_/A NOR3X1
XFILLER_45_873 VSS VDD FILLER2
XFILLER_51_309 VDD VSS FILLER4
X_11967_ _19119_/Q _11967_/B _11967_/C VDD VSS _11968_/C MIN3X1
X_17543_ _19869_/Q _19837_/Q VDD VSS _17544_/B XOR2X1
X_14755_ _14778_/A _14840_/A _14773_/C VDD VSS _15800_/B XNOR3X1
X_10918_ _10954_/B _10954_/C VDD VSS _10919_/B NOR2BX1
X_13706_ _13716_/A _13716_/B _13716_/C VDD VSS _13779_/B OA21X2
X_17474_ _19854_/Q _19822_/Q VDD VSS _17477_/A XNOR2X1
XFILLER_32_534 VDD VSS FILLER4
X_11898_ _11966_/A _11966_/B VDD VSS _14398_/B XNOR2X1
X_14686_ _14733_/A _14733_/B _14702_/C VDD VSS _15798_/B XNOR3X1
X_19213_ _19242_/CK _19213_/D _19213_/Q VDD VSS DFFQX1
X_16425_ _19599_/Q _16750_/B VDD VSS _16426_/B XOR2X1
XTAP_TAPCELL_ROW_100_1020 VDD VSS WELLTAP
X_10849_ _18565_/Q _10849_/B VDD VSS _10851_/A NAND2X1
X_13637_ _13637_/A _13637_/B _13637_/C _13637_/D VDD VSS _14453_/B AOAI211X1
X_13568_ _18972_/Q _13568_/B _14226_/C VDD VSS _13675_/B XNOR3X1
X_19144_ _19172_/CK _19144_/D _19144_/Q VDD VSS DFFQX1
X_16356_ _16512_/A _16356_/B VDD VSS _19532_/D NOR2X1
XFILLER_9_796 VDD VSS DECAPHV8
X_12519_ _19044_/Q _12519_/B _12519_/C VDD VSS _12540_/C OR3BX1
X_19075_ _19124_/CK _19075_/D _19075_/Q VDD VSS DFFQX1
X_16287_ _16287_/A _16313_/C VDD VSS _16744_/B XNOR2X1
X_15307_ _15307_/A _15307_/B VDD VSS _15878_/B _15307_/C _15307_/D NAND4X2
X_13499_ _18915_/Q _14161_/B VDD VSS _13662_/A AND2X1
X_18026_ _18534_/Q _18026_/B VDD VSS _18027_/C NOR2X1
X_15238_ _19512_/Q _15906_/B VDD VSS _15274_/B NAND2BX1
XFILLER_114_801 VSS VDD FILLER2
XFILLER_126_672 VDD VSS FILLER4
XFILLER_99_501 VSS VDD FILLER2
X_15169_ _15171_/B _15169_/B VDD VSS _18102_/B XNOR2X1
XFILLER_113_344 VDD VSS FILLER4
XFILLER_113_366 VDD VSS FILLER1
X_19977_ _19986_/CK _19977_/D _19977_/Q VDD VSS DFFQX1
Xfanout219 _20081_/RB VDD VSS _20079_/RB BUFX3
Xfanout208 _18455_/RB VDD VSS _18452_/RB BUFX3
XFILLER_140_185 VSS VDD FILLER2
XFILLER_141_697 VDD VSS FILLER1
X_09730_ _09753_/A _09730_/B _09730_/C VDD VSS _09731_/D AOI21X1
X_18928_ _18935_/CK _18928_/D _18928_/Q VDD VSS DFFQX1
XFILLER_95_751 VDD VSS FILLER1
XFILLER_67_464 VDD VSS FILLER1
XFILLER_95_762 VDD VSS DECAPHV8
X_09661_ _20202_/A _09811_/C _09770_/C _20087_/A VDD VSS _09664_/B AOI22X1
X_18859_ _18888_/CK _18859_/D _18859_/Q VDD VSS DFFQX1
XFILLER_67_497 VDD VSS DECAPHV8
XTAP_TAPCELL_ROW_93_941 VDD VSS WELLTAP
X_09592_ _18240_/Q _09770_/B _09797_/C _20198_/A _09592_/E VDD VSS _09593_/D AOI221X1
XTAP_TAPCELL_ROW_65_665 VDD VSS WELLTAP
XFILLER_63_681 VDD VSS FILLER1
XTAP_TAPCELL_ROW_37_389 VDD VSS WELLTAP
XFILLER_24_16 VDD VSS DECAPHV8
XFILLER_24_38 VDD VSS FILLER1
XFILLER_11_718 VDD VSS DECAPHV8
XFILLER_50_353 VSS VDD FILLER2
XFILLER_10_217 VDD VSS DECAPHV8
XTAP_TAPCELL_ROW_20_212 VDD VSS WELLTAP
XFILLER_108_127 VDD VSS DECAPHV8
XFILLER_117_650 VDD VSS FILLER1
XFILLER_123_108 VDD VSS FILLER1
XFILLER_3_917 VDD VSS FILLER4
XFILLER_105_845 VDD VSS DECAPHV8
XFILLER_117_683 VDD VSS DECAPHV16
XFILLER_144_480 VDD VSS DECAPHV8
Xhold262 hold262/A VDD VSS input4/A BUFX3
X_09928_ _09928_/A _09928_/B _09928_/C VDD VSS _09929_/C OAI21X1
X_20117_ _20117_/A VDD VSS _20117_/Y BUFX3
XFILLER_18_306 VDD VSS FILLER4
XFILLER_74_924 VSS VDD FILLER2
XFILLER_86_784 VDD VSS FILLER1
X_09859_ _10966_/A VDD VSS _11229_/A BUFX3
X_20048_ _20048_/CK _20048_/D _20048_/Q _09280_/Y VDD VSS DFFRQX1
XFILLER_18_328 VDD VSS DECAPHV8
XFILLER_45_103 VSS VDD FILLER2
XFILLER_73_412 VDD VSS FILLER4
X_12870_ _12906_/A _13005_/B _12997_/C VDD VSS _12996_/B XNOR3X1
XFILLER_27_840 VSS VDD FILLER2
XFILLER_65_78 VDD VSS FILLER1
X_11821_ _19118_/Q _11821_/B _11821_/C VDD VSS _11899_/B MIN3X1
XFILLER_121_40 VDD VSS FILLER1
XFILLER_42_821 VDD VSS FILLER1
XFILLER_54_670 VDD VSS FILLER1
XFILLER_60_128 VDD VSS DECAPHV8
XFILLER_73_489 VDD VSS FILLER4
X_14540_ _14540_/A _14540_/B _17827_/B VDD VSS _19246_/D AOI21X1
XFILLER_121_73 VDD VSS FILLER1
X_11752_ _11776_/A _11835_/B _11835_/C VDD VSS _11764_/C OR3BX1
XFILLER_41_375 VDD VSS FILLER1
X_10703_ _10703_/A _10709_/C VDD VSS _10707_/B XNOR2X1
X_11683_ _18928_/Q VDD VSS _12129_/A INVX1
X_14471_ _14766_/A _14471_/B VDD VSS _19184_/D AND2X1
XFILLER_128_915 VSS VDD FILLER2
X_10634_ _10681_/B _10634_/B VDD VSS _10653_/B XNOR2X1
X_13422_ _14323_/A _13422_/B _13422_/C _13422_/D VDD VSS _13601_/B AOI31X1
X_17190_ _19793_/Q _19761_/Q VDD VSS _17197_/C NOR2X1
X_16210_ _19559_/Q _19911_/Q VDD VSS _16211_/B XNOR2X1
X_13353_ _19138_/Q _13546_/A _13617_/B VDD VSS _13616_/D XNOR3X1
X_16141_ _19620_/Q _16773_/B VDD VSS _16142_/B XOR2X1
X_10565_ _18637_/Q _18799_/Q VDD VSS _10570_/B OR2X2
X_12304_ _12382_/A _12382_/B _12382_/C VDD VSS _14437_/B AOI21X1
X_10496_ _10496_/A _10496_/B _10496_/C _10496_/D VDD VSS _10582_/B AND4X2
X_13284_ _14522_/A VDD VSS _14118_/A BUFX3
X_16072_ _19681_/Q _16841_/B VDD VSS _16080_/B NAND2X1
XTAP_TAPCELL_ROW_1_30 VDD VSS WELLTAP
X_12235_ _12236_/A _12236_/B _12236_/D _12236_/C VDD VSS _14531_/B AO211X2
X_19900_ _19928_/CK _19900_/D _19900_/Q VDD VSS DFFQX1
X_15023_ _15044_/A _15092_/A _15092_/B VDD VSS _15045_/D XNOR3X1
X_12166_ _20000_/Q _19264_/Q VDD VSS _12236_/C NOR2X1
X_19831_ _19833_/CK _19831_/D _19831_/Q VDD VSS DFFQX1
XFILLER_111_826 VDD VSS FILLER4
XFILLER_111_848 VDD VSS FILLER1
X_11117_ _11048_/Y _11116_/Y _10947_/Y VDD VSS _11118_/B MUXI2X1
XFILLER_110_336 VDD VSS FILLER4
XFILLER_49_442 VDD VSS FILLER1
XFILLER_77_751 VDD VSS FILLER1
X_12097_ _12160_/A _14465_/B VDD VSS _12112_/B NOR2X1
X_19762_ _19795_/CK _19762_/D _19762_/Q VDD VSS DFFQX1
X_16974_ _19750_/Q _16978_/B VDD VSS _16975_/B XOR2X1
X_11048_ _11014_/Y _11047_/Y _10984_/A VDD VSS _11048_/Y MUX2X1
X_19693_ _19724_/CK _19693_/D _19693_/Q VDD VSS DFFQX1
X_18713_ _18768_/CK _18713_/D _18713_/Q VDD VSS DFFQX1
X_15925_ _19548_/Q _19900_/Q VDD VSS _15939_/B XNOR2X1
XFILLER_37_626 VDD VSS FILLER1
XFILLER_92_732 VDD VSS FILLER1
X_18644_ _18809_/CK _18644_/D _18644_/Q VDD VSS DFFQX1
X_15856_ _15867_/A _15856_/B VDD VSS _19467_/D NOR2X1
XFILLER_36_158 VDD VSS FILLER4
XFILLER_92_776 VDD VSS FILLER1
X_14807_ _14809_/A _14807_/B VDD VSS _18063_/B XNOR2X1
XFILLER_17_361 VDD VSS FILLER4
XFILLER_91_286 VSS VDD FILLER2
XTAP_TAPCELL_ROW_90_911 VDD VSS WELLTAP
X_12999_ _13007_/A _13095_/A _13270_/B VDD VSS _13008_/D XNOR3X1
Xclkbuf_leaf_7__000_ clkload79/A VDD VSS _19615_/CK BUFX12
X_18575_ _18582_/CK _18575_/D _18575_/Q VDD VSS DFFQX1
X_15787_ _15793_/A _15787_/B VDD VSS _19406_/D AND2X1
XFILLER_44_180 VDD VSS DECAPHV16
XTAP_TAPCELL_ROW_62_635 VDD VSS WELLTAP
X_17526_ _19864_/Q _19832_/Q VDD VSS _17527_/C NAND2X1
X_14738_ _14781_/A _14781_/B VDD VSS _14751_/B NAND2X1
XFILLER_20_504 VDD VSS FILLER4
XTAP_TAPCELL_ROW_34_359 VDD VSS WELLTAP
X_14669_ _14669_/A _14669_/B _15797_/B VDD VSS _14698_/B MIN3X1
X_17457_ _17460_/A _17460_/B _17509_/C VDD VSS _17458_/C OAI21X1
X_17388_ _19836_/Q _19804_/Q VDD VSS _17389_/B XOR2X1
X_16408_ _19694_/Q _16855_/B VDD VSS _16416_/B XNOR2X1
XFILLER_119_926 VDD VSS FILLER4
XFILLER_9_571 VDD VSS DECAPHV8
X_19127_ _19129_/CK _19127_/D _19127_/Q VDD VSS DFFQX1
X_16339_ _19915_/Q VDD VSS _16710_/A INVX1
XFILLER_65_0 VSS VDD FILLER2
XFILLER_133_406 VSS VDD FILLER2
X_19058_ _19115_/CK _19058_/D _19058_/Q VDD VSS DFFQX1
XFILLER_10_29 VDD VSS FILLER4
X_18009_ _18549_/Q _18057_/C _18058_/B VDD VSS _18054_/A OAI21X1
XFILLER_0_909 VDD VSS FILLER4
XFILLER_113_141 VSS VDD FILLER2
XFILLER_113_174 VDD VSS FILLER4
XFILLER_87_537 VDD VSS FILLER4
XFILLER_113_185 VDD VSS FILLER1
XFILLER_141_494 VDD VSS DECAPHV8
XFILLER_110_870 VDD VSS DECAPHV8
XFILLER_142_39 VSS VDD FILLER2
XFILLER_67_250 VDD VSS FILLER1
X_09713_ _20141_/A _20189_/A _09753_/A VDD VSS _09716_/C MUX2X1
XFILLER_82_220 VSS VDD FILLER2
XFILLER_83_743 VDD VSS FILLER1
X_09644_ _18444_/Q _09751_/B _09772_/B _18348_/Q _09644_/E VDD VSS _09647_/C OAI221X1
XFILLER_28_659 VSS VDD FILLER2
XFILLER_82_231 VDD VSS FILLER1
X_09575_ _18344_/Q _09772_/B _09575_/C VDD VSS _09581_/B OAI21X1
XFILLER_24_843 VSS VDD FILLER2
XTAP_TAPCELL_ROW_120_1215 VDD VSS WELLTAP
XFILLER_23_375 VDD VSS FILLER4
XFILLER_24_876 VDD VSS FILLER4
XFILLER_137_712 VDD VSS FILLER1
XFILLER_7_508 VDD VSS DECAPHV16
XFILLER_137_734 VSS VDD FILLER2
XFILLER_125_907 VDD VSS FILLER1
XFILLER_125_918 VDD VSS DECAPHV8
XFILLER_136_255 VDD VSS FILLER1
X_10350_ _10512_/A _10500_/B _10500_/C _10550_/A VDD VSS _10660_/B OAOI211X1
XFILLER_136_288 VDD VSS DECAPHV8
XTAP_TAPCELL_ROW_118_1199 VDD VSS WELLTAP
X_10281_ _10329_/A _10329_/B VDD VSS _10281_/Y NOR2X1
XFILLER_2_235 VSS VDD FILLER2
XTAP_TAPCELL_ROW_131_1322 VDD VSS WELLTAP
X_12020_ _19066_/Q _12020_/B _12075_/C VDD VSS _12284_/B MIN3X1
XFILLER_104_152 VDD VSS DECAPHV8
XFILLER_120_601 VSS VDD FILLER2
XFILLER_59_773 VDD VSS FILLER4
X_13971_ _14036_/A _14045_/B VDD VSS _14201_/B XNOR2X1
XFILLER_19_648 VSS VDD FILLER2
XFILLER_46_423 VDD VSS FILLER1
XFILLER_58_283 VSS VDD FILLER2
XFILLER_76_77 VSS VDD FILLER2
X_12922_ _19078_/Q VDD VSS _13020_/A INVX1
X_16690_ _16690_/A _16690_/B _16690_/C VDD VSS _19545_/D AOI21X1
X_15710_ _15710_/A _15710_/B VDD VSS _19337_/D NOR2X1
XFILLER_132_61 VDD VSS FILLER4
XFILLER_34_607 VSS VDD FILLER2
XFILLER_73_253 VDD VSS FILLER1
X_15641_ _15641_/A _15641_/B _15641_/C VDD VSS _15653_/A OAI21X1
XFILLER_15_821 VSS VDD FILLER2
XTAP_TAPCELL_ROW_142_1440 VDD VSS WELLTAP
X_12853_ _19245_/Q _13049_/A _13054_/B VDD VSS _12951_/D XNOR3X1
XFILLER_92_87 VDD VSS FILLER4
X_11804_ _11804_/A _11804_/B _11804_/C _11804_/D VDD VSS wire165/A OAOI211X1
X_12784_ _18936_/Q _12877_/B _14184_/B VDD VSS _14152_/B XNOR3X1
X_18360_ _18367_/CK _18525_/Q _20197_/A _20075_/RB VDD VSS DFFRQX1
X_15572_ _15599_/A _15599_/B VDD VSS _15578_/A NAND2X1
XFILLER_15_876 VDD VSS DECAPHV8
X_11735_ _19225_/Q VDD VSS _11737_/A INVX1
X_14523_ _14522_/Y _14523_/B _14523_/C VDD VSS _19229_/D AND3BX1
X_18291_ _18291_/CK _18291_/D _18291_/Q VDD VSS DFFQX1
X_17311_ _19819_/Q _19787_/Q VDD VSS _17318_/B NAND2X1
XFILLER_30_857 VDD VSS DECAPHV16
XTAP_TAPCELL_ROW_31_329 VDD VSS WELLTAP
X_14454_ _14467_/A _14454_/B VDD VSS _19169_/D AND2X1
X_17242_ _17240_/B _17242_/B VDD VSS _17243_/C NOR2BX1
X_11666_ _18805_/Q _11669_/B VDD VSS _18832_/D AND2X1
X_13405_ _13406_/A _13406_/B _13406_/D _13406_/C VDD VSS _14293_/C AOI211X1
XFILLER_10_581 VDD VSS FILLER1
X_10617_ _10638_/A _10638_/B VDD VSS _10618_/B _10617_/C NAND3X1
X_11597_ _18742_/Q _11600_/B VDD VSS _18769_/D AND2X1
X_14385_ _14410_/A _14385_/B _14385_/C VDD VSS _19107_/D NOR3X1
X_17173_ _17176_/C _17174_/B _17229_/C VDD VSS _17174_/C OAI21X1
XFILLER_116_918 VDD VSS FILLER4
XFILLER_127_244 VSS VDD FILLER2
XFILLER_128_789 VDD VSS FILLER1
XFILLER_143_715 VSS VDD FILLER2
X_10548_ _10548_/A _10548_/B _10548_/C VDD VSS _10596_/A NOR3X1
X_13336_ _19193_/Q _14480_/B VDD VSS _13451_/A AND2X1
X_16124_ _16126_/B _16124_/B VDD VSS _16125_/B XNOR2X1
XFILLER_142_214 VDD VSS FILLER1
X_13267_ _19109_/Q _13432_/A _13322_/C VDD VSS _13364_/D XNOR3X1
X_16055_ _16049_/A _16055_/B _16055_/C VDD VSS _16074_/A AOI2B1X1
X_10479_ _10514_/D _10514_/C VDD VSS _10481_/D NOR2BX1
X_12218_ _12329_/A _12218_/B VDD VSS _14467_/B XNOR2X1
X_15006_ _15054_/A _15054_/B VDD VSS _15022_/B NOR2X1
XFILLER_111_601 VDD VSS FILLER4
XFILLER_111_612 VDD VSS FILLER4
XFILLER_123_472 VDD VSS DECAPHV8
X_13198_ _13198_/A _13198_/B _13198_/C _13198_/D VDD VSS _13203_/A OAOI211X1
X_12149_ _12149_/A _12149_/B _12149_/C _12149_/D VDD VSS wire159/A OAOI211X1
X_19814_ _19863_/CK _19814_/D _19814_/Q VDD VSS DFFQX1
XFILLER_49_250 VDD VSS FILLER1
XFILLER_84_507 VDD VSS FILLER4
XTAP_TAPCELL_ROW_39_407 VDD VSS WELLTAP
X_19745_ clkload2/A _19745_/D _19745_/Q VDD VSS DFFQX1
X_16957_ _19747_/Q _16978_/B VDD VSS _16962_/B XOR2X1
X_15908_ _16100_/A _15908_/B VDD VSS _19513_/D NOR2X1
XFILLER_25_607 VSS VDD FILLER2
X_19676_ _19711_/CK _19676_/D _19676_/Q VDD VSS DFFQX1
X_16888_ _16891_/A _16888_/B VDD VSS _19724_/D NOR2X1
XFILLER_52_426 VDD VSS FILLER4
XFILLER_53_949 VDD VSS FILLER1
XFILLER_92_573 VDD VSS DECAPHV16
X_18627_ _18628_/CK _18627_/D _18627_/Q VDD VSS DFFQX1
X_15839_ _17172_/A VDD VSS _17986_/C BUFX3
XTAP_TAPCELL_ROW_47_484 VDD VSS WELLTAP
X_09360_ _20071_/RB _09414_/D VDD VSS _09360_/Y NOR2BX1
X_18558_ _18565_/CK _18558_/D _18558_/Q VDD VSS DFFQX1
X_09291_ _09516_/B VDD VSS _18201_/A BUFX3
X_17509_ _17512_/C _17510_/B _17509_/C VDD VSS _17510_/C OAI21X1
XANTENNA_13 _17906_/C VDD VSS ANTENNA2
X_18489_ _18494_/CK _18510_/Q _20102_/A _18492_/RB VDD VSS DFFRQX1
XANTENNA_24 _20122_/Y VDD VSS ANTENNA2
XANTENNA_35 _18127_/B VDD VSS ANTENNA2
XFILLER_21_39 VDD VSS FILLER1
XFILLER_133_214 VDD VSS FILLER1
Xoutput142 _20225_/Y VDD VSS o_uwb_tx_cfg[28] BUFX3
Xoutput131 _20215_/Y VDD VSS o_uwb_tx_cfg[18] BUFX3
Xoutput120 _20189_/Y VDD VSS o_tst_ctrl[8] BUFX3
XFILLER_102_601 VSS VDD FILLER2
XFILLER_15_117 VDD VSS FILLER1
XFILLER_44_949 VDD VSS FILLER1
XFILLER_70_201 VDD VSS DECAPHV8
X_09627_ _20166_/A _09811_/B _09627_/C VDD VSS _09628_/D AOI21X1
XFILLER_102_31 VDD VSS FILLER1
X_09558_ _09766_/C VDD VSS _09784_/B BUFX3
XFILLER_12_824 VDD VSS FILLER1
XFILLER_51_492 VDD VSS FILLER1
XFILLER_70_289 VDD VSS FILLER1
X_09489_ _18457_/D _09501_/B _09489_/C VDD VSS _18240_/D AOI21X1
X_11520_ _16860_/A VDD VSS _11531_/B BUFX3
XFILLER_7_338 VSS VDD FILLER2
X_11451_ _19944_/Q _11460_/B VDD VSS _18637_/D AND2X1
XFILLER_109_266 VDD VSS DECAPHV8
X_10402_ _10402_/A _10402_/B _10402_/C _10402_/D VDD VSS _10476_/B OAOI211X1
X_11382_ _11382_/A _11384_/C VDD VSS _11383_/B XNOR2X1
X_14170_ _14219_/A _14170_/B _14170_/C VDD VSS _18923_/D NOR3X1
X_10333_ _18632_/Q _18794_/Q VDD VSS _10372_/D XOR2X1
X_13121_ _19163_/Q VDD VSS _13122_/A INVX1
XFILLER_127_50 VDD VSS DECAPHV8
Xclkbuf_leaf_6__001_ clkload41/A VDD VSS _19196_/CK BUFX12
XFILLER_121_921 VSS VDD FILLER2
X_10264_ _10264_/A _10264_/B VDD VSS _10349_/B NAND2X1
X_13052_ _19247_/Q VDD VSS _13244_/A INVX1
XFILLER_132_291 VDD VSS FILLER4
X_10195_ _10200_/A _10195_/B VDD VSS _11424_/C XNOR2X1
X_12003_ _19122_/Q _12087_/A _14401_/B VDD VSS _12079_/C XOR3X1
X_17860_ _17863_/C _17860_/B _17860_/C VDD VSS _19940_/D AOI21X1
XFILLER_78_378 VDD VSS FILLER1
X_16811_ _16811_/A _16811_/B VDD VSS _19654_/D NOR2X1
X_19530_ _19533_/CK _19530_/D _19530_/Q VDD VSS DFFQX1
X_17791_ _19922_/Q _19890_/Q VDD VSS _17793_/D XNOR2X1
XFILLER_47_743 VDD VSS FILLER1
X_13954_ _13955_/A _13955_/B _13955_/D _13955_/C VDD VSS _14004_/B OAOI211X1
X_16742_ _16748_/A _16742_/B VDD VSS _19592_/D NOR2X1
XFILLER_34_404 VDD VSS FILLER1
XFILLER_35_949 VDD VSS FILLER1
X_12905_ _13005_/A _13005_/C _13005_/B VDD VSS _14287_/C AOI21X1
X_13885_ _18920_/Q _14167_/B VDD VSS _13981_/C _14167_/C AND3X2
X_19461_ _19461_/CK _19461_/D _19461_/Q VDD VSS DFFQX1
X_16673_ _16673_/A VDD VSS _16794_/B INVX1
XFILLER_62_768 VDD VSS FILLER1
X_12836_ _12841_/B _12841_/C _19215_/Q VDD VSS _12843_/A AOI21X1
X_19392_ _19425_/CK _19392_/D _19392_/Q VDD VSS DFFQX1
X_18412_ _18423_/CK _18513_/Q _20167_/A _18444_/RB VDD VSS DFFRQX1
X_15624_ _15792_/B VDD VSS _15625_/C INVX1
XTAP_TAPCELL_ROW_44_454 VDD VSS WELLTAP
XTAP_TAPCELL_ROW_7_84 VDD VSS WELLTAP
X_18343_ _18343_/CK _18343_/D _18343_/Q _18373_/RB VDD VSS DFFRQX1
X_15555_ _15569_/A _15569_/B VDD VSS _15758_/B XNOR2X1
XFILLER_14_150 VDD VSS DECAPHV16
XFILLER_61_289 VDD VSS FILLER4
XTAP_TAPCELL_ROW_16_178 VDD VSS WELLTAP
X_12767_ _19216_/Q _12968_/A _12951_/B VDD VSS _12827_/D XNOR3X1
X_14506_ _15806_/A _14506_/B _14506_/C VDD VSS _19214_/D NOR3X1
XTAP_TAPCELL_ROW_99_1003 VDD VSS WELLTAP
X_11718_ _11742_/A _11742_/B VDD VSS _14519_/C _11742_/C NAND3X1
X_12698_ _18879_/Q _12790_/B _12703_/C VDD VSS _17870_/B XNOR3X1
X_18274_ _18275_/CK _18274_/D _18274_/Q _20081_/RB VDD VSS DFFRQX1
X_15486_ _19407_/Q _15788_/B VDD VSS _15525_/C NAND2X1
XTAP_TAPCELL_ROW_0_6 VDD VSS WELLTAP
X_11649_ _18789_/Q _11658_/B VDD VSS _18816_/D AND2X1
X_14437_ _14449_/A _14437_/B _14437_/C VDD VSS _19154_/D NOR3X1
Xclkbuf_leaf_10__000_ clkbuf_leaf_9__000_/A VDD VSS _19711_/CK BUFX12
X_17225_ _17227_/A _17227_/B _17225_/C VDD VSS _19800_/D AOI21X1
X_14368_ _14368_/A _14368_/B VDD VSS _19092_/D NOR2X1
X_17156_ _19785_/Q _19753_/Q _17156_/C VDD VSS _17160_/B MIN3X1
XFILLER_143_523 VDD VSS FILLER1
XFILLER_7_872 VSS VDD FILLER2
X_13319_ _13319_/A _13319_/B _13319_/C _13319_/D VDD VSS _13616_/A AOAI211X1
X_16107_ _16107_/A VDD VSS _16770_/B INVX1
X_14299_ _14334_/A _14299_/B VDD VSS _19031_/D AND2X1
Xclkbuf_leaf_25__000_ clkload78/A VDD VSS _19290_/CK BUFX12
X_17087_ _19771_/Q _19739_/Q _17087_/C VDD VSS _17091_/B AOI21X1
XFILLER_124_781 VSS VDD FILLER2
X_16038_ _19551_/Q _16696_/A _16038_/C VDD VSS _16062_/C MIN3X1
XFILLER_69_323 VDD VSS FILLER1
XFILLER_97_621 VDD VSS FILLER1
Xclkbuf_1_0__f_clk clkbuf_0_clk/Y VDD VSS _231_/CK BUFX12
XFILLER_111_464 VDD VSS FILLER1
XFILLER_28_0 VDD VSS FILLER4
XFILLER_96_142 VDD VSS FILLER1
XFILLER_97_654 VDD VSS DECAPHV8
X_17989_ _17989_/A _17989_/B _17989_/C _18163_/A VDD VSS _19963_/D OAOI211X1
X_19728_ _19730_/CK _19728_/D _19728_/Q VDD VSS DFFQX1
XFILLER_26_927 VDD VSS FILLER1
XFILLER_65_573 VDD VSS FILLER4
X_19659_ _19724_/CK _19659_/D _19659_/Q VDD VSS DFFQX1
XFILLER_52_223 VDD VSS FILLER4
XFILLER_53_757 VDD VSS DECAPHV8
X_09412_ _09507_/C VDD VSS _09506_/C BUFX3
XFILLER_12_109 VSS VDD FILLER2
X_09343_ _18444_/RB _09346_/B VDD VSS _09343_/Y NOR2BX1
XFILLER_32_38 VDD VSS FILLER1
X_09274_ _20043_/RB _09349_/B VDD VSS _09274_/Y NOR2BX1
XFILLER_138_328 VDD VSS FILLER1
XFILLER_20_142 VDD VSS FILLER1
XFILLER_32_49 VSS VDD FILLER2
XFILLER_119_586 VSS VDD FILLER2
XFILLER_119_597 VDD VSS DECAPHV8
XFILLER_115_770 VDD VSS FILLER4
XFILLER_122_729 VDD VSS FILLER1
XTAP_TAPCELL_ROW_115_1169 VDD VSS WELLTAP
XFILLER_0_569 VSS VDD FILLER2
XFILLER_76_816 VDD VSS FILLER4
XFILLER_29_743 VDD VSS FILLER1
XFILLER_57_79 VSS VDD FILLER2
XFILLER_113_52 VDD VSS FILLER4
XFILLER_28_242 VSS VDD FILLER2
XFILLER_28_275 VDD VSS FILLER1
XFILLER_84_882 VDD VSS FILLER1
XTAP_TAPCELL_ROW_86_877 VDD VSS WELLTAP
X_10951_ _10951_/A _10958_/B VDD VSS _10957_/B XOR2X1
XFILLER_16_448 VSS VDD FILLER2
XFILLER_17_949 VDD VSS FILLER1
XFILLER_44_757 VDD VSS FILLER4
XTAP_TAPCELL_ROW_126_1276 VDD VSS WELLTAP
X_13670_ _13748_/A _13748_/B VDD VSS _14163_/B _13748_/C AND3X2
X_10882_ _10882_/A _10921_/B VDD VSS _10887_/B XNOR2X1
X_12621_ _12632_/A _12632_/B _12632_/C VDD VSS _14284_/C OR3X2
XFILLER_43_289 VDD VSS FILLER1
XFILLER_8_603 VDD VSS FILLER1
XTAP_TAPCELL_ROW_13_148 VDD VSS WELLTAP
XTAP_TAPCELL_ROW_41_424 VDD VSS WELLTAP
X_12552_ _14440_/B _14439_/C _19156_/Q VDD VSS _12553_/D AND3BX1
X_15340_ _15340_/A _15690_/B _15340_/C VDD VSS _15385_/B MIN3X1
XFILLER_129_339 VSS VDD FILLER2
XFILLER_132_0 VDD VSS DECAPHV8
XFILLER_7_113 VDD VSS DECAPHV8
X_11503_ _18657_/Q _11508_/B VDD VSS _18684_/D AND2X1
X_12483_ _12483_/A _12483_/B _12483_/C _12483_/D VDD VSS _14440_/B OAOI211X1
X_15271_ _19540_/Q _15313_/B VDD VSS _15908_/B XOR2X1
X_11434_ _232_/E _11434_/B VDD VSS _18626_/D NOR2X1
X_14222_ _14294_/A _14222_/B _14222_/C VDD VSS _18969_/D NOR3X1
X_17010_ _17010_/A _17010_/B _17012_/C VDD VSS _19756_/D NOR3X1
XTAP_TAPCELL_ROW_137_1383 VDD VSS WELLTAP
XFILLER_125_556 VSS VDD FILLER2
X_11365_ _11371_/B _11365_/B VDD VSS _11375_/B XOR2X1
X_14153_ _14154_/A _14153_/B VDD VSS _18909_/D NOR2X1
XFILLER_140_504 VDD VSS FILLER4
XFILLER_4_886 VDD VSS DECAPHV8
X_10316_ _18659_/Q _18767_/Q VDD VSS _10405_/D XOR2X1
X_11296_ _18583_/Q _11296_/B _11296_/C VDD VSS _11304_/A MIN3X1
X_13104_ _13211_/A _13104_/B _13314_/D VDD VSS _13161_/C XNOR3X1
X_14084_ _14104_/C _14104_/A VDD VSS _14096_/A NOR2BX1
X_18961_ _18993_/CK _18961_/D _18961_/Q VDD VSS DFFQX1
XFILLER_112_228 VDD VSS FILLER4
XFILLER_140_548 VDD VSS DECAPHV8
XFILLER_78_120 VDD VSS FILLER1
X_10247_ _10247_/A _11430_/B _10266_/D _10266_/C VDD VSS _10315_/A AO22X2
X_13035_ _19217_/Q _14510_/B VDD VSS _13036_/D _14510_/C NAND3X1
X_17912_ _17912_/A _17914_/C VDD VSS _17913_/B XNOR2X1
XFILLER_121_751 VDD VSS FILLER1
XFILLER_79_654 VDD VSS FILLER1
X_18892_ _18917_/CK _18892_/D _18892_/Q VDD VSS DFFQX1
XFILLER_66_304 VDD VSS DECAPHV8
XFILLER_93_112 VDD VSS DECAPHV16
XTAP_TAPCELL_ROW_49_502 VDD VSS WELLTAP
X_10178_ _10184_/C _10184_/B VDD VSS _10179_/B NAND2BX1
X_17843_ _18846_/Q _17843_/B VDD VSS _17847_/C OR2X2
XFILLER_19_220 VDD VSS FILLER4
X_17774_ _17775_/A _17776_/C _17828_/C VDD VSS _17775_/C OAI21X1
X_14986_ _19311_/Q _15682_/B VDD VSS _14987_/B XNOR2X1
XFILLER_93_189 VDD VSS DECAPHV8
X_13937_ _18921_/Q _13949_/A _13949_/B VDD VSS _13938_/D XNOR3X1
X_19513_ _19543_/CK _19513_/D _19513_/Q VDD VSS DFFQX1
X_16725_ _19928_/Q _16726_/B VDD VSS _19576_/D AND2X1
XTAP_TAPCELL_ROW_57_590 VDD VSS WELLTAP
X_19444_ _19492_/CK _19444_/D _19444_/Q VDD VSS DFFQX1
X_13868_ _13868_/A _13868_/B _13868_/C _13868_/D VDD VSS _17940_/B OAOI211X1
X_16656_ _16657_/A _16657_/B _16657_/C VDD VSS _16675_/C AO21X2
XFILLER_50_738 VDD VSS FILLER1
X_12819_ _12819_/A _12819_/B _12819_/C _12819_/D VDD VSS _14382_/C OAI211X1
X_13799_ _18975_/Q _13827_/B _13845_/C VDD VSS _13987_/B XNOR3X1
X_19375_ _19393_/CK _19375_/D _19375_/Q VDD VSS DFFQX1
X_16587_ _19733_/Q _16898_/B VDD VSS _16589_/B XOR2X1
X_15607_ _15607_/A _15620_/C VDD VSS _15730_/B XNOR2X1
X_18326_ _18327_/CK _18470_/D _18326_/Q _18471_/RB VDD VSS DFFRQX1
X_15538_ _19352_/Q _15727_/B VDD VSS _15539_/C NAND2X1
X_18257_ _18257_/CK _18257_/D _18260_/D _18485_/RB VDD VSS DFFRQX1
X_15469_ _15469_/A _15469_/B _15850_/B VDD VSS _15511_/A MIN3X1
X_17208_ _17357_/B _17208_/B _17208_/C VDD VSS _17212_/C MIN3X1
XFILLER_116_501 VDD VSS FILLER4
XFILLER_128_350 VSS VDD FILLER2
X_18188_ _18191_/C _18188_/B _18188_/C VDD VSS _20011_/D AOI21X1
XFILLER_144_854 VDD VSS FILLER1
X_17139_ _17140_/A _17140_/B _17140_/D _17140_/C VDD VSS _17142_/C AOI211X1
XFILLER_143_375 VDD VSS FILLER4
X_20150_ _20150_/A VDD VSS _20150_/Y BUFX3
X_20081_ _20081_/CK _20081_/D _20081_/Q _20081_/RB VDD VSS DFFRQX1
XFILLER_112_762 VDD VSS FILLER4
XFILLER_58_816 VDD VSS DECAPHV16
X_09892_ _18561_/Q _09892_/B VDD VSS _09893_/B XOR2X1
XFILLER_111_261 VDD VSS DECAPHV8
XFILLER_66_871 VDD VSS FILLER1
XTAP_TAPCELL_ROW_83_847 VDD VSS WELLTAP
XFILLER_41_705 VDD VSS DECAPHV16
XFILLER_53_576 VDD VSS FILLER4
XFILLER_81_863 VDD VSS FILLER4
Xclkbuf_leaf_5__002_ clkbuf_leaf_9__002_/A VDD VSS _18799_/CK BUFX12
X_09326_ _18288_/Q _18516_/Q _09299_/Y VDD VSS _09326_/Y MUXI2X1
XFILLER_139_637 VDD VSS FILLER4
X_09257_ _20047_/Q _20048_/Q _09257_/C VDD VSS _09258_/B AND3BX1
XFILLER_138_136 VSS VDD FILLER2
XTAP_TAPCELL_ROW_10_118 VDD VSS WELLTAP
X_09188_ _18525_/Q VDD VSS _18456_/D INVX1
X_11150_ _11116_/B _11149_/Y _10984_/A VDD VSS _11150_/Y MUXI2X1
X_10101_ _10101_/A _10101_/B _10101_/C VDD VSS _10120_/A MIN3X1
XFILLER_122_559 VDD VSS DECAPHV8
XFILLER_76_602 VSS VDD FILLER2
X_11081_ _10948_/Y _11080_/Y _11118_/A VDD VSS _11081_/Y MUXI2X1
X_10032_ _10032_/A VDD VSS _10155_/A BUFX3
X_14840_ _14840_/A _14840_/B _14840_/C _14840_/D VDD VSS _14867_/B OAOI211X1
XFILLER_91_627 VSS VDD FILLER2
X_14771_ _19391_/Q VDD VSS _14811_/A INVX1
XFILLER_17_735 VSS VDD FILLER2
XFILLER_75_189 VDD VSS FILLER4
XFILLER_84_99 VDD VSS FILLER4
X_11983_ _19233_/Q _12055_/A _12055_/B VDD VSS _11985_/C XNOR3X1
X_13722_ _13791_/A _13791_/C VDD VSS _13723_/C NOR2X1
X_16510_ _19730_/Q _16895_/B VDD VSS _16511_/B XNOR2X1
XFILLER_17_71 VSS VDD FILLER2
XFILLER_72_863 VDD VSS FILLER4
X_10934_ _18674_/Q VDD VSS _11522_/A INVX1
X_17490_ _19857_/Q _19825_/Q VDD VSS _17496_/B NAND2X1
XFILLER_16_278 VDD VSS FILLER1
XFILLER_31_226 VDD VSS DECAPHV16
XFILLER_44_576 VDD VSS FILLER1
XTAP_TAPCELL_ROW_26_273 VDD VSS WELLTAP
XTAP_TAPCELL_ROW_54_560 VDD VSS WELLTAP
X_10865_ _18645_/Q _18807_/Q VDD VSS _10866_/D NOR2X1
X_13653_ _18973_/Q _13768_/A _13830_/B VDD VSS _13675_/D XNOR3X1
Xclkbuf_leaf_24__001_ clkbuf_2_3__f__001_/Y VDD VSS _18970_/CK BUFX12
X_16441_ _16442_/B _16441_/B _16441_/C VDD VSS _19535_/D AOI21X1
XFILLER_25_790 VSS VDD FILLER2
XFILLER_31_259 VSS VDD FILLER2
XTAP_TAPCELL_ROW_139_1401 VDD VSS WELLTAP
X_12604_ _18962_/Q _12619_/B _14213_/B VDD VSS _14182_/B XNOR3X1
X_13584_ _18944_/Q VDD VSS _13656_/D INVX1
X_19160_ _19187_/CK _19160_/D _19160_/Q VDD VSS DFFQX1
X_16372_ _19597_/Q _16747_/B VDD VSS _16398_/B NOR2X1
XFILLER_12_440 VDD VSS FILLER1
XFILLER_33_70 VDD VSS FILLER1
X_10796_ _18644_/Q _18806_/Q VDD VSS _10798_/C XNOR2X1
X_12535_ _12535_/A _12535_/B _14212_/B VDD VSS _12619_/B MIN3X1
X_18111_ _18173_/A _18111_/B VDD VSS _19996_/D NOR2X1
X_15323_ _19431_/Q _15815_/B VDD VSS _15347_/D XNOR2X1
XTAP_TAPCELL_ROW_4_52 VDD VSS WELLTAP
X_19091_ _19121_/CK _19091_/D _19091_/Q VDD VSS DFFQX1
XFILLER_138_670 VDD VSS FILLER1
X_12466_ _12553_/A _12553_/B _12553_/C VDD VSS _14407_/B OAI21X1
Xclkbuf_leaf_39__001_ clkbuf_leaf_5__001_/A VDD VSS _19187_/CK BUFX12
X_18042_ _18541_/Q _18042_/B _18542_/Q VDD VSS _18043_/C AOI21X1
X_15254_ _15293_/B _15254_/B VDD VSS _15688_/B XNOR2X1
X_11417_ _11422_/A _17990_/B _11417_/C VDD VSS _18611_/D NOR3X1
X_12397_ _12407_/A _14531_/B _12397_/C VDD VSS _12402_/B AOI21X1
X_14205_ _14231_/A _14205_/B VDD VSS _18954_/D AND2X1
X_15185_ _15198_/A _15198_/B _15198_/C _15185_/D VDD VSS _15243_/A OAOI211X1
X_11348_ _11383_/A _11348_/B VDD VSS _18588_/D NOR2X1
X_14136_ _18163_/A VDD VSS _14136_/Y BUFX3
XFILLER_125_375 VSS VDD FILLER2
XFILLER_140_323 VSS VDD FILLER2
XFILLER_99_738 VDD VSS FILLER1
X_19993_ _19999_/CK _19993_/D _19993_/Q VDD VSS DFFQX1
X_11279_ _11119_/Y _11364_/C _11289_/A VDD VSS _11286_/B MUXI2X1
X_14067_ _14068_/A _14068_/C _14068_/B VDD VSS _14203_/A OA21X2
X_18944_ _19001_/CK _18944_/D _18944_/Q VDD VSS DFFQX1
XFILLER_121_581 VDD VSS DECAPHV16
XFILLER_140_378 VDD VSS FILLER1
XFILLER_39_304 VDD VSS FILLER1
XFILLER_66_101 VSS VDD FILLER2
XFILLER_95_933 VSS VDD FILLER2
X_13018_ _19105_/Q _14383_/B VDD VSS _13102_/C _14383_/C AND3X2
X_18875_ _18908_/CK _18875_/D _18875_/Q VDD VSS DFFQX1
XFILLER_39_337 VDD VSS FILLER1
XFILLER_94_421 VDD VSS FILLER1
X_17826_ _17826_/A _17826_/B _17826_/C VDD VSS _19929_/D AOI21X1
XFILLER_81_104 VDD VSS FILLER4
XFILLER_47_381 VDD VSS FILLER1
XFILLER_48_893 VDD VSS FILLER4
X_17757_ _19914_/Q _19882_/Q VDD VSS _17758_/C NAND2X1
X_14969_ _19506_/Q _15018_/B VDD VSS _15056_/C NAND2X1
XTAP_TAPCELL_ROW_80_817 VDD VSS WELLTAP
X_17688_ _19899_/Q _19867_/Q _17688_/C VDD VSS _17692_/B AOI21X1
X_16708_ _19913_/Q _16726_/B VDD VSS _19561_/D AND2X1
X_19427_ _19547_/CK _19427_/D _19427_/Q VDD VSS DFFQX1
X_16639_ _19735_/Q _16900_/B VDD VSS _16643_/C XOR2X1
XFILLER_95_0 VSS VDD FILLER2
X_19358_ _19358_/CK _19358_/D _19358_/Q VDD VSS DFFQX1
XFILLER_13_29 VDD VSS FILLER4
X_18309_ _18310_/CK _18522_/Q _18309_/Q _20072_/RB VDD VSS DFFRQX1
XFILLER_31_782 VDD VSS FILLER4
X_19289_ _19290_/CK _19289_/D _19289_/Q VDD VSS DFFQX1
XFILLER_135_139 VDD VSS FILLER4
XFILLER_144_673 VSS VDD FILLER2
X_20202_ _20202_/A VDD VSS _20202_/Y BUFX3
XFILLER_132_857 VDD VSS DECAPHV16
XFILLER_143_161 VDD VSS FILLER1
XFILLER_144_684 VDD VSS FILLER1
XTAP_TAPCELL_ROW_112_1139 VDD VSS WELLTAP
Xmax_cap185 _18519_/Q VDD VSS _18498_/D BUFX8
XFILLER_131_367 VDD VSS FILLER4
X_09944_ _09944_/A VDD VSS _10166_/D BUFX3
X_20133_ _20133_/A VDD VSS _20133_/Y BUFX3
XFILLER_100_721 VDD VSS FILLER4
XFILLER_38_26 VDD VSS FILLER1
XFILLER_86_911 VDD VSS DECAPHV16
X_09875_ _09885_/A _10017_/B _10017_/C _09944_/A VDD VSS _09876_/C AOI211X1
X_20064_ clkload5/A _20064_/D _20064_/Q _20064_/RB VDD VSS DFFRQX1
XFILLER_100_732 VSS VDD FILLER2
XFILLER_140_890 VDD VSS FILLER1
XFILLER_58_668 VSS VDD FILLER2
XFILLER_57_167 VSS VDD FILLER2
XTAP_TAPCELL_ROW_96_972 VDD VSS WELLTAP
XFILLER_54_830 VDD VSS FILLER1
XFILLER_57_189 VSS VDD FILLER2
XTAP_TAPCELL_ROW_68_696 VDD VSS WELLTAP
XFILLER_26_598 VDD VSS FILLER1
XFILLER_53_362 VSS VDD FILLER2
XTAP_TAPCELL_ROW_123_1246 VDD VSS WELLTAP
XFILLER_110_53 VSS VDD FILLER2
XTAP_TAPCELL_ROW_51_530 VDD VSS WELLTAP
X_10650_ _10729_/C _10729_/D VDD VSS _10652_/B XNOR2X1
XFILLER_139_412 VDD VSS FILLER1
XFILLER_13_259 VDD VSS FILLER4
XTAP_TAPCELL_ROW_23_243 VDD VSS WELLTAP
X_09309_ _18454_/D _09308_/Y _09302_/Y VDD VSS _18523_/D MUXI2X1
XFILLER_10_944 VSS VDD FILLER2
XFILLER_22_793 VDD VSS DECAPHV32
X_10581_ _10581_/A VDD VSS _11116_/A BUFX3
XFILLER_127_629 VSS VDD FILLER2
X_12320_ _12396_/A _12396_/B _12396_/C VDD VSS _14532_/B OAI21X1
XFILLER_108_832 VDD VSS DECAPHV8
XFILLER_119_180 VDD VSS FILLER1
X_12251_ _12299_/A _12258_/B _12258_/C VDD VSS _12300_/C XNOR3X1
XTAP_TAPCELL_ROW_134_1353 VDD VSS WELLTAP
X_11202_ _11228_/C _11202_/B VDD VSS _11208_/C XNOR2X1
XFILLER_107_386 VDD VSS FILLER4
XFILLER_122_301 VSS VDD FILLER2
XFILLER_123_846 VDD VSS DECAPHV16
XFILLER_79_88 VDD VSS FILLER4
X_12182_ _12372_/A _12372_/C VDD VSS _12183_/C AND2X1
XFILLER_123_868 VDD VSS DECAPHV16
XFILLER_96_708 VDD VSS DECAPHV8
X_11133_ _11226_/A _11163_/C VDD VSS _11134_/D NOR2X1
X_16990_ _19753_/Q _17011_/B VDD VSS _16994_/B XOR2X1
XFILLER_1_675 VDD VSS FILLER1
XFILLER_77_922 VDD VSS FILLER1
X_11064_ _11064_/A _11064_/B wire170/Y VDD VSS _11065_/B OAI21X1
X_15941_ _19549_/Q _19901_/Q VDD VSS _15942_/B XNOR2X1
XFILLER_76_421 VSS VDD FILLER2
XFILLER_76_443 VSS VDD FILLER2
XFILLER_95_65 VDD VSS FILLER1
X_10015_ _10000_/Y _10014_/Y _11178_/C VDD VSS _10015_/Y MUX2X1
X_18660_ _18797_/CK _18660_/D _18660_/Q VDD VSS DFFQX1
XFILLER_92_925 VDD VSS FILLER1
X_17611_ _19883_/Q _19851_/Q VDD VSS _17618_/C NOR2X1
X_15872_ _14522_/Y _15872_/B _15872_/C VDD VSS _19480_/D AND3BX1
XFILLER_29_370 VSS VDD FILLER2
XFILLER_64_649 VDD VSS DECAPHV16
XFILLER_76_498 VDD VSS DECAPHV8
X_18591_ _18595_/CK _18591_/D _18591_/Q VDD VSS DFFQX1
X_14823_ _14826_/A _14872_/B _14872_/C VDD VSS _14824_/C AND3BX1
XFILLER_45_852 VDD VSS FILLER4
XFILLER_91_468 VDD VSS DECAPHV16
X_11966_ _11966_/A _11966_/B VDD VSS _11967_/C XOR2X1
X_17542_ _19868_/Q _19836_/Q _17542_/C VDD VSS _17546_/B AOI21X1
X_14754_ _15831_/B _15831_/C VDD VSS _14773_/C NOR2X1
XFILLER_44_373 VDD VSS FILLER1
XFILLER_60_822 VSS VDD FILLER2
X_10917_ _18568_/Q _10917_/B VDD VSS _10954_/C AND2X1
X_13705_ _19085_/Q VDD VSS _13779_/A INVX1
X_14685_ _14737_/A _14737_/B VDD VSS _14702_/C XOR2X1
X_17473_ _17475_/C _17473_/B _17473_/C VDD VSS _19853_/D AOI21X1
XFILLER_32_546 VDD VSS FILLER4
XFILLER_32_557 VDD VSS DECAPHV16
XFILLER_60_855 VSS VDD FILLER2
X_11897_ _19119_/Q VDD VSS _11899_/A INVX1
X_13636_ _19168_/Q VDD VSS _13639_/C INVX1
X_19212_ _19242_/CK _19212_/D _19212_/Q VDD VSS DFFQX1
X_16424_ _16450_/C _16424_/B VDD VSS _16750_/B XNOR2X1
X_10848_ _18566_/Q _10848_/B VDD VSS _10851_/D NOR2X1
X_10779_ _18564_/Q _10780_/B VDD VSS _10814_/A AND2X1
X_13567_ _19000_/Q _13567_/B _13683_/D VDD VSS _14226_/C XNOR3X1
X_19143_ _19172_/CK _19143_/D _19143_/Q VDD VSS DFFQX1
X_16355_ _16355_/A _16358_/B VDD VSS _16356_/B XOR2X1
XFILLER_12_292 VDD VSS FILLER4
X_12518_ _19045_/Q _12803_/A _12803_/B VDD VSS _12540_/D XNOR3X1
X_13498_ _13656_/A _13498_/B VDD VSS _14161_/B XNOR2X1
X_19074_ _19126_/CK _19074_/D _19074_/Q VDD VSS DFFQX1
X_16286_ _19913_/Q _19561_/Q _16286_/C VDD VSS _16313_/C AOI2B1X1
X_15306_ _19458_/Q _15306_/B _15306_/C VDD VSS _15351_/A MIN3X1
XFILLER_67_4 VDD VSS FILLER4
X_12449_ _19069_/Q _12449_/B _12449_/C VDD VSS _12452_/A MIN3X1
X_18025_ _18026_/B _18045_/B _18025_/C _18049_/D VDD VSS _19970_/D OAI31X1
X_15237_ _19539_/Q _15237_/B VDD VSS _15906_/B XOR2X1
X_15168_ _19315_/Q _15686_/B VDD VSS _15169_/B XOR2X1
XFILLER_140_142 VDD VSS FILLER1
XFILLER_141_665 VSS VDD FILLER2
XFILLER_5_74 VDD VSS DECAPHV8
XFILLER_5_96 VSS VDD FILLER2
X_14119_ _14522_/A VDD VSS _14142_/A BUFX3
X_19976_ _19984_/CK _19976_/D _19976_/Q VDD VSS DFFQX1
Xfanout209 _09362_/AB VDD VSS _18455_/RB BUFX3
X_15099_ _15108_/A _15145_/B _15099_/C VDD VSS _15100_/B OR3BX1
XFILLER_113_389 VDD VSS DECAPHV8
XFILLER_140_175 VSS VDD FILLER2
XFILLER_39_101 VDD VSS FILLER1
XFILLER_67_410 VDD VSS DECAPHV8
XFILLER_86_207 VSS VDD FILLER2
X_18927_ _18935_/CK _18927_/D _18927_/Q VDD VSS DFFQX1
X_09660_ _18461_/Q _09784_/B VDD VSS _09664_/A NAND2X1
XFILLER_10_0 VDD VSS FILLER4
XFILLER_55_605 VSS VDD FILLER2
XFILLER_95_774 VSS VDD FILLER2
X_18858_ _18888_/CK _18858_/D _18858_/Q VDD VSS DFFQX1
XFILLER_39_189 VDD VSS FILLER4
XFILLER_55_627 VDD VSS FILLER4
XFILLER_55_649 VSS VDD FILLER2
XFILLER_95_796 VDD VSS DECAPHV16
X_09591_ _18425_/Q _09696_/B VDD VSS _09592_/E NOR2X1
X_18789_ _19937_/CK _18789_/D _18789_/Q VDD VSS DFFQX1
X_17809_ _17810_/B _17809_/B VDD VSS _17811_/B NOR2BX1
XTAP_TAPCELL_ROW_65_666 VDD VSS WELLTAP
XTAP_TAPCELL_ROW_93_942 VDD VSS WELLTAP
XFILLER_24_28 VDD VSS DECAPHV8
XFILLER_11_708 VDD VSS FILLER1
XFILLER_10_229 VSS VDD FILLER2
XTAP_TAPCELL_ROW_20_213 VDD VSS WELLTAP
XFILLER_137_927 VSS VDD FILLER2
XFILLER_137_949 VDD VSS FILLER1
XFILLER_40_49 VDD VSS FILLER4
XFILLER_116_150 VDD VSS DECAPHV8
XFILLER_116_172 VSS VDD FILLER2
XFILLER_132_632 VDD VSS DECAPHV16
Xclkbuf_2_0__f__09182_ clkbuf_0__09182_/Y VDD VSS _18582_/CK BUFX12
XFILLER_116_183 VSS VDD FILLER2
XFILLER_144_492 VSS VDD FILLER2
Xhold263 input4/Y VDD VSS hold263/Y BUFX3
X_09927_ _09941_/C _09927_/B VDD VSS _09928_/B NOR2X1
X_20116_ _20116_/A VDD VSS _20116_/Y BUFX3
Xclkbuf_leaf_23__002_ clkload17/A VDD VSS _19986_/CK BUFX12
XFILLER_105_31 VDD VSS DECAPHV16
XFILLER_58_421 VDD VSS FILLER1
XFILLER_86_741 VDD VSS DECAPHV8
X_18205__251 _18259_/CK VDD VSS _20047_/CK INVX1
XFILLER_19_808 VDD VSS FILLER4
XFILLER_19_819 VDD VSS FILLER4
XFILLER_86_763 VDD VSS DECAPHV8
X_09858_ _18571_/Q _09858_/B VDD VSS _09901_/B XOR2X1
X_20047_ _20047_/CK _20047_/D _20047_/Q _09284_/Y VDD VSS DFFRQX1
XFILLER_18_318 VDD VSS FILLER4
XFILLER_58_487 VDD VSS DECAPHV16
XFILLER_73_435 VSS VDD FILLER2
X_09789_ _09788_/Y _09791_/A _18273_/Q _09818_/C VDD VSS _09791_/C AOI2B2X1
XFILLER_61_608 VDD VSS FILLER4
XFILLER_65_68 VDD VSS DECAPHV8
XFILLER_73_457 VDD VSS DECAPHV8
XFILLER_73_468 VDD VSS FILLER4
X_11820_ _11854_/B _11820_/B VDD VSS _11821_/C XNOR2X1
XFILLER_14_502 VDD VSS FILLER4
X_11751_ _11751_/A _14520_/B VDD VSS _11776_/A OR2X2
XFILLER_14_546 VDD VSS FILLER1
XFILLER_41_321 VDD VSS FILLER1
XFILLER_81_45 VDD VSS FILLER4
X_10702_ _10960_/A _10987_/B _10702_/C VDD VSS _10709_/C OAI21X1
XFILLER_14_568 VDD VSS DECAPHV8
XFILLER_41_343 VDD VSS FILLER4
XFILLER_41_354 VSS VDD FILLER2
XFILLER_81_78 VDD VSS FILLER1
X_11682_ _18901_/Q VDD VSS _12197_/A INVX1
X_14470_ _15383_/A VDD VSS _14766_/A BUFX3
XFILLER_128_905 VDD VSS FILLER1
XFILLER_81_89 VDD VSS FILLER4
X_10633_ _10633_/A _10633_/B _10633_/C _10633_/D VDD VSS _10634_/B AO31X2
X_13421_ _13533_/A _14293_/B VDD VSS _13599_/B NOR2X1
X_10564_ _10649_/B _10763_/A _10564_/C VDD VSS _10578_/B OR3BX1
X_13352_ _19166_/Q _13542_/B _13542_/C VDD VSS _13617_/B XNOR3X1
X_16140_ _16157_/A _16157_/B VDD VSS _16773_/B XNOR2X1
XFILLER_128_949 VDD VSS FILLER1
X_12303_ _19182_/Q _12303_/B _12303_/C VDD VSS _12382_/C XNOR3X1
X_16071_ _19681_/Q _16841_/B VDD VSS _16080_/C NOR2X1
XFILLER_108_662 VDD VSS FILLER4
XFILLER_127_459 VDD VSS FILLER4
XFILLER_6_778 VDD VSS FILLER4
X_10495_ _10525_/A _10525_/B _10525_/C _10495_/D VDD VSS _10496_/D AOAI211X1
X_13283_ _13283_/A _17901_/B VDD VSS _18857_/D AND2X1
X_15022_ _19452_/Q _15022_/B _15054_/C VDD VSS _15092_/B XNOR3X1
XFILLER_5_277 VSS VDD FILLER2
X_12234_ _12234_/A _12234_/B _12234_/C _12234_/D VDD VSS _14499_/B AOAI211X1
XFILLER_123_654 VDD VSS DECAPHV8
X_12165_ _20000_/Q _19264_/Q VDD VSS _12236_/B NAND2X1
X_19830_ _19830_/CK _19830_/D _19830_/Q VDD VSS DFFQX1
XFILLER_122_142 VDD VSS FILLER4
XFILLER_122_153 VDD VSS DECAPHV8
XFILLER_68_218 VDD VSS FILLER1
X_11116_ _11116_/A _11116_/B _11116_/C VDD VSS _11116_/Y OAI21X1
X_19761_ _19795_/CK _19761_/D _19761_/Q VDD VSS DFFQX1
XFILLER_77_741 VSS VDD FILLER2
X_12096_ _12113_/A _12113_/B _12113_/D _12113_/C VDD VSS _14465_/B OAOI211X2
X_18712_ _18768_/CK _18712_/D _18712_/Q VDD VSS DFFQX1
X_16973_ _16973_/A _16973_/B _16973_/C _16973_/D VDD VSS _16977_/B OA211X2
XFILLER_37_605 VSS VDD FILLER2
XFILLER_92_700 VDD VSS DECAPHV16
X_11047_ _11229_/A _11047_/B _11047_/C _11047_/D VDD VSS _11047_/Y OA211X2
X_19692_ _19724_/CK _19692_/D _19692_/Q VDD VSS DFFQX1
X_15924_ _19547_/Q _16692_/A _15924_/C VDD VSS _15939_/A OAI21X1
X_18643_ _19949_/CK _18643_/D _18643_/Q VDD VSS DFFQX1
X_15855_ _18196_/A _15855_/B VDD VSS _19466_/D NOR2X1
XFILLER_36_137 VSS VDD FILLER2
XFILLER_64_446 VDD VSS FILLER4
XFILLER_80_906 VDD VSS FILLER1
XFILLER_92_755 VSS VDD FILLER2
X_18574_ _18582_/CK _18574_/D _18574_/Q VDD VSS DFFQX1
X_14806_ _14809_/C _14809_/B VDD VSS _14807_/B NOR2BX1
XFILLER_45_671 VDD VSS FILLER4
XFILLER_45_682 VDD VSS DECAPHV16
XFILLER_55_90 VSS VDD FILLER2
XFILLER_91_276 VSS VDD FILLER2
XTAP_TAPCELL_ROW_90_912 VDD VSS WELLTAP
X_12998_ _19022_/Q VDD VSS _13007_/A INVX1
X_17525_ _17675_/A _17525_/B VDD VSS _19864_/D NOR2X1
X_15786_ _15800_/A _15786_/B VDD VSS _19405_/D NOR2X1
XFILLER_32_321 VDD VSS FILLER4
XFILLER_60_641 VSS VDD FILLER2
XTAP_TAPCELL_ROW_62_636 VDD VSS WELLTAP
X_11949_ _18981_/Q _14237_/B VDD VSS _12010_/B NOR2X1
X_14737_ _14737_/A _14737_/B _14737_/C _14775_/B VDD VSS _14837_/B OAOI211X1
X_14668_ _19415_/Q VDD VSS _14669_/A INVX1
X_17456_ _17838_/A VDD VSS _17509_/C BUFX3
XFILLER_20_527 VDD VSS FILLER1
XFILLER_20_549 VSS VDD FILLER2
XFILLER_32_376 VSS VDD FILLER2
XFILLER_60_685 VDD VSS FILLER4
X_13619_ _19139_/Q _14420_/B VDD VSS _13620_/D _14420_/C NAND3X1
X_17387_ _19835_/Q _19803_/Q _17387_/C VDD VSS _17392_/B AOI21X1
X_16407_ _16433_/B _16407_/B VDD VSS _16855_/B OR2X2
XFILLER_9_561 VDD VSS FILLER1
X_14599_ _19522_/Q _15887_/B VDD VSS _15888_/B XNOR2X1
X_19126_ _19126_/CK _19126_/D _19126_/Q VDD VSS DFFQX1
X_16338_ _19564_/Q _19916_/Q VDD VSS _16368_/A XNOR2X1
XFILLER_119_949 VDD VSS FILLER1
X_19057_ _19085_/CK _19057_/D _19057_/Q VDD VSS DFFQX1
X_16269_ _19689_/Q _16850_/B VDD VSS _16270_/B XNOR2X1
XFILLER_133_429 VSS VDD FILLER2
XFILLER_58_0 VSS VDD FILLER2
X_18008_ _18528_/Q _18527_/Q VDD VSS _18013_/B XNOR2X1
XFILLER_114_643 VDD VSS FILLER1
XFILLER_99_387 VDD VSS FILLER4
XFILLER_59_229 VSS VDD FILLER2
XFILLER_68_741 VDD VSS DECAPHV16
X_09712_ _09791_/A _09712_/B VDD VSS _09717_/C NAND2X1
X_19959_ _19963_/CK _19959_/D _19959_/Q VDD VSS DFFQX1
XFILLER_67_240 VDD VSS DECAPHV8
XFILLER_27_104 VDD VSS FILLER1
XFILLER_28_638 VDD VSS DECAPHV8
XFILLER_83_733 VDD VSS FILLER1
X_09643_ _20167_/A _09811_/B _09815_/C _18316_/Q VDD VSS _09644_/E AOI22X1
XFILLER_55_457 VDD VSS FILLER4
XFILLER_83_777 VDD VSS DECAPHV8
XTAP_TAPCELL_ROW_78_791 VDD VSS WELLTAP
X_09574_ _20163_/A _09811_/B _09770_/C _18312_/Q _09574_/E VDD VSS _09575_/C AOI221X1
XFILLER_35_38 VDD VSS FILLER1
XFILLER_42_107 VDD VSS FILLER1
XFILLER_42_118 VSS VDD FILLER2
XFILLER_55_479 VDD VSS FILLER4
XTAP_TAPCELL_ROW_120_1216 VDD VSS WELLTAP
XFILLER_51_663 VSS VDD FILLER2
XFILLER_50_162 VSS VDD FILLER2
XFILLER_50_184 VDD VSS FILLER1
XFILLER_137_702 VDD VSS FILLER1
XFILLER_109_459 VDD VSS FILLER1
XFILLER_3_726 VSS VDD FILLER2
X_10280_ _18685_/Q _18739_/Q VDD VSS _10329_/B XOR2X1
XTAP_TAPCELL_ROW_131_1323 VDD VSS WELLTAP
XFILLER_104_142 VSS VDD FILLER2
XFILLER_105_676 VDD VSS FILLER4
XFILLER_104_186 VDD VSS FILLER4
XFILLER_116_52 VDD VSS FILLER4
XFILLER_132_484 VDD VSS FILLER1
XFILLER_74_700 VDD VSS DECAPHV8
XFILLER_76_45 VDD VSS FILLER1
X_13970_ _18978_/Q _13970_/B _14004_/C VDD VSS _14045_/B XNOR3X1
XFILLER_86_571 VDD VSS FILLER4
X_12921_ _13021_/A _13021_/B VDD VSS _13091_/B NOR2X1
Xclkbuf_leaf_12_clk_regs clkbuf_leaf_9_clk_regs/A VDD VSS _19795_/CK BUFX12
X_15640_ _19412_/Q _15793_/B VDD VSS _15641_/C NAND2X1
XFILLER_61_416 VDD VSS FILLER1
XFILLER_92_22 VDD VSS FILLER4
XFILLER_92_33 VDD VSS DECAPHV8
X_12852_ _12955_/A _12955_/B _12955_/C _12955_/D VDD VSS _13054_/B AO31X2
XFILLER_14_321 VDD VSS FILLER4
XFILLER_27_693 VDD VSS FILLER4
XFILLER_61_438 VDD VSS FILLER1
X_11803_ _19993_/Q _19257_/Q VDD VSS _11804_/D AND2X1
X_12783_ _18964_/Q _12796_/B _14215_/B VDD VSS _14184_/B XNOR3X1
X_15571_ _19437_/Q _15822_/B VDD VSS _15599_/A NAND2X1
XFILLER_15_888 VSS VDD FILLER2
XFILLER_42_663 VDD VSS FILLER4
X_11734_ _19198_/Q VDD VSS _11739_/A INVX1
X_14522_ _14522_/A VDD VSS _14522_/Y BUFX3
X_18290_ _18291_/CK _18290_/D _18290_/Q VDD VSS DFFQX1
X_17310_ _19819_/Q _19787_/Q VDD VSS _17318_/C NOR2X1
XFILLER_41_151 VDD VSS FILLER1
XFILLER_41_184 VSS VDD FILLER2
X_11665_ _18804_/Q _11669_/B VDD VSS _18831_/D AND2X1
X_14453_ _14453_/A _14453_/B _17827_/B VDD VSS _19168_/D AOI21X1
X_17241_ _17390_/A _17241_/B VDD VSS _19804_/D NOR2X1
X_10616_ _10638_/A _10638_/B _10617_/C _10803_/A VDD VSS _10616_/Y AOAI211X1
X_13404_ _18971_/Q VDD VSS _13585_/A INVX1
XFILLER_128_735 VSS VDD FILLER2
X_11596_ _18741_/Q _11600_/B VDD VSS _18768_/D AND2X1
X_14384_ _14393_/A _14384_/B VDD VSS _19106_/D NOR2X1
X_17172_ _17172_/A VDD VSS _17229_/C BUFX3
X_10547_ _10547_/A VDD VSS _11263_/A BUFX3
X_13335_ _13457_/A _13466_/B VDD VSS _14480_/B XNOR2X1
X_16123_ _19715_/Q _16879_/B VDD VSS _16124_/B XNOR2X1
XFILLER_115_429 VSS VDD FILLER2
X_10478_ _18636_/Q _18798_/Q VDD VSS _10514_/C NOR2X1
X_13266_ _19137_/Q _13266_/B _13354_/C VDD VSS _13322_/C XNOR3X1
X_16054_ _16051_/A _16054_/B _16054_/C VDD VSS _16076_/A AOI2B1X1
XFILLER_108_481 VDD VSS FILLER1
X_12217_ _19154_/Q VDD VSS _12307_/A INVX1
X_15005_ _19479_/Q _15871_/B VDD VSS _15054_/A NOR2BX1
XFILLER_96_302 VSS VDD FILLER2
XFILLER_97_836 VDD VSS FILLER1
X_13197_ _13097_/B _14256_/C _18994_/Q VDD VSS _13198_/D AND3BX1
X_19813_ _19863_/CK _19813_/D _19813_/Q VDD VSS DFFQX1
XFILLER_69_538 VDD VSS FILLER4
X_12148_ _19124_/Q _14403_/B _14403_/C VDD VSS _12149_/D NOR3BX1
XFILLER_38_903 VDD VSS DECAPHV8
XFILLER_96_379 VDD VSS FILLER1
X_12079_ _12083_/A _12083_/B _12079_/C VDD VSS _14338_/B XNOR3X1
X_19744_ clkload3/A _19744_/D _19744_/Q VDD VSS DFFQX1
X_16956_ _16954_/A _16956_/B VDD VSS _16962_/A NOR2BX1
XFILLER_37_402 VSS VDD FILLER2
XFILLER_38_947 VSS VDD FILLER2
XTAP_TAPCELL_ROW_39_408 VDD VSS WELLTAP
X_19675_ _19711_/CK _19675_/D _19675_/Q VDD VSS DFFQX1
X_15907_ _16776_/A VDD VSS _16100_/A BUFX3
XFILLER_64_243 VSS VDD FILLER2
XFILLER_65_755 VSS VDD FILLER2
X_18626_ _18626_/CK _18626_/D _18626_/Q VDD VSS DFFQX1
X_16887_ _16891_/A _16887_/B VDD VSS _19723_/D NOR2X1
XFILLER_37_468 VDD VSS DECAPHV8
XFILLER_52_416 VSS VDD FILLER2
XFILLER_64_265 VSS VDD FILLER2
XTAP_TAPCELL_ROW_75_761 VDD VSS WELLTAP
X_15838_ _15849_/A _15838_/B VDD VSS _19453_/D AND2X1
XFILLER_64_287 VDD VSS FILLER1
XTAP_TAPCELL_ROW_106_1071 VDD VSS WELLTAP
XTAP_TAPCELL_ROW_47_485 VDD VSS WELLTAP
X_18557_ _18565_/CK _18557_/D _18557_/Q VDD VSS DFFQX1
X_15769_ _15780_/A _15769_/B VDD VSS _19391_/D NOR2X1
X_09290_ _20057_/Q _20061_/D VDD VSS _09516_/B NAND2X1
X_18488_ _18494_/CK _18525_/Q _20101_/A _18492_/RB VDD VSS DFFRQX1
X_17508_ _19861_/Q _19829_/Q VDD VSS _17510_/B XOR2X1
XANTENNA_14 _17906_/C VDD VSS ANTENNA2
XFILLER_20_324 VDD VSS FILLER1
XFILLER_21_836 VDD VSS FILLER1
X_17439_ _17439_/A _17439_/B _17439_/C _17439_/D VDD VSS _17440_/C AOAI211X1
XANTENNA_25 _20101_/Y VDD VSS ANTENNA2
XANTENNA_36 _18127_/B VDD VSS ANTENNA2
X_19109_ _19137_/CK _19109_/D _19109_/Q VDD VSS DFFQX1
Xoutput110 _20194_/Y VDD VSS o_tst_ctrl[13] BUFX3
Xoutput143 _20226_/Y VDD VSS o_uwb_tx_cfg[29] BUFX3
Xoutput132 _20216_/Y VDD VSS o_uwb_tx_cfg[19] BUFX3
Xoutput121 _20190_/Y VDD VSS o_tst_ctrl[9] BUFX3
XFILLER_114_440 VDD VSS DECAPHV16
XFILLER_130_944 VDD VSS FILLER4
XFILLER_141_270 VSS VDD FILLER2
XFILLER_142_793 VDD VSS DECAPHV8
XFILLER_102_679 VDD VSS FILLER1
XFILLER_29_914 VDD VSS FILLER4
XFILLER_101_189 VDD VSS DECAPHV8
XFILLER_56_700 VDD VSS DECAPHV16
XFILLER_56_722 VDD VSS FILLER4
XFILLER_46_37 VDD VSS DECAPHV8
XFILLER_28_468 VSS VDD FILLER2
X_09626_ _20120_/A _09791_/A _09626_/C VDD VSS _09627_/C AOI2B1X1
XFILLER_70_235 VDD VSS FILLER1
XFILLER_71_747 VDD VSS FILLER4
X_09557_ _18505_/Q _09630_/C _18506_/Q VDD VSS _09813_/B NOR3BX1
X_09488_ _19982_/Q _09490_/B _09507_/B VDD VSS _09489_/C AOI21X1
XFILLER_102_98 VSS VDD FILLER2
XFILLER_51_482 VDD VSS FILLER1
X_11450_ _16860_/A VDD VSS _11460_/B BUFX3
XFILLER_137_543 VDD VSS FILLER1
X_10401_ _18633_/Q _18795_/Q VDD VSS _10402_/D AND2X1
X_11381_ _11381_/A _11381_/B _11381_/C VDD VSS _11384_/C OA21X2
X_10332_ _18631_/Q _18793_/Q VDD VSS _10372_/B XOR2X1
X_13120_ _19136_/Q VDD VSS _13230_/A INVX1
XFILLER_124_248 VSS VDD FILLER2
XFILLER_3_545 VSS VDD FILLER2
X_13051_ _13133_/A _13133_/C _13133_/B _13129_/D VDD VSS _13240_/A AOI31X1
Xclkbuf_leaf_6__000_ clkload79/A VDD VSS _19643_/CK BUFX12
XFILLER_127_84 VDD VSS FILLER4
XFILLER_133_760 VDD VSS FILLER4
XFILLER_78_302 VDD VSS FILLER1
X_10263_ _10263_/A _10263_/B _10263_/C _10383_/A _10263_/E VDD VSS _10264_/B AOI221X1
X_12002_ _12026_/B _12026_/C VDD VSS _14401_/B NAND2X1
XFILLER_120_421 VDD VSS FILLER1
XFILLER_79_836 VDD VSS FILLER1
XFILLER_87_77 VDD VSS DECAPHV16
X_10194_ _10200_/D _10200_/B VDD VSS _10195_/B NOR2BX1
XFILLER_66_519 VDD VSS FILLER4
XFILLER_87_99 VDD VSS DECAPHV16
X_17790_ _17793_/A _17790_/B _17790_/C VDD VSS _19921_/D AOI21X1
X_16810_ _16811_/A _16810_/B VDD VSS _19653_/D NOR2X1
XFILLER_143_50 VDD VSS FILLER1
XFILLER_47_711 VDD VSS FILLER1
XFILLER_87_880 VDD VSS FILLER4
X_16741_ _16748_/A _16741_/B VDD VSS _19591_/D NOR2X1
XFILLER_47_733 VDD VSS DECAPHV8
X_13953_ _19005_/Q wire154/Y _13958_/B VDD VSS _13955_/C XOR3X1
XFILLER_46_243 VDD VSS FILLER4
X_12904_ _13005_/A _13005_/B VDD VSS _14287_/B _13005_/C AND3X2
X_13884_ _13990_/A _14166_/B _13884_/C VDD VSS _14167_/C OAI21X1
X_19460_ _19461_/CK _19460_/D _19460_/Q VDD VSS DFFQX1
X_16672_ _19672_/Q _16672_/B _16831_/B VDD VSS _16685_/A MIN3X1
XFILLER_15_630 VSS VDD FILLER2
XFILLER_34_449 VDD VSS DECAPHV8
XFILLER_61_213 VDD VSS FILLER4
XTAP_TAPCELL_ROW_72_731 VDD VSS WELLTAP
X_12835_ _12835_/A _14506_/B _12835_/C _12835_/D VDD VSS _12841_/B OAI211X1
X_19391_ _19435_/CK _19391_/D _19391_/Q VDD VSS DFFQX1
X_18411_ _18420_/CK _18512_/Q _20166_/A _09380_/B VDD VSS DFFRQX1
X_15623_ _19412_/Q _15793_/B VDD VSS _15641_/A XNOR2X1
XFILLER_36_92 VDD VSS FILLER1
XFILLER_50_909 VDD VSS FILLER4
XFILLER_61_246 VDD VSS DECAPHV8
XTAP_TAPCELL_ROW_44_455 VDD VSS WELLTAP
X_18342_ _18342_/CK _18342_/D _18342_/Q _18373_/RB VDD VSS DFFRQX1
X_15554_ _19409_/Q _15790_/B VDD VSS _15569_/B XNOR2X1
XTAP_TAPCELL_ROW_16_179 VDD VSS WELLTAP
XTAP_TAPCELL_ROW_7_85 VDD VSS WELLTAP
X_12766_ _12967_/C _12966_/B _12966_/C VDD VSS _12951_/B XNOR3X1
X_14505_ _14539_/A _14505_/B VDD VSS _19213_/D NOR2X1
XTAP_TAPCELL_ROW_99_1004 VDD VSS WELLTAP
X_11717_ _19990_/Q _19254_/Q VDD VSS _11742_/C XNOR2X1
X_12697_ _18907_/Q _12789_/B _12789_/C VDD VSS _12703_/C XNOR3X1
X_18273_ _18275_/CK _18273_/D _18273_/Q _20080_/RB VDD VSS DFFRQX1
X_15485_ _15509_/B _15485_/B VDD VSS _15788_/B XNOR2X1
XTAP_TAPCELL_ROW_0_7 VDD VSS WELLTAP
X_11648_ _11648_/A VDD VSS _11658_/B BUFX3
X_14436_ _14449_/A _14436_/B _14436_/C VDD VSS _19153_/D NOR3X1
X_17224_ _17227_/A _17227_/B _17229_/C VDD VSS _17225_/C OAI21X1
XFILLER_11_891 VDD VSS DECAPHV16
XFILLER_7_840 VSS VDD FILLER2
X_11579_ _11648_/A VDD VSS _11589_/B BUFX3
X_14367_ _14368_/A _14367_/B VDD VSS _19091_/D NOR2X1
X_17155_ _19786_/Q _19754_/Q VDD VSS _17160_/A XNOR2X1
X_13318_ _19136_/Q _13430_/B VDD VSS _13319_/D _13318_/C NAND3X1
X_16106_ _16106_/A _16106_/B _16106_/C VDD VSS _16120_/A AOI21X1
XFILLER_143_557 VDD VSS FILLER1
X_14298_ _14352_/A _14298_/B _14298_/C VDD VSS _19030_/D NOR3X1
X_17086_ _17536_/A _17086_/B _17087_/C VDD VSS _19771_/D NOR3X1
XFILLER_124_771 VDD VSS FILLER1
X_13249_ _13254_/A _14478_/B _13329_/D _13254_/C VDD VSS _14479_/B OAI211X1
X_16037_ _19903_/Q VDD VSS _16696_/A INVX1
XFILLER_111_421 VDD VSS FILLER1
XFILLER_112_933 VSS VDD FILLER2
XFILLER_124_793 VDD VSS DECAPHV8
XFILLER_111_454 VDD VSS FILLER4
XFILLER_97_666 VSS VDD FILLER2
X_19727_ _19730_/CK _19727_/D _19727_/Q VDD VSS DFFQX1
X_17988_ _17982_/B _18872_/Q VDD VSS _17989_/C NAND2BX1
XFILLER_38_755 VDD VSS FILLER4
XTAP_TAPCELL_ROW_108_1100 VDD VSS WELLTAP
X_16939_ _16943_/C _16939_/B VDD VSS _16940_/B XNOR2X1
XFILLER_93_883 VDD VSS DECAPHV8
X_19658_ _19724_/CK _19658_/D _19658_/Q VDD VSS DFFQX1
XFILLER_37_298 VDD VSS DECAPHV8
XFILLER_53_747 VSS VDD FILLER2
XFILLER_65_596 VSS VDD FILLER2
XFILLER_80_522 VDD VSS FILLER4
X_09411_ _09496_/B _09496_/C VDD VSS _09507_/C NOR2X1
X_19589_ _19673_/CK _19589_/D _19589_/Q VDD VSS DFFQX1
X_18609_ _18622_/CK _18609_/D _18609_/Q VDD VSS DFFQX1
XFILLER_52_268 VSS VDD FILLER2
XFILLER_53_769 VSS VDD FILLER2
X_09342_ _18443_/D _09341_/Y _09302_/A VDD VSS _18512_/D MUXI2X1
XFILLER_33_460 VDD VSS FILLER4
X_09273_ _09273_/A _09273_/B _09273_/C VDD VSS _18277_/D OAI21X1
XFILLER_21_677 VDD VSS FILLER1
XFILLER_107_705 VSS VDD FILLER2
XFILLER_106_215 VDD VSS FILLER1
XFILLER_103_900 VSS VDD FILLER2
XFILLER_122_719 VDD VSS DECAPHV8
XFILLER_102_421 VSS VDD FILLER2
XFILLER_103_933 VSS VDD FILLER2
XFILLER_103_944 VDD VSS FILLER4
XFILLER_0_559 VSS VDD FILLER2
XFILLER_102_443 VDD VSS FILLER1
XFILLER_102_454 VDD VSS FILLER1
XFILLER_130_763 VDD VSS FILLER4
XFILLER_130_785 VDD VSS FILLER4
XFILLER_75_305 VDD VSS FILLER4
XTAP_TAPCELL_ROW_86_878 VDD VSS WELLTAP
X_10950_ _10661_/B _11213_/B _11120_/A VDD VSS _10958_/B MUXI2X1
XFILLER_44_736 VDD VSS FILLER1
XTAP_TAPCELL_ROW_126_1277 VDD VSS WELLTAP
X_09609_ _18346_/Q _09772_/B _09609_/C _09609_/D VDD VSS _09612_/C OAI211X1
X_10881_ _10960_/A _10881_/B _10881_/C VDD VSS _10921_/B OAI21X1
XFILLER_43_246 VSS VDD FILLER2
X_12620_ _12632_/A _12632_/B _12632_/C VDD VSS _14284_/B OAI21X1
XFILLER_24_482 VDD VSS FILLER1
XTAP_TAPCELL_ROW_41_425 VDD VSS WELLTAP
X_12551_ _19129_/Q VDD VSS _12593_/D INVX1
XFILLER_129_318 VDD VSS FILLER1
XTAP_TAPCELL_ROW_13_149 VDD VSS WELLTAP
X_11502_ _18656_/Q _11508_/B VDD VSS _18683_/D AND2X1
X_12482_ _19184_/Q _14471_/B VDD VSS _14440_/A AND2X1
X_15270_ _19538_/Q _19539_/Q VDD VSS _15313_/B _15270_/C NAND3X1
XFILLER_22_61 VDD VSS FILLER1
X_11433_ _11435_/A _11433_/B VDD VSS _11434_/B XOR2X1
X_14221_ _14221_/A _14221_/B _14221_/C VDD VSS _14222_/C NOR3X1
XFILLER_125_502 VSS VDD FILLER2
XFILLER_137_362 VSS VDD FILLER2
X_14152_ _14154_/A _14152_/B VDD VSS _18908_/D NOR2X1
XFILLER_138_94 VDD VSS FILLER1
XTAP_TAPCELL_ROW_137_1384 VDD VSS WELLTAP
X_11364_ _11364_/A _11364_/B _11364_/C _11364_/D VDD VSS _11365_/B AO31X2
X_10315_ _10315_/A _10315_/B VDD VSS _10512_/A _10315_/C _10315_/D OR4X1
X_11295_ _11296_/B _11295_/B _11295_/C _11378_/A VDD VSS _18583_/D AOI211X1
X_13103_ _19107_/Q VDD VSS _13211_/A INVX1
X_14083_ _18926_/Q _14174_/A _14174_/B VDD VSS _14104_/A NOR3X1
X_18960_ _18993_/CK _18960_/D _18960_/Q VDD VSS DFFQX1
XFILLER_106_793 VDD VSS DECAPHV8
XFILLER_3_375 VSS VDD FILLER2
XFILLER_4_898 VSS VDD FILLER2
X_10246_ _18623_/Q _18624_/Q VDD VSS _10266_/D NOR2X1
X_13034_ _14510_/B _14510_/C _19217_/Q VDD VSS _13036_/C AOI21X1
X_18891_ _18917_/CK _18891_/D _18891_/Q VDD VSS DFFQX1
X_17911_ _18859_/Q _17911_/B _17911_/C VDD VSS _17914_/C MIN3X1
XFILLER_94_603 VDD VSS FILLER1
X_17842_ _19935_/Q _19936_/Q _17842_/C _17842_/D VDD VSS _19936_/D AOI31X1
XFILLER_120_251 VDD VSS FILLER1
XFILLER_120_262 VDD VSS DECAPHV8
XFILLER_66_316 VSS VDD FILLER2
XTAP_TAPCELL_ROW_49_503 VDD VSS WELLTAP
X_10177_ _18615_/Q _10177_/B VDD VSS _10184_/B NAND2X1
X_17773_ _19917_/Q _19885_/Q _17773_/C VDD VSS _17776_/C MIN3X1
X_14985_ _14991_/B _14985_/B VDD VSS _15682_/B XNOR2X1
XFILLER_19_243 VDD VSS DECAPHV16
XFILLER_35_703 VSS VDD FILLER2
XFILLER_62_500 VDD VSS FILLER1
XFILLER_93_157 VSS VDD FILLER2
X_13936_ _18949_/Q _13936_/B _13957_/C VDD VSS _13949_/A XNOR3X1
X_19512_ _19707_/CK _19512_/D _19512_/Q VDD VSS DFFQX1
X_16724_ _16724_/A _16724_/B VDD VSS _19575_/D NOR2X1
XFILLER_35_747 VDD VSS FILLER4
XFILLER_62_522 VDD VSS FILLER4
XFILLER_74_371 VDD VSS FILLER4
X_19443_ _19492_/CK _19443_/D _19443_/Q VDD VSS DFFQX1
X_16655_ _19608_/Q _16759_/B VDD VSS _16657_/C XNOR2X1
X_13867_ _18892_/Q _13981_/A _13981_/B VDD VSS _13868_/D XNOR3X1
X_15606_ _19383_/Q _15761_/B VDD VSS _15620_/C XOR2X1
XFILLER_43_780 VDD VSS DECAPHV16
XFILLER_90_886 VDD VSS FILLER4
XTAP_TAPCELL_ROW_103_1041 VDD VSS WELLTAP
X_12818_ _12819_/A _12819_/B _12819_/D _12819_/C VDD VSS _12939_/B OAOI211X1
X_13798_ _19003_/Q _13833_/B _13889_/D VDD VSS _13845_/C XNOR3X1
X_19374_ _19393_/CK _19374_/D _19374_/Q VDD VSS DFFQX1
X_16586_ _16620_/B _16586_/B VDD VSS _16898_/B NAND2X1
XFILLER_63_90 VSS VDD FILLER2
XFILLER_97_4 VDD VSS FILLER4
X_12749_ _19160_/Q VDD VSS _12936_/A INVX1
X_18325_ _18327_/CK _18469_/D _18325_/Q _18453_/RB VDD VSS DFFRQX1
X_15537_ _19325_/Q VDD VSS _15563_/A INVX1
XFILLER_30_474 VDD VSS DECAPHV16
X_18256_ _18257_/CK _18256_/D _18261_/D _20079_/RB VDD VSS DFFRQX1
X_15468_ _15468_/A VDD VSS _15850_/B INVX1
X_14419_ _14467_/A _14419_/B VDD VSS _19138_/D AND2X1
X_17207_ _19796_/Q VDD VSS _17357_/B INVX1
XFILLER_128_373 VSS VDD FILLER2
X_18187_ _18191_/C _18188_/B _18187_/C VDD VSS _18188_/C OAI21X1
X_15399_ _19541_/Q _19542_/Q VDD VSS _15439_/B _15399_/C NAND3X1
XFILLER_144_844 VSS VDD FILLER2
XFILLER_7_692 VSS VDD FILLER2
X_17138_ _19782_/Q _19750_/Q VDD VSS _17140_/D XNOR2X1
XFILLER_144_899 VDD VSS FILLER1
XFILLER_89_408 VDD VSS DECAPHV8
X_17069_ _19767_/Q _17073_/B VDD VSS _17070_/B XOR2X1
XFILLER_131_538 VDD VSS DECAPHV16
XFILLER_40_0 VSS VDD FILLER2
X_20080_ _20081_/CK _20080_/D _20080_/Q _20080_/RB VDD VSS DFFRQX1
X_09891_ _18560_/Q _09941_/C VDD VSS _09892_/B NAND2X1
XFILLER_100_936 VDD VSS DECAPHV8
XFILLER_84_113 VDD VSS FILLER1
XFILLER_84_146 VSS VDD FILLER2
XFILLER_65_371 VDD VSS FILLER1
XTAP_TAPCELL_ROW_83_848 VDD VSS WELLTAP
XFILLER_41_728 VDD VSS FILLER1
XFILLER_41_739 VDD VSS FILLER4
XFILLER_81_886 VDD VSS FILLER4
XFILLER_81_897 VDD VSS DECAPHV8
Xclkbuf_leaf_5__001_ clkbuf_leaf_5__001_/A VDD VSS _19194_/CK BUFX12
XFILLER_43_49 VDD VSS FILLER4
X_09325_ _20080_/RB _09346_/B VDD VSS _09325_/Y NOR2BX1
XFILLER_21_463 VSS VDD FILLER2
X_09256_ _18258_/Q _20046_/Q VDD VSS _09277_/A _09256_/C NAND3X1
XTAP_TAPCELL_ROW_10_119 VDD VSS WELLTAP
XFILLER_5_607 VDD VSS FILLER1
XFILLER_5_618 VDD VSS FILLER4
X_09187_ _18510_/Q VDD VSS _18457_/D INVX1
XFILLER_108_20 VDD VSS FILLER1
XFILLER_4_117 VSS VDD FILLER2
XFILLER_107_579 VSS VDD FILLER2
XFILLER_122_505 VDD VSS FILLER4
XFILLER_134_343 VSS VDD FILLER2
XFILLER_108_75 VDD VSS FILLER1
XFILLER_135_899 VDD VSS FILLER1
XFILLER_1_835 VSS VDD FILLER2
X_10100_ _10180_/A _11414_/C VDD VSS _18536_/D NOR2X1
X_11080_ _11015_/Y _11079_/Y _10947_/Y VDD VSS _11080_/Y MUX2X1
XFILLER_103_730 VSS VDD FILLER2
X_10031_ _10014_/Y _10029_/Y _10127_/A VDD VSS _10031_/Y MUX2X1
XFILLER_102_251 VDD VSS DECAPHV8
XFILLER_103_763 VDD VSS FILLER4
XFILLER_76_614 VSS VDD FILLER2
XFILLER_102_284 VDD VSS FILLER4
XFILLER_48_349 VDD VSS FILLER1
XFILLER_88_496 VDD VSS FILLER1
XFILLER_91_606 VDD VSS FILLER1
X_14770_ _19334_/Q _14770_/B _15706_/B VDD VSS _14850_/B MIN3X1
XFILLER_72_831 VDD VSS DECAPHV32
XFILLER_90_127 VDD VSS DECAPHV8
X_11982_ _19997_/Q _19261_/Q VDD VSS _12055_/A XNOR2X1
X_13721_ _13721_/A _13721_/B _14423_/B _19141_/Q _13721_/E VDD VSS _13791_/C AOI221X1
XFILLER_16_235 VDD VSS FILLER1
XFILLER_44_566 VDD VSS DECAPHV8
X_10933_ _18675_/Q _18783_/Q VDD VSS _10937_/A XNOR2X1
XFILLER_31_205 VDD VSS FILLER1
XFILLER_72_886 VDD VSS DECAPHV8
X_10864_ _18645_/Q _18807_/Q VDD VSS _10866_/C NAND2X1
X_13652_ _19001_/Q _13652_/B _13692_/C VDD VSS _13830_/B XNOR3X1
Xclkbuf_leaf_24__000_ clkload78/A VDD VSS _19337_/CK BUFX12
X_16440_ _16442_/B _16441_/B _18168_/C VDD VSS _16441_/C OAI21X1
XFILLER_12_430 VDD VSS DECAPHV8
XTAP_TAPCELL_ROW_26_274 VDD VSS WELLTAP
X_10795_ _11229_/D _10795_/B VDD VSS _10804_/D NOR2X1
X_12603_ _12693_/A _12693_/B _14250_/B VDD VSS _14213_/B XNOR3X1
X_13583_ _18888_/Q _14129_/B VDD VSS _13660_/C _14129_/C NAND3X1
X_16371_ _16395_/C _16371_/B VDD VSS _16747_/B XNOR2X1
XTAP_TAPCELL_ROW_139_1402 VDD VSS WELLTAP
X_12534_ _18933_/Q _12534_/B _14181_/B VDD VSS _12617_/B MIN3X1
X_19090_ _19121_/CK _19090_/D _19090_/Q VDD VSS DFFQX1
X_18110_ _18110_/A _18112_/B VDD VSS _18111_/B XOR2X1
X_15322_ _15351_/A _15322_/B VDD VSS _15815_/B XNOR2X1
XTAP_TAPCELL_ROW_4_53 VDD VSS WELLTAP
X_18041_ _18056_/A _18041_/B _18056_/C VDD VSS _19978_/D OAI21X1
XFILLER_8_467 VDD VSS FILLER4
X_12465_ _12558_/A _14345_/B VDD VSS _12625_/B NOR2X1
X_15253_ _19345_/Q _15719_/B VDD VSS _15254_/B XOR2X1
XFILLER_126_833 VDD VSS FILLER4
X_11416_ _18538_/D _11428_/B VDD VSS _18610_/D NOR2BX1
X_12396_ _12396_/A _12396_/B _12396_/C VDD VSS _12402_/A NOR3X1
X_14204_ _14218_/A _14204_/B VDD VSS _18953_/D NOR2X1
X_15184_ _19483_/Q _15875_/B VDD VSS _15185_/D _15875_/C AND3X2
XFILLER_126_866 VDD VSS FILLER1
XFILLER_141_803 VSS VDD FILLER2
X_11347_ _11352_/A _11347_/B VDD VSS _11348_/B XNOR2X1
X_14135_ _14163_/A _14135_/B _14135_/C VDD VSS _18893_/D NOR3X1
X_19992_ _19992_/CK _19992_/D _19992_/Q VDD VSS DFFQX1
X_11278_ _11298_/A _11278_/B _11298_/C VDD VSS _11364_/C OA21X2
X_14066_ _18953_/Q _14204_/B VDD VSS _14086_/D XNOR2X1
X_18943_ _19001_/CK _18943_/D _18943_/Q VDD VSS DFFQX1
XFILLER_79_463 VSS VDD FILLER2
XFILLER_94_411 VDD VSS FILLER4
X_10229_ _10229_/A _10229_/B _10229_/C VDD VSS _10234_/A OAI21X1
X_13017_ _13017_/A _13017_/B _13017_/C _13017_/D VDD VSS _14352_/B OAOI211X1
X_18874_ _18908_/CK _18874_/D _18874_/Q VDD VSS DFFQX1
XFILLER_79_496 VDD VSS FILLER4
X_17825_ _17826_/A _17826_/B _17828_/C VDD VSS _17826_/C OAI21X1
XFILLER_54_308 VDD VSS DECAPHV8
XFILLER_94_455 VDD VSS DECAPHV8
X_17756_ _17758_/A _17758_/B _17756_/C VDD VSS _19914_/D AOI21X1
XFILLER_94_488 VSS VDD FILLER2
X_16707_ _17748_/A _16724_/B VDD VSS _19560_/D NOR2X1
X_14968_ _19533_/Q _14970_/B VDD VSS _15018_/B XNOR2X1
X_13919_ _13827_/A _14230_/B _14230_/C VDD VSS _13987_/D AND3BX1
X_17687_ _18132_/A _17687_/B _17688_/C VDD VSS _19899_/D NOR3X1
X_14899_ _19309_/Q _15680_/B _14899_/C VDD VSS _14951_/B MIN3X1
XFILLER_50_514 VDD VSS DECAPHV8
XTAP_TAPCELL_ROW_80_818 VDD VSS WELLTAP
X_19426_ _19547_/CK _19426_/D _19426_/Q VDD VSS DFFQX1
X_16638_ _16645_/B _16638_/B VDD VSS _16900_/B XOR2X1
X_19357_ _19385_/CK _19357_/D _19357_/Q VDD VSS DFFQX1
X_16569_ _16558_/A _16569_/B _16569_/C VDD VSS _16582_/A AOI2B1X1
X_18308_ _18310_/CK _18500_/D _18308_/Q _20072_/RB VDD VSS DFFRQX1
XFILLER_129_19 VDD VSS FILLER4
X_19288_ _19290_/CK _19288_/D _19288_/Q VDD VSS DFFQX1
X_18239_ _18241_/CK _18239_/D _18239_/Q _20078_/RB VDD VSS DFFRQX1
XFILLER_117_822 VSS VDD FILLER2
X_20201_ _20201_/A VDD VSS _20201_/Y BUFX3
XFILLER_89_238 VDD VSS FILLER4
X_20132_ _20132_/A VDD VSS _20132_/Y BUFX3
Xmax_cap186 _18518_/Q VDD VSS _18465_/D BUFX12
X_09943_ _18563_/Q _11178_/C _09942_/Y VDD VSS _09945_/B AOI21BX1
XFILLER_140_880 VSS VDD FILLER2
XFILLER_98_761 VDD VSS FILLER4
X_09874_ _09885_/A _09874_/B VDD VSS _10017_/C NOR2X1
X_20063_ clkload5/A _20195_/A _20065_/D _20065_/RB VDD VSS DFFRQX1
XFILLER_38_49 VDD VSS DECAPHV16
XFILLER_57_135 VDD VSS DECAPHV32
XFILLER_58_636 VDD VSS FILLER4
XFILLER_86_945 VDD VSS FILLER4
XFILLER_97_282 VDD VSS FILLER4
XFILLER_100_766 VSS VDD FILLER2
XFILLER_100_788 VSS VDD FILLER2
XFILLER_46_809 VSS VDD FILLER2
XFILLER_73_617 VDD VSS FILLER4
XTAP_TAPCELL_ROW_96_973 VDD VSS WELLTAP
XFILLER_100_799 VSS VDD FILLER2
XTAP_TAPCELL_ROW_68_697 VDD VSS WELLTAP
XFILLER_72_138 VDD VSS FILLER1
XFILLER_13_205 VSS VDD FILLER2
XFILLER_14_717 VSS VDD FILLER2
XFILLER_53_352 VSS VDD FILLER2
XFILLER_54_875 VDD VSS FILLER4
XFILLER_54_886 VSS VDD FILLER2
XTAP_TAPCELL_ROW_123_1247 VDD VSS WELLTAP
XFILLER_81_694 VSS VDD FILLER2
XFILLER_10_912 VDD VSS FILLER1
XTAP_TAPCELL_ROW_23_244 VDD VSS WELLTAP
X_09308_ _18294_/Q _18469_/D _09299_/Y VDD VSS _09308_/Y MUXI2X1
XFILLER_21_282 VSS VDD FILLER2
X_10580_ _10945_/A _10656_/B _10656_/C _11255_/A VDD VSS _10737_/B AOI211X1
XFILLER_108_800 VDD VSS FILLER1
X_09239_ _18474_/D VDD VSS _18346_/D INVX1
XFILLER_126_129 VDD VSS DECAPHV8
XFILLER_5_426 VSS VDD FILLER2
X_12250_ wire159/Y _12298_/B _12298_/D VDD VSS _12258_/C OAI21X1
XFILLER_102_2 VDD VSS FILLER1
XFILLER_107_332 VDD VSS FILLER1
XFILLER_119_96 VSS VDD FILLER2
XTAP_TAPCELL_ROW_134_1354 VDD VSS WELLTAP
X_11201_ _18710_/Q _18764_/Q VDD VSS _11202_/B XOR2X1
X_12181_ _12181_/A _12181_/B _14435_/B _12181_/D _12181_/E VDD VSS _12372_/C OAI221X1
XFILLER_135_674 VDD VSS FILLER1
XFILLER_135_685 VDD VSS FILLER4
X_11132_ _11132_/A _11132_/B _11132_/C _11132_/D VDD VSS _11163_/C AOI211X1
X_09972__242 _20079_/CK VDD VSS _18519_/CK INVX1
XFILLER_135_62 VDD VSS FILLER4
XFILLER_1_654 VDD VSS DECAPHV8
X_11063_ _11064_/A _11064_/B VDD VSS _11102_/C AND2X1
X_15940_ _19548_/Q _16693_/A _15940_/C VDD VSS _15963_/C OAI21X1
XFILLER_131_891 VDD VSS FILLER4
X_10014_ _18580_/Q _10042_/C VDD VSS _10014_/Y XNOR2X1
X_15871_ _15895_/A _15871_/B VDD VSS _19479_/D NOR2X1
X_17610_ _17610_/A _17610_/B _17610_/C VDD VSS _17618_/A OA21X2
X_14822_ _14872_/A _14872_/B _14872_/C VDD VSS _14824_/B AOI21X1
XFILLER_57_680 VSS VDD FILLER2
X_18590_ _18595_/CK _18590_/D _18590_/Q VDD VSS DFFQX1
X_11965_ _19148_/Q _11973_/A _14431_/B VDD VSS _14399_/B XNOR3X1
X_17541_ _17539_/B _17541_/B VDD VSS _17542_/C NOR2BX1
X_14753_ _14837_/A _14837_/B _14837_/C VDD VSS _15831_/C NOR3X1
XFILLER_17_577 VDD VSS FILLER1
XFILLER_32_514 VDD VSS DECAPHV8
XFILLER_45_875 VDD VSS FILLER1
X_10916_ _18568_/Q _10917_/B VDD VSS _10954_/B OR2X2
X_13704_ _13783_/A _14297_/B VDD VSS _13766_/B NOR2X1
X_14684_ _19472_/Q _15863_/B VDD VSS _14737_/B XNOR2X1
X_17472_ _17475_/C _17473_/B _17509_/C VDD VSS _17473_/C OAI21X1
XFILLER_44_396 VDD VSS FILLER4
X_11896_ _19148_/Q _11973_/A _14431_/B VDD VSS _11961_/B XOR3X1
X_13635_ _19169_/Q _14454_/B VDD VSS _13719_/A XOR2X1
X_19211_ _19242_/CK _19211_/D _19211_/Q VDD VSS DFFQX1
X_16423_ _19567_/Q _19919_/Q VDD VSS _16424_/B XOR2X1
XFILLER_44_81 VDD VSS FILLER1
XTAP_TAPCELL_ROW_100_1011 VDD VSS WELLTAP
X_10847_ _18566_/Q _10848_/B VDD VSS _10885_/A AND2X1
X_19142_ _19196_/CK _19142_/D _19142_/Q VDD VSS DFFQX1
XFILLER_13_794 VDD VSS DECAPHV8
X_10778_ _10778_/A _10816_/B VDD VSS _10780_/B XOR2X1
X_13566_ _19028_/Q _13733_/A _13610_/B VDD VSS _13683_/D XNOR3X1
X_16354_ _19724_/Q _16888_/B VDD VSS _16358_/B XOR2X1
XFILLER_12_282 VSS VDD FILLER2
X_12517_ _12517_/A _12517_/B _12517_/C _12517_/D VDD VSS _12803_/A AOAI211X1
X_13497_ _13497_/A _14128_/B _13497_/C VDD VSS _13869_/A MIN3X1
X_19073_ _19096_/CK _19073_/D _19073_/Q VDD VSS DFFQX1
X_16285_ _19561_/Q _19913_/Q _16285_/C VDD VSS _16286_/C AOI2B1X1
X_15305_ _15305_/A _15305_/B _15305_/C _15305_/D VDD VSS _15345_/B AOAI211X1
X_12448_ _12448_/A _12448_/B _14341_/B VDD VSS _12449_/B MIN3X1
X_18024_ _18532_/Q _18024_/B _18533_/Q VDD VSS _18025_/C AOI21X1
X_15236_ _19512_/Q _15276_/B VDD VSS _15311_/C NAND2X1
XFILLER_114_803 VDD VSS FILLER1
XFILLER_99_503 VDD VSS FILLER1
XFILLER_113_313 VSS VDD FILLER2
XFILLER_114_836 VDD VSS FILLER4
XFILLER_125_151 VDD VSS FILLER4
XFILLER_141_611 VDD VSS FILLER1
X_12379_ _12553_/B _14406_/C _19127_/Q VDD VSS _12380_/D AND3BX1
X_15167_ _15172_/A _15167_/B VDD VSS _15686_/B XNOR2X1
XFILLER_4_492 VDD VSS FILLER4
XFILLER_5_86 VSS VDD FILLER2
X_14118_ _14118_/A _14118_/B VDD VSS _18878_/D NOR2X1
X_19975_ _19984_/CK _19975_/D _19975_/Q VDD VSS DFFQX1
X_15098_ _19507_/Q _15098_/B VDD VSS _15108_/A NAND2X1
XFILLER_101_508 VSS VDD FILLER2
X_14049_ _18896_/Q _14049_/B _14085_/D VDD VSS _17960_/C XNOR3X1
Xclkbuf_leaf_4__002_ clkbuf_leaf_9__002_/A VDD VSS _18797_/CK BUFX12
X_18926_ _19197_/CK _18926_/D _18926_/Q VDD VSS DFFQX1
XFILLER_140_187 VDD VSS FILLER1
XFILLER_79_282 VDD VSS DECAPHV8
XFILLER_95_742 VSS VDD FILLER2
X_18857_ _18888_/CK _18857_/D _18857_/Q VDD VSS DFFQX1
XFILLER_36_820 VSS VDD FILLER2
XFILLER_55_639 VSS VDD FILLER2
XFILLER_83_948 VSS VDD FILLER2
X_09590_ _09811_/C VDD VSS _09797_/C BUFX3
X_18788_ _18811_/CK _18788_/D _18788_/Q VDD VSS DFFQX1
X_17808_ _19926_/Q _19894_/Q VDD VSS _17809_/B XOR2X1
XTAP_TAPCELL_ROW_93_943 VDD VSS WELLTAP
X_17739_ _17740_/C _18127_/B _17739_/C VDD VSS _19910_/D AND3BX1
XFILLER_36_886 VDD VSS DECAPHV8
XFILLER_62_160 VDD VSS FILLER1
XTAP_TAPCELL_ROW_65_667 VDD VSS WELLTAP
XFILLER_90_480 VDD VSS DECAPHV8
X_19409_ _19435_/CK _19409_/D _19409_/Q VDD VSS DFFQX1
XFILLER_50_355 VDD VSS FILLER1
XTAP_TAPCELL_ROW_20_214 VDD VSS WELLTAP
XFILLER_136_438 VDD VSS FILLER1
XFILLER_136_449 VSS VDD FILLER2
XFILLER_40_28 VDD VSS FILLER1
XFILLER_105_814 VSS VDD FILLER2
XFILLER_104_335 VDD VSS FILLER4
XFILLER_49_59 VDD VSS FILLER4
X_09926_ _18558_/Q _10247_/A _18559_/Q VDD VSS _09927_/B AOI21X1
X_20115_ _20115_/A VDD VSS _20115_/Y BUFX3
Xclkbuf_leaf_23__001_ clkbuf_2_3__f__001_/Y VDD VSS _18935_/CK BUFX12
XFILLER_105_10 VDD VSS DECAPHV16
X_20046_ _20046_/CK _20046_/D _20046_/Q _09285_/Y VDD VSS DFFRQX1
XFILLER_74_926 VDD VSS FILLER1
XFILLER_85_230 VDD VSS DECAPHV8
XFILLER_86_753 VSS VDD FILLER2
XFILLER_86_775 VDD VSS FILLER1
X_09857_ _18572_/Q _09864_/B VDD VSS _09857_/Y XNOR2X1
XFILLER_45_105 VDD VSS FILLER1
X_09788_ _20130_/A _09788_/B _09813_/C _20194_/A _09788_/E VDD VSS _09788_/Y AOI221X1
Xclkbuf_leaf_38__001_ clkbuf_leaf_5__001_/A VDD VSS _19137_/CK BUFX12
XFILLER_27_842 VDD VSS FILLER1
XFILLER_121_53 VDD VSS DECAPHV16
XFILLER_14_514 VDD VSS DECAPHV8
XFILLER_27_875 VDD VSS FILLER1
X_11750_ _11835_/A _11835_/B _11835_/C VDD VSS _11764_/B OAI21X1
XFILLER_14_536 VDD VSS DECAPHV8
XTAP_TAPCELL_ROW_36_380 VDD VSS WELLTAP
X_10701_ _10960_/A _10843_/A VDD VSS _10702_/C _10701_/C NAND3X1
X_11681_ _18818_/Q _14547_/B VDD VSS _18845_/D AND2X1
XFILLER_14_62 VDD VSS DECAPHV8
X_10632_ _19947_/Q _18829_/Q VDD VSS _10681_/B XOR2X1
X_13420_ _13420_/A _13420_/B _13420_/C _13420_/D VDD VSS _14293_/B OAOI211X1
XFILLER_128_917 VDD VSS FILLER1
XFILLER_22_591 VDD VSS FILLER1
X_10563_ _10563_/A _10563_/B _10563_/C _10563_/D VDD VSS _10564_/C AOI211X1
X_13351_ _19194_/Q _13449_/B _13454_/C VDD VSS _13542_/C XNOR3X1
XFILLER_10_775 VDD VSS DECAPHV8
X_12302_ _12380_/A _14375_/B VDD VSS _12334_/B NOR2X1
X_16070_ _16081_/B _16070_/B VDD VSS _16841_/B XNOR2X1
X_10494_ _10525_/A _10525_/B _10525_/C _10763_/A VDD VSS _10495_/D AOI31X1
X_13282_ _18885_/Q _13495_/B _13288_/C VDD VSS _17901_/B XNOR3X1
X_15021_ _19480_/Q _15021_/B _15021_/C VDD VSS _15054_/C XOR3X1
XFILLER_107_162 VDD VSS FILLER4
XFILLER_108_674 VDD VSS FILLER4
XFILLER_135_460 VDD VSS FILLER4
XFILLER_30_72 VSS VDD FILLER2
XTAP_TAPCELL_ROW_1_21 VDD VSS WELLTAP
X_12233_ _19236_/Q _12236_/A _12233_/C VDD VSS _12234_/D XNOR3X1
X_12164_ _20001_/Q _19265_/Q VDD VSS _12236_/D XNOR2X1
XFILLER_110_305 VDD VSS FILLER4
XFILLER_111_817 VDD VSS FILLER4
X_11115_ _11116_/A _11115_/B VDD VSS _11116_/C NAND2X1
X_12095_ _19207_/Q _14498_/B VDD VSS _12160_/A NOR2BX1
X_19760_ _19795_/CK _19760_/D _19760_/Q VDD VSS DFFQX1
X_16972_ _19748_/Q _19749_/Q _16978_/B VDD VSS _16973_/C OAI21X1
X_11046_ _11078_/A _18732_/Q wire170/Y _11046_/D VDD VSS _11047_/D AOI22X1
X_18711_ _18768_/CK _18711_/D _18711_/Q VDD VSS DFFQX1
X_15923_ _15923_/A _15923_/B VDD VSS _15924_/C NAND2X1
XFILLER_39_81 VDD VSS FILLER1
X_19691_ _19724_/CK _19691_/D _19691_/Q VDD VSS DFFQX1
XFILLER_65_948 VSS VDD FILLER2
XFILLER_77_797 VDD VSS DECAPHV8
XFILLER_91_211 VDD VSS FILLER4
X_18642_ _18779_/CK _18642_/D _18642_/Q VDD VSS DFFQX1
X_15854_ _15867_/A _15855_/B VDD VSS _19465_/D NOR2X1
X_18573_ _18582_/CK _18573_/D _18573_/Q VDD VSS DFFQX1
X_15785_ _15793_/A _15785_/B VDD VSS _19404_/D AND2X1
X_14805_ _19307_/Q _15677_/B VDD VSS _14809_/B NOR2X1
XFILLER_18_886 VDD VSS FILLER1
XFILLER_51_108 VDD VSS FILLER4
XTAP_TAPCELL_ROW_90_913 VDD VSS WELLTAP
X_12997_ _19021_/Q _13005_/B _12997_/C VDD VSS _13008_/B XNOR3X1
X_17524_ _17527_/A _17527_/B VDD VSS _17525_/B XNOR2X1
X_14736_ _19473_/Q _15864_/B VDD VSS _14837_/A NOR2BX1
XFILLER_33_856 VDD VSS DECAPHV16
XTAP_TAPCELL_ROW_62_637 VDD VSS WELLTAP
X_11948_ _11950_/A _11950_/B _14271_/B VDD VSS _14237_/B XNOR3X1
X_11879_ _11918_/A _11918_/B _11918_/D VDD VSS _11891_/B OAI21X1
X_14667_ _14667_/A _14667_/B _15765_/B VDD VSS _14696_/B MIN3X1
X_17455_ _19849_/Q _19817_/Q _17455_/C VDD VSS _17460_/B MIN3X1
X_13618_ _14420_/B _14420_/C _19139_/Q VDD VSS _13620_/C AOI21X1
X_14598_ _14615_/A _14598_/B VDD VSS _15859_/A _14645_/B NAND3X1
X_17386_ _17536_/A _17386_/B _17387_/C VDD VSS _19835_/D NOR3X1
X_16406_ _16406_/A _16406_/B _16406_/C VDD VSS _16407_/B NOR3X1
X_13549_ _13637_/A _13549_/B VDD VSS _14452_/B XNOR2X1
X_19125_ _19129_/CK _19125_/D _19125_/Q VDD VSS DFFQX1
X_16337_ _16317_/A _16337_/B _16337_/C VDD VSS _16366_/B AOI2B1X1
XFILLER_118_427 VDD VSS DECAPHV8
X_19056_ _19085_/CK _19056_/D _19056_/Q VDD VSS DFFQX1
XFILLER_65_2 VDD VSS FILLER1
X_18007_ _18049_/B VDD VSS _18056_/A BUFX3
X_16268_ _16296_/B _16268_/B VDD VSS _16850_/B NOR2BX1
XFILLER_99_311 VDD VSS FILLER4
X_16199_ _16196_/A _16199_/B VDD VSS _16222_/B NOR2BX1
X_15219_ _19372_/Q VDD VSS _15221_/A INVX1
XFILLER_141_430 VDD VSS FILLER4
XFILLER_142_942 VDD VSS DECAPHV8
XFILLER_99_322 VDD VSS FILLER4
XFILLER_113_143 VDD VSS FILLER1
XFILLER_99_355 VDD VSS FILLER4
X_09711_ _18448_/Q _09751_/B _09711_/C _09711_/D VDD VSS _09712_/B OAI211X1
X_19958_ _19958_/CK _19958_/D _19958_/Q VDD VSS DFFQX1
XFILLER_68_764 VDD VSS DECAPHV8
X_19889_ clkload8/A _19889_/D _19889_/Q VDD VSS DFFQX1
X_18909_ _18936_/CK _18909_/D _18909_/Q VDD VSS DFFQX1
XFILLER_67_263 VDD VSS DECAPHV16
XFILLER_95_572 VDD VSS FILLER4
X_09642_ _18237_/Q _09770_/B _09797_/C _20201_/A _09642_/E VDD VSS _09650_/B AOI221X1
XTAP_TAPCELL_ROW_78_792 VDD VSS WELLTAP
X_09573_ _18440_/Q _09816_/B _09573_/C _09753_/A VDD VSS _09574_/E OAI211X1
XFILLER_36_672 VDD VSS DECAPHV8
XFILLER_70_417 VDD VSS FILLER1
XFILLER_23_300 VDD VSS FILLER1
XFILLER_35_171 VSS VDD FILLER2
XTAP_TAPCELL_ROW_120_1217 VDD VSS WELLTAP
XTAP_TAPCELL_ROW_33_350 VDD VSS WELLTAP
XFILLER_136_213 VDD VSS FILLER4
XFILLER_137_736 VDD VSS FILLER1
XFILLER_136_235 VDD VSS FILLER1
XFILLER_105_600 VSS VDD FILLER2
XFILLER_136_268 VDD VSS DECAPHV8
XTAP_TAPCELL_ROW_131_1324 VDD VSS WELLTAP
XFILLER_120_603 VDD VSS FILLER1
XFILLER_59_720 VDD VSS FILLER1
X_09909_ _11014_/A _09909_/B _09909_/C VDD VSS _09939_/B AOI21X1
XFILLER_19_617 VDD VSS FILLER4
XFILLER_19_628 VDD VSS DECAPHV16
XFILLER_58_285 VDD VSS FILLER1
X_12920_ _19077_/Q _14351_/B VDD VSS _13021_/A AND2X1
X_20029_ _20045_/CK _20029_/D _20029_/Q _20031_/RB VDD VSS DFFRQX1
XFILLER_74_745 VDD VSS FILLER1
X_12851_ _20008_/Q _19272_/Q VDD VSS _12955_/D NOR2X1
XFILLER_27_661 VDD VSS DECAPHV32
XFILLER_34_609 VDD VSS FILLER1
XFILLER_92_45 VDD VSS FILLER1
XTAP_TAPCELL_ROW_142_1431 VDD VSS WELLTAP
X_11802_ _11828_/A _11828_/B _11828_/C VDD VSS _11807_/B AOI21X1
XFILLER_15_834 VSS VDD FILLER2
XFILLER_42_631 VDD VSS DECAPHV16
X_12782_ _18992_/Q _12903_/A _14253_/B VDD VSS _14215_/B XOR3X1
X_15570_ _19409_/Q _15790_/B _15570_/C VDD VSS _15597_/A AOI21X1
XFILLER_15_856 VDD VSS FILLER4
XFILLER_15_867 VDD VSS FILLER4
X_11733_ _19171_/Q _11733_/B _11733_/C VDD VSS _11793_/B MIN3X1
X_14521_ _14491_/Y _14521_/B _14521_/C VDD VSS _19228_/D AND3BX1
X_11664_ _18803_/Q _11669_/B VDD VSS _18830_/D AND2X1
X_14452_ _14456_/A _14452_/B VDD VSS _19167_/D NOR2X1
X_17240_ _17242_/B _17240_/B VDD VSS _17241_/B XOR2X1
X_10615_ _18639_/Q _18801_/Q VDD VSS _10617_/C XNOR2X1
X_13403_ _13586_/A _14192_/B VDD VSS _13490_/B NOR2X1
X_17171_ _19789_/Q _19757_/Q VDD VSS _17174_/B XOR2X1
XFILLER_10_561 VDD VSS FILLER1
XFILLER_6_510 VDD VSS FILLER1
X_11595_ _18740_/Q _11600_/B VDD VSS _18767_/D AND2X1
X_14383_ _14381_/Y _14383_/B _14383_/C VDD VSS _19105_/D AND3BX1
X_16122_ _16129_/B _16122_/B VDD VSS _16879_/B XNOR2X1
XFILLER_127_246 VDD VSS FILLER1
X_10546_ _10546_/A _10546_/B VDD VSS _10547_/A AND2X1
X_13334_ _13354_/A _14416_/B _13354_/C _13334_/D VDD VSS _13546_/A OAOI211X1
XFILLER_108_471 VDD VSS FILLER4
X_10477_ _18636_/Q _18798_/Q VDD VSS _10514_/D NAND2X1
X_13265_ _19165_/Q _13356_/B _13443_/D VDD VSS _13354_/C XNOR3X1
X_16053_ _19712_/Q _16875_/B VDD VSS _16054_/C NOR2X1
X_12216_ _12372_/A _12372_/B _12372_/C _12372_/D VDD VSS _12471_/A AO31X2
X_15004_ _15052_/A _15052_/B VDD VSS _15871_/B XNOR2X1
XFILLER_123_463 VSS VDD FILLER2
X_13196_ _18996_/Q _14258_/B VDD VSS _14221_/A AND2X1
X_19812_ _19843_/CK _19812_/D _19812_/Q VDD VSS DFFQX1
XFILLER_96_336 VDD VSS FILLER1
X_12147_ _12147_/A _12181_/B _12181_/E _12147_/D VDD VSS _14403_/C OAOI211X1
XFILLER_110_135 VDD VSS FILLER4
XFILLER_1_292 VSS VDD FILLER2
XFILLER_96_347 VDD VSS FILLER1
X_12078_ _19094_/Q VDD VSS _12083_/A INVX1
X_19743_ clkload2/A _19743_/D _19743_/Q VDD VSS DFFQX1
X_16955_ _16976_/A _16955_/B VDD VSS _19746_/D NOR2X1
XFILLER_77_561 VSS VDD FILLER2
XTAP_TAPCELL_ROW_39_409 VDD VSS WELLTAP
X_11029_ _18812_/Q VDD VSS _11675_/A INVX1
X_19674_ _19707_/CK _19674_/D _19674_/Q VDD VSS DFFQX1
X_16886_ _16899_/A _16886_/B VDD VSS _19722_/D AND2X1
X_15906_ _15906_/A _15906_/B VDD VSS _19512_/D NOR2X1
X_18625_ _18626_/CK _18625_/D _18625_/Q VDD VSS DFFQX1
X_15837_ _17010_/A _15837_/B _15837_/C VDD VSS _19452_/D NOR3X1
XTAP_TAPCELL_ROW_75_762 VDD VSS WELLTAP
XFILLER_45_480 VDD VSS FILLER4
XFILLER_92_597 VDD VSS FILLER4
XTAP_TAPCELL_ROW_47_486 VDD VSS WELLTAP
X_18556_ _18571_/CK _18556_/D _18556_/Q VDD VSS DFFQX1
X_15768_ _15770_/A _15768_/B VDD VSS _19390_/D AND2X1
XTAP_TAPCELL_ROW_106_1072 VDD VSS WELLTAP
X_18487_ _18487_/CK _18524_/Q _20132_/A _18503_/RB VDD VSS DFFRQX1
X_17507_ _17657_/B _17507_/B _17507_/C VDD VSS _17512_/C MIN3X1
X_15699_ _15706_/A _15699_/B VDD VSS _19327_/D AND2X1
X_14719_ _19417_/Q _14730_/B _15799_/B VDD VSS _15767_/B XNOR3X1
Xclkbuf_leaf_22__002_ clkload17/A VDD VSS _19984_/CK BUFX12
X_17438_ _17439_/A _17439_/B _17439_/D _17439_/C VDD VSS _17441_/C AOI211X1
XANTENNA_15 _09740_/C VDD VSS ANTENNA2
XANTENNA_26 _20138_/Y VDD VSS ANTENNA2
XANTENNA_37 _18127_/B VDD VSS ANTENNA2
XFILLER_119_703 VSS VDD FILLER2
XTAP_TAPCELL_ROW_30_320 VDD VSS WELLTAP
XFILLER_119_747 VDD VSS DECAPHV8
XFILLER_21_19 VDD VSS DECAPHV8
XFILLER_70_0 VDD VSS FILLER4
X_17369_ _17372_/A _17370_/B _17452_/C VDD VSS _17370_/C OAI21X1
XFILLER_118_235 VDD VSS DECAPHV8
X_19108_ _19121_/CK _19108_/D _19108_/Q VDD VSS DFFQX1
XFILLER_134_728 VDD VSS FILLER4
Xoutput100 _20169_/Y VDD VSS o_lf_cfg[6] BUFX3
X_19039_ _19040_/CK _19039_/D _19039_/Q VDD VSS DFFQX1
XTAP_TAPCELL_ROW_117_1190 VDD VSS WELLTAP
Xoutput133 _20198_/Y VDD VSS o_uwb_tx_cfg[1] BUFX3
Xoutput122 _20197_/Y VDD VSS o_uwb_tx_cfg[0] BUFX3
Xoutput111 _20195_/Y VDD VSS o_tst_ctrl[14] BUFX3
XFILLER_102_603 VDD VSS FILLER1
XFILLER_87_303 VSS VDD FILLER2
Xoutput144 _20199_/Y VDD VSS o_uwb_tx_cfg[2] BUFX3
XFILLER_114_474 VSS VDD FILLER2
XFILLER_87_325 VDD VSS FILLER1
XFILLER_29_904 VDD VSS FILLER4
XFILLER_29_948 VSS VDD FILLER2
XFILLER_46_16 VSS VDD FILLER2
XFILLER_68_583 VSS VDD FILLER2
XFILLER_46_49 VDD VSS DECAPHV8
X_09625_ _18315_/Q _09815_/C VDD VSS _09628_/C NAND2X1
X_09556_ _20133_/A _20181_/A _09753_/A VDD VSS _09582_/B MUXI2X1
XFILLER_24_664 VDD VSS FILLER1
XFILLER_62_37 VDD VSS FILLER4
XFILLER_70_258 VDD VSS FILLER1
X_09487_ _18456_/D _09501_/B _09487_/C VDD VSS _18241_/D AOI21X1
XFILLER_51_450 VDD VSS DECAPHV8
XFILLER_109_213 VSS VDD FILLER2
XFILLER_127_4 VDD VSS FILLER4
XFILLER_137_566 VDD VSS DECAPHV8
X_10400_ _10441_/A _10441_/B VDD VSS _10404_/C NAND2X1
X_11380_ _11384_/A _11390_/B VDD VSS _11382_/A XNOR2X1
X_10331_ _18630_/Q _18792_/Q VDD VSS _10372_/A AND2X1
XFILLER_124_227 VDD VSS FILLER4
X_10262_ _11438_/A _18711_/Q VDD VSS _10263_/E AND2X1
X_13050_ _14540_/A _14540_/B _19246_/Q VDD VSS _13129_/D AOI21BX1
X_12001_ _12031_/A _12031_/B _12031_/C VDD VSS _12026_/C OR3X2
XFILLER_121_923 VDD VSS FILLER1
XFILLER_127_96 VDD VSS FILLER1
X_10193_ _18617_/Q _10193_/B VDD VSS _10200_/B NOR2BX1
XFILLER_143_62 VDD VSS DECAPHV8
XFILLER_59_561 VDD VSS DECAPHV8
X_13952_ _19004_/Q _14266_/B _14266_/C VDD VSS _13955_/D OR3BX1
X_16740_ _16748_/A _16740_/B VDD VSS _19590_/D NOR2X1
X_12903_ _12903_/A _12903_/B _12903_/C _12903_/D VDD VSS _13198_/B AOI211X1
XFILLER_62_715 VDD VSS FILLER1
X_13883_ _13924_/A _14166_/B _13884_/C VDD VSS _14167_/B OR3BX1
X_16671_ _16671_/A VDD VSS _16831_/B INVX1
XFILLER_34_417 VDD VSS FILLER1
XTAP_TAPCELL_ROW_72_732 VDD VSS WELLTAP
X_12834_ _12945_/A _14509_/B VDD VSS _12953_/A NOR2X1
X_19390_ _19435_/CK _19390_/D _19390_/Q VDD VSS DFFQX1
X_18410_ _18423_/CK _18511_/Q _20165_/A _18444_/RB VDD VSS DFFRQX1
X_15622_ _15622_/A _15622_/B _15824_/B VDD VSS _15793_/B MIN3X1
XFILLER_61_236 VDD VSS FILLER4
XFILLER_61_258 VSS VDD FILLER2
XTAP_TAPCELL_ROW_44_456 VDD VSS WELLTAP
X_12765_ _20008_/Q _19272_/Q VDD VSS _12966_/C XOR2X1
X_18341_ _18342_/CK _18341_/D _18341_/Q _18373_/RB VDD VSS DFFRQX1
X_15553_ _15599_/B _15553_/B VDD VSS _15790_/B NOR2BX1
XTAP_TAPCELL_ROW_7_86 VDD VSS WELLTAP
X_11716_ _11716_/A _11716_/B _11716_/C _11716_/D VDD VSS _11742_/B AOAI211X1
X_14504_ _14491_/Y _14504_/B _14504_/C VDD VSS _19212_/D AND3BX1
X_18272_ _18272_/CK _18272_/D _18272_/Q _18485_/RB VDD VSS DFFRQX1
XFILLER_14_174 VSS VDD FILLER2
XFILLER_30_634 VDD VSS FILLER4
XTAP_TAPCELL_ROW_99_1005 VDD VSS WELLTAP
X_12696_ _18935_/Q _12708_/B _14183_/B VDD VSS _12789_/C XNOR3X1
X_17223_ _19800_/Q _19768_/Q VDD VSS _17227_/B XNOR2X1
X_15484_ _19435_/Q _15820_/B VDD VSS _15485_/B XNOR2X1
XFILLER_11_870 VDD VSS FILLER4
X_11647_ _18788_/Q _11647_/B VDD VSS _18815_/D AND2X1
X_14435_ _14456_/A _14435_/B VDD VSS _19152_/D NOR2X1
XTAP_TAPCELL_ROW_0_8 VDD VSS WELLTAP
X_11578_ _18725_/Q _11578_/B VDD VSS _18752_/D AND2X1
X_14366_ _14368_/A _14366_/B VDD VSS _19090_/D NOR2X1
X_17154_ _17156_/C _17154_/B _17154_/C VDD VSS _19785_/D AOI21X1
XFILLER_10_391 VSS VDD FILLER2
XFILLER_128_599 VDD VSS FILLER4
X_10529_ _19943_/Q _18825_/Q VDD VSS _10530_/D NAND2X1
X_13317_ _13430_/B _13318_/C _19136_/Q VDD VSS _13319_/C AOI21X1
X_17085_ _19770_/Q _19738_/Q VDD VSS _17087_/C _17085_/C AND3X2
X_16105_ _19650_/Q _16807_/B VDD VSS _16106_/C NOR2X1
X_14297_ _14352_/A _14297_/B _14297_/C VDD VSS _19029_/D NOR3X1
X_16036_ _19552_/Q _19904_/Q VDD VSS _16039_/A XNOR2X1
XFILLER_112_901 VDD VSS DECAPHV32
X_13248_ _14513_/B _14513_/C _13253_/A VDD VSS _13254_/C OAI21X1
XFILLER_111_411 VDD VSS DECAPHV8
XFILLER_124_783 VDD VSS FILLER1
X_13179_ _18881_/Q VDD VSS _13181_/A INVX1
XFILLER_69_347 VDD VSS DECAPHV16
XFILLER_38_712 VDD VSS FILLER1
XFILLER_85_829 VDD VSS DECAPHV8
X_19726_ _19730_/CK _19726_/D _19726_/Q VDD VSS DFFQX1
X_17987_ _17987_/A _17987_/B _17987_/C VDD VSS _17989_/B AOI21X1
XFILLER_93_840 VDD VSS FILLER4
X_16938_ _19743_/Q _17078_/B VDD VSS _16939_/B XOR2X1
XFILLER_38_778 VDD VSS FILLER1
X_19657_ _19703_/CK _19657_/D _19657_/Q VDD VSS DFFQX1
X_16869_ _16876_/A _16869_/B VDD VSS _19706_/D NOR2X1
XFILLER_53_737 VDD VSS FILLER4
XFILLER_80_534 VDD VSS FILLER1
XFILLER_93_895 VDD VSS FILLER1
X_09410_ _09422_/B _09410_/B VDD VSS _09496_/C AND2X1
X_19588_ _19673_/CK _19588_/D _19588_/Q VDD VSS DFFQX1
X_18608_ _18608_/CK _18608_/D _18608_/Q VDD VSS DFFQX1
X_09341_ _18283_/Q _18511_/Q _09354_/B VDD VSS _09341_/Y MUXI2X1
X_18539_ _18543_/CK _18539_/D _18539_/Q VDD VSS DFFQX1
XFILLER_21_634 VSS VDD FILLER2
XFILLER_32_18 VDD VSS DECAPHV16
X_09272_ _18277_/Q _09354_/A VDD VSS _09273_/C NAND2X1
XFILLER_119_533 VDD VSS DECAPHV8
XFILLER_107_728 VDD VSS FILLER1
XFILLER_119_566 VDD VSS FILLER1
XFILLER_134_514 VDD VSS FILLER4
XFILLER_121_208 VDD VSS DECAPHV8
XFILLER_0_516 VDD VSS FILLER4
XFILLER_0_527 VDD VSS DECAPHV8
XFILLER_102_411 VDD VSS FILLER4
XFILLER_114_271 VDD VSS DECAPHV8
XFILLER_130_775 VDD VSS FILLER1
XFILLER_130_797 VSS VDD FILLER2
XFILLER_29_712 VSS VDD FILLER2
XFILLER_75_317 VDD VSS DECAPHV8
XFILLER_28_244 VDD VSS FILLER1
XFILLER_29_767 VDD VSS DECAPHV8
XFILLER_56_564 VDD VSS FILLER4
XTAP_TAPCELL_ROW_86_879 VDD VSS WELLTAP
XFILLER_43_214 VDD VSS FILLER4
XFILLER_73_47 VSS VDD FILLER2
XTAP_TAPCELL_ROW_126_1278 VDD VSS WELLTAP
X_09608_ _20165_/A _09784_/C _09769_/C _18314_/Q VDD VSS _09609_/D AOI22X1
X_10880_ _10960_/A _10880_/B VDD VSS _10881_/C NAND2X1
X_09539_ _20033_/Q _09547_/B VDD VSS _20034_/D NOR2BX1
XFILLER_24_461 VSS VDD FILLER2
XFILLER_43_269 VSS VDD FILLER2
XTAP_TAPCELL_ROW_41_426 VDD VSS WELLTAP
X_12550_ _12803_/A _12803_/B _12803_/C VDD VSS _12597_/B AOI21X1
XFILLER_12_656 VSS VDD FILLER2
X_11501_ _18655_/Q _11508_/B VDD VSS _18682_/D AND2X1
X_12481_ _12566_/A _12662_/B VDD VSS _14471_/B XNOR2X1
XFILLER_138_864 VDD VSS FILLER1
X_11432_ _11433_/B _11432_/B wire166/Y _11432_/D VDD VSS _18625_/D AND4X2
X_14220_ _17566_/A VDD VSS _14294_/A BUFX3
XFILLER_118_0 VSS VDD FILLER2
XFILLER_138_886 VDD VSS DECAPHV16
X_14151_ _14154_/A _14151_/B VDD VSS _18907_/D NOR2X1
XFILLER_98_33 VDD VSS DECAPHV8
XTAP_TAPCELL_ROW_137_1385 VDD VSS WELLTAP
X_11363_ _11370_/A _11363_/B _11370_/C VDD VSS _11371_/B OAI21X1
X_13102_ _13102_/A _13102_/B _13102_/C _13102_/D VDD VSS _13161_/B AOAI211X1
X_10314_ _10237_/B _10314_/B _10314_/C VDD VSS _10625_/A AOI2B1X1
X_11294_ _11296_/B _11295_/B VDD VSS _11295_/C NOR2X1
X_14082_ _14174_/A _14174_/B _18926_/Q VDD VSS _14104_/C OAI21X1
XFILLER_0_0 VDD VSS DECAPHV32
XFILLER_106_783 VDD VSS FILLER1
X_10245_ _10383_/A _10314_/C VDD VSS _10346_/A NAND2X1
X_13033_ _19189_/Q _14476_/B _14476_/C VDD VSS _13039_/D OR3BX1
X_18890_ _18917_/CK _18890_/D _18890_/Q VDD VSS DFFQX1
X_17910_ _17914_/A _17914_/B VDD VSS _17912_/A XNOR2X1
XFILLER_105_282 VDD VSS FILLER1
XFILLER_79_645 VSS VDD FILLER2
XFILLER_79_667 VDD VSS FILLER4
X_10176_ _18615_/Q _10177_/B VDD VSS _10184_/C NOR2X1
X_17841_ _19935_/Q _17842_/C _19936_/Q _18087_/D VDD VSS _17842_/D AOAI211X1
XFILLER_121_775 VDD VSS FILLER4
XTAP_TAPCELL_ROW_49_504 VDD VSS WELLTAP
XFILLER_78_188 VDD VSS FILLER4
Xfanout190 _09816_/D VDD VSS _09753_/A BUFX3
X_17772_ _19918_/Q _19886_/Q VDD VSS _17775_/A XNOR2X1
X_14984_ _19339_/Q _15713_/B VDD VSS _14985_/B XNOR2X1
XFILLER_47_70 VDD VSS FILLER4
XFILLER_47_81 VDD VSS DECAPHV8
X_13935_ _18920_/Q _14167_/B VDD VSS _13938_/C _14167_/C NAND3X1
X_19511_ _19707_/CK _19511_/D _19511_/Q VDD VSS DFFQX1
X_16723_ _19926_/Q _16726_/B VDD VSS _19574_/D AND2X1
XFILLER_62_534 VDD VSS DECAPHV8
XFILLER_90_832 VDD VSS DECAPHV8
XTAP_TAPCELL_ROW_57_581 VDD VSS WELLTAP
X_13866_ _18920_/Q _13866_/B _13884_/C VDD VSS _13981_/B XNOR3X1
X_19442_ _19492_/CK _19442_/D _19442_/Q VDD VSS DFFQX1
X_16654_ _16677_/C _16654_/B VDD VSS _16759_/B XNOR2X1
X_12817_ _19132_/Q _13107_/A _12822_/B VDD VSS _12819_/C XNOR3X1
X_15605_ _15625_/B _15605_/B VDD VSS _15761_/B XNOR2X1
XFILLER_15_461 VDD VSS FILLER4
XTAP_TAPCELL_ROW_103_1042 VDD VSS WELLTAP
X_13797_ _19031_/Q _13912_/A _13846_/B VDD VSS _13889_/D XNOR3X1
X_19373_ _19393_/CK _19373_/D _19373_/Q VDD VSS DFFQX1
X_16585_ _16585_/A _16585_/B _16585_/C VDD VSS _16586_/B OR3X2
X_12748_ _12748_/A _14409_/B _12813_/C _12748_/D VDD VSS _12932_/A OAOI211X1
X_18324_ _18324_/CK _18500_/D _18324_/Q _20078_/RB VDD VSS DFFRQX1
X_15536_ _15564_/A _15564_/B VDD VSS _15561_/A NAND2X1
XFILLER_129_820 VDD VSS FILLER1
X_12679_ _19241_/Q _14535_/B _14535_/C VDD VSS _12755_/C OR3BX1
X_18255_ _18255_/CK _18255_/D _18262_/D _18485_/RB VDD VSS DFFRQX1
X_15467_ _19434_/Q _15819_/B _15448_/Y VDD VSS _15509_/B AOI21BX1
X_14418_ _15383_/A VDD VSS _14467_/A BUFX3
X_18186_ _19303_/Q _18190_/A VDD VSS _18188_/B XNOR2X1
X_17206_ _17206_/A _17208_/C _17206_/C VDD VSS _19796_/D AOI21X1
XFILLER_116_514 VSS VDD FILLER2
XFILLER_128_352 VDD VSS FILLER1
X_17137_ _17140_/A _17137_/B _17137_/C VDD VSS _19781_/D AOI21X1
X_15398_ _15398_/A _15910_/B _15398_/C VDD VSS _15440_/B MIN3X1
XFILLER_116_547 VSS VDD FILLER2
XFILLER_143_300 VSS VDD FILLER2
XFILLER_144_834 VDD VSS FILLER4
X_14349_ _14316_/Y _14349_/B _14349_/C VDD VSS _19076_/D AND3BX1
XFILLER_144_878 VDD VSS FILLER1
X_17068_ _19766_/Q _17073_/B _17068_/C VDD VSS _17073_/C AO21X2
XTAP_TAPCELL_ROW_114_1160 VDD VSS WELLTAP
X_09890_ _11014_/A VDD VSS _11178_/C BUFX3
X_16019_ _19706_/Q _16869_/B VDD VSS _16022_/C NAND2X1
XFILLER_33_0 VDD VSS FILLER4
XFILLER_69_133 VDD VSS DECAPHV16
XFILLER_100_915 VSS VDD FILLER2
XFILLER_111_241 VDD VSS DECAPHV8
XFILLER_84_103 VDD VSS FILLER1
XFILLER_100_948 VSS VDD FILLER2
X_19709_ _19711_/CK _19709_/D _19709_/Q VDD VSS DFFQX1
XFILLER_65_383 VSS VDD FILLER2
XTAP_TAPCELL_ROW_83_849 VDD VSS WELLTAP
Xclkbuf_leaf_5__000_ clkload77/A VDD VSS _19483_/CK BUFX12
XFILLER_22_943 VDD VSS FILLER4
XFILLER_40_228 VDD VSS FILLER4
XFILLER_80_397 VDD VSS FILLER1
X_09324_ _18449_/D _09323_/Y _09302_/Y VDD VSS _18518_/D MUXI2X1
X_09255_ _20047_/Q _20048_/Q VDD VSS _09256_/C NOR2X1
XFILLER_138_138 VDD VSS FILLER1
XFILLER_138_149 VSS VDD FILLER2
XFILLER_135_856 VDD VSS FILLER4
XFILLER_108_65 VDD VSS DECAPHV8
XFILLER_1_814 VDD VSS FILLER1
X_10030_ _11178_/C VDD VSS _10127_/A BUFX3
XFILLER_130_550 VDD VSS FILLER1
XFILLER_88_475 VDD VSS FILLER1
XFILLER_75_136 VSS VDD FILLER2
XFILLER_75_169 VSS VDD FILLER2
X_11981_ _14526_/A _14526_/B _11981_/C VDD VSS _11985_/D AO21X2
XFILLER_84_57 VSS VDD FILLER2
XFILLER_84_79 VSS VDD FILLER2
XFILLER_91_629 VDD VSS FILLER1
X_10932_ _11039_/C _10932_/B VDD VSS _10944_/B _10932_/C NAND3X1
X_13720_ _19141_/Q _14423_/B VDD VSS _13791_/A NOR2X1
XFILLER_140_41 VDD VSS FILLER4
XFILLER_44_534 VDD VSS FILLER4
XFILLER_17_84 VSS VDD FILLER2
XFILLER_71_375 VDD VSS DECAPHV8
XFILLER_72_876 VDD VSS FILLER4
XTAP_TAPCELL_ROW_54_551 VDD VSS WELLTAP
X_10863_ _18646_/Q _18808_/Q VDD VSS _10874_/A XOR2X1
X_13651_ _13839_/A _13837_/C _13651_/C VDD VSS _13692_/C XNOR3X1
XFILLER_25_792 VDD VSS FILLER1
XTAP_TAPCELL_ROW_26_275 VDD VSS WELLTAP
X_10794_ _10794_/A _10794_/B _10794_/C _10794_/D VDD VSS _10795_/B OAOI211X1
X_12602_ _12717_/A _12717_/B VDD VSS _14250_/B XNOR2X1
X_13582_ _14129_/B _14129_/C _18888_/Q VDD VSS _13660_/B AOI21X1
X_16370_ _19565_/Q _19917_/Q VDD VSS _16371_/B XNOR2X1
XFILLER_129_116 VSS VDD FILLER2
XTAP_TAPCELL_ROW_139_1403 VDD VSS WELLTAP
X_12533_ _12533_/A _12609_/B _14149_/B VDD VSS _12701_/B MIN3X1
X_15321_ _19459_/Q _15845_/B VDD VSS _15322_/B XNOR2X1
XTAP_TAPCELL_ROW_4_54 VDD VSS WELLTAP
X_18040_ _18541_/Q _18042_/B VDD VSS _18041_/B XNOR2X1
X_15252_ _15260_/B _15252_/B VDD VSS _15719_/B XNOR2X1
X_12464_ _12543_/A _14377_/B VDD VSS _12558_/A NOR2X1
X_14203_ _14203_/A _14203_/B _15836_/C VDD VSS _18952_/D OA21X2
XFILLER_144_119 VDD VSS DECAPHV16
X_11415_ _11422_/A _17990_/B _11415_/C VDD VSS _18609_/D NOR3X1
X_12395_ _19239_/Q _14533_/B VDD VSS _12497_/A AND2X1
X_15183_ _15183_/A _15183_/B _15183_/C _15183_/D VDD VSS _15875_/C AO22X2
X_11346_ _11352_/C _11352_/B VDD VSS _11347_/B NAND2BX1
X_14134_ _14158_/A _14134_/B VDD VSS _18892_/D AND2X1
X_19991_ _19992_/CK _19991_/D _19991_/Q VDD VSS DFFQX1
XFILLER_113_539 VDD VSS DECAPHV8
XFILLER_125_388 VDD VSS DECAPHV16
X_14065_ _14068_/A _14068_/C _14068_/B _14065_/D VDD VSS _14204_/B OAOI211X1
X_18942_ _19001_/CK _18942_/D _18942_/Q VDD VSS DFFQX1
XFILLER_4_696 VDD VSS FILLER1
XFILLER_79_442 VDD VSS FILLER1
X_11277_ _11379_/A _11286_/A VDD VSS _11280_/A NOR2X1
X_13016_ _13101_/A _13113_/A _13314_/B VDD VSS _13017_/D XNOR3X1
X_10228_ _10229_/A _10228_/B _10228_/C VDD VSS _18549_/D OA21X2
X_18873_ _18908_/CK _18873_/D _18873_/Q VDD VSS DFFQX1
XFILLER_0_891 VDD VSS FILLER4
XFILLER_67_659 VSS VDD FILLER2
X_10159_ _11226_/D _10159_/B _10159_/C _18613_/Q VDD VSS _10172_/B AOAI211X1
X_17824_ _19929_/Q _19897_/Q VDD VSS _17826_/B XNOR2X1
XFILLER_94_467 VSS VDD FILLER2
X_17755_ _17758_/A _17758_/B _17828_/C VDD VSS _17756_/C OAI21X1
X_14967_ _19532_/Q _15009_/C VDD VSS _14970_/B NAND2X1
XFILLER_35_523 VDD VSS DECAPHV8
XFILLER_75_681 VDD VSS DECAPHV8
Xclkbuf_leaf_7_clk_regs clkbuf_leaf_9_clk_regs/A VDD VSS _19833_/CK BUFX12
X_16706_ _17812_/A VDD VSS _16724_/B BUFX3
X_13918_ _13918_/A _13918_/B _13918_/C _13918_/D VDD VSS _13924_/B AOAI211X1
X_17686_ _19898_/Q _19866_/Q VDD VSS _17688_/C _17686_/C AND3X2
X_14898_ _15297_/A _18073_/B VDD VSS _19281_/D AND2X1
XTAP_TAPCELL_ROW_80_819 VDD VSS WELLTAP
X_13849_ _13860_/A _14329_/B _13850_/C VDD VSS _13849_/Y AOI21X1
X_19425_ _19425_/CK _19425_/D _19425_/Q VDD VSS DFFQX1
X_16637_ _19703_/Q _16865_/B VDD VSS _16638_/B XNOR2X1
XFILLER_50_526 VDD VSS FILLER1
XFILLER_95_2 VDD VSS FILLER1
X_19356_ _19385_/CK _19356_/D _19356_/Q VDD VSS DFFQX1
X_16568_ _19668_/Q _16826_/B VDD VSS _16569_/C NOR2X1
X_18307_ _18310_/CK _18499_/D _18307_/Q _20072_/RB VDD VSS DFFRQX1
X_15519_ _15520_/A _15520_/B _15520_/C VDD VSS _15546_/C OA21X2
X_19287_ _19290_/CK _19287_/D _19287_/Q VDD VSS DFFQX1
X_16499_ _16525_/A _16525_/B VDD VSS _16753_/B XNOR2X1
X_18238_ _18240_/CK _18238_/D _18238_/Q _20079_/RB VDD VSS DFFRQX1
XFILLER_128_171 VDD VSS FILLER1
XFILLER_144_620 VDD VSS DECAPHV8
X_18169_ _19299_/Q _18169_/B VDD VSS _18170_/A NAND2X1
X_20200_ _20200_/A VDD VSS _20200_/Y BUFX3
X_09942_ _09942_/A _09942_/B _11229_/A VDD VSS _09942_/Y OAI21X1
X_20131_ _20131_/A VDD VSS _20131_/Y BUFX3
Xmax_cap187 _18517_/Q VDD VSS _18496_/D BUFX12
XFILLER_58_615 VSS VDD FILLER2
XFILLER_98_784 VDD VSS FILLER4
X_09873_ _09871_/Y _09872_/Y _11229_/A VDD VSS _09874_/B MUXI2X1
X_20062_ clkload5/A _20194_/A _20064_/D _20064_/RB VDD VSS DFFRQX1
XFILLER_58_626 VSS VDD FILLER2
XFILLER_85_434 VSS VDD FILLER2
XFILLER_39_840 VDD VSS FILLER4
XFILLER_57_169 VDD VSS FILLER1
XTAP_TAPCELL_ROW_96_974 VDD VSS WELLTAP
XFILLER_38_361 VDD VSS FILLER1
XTAP_TAPCELL_ROW_68_698 VDD VSS WELLTAP
XFILLER_54_16 VSS VDD FILLER2
XFILLER_54_27 VSS VDD FILLER2
XFILLER_54_843 VDD VSS DECAPHV32
XFILLER_81_640 VDD VSS FILLER4
XTAP_TAPCELL_ROW_123_1248 VDD VSS WELLTAP
XTAP_TAPCELL_ROW_51_521 VDD VSS WELLTAP
XFILLER_110_55 VDD VSS FILLER1
XFILLER_139_403 VSS VDD FILLER2
XFILLER_70_26 VDD VSS FILLER4
XTAP_TAPCELL_ROW_23_245 VDD VSS WELLTAP
X_09307_ _20080_/RB _09346_/B VDD VSS _09307_/Y NOR2BX1
XFILLER_110_99 VDD VSS FILLER4
XFILLER_139_436 VDD VSS FILLER4
XFILLER_21_294 VDD VSS DECAPHV8
X_09238_ _18512_/Q VDD VSS _18347_/D INVX1
XFILLER_119_86 VDD VSS FILLER4
XTAP_TAPCELL_ROW_134_1355 VDD VSS WELLTAP
X_11200_ _18709_/Q _18763_/Q _11200_/C VDD VSS _11228_/C AOI21X1
X_12180_ _12181_/D _14435_/B VDD VSS _12372_/A NAND2X1
X_11131_ _11132_/A _11132_/B _11132_/D _11132_/C VDD VSS _11134_/C AOAI211X1
XFILLER_103_561 VDD VSS FILLER1
X_11062_ _11556_/A _11616_/A _11062_/C VDD VSS _11064_/B MIN3X1
XFILLER_103_594 VSS VDD FILLER2
XFILLER_135_96 VDD VSS FILLER4
XFILLER_1_688 VDD VSS DECAPHV8
XFILLER_76_423 VDD VSS FILLER1
XFILLER_88_272 VSS VDD FILLER2
XFILLER_88_283 VDD VSS FILLER1
XTAP_TAPCELL_ROW_59_610 VDD VSS WELLTAP
X_10013_ _18579_/Q _10013_/B VDD VSS _10042_/C NOR2BX1
X_15870_ _16776_/A VDD VSS _15895_/A BUFX3
XFILLER_64_607 VDD VSS FILLER4
XFILLER_76_445 VDD VSS FILLER1
XFILLER_76_456 VDD VSS FILLER4
X_14821_ _19501_/Q _14877_/C _14821_/C VDD VSS _14872_/A OR3BX1
XFILLER_28_83 VDD VSS FILLER4
XFILLER_45_810 VDD VSS FILLER1
XFILLER_64_629 VSS VDD FILLER2
XFILLER_91_415 VDD VSS FILLER4
XFILLER_91_426 VDD VSS FILLER4
XFILLER_92_949 VDD VSS FILLER1
XFILLER_17_545 VDD VSS FILLER4
XFILLER_29_383 VSS VDD FILLER2
X_11964_ _19093_/Q _12018_/A _11964_/C VDD VSS _12083_/B MIN3X1
X_17540_ _17675_/A _17540_/B VDD VSS _19868_/D NOR2X1
X_14752_ _14837_/A _14837_/B _14837_/C VDD VSS _15831_/B OA21X2
XFILLER_32_504 VDD VSS FILLER4
X_10915_ _10915_/A _10921_/C VDD VSS _10917_/B XNOR2X1
X_11895_ _11912_/B _11912_/C VDD VSS _14431_/B NAND2X1
X_13703_ _13733_/A _13733_/B _13733_/D _13733_/C VDD VSS _14297_/B OAOI211X1
X_14683_ _14708_/A _14683_/B _14739_/C VDD VSS _15863_/B XNOR3X1
X_17471_ _19853_/Q _19821_/Q VDD VSS _17473_/B XOR2X1
XFILLER_72_695 VSS VDD FILLER2
X_10846_ _10846_/A _10853_/B VDD VSS _10848_/B XNOR2X1
X_13634_ _13634_/A _14483_/B _14453_/A VDD VSS _14454_/B OAI21X1
X_19210_ _19242_/CK _19210_/D _19210_/Q VDD VSS DFFQX1
X_16422_ _19566_/Q _19918_/Q _16422_/C VDD VSS _16450_/C AOI2B1X1
XFILLER_13_751 VDD VSS FILLER1
XTAP_TAPCELL_ROW_100_1012 VDD VSS WELLTAP
X_19141_ _19196_/CK _19141_/D _19141_/Q VDD VSS DFFQX1
X_16353_ _16388_/B _16353_/B VDD VSS _16888_/B NAND2X1
XFILLER_8_221 VDD VSS FILLER1
X_10777_ _10467_/B _10776_/Y _11120_/A VDD VSS _10816_/B MUX2X1
X_13565_ _19056_/Q _13565_/B _13728_/C VDD VSS _13610_/B XNOR3X1
X_15304_ _15304_/A _15783_/B VDD VSS _15305_/D OR2X2
X_12516_ _19072_/Q _14345_/B _14345_/C VDD VSS _12517_/D OR3BX1
X_13496_ _18886_/Q _13496_/B _13496_/C VDD VSS _13497_/C MIN3X1
X_19072_ _19126_/CK _19072_/D _19072_/Q VDD VSS DFFQX1
X_16284_ _19562_/Q _19914_/Q VDD VSS _16287_/A XNOR2X1
XFILLER_126_620 VDD VSS FILLER4
XFILLER_60_81 VDD VSS DECAPHV8
X_12447_ _12447_/A _12447_/B VDD VSS _14341_/B XNOR2X1
X_18023_ _18056_/A _18023_/B _18056_/C VDD VSS _19969_/D OAI21X1
X_15235_ _19539_/Q _15237_/B VDD VSS _15276_/B XNOR2X1
XFILLER_126_664 VDD VSS DECAPHV8
X_15166_ _19343_/Q _15717_/B VDD VSS _15167_/B XOR2X1
XFILLER_125_141 VDD VSS FILLER1
XFILLER_141_601 VDD VSS DECAPHV8
X_12378_ _12378_/A _12378_/B _12378_/C _12378_/D VDD VSS _14406_/C OAI211X1
X_14117_ _14118_/A _14117_/B VDD VSS _18877_/D NOR2X1
XFILLER_113_336 VDD VSS DECAPHV8
XFILLER_141_645 VDD VSS FILLER1
X_11329_ _11370_/A _11379_/B VDD VSS _11370_/C NAND2X1
X_19974_ _19984_/CK _19974_/D _19974_/Q VDD VSS DFFQX1
X_15097_ _15901_/B VDD VSS _15098_/B INVX1
XFILLER_141_667 VDD VSS FILLER1
XFILLER_68_913 VDD VSS FILLER1
XFILLER_69_90 VSS VDD FILLER2
XTAP_TAPCELL_ROW_111_1130 VDD VSS WELLTAP
X_14048_ _18924_/Q wire153/Y _14061_/B VDD VSS _14085_/D XNOR3X1
Xclkbuf_leaf_4__001_ clkbuf_leaf_5__001_/A VDD VSS _19250_/CK BUFX12
X_18925_ _19197_/CK _18925_/D _18925_/Q VDD VSS DFFQX1
X_18856_ _18888_/CK _18856_/D _18856_/Q VDD VSS DFFQX1
XFILLER_94_231 VDD VSS FILLER1
XFILLER_94_242 VDD VSS FILLER4
XFILLER_95_776 VDD VSS FILLER1
X_17807_ _19925_/Q _19893_/Q _17807_/C VDD VSS _17810_/B MIN3X1
XFILLER_39_169 VSS VDD FILLER2
X_18787_ _18811_/CK _18787_/D _18787_/Q VDD VSS DFFQX1
X_15999_ _15999_/A _16035_/B VDD VSS _16767_/B XNOR2X1
XFILLER_54_128 VDD VSS FILLER1
XTAP_TAPCELL_ROW_93_944 VDD VSS WELLTAP
X_17738_ _17738_/A _17738_/B _17738_/C _17738_/D VDD VSS _17739_/C AOAI211X1
XFILLER_23_515 VDD VSS FILLER4
XFILLER_35_353 VSS VDD FILLER2
XFILLER_51_813 VDD VSS DECAPHV8
XTAP_TAPCELL_ROW_65_668 VDD VSS WELLTAP
X_17669_ _17672_/A _17670_/B _17746_/C VDD VSS _17670_/C OAI21X1
XFILLER_23_526 VDD VSS DECAPHV16
XFILLER_35_375 VSS VDD FILLER2
X_19408_ _19435_/CK _19408_/D _19408_/Q VDD VSS DFFQX1
XFILLER_50_345 VDD VSS DECAPHV8
XFILLER_62_194 VDD VSS FILLER4
X_19339_ _19551_/CK _19339_/D _19339_/Q VDD VSS DFFQX1
XFILLER_137_929 VDD VSS FILLER1
XTAP_TAPCELL_ROW_20_215 VDD VSS WELLTAP
XFILLER_117_675 VSS VDD FILLER2
XFILLER_116_174 VDD VSS FILLER1
XFILLER_116_185 VDD VSS FILLER1
XFILLER_144_494 VDD VSS FILLER1
XFILLER_120_807 VSS VDD FILLER2
XFILLER_131_155 VDD VSS FILLER4
X_09925_ _09928_/C _09925_/B _09925_/C VDD VSS _09930_/B OAI21X1
X_20114_ _20114_/A VDD VSS _20114_/Y BUFX3
Xclkbuf_leaf_23__000_ clkload78/A VDD VSS _19551_/CK BUFX12
X_09856_ _18571_/Q _09858_/B VDD VSS _09864_/B NOR2BX1
X_20045_ _20045_/CK _20045_/D _20045_/Q _20071_/RB VDD VSS DFFRQX1
XFILLER_105_55 VDD VSS FILLER4
XFILLER_112_391 VDD VSS FILLER1
Xclkbuf_1_1__f__09179_ clkbuf_0__09179_/Y VDD VSS _20022_/CK BUFX12
XFILLER_86_798 VDD VSS DECAPHV8
X_09787_ _18357_/Q _09787_/B _09787_/C _09787_/D VDD VSS _09788_/E OAI211X1
Xclkbuf_leaf_38__000_ clkload77/A VDD VSS _19495_/CK BUFX12
XFILLER_53_150 VDD VSS DECAPHV8
XFILLER_14_526 VSS VDD FILLER2
XFILLER_54_695 VSS VDD FILLER2
X_10700_ _10844_/B _10699_/Y _10843_/A VDD VSS _10987_/B MUX2X1
XFILLER_53_194 VDD VSS DECAPHV16
X_11680_ _18817_/Q _14547_/B VDD VSS _18844_/D AND2X1
XFILLER_22_570 VSS VDD FILLER2
X_10631_ _11127_/A _10709_/A VDD VSS _10662_/A NAND2X1
X_10562_ _10563_/A _10563_/B _10563_/D _10563_/C VDD VSS _10649_/B AOAI211X1
X_13350_ _19222_/Q _13464_/A _13464_/B VDD VSS _13454_/C XNOR3X1
X_18212__257 _18259_/CK VDD VSS _18279_/CK INVX1
XFILLER_10_787 VSS VDD FILLER2
XFILLER_139_277 VSS VDD FILLER2
X_12301_ _19126_/Q _14405_/B VDD VSS _12380_/A NOR2BX1
X_13281_ _18913_/Q _13494_/B _14158_/B VDD VSS _13288_/C XNOR3X1
XFILLER_5_235 VDD VSS FILLER1
X_10493_ _18690_/Q _18744_/Q VDD VSS _10525_/C XNOR2X1
X_12232_ _12101_/A _14529_/B _14529_/C VDD VSS _12234_/C AND3BX1
X_15020_ _15108_/B _15052_/D VDD VSS _15021_/C NAND2X1
XFILLER_100_0 VDD VSS DECAPHV8
XFILLER_30_62 VSS VDD FILLER2
XTAP_TAPCELL_ROW_1_22 VDD VSS WELLTAP
XFILLER_107_185 VDD VSS FILLER1
XFILLER_122_100 VSS VDD FILLER2
X_12163_ _12401_/A _12401_/B VDD VSS _12172_/B NOR2X1
XFILLER_68_209 VDD VSS FILLER1
X_11114_ _11096_/Y _11114_/B _11114_/C VDD VSS _11116_/B OR3BX1
X_12094_ _12234_/A _12234_/B VDD VSS _14498_/B XNOR2X1
X_16971_ _16971_/A _16971_/B VDD VSS _16973_/B NAND2X1
XFILLER_104_870 VSS VDD FILLER2
XFILLER_122_177 VDD VSS FILLER4
XFILLER_77_721 VSS VDD FILLER2
X_11045_ _11062_/C _11045_/B VDD VSS _11046_/D XNOR2X1
X_18710_ _18764_/CK _18710_/D _18710_/Q VDD VSS DFFQX1
X_15922_ _19899_/Q VDD VSS _16692_/A INVX1
XFILLER_76_231 VDD VSS FILLER1
XFILLER_77_743 VDD VSS FILLER1
XFILLER_77_765 VSS VDD FILLER2
X_19690_ _19724_/CK _19690_/D _19690_/Q VDD VSS DFFQX1
XFILLER_37_618 VDD VSS DECAPHV8
XFILLER_65_927 VSS VDD FILLER2
XFILLER_92_724 VDD VSS DECAPHV8
X_18641_ _19948_/CK _18641_/D _18641_/Q VDD VSS DFFQX1
X_15853_ _15879_/A _15853_/B VDD VSS _19464_/D AND2X1
XFILLER_64_437 VDD VSS FILLER1
XFILLER_92_757 VDD VSS FILLER1
X_12996_ _12996_/A _12996_/B _12996_/C _12996_/D VDD VSS _14256_/B AOAI211X1
X_18572_ _18582_/CK _18572_/D _18572_/Q VDD VSS DFFQX1
X_15784_ _15800_/A _15784_/B VDD VSS _19403_/D NOR2X1
X_14804_ _19307_/Q _15677_/B VDD VSS _14809_/C NAND2X1
XFILLER_33_802 VSS VDD FILLER2
XFILLER_91_278 VDD VSS FILLER1
XTAP_TAPCELL_ROW_90_914 VDD VSS WELLTAP
X_11947_ _12015_/A _12015_/B _11955_/C VDD VSS _14271_/B XNOR3X1
X_17523_ _19863_/Q _19831_/Q _17523_/C VDD VSS _17527_/B MIN3X1
X_14735_ _14781_/A _14781_/B VDD VSS _15864_/B XNOR2X1
XFILLER_33_835 VSS VDD FILLER2
XFILLER_55_92 VDD VSS FILLER1
XFILLER_60_621 VDD VSS DECAPHV16
XFILLER_72_481 VSS VDD FILLER2
XTAP_TAPCELL_ROW_62_638 VDD VSS WELLTAP
XFILLER_32_345 VDD VSS DECAPHV16
XFILLER_60_643 VDD VSS FILLER1
X_11878_ _19203_/Q _14492_/B VDD VSS _11918_/D _14492_/C NAND3X1
X_14666_ _19387_/Q VDD VSS _14667_/A INVX1
X_17454_ _19850_/Q _19818_/Q VDD VSS _17460_/A XNOR2X1
X_10829_ _18671_/Q _18779_/Q VDD VSS _10871_/A NAND2X1
X_13617_ _13617_/A _13617_/B _13617_/C _13617_/D VDD VSS _14420_/B AOAI211X1
X_14597_ _14601_/A _14601_/B _14615_/B _14601_/D VDD VSS _14645_/B AO211X2
X_17385_ _19834_/Q _19802_/Q VDD VSS _17387_/C _17385_/C AND3X2
X_16405_ _16406_/A _16406_/B _16406_/C VDD VSS _16433_/B OA21X2
XFILLER_71_91 VSS VDD FILLER2
X_13548_ _13548_/A _14388_/B _13614_/C _13548_/D VDD VSS _13714_/A OAOI211X1
X_19124_ _19124_/CK _19124_/D _19124_/Q VDD VSS DFFQX1
X_16336_ _19595_/Q _16745_/B VDD VSS _16337_/C NOR2X1
XFILLER_118_439 VSS VDD FILLER2
XFILLER_72_4 VDD VSS FILLER1
X_09979__249 _18259_/CK VDD VSS _18526_/CK INVX1
X_19055_ _19085_/CK _19055_/D _19055_/Q VDD VSS DFFQX1
X_16267_ _16267_/A _16267_/B _16267_/C VDD VSS _16268_/B NOR3X1
X_13479_ _18998_/Q _14260_/B VDD VSS _13511_/C _14260_/C NAND3X1
X_18006_ _18058_/B _18006_/B _18006_/C VDD VSS _18049_/B OAI21X1
X_15218_ _15218_/A _15218_/B _15718_/B VDD VSS _15293_/B MIN3X1
XFILLER_114_601 VSS VDD FILLER2
XFILLER_126_461 VDD VSS FILLER4
XFILLER_142_910 VDD VSS DECAPHV32
XFILLER_58_2 VDD VSS FILLER1
X_16198_ _19718_/Q _16882_/B VDD VSS _16222_/A NOR2X1
X_15149_ _19510_/Q _15149_/B VDD VSS _15191_/C NAND2X1
XFILLER_114_689 VSS VDD FILLER2
X_19957_ _19957_/CK _19957_/D _19957_/Q VDD VSS DFFQX1
XFILLER_87_529 VDD VSS DECAPHV8
X_09710_ _20171_/A _09784_/C _09797_/C _20220_/A VDD VSS _09711_/D AOI22X1
X_18908_ _18908_/CK _18908_/D _18908_/Q VDD VSS DFFQX1
XFILLER_28_607 VDD VSS DECAPHV8
X_19888_ clkload7/A _19888_/D _19888_/Q VDD VSS DFFQX1
XFILLER_68_776 VSS VDD FILLER2
X_09641_ _18428_/Q _09696_/B _09641_/C _09641_/D VDD VSS _09642_/E OAI211X1
X_18839_ _19957_/CK _18839_/D _18839_/Q VDD VSS DFFQX1
XTAP_TAPCELL_ROW_78_793 VDD VSS WELLTAP
X_09572_ _20117_/A _09767_/B VDD VSS _09573_/C NAND2X1
XFILLER_50_142 VDD VSS DECAPHV16
XFILLER_51_654 VSS VDD FILLER2
XFILLER_51_665 VDD VSS FILLER1
XTAP_TAPCELL_ROW_120_1218 VDD VSS WELLTAP
XFILLER_23_367 VDD VSS FILLER1
XFILLER_51_17 VSS VDD FILLER2
XFILLER_51_28 VSS VDD FILLER2
XFILLER_137_726 VSS VDD FILLER2
XFILLER_136_247 VDD VSS DECAPHV8
XFILLER_137_759 VSS VDD FILLER2
XFILLER_117_472 VSS VDD FILLER2
XFILLER_2_205 VDD VSS FILLER1
XFILLER_105_623 VDD VSS FILLER4
XFILLER_105_645 VDD VSS FILLER1
XTAP_TAPCELL_ROW_131_1325 VDD VSS WELLTAP
XFILLER_104_144 VDD VSS FILLER1
XFILLER_116_65 VDD VSS FILLER4
XFILLER_59_710 VSS VDD FILLER2
XFILLER_101_840 VSS VDD FILLER2
XFILLER_58_231 VDD VSS FILLER1
XFILLER_59_765 VDD VSS DECAPHV8
X_09908_ _11014_/A _09908_/B VDD VSS _09909_/C NOR2X1
XFILLER_47_949 VDD VSS FILLER1
XFILLER_58_275 VDD VSS FILLER1
X_09839_ _18564_/Q _11195_/A VDD VSS _09910_/B XNOR2X1
X_20028_ _20045_/CK _20028_/D _20028_/Q _20031_/RB VDD VSS DFFRQX1
XFILLER_132_53 VDD VSS DECAPHV8
XFILLER_62_908 VDD VSS FILLER1
X_12850_ _20008_/Q _19272_/Q VDD VSS _12955_/C NAND2X1
XFILLER_132_75 VDD VSS FILLER1
XTAP_TAPCELL_ROW_142_1432 VDD VSS WELLTAP
X_11801_ _19229_/Q _14523_/B VDD VSS _11828_/C _14523_/C AND3X2
XFILLER_132_97 VSS VDD FILLER2
XFILLER_54_481 VDD VSS DECAPHV16
XFILLER_92_68 VSS VDD FILLER2
X_12781_ _12779_/Y _12872_/B VDD VSS _14253_/B NAND2BX1
X_14520_ _14539_/A _14520_/B VDD VSS _19227_/D NOR2X1
XFILLER_14_356 VDD VSS DECAPHV16
XFILLER_25_62 VSS VDD FILLER2
X_11732_ _19170_/Q _14455_/B VDD VSS _11733_/B OR2X2
X_11663_ _18802_/Q _11669_/B VDD VSS _18829_/D AND2X1
X_14451_ _14490_/A _14451_/B _14451_/C VDD VSS _19166_/D NOR3X1
Xclkbuf_leaf_3__002_ clkbuf_leaf_9__002_/A VDD VSS _18768_/CK BUFX12
XFILLER_41_197 VSS VDD FILLER2
X_10614_ _18638_/Q _18800_/Q VDD VSS _10638_/A NAND2X1
X_13402_ _13402_/A _13402_/B _13402_/C _13402_/D VDD VSS _14192_/B OAOI211X1
X_14382_ _14381_/Y _14382_/B _14382_/C VDD VSS _19104_/D AND3BX1
X_17170_ _19788_/Q _19756_/Q _17170_/C VDD VSS _17176_/C AO21X2
XFILLER_128_737 VDD VSS FILLER1
X_11594_ _18739_/Q _11600_/B VDD VSS _18766_/D AND2X1
X_13333_ _13356_/A _14449_/B _14449_/C VDD VSS _13334_/D NOR3X1
X_16121_ _19683_/Q _16843_/B VDD VSS _16122_/B XNOR2X1
XFILLER_128_759 VDD VSS FILLER4
XFILLER_41_61 VSS VDD FILLER2
X_10545_ _10543_/Y _10592_/B _11431_/A VDD VSS _18558_/D AND3BX1
XFILLER_108_450 VDD VSS FILLER4
X_10476_ _10476_/A _10476_/B _10476_/C _10476_/D VDD VSS _10481_/C OAOI211X1
X_13264_ _19193_/Q _13457_/A _13466_/B VDD VSS _13443_/D XNOR3X1
X_16052_ _16100_/A _16052_/B VDD VSS _19520_/D NOR2X1
XFILLER_108_494 VSS VDD FILLER2
X_12215_ _14436_/C _19153_/Q _12382_/B VDD VSS _12372_/D AND3BX1
X_13195_ _13373_/A _13195_/B VDD VSS _14258_/B XNOR2X1
X_15003_ _15003_/A _15805_/B _15003_/C _15003_/D VDD VSS _15092_/A AOAI211X1
XFILLER_97_805 VDD VSS FILLER4
X_12146_ _12147_/A _12181_/B _12147_/D _12181_/E VDD VSS _14403_/B OA211X2
X_19811_ _19843_/CK _19811_/D _19811_/Q VDD VSS DFFQX1
XFILLER_110_103 VSS VDD FILLER2
XFILLER_1_282 VDD VSS FILLER4
XFILLER_2_44 VSS VDD FILLER2
XFILLER_49_220 VDD VSS FILLER4
XFILLER_49_231 VDD VSS FILLER4
X_12077_ _19039_/Q _12077_/B _12077_/C VDD VSS _12189_/B MIN3X1
X_19742_ clkload3/A _19742_/D _19742_/Q VDD VSS DFFQX1
X_16954_ _16954_/A _16956_/B VDD VSS _16955_/B XOR2X1
XFILLER_110_169 VDD VSS FILLER1
XFILLER_37_404 VDD VSS FILLER1
XFILLER_38_916 VDD VSS DECAPHV16
X_11028_ _18650_/Q VDD VSS _11495_/A INVX1
X_19673_ _19673_/CK _19673_/D _19673_/Q VDD VSS DFFQX1
X_16885_ _16891_/A _16885_/B VDD VSS _19721_/D NOR2X1
X_15905_ _15906_/A _15905_/B VDD VSS _19511_/D NOR2X1
XFILLER_37_426 VSS VDD FILLER2
XFILLER_38_949 VDD VSS FILLER1
X_18624_ _18628_/CK _18624_/D _18624_/Q VDD VSS DFFQX1
X_15836_ _15054_/B _15836_/B _15836_/C VDD VSS _19451_/D AND3BX1
XFILLER_18_640 VDD VSS DECAPHV16
XFILLER_65_768 VDD VSS FILLER1
XFILLER_80_716 VSS VDD FILLER2
XFILLER_92_554 VSS VDD FILLER2
XTAP_TAPCELL_ROW_75_763 VDD VSS WELLTAP
XFILLER_24_109 VDD VSS FILLER1
XTAP_TAPCELL_ROW_47_487 VDD VSS WELLTAP
X_12979_ _13198_/A _13198_/B _13198_/C VDD VSS _12994_/B OAI21X1
X_18555_ _18571_/CK _18555_/D _18555_/Q VDD VSS DFFQX1
X_15767_ _15780_/A _15767_/B VDD VSS _19389_/D NOR2X1
XFILLER_33_654 VDD VSS FILLER4
XFILLER_60_440 VSS VDD FILLER2
XTAP_TAPCELL_ROW_106_1073 VDD VSS WELLTAP
X_18486_ _18487_/CK _18523_/Q _20131_/A _18503_/RB VDD VSS DFFRQX1
X_17506_ _19860_/Q VDD VSS _17657_/B INVX1
X_15698_ _15710_/A _15698_/B VDD VSS _19326_/D NOR2X1
X_14718_ _14776_/A _14776_/B _14734_/C VDD VSS _15799_/B XNOR3X1
XFILLER_32_142 VDD VSS FILLER4
X_14649_ _19523_/Q _19524_/Q _14649_/C _19525_/Q VDD VSS _14705_/C AOI31X1
Xclkbuf_leaf_22__001_ clkbuf_2_3__f__001_/Y VDD VSS _18936_/CK BUFX12
X_17437_ _19846_/Q _19814_/Q VDD VSS _17439_/D XNOR2X1
XANTENNA_16 _11641_/B VDD VSS ANTENNA2
XANTENNA_27 _20158_/A VDD VSS ANTENNA2
XANTENNA_38 _18127_/B VDD VSS ANTENNA2
XFILLER_60_484 VSS VDD FILLER2
XFILLER_118_203 VDD VSS FILLER1
X_19107_ _19121_/CK _19107_/D _19107_/Q VDD VSS DFFQX1
X_17368_ _17838_/A VDD VSS _17452_/C BUFX3
X_17299_ _19816_/Q VDD VSS _17450_/B INVX1
X_16319_ _16320_/A _16320_/B _16320_/C VDD VSS _16335_/C OA21X2
XFILLER_63_0 VDD VSS FILLER4
Xclkbuf_leaf_37__001_ clkbuf_2_1__f__001_/Y VDD VSS _19121_/CK BUFX12
Xoutput101 _20170_/Y VDD VSS o_lf_cfg[7] BUFX3
X_19038_ _19040_/CK _19038_/D _19038_/Q VDD VSS DFFQX1
XFILLER_115_921 VSS VDD FILLER2
Xoutput134 _20217_/Y VDD VSS o_uwb_tx_cfg[20] BUFX3
Xoutput123 _20207_/Y VDD VSS o_uwb_tx_cfg[10] BUFX3
Xoutput112 _20196_/Y VDD VSS o_tst_ctrl[15] BUFX3
XFILLER_88_827 VSS VDD FILLER2
Xoutput145 _20200_/Y VDD VSS o_uwb_tx_cfg[3] BUFX3
XFILLER_102_615 VSS VDD FILLER2
XFILLER_101_125 VDD VSS DECAPHV16
XFILLER_87_359 VDD VSS FILLER4
XFILLER_110_670 VSS VDD FILLER2
XFILLER_28_437 VSS VDD FILLER2
XFILLER_56_735 VSS VDD FILLER2
X_09624_ _09812_/C _09624_/B _09788_/B _20104_/A VDD VSS _09635_/A AOI22X1
XFILLER_15_109 VSS VDD FILLER2
XFILLER_24_621 VDD VSS FILLER4
X_09555_ _18392_/Q VDD VSS _20133_/A INVX1
XFILLER_102_56 VDD VSS FILLER1
X_09486_ _19981_/Q _09490_/B _09507_/B VDD VSS _09487_/C AOI21X1
XFILLER_51_462 VSS VDD FILLER2
XFILLER_62_49 VDD VSS FILLER1
XFILLER_137_501 VSS VDD FILLER2
XFILLER_137_556 VSS VDD FILLER2
X_10330_ _10328_/Y wire170/A _10413_/B VDD VSS _10345_/B AND3BX1
X_10261_ _18657_/Q _18765_/Q VDD VSS _10263_/C XOR2X1
X_12000_ _12031_/A _12031_/B _12031_/C VDD VSS _12026_/B OAI21X1
XFILLER_105_464 VDD VSS FILLER1
XFILLER_87_46 VDD VSS FILLER4
X_10192_ _18617_/Q _10193_/B VDD VSS _10200_/D NAND2BX1
XFILLER_120_445 VDD VSS DECAPHV8
XFILLER_132_283 VDD VSS DECAPHV8
XFILLER_19_404 VDD VSS FILLER1
XFILLER_93_318 VDD VSS FILLER4
X_13951_ _13951_/A _13951_/B _13951_/C VDD VSS _13955_/B XNOR3X1
XFILLER_101_681 VSS VDD FILLER2
XFILLER_143_74 VDD VSS FILLER1
XFILLER_143_96 VDD VSS DECAPHV8
XFILLER_74_521 VDD VSS FILLER4
XFILLER_74_532 VDD VSS FILLER1
X_12902_ _18993_/Q _14254_/B VDD VSS _13198_/A AND2X1
XFILLER_46_256 VSS VDD FILLER2
XFILLER_47_768 VSS VDD FILLER2
X_13882_ _18947_/Q _14197_/B VDD VSS _13924_/A NAND2X1
X_16670_ _19704_/Q _16670_/B _16867_/B VDD VSS _16687_/A MIN3X1
X_12833_ _12951_/A _12951_/B VDD VSS _14509_/B XNOR2X1
X_15621_ _19439_/Q VDD VSS _15622_/A INVX1
XFILLER_15_632 VDD VSS FILLER1
XFILLER_15_654 VSS VDD FILLER2
XTAP_TAPCELL_ROW_72_733 VDD VSS WELLTAP
X_12764_ _12955_/A _12955_/B VDD VSS _12966_/B NAND2X1
X_18340_ _18343_/CK _18340_/D _18340_/Q _20072_/RB VDD VSS DFFRQX1
X_15552_ _15552_/A _15552_/B _15552_/C VDD VSS _15553_/B NOR3X1
XFILLER_70_782 VSS VDD FILLER2
XTAP_TAPCELL_ROW_44_457 VDD VSS WELLTAP
XTAP_TAPCELL_ROW_7_87 VDD VSS WELLTAP
X_11715_ _11724_/A _11724_/B _11724_/C VDD VSS _14519_/B OAI21X1
X_14503_ _15806_/A _14503_/B _14503_/C VDD VSS _19211_/D NOR3X1
X_18271_ _18272_/CK _18271_/D _18271_/Q _18485_/RB VDD VSS DFFRQX1
X_15483_ _15511_/A _15511_/B VDD VSS _15820_/B XNOR2X1
XTAP_TAPCELL_ROW_99_1006 VDD VSS WELLTAP
X_12695_ _12712_/A _12712_/B _12705_/C VDD VSS _14183_/B XNOR3X1
X_17222_ _19799_/Q _19767_/Q _17222_/C VDD VSS _17227_/A AOI21X1
XFILLER_52_93 VSS VDD FILLER2
X_11646_ _18787_/Q _11647_/B VDD VSS _18814_/D AND2X1
X_14434_ _14449_/A _14434_/B _14434_/C VDD VSS _19151_/D NOR3X1
XFILLER_128_545 VDD VSS DECAPHV16
XFILLER_7_842 VDD VSS FILLER1
XTAP_TAPCELL_ROW_0_9 VDD VSS WELLTAP
X_11577_ _18724_/Q _11578_/B VDD VSS _18751_/D AND2X1
X_14365_ _14415_/A _14365_/B VDD VSS _19089_/D AND2X1
X_17153_ _17156_/C _17154_/B _17164_/C VDD VSS _17154_/C OAI21X1
XFILLER_128_589 VDD VSS FILLER4
X_10528_ _10522_/Y _10528_/B _10527_/Y wire170/A VDD VSS _10579_/B AOI2B2BX1
X_13316_ _13316_/A _13316_/B _13316_/C _13316_/D VDD VSS _13318_/C OAI211X1
X_14296_ _17566_/A VDD VSS _14352_/A BUFX3
X_17084_ _19770_/Q _19738_/Q _17085_/C VDD VSS _17086_/B AOI21X1
X_16104_ _19682_/Q _16104_/B _16842_/B VDD VSS _16129_/B MIN3X1
X_13247_ _19220_/Q VDD VSS _13253_/A INVX1
X_16035_ _15999_/A _16035_/B _16035_/C VDD VSS _16060_/B AOI2B1X1
X_10459_ _10460_/A _10460_/B _10460_/D _10460_/C VDD VSS _10525_/B AOAI211X1
XFILLER_123_250 VDD VSS FILLER1
XFILLER_35_4 VDD VSS FILLER4
X_13178_ _13178_/A _13178_/B _13178_/C VDD VSS _14124_/B XNOR3X1
XFILLER_97_646 VDD VSS FILLER4
X_12129_ _12129_/A _12129_/B _14176_/B VDD VSS _12198_/B MIN3X1
X_17986_ _17984_/Y _17986_/B _17986_/C VDD VSS _19962_/D AND3BX1
XFILLER_111_478 VDD VSS DECAPHV16
XFILLER_84_307 VSS VDD FILLER2
X_19725_ _19736_/CK _19725_/D _19725_/Q VDD VSS DFFQX1
X_16937_ _16937_/A _16937_/B _16937_/C VDD VSS _16943_/C OAI21X1
XFILLER_37_212 VDD VSS FILLER1
XFILLER_77_370 VSS VDD FILLER2
XFILLER_26_919 VDD VSS DECAPHV8
XFILLER_92_351 VDD VSS FILLER4
X_19656_ _19703_/CK _19656_/D _19656_/Q VDD VSS DFFQX1
X_16868_ _16876_/A _16868_/B VDD VSS _19705_/D NOR2X1
XFILLER_37_267 VDD VSS FILLER4
XFILLER_92_384 VSS VDD FILLER2
X_19587_ _19673_/CK _19587_/D _19587_/Q VDD VSS DFFQX1
X_18607_ _18608_/CK _18607_/D _18607_/Q VDD VSS DFFQX1
X_16799_ _17391_/A VDD VSS _16811_/A BUFX3
X_15819_ _15849_/A _15819_/B VDD VSS _19434_/D AND2X1
X_09340_ _18444_/RB _09346_/B VDD VSS _09340_/Y NOR2BX1
X_18538_ _18550_/CK _18538_/D _18538_/Q VDD VSS DFFQX1
X_09271_ _18277_/Q _18276_/Q VDD VSS _09273_/B XNOR2X1
XTAP_TAPCELL_ROW_15_170 VDD VSS WELLTAP
X_18469_ _18471_/CK _18469_/D _18469_/Q _20075_/RB VDD VSS DFFRQX1
XFILLER_20_189 VDD VSS FILLER4
XFILLER_107_707 VDD VSS FILLER1
XFILLER_134_559 VDD VSS FILLER1
XFILLER_0_506 VSS VDD FILLER2
XFILLER_115_784 VDD VSS FILLER1
XFILLER_102_423 VDD VSS FILLER1
XFILLER_56_510 VDD VSS FILLER1
XFILLER_75_329 VSS VDD FILLER2
XFILLER_84_852 VDD VSS FILLER4
XFILLER_56_598 VDD VSS FILLER4
XFILLER_71_513 VDD VSS DECAPHV16
XTAP_TAPCELL_ROW_126_1279 VDD VSS WELLTAP
X_09607_ _20154_/A _09784_/B VDD VSS _09609_/C NAND2X1
X_09538_ _20032_/Q _09547_/B VDD VSS _20033_/D NOR2BX1
XFILLER_12_602 VSS VDD FILLER2
XTAP_TAPCELL_ROW_41_427 VDD VSS WELLTAP
X_09469_ _09496_/B VDD VSS _09490_/B BUFX3
X_11500_ _18654_/Q _11508_/B VDD VSS _18681_/D AND2X1
X_12480_ _12480_/A _14406_/B _12480_/C _12480_/D VDD VSS _12643_/A AOAI211X1
XFILLER_11_189 VSS VDD FILLER2
X_11431_ _11431_/A _11431_/B VDD VSS _18624_/D AND2X1
XFILLER_125_504 VDD VSS FILLER1
XFILLER_137_364 VDD VSS FILLER1
XFILLER_138_876 VDD VSS FILLER4
X_11362_ _11383_/A _11362_/B VDD VSS _18590_/D NOR2X1
X_14150_ _14154_/A _14150_/B VDD VSS _18906_/D NOR2X1
XTAP_TAPCELL_ROW_137_1386 VDD VSS WELLTAP
X_10313_ _11436_/C _10313_/B VDD VSS _10314_/B NOR2X1
X_13101_ _13101_/A _14384_/B VDD VSS _13161_/A OR2X2
XFILLER_98_45 VDD VSS FILLER1
XFILLER_98_56 VDD VSS FILLER1
X_11293_ _18583_/Q _11296_/C VDD VSS _11295_/B XOR2X1
X_14081_ wire153/Y _14086_/B _14086_/D _14086_/C VDD VSS _14174_/B OA211X2
X_10244_ _11436_/C _10358_/B _10358_/C VDD VSS _10550_/A OAI21X1
X_13032_ _13032_/A _13032_/B _13032_/C VDD VSS _13039_/B XNOR3X1
XFILLER_120_231 VDD VSS FILLER1
X_10175_ _11435_/B _10175_/B _11226_/D _10175_/D VDD VSS _10177_/B AOI2B2X1
X_17840_ _19935_/Q _17842_/C _17840_/C VDD VSS _19935_/D AOI21X1
XTAP_TAPCELL_ROW_49_505 VDD VSS WELLTAP
Xclkbuf_leaf_21__002_ clkload17/A VDD VSS _19963_/CK BUFX12
XFILLER_19_201 VDD VSS FILLER4
X_19510_ _19707_/CK _19510_/D _19510_/Q VDD VSS DFFQX1
Xfanout191 _09816_/D VDD VSS _09791_/A BUFX3
X_17771_ _17806_/A _17771_/B VDD VSS _19917_/D NOR2X1
X_14983_ _14992_/B _14983_/B VDD VSS _15713_/B XNOR2X1
XFILLER_47_565 VSS VDD FILLER2
XFILLER_47_60 VSS VDD FILLER2
XFILLER_90_800 VDD VSS DECAPHV8
XFILLER_93_159 VDD VSS FILLER1
X_13934_ _14167_/B _14167_/C _18920_/Q VDD VSS _13938_/B AOI21X1
X_16722_ _16722_/A _16724_/B VDD VSS _19573_/D NOR2X1
X_13865_ _13989_/A _13865_/B _13987_/C VDD VSS _13884_/C XNOR3X1
X_19441_ _19495_/CK _19441_/D _19441_/Q VDD VSS DFFQX1
X_16653_ _19576_/Q _19928_/Q VDD VSS _16654_/B XNOR2X1
XFILLER_62_546 VSS VDD FILLER2
XTAP_TAPCELL_ROW_57_582 VDD VSS WELLTAP
X_12816_ _12816_/A _12816_/B _12816_/C _12816_/D VDD VSS _13107_/A AOAI211X1
X_19372_ _19547_/CK _19372_/D _19372_/Q VDD VSS DFFQX1
X_15604_ _19411_/Q _15792_/B VDD VSS _15605_/B XNOR2X1
XTAP_TAPCELL_ROW_103_1043 VDD VSS WELLTAP
X_13796_ _19059_/Q _13831_/B _13850_/C VDD VSS _13846_/B XOR3X1
X_18323_ _18324_/CK _18499_/D _18323_/Q _18455_/RB VDD VSS DFFRQX1
X_16584_ _16585_/A _16585_/B _16585_/C VDD VSS _16620_/B OAI21X1
XFILLER_15_484 VDD VSS DECAPHV32
XFILLER_30_421 VDD VSS FILLER4
XFILLER_63_92 VDD VSS FILLER1
X_12747_ _12747_/A _14443_/B _14443_/C VDD VSS _12748_/D NOR3X1
X_15535_ _15532_/A _15535_/B VDD VSS _15564_/B NAND2BX1
XFILLER_8_32 VSS VDD FILLER2
X_12678_ _19242_/Q _12763_/A _12678_/C VDD VSS _12755_/D XNOR3X1
X_18254_ _18257_/CK _18254_/D _18263_/D _20079_/RB VDD VSS DFFRQX1
X_15466_ _19406_/Q _15787_/B _15466_/C VDD VSS _15525_/A AOI21X1
XFILLER_30_498 VDD VSS FILLER4
XFILLER_8_54 VSS VDD FILLER2
XFILLER_8_65 VSS VDD FILLER2
XTAP_TAPCELL_ROW_12_140 VDD VSS WELLTAP
X_11629_ _18771_/Q _11635_/B VDD VSS _18798_/D AND2X1
X_14417_ _14381_/Y _14417_/B _14417_/C VDD VSS _19137_/D AND3BX1
X_18185_ _18185_/A _18185_/B _18185_/C VDD VSS _18191_/C AO21X2
X_17205_ _17206_/A _17208_/C _17229_/C VDD VSS _17206_/C OAI21X1
XFILLER_129_876 VDD VSS FILLER1
XFILLER_7_650 VDD VSS FILLER1
X_17136_ _17140_/A _17137_/B _17164_/C VDD VSS _17137_/C OAI21X1
X_15397_ _19515_/Q VDD VSS _15398_/A INVX1
XFILLER_128_375 VDD VSS FILLER1
XFILLER_128_397 VSS VDD FILLER2
XFILLER_143_323 VSS VDD FILLER2
XFILLER_144_846 VDD VSS FILLER1
X_14348_ _14316_/Y _14348_/B _14348_/C VDD VSS _19075_/D AND3BX1
XFILLER_144_868 VDD VSS FILLER1
XFILLER_98_900 VDD VSS DECAPHV8
X_14279_ _14279_/A _14279_/B VDD VSS _14280_/B XNOR2X1
X_17067_ _17536_/A _17067_/B _17068_/C VDD VSS _19766_/D NOR3X1
XFILLER_40_2 VDD VSS FILLER1
X_16018_ _19674_/Q _16833_/B VDD VSS _16869_/B XNOR2X1
XFILLER_112_721 VSS VDD FILLER2
XFILLER_112_743 VSS VDD FILLER2
XFILLER_111_253 VDD VSS FILLER1
XFILLER_57_318 VSS VDD FILLER2
XFILLER_85_616 VSS VDD FILLER2
XFILLER_66_830 VDD VSS FILLER1
X_17969_ _18870_/Q _17969_/B VDD VSS _17971_/C XNOR2X1
XFILLER_38_532 VSS VDD FILLER2
X_19708_ _19711_/CK _19708_/D _19708_/Q VDD VSS DFFQX1
XFILLER_65_351 VDD VSS DECAPHV8
X_19639_ _19671_/CK _19639_/D _19639_/Q VDD VSS DFFQX1
XFILLER_40_207 VDD VSS FILLER4
XFILLER_43_18 VDD VSS FILLER1
X_09323_ _18289_/Q _18517_/Q _09299_/Y VDD VSS _09323_/Y MUXI2X1
XFILLER_139_607 VDD VSS FILLER1
XFILLER_34_793 VDD VSS FILLER4
XFILLER_61_590 VDD VSS FILLER1
XFILLER_139_629 VDD VSS DECAPHV8
X_09254_ _18279_/Q _09408_/C _09299_/A VDD VSS _09351_/B AOI21BX1
XFILLER_119_375 VDD VSS DECAPHV16
XFILLER_134_312 VDD VSS FILLER1
XFILLER_134_345 VDD VSS FILLER1
XFILLER_135_879 VSS VDD FILLER2
XFILLER_103_787 VDD VSS FILLER4
XFILLER_130_562 VSS VDD FILLER2
XFILLER_76_616 VDD VSS FILLER1
XFILLER_130_584 VDD VSS FILLER4
XFILLER_130_595 VDD VSS FILLER1
XFILLER_75_104 VDD VSS FILLER1
XFILLER_76_649 VDD VSS FILLER1
XFILLER_56_340 VDD VSS FILLER4
X_11980_ _19232_/Q _11980_/B _11980_/C VDD VSS _11985_/B XNOR3X1
XFILLER_16_215 VDD VSS FILLER4
XFILLER_17_41 VDD VSS FILLER4
X_10931_ _10931_/A _10931_/B _10931_/C _10931_/D VDD VSS _10932_/C AO211X2
XFILLER_140_20 VDD VSS DECAPHV8
XFILLER_16_248 VSS VDD FILLER2
XFILLER_56_384 VDD VSS FILLER1
XFILLER_56_395 VDD VSS DECAPHV8
XFILLER_140_75 VDD VSS FILLER1
XFILLER_17_96 VSS VDD FILLER2
XTAP_TAPCELL_ROW_54_552 VDD VSS WELLTAP
X_10862_ _10862_/A _10903_/C VDD VSS _10875_/D XNOR2X1
X_13650_ _13733_/A _13733_/B _13733_/D VDD VSS _13651_/C OAI21X1
XFILLER_12_421 VDD VSS FILLER4
XFILLER_13_944 VSS VDD FILLER2
XFILLER_25_782 VDD VSS DECAPHV8
XFILLER_71_387 VDD VSS FILLER1
XTAP_TAPCELL_ROW_26_276 VDD VSS WELLTAP
X_10793_ _10794_/A _10794_/B _10794_/D _10794_/C VDD VSS _10804_/C OAI211X1
X_12601_ _12894_/A _12894_/B _12894_/C VDD VSS _12717_/B OAI21X1
X_13581_ _13591_/A _13591_/B VDD VSS _14129_/C _13591_/C NAND3X1
XTAP_TAPCELL_ROW_139_1404 VDD VSS WELLTAP
X_12532_ _18877_/Q _12532_/B _12532_/C VDD VSS _17862_/A MIN3X1
X_15320_ _15364_/A _15364_/B VDD VSS _15845_/B XOR2X1
XFILLER_130_0 VDD VSS FILLER4
XFILLER_9_948 VSS VDD FILLER2
XTAP_TAPCELL_ROW_4_55 VDD VSS WELLTAP
X_12463_ _12593_/A _12593_/B VDD VSS _14377_/B XNOR2X1
X_15251_ _19373_/Q _15750_/B VDD VSS _15252_/B XNOR2X1
X_11414_ _11422_/A _17990_/B _11414_/C VDD VSS _18608_/D NOR3X1
X_14202_ _14219_/A _14202_/B _14202_/C VDD VSS _18951_/D NOR3X1
XFILLER_125_323 VDD VSS FILLER4
XFILLER_137_161 VDD VSS FILLER1
XFILLER_138_695 VSS VDD FILLER2
X_12394_ _12577_/A _12499_/B VDD VSS _14533_/B XNOR2X1
X_15182_ _15183_/A _15183_/B VDD VSS _15875_/B _15183_/C _15183_/D NAND4X2
X_11345_ _11357_/A _11345_/B _11345_/C _18588_/Q VDD VSS _11352_/B AOAI211X1
X_14133_ _14163_/A _14133_/B _14133_/C VDD VSS _18891_/D NOR3X1
X_19990_ _19992_/CK _19990_/D _19990_/Q VDD VSS DFFQX1
XFILLER_140_315 VDD VSS DECAPHV8
X_11276_ _11276_/A _11276_/B VDD VSS _11286_/A AND2X1
X_14064_ _18980_/Q _14236_/B VDD VSS _14065_/D NOR2BX1
X_18941_ _19001_/CK _18941_/D _18941_/Q VDD VSS DFFQX1
X_10227_ _10229_/A _10228_/B _17906_/C VDD VSS _10228_/C AOI21X1
X_13015_ _19106_/Q VDD VSS _13101_/A INVX1
XFILLER_121_540 VDD VSS FILLER1
X_18872_ _19197_/CK _18872_/D _18872_/Q VDD VSS DFFQX1
XFILLER_66_126 VDD VSS DECAPHV8
XFILLER_67_627 VDD VSS FILLER1
X_10158_ _11226_/D _10159_/B _10159_/C _18613_/Q VDD VSS _10172_/C AOI211X1
X_17823_ _17823_/A _17823_/B _17823_/C VDD VSS _17826_/A OA21X2
XFILLER_48_841 VDD VSS FILLER1
X_10089_ _18585_/Q _10089_/B VDD VSS _10113_/C NOR2BX1
X_17754_ _19913_/Q _19881_/Q _17754_/C VDD VSS _17758_/B MIN3X1
X_14966_ _14966_/A _14966_/B _14966_/C _15016_/A VDD VSS _15013_/A AOAI211X1
X_13917_ _18949_/Q _13936_/B _13957_/C VDD VSS _13993_/A XOR3X1
X_16705_ _19911_/Q _16726_/B VDD VSS _19559_/D AND2X1
XFILLER_35_557 VDD VSS FILLER1
XFILLER_63_866 VDD VSS FILLER4
X_19424_ _19461_/CK _19424_/D _19424_/Q VDD VSS DFFQX1
X_17685_ _19898_/Q _19866_/Q _17686_/C VDD VSS _17687_/B AOI21X1
X_14897_ _14897_/A _14899_/C VDD VSS _18073_/B XNOR2X1
XFILLER_23_708 VDD VSS FILLER1
XFILLER_35_568 VSS VDD FILLER2
X_13848_ _13903_/A _13903_/B VDD VSS _13951_/B NOR2X1
X_16636_ _16647_/B _16636_/B VDD VSS _16865_/B XOR2X1
XFILLER_16_782 VSS VDD FILLER2
XFILLER_22_229 VSS VDD FILLER2
XFILLER_62_398 VDD VSS FILLER4
X_13779_ _13779_/A _13779_/B _13779_/C VDD VSS _13781_/D NOR3X1
X_19355_ _19362_/CK _19355_/D _19355_/Q VDD VSS DFFQX1
X_16567_ _19700_/Q _16862_/B VDD VSS _16585_/A NOR2X1
X_19286_ _19290_/CK _19286_/D _19286_/Q VDD VSS DFFQX1
X_18306_ _18310_/CK _18498_/D _18306_/Q _20072_/RB VDD VSS DFFRQX1
X_15518_ _19464_/Q _15853_/B VDD VSS _15520_/C XOR2X1
XFILLER_30_251 VSS VDD FILLER2
XFILLER_30_273 VSS VDD FILLER2
X_18237_ _18240_/CK _18237_/D _18237_/Q _20079_/RB VDD VSS DFFRQX1
X_16498_ _19569_/Q _16717_/A _16498_/C VDD VSS _16525_/B MIN3X1
X_15449_ _15449_/A _15449_/B _15449_/C VDD VSS _15450_/B NOR3X1
XFILLER_129_684 VSS VDD FILLER2
X_18168_ _18166_/Y _18170_/B _18168_/C VDD VSS _20007_/D AND3BX1
XFILLER_117_868 VSS VDD FILLER2
XFILLER_144_665 VDD VSS DECAPHV8
X_18099_ _18173_/A _18099_/B VDD VSS _19994_/D NOR2X1
X_17119_ _19778_/Q _19746_/Q VDD VSS _17120_/B XOR2X1
XFILLER_144_698 VDD VSS FILLER4
X_09941_ _18560_/Q _18561_/Q _09941_/C _18562_/Q VDD VSS _09942_/B AOI31X1
X_20130_ _20130_/A VDD VSS _20130_/Y BUFX3
XFILLER_143_197 VDD VSS FILLER4
Xmax_cap188 _18514_/Q VDD VSS _18477_/D BUFX12
XFILLER_140_860 VDD VSS FILLER4
X_09872_ _18573_/Q _09872_/B VDD VSS _09872_/Y XOR2X1
X_20061_ clkload6/A _20061_/D _20061_/Q _20069_/RB VDD VSS DFFRQX1
XFILLER_100_713 VDD VSS DECAPHV8
XFILLER_140_882 VDD VSS FILLER1
XFILLER_85_424 VDD VSS FILLER1
XFILLER_97_262 VDD VSS FILLER4
XFILLER_97_273 VDD VSS FILLER4
XFILLER_100_768 VDD VSS FILLER1
XFILLER_85_468 VDD VSS DECAPHV16
XFILLER_38_351 VDD VSS DECAPHV8
XFILLER_72_118 VDD VSS DECAPHV16
XTAP_TAPCELL_ROW_68_699 VDD VSS WELLTAP
XTAP_TAPCELL_ROW_96_975 VDD VSS WELLTAP
XFILLER_14_708 VDD VSS FILLER4
XFILLER_26_557 VSS VDD FILLER2
XFILLER_53_354 VDD VSS FILLER1
XTAP_TAPCELL_ROW_123_1249 VDD VSS WELLTAP
XTAP_TAPCELL_ROW_51_522 VDD VSS WELLTAP
XTAP_TAPCELL_ROW_23_246 VDD VSS WELLTAP
X_09306_ _18455_/D _09305_/Y _09302_/Y VDD VSS _18524_/D MUXI2X1
XFILLER_139_448 VDD VSS DECAPHV16
X_09237_ _18513_/Q VDD VSS _18348_/D INVX1
XFILLER_119_10 VDD VSS FILLER1
XFILLER_21_284 VDD VSS FILLER1
XFILLER_108_813 VSS VDD FILLER2
XFILLER_135_621 VDD VSS DECAPHV16
XFILLER_108_868 VSS VDD FILLER2
XFILLER_135_654 VDD VSS DECAPHV16
XTAP_TAPCELL_ROW_134_1356 VDD VSS WELLTAP
XFILLER_119_98 VDD VSS FILLER1
XFILLER_123_827 VSS VDD FILLER2
X_11130_ _18681_/Q _18789_/Q VDD VSS _11132_/C XNOR2X1
X_11061_ _18759_/Q VDD VSS _11616_/A INVX1
XFILLER_0_177 VSS VDD FILLER2
XFILLER_48_104 VSS VDD FILLER2
XFILLER_49_649 VSS VDD FILLER2
XFILLER_76_413 VDD VSS FILLER4
X_10012_ _09876_/B _09887_/B _10166_/D VDD VSS _10012_/Y MUX2X1
XFILLER_48_137 VSS VDD FILLER2
X_14820_ _14865_/A _14865_/B _14865_/D VDD VSS _14833_/B OAI21X1
XFILLER_57_682 VDD VSS FILLER1
XFILLER_63_107 VSS VDD FILLER2
XFILLER_76_479 VSS VDD FILLER2
XFILLER_45_833 VDD VSS FILLER4
X_11963_ _11963_/A _12022_/B VDD VSS _11964_/C XNOR2X1
X_14751_ _19474_/Q _14751_/B _14751_/C VDD VSS _14837_/C XNOR3X1
XFILLER_60_803 VDD VSS FILLER1
XFILLER_60_814 VDD VSS DECAPHV8
X_10914_ _10624_/Y _10913_/Y _11120_/A VDD VSS _10921_/C MUXI2X1
X_11894_ _11922_/A _12035_/B _12035_/C VDD VSS _11912_/C OR3BX1
X_13702_ _19057_/Q _13781_/A _13781_/B VDD VSS _13733_/C XNOR3X1
X_14682_ _14739_/D _14710_/C VDD VSS _14739_/C NAND2X1
X_17470_ _19852_/Q _19820_/Q _17470_/C VDD VSS _17475_/C AO21X2
XFILLER_32_538 VSS VDD FILLER2
X_10845_ _11120_/A _10845_/B _10845_/C VDD VSS _10853_/B AOI21X1
X_13633_ _13637_/A _13637_/B _13637_/D _13637_/C VDD VSS _14453_/A AO211X2
X_16421_ _16421_/A _16421_/B VDD VSS _16422_/C NOR2X1
XTAP_TAPCELL_ROW_100_1013 VDD VSS WELLTAP
X_19140_ _19196_/CK _19140_/D _19140_/Q VDD VSS DFFQX1
X_16352_ _16352_/A _16352_/B _16352_/C VDD VSS _16353_/B OR3X2
XFILLER_8_200 VDD VSS DECAPHV8
X_10776_ _10746_/Y _10775_/Y _10843_/A VDD VSS _10776_/Y MUXI2X1
X_13564_ _19084_/Q _13564_/B _13696_/D VDD VSS _13728_/C XNOR3X1
X_15303_ _15303_/A _15303_/B _15751_/B VDD VSS _15343_/A MIN3X1
X_12515_ _12519_/B _12519_/C _12515_/C VDD VSS _12540_/B OA21X2
X_13495_ _13495_/A _13495_/B _14126_/B VDD VSS _13496_/B MIN3X1
X_19071_ _19126_/CK _19071_/D _19071_/Q VDD VSS DFFQX1
X_16283_ _16262_/B _16283_/B _16283_/C VDD VSS _16289_/A AOI2B1X1
X_12446_ _19068_/Q VDD VSS _12448_/A INVX1
X_18022_ _18532_/Q _18024_/B VDD VSS _18023_/B XNOR2X1
X_15234_ _19538_/Q _15270_/C VDD VSS _15237_/B NAND2X1
XFILLER_126_632 VDD VSS DECAPHV16
XFILLER_60_93 VDD VSS FILLER1
X_12377_ _12378_/A _12378_/B _12378_/D _12378_/C VDD VSS _12553_/B OAOI211X1
X_15165_ _15176_/B _15165_/B VDD VSS _15717_/B XNOR2X1
XFILLER_126_687 VSS VDD FILLER2
X_11328_ _11383_/A _11328_/B VDD VSS _18586_/D NOR2X1
X_14116_ _14118_/A _14116_/B VDD VSS _18876_/D NOR2X1
XFILLER_113_348 VDD VSS FILLER1
XFILLER_125_197 VSS VDD FILLER2
XFILLER_140_101 VDD VSS FILLER1
XFILLER_141_624 VSS VDD FILLER2
XFILLER_5_88 VDD VSS FILLER1
X_19973_ _19984_/CK _19973_/D _19973_/Q VDD VSS DFFQX1
Xclkbuf_leaf_4__000_ clkbuf_leaf_9__000_/A VDD VSS _19707_/CK BUFX12
X_15096_ _15145_/A _15145_/B _15099_/C VDD VSS _15100_/A OAI21X1
XFILLER_140_156 VDD VSS FILLER4
XFILLER_95_700 VDD VSS FILLER1
X_11259_ _18580_/Q _11262_/C VDD VSS _11261_/B XOR2X1
X_14047_ _18952_/Q _14068_/B _14047_/C VDD VSS _14061_/B XOR3X1
X_18924_ _19171_/CK _18924_/D _18924_/Q VDD VSS DFFQX1
XFILLER_79_262 VSS VDD FILLER2
X_18855_ _18888_/CK _18855_/D _18855_/Q VDD VSS DFFQX1
XFILLER_67_468 VDD VSS FILLER1
XFILLER_94_221 VSS VDD FILLER2
X_17806_ _17806_/A _17806_/B VDD VSS _19925_/D NOR2X1
XFILLER_36_822 VDD VSS FILLER1
XFILLER_48_671 VDD VSS DECAPHV8
X_18786_ _18811_/CK _18786_/D _18786_/Q VDD VSS DFFQX1
X_15998_ _19583_/Q _16732_/B VDD VSS _16035_/B XOR2X1
XTAP_TAPCELL_ROW_93_945 VDD VSS WELLTAP
X_17737_ _17738_/A _17738_/B _17738_/D _17738_/C VDD VSS _17740_/C AOI211X1
X_14949_ _15297_/A _18079_/B VDD VSS _19282_/D AND2X1
XTAP_TAPCELL_ROW_65_669 VDD VSS WELLTAP
X_17668_ _19895_/Q _19863_/Q VDD VSS _17670_/B XNOR2X1
X_19407_ _19435_/CK _19407_/D _19407_/Q VDD VSS DFFQX1
X_16619_ _19702_/Q _16864_/B VDD VSS _16620_/D NAND2BX1
XFILLER_50_335 VSS VDD FILLER2
XFILLER_93_0 VSS VDD FILLER2
X_19338_ _19551_/CK _19338_/D _19338_/Q VDD VSS DFFQX1
X_17599_ _19880_/Q VDD VSS _17748_/B INVX1
XTAP_TAPCELL_ROW_20_216 VDD VSS WELLTAP
X_19269_ _20005_/CK _19269_/D _19269_/Q VDD VSS DFFQX1
XFILLER_117_654 VDD VSS FILLER1
XFILLER_105_816 VDD VSS FILLER1
XFILLER_132_602 VSS VDD FILLER2
XFILLER_132_613 VDD VSS FILLER4
XFILLER_144_473 VSS VDD FILLER2
XFILLER_131_112 VDD VSS FILLER1
XFILLER_59_914 VDD VSS FILLER4
XFILLER_86_700 VDD VSS DECAPHV8
X_09924_ _09928_/C _09924_/B VDD VSS _09925_/C NAND2X1
X_20113_ _20113_/A VDD VSS _20113_/Y BUFX3
XFILLER_131_178 VDD VSS DECAPHV8
XFILLER_131_189 VDD VSS DECAPHV16
X_09855_ _18570_/Q _09855_/B VDD VSS _09858_/B NAND2X1
X_20044_ _20045_/CK _20044_/D _20044_/Q _20071_/RB VDD VSS DFFRQX1
Xclkbuf_1_1__f__09178_ clkbuf_0__09178_/Y VDD VSS _20043_/CK BUFX12
XFILLER_58_457 VDD VSS DECAPHV8
XFILLER_86_755 VDD VSS FILLER1
XFILLER_39_671 VDD VSS FILLER4
XFILLER_65_38 VDD VSS FILLER1
XFILLER_73_416 VSS VDD FILLER2
XFILLER_73_427 VDD VSS FILLER4
X_09786_ _20176_/A _09811_/B VDD VSS _09787_/D NAND2X1
XFILLER_38_181 VDD VSS FILLER1
XFILLER_85_298 VDD VSS FILLER1
XFILLER_121_22 VDD VSS DECAPHV16
XFILLER_26_387 VSS VDD FILLER2
XFILLER_27_899 VSS VDD FILLER2
XTAP_TAPCELL_ROW_36_371 VDD VSS WELLTAP
X_10630_ _10630_/A _10630_/B VDD VSS _10709_/A OR2X2
XFILLER_10_700 VSS VDD FILLER2
XFILLER_139_201 VDD VSS FILLER1
XFILLER_14_31 VDD VSS DECAPHV8
XFILLER_139_245 VSS VDD FILLER2
X_10561_ _10561_/A VDD VSS _10563_/C INVX1
X_10492_ _18689_/Q _18743_/Q VDD VSS _10525_/A NAND2X1
X_12300_ _12300_/A _12300_/B _12300_/C _12300_/D VDD VSS _12457_/A OAOI211X1
X_13280_ _13280_/A _13290_/C VDD VSS _14158_/B XNOR2X1
XFILLER_6_748 VSS VDD FILLER2
X_12231_ _19238_/Q _12231_/B _12397_/C VDD VSS _12391_/A XNOR3X1
XFILLER_107_131 VDD VSS DECAPHV8
XFILLER_5_269 VDD VSS DECAPHV8
XTAP_TAPCELL_ROW_1_23 VDD VSS WELLTAP
X_12162_ _12222_/A _14530_/B VDD VSS _12401_/A NOR2X1
X_11113_ _11226_/A _11113_/B _11113_/C VDD VSS _11114_/C OAI21X1
X_12093_ _12147_/A _12181_/B _12181_/E VDD VSS _12118_/B OA21X2
X_16970_ _16976_/A _16970_/B VDD VSS _19749_/D NOR2X1
XFILLER_122_189 VDD VSS FILLER1
XFILLER_89_571 VDD VSS FILLER1
XFILLER_89_593 VDD VSS DECAPHV16
X_11044_ _18705_/Q _18759_/Q VDD VSS _11045_/B XOR2X1
X_15921_ _19579_/Q _16728_/B _15921_/C VDD VSS _15936_/A OAI21X1
XFILLER_39_72 VSS VDD FILLER2
XFILLER_76_243 VDD VSS FILLER1
X_18640_ _19947_/CK _18640_/D _18640_/Q VDD VSS DFFQX1
XFILLER_36_107 VDD VSS DECAPHV16
XFILLER_49_468 VDD VSS FILLER1
X_15852_ _16795_/A VDD VSS _15879_/A BUFX3
X_12995_ _13171_/A _13171_/B _13171_/E VDD VSS _13083_/A OA21X2
X_18571_ _18571_/CK _18571_/D _18571_/Q VDD VSS DFFQX1
X_15783_ _15800_/A _15783_/B VDD VSS _19402_/D NOR2X1
X_14803_ _14850_/B _14803_/B VDD VSS _15677_/B XNOR2X1
XFILLER_18_866 VDD VSS FILLER4
XFILLER_45_663 VDD VSS DECAPHV8
XTAP_TAPCELL_ROW_90_915 VDD VSS WELLTAP
X_11946_ _12014_/A _12019_/C VDD VSS _11955_/C XNOR2X1
X_17522_ _17522_/A VDD VSS _17523_/C INVX1
X_14734_ _19445_/Q _14734_/B _14734_/C VDD VSS _14840_/A MIN3X1
XFILLER_17_365 VSS VDD FILLER2
XTAP_TAPCELL_ROW_62_639 VDD VSS WELLTAP
X_17453_ _17455_/C _17453_/B _17453_/C VDD VSS _19849_/D AOI21X1
X_11877_ _11884_/A _14490_/B _11979_/C VDD VSS _14492_/C OR3BX1
X_14665_ _19359_/Q _15734_/B VDD VSS _14694_/B NOR2X1
X_16404_ _19662_/Q _16820_/B VDD VSS _16406_/C XOR2X1
XFILLER_20_508 VSS VDD FILLER2
X_10828_ _10826_/Y wire170/Y _10828_/C VDD VSS _10838_/C AND3BX1
X_13616_ _13616_/A _13616_/B _13616_/C _13616_/D VDD VSS _13620_/B AOAI211X1
X_14596_ _14601_/A _14601_/B _14601_/D _14615_/B VDD VSS _14598_/B AOAI211X1
X_17384_ _19834_/Q _19802_/Q _17385_/C VDD VSS _17386_/B AOI21X1
X_10759_ _18670_/Q _18778_/Q VDD VSS _10801_/B AND2X1
X_13547_ _13640_/B _14420_/C _19139_/Q VDD VSS _13548_/D AND3BX1
X_19123_ _19124_/CK _19123_/D _19123_/Q VDD VSS DFFQX1
X_16335_ _19627_/Q _16781_/B _16335_/C VDD VSS _16345_/A AOI2B1X1
X_19054_ _19064_/CK _19054_/D _19054_/Q VDD VSS DFFQX1
X_16266_ _16267_/A _16267_/B _16267_/C VDD VSS _16296_/B OAI21X1
X_13478_ _14260_/B _14260_/C _18998_/Q VDD VSS _13511_/B AOI21X1
X_18005_ _18549_/Q _18057_/C _18550_/Q VDD VSS _18006_/B OA21X2
X_15217_ _15217_/A _15217_/B _15687_/B VDD VSS _15259_/B MIN3X1
X_12429_ _12429_/A _12429_/B _14147_/B VDD VSS _12527_/C MIN3X1
X_16197_ _16512_/A _16197_/B VDD VSS _19526_/D NOR2X1
XFILLER_126_495 VDD VSS DECAPHV16
XFILLER_5_781 VSS VDD FILLER2
X_15148_ _15904_/B VDD VSS _15149_/B INVX1
XFILLER_99_379 VDD VSS DECAPHV8
X_19956_ _19957_/CK _19956_/D _19956_/Q VDD VSS DFFQX1
X_15079_ _15297_/A _18094_/B VDD VSS _19285_/D AND2X1
XFILLER_101_329 VDD VSS DECAPHV8
XFILLER_113_178 VSS VDD FILLER2
XFILLER_113_189 VSS VDD FILLER2
XFILLER_68_700 VDD VSS DECAPHV16
X_18907_ _18936_/CK _18907_/D _18907_/Q VDD VSS DFFQX1
XFILLER_110_830 VSS VDD FILLER2
X_19887_ clkload7/A _19887_/D _19887_/Q VDD VSS DFFQX1
XFILLER_83_725 VDD VSS DECAPHV8
X_09640_ _18300_/Q _09797_/B _09813_/B _18460_/Q VDD VSS _09641_/D AOI22X1
X_18838_ _19958_/CK _18838_/D _18838_/Q VDD VSS DFFQX1
XFILLER_55_427 VDD VSS DECAPHV16
XFILLER_55_449 VDD VSS DECAPHV8
XFILLER_82_235 VSS VDD FILLER2
XTAP_TAPCELL_ROW_78_794 VDD VSS WELLTAP
X_09571_ _09814_/B VDD VSS _09811_/B BUFX3
X_18769_ _18797_/CK _18769_/D _18769_/Q VDD VSS DFFQX1
XFILLER_36_641 VSS VDD FILLER2
XFILLER_35_173 VDD VSS FILLER1
XFILLER_63_482 VDD VSS FILLER1
XFILLER_82_279 VDD VSS FILLER4
XTAP_TAPCELL_ROW_120_1219 VDD VSS WELLTAP
X_09962__232 _18259_/CK VDD VSS _18509_/CK INVX1
XFILLER_11_508 VDD VSS FILLER1
XFILLER_23_379 VSS VDD FILLER2
XTAP_TAPCELL_ROW_33_341 VDD VSS WELLTAP
Xclkbuf_0_clk_regs clkbuf_regs_0_clk/Y VDD VSS clkbuf_0_clk_regs/Y BUFX12
XFILLER_117_484 VDD VSS DECAPHV8
XFILLER_132_421 VDD VSS FILLER4
XTAP_TAPCELL_ROW_131_1326 VDD VSS WELLTAP
XFILLER_120_638 VSS VDD FILLER2
X_09907_ _09907_/A _10247_/A VDD VSS _09938_/A NOR2X1
XFILLER_58_221 VDD VSS FILLER1
XFILLER_76_26 VDD VSS FILLER4
XFILLER_100_351 VDD VSS FILLER1
XFILLER_59_777 VDD VSS FILLER1
X_09838_ _18563_/Q _10803_/A _09942_/A VDD VSS _09910_/A MIN3X1
X_20027_ _20045_/CK _20027_/D _20027_/Q _20031_/RB VDD VSS DFFRQX1
X_09769_ _20078_/Q _09770_/B _09769_/C _20094_/A _09769_/E VDD VSS _09776_/B AOI221X1
XFILLER_132_65 VSS VDD FILLER2
XTAP_TAPCELL_ROW_142_1433 VDD VSS WELLTAP
X_11800_ _11804_/A _11804_/B _11804_/C VDD VSS _14523_/C OR3X2
XFILLER_15_836 VDD VSS FILLER1
XFILLER_42_611 VSS VDD FILLER2
XFILLER_70_920 VSS VDD FILLER2
X_12780_ _12801_/A _12801_/B VDD VSS _12872_/B _12801_/C NAND3X1
X_11731_ _19172_/Q VDD VSS _11793_/A INVX1
XFILLER_25_85 VDD VSS DECAPHV8
XFILLER_41_143 VDD VSS FILLER1
X_11662_ _18801_/Q _11669_/B VDD VSS _18828_/D AND2X1
X_14450_ _17566_/A VDD VSS _14490_/A BUFX3
Xclkbuf_leaf_3__001_ clkbuf_leaf_5__001_/A VDD VSS _20013_/CK BUFX12
XFILLER_41_176 VDD VSS DECAPHV8
X_10613_ _10642_/A _10642_/B _10613_/C _10613_/D VDD VSS _10619_/C AO31X2
X_11593_ _18738_/Q _11600_/B VDD VSS _18765_/D AND2X1
X_13401_ _18970_/Q _13594_/A _13401_/C VDD VSS _13402_/D XNOR3X1
X_14381_ _18163_/A VDD VSS _14381_/Y BUFX3
XFILLER_128_716 VDD VSS FILLER4
XFILLER_128_727 VDD VSS DECAPHV8
X_10544_ _10544_/A _10544_/B _10544_/C _10544_/D VDD VSS _10592_/B AOAI211X1
X_13332_ _13443_/A _13443_/B _13443_/D _13443_/C VDD VSS _14449_/C AOI211X1
X_16120_ _16120_/A _16131_/B VDD VSS _16843_/B XNOR2X1
XFILLER_127_259 VDD VSS FILLER4
X_10475_ _18635_/Q _18797_/Q VDD VSS _10514_/A NAND2X1
X_13263_ _19221_/Q _13263_/B _13347_/C VDD VSS _13466_/B XNOR3X1
X_16051_ _16051_/A _16054_/B VDD VSS _16052_/B XOR2X1
XFILLER_123_421 VDD VSS DECAPHV8
XFILLER_135_270 VDD VSS FILLER4
X_12214_ _12214_/A _12214_/B _12214_/C _12214_/D VDD VSS _12382_/B AOAI211X1
X_13194_ _13295_/A _13295_/B _13295_/C _13295_/D VDD VSS _13391_/A AO31X2
X_15002_ _15054_/B _15836_/B _19451_/Q VDD VSS _15003_/D NAND3BX1
X_12145_ _12210_/A _12210_/B _12210_/C VDD VSS _12206_/A OAI21X1
X_19810_ clkload2/A _19810_/D _19810_/Q VDD VSS DFFQX1
XFILLER_111_605 VSS VDD FILLER2
XFILLER_123_498 VDD VSS DECAPHV16
XFILLER_1_294 VDD VSS FILLER1
XFILLER_77_541 VDD VSS FILLER1
X_12076_ _12076_/A _12076_/B _14306_/B VDD VSS _12077_/B MIN3X1
X_19741_ clkload3/A _19741_/D _19741_/Q VDD VSS DFFQX1
X_16953_ _19745_/Q _16978_/B _16953_/C VDD VSS _16956_/B MIN3X1
X_11027_ _11127_/A _11090_/A VDD VSS _11052_/A NAND2X1
X_19672_ _19703_/CK _19672_/D _19672_/Q VDD VSS DFFQX1
X_16884_ _16891_/A _16884_/B VDD VSS _19720_/D NOR2X1
X_15904_ _15906_/A _15904_/B VDD VSS _19510_/D NOR2X1
XFILLER_64_213 VDD VSS FILLER4
XFILLER_65_747 VDD VSS DECAPHV8
X_18623_ _18626_/CK _18623_/D _18623_/Q VDD VSS DFFQX1
X_15835_ _15849_/A _15835_/B VDD VSS _19450_/D AND2X1
XFILLER_64_235 VDD VSS DECAPHV8
XTAP_TAPCELL_ROW_75_764 VDD VSS WELLTAP
X_18554_ _18571_/CK _18554_/D _18554_/Q VDD VSS DFFQX1
XFILLER_18_696 VDD VSS FILLER1
XTAP_TAPCELL_ROW_47_488 VDD VSS WELLTAP
X_12978_ _18994_/Q _12978_/B _12996_/D VDD VSS _13198_/C XNOR3X1
X_17505_ _17505_/A _17507_/C _17505_/C VDD VSS _19860_/D AOI21X1
X_15766_ _15770_/A _15766_/B VDD VSS _19388_/D AND2X1
XTAP_TAPCELL_ROW_106_1074 VDD VSS WELLTAP
X_11929_ _12048_/A _12048_/B _12048_/C VDD VSS _11936_/B AOI21X1
X_18485_ _18487_/CK _18522_/Q _20130_/A _18485_/RB VDD VSS DFFRQX1
X_15697_ _15710_/A _15697_/B VDD VSS _19325_/D NOR2X1
X_14717_ _14775_/A _14775_/B VDD VSS _14734_/C XOR2X1
XFILLER_33_666 VDD VSS FILLER1
X_14648_ _19523_/Q _19524_/Q _19525_/Q _14649_/C VDD VSS _14742_/C AND4X2
Xclkbuf_leaf_22__000_ clkload79/A VDD VSS _19591_/CK BUFX12
X_17436_ _17439_/A _17436_/B _17436_/C VDD VSS _19845_/D AOI21X1
XANTENNA_17 _18127_/B VDD VSS ANTENNA2
XANTENNA_28 _20093_/A VDD VSS ANTENNA2
XANTENNA_39 _18173_/A VDD VSS ANTENNA2
XTAP_TAPCELL_ROW_30_311 VDD VSS WELLTAP
X_17367_ _19831_/Q _19799_/Q VDD VSS _17370_/B XNOR2X1
XFILLER_119_727 VDD VSS DECAPHV16
X_14579_ _19520_/Q _19519_/Q VDD VSS _15886_/B XOR2X1
X_19106_ _19121_/CK _19106_/D _19106_/Q VDD VSS DFFQX1
X_16318_ _19627_/Q _16781_/B VDD VSS _16320_/C XNOR2X1
X_17298_ _17298_/A _17300_/C _17298_/C VDD VSS _19816_/D AOI21X1
XFILLER_134_708 VDD VSS FILLER4
Xclkbuf_leaf_37__000_ clkload77/A VDD VSS _19492_/CK BUFX12
X_19037_ _19037_/CK _19037_/D _19037_/Q VDD VSS DFFQX1
X_16249_ _19720_/Q _16884_/B VDD VSS _16250_/C NOR2X1
XFILLER_114_421 VDD VSS DECAPHV8
XTAP_TAPCELL_ROW_117_1181 VDD VSS WELLTAP
Xoutput124 _20208_/Y VDD VSS o_uwb_tx_cfg[11] BUFX3
Xoutput113 _20182_/Y VDD VSS o_tst_ctrl[1] BUFX3
Xoutput102 _20171_/Y VDD VSS o_lf_cfg[8] BUFX3
Xoutput146 _20201_/Y VDD VSS o_uwb_tx_cfg[4] BUFX3
Xoutput135 _20218_/Y VDD VSS o_uwb_tx_cfg[21] BUFX3
XFILLER_114_476 VDD VSS FILLER1
XFILLER_141_262 VDD VSS DECAPHV8
X_19939_ _19940_/CK _19939_/D _19939_/Q VDD VSS DFFQX1
XTAP_TAPCELL_ROW_38_400 VDD VSS WELLTAP
X_09623_ _20200_/A _09797_/C _09769_/C _20085_/A _09623_/E VDD VSS _09636_/B AOI221X1
XFILLER_71_728 VDD VSS FILLER1
X_09554_ _18424_/Q VDD VSS _20049_/D INVX1
XFILLER_24_644 VDD VSS DECAPHV16
XFILLER_51_430 VSS VDD FILLER2
XFILLER_62_28 VDD VSS FILLER4
X_09485_ _09496_/C VDD VSS _09507_/B BUFX3
XFILLER_20_861 VSS VDD FILLER2
XFILLER_109_215 VDD VSS FILLER1
XFILLER_137_524 VSS VDD FILLER2
XFILLER_11_32 VSS VDD FILLER2
XFILLER_118_793 VDD VSS DECAPHV8
XFILLER_127_10 VDD VSS FILLER1
XFILLER_3_537 VDD VSS FILLER4
X_10260_ _18684_/Q _18738_/Q VDD VSS _10263_/B XOR2X1
XFILLER_11_87 VDD VSS FILLER4
XFILLER_127_76 VDD VSS DECAPHV8
XFILLER_79_806 VDD VSS FILLER1
XFILLER_79_828 VDD VSS DECAPHV8
X_10191_ _11226_/D _10191_/B _10191_/C VDD VSS _10193_/B AOI21X1
Xdelaybuf_1_clk delaybuf_1_clk/A VDD VSS _18232_/CK BUFX12
XFILLER_105_498 VDD VSS DECAPHV8
XFILLER_132_295 VDD VSS FILLER1
X_13950_ _18950_/Q VDD VSS _13991_/A INVX1
XFILLER_100_170 VDD VSS FILLER1
XFILLER_101_693 VSS VDD FILLER2
XFILLER_47_747 VDD VSS FILLER4
X_12901_ _13008_/A _12996_/B VDD VSS _14254_/B XNOR2X1
XFILLER_100_192 VDD VSS DECAPHV8
XFILLER_46_235 VDD VSS FILLER1
X_13881_ _18892_/Q _14134_/B VDD VSS _13978_/A AND2X1
X_15620_ _15620_/A _15620_/B _15620_/C _15620_/D VDD VSS _15644_/B AOAI211X1
XFILLER_27_460 VDD VSS FILLER4
XFILLER_36_51 VDD VSS FILLER1
XFILLER_61_205 VDD VSS DECAPHV8
X_12832_ _12832_/A _12832_/B _12832_/C _12835_/C VDD VSS _12951_/A AOAI211X1
XFILLER_14_121 VSS VDD FILLER2
XTAP_TAPCELL_ROW_72_734 VDD VSS WELLTAP
X_12763_ _12763_/A _12763_/B _12763_/C _12763_/D VDD VSS _12955_/B OAI211X1
X_15551_ _15552_/A _15552_/B _15552_/C VDD VSS _15599_/B OAI21X1
XTAP_TAPCELL_ROW_44_458 VDD VSS WELLTAP
XTAP_TAPCELL_ROW_7_88 VDD VSS WELLTAP
X_11714_ _19198_/Q _11714_/B _11714_/C VDD VSS _11728_/B MIN3X1
X_14502_ _17566_/A VDD VSS _15806_/A BUFX3
X_18270_ _18275_/CK _18270_/D _18270_/Q _20080_/RB VDD VSS DFFRQX1
X_15482_ _19463_/Q _15851_/B VDD VSS _15511_/B XNOR2X1
XFILLER_14_176 VDD VSS FILLER1
XFILLER_30_647 VDD VSS FILLER4
XFILLER_42_474 VDD VSS FILLER4
XTAP_TAPCELL_ROW_99_1007 VDD VSS WELLTAP
X_12694_ _18991_/Q _14251_/B _12713_/C VDD VSS _12705_/C XNOR3X1
X_14433_ _14449_/A _14433_/B _14433_/C VDD VSS _19150_/D NOR3X1
X_17221_ _17219_/B _17221_/B VDD VSS _17222_/C NOR2BX1
X_11645_ _18786_/Q _11647_/B VDD VSS _18813_/D AND2X1
X_11576_ _18723_/Q _11578_/B VDD VSS _18750_/D AND2X1
X_14364_ _14415_/A _14364_/B VDD VSS _19088_/D AND2X1
X_17152_ _19785_/Q _19753_/Q VDD VSS _17154_/B XOR2X1
XFILLER_10_393 VDD VSS FILLER1
X_10527_ _10563_/A _10563_/B VDD VSS _10527_/Y XNOR2X1
X_13315_ _13315_/A _13315_/B _13315_/C _13315_/D VDD VSS _13430_/B AOAI211X1
X_14295_ _14334_/A _14295_/B VDD VSS _19028_/D AND2X1
X_17083_ _19771_/Q _19739_/Q VDD VSS _17085_/C XOR2X1
X_16103_ _16099_/A _16103_/B _16103_/C VDD VSS _16126_/B AOI2B1X1
XFILLER_115_207 VDD VSS DECAPHV16
XFILLER_143_538 VDD VSS FILLER1
XFILLER_6_386 VDD VSS FILLER4
X_10458_ _10458_/A VDD VSS _10460_/C INVX1
X_13246_ _19220_/Q _14513_/B _14513_/C VDD VSS _13329_/D OR3BX1
X_16034_ _19583_/Q _16732_/B VDD VSS _16035_/C NOR2X1
XFILLER_124_741 VDD VSS FILLER4
X_10389_ _10427_/B _10389_/B VDD VSS _10390_/B XNOR2X1
X_13177_ _13177_/A _17894_/B VDD VSS _18856_/D NOR2X1
XFILLER_96_135 VDD VSS FILLER4
X_12128_ _18900_/Q _14143_/B VDD VSS _12197_/B NOR2X1
X_17985_ _17987_/A _17987_/B _17987_/C _17989_/A VDD VSS _17986_/B AOAI211X1
X_12059_ _12154_/A _12059_/B _12113_/C VDD VSS _12091_/C XNOR3X1
X_19724_ _19724_/CK _19724_/D _19724_/Q VDD VSS DFFQX1
X_16936_ _19742_/Q wire163/Y VDD VSS _16937_/C NAND2X1
XFILLER_37_224 VDD VSS DECAPHV16
XFILLER_38_747 VDD VSS DECAPHV8
XFILLER_77_382 VSS VDD FILLER2
XFILLER_65_555 VSS VDD FILLER2
XFILLER_65_566 VSS VDD FILLER2
X_19655_ _19736_/CK _19655_/D _19655_/Q VDD VSS DFFQX1
X_16867_ _16876_/A _16867_/B VDD VSS _19704_/D NOR2X1
XFILLER_65_577 VSS VDD FILLER2
XFILLER_80_514 VDD VSS DECAPHV8
X_19586_ _19678_/CK _19586_/D _19586_/Q VDD VSS DFFQX1
X_18606_ _18608_/CK _18606_/D _18606_/Q VDD VSS DFFQX1
X_16798_ _17906_/C VDD VSS _17391_/A BUFX3
X_15818_ _15830_/A _15818_/B VDD VSS _19433_/D NOR2X1
XFILLER_52_227 VDD VSS FILLER1
XFILLER_80_547 VSS VDD FILLER2
X_18537_ _18543_/CK _18537_/D _18537_/Q VDD VSS DFFQX1
X_15749_ _15758_/A _15749_/B VDD VSS _19372_/D NOR2X1
XFILLER_80_569 VDD VSS FILLER4
X_09270_ _20043_/RB _09349_/B VDD VSS _09270_/Y NOR2BX1
X_18468_ _18468_/CK _18500_/D _18468_/Q _20072_/RB VDD VSS DFFRQX1
XFILLER_21_636 VDD VSS FILLER1
X_17419_ _17420_/B _17419_/B VDD VSS _17421_/B NOR2BX1
XFILLER_20_135 VDD VSS FILLER1
XFILLER_21_669 VDD VSS DECAPHV8
X_18399_ _18400_/CK _18399_/D _18399_/Q _18444_/RB VDD VSS DFFRQX1
XTAP_TAPCELL_ROW_119_1210 VDD VSS WELLTAP
XFILLER_115_741 VSS VDD FILLER2
XFILLER_115_774 VSS VDD FILLER2
XFILLER_88_614 VSS VDD FILLER2
XFILLER_102_435 VDD VSS FILLER1
XFILLER_114_295 VSS VDD FILLER2
XFILLER_130_755 VDD VSS DECAPHV8
XFILLER_76_809 VDD VSS FILLER1
Xclkbuf_leaf_2__002_ clkbuf_leaf_9__002_/A VDD VSS _18820_/CK BUFX12
XFILLER_130_799 VDD VSS FILLER1
XFILLER_29_747 VDD VSS DECAPHV16
XFILLER_84_831 VDD VSS FILLER1
XFILLER_28_235 VDD VSS FILLER1
XFILLER_113_56 VDD VSS FILLER1
X_09606_ _18362_/Q VDD VSS _20199_/A INVX1
XFILLER_73_49 VDD VSS FILLER1
X_09537_ _18201_/A VDD VSS _09547_/B BUFX3
XFILLER_24_463 VDD VSS FILLER1
XFILLER_40_923 VSS VDD FILLER2
XFILLER_40_945 VDD VSS FILLER1
XTAP_TAPCELL_ROW_41_428 VDD VSS WELLTAP
X_09468_ _18448_/D _09468_/B _09468_/C VDD VSS _18249_/D AOI21X1
XFILLER_12_658 VDD VSS FILLER1
X_09399_ input3/Y _20051_/Q VDD VSS _09400_/A AND2X1
XFILLER_22_20 VDD VSS DECAPHV8
X_11430_ wire166/Y _11430_/B VDD VSS _18623_/D AND2X1
XFILLER_137_343 VSS VDD FILLER2
X_11361_ _11367_/B _11361_/B VDD VSS _11362_/B XNOR2X1
XFILLER_118_2 VDD VSS FILLER1
XTAP_TAPCELL_ROW_137_1387 VDD VSS WELLTAP
X_10312_ _10312_/A _10312_/B _10312_/C VDD VSS _10357_/B MIN3X1
X_13100_ _13415_/A _13415_/B VDD VSS _13201_/B NOR2X1
XFILLER_4_857 VDD VSS FILLER1
X_11292_ _11292_/A _11308_/B VDD VSS _11296_/C XNOR2X1
X_14080_ _18953_/Q _14204_/B VDD VSS _14174_/A NOR2BX1
XFILLER_140_508 VSS VDD FILLER2
X_10243_ _10314_/C _11430_/B _10383_/A VDD VSS _10358_/C OAI21X1
X_13031_ _13314_/A _13314_/B _13314_/C VDD VSS _13104_/B AOI21X1
XFILLER_120_210 VDD VSS DECAPHV8
X_10174_ _18614_/Q _10174_/B _10174_/C VDD VSS _10184_/A AOI21X1
XTAP_TAPCELL_ROW_49_506 VDD VSS WELLTAP
Xclkbuf_leaf_21__001_ clkbuf_2_3__f__001_/Y VDD VSS _18908_/CK BUFX12
X_17770_ _17773_/C _17770_/B VDD VSS _17771_/B XNOR2X1
XFILLER_59_371 VDD VSS FILLER1
Xfanout192 _18508_/Q VDD VSS _09816_/D BUFX3
X_16721_ _17803_/A _16724_/B VDD VSS _19572_/D NOR2X1
X_14982_ _19367_/Q _15743_/B VDD VSS _14983_/B XOR2X1
XFILLER_19_224 VSS VDD FILLER2
XFILLER_47_533 VDD VSS DECAPHV16
X_13933_ _18196_/A _17937_/A _17937_/B VDD VSS _18865_/D AND3BX1
XFILLER_35_728 VDD VSS FILLER1
XFILLER_62_514 VDD VSS DECAPHV8
XFILLER_75_886 VSS VDD FILLER2
XTAP_TAPCELL_ROW_85_870 VDD VSS WELLTAP
X_13864_ _18976_/Q _13955_/A _13998_/B VDD VSS _13987_/C XNOR3X1
X_19440_ _19495_/CK _19440_/D _19440_/Q VDD VSS DFFQX1
Xclkbuf_leaf_36__001_ clkbuf_2_1__f__001_/Y VDD VSS _19124_/CK BUFX12
X_16652_ _19575_/Q _16724_/A _16652_/C VDD VSS _16677_/C MIN3X1
XFILLER_74_396 VDD VSS FILLER1
XTAP_TAPCELL_ROW_57_583 VDD VSS WELLTAP
X_12815_ _19159_/Q _14443_/B _14443_/C VDD VSS _12816_/D OR3BX1
X_19371_ _19551_/CK _19371_/D _19371_/Q VDD VSS DFFQX1
X_16583_ _19701_/Q _16863_/B VDD VSS _16585_/C XNOR2X1
X_15603_ _15622_/B _15603_/B VDD VSS _15792_/B XNOR2X1
XFILLER_27_290 VDD VSS FILLER1
XFILLER_62_569 VDD VSS FILLER4
XFILLER_63_60 VDD VSS FILLER1
X_13795_ _19087_/Q _13857_/D _13854_/C VDD VSS _13850_/C XNOR3X1
X_18322_ _18324_/CK _18519_/Q _18322_/Q _18455_/RB VDD VSS DFFRQX1
X_15534_ _19324_/Q _15696_/B VDD VSS _15564_/A NAND2X1
XTAP_TAPCELL_ROW_103_1044 VDD VSS WELLTAP
X_12746_ _12771_/A _12771_/B _12771_/E _12746_/D VDD VSS _14443_/C OAOI211X1
XFILLER_30_433 VDD VSS FILLER4
XFILLER_42_293 VDD VSS FILLER4
X_12677_ _12677_/A _12677_/B _12677_/C VDD VSS _12755_/B XNOR3X1
X_18253_ _18257_/CK _18253_/D _18264_/D _20079_/RB VDD VSS DFFRQX1
X_15465_ _15465_/A _15465_/B VDD VSS _15466_/C NOR2X1
X_11628_ _18770_/Q _11635_/B VDD VSS _18797_/D AND2X1
X_14416_ _14449_/A _14416_/B _14416_/C VDD VSS _19136_/D NOR3X1
X_18184_ _18196_/A _18184_/B VDD VSS _20010_/D NOR2X1
X_17204_ _19795_/Q _19763_/Q _17204_/C VDD VSS _17208_/C MIN3X1
X_15396_ _15396_/A _15396_/B VDD VSS _15434_/A NAND2X1
XFILLER_116_505 VDD VSS FILLER1
XFILLER_7_640 VSS VDD FILLER2
X_14347_ _14368_/A _14347_/B VDD VSS _19074_/D NOR2X1
X_17135_ _17140_/C _17140_/B VDD VSS _17137_/B NAND2BX1
XFILLER_116_516 VDD VSS FILLER1
XFILLER_129_899 VSS VDD FILLER2
X_11559_ _18707_/Q _11567_/B VDD VSS _18734_/D AND2X1
XFILLER_116_549 VDD VSS FILLER1
XFILLER_144_858 VDD VSS FILLER1
XFILLER_6_194 VDD VSS FILLER1
X_14278_ _14278_/A _14278_/B VDD VSS _14279_/B XNOR2X1
X_17066_ _17062_/Y _17066_/B _17066_/C VDD VSS _17068_/C AOI2B1X1
XFILLER_143_379 VSS VDD FILLER2
XTAP_TAPCELL_ROW_114_1151 VDD VSS WELLTAP
X_13229_ _13315_/A _13315_/B _13315_/D _13315_/C VDD VSS _14416_/C AOI211X1
X_16017_ _19675_/Q _16834_/B VDD VSS _16022_/B XNOR2X1
XFILLER_100_917 VDD VSS FILLER1
XFILLER_111_232 VDD VSS FILLER4
XFILLER_57_308 VSS VDD FILLER2
XFILLER_58_809 VDD VSS FILLER1
XFILLER_85_628 VDD VSS DECAPHV16
X_17968_ _18869_/Q _17968_/B VDD VSS _17976_/A AND2X1
XFILLER_111_298 VDD VSS FILLER4
XFILLER_84_138 VDD VSS FILLER1
X_19707_ _19707_/CK _19707_/D _19707_/Q VDD VSS DFFQX1
X_17899_ _18858_/Q VDD VSS _17905_/A INVX1
X_16919_ _19739_/Q _17078_/B VDD VSS _16922_/B XOR2X1
XFILLER_38_566 VSS VDD FILLER2
XFILLER_65_363 VDD VSS FILLER1
XFILLER_66_886 VDD VSS DECAPHV8
XFILLER_93_661 VSS VDD FILLER2
X_19638_ _19671_/CK _19638_/D _19638_/Q VDD VSS DFFQX1
XFILLER_53_525 VDD VSS FILLER1
XFILLER_81_867 VDD VSS FILLER1
XFILLER_80_377 VDD VSS DECAPHV16
XFILLER_81_878 VDD VSS DECAPHV8
X_09322_ _18452_/RB _09346_/B VDD VSS _09322_/Y NOR2BX1
X_19569_ _19606_/CK _19569_/D _19569_/Q VDD VSS DFFQX1
X_09253_ _20048_/Q _09257_/C _20047_/Q VDD VSS _09299_/A AND3BX1
XFILLER_119_321 VDD VSS DECAPHV16
XFILLER_119_354 VDD VSS FILLER4
XFILLER_108_34 VSS VDD FILLER2
XFILLER_134_335 VDD VSS DECAPHV8
XFILLER_102_221 VDD VSS FILLER4
XFILLER_143_880 VDD VSS FILLER4
XFILLER_68_49 VDD VSS DECAPHV32
XFILLER_29_500 VDD VSS DECAPHV8
XFILLER_75_149 VDD VSS DECAPHV16
XFILLER_44_514 VDD VSS FILLER4
X_10930_ _10931_/A _10931_/B _10931_/D _10931_/C VDD VSS _10932_/B AOAI211X1
XFILLER_72_867 VSS VDD FILLER2
XTAP_TAPCELL_ROW_54_553 VDD VSS WELLTAP
XTAP_TAPCELL_ROW_82_840 VDD VSS WELLTAP
X_10861_ _11550_/A _11609_/A _10861_/C VDD VSS _10903_/C MIN3X1
X_12600_ _19017_/Q _12600_/B VDD VSS _12894_/C _12600_/C NAND3X1
XFILLER_12_400 VDD VSS FILLER4
XTAP_TAPCELL_ROW_26_277 VDD VSS WELLTAP
X_10792_ _18698_/Q _18752_/Q VDD VSS _10794_/D XOR2X1
X_13580_ _13661_/A _13580_/B _13580_/C VDD VSS _13591_/C XNOR3X1
XFILLER_12_444 VDD VSS FILLER4
XTAP_TAPCELL_ROW_139_1405 VDD VSS WELLTAP
X_12531_ _18878_/Q VDD VSS _17861_/A INVX1
XFILLER_129_118 VDD VSS FILLER1
XFILLER_12_466 VSS VDD FILLER2
XFILLER_8_415 VSS VDD FILLER2
X_12462_ _19128_/Q _12462_/B _12553_/C VDD VSS _12593_/B XOR3X1
X_15250_ _15262_/A _15262_/B VDD VSS _15750_/B XOR2X1
XFILLER_123_0 VSS VDD FILLER2
XFILLER_8_459 VDD VSS DECAPHV8
XTAP_TAPCELL_ROW_4_56 VDD VSS WELLTAP
X_11413_ _18535_/D _11428_/B VDD VSS _18607_/D NOR2BX1
X_14201_ _14231_/A _14201_/B VDD VSS _18950_/D AND2X1
XFILLER_126_825 VDD VSS DECAPHV8
X_12393_ _12474_/A _12474_/B _12474_/C _12474_/D VDD VSS _12566_/A AOI31X1
X_15181_ _19428_/Q VDD VSS _15204_/C INVX1
XFILLER_4_643 VDD VSS FILLER4
X_11344_ _11357_/A _11345_/B _18588_/Q _11345_/C VDD VSS _11352_/C AOI211X1
X_14132_ _14132_/A _14132_/B _14132_/C VDD VSS _14133_/C NOR3X1
XFILLER_106_560 VSS VDD FILLER2
XFILLER_4_665 VDD VSS DECAPHV16
X_11275_ _11271_/A _11275_/B _11275_/C VDD VSS _11285_/A AOI2B1X1
X_14063_ _14078_/A _14078_/B VDD VSS _14073_/B NOR2X1
X_18940_ _18970_/CK _18940_/D _18940_/Q VDD VSS DFFQX1
X_10226_ _10229_/C _10226_/B VDD VSS _10228_/B NAND2X1
X_13014_ _13270_/A _13270_/B _13270_/C VDD VSS _13069_/B AOI21X1
XFILLER_95_904 VDD VSS DECAPHV16
X_18871_ _19197_/CK _18871_/D _18871_/Q VDD VSS DFFQX1
XFILLER_121_574 VDD VSS FILLER1
XFILLER_48_820 VSS VDD FILLER2
XFILLER_79_488 VDD VSS DECAPHV8
XFILLER_94_403 VDD VSS DECAPHV8
XFILLER_95_948 VSS VDD FILLER2
X_10157_ _11226_/D _10222_/B VDD VSS _10159_/C NOR2X1
X_17822_ _19928_/Q _19896_/Q VDD VSS _17823_/C NAND2X1
X_10088_ _18608_/Q VDD VSS _10101_/A INVX1
X_17753_ _19914_/Q _19882_/Q VDD VSS _17758_/A XNOR2X1
X_14965_ _14963_/Y _14965_/B _15868_/B VDD VSS _15052_/A AND3BX1
XFILLER_47_341 VDD VSS DECAPHV8
XFILLER_48_897 VSS VDD FILLER2
XFILLER_81_108 VSS VDD FILLER2
X_13916_ _18977_/Q _13916_/B _13998_/D VDD VSS _13957_/C XNOR3X1
X_17684_ _19899_/Q _19867_/Q VDD VSS _17686_/C XOR2X1
X_16704_ _16704_/A _16704_/B VDD VSS _19558_/D NOR2X1
XFILLER_47_396 VDD VSS DECAPHV8
XFILLER_63_856 VDD VSS FILLER4
XFILLER_74_160 VDD VSS DECAPHV8
XFILLER_90_620 VDD VSS FILLER4
X_19423_ _19461_/CK _19423_/D _19423_/Q VDD VSS DFFQX1
X_16635_ _19671_/Q _16830_/B VDD VSS _16636_/B XNOR2X1
X_14896_ _14896_/A _14896_/B _15679_/B VDD VSS _14899_/C MIN3X1
X_13847_ _19031_/Q _14299_/B VDD VSS _13903_/A AND2X1
XFILLER_15_260 VDD VSS DECAPHV8
X_13778_ _13889_/A _13889_/B _13889_/C VDD VSS _13833_/B AOI21X1
X_19354_ _19362_/CK _19354_/D _19354_/Q VDD VSS DFFQX1
X_16566_ _19732_/Q _16566_/B _16897_/B VDD VSS _16589_/A MIN3X1
XFILLER_15_282 VSS VDD FILLER2
XFILLER_30_230 VSS VDD FILLER2
X_12729_ wire158/Y _12729_/B _12729_/C _12729_/D VDD VSS _14348_/C OAI211X1
X_19285_ _19290_/CK _19285_/D _19285_/Q VDD VSS DFFQX1
X_18305_ _18310_/CK _18465_/D _18305_/Q _18465_/RB VDD VSS DFFRQX1
X_16497_ _19921_/Q VDD VSS _16717_/A INVX1
X_15517_ _15547_/B _15517_/B VDD VSS _15853_/B XNOR2X1
XFILLER_30_241 VDD VSS FILLER1
XFILLER_31_786 VSS VDD FILLER2
X_18236_ _18241_/CK _18236_/D _18236_/Q _20079_/RB VDD VSS DFFRQX1
X_15448_ _15449_/A _15449_/B _15449_/C VDD VSS _15448_/Y OAI21X1
XFILLER_30_296 VDD VSS FILLER1
X_18167_ _18167_/A _18167_/B _18167_/C VDD VSS _18170_/B OAI21X1
X_15379_ _15386_/B _15379_/B VDD VSS _15691_/B XNOR2X1
XFILLER_128_195 VDD VSS FILLER4
XFILLER_143_132 VDD VSS FILLER1
XFILLER_144_633 VDD VSS DECAPHV32
X_18098_ _18100_/C _18098_/B VDD VSS _18099_/B XNOR2X1
X_17118_ _19777_/Q _19745_/Q _17118_/C VDD VSS _17121_/B MIN3X1
X_09940_ _10190_/B _09940_/B _09940_/C VDD VSS _09953_/B OAI21X1
Xmax_cap156 _13215_/A VDD VSS _13271_/A BUFX4
X_17049_ _19762_/Q _17049_/B _17064_/A _17064_/B VDD VSS _17050_/B AOAI211X1
X_20060_ clkload6/A _20060_/D _20061_/D _20069_/RB VDD VSS DFFRQX1
Xmax_cap189 _18511_/Q VDD VSS _18474_/D BUFX8
X_09871_ _18574_/Q _09871_/B VDD VSS _09871_/Y XNOR2X1
XFILLER_112_563 VDD VSS DECAPHV16
XFILLER_112_585 VDD VSS DECAPHV16
XFILLER_39_820 VDD VSS FILLER1
XFILLER_58_617 VDD VSS FILLER1
XFILLER_38_330 VDD VSS FILLER1
XFILLER_57_127 VSS VDD FILLER2
XFILLER_85_436 VDD VSS FILLER1
XFILLER_26_514 VDD VSS FILLER1
XFILLER_39_886 VDD VSS FILLER1
XTAP_TAPCELL_ROW_96_976 VDD VSS WELLTAP
XFILLER_38_385 VDD VSS FILLER1
XFILLER_54_29 VDD VSS FILLER1
XFILLER_93_480 VSS VDD FILLER2
XFILLER_26_569 VDD VSS FILLER4
XFILLER_41_539 VDD VSS FILLER4
XFILLER_81_686 VDD VSS DECAPHV8
XTAP_TAPCELL_ROW_51_523 VDD VSS WELLTAP
X_09305_ _18295_/Q _18523_/Q _09299_/Y VDD VSS _09305_/Y MUXI2X1
XFILLER_22_764 VSS VDD FILLER2
XTAP_TAPCELL_ROW_23_247 VDD VSS WELLTAP
X_09236_ _18477_/D VDD VSS _18349_/D INVX1
XFILLER_21_274 VDD VSS FILLER4
Xclkbuf_leaf_20__002_ clkbuf_leaf_9__002_/A VDD VSS _19949_/CK BUFX12
XFILLER_107_302 VDD VSS FILLER4
XFILLER_119_140 VDD VSS DECAPHV16
XFILLER_119_55 VDD VSS FILLER4
XFILLER_134_121 VDD VSS FILLER1
XTAP_TAPCELL_ROW_134_1357 VDD VSS WELLTAP
X_11060_ _18705_/Q VDD VSS _11556_/A INVX1
XFILLER_115_390 VDD VSS FILLER4
XFILLER_89_775 VDD VSS FILLER4
X_10011_ _10008_/B _10011_/B VDD VSS _10022_/B NOR2BX1
XFILLER_77_948 VSS VDD FILLER2
XFILLER_88_274 VDD VSS FILLER1
XTAP_TAPCELL_ROW_59_601 VDD VSS WELLTAP
X_20189_ _20189_/A VDD VSS _20189_/Y BUFX3
XFILLER_88_296 VDD VSS DECAPHV8
X_14750_ _14872_/B _14781_/D VDD VSS _14751_/C AND2X1
XFILLER_56_182 VDD VSS DECAPHV16
X_11962_ _11962_/A _11962_/B _14368_/B VDD VSS _12018_/A MIN3X1
X_13701_ _19057_/Q _14328_/B VDD VSS _13783_/A NOR2BX1
XFILLER_44_333 VDD VSS DECAPHV16
XFILLER_45_889 VSS VDD FILLER2
XFILLER_72_642 VDD VSS FILLER1
X_10913_ _10775_/Y _10912_/Y _11118_/A VDD VSS _10913_/Y MUXI2X1
X_11893_ _19175_/Q _14461_/B VDD VSS _11922_/A NAND2X1
X_14681_ _14681_/A _15892_/B VDD VSS _14710_/C NAND2X1
Xclkbuf_leaf_15_clk_regs clkload1/A VDD VSS clkload4/A BUFX12
XFILLER_44_388 VDD VSS DECAPHV8
X_10844_ _11118_/A _10844_/B _10844_/C _11120_/A VDD VSS _10845_/C AOI211X1
X_13632_ _13721_/A _13721_/B _13721_/E VDD VSS _13642_/B AOI21X1
X_16420_ _16399_/B _16420_/B _16420_/C VDD VSS _16453_/B AOI2B1X1
XTAP_TAPCELL_ROW_100_1014 VDD VSS WELLTAP
X_13563_ _19112_/Q _13714_/A _13721_/B VDD VSS _13696_/D XNOR3X1
X_16351_ _16352_/A _16352_/B _16352_/C VDD VSS _16388_/B OAI21X1
XFILLER_9_724 VSS VDD FILLER2
X_10775_ _10698_/Y _10774_/Y _10947_/A VDD VSS _10775_/Y MUXI2X1
X_12514_ _19043_/Q _12514_/B _12514_/C VDD VSS _12540_/A MIN3X1
X_19070_ _19126_/CK _19070_/D _19070_/Q VDD VSS DFFQX1
X_15302_ _19374_/Q VDD VSS _15303_/A INVX1
XFILLER_12_296 VSS VDD FILLER2
XFILLER_40_594 VSS VDD FILLER2
X_13494_ _13494_/A _13494_/B _14158_/B VDD VSS _14126_/B XNOR3X1
X_18021_ _18024_/B _18045_/B _18021_/C _18056_/C VDD VSS _19968_/D OAI31X1
X_16282_ _19593_/Q _16743_/B VDD VSS _16283_/C NOR2X1
XFILLER_8_267 VSS VDD FILLER2
X_12445_ _12515_/C _12519_/B _12519_/C VDD VSS _12510_/C NOR3X1
X_15233_ _15275_/A _15275_/B _15275_/C _15275_/D VDD VSS _15274_/A AO31X2
XFILLER_126_655 VDD VSS FILLER1
XFILLER_138_493 VDD VSS DECAPHV8
XFILLER_67_8 VDD VSS FILLER1
X_12376_ _12467_/A _12483_/A _12472_/B VDD VSS _12378_/C XNOR3X1
X_15164_ _19371_/Q _15748_/B VDD VSS _15165_/B XNOR2X1
XFILLER_113_305 VDD VSS DECAPHV8
XFILLER_5_23 VDD VSS FILLER4
X_11327_ _11333_/A _11327_/B VDD VSS _11328_/B XNOR2X1
X_14115_ _14118_/A _14115_/B VDD VSS _18875_/D NOR2X1
XFILLER_140_113 VSS VDD FILLER2
XFILLER_4_462 VDD VSS DECAPHV16
XFILLER_4_484 VDD VSS DECAPHV8
XFILLER_5_67 VSS VDD FILLER2
X_19972_ _19984_/CK _19972_/D _19972_/Q VDD VSS DFFQX1
X_15095_ _19481_/Q _15873_/B VDD VSS _15112_/D NAND2X1
XFILLER_122_850 VDD VSS FILLER4
XFILLER_140_146 VDD VSS FILLER1
XFILLER_69_92 VDD VSS FILLER1
XTAP_TAPCELL_ROW_111_1121 VDD VSS WELLTAP
X_11258_ _11258_/A _11264_/C VDD VSS _11262_/C XOR2X1
X_14046_ _14068_/A _14068_/C VDD VSS _14047_/C NOR2X1
X_18923_ _19171_/CK _18923_/D _18923_/Q VDD VSS DFFQX1
XFILLER_68_948 VSS VDD FILLER2
X_10209_ _10217_/A _10209_/B VDD VSS _11426_/C XNOR2X1
X_11189_ _11272_/A _11189_/B VDD VSS _18576_/D NOR2X1
X_18854_ _18888_/CK _18854_/D _18854_/Q VDD VSS DFFQX1
XFILLER_0_690 VDD VSS FILLER1
XFILLER_121_393 VDD VSS FILLER1
XFILLER_39_127 VDD VSS FILLER1
XFILLER_67_458 VDD VSS FILLER4
X_17805_ _17807_/C _17805_/B VDD VSS _17806_/B XNOR2X1
XFILLER_10_4 VSS VDD FILLER2
XFILLER_36_812 VDD VSS DECAPHV8
XFILLER_94_266 VSS VDD FILLER2
X_18785_ _18785_/CK _18785_/D _18785_/Q VDD VSS DFFQX1
X_15997_ _16038_/C _15997_/B VDD VSS _16732_/B XNOR2X1
XFILLER_36_834 VDD VSS FILLER1
XFILLER_48_694 VSS VDD FILLER2
XFILLER_94_288 VSS VDD FILLER2
XTAP_TAPCELL_ROW_93_946 VDD VSS WELLTAP
X_17736_ _19910_/Q _19878_/Q VDD VSS _17738_/D XNOR2X1
X_14948_ _14951_/B _14948_/B VDD VSS _18079_/B XNOR2X1
X_17667_ _17667_/A _17667_/B _17667_/C VDD VSS _17672_/A OA21X2
X_14879_ _19504_/Q _15898_/B VDD VSS _15015_/D XOR2X1
XFILLER_35_377 VDD VSS FILLER1
XFILLER_51_848 VSS VDD FILLER2
X_19406_ _19435_/CK _19406_/D _19406_/Q VDD VSS DFFQX1
X_17598_ _17598_/A _17600_/C _17598_/C VDD VSS _19880_/D AOI21X1
X_16618_ _16899_/B _19734_/Q VDD VSS _16643_/A NOR2BX1
XFILLER_16_580 VSS VDD FILLER2
XFILLER_62_185 VDD VSS FILLER4
X_19337_ _19337_/CK _19337_/D _19337_/Q VDD VSS DFFQX1
X_16549_ _19572_/Q _19924_/Q VDD VSS _16573_/A XOR2X1
XFILLER_31_561 VDD VSS DECAPHV16
XFILLER_86_0 VSS VDD FILLER2
XTAP_TAPCELL_ROW_20_217 VDD VSS WELLTAP
X_19268_ _20005_/CK _19268_/D _19268_/Q VDD VSS DFFQX1
XFILLER_129_460 VDD VSS FILLER1
X_19199_ _19988_/CK _19199_/D _19199_/Q VDD VSS DFFQX1
X_18219_ _18233_/CK _18219_/E _18219_/ECK VDD VSS CGX3
XFILLER_116_110 VSS VDD FILLER2
XFILLER_117_633 VDD VSS FILLER1
XFILLER_117_677 VDD VSS FILLER1
X_20112_ _20112_/A VDD VSS _20112_/Y BUFX3
X_09923_ _09912_/B _09922_/Y _10966_/A VDD VSS _09924_/B MUXI2X1
XFILLER_140_680 VDD VSS FILLER1
XFILLER_58_414 VDD VSS FILLER4
XFILLER_59_948 VSS VDD FILLER2
X_09854_ _09902_/B _09850_/Y _10966_/A VDD VSS _09862_/B MUXI2X1
X_20043_ _20043_/CK _20043_/D _20043_/Q _20043_/RB VDD VSS DFFRQX1
Xclkbuf_1_1__f__09177_ clkbuf_0__09177_/Y VDD VSS _18255_/CK BUFX12
XFILLER_98_594 VDD VSS FILLER1
XFILLER_105_79 VSS VDD FILLER2
XFILLER_58_469 VSS VDD FILLER2
X_09785_ _20151_/A _09785_/B _09815_/C _18325_/Q VDD VSS _09787_/C AOI22X1
XFILLER_26_344 VSS VDD FILLER2
XFILLER_14_506 VDD VSS FILLER1
XFILLER_14_528 VDD VSS FILLER1
XFILLER_81_483 VSS VDD FILLER2
XFILLER_81_38 VSS VDD FILLER2
XTAP_TAPCELL_ROW_36_372 VDD VSS WELLTAP
XFILLER_139_224 VDD VSS FILLER4
X_10560_ _18692_/Q _18746_/Q VDD VSS _10561_/A XNOR2X1
XFILLER_6_716 VDD VSS FILLER1
X_09219_ _18516_/Q VDD VSS _18399_/D INVX1
X_10491_ _10530_/A _10530_/B _10530_/C _10491_/D VDD VSS _10496_/C AOAI211X1
XFILLER_107_110 VDD VSS FILLER1
XFILLER_108_644 VSS VDD FILLER2
XFILLER_10_789 VDD VSS FILLER1
X_12230_ _20002_/Q _19266_/Q VDD VSS _12397_/C XOR2X1
XFILLER_107_154 VDD VSS DECAPHV8
XFILLER_108_666 VDD VSS FILLER1
XTAP_TAPCELL_ROW_1_24 VDD VSS WELLTAP
XFILLER_107_176 VDD VSS FILLER1
XFILLER_123_636 VDD VSS FILLER4
XFILLER_135_474 VSS VDD FILLER2
XFILLER_135_485 VDD VSS FILLER4
X_12161_ _12236_/A _12233_/C VDD VSS _14530_/B XOR2X1
XFILLER_122_146 VSS VDD FILLER2
X_11112_ _11196_/A _18734_/Q VDD VSS _11113_/C NAND2X1
X_12092_ _19151_/Q _14434_/B _14434_/C VDD VSS _12181_/E OR3BX1
XFILLER_39_51 VDD VSS DECAPHV8
XFILLER_77_723 VDD VSS FILLER1
X_11043_ _11002_/B _11043_/B _11043_/C VDD VSS _11062_/C AOI2B1X1
X_15920_ _15929_/A _15929_/B VDD VSS _15921_/C NAND2X1
XFILLER_77_767 VDD VSS FILLER1
X_15851_ _15867_/A _15851_/B VDD VSS _19463_/D NOR2X1
XFILLER_64_417 VDD VSS FILLER1
XFILLER_65_929 VDD VSS FILLER1
X_14802_ _19335_/Q _15707_/B VDD VSS _14803_/B XNOR2X1
XFILLER_18_834 VDD VSS FILLER1
X_12994_ _18966_/Q _12994_/B VDD VSS _13171_/E _12994_/C NAND3X1
X_18570_ _18571_/CK _18570_/D _18570_/Q VDD VSS DFFQX1
X_15782_ _15817_/A VDD VSS _15800_/A BUFX3
XFILLER_18_878 VDD VSS FILLER4
XFILLER_55_50 VDD VSS FILLER1
XFILLER_55_72 VSS VDD FILLER2
XFILLER_91_258 VDD VSS FILLER4
X_11945_ _19064_/Q _11945_/B _11953_/C VDD VSS _12019_/C MIN3X1
X_17521_ _19864_/Q _19832_/Q VDD VSS _17527_/A XNOR2X1
X_14733_ _14733_/A _14733_/B _15829_/B VDD VSS _14734_/B MIN3X1
XFILLER_17_388 VDD VSS DECAPHV16
XFILLER_45_675 VSS VDD FILLER2
XFILLER_55_83 VDD VSS FILLER1
XTAP_TAPCELL_ROW_90_916 VDD VSS WELLTAP
X_14664_ _14667_/B _14664_/B VDD VSS _15734_/B XNOR2X1
X_17452_ _17455_/C _17453_/B _17452_/C VDD VSS _17453_/C OAI21X1
XFILLER_44_196 VDD VSS FILLER4
X_11876_ _11876_/A _14524_/B VDD VSS _11884_/A OR2X2
X_13615_ _19111_/Q _14389_/B VDD VSS _13623_/D _14389_/C NAND3X1
X_16403_ _16429_/B _16403_/B VDD VSS _16820_/B NAND2BX1
XFILLER_13_550 VSS VDD FILLER2
XFILLER_32_369 VSS VDD FILLER2
XFILLER_60_689 VSS VDD FILLER2
X_10827_ _10861_/C _10827_/B VDD VSS _10828_/C NAND2X1
X_14595_ _19468_/Q _14595_/B _14595_/C VDD VSS _14608_/B MIN3X1
X_17383_ _19835_/Q _19803_/Q VDD VSS _17385_/C XOR2X1
XFILLER_41_892 VSS VDD FILLER2
XFILLER_9_521 VSS VDD FILLER2
X_10758_ _18670_/Q _18778_/Q VDD VSS _10801_/D OR2X2
X_13546_ _13546_/A _13546_/B _13546_/C _13546_/D VDD VSS _14420_/C OAI211X1
X_19122_ _19124_/CK _19122_/D _19122_/Q VDD VSS DFFQX1
X_16334_ _19659_/Q _16817_/B VDD VSS _16348_/D NOR2X1
X_13477_ _13509_/A _13509_/C _13509_/B VDD VSS _14260_/C AO21X2
X_19053_ _19064_/CK _19053_/D _19053_/Q VDD VSS DFFQX1
X_16265_ _19657_/Q _16815_/B VDD VSS _16267_/C XNOR2X1
X_10689_ _10715_/A _10689_/B VDD VSS _10695_/D XNOR2X1
X_12428_ _18932_/Q _12438_/B _14180_/B VDD VSS _14148_/B XNOR3X1
X_18004_ _18549_/Q _18057_/C _18550_/Q VDD VSS _18058_/B AOI21X1
X_15216_ _19316_/Q VDD VSS _15217_/A INVX1
XFILLER_114_603 VDD VSS FILLER1
X_16196_ _16196_/A _16199_/B VDD VSS _16197_/B XOR2X1
XFILLER_114_625 VDD VSS FILLER4
XFILLER_99_303 VDD VSS DECAPHV8
X_12359_ _12421_/A _12457_/A _12544_/B VDD VSS _12452_/D XNOR3X1
X_15147_ _19537_/Q _15186_/B VDD VSS _15904_/B XOR2X1
X_19955_ _19957_/CK _19955_/D _19955_/Q VDD VSS DFFQX1
X_15078_ _15080_/B _15078_/B VDD VSS _18094_/B XNOR2X1
X_14029_ _14038_/A _14169_/B _14054_/C VDD VSS _14170_/C NOR3X1
X_18906_ _18936_/CK _18906_/D _18906_/Q VDD VSS DFFQX1
XFILLER_67_233 VSS VDD FILLER2
X_19886_ clkload8/A _19886_/D _19886_/Q VDD VSS DFFQX1
XFILLER_68_778 VDD VSS FILLER1
XFILLER_96_90 VSS VDD FILLER2
X_18837_ _19958_/CK _18837_/D _18837_/Q VDD VSS DFFQX1
XTAP_TAPCELL_ROW_78_795 VDD VSS WELLTAP
X_09570_ _18506_/Q _18505_/Q _09630_/C VDD VSS _09814_/B AND3BX1
X_18768_ _18768_/CK _18768_/D _18768_/Q VDD VSS DFFQX1
X_17719_ _17718_/B _17719_/B VDD VSS _17721_/C NOR2BX1
XFILLER_63_472 VDD VSS FILLER1
X_18699_ _18779_/CK _18699_/D _18699_/Q VDD VSS DFFQX1
XFILLER_35_185 VDD VSS FILLER1
XFILLER_35_196 VDD VSS DECAPHV8
XFILLER_50_133 VDD VSS FILLER4
XTAP_TAPCELL_ROW_33_342 VDD VSS WELLTAP
XFILLER_136_205 VDD VSS DECAPHV8
XFILLER_137_728 VDD VSS FILLER1
XFILLER_31_391 VDD VSS DECAPHV8
XFILLER_117_452 VDD VSS FILLER4
XFILLER_117_474 VDD VSS FILLER1
XFILLER_144_282 VDD VSS FILLER1
XTAP_TAPCELL_ROW_131_1327 VDD VSS WELLTAP
XFILLER_105_669 VSS VDD FILLER2
XFILLER_116_56 VSS VDD FILLER2
XFILLER_120_617 VSS VDD FILLER2
X_09906_ _10032_/A _09929_/B _09944_/A VDD VSS _09915_/C OAI21X1
XFILLER_101_842 VDD VSS FILLER1
XFILLER_113_691 VDD VSS FILLER4
XFILLER_132_499 VDD VSS FILLER4
XFILLER_58_211 VDD VSS DECAPHV8
XFILLER_76_49 VDD VSS DECAPHV16
X_20026_ _20045_/CK _20026_/D _20026_/Q _20031_/RB VDD VSS DFFRQX1
XFILLER_86_575 VDD VSS FILLER1
X_09837_ _18560_/Q _18561_/Q _18562_/Q _09941_/C VDD VSS _09942_/A AND4X2
XFILLER_100_385 VDD VSS FILLER4
XFILLER_132_33 VDD VSS FILLER4
XFILLER_132_44 VSS VDD FILLER2
XFILLER_46_439 VSS VDD FILLER2
XFILLER_73_203 VDD VSS FILLER4
XFILLER_73_214 VDD VSS FILLER1
X_09768_ _18372_/Q _09772_/B _09768_/C _09768_/D VDD VSS _09769_/E OAI211X1
XFILLER_92_26 VSS VDD FILLER2
XFILLER_26_152 VDD VSS FILLER4
XFILLER_27_697 VSS VDD FILLER2
XFILLER_54_461 VDD VSS FILLER4
XFILLER_82_781 VDD VSS FILLER1
XTAP_TAPCELL_ROW_142_1434 VDD VSS WELLTAP
X_09699_ _20073_/Q _09818_/B _09813_/C _09699_/D _09699_/E VDD VSS _09700_/B AOI221X1
X_11730_ _19143_/Q _14425_/B VDD VSS _11758_/B NOR2X1
XFILLER_14_336 VDD VSS FILLER4
XFILLER_25_64 VDD VSS FILLER1
X_11661_ _18800_/Q _11669_/B VDD VSS _18827_/D AND2X1
Xclkbuf_leaf_3__000_ clkbuf_leaf_9__000_/A VDD VSS _19543_/CK BUFX12
X_10612_ _10642_/A _10642_/B _10613_/C _11195_/A VDD VSS _10613_/D AOAI211X1
X_11592_ _18737_/Q _11600_/B VDD VSS _18764_/D AND2X1
X_13400_ _18969_/Q _13400_/B VDD VSS _13402_/C _13400_/C NAND3X1
X_14380_ _14393_/A _14380_/B VDD VSS _19103_/D NOR2X1
X_10543_ _10544_/A _10544_/B _10544_/D _10544_/C VDD VSS _10543_/Y AOI211X1
X_13331_ _13331_/A _13331_/B _13331_/C _13331_/D VDD VSS _14449_/B OAOI211X1
XFILLER_10_575 VDD VSS FILLER4
XFILLER_10_586 VDD VSS DECAPHV16
X_16050_ _19712_/Q _16875_/B VDD VSS _16054_/B XOR2X1
X_10474_ _18556_/Q _10474_/B _10474_/C VDD VSS _10544_/A AO21X2
X_13262_ _19249_/Q _13262_/B _13345_/D VDD VSS _13347_/C XNOR3X1
X_15001_ _15054_/B _15836_/B _19451_/Q VDD VSS _15003_/C AOI2B1X1
XFILLER_124_945 VDD VSS FILLER4
X_12213_ _19153_/Q _12213_/B _12214_/D VDD VSS _12372_/B XNOR3X1
X_13193_ _14219_/C _18968_/Q _13395_/B VDD VSS _13295_/D AND3BX1
X_12144_ _19096_/Q _14373_/B VDD VSS _12210_/C _14373_/C NAND3X1
XFILLER_110_105 VDD VSS FILLER1
XFILLER_96_328 VDD VSS DECAPHV8
X_19740_ clkload4/A _19740_/D _19740_/Q VDD VSS DFFQX1
XFILLER_104_680 VDD VSS DECAPHV8
XFILLER_110_127 VDD VSS DECAPHV8
X_12075_ _12080_/A _12080_/B _12075_/C VDD VSS _14306_/B XNOR3X1
X_16952_ _19746_/Q _16978_/B VDD VSS _16954_/A XOR2X1
X_11026_ _10996_/A _11026_/B _11026_/C VDD VSS _11090_/A OR3BX1
X_19671_ _19671_/CK _19671_/D _19671_/Q VDD VSS DFFQX1
X_16883_ _16899_/A _16883_/B VDD VSS _19719_/D AND2X1
X_15903_ _15906_/A _15903_/B VDD VSS _19509_/D NOR2X1
XFILLER_92_534 VDD VSS DECAPHV16
X_18622_ _18622_/CK _18622_/D _18622_/Q VDD VSS DFFQX1
X_15834_ _14522_/Y _15834_/B _15834_/C VDD VSS _19449_/D AND3BX1
XFILLER_92_556 VDD VSS FILLER1
X_18553_ _18565_/CK _18553_/D _18553_/Q VDD VSS DFFQX1
XFILLER_73_770 VDD VSS FILLER4
XFILLER_80_718 VDD VSS FILLER1
XFILLER_92_589 VDD VSS FILLER1
XTAP_TAPCELL_ROW_47_489 VDD VSS WELLTAP
XTAP_TAPCELL_ROW_75_765 VDD VSS WELLTAP
X_12977_ _19022_/Q _13095_/A _13270_/B VDD VSS _12996_/D XNOR3X1
X_17504_ _17505_/A _17507_/C _17509_/C VDD VSS _17505_/C OAI21X1
X_15765_ _15780_/A _15765_/B VDD VSS _19387_/D NOR2X1
XTAP_TAPCELL_ROW_106_1075 VDD VSS WELLTAP
X_11928_ _14526_/A _14526_/B _11981_/C VDD VSS _12048_/C AOI21X1
X_18484_ _18487_/CK _18500_/D _20129_/A _18496_/RB VDD VSS DFFRQX1
X_15696_ _15706_/A _15696_/B VDD VSS _19324_/D AND2X1
X_14716_ _19473_/Q _14781_/A _14781_/B VDD VSS _14775_/B XNOR3X1
XFILLER_32_133 VDD VSS FILLER4
XFILLER_33_689 VDD VSS DECAPHV16
XFILLER_60_442 VDD VSS FILLER1
X_11859_ _19035_/Q _14303_/B VDD VSS _11954_/B NOR2X1
X_14647_ _19497_/Q _14655_/B VDD VSS _14652_/C AND2X1
X_17435_ _17439_/A _17436_/B _17452_/C VDD VSS _17436_/C OAI21X1
XANTENNA_18 _18127_/B VDD VSS ANTENNA2
XANTENNA_29 _11435_/A VDD VSS ANTENNA2
XFILLER_14_881 VSS VDD FILLER2
XFILLER_60_486 VDD VSS FILLER1
XTAP_TAPCELL_ROW_30_312 VDD VSS WELLTAP
X_14578_ _19521_/Q _19494_/Q _14578_/C VDD VSS _14584_/B XOR3X1
X_17366_ _17366_/A _17366_/B _17366_/C VDD VSS _17372_/A OA21X2
X_13529_ _19083_/Q _13696_/A _13696_/B VDD VSS _13531_/C XNOR3X1
X_19105_ _19129_/CK _19105_/D _19105_/Q VDD VSS DFFQX1
X_16317_ _16317_/A _16337_/B VDD VSS _16781_/B XNOR2X1
X_17297_ _17298_/A _17300_/C _17306_/C VDD VSS _17298_/C OAI21X1
X_19036_ _19037_/CK _19036_/D _19036_/Q VDD VSS DFFQX1
X_16248_ _16512_/A _16248_/B VDD VSS _19528_/D NOR2X1
XTAP_TAPCELL_ROW_117_1182 VDD VSS WELLTAP
Xoutput125 _20209_/Y VDD VSS o_uwb_tx_cfg[12] BUFX3
Xoutput114 _20183_/Y VDD VSS o_tst_ctrl[2] BUFX3
Xoutput103 _20172_/Y VDD VSS o_lf_cfg[9] BUFX3
X_16179_ _16179_/A _16179_/B _16774_/B VDD VSS _16205_/B MIN3X1
XFILLER_114_433 VDD VSS FILLER1
XFILLER_49_0 VDD VSS DECAPHV8
XFILLER_5_590 VDD VSS FILLER1
Xoutput147 _20202_/Y VDD VSS o_uwb_tx_cfg[5] BUFX3
Xoutput136 _20219_/Y VDD VSS o_uwb_tx_cfg[22] BUFX3
XFILLER_102_617 VDD VSS FILLER1
XFILLER_88_829 VDD VSS FILLER1
XFILLER_130_948 VSS VDD FILLER2
XFILLER_68_531 VSS VDD FILLER2
XFILLER_87_339 VDD VSS FILLER4
X_19938_ _19940_/CK _19938_/D _19938_/Q VDD VSS DFFQX1
XFILLER_68_553 VDD VSS FILLER4
XFILLER_68_575 VDD VSS DECAPHV8
X_19869_ _19903_/CK _19869_/D _19869_/Q VDD VSS DFFQX1
XFILLER_110_683 VDD VSS FILLER1
XFILLER_28_439 VDD VSS FILLER1
XFILLER_56_737 VDD VSS FILLER1
XFILLER_95_394 VSS VDD FILLER2
X_09622_ _18427_/Q _09696_/B VDD VSS _09623_/E NOR2X1
X_09553_ _18456_/Q VDD VSS _20098_/A INVX1
XFILLER_83_589 VDD VSS DECAPHV16
X_09484_ _09496_/C VDD VSS _09501_/B BUFX3
XFILLER_24_678 VDD VSS FILLER4
XFILLER_51_464 VDD VSS FILLER1
XTAP_TAPCELL_ROW_18_191 VDD VSS WELLTAP
XFILLER_51_497 VDD VSS DECAPHV16
XFILLER_105_411 VDD VSS FILLER1
XFILLER_118_783 VSS VDD FILLER2
XFILLER_124_219 VDD VSS DECAPHV8
XFILLER_3_505 VDD VSS FILLER1
XFILLER_105_444 VDD VSS DECAPHV16
X_10190_ _11435_/B _10190_/B _10190_/C VDD VSS _10191_/C NOR3X1
XFILLER_133_786 VDD VSS DECAPHV16
XFILLER_87_840 VSS VDD FILLER2
XFILLER_101_683 VDD VSS FILLER1
XFILLER_46_214 VSS VDD FILLER2
XFILLER_87_884 VSS VDD FILLER2
X_09969__239 _20081_/CK VDD VSS _18516_/CK INVX1
X_12900_ _12900_/A _12900_/B _12900_/C _12900_/D VDD VSS _13008_/A OAOI211X1
X_13880_ _13938_/A _13981_/B VDD VSS _14134_/B XNOR2X1
X_20009_ _20013_/CK _20009_/D _20009_/Q VDD VSS DFFQX1
XFILLER_46_247 VDD VSS FILLER1
X_12831_ _19243_/Q _14537_/B _14537_/C VDD VSS _12835_/C OR3BX1
XFILLER_61_217 VSS VDD FILLER2
XFILLER_54_280 VDD VSS FILLER1
XTAP_TAPCELL_ROW_72_735 VDD VSS WELLTAP
X_12762_ _20007_/Q _19271_/Q VDD VSS _12955_/A NAND2X1
X_15550_ _19437_/Q _15822_/B VDD VSS _15552_/C XOR2X1
XFILLER_15_678 VDD VSS FILLER4
XFILLER_70_751 VSS VDD FILLER2
XTAP_TAPCELL_ROW_44_459 VDD VSS WELLTAP
XTAP_TAPCELL_ROW_7_89 VDD VSS WELLTAP
X_11713_ _19197_/Q _14484_/B VDD VSS _11714_/B OR2X2
X_12693_ _12693_/A _12693_/B _14250_/B VDD VSS _12713_/C MIN3X1
X_14501_ _14539_/A _14501_/B VDD VSS _19210_/D NOR2X1
X_15481_ _15512_/B _15481_/B VDD VSS _15851_/B XNOR2X1
XFILLER_14_166 VDD VSS DECAPHV8
XFILLER_42_486 VDD VSS DECAPHV16
XFILLER_70_784 VDD VSS FILLER1
X_11644_ _18785_/Q _11647_/B VDD VSS _18812_/D AND2X1
X_14432_ _14456_/A _14432_/B VDD VSS _19149_/D NOR2X1
X_17220_ _17390_/A _17220_/B VDD VSS _19799_/D NOR2X1
XFILLER_11_840 VSS VDD FILLER2
XFILLER_128_503 VDD VSS FILLER1
XFILLER_52_84 VDD VSS FILLER4
XTAP_TAPCELL_ROW_99_1008 VDD VSS WELLTAP
X_17151_ _17300_/B _17151_/B _17151_/C VDD VSS _17156_/C MIN3X1
XFILLER_11_862 VDD VSS DECAPHV8
XFILLER_128_514 VDD VSS FILLER1
XFILLER_128_525 VDD VSS FILLER1
XFILLER_7_811 VDD VSS DECAPHV8
X_11575_ _18722_/Q _11578_/B VDD VSS _18749_/D AND2X1
X_14363_ _14363_/A _14363_/B _15836_/C VDD VSS _19087_/D OA21X2
X_16102_ _19714_/Q _16878_/B VDD VSS _16103_/C NOR2X1
X_10526_ _18691_/Q _18745_/Q VDD VSS _10563_/B XOR2X1
X_13314_ _13314_/A _13314_/B _13314_/C _13314_/D VDD VSS _13319_/B AOAI211X1
X_14294_ _14294_/A _14294_/B _14294_/C VDD VSS _19027_/D NOR3X1
X_17082_ _19770_/Q _19738_/Q _17082_/C VDD VSS _19770_/D AOI21X1
XFILLER_108_271 VDD VSS FILLER4
XFILLER_109_794 VDD VSS DECAPHV8
X_10457_ _18689_/Q _18743_/Q VDD VSS _10458_/A XNOR2X1
X_13245_ _13444_/A _13444_/B _13444_/D _13444_/C VDD VSS _14513_/C AOI211X1
X_16033_ _16033_/A _16033_/B _16033_/C VDD VSS _16059_/B AO21X2
X_10388_ _10625_/A _10660_/B _10388_/C _10595_/A VDD VSS _10389_/B AOAI211X1
X_13176_ _13287_/A _13287_/B _13184_/C VDD VSS _17894_/B XNOR3X1
XFILLER_112_948 VSS VDD FILLER2
XFILLER_78_840 VSS VDD FILLER2
X_12127_ _12129_/A _12129_/B _14176_/B VDD VSS _14143_/B XNOR3X1
X_17984_ _17987_/A _17987_/B _17989_/A _17987_/C VDD VSS _17984_/Y AOI211X1
XFILLER_111_458 VSS VDD FILLER2
X_12058_ _19207_/Q _12234_/A _12234_/B VDD VSS _12113_/C XNOR3X1
X_19723_ _19724_/CK _19723_/D _19723_/Q VDD VSS DFFQX1
X_16935_ _16937_/A _16937_/B _16935_/C VDD VSS _19742_/D AOI21X1
X_11009_ _11009_/A _11009_/B VDD VSS _11010_/C NAND2X1
X_19654_ _19737_/CK _19654_/D _19654_/Q VDD VSS DFFQX1
XFILLER_38_759 VDD VSS FILLER1
X_18605_ _18608_/CK _18605_/D _18605_/Q VDD VSS DFFQX1
X_16866_ _17391_/A VDD VSS _16876_/A BUFX3
X_19585_ _19615_/CK _19585_/D _19585_/Q VDD VSS DFFQX1
X_16797_ _16843_/A _16797_/B VDD VSS _19642_/D AND2X1
X_15817_ _15817_/A VDD VSS _15830_/A BUFX3
XFILLER_46_781 VSS VDD FILLER2
XFILLER_92_397 VDD VSS DECAPHV8
X_18536_ _18543_/CK _18536_/D _18536_/Q VDD VSS DFFQX1
X_15748_ _15758_/A _15748_/B VDD VSS _19371_/D NOR2X1
XFILLER_33_464 VDD VSS FILLER1
X_18467_ _18468_/CK _18499_/D _18467_/Q _20072_/RB VDD VSS DFFRQX1
XFILLER_61_795 VDD VSS FILLER4
XTAP_TAPCELL_ROW_15_161 VDD VSS WELLTAP
X_17418_ _19842_/Q _19810_/Q VDD VSS _17419_/B XOR2X1
X_15679_ _15693_/A _15679_/B VDD VSS _19308_/D NOR2X1
X_18398_ _18400_/CK _18515_/Q _20139_/A _09380_/B VDD VSS DFFRQX1
X_17349_ _19827_/Q _19795_/Q VDD VSS _17351_/B XOR2X1
X_19019_ _19045_/CK _19019_/D _19019_/Q VDD VSS DFFQX1
XFILLER_0_508 VDD VSS FILLER1
XFILLER_103_948 VSS VDD FILLER2
XFILLER_130_723 VDD VSS FILLER4
XFILLER_87_125 VDD VSS DECAPHV16
XFILLER_75_309 VSS VDD FILLER2
Xclkbuf_leaf_2__001_ clkbuf_leaf_5__001_/A VDD VSS _20008_/CK BUFX12
XFILLER_130_789 VDD VSS FILLER1
XFILLER_28_203 VDD VSS FILLER1
XFILLER_56_545 VDD VSS FILLER4
XFILLER_95_191 VDD VSS FILLER1
X_09605_ _18394_/Q VDD VSS _20135_/A INVX1
XFILLER_113_68 VDD VSS DECAPHV8
XFILLER_83_364 VDD VSS DECAPHV8
XFILLER_83_375 VSS VDD FILLER2
XFILLER_73_39 VDD VSS DECAPHV8
X_09536_ _20031_/Q _18199_/A VDD VSS _20032_/D NOR2BX1
X_09467_ _19973_/Q _09467_/B _09476_/C VDD VSS _09468_/C AOI21X1
XFILLER_51_250 VSS VDD FILLER2
XTAP_TAPCELL_ROW_41_429 VDD VSS WELLTAP
XFILLER_138_801 VDD VSS FILLER4
X_09398_ _18231_/E _11378_/A VDD VSS _18230_/E AND2X1
XFILLER_138_856 VDD VSS DECAPHV8
X_11360_ _11367_/A _11367_/C VDD VSS _11361_/B XNOR2X1
XFILLER_98_25 VDD VSS FILLER1
XTAP_TAPCELL_ROW_137_1388 VDD VSS WELLTAP
X_10311_ _11273_/A VDD VSS _11272_/A BUFX3
XFILLER_106_742 VSS VDD FILLER2
X_11291_ _11291_/A VDD VSS _11308_/B INVX1
X_13030_ _19134_/Q _14414_/B VDD VSS _13314_/C _14414_/C AND3X2
XFILLER_105_252 VSS VDD FILLER2
XFILLER_133_561 VSS VDD FILLER2
X_10242_ _18624_/Q _11436_/C _18623_/Q VDD VSS _11430_/B AOI21X1
XFILLER_121_734 VSS VDD FILLER2
X_10173_ _10174_/C _16273_/A _10173_/C VDD VSS _18542_/D AND3BX1
XFILLER_78_158 VDD VSS FILLER1
XFILLER_94_607 VDD VSS DECAPHV8
Xclkbuf_leaf_21__000_ clkload79/A VDD VSS _19673_/CK BUFX12
XFILLER_47_501 VDD VSS FILLER1
XFILLER_59_361 VDD VSS DECAPHV8
XFILLER_93_128 VDD VSS FILLER4
XTAP_TAPCELL_ROW_49_507 VDD VSS WELLTAP
X_16720_ _19924_/Q VDD VSS _17803_/A INVX1
X_14981_ _15026_/A _14981_/B VDD VSS _15743_/B XNOR2X1
XFILLER_47_62 VDD VSS FILLER1
X_13932_ _13941_/A _13941_/B VDD VSS _17937_/B _13941_/C NAND3X1
Xfanout193 _09776_/A VDD VSS _09812_/C BUFX3
XFILLER_47_567 VDD VSS FILLER1
XFILLER_74_375 VDD VSS FILLER1
X_13863_ _19004_/Q _13951_/B _13951_/C VDD VSS _13998_/B XNOR3X1
Xclkbuf_leaf_36__000_ clkload77/A VDD VSS _19466_/CK BUFX12
X_16651_ _19927_/Q VDD VSS _16724_/A INVX1
XFILLER_28_781 VSS VDD FILLER2
XFILLER_62_526 VSS VDD FILLER2
XTAP_TAPCELL_ROW_57_584 VDD VSS WELLTAP
X_12814_ _19131_/Q _14410_/B _14410_/C VDD VSS _12819_/D OR3BX1
X_13794_ _13857_/A _13857_/B _13857_/C VDD VSS _13854_/C OAI21X1
X_19370_ _19547_/CK _19370_/D _19370_/Q VDD VSS DFFQX1
X_16582_ _16582_/A _16595_/B VDD VSS _16863_/B XNOR2X1
X_15602_ _19439_/Q _15824_/B VDD VSS _15603_/B XNOR2X1
X_12745_ _12771_/A _12771_/B _12746_/D _12771_/E VDD VSS _14443_/B OA211X2
X_18321_ _18327_/CK _18465_/D _18321_/Q _20065_/RB VDD VSS DFFRQX1
X_15533_ _15674_/A _18153_/B VDD VSS _19296_/D AND2X1
XFILLER_42_261 VSS VDD FILLER2
XFILLER_97_8 VSS VDD FILLER2
XTAP_TAPCELL_ROW_103_1045 VDD VSS WELLTAP
X_12676_ _19215_/Q _14507_/B _12832_/C VDD VSS _12827_/A XNOR3X1
X_18252_ _18257_/CK _18252_/D _18265_/D _18485_/RB VDD VSS DFFRQX1
X_15464_ _15464_/A _15464_/B VDD VSS _15492_/B AND2X1
XFILLER_128_300 VDD VSS DECAPHV16
XFILLER_129_845 VSS VDD FILLER2
XFILLER_30_467 VSS VDD FILLER2
XFILLER_8_56 VDD VSS FILLER1
XFILLER_8_67 VDD VSS FILLER1
XTAP_TAPCELL_ROW_12_131 VDD VSS WELLTAP
X_11627_ _18769_/Q _11635_/B VDD VSS _18796_/D AND2X1
X_14415_ _14415_/A _14415_/B VDD VSS _19135_/D AND2X1
X_18183_ _18185_/A _18183_/B VDD VSS _18184_/B XOR2X1
X_17203_ _19796_/Q _19764_/Q VDD VSS _17206_/A XNOR2X1
X_15395_ _19488_/Q _15881_/B _15395_/C VDD VSS _15405_/A AOI21X1
X_11558_ _18706_/Q _11567_/B VDD VSS _18733_/D AND2X1
X_14346_ _14352_/A _14346_/B _14346_/C VDD VSS _19073_/D NOR3X1
X_17134_ _19781_/Q _19749_/Q VDD VSS _17140_/B NAND2X1
X_10509_ _10544_/A _10509_/B VDD VSS _10510_/B XOR2X1
X_17065_ _17062_/Y _17066_/C _17066_/B VDD VSS _17067_/B AND3BX1
XFILLER_143_325 VDD VSS FILLER1
X_11489_ _18644_/Q _11496_/B VDD VSS _18671_/D AND2X1
X_14277_ _14285_/A _14277_/B VDD VSS _19013_/D NOR2X1
X_16016_ _19707_/Q VDD VSS _16022_/A INVX1
XFILLER_124_550 VDD VSS DECAPHV16
XFILLER_97_401 VDD VSS FILLER1
XTAP_TAPCELL_ROW_114_1152 VDD VSS WELLTAP
X_13228_ _13122_/A _14447_/B _14447_/C VDD VSS _13315_/C AND3BX1
XFILLER_111_211 VSS VDD FILLER2
XFILLER_112_745 VDD VSS FILLER1
XFILLER_124_583 VDD VSS FILLER4
XFILLER_97_423 VDD VSS FILLER4
X_13159_ _19080_/Q _13364_/A _13364_/B VDD VSS _13271_/D XNOR3X1
XFILLER_97_445 VDD VSS FILLER1
XFILLER_38_501 VDD VSS DECAPHV8
XFILLER_97_478 VDD VSS FILLER4
X_19706_ _19707_/CK _19706_/D _19706_/Q VDD VSS DFFQX1
X_17967_ _17976_/B _18127_/B _17967_/C VDD VSS _19959_/D AND3BX1
XFILLER_38_534 VDD VSS FILLER1
X_17898_ _17901_/C _17898_/B _17898_/C _17898_/D VDD VSS _19947_/D AOI31X1
X_16918_ _17073_/B VDD VSS _17078_/B BUFX3
XFILLER_38_578 VSS VDD FILLER2
XFILLER_65_375 VDD VSS DECAPHV8
XFILLER_93_673 VDD VSS FILLER1
X_19637_ _19671_/CK _19637_/D _19637_/Q VDD VSS DFFQX1
X_16849_ _16865_/A _16849_/B VDD VSS _19688_/D NOR2X1
XFILLER_80_334 VDD VSS FILLER4
X_19568_ _19604_/CK _19568_/D _19568_/Q VDD VSS DFFQX1
Xdelaybuf_0_sclk clkload116/A VDD VSS _18217_/CK BUFX12
XTAP_TAPCELL_ROW_125_1270 VDD VSS WELLTAP
X_09321_ _18450_/D _09320_/Y _09302_/Y VDD VSS _18519_/D MUXI2X1
X_18519_ _18519_/CK _18519_/D _18519_/Q _09319_/Y VDD VSS DFFRQX1
X_19499_ _19521_/CK _19499_/D _19499_/Q VDD VSS DFFQX1
XFILLER_21_434 VSS VDD FILLER2
X_09252_ _20046_/Q _18258_/Q VDD VSS _09257_/C NOR2BX1
XFILLER_21_489 VSS VDD FILLER2
XFILLER_107_528 VDD VSS DECAPHV8
XFILLER_115_561 VDD VSS DECAPHV8
XFILLER_122_509 VSS VDD FILLER2
XFILLER_1_806 VSS VDD FILLER2
XFILLER_88_445 VDD VSS FILLER4
XFILLER_124_45 VDD VSS FILLER1
XFILLER_29_534 VDD VSS FILLER1
XFILLER_84_27 VSS VDD FILLER2
Xclkbuf_0_sclk sclk VDD VSS clkbuf_0_sclk/Y BUFX12
XFILLER_56_364 VDD VSS FILLER1
XFILLER_84_49 VDD VSS DECAPHV8
XFILLER_16_228 VDD VSS FILLER4
X_10860_ _18753_/Q VDD VSS _11609_/A INVX1
XFILLER_17_98 VDD VSS FILLER1
XFILLER_25_762 VDD VSS FILLER4
XTAP_TAPCELL_ROW_54_554 VDD VSS WELLTAP
X_09519_ _20018_/Q _20017_/Q _09519_/C VDD VSS _20018_/D AOI21X1
XTAP_TAPCELL_ROW_26_278 VDD VSS WELLTAP
X_10791_ _11039_/C _10856_/B VDD VSS _10805_/B NAND2X1
XTAP_TAPCELL_ROW_139_1406 VDD VSS WELLTAP
X_12530_ _13283_/A _17868_/B VDD VSS _18849_/D AND2X1
XFILLER_8_427 VSS VDD FILLER2
XFILLER_9_928 VSS VDD FILLER2
X_12461_ _12461_/A _12461_/B _12461_/C _12461_/D VDD VSS _12630_/A OAOI211X1
XTAP_TAPCELL_ROW_4_57 VDD VSS WELLTAP
X_11412_ _18534_/D _11428_/B VDD VSS _18606_/D NOR2BX1
X_14200_ _15383_/A VDD VSS _14231_/A BUFX3
X_15180_ _15161_/B _15180_/B _15180_/C VDD VSS _15206_/A AOI2B1X1
XFILLER_116_0 VDD VSS FILLER1
XFILLER_126_837 VSS VDD FILLER2
XFILLER_138_664 VDD VSS FILLER4
X_12392_ _14503_/C _19211_/Q _12571_/B VDD VSS _12474_/D AND3BX1
X_14131_ _18196_/A _14131_/B _14131_/C VDD VSS _18890_/D AND3BX1
XFILLER_126_848 VSS VDD FILLER2
X_11343_ _11379_/A _11343_/B VDD VSS _11345_/C AND2X1
XFILLER_113_509 VDD VSS DECAPHV8
X_11274_ _18581_/Q _11274_/B VDD VSS _11275_/C NOR2BX1
X_14062_ _18924_/Q _14171_/B VDD VSS _14078_/A NOR2BX1
XFILLER_106_583 VDD VSS FILLER1
XFILLER_140_328 VSS VDD FILLER2
XFILLER_79_434 VDD VSS DECAPHV8
X_10225_ _10229_/B VDD VSS _10226_/B INVX1
X_13013_ _13091_/A _14320_/B _14320_/C VDD VSS _13270_/C NOR3X1
X_18870_ _19197_/CK _18870_/D _18870_/Q VDD VSS DFFQX1
XFILLER_67_607 VDD VSS DECAPHV16
X_17821_ _17823_/A _17823_/B _17821_/C VDD VSS _19928_/D AOI21X1
XFILLER_94_415 VSS VDD FILLER2
X_10156_ _10105_/Y _10166_/D _10156_/C VDD VSS _10222_/B AOI2B1X1
XFILLER_121_597 VDD VSS FILLER4
XFILLER_47_320 VSS VDD FILLER2
X_10087_ _17812_/A _10087_/B VDD VSS _18535_/D NOR2X1
X_17752_ _17754_/C _17752_/B _17752_/C VDD VSS _19913_/D AOI21X1
X_14964_ _14966_/A _14966_/B VDD VSS _14965_/B _14966_/C NAND3X1
XFILLER_74_150 VDD VSS FILLER1
XFILLER_75_673 VSS VDD FILLER2
X_13915_ _19005_/Q wire154/Y _13958_/B VDD VSS _13998_/D XNOR3X1
X_17683_ _19898_/Q _19866_/Q _17683_/C VDD VSS _19898_/D AOI21X1
X_16703_ _16703_/A _16704_/B VDD VSS _19557_/D NOR2X1
XFILLER_35_548 VDD VSS FILLER1
XFILLER_47_375 VDD VSS FILLER4
X_19422_ _19461_/CK _19422_/D _19422_/Q VDD VSS DFFQX1
X_16634_ _16649_/B _16634_/B VDD VSS _16830_/B XNOR2X1
X_14895_ _19308_/Q VDD VSS _14896_/A INVX1
XFILLER_90_676 VDD VSS FILLER4
X_13846_ _13912_/A _13846_/B VDD VSS _14299_/B XNOR2X1
XFILLER_31_710 VSS VDD FILLER2
X_10989_ _10989_/A _11026_/B VDD VSS _10990_/B XNOR2X1
X_13777_ _13777_/A _14298_/B _14298_/C VDD VSS _13889_/C NOR3X1
X_19353_ _19362_/CK _19353_/D _19353_/Q VDD VSS DFFQX1
X_16565_ _16735_/A _16565_/B VDD VSS _19540_/D NOR2X1
XFILLER_15_272 VSS VDD FILLER2
X_12728_ wire158/Y _12729_/B _12729_/D _12729_/C VDD VSS _12821_/B OAOI211X1
X_19284_ _19290_/CK _19284_/D _19284_/Q VDD VSS DFFQX1
X_18304_ _18311_/CK _18496_/D _18304_/Q _18471_/RB VDD VSS DFFRQX1
X_16496_ _19570_/Q _19922_/Q VDD VSS _16525_/A XNOR2X1
X_15516_ _19492_/Q _15885_/B VDD VSS _15517_/B XOR2X1
XFILLER_88_4 VSS VDD FILLER2
X_12659_ _12659_/A _14505_/B VDD VSS _12683_/A OR2X2
Xclkbuf_leaf_1__002_ clkbuf_leaf_9__002_/A VDD VSS _19940_/CK BUFX12
X_18235_ _18235_/CK _18235_/E _18235_/ECK VDD VSS CGX3
X_15447_ _19434_/Q _15819_/B VDD VSS _15449_/C XOR2X1
XFILLER_30_275 VDD VSS FILLER1
XFILLER_116_303 VDD VSS FILLER1
X_18166_ _18167_/A _18167_/B _18167_/C VDD VSS _18166_/Y NOR3X1
X_15378_ _19348_/Q _15722_/B VDD VSS _15379_/B XOR2X1
X_14329_ _14316_/Y _14329_/B _14329_/C VDD VSS _19058_/D AND3BX1
X_18097_ _19286_/Q _18100_/B VDD VSS _18098_/B XOR2X1
X_17117_ _17118_/C _17117_/B _17117_/C VDD VSS _19777_/D AOI21X1
XFILLER_143_155 VDD VSS FILLER4
XFILLER_144_678 VDD VSS FILLER4
XFILLER_99_90 VSS VDD FILLER2
Xmax_cap157 _14319_/B VDD VSS _13021_/B BUFX3
X_17048_ _19762_/Q _17049_/B _17064_/A _17064_/B VDD VSS _17048_/Y AOI211X1
X_09870_ _09867_/Y _09869_/Y _11229_/A VDD VSS _10017_/B MUX2X1
XFILLER_31_0 VDD VSS DECAPHV8
XFILLER_58_607 VDD VSS DECAPHV8
XFILLER_98_765 VSS VDD FILLER2
XFILLER_86_927 VDD VSS FILLER1
XFILLER_86_949 VDD VSS FILLER1
XFILLER_97_286 VSS VDD FILLER2
X_18999_ _19085_/CK _18999_/D _18999_/Q VDD VSS DFFQX1
XTAP_TAPCELL_ROW_96_977 VDD VSS WELLTAP
XFILLER_38_375 VDD VSS FILLER4
XFILLER_26_559 VDD VSS FILLER1
XFILLER_81_654 VDD VSS DECAPHV16
XFILLER_41_529 VDD VSS FILLER4
XTAP_TAPCELL_ROW_51_524 VDD VSS WELLTAP
X_09304_ _20080_/RB _09346_/B VDD VSS _09304_/Y NOR2BX1
XFILLER_70_18 VDD VSS DECAPHV8
XTAP_TAPCELL_ROW_23_248 VDD VSS WELLTAP
X_09235_ _18515_/Q VDD VSS _18350_/D INVX1
Xclkbuf_leaf_20__001_ clkbuf_2_3__f__001_/Y VDD VSS _18878_/CK BUFX12
XFILLER_6_909 VDD VSS DECAPHV16
XFILLER_108_815 VDD VSS FILLER1
XFILLER_119_34 VDD VSS FILLER4
XFILLER_119_174 VDD VSS FILLER4
XFILLER_119_196 VDD VSS DECAPHV8
XFILLER_79_16 VDD VSS FILLER4
XFILLER_123_829 VDD VSS FILLER1
XFILLER_134_133 VSS VDD FILLER2
XFILLER_135_689 VSS VDD FILLER2
XTAP_TAPCELL_ROW_134_1358 VDD VSS WELLTAP
Xclkbuf_leaf_35__001_ clkbuf_2_1__f__001_/Y VDD VSS _19129_/CK BUFX12
XFILLER_116_881 VSS VDD FILLER2
XFILLER_122_328 VSS VDD FILLER2
XFILLER_134_188 VSS VDD FILLER2
XFILLER_1_625 VDD VSS DECAPHV8
XFILLER_131_840 VDD VSS DECAPHV16
XFILLER_77_916 VDD VSS FILLER4
X_10010_ _18601_/Q _10010_/B VDD VSS _10022_/A AND2X1
XFILLER_0_146 VSS VDD FILLER2
XFILLER_0_179 VDD VSS FILLER1
XFILLER_131_884 VSS VDD FILLER2
XFILLER_131_895 VDD VSS FILLER1
XFILLER_135_66 VDD VSS FILLER1
XFILLER_135_77 VDD VSS FILLER4
XFILLER_49_629 VDD VSS DECAPHV16
XFILLER_88_253 VSS VDD FILLER2
XFILLER_95_26 VDD VSS DECAPHV8
XTAP_TAPCELL_ROW_59_602 VDD VSS WELLTAP
X_09999_ _18577_/Q _18578_/Q VDD VSS _10013_/B _09999_/C NAND3X1
X_20188_ _20188_/A VDD VSS _20188_/Y BUFX3
XFILLER_28_42 VDD VSS FILLER4
XFILLER_28_64 VDD VSS FILLER1
XFILLER_29_364 VDD VSS FILLER1
X_11961_ _19120_/Q _11961_/B _11961_/C VDD VSS _14368_/B XNOR3X1
XFILLER_29_375 VDD VSS DECAPHV8
X_10912_ _10840_/Y _10911_/Y _10947_/A VDD VSS _10912_/Y MUXI2X1
X_13700_ _13781_/A _13781_/B VDD VSS _14328_/B XNOR2X1
XTAP_TAPCELL_ROW_67_690 VDD VSS WELLTAP
X_11892_ _12035_/A _12035_/B _12035_/C VDD VSS _11912_/B OAI21X1
X_14680_ _14681_/A _15892_/B VDD VSS _14739_/D OR2X2
XFILLER_44_41 VDD VSS FILLER4
XFILLER_72_687 VDD VSS DECAPHV8
X_10843_ _10843_/A VDD VSS _11118_/A BUFX3
X_13631_ _19140_/Q _14422_/B VDD VSS _13721_/E _14422_/C AND3X2
XFILLER_12_220 VDD VSS DECAPHV8
XTAP_TAPCELL_ROW_100_1015 VDD VSS WELLTAP
X_10774_ _10774_/A _10774_/B VDD VSS _10774_/Y NOR2X1
X_13562_ _19140_/Q _13562_/B _13630_/C VDD VSS _13721_/B XNOR3X1
X_16350_ _19692_/Q _16853_/B VDD VSS _16352_/C XNOR2X1
XFILLER_9_703 VDD VSS FILLER1
X_12513_ _14278_/A _12513_/B _14310_/B VDD VSS _12514_/B MIN3X1
X_16281_ _16264_/A _16281_/B VDD VSS _16292_/B NAND2BX1
X_15301_ _19347_/Q VDD VSS _15341_/A INVX1
XFILLER_8_235 VDD VSS DECAPHV32
X_13493_ _18885_/Q VDD VSS _13495_/A INVX1
X_18020_ _18531_/Q _18020_/B VDD VSS _18021_/C NOR2X1
XFILLER_126_612 VDD VSS DECAPHV8
X_12444_ _12519_/B _12519_/C _12515_/C VDD VSS _12510_/B OAI21X1
X_15232_ _15875_/B _15232_/B _15232_/C VDD VSS _15307_/A NOR3X1
X_12375_ _19155_/Q VDD VSS _12467_/A INVX1
X_15163_ _15178_/A _15178_/B VDD VSS _15748_/B XNOR2X1
X_11326_ _11333_/C _11333_/B VDD VSS _11327_/B NOR2BX1
X_14114_ _14118_/A _14114_/B VDD VSS _18874_/D NOR2X1
X_19971_ _19986_/CK _19971_/D _19971_/Q VDD VSS DFFQX1
X_15094_ _19481_/Q _15873_/B VDD VSS _15112_/B XNOR2X1
XFILLER_107_881 VDD VSS DECAPHV16
XFILLER_125_166 VDD VSS FILLER4
XFILLER_126_689 VDD VSS FILLER1
XFILLER_141_637 VDD VSS DECAPHV8
X_14045_ _14045_/A _14045_/B _14235_/B _18979_/Q _14045_/E VDD VSS _14068_/C AOI221X1
X_18922_ _18950_/CK _18922_/D _18922_/Q VDD VSS DFFQX1
XFILLER_79_220 VSS VDD FILLER2
XTAP_TAPCELL_ROW_111_1122 VDD VSS WELLTAP
X_11257_ _11050_/Y _11341_/B _11289_/A VDD VSS _11264_/C MUXI2X1
XFILLER_122_895 VSS VDD FILLER2
X_10208_ _10217_/C _10217_/B VDD VSS _10209_/B NAND2BX1
X_11188_ _11217_/A _11188_/B VDD VSS _11189_/B XNOR2X1
X_18853_ _18878_/CK _18853_/D _18853_/Q VDD VSS DFFQX1
XFILLER_39_117 VSS VDD FILLER2
XFILLER_94_223 VDD VSS FILLER1
X_10139_ _18589_/Q _10163_/C VDD VSS _10153_/B XNOR2X1
X_18784_ _18785_/CK _18784_/D _18784_/Q VDD VSS DFFQX1
X_17804_ _19925_/Q _19893_/Q VDD VSS _17805_/B XOR2X1
XFILLER_48_640 VDD VSS FILLER4
X_17735_ _17738_/A _17735_/B _17735_/C VDD VSS _19909_/D AOI21X1
X_15996_ _19551_/Q _19903_/Q VDD VSS _15997_/B XOR2X1
XFILLER_82_429 VDD VSS FILLER4
XFILLER_85_92 VDD VSS FILLER1
XTAP_TAPCELL_ROW_93_947 VDD VSS WELLTAP
X_14947_ _19310_/Q _15681_/B VDD VSS _14948_/B XNOR2X1
XFILLER_62_142 VDD VSS FILLER4
XFILLER_63_654 VDD VSS FILLER4
X_17666_ _19894_/Q _19862_/Q VDD VSS _17667_/C NAND2X1
X_14878_ _15009_/C _14921_/C VDD VSS _15898_/B OR2X2
XFILLER_23_507 VDD VSS DECAPHV8
XTAP_TAPCELL_ROW_122_1240 VDD VSS WELLTAP
X_13829_ _19002_/Q _14264_/B VDD VSS _13891_/A NAND2X1
X_19405_ _19435_/CK _19405_/D _19405_/Q VDD VSS DFFQX1
X_17597_ _17598_/A _17600_/C _17597_/C VDD VSS _17598_/C OAI21X1
X_16617_ _17010_/A _16617_/B _16643_/B VDD VSS _19542_/D NOR3X1
XFILLER_44_890 VSS VDD FILLER2
XFILLER_50_337 VDD VSS FILLER1
XFILLER_93_2 VDD VSS FILLER1
X_19336_ _19337_/CK _19336_/D _19336_/Q VDD VSS DFFQX1
X_16548_ _16548_/A _16548_/B _16548_/C VDD VSS _16572_/B AOI21X1
XTAP_TAPCELL_ROW_20_218 VDD VSS WELLTAP
X_19267_ _20005_/CK _19267_/D _19267_/Q VDD VSS DFFQX1
X_16479_ _19601_/Q _16501_/A VDD VSS _16480_/B XOR2X1
X_19198_ _19988_/CK _19198_/D _19198_/Q VDD VSS DFFQX1
X_18218_ _18233_/CK _18218_/E _18218_/ECK VDD VSS CGX3
X_18149_ _19295_/Q _18149_/B VDD VSS _18150_/C NAND2X1
XFILLER_144_453 VDD VSS DECAPHV16
XFILLER_104_306 VSS VDD FILLER2
X_20111_ _20111_/A VDD VSS _20111_/Y BUFX3
XFILLER_104_339 VSS VDD FILLER2
XFILLER_131_147 VDD VSS DECAPHV8
XFILLER_132_648 VDD VSS FILLER1
X_09922_ _09942_/A _09922_/B VDD VSS _09922_/Y XNOR2X1
XFILLER_131_169 VSS VDD FILLER2
X_09853_ _10927_/C VDD VSS _10966_/A BUFX3
X_20042_ _20045_/CK _20042_/D _20042_/Q _20043_/RB VDD VSS DFFRQX1
Xclkbuf_1_1__f__09176_ clkbuf_0__09176_/Y VDD VSS _18241_/CK BUFX12
XFILLER_100_534 VDD VSS FILLER4
XFILLER_105_47 VDD VSS DECAPHV8
XFILLER_112_383 VDD VSS DECAPHV8
X_09784_ _18469_/Q _09784_/B _09784_/C _18437_/Q _09784_/E VDD VSS _09791_/B AOI221X1
XFILLER_100_556 VSS VDD FILLER2
XFILLER_26_312 VSS VDD FILLER2
XFILLER_73_418 VDD VSS FILLER1
XFILLER_82_941 VDD VSS DECAPHV8
XFILLER_54_687 VDD VSS FILLER1
XTAP_TAPCELL_ROW_64_660 VDD VSS WELLTAP
XTAP_TAPCELL_ROW_36_373 VDD VSS WELLTAP
XFILLER_22_562 VDD VSS DECAPHV8
XFILLER_139_236 VSS VDD FILLER2
XFILLER_139_247 VDD VSS FILLER1
XFILLER_10_768 VSS VDD FILLER2
XFILLER_139_269 VDD VSS DECAPHV8
X_09218_ _18520_/Q VDD VSS _18403_/D INVX1
X_10490_ _10530_/A _10530_/B _10530_/C _11095_/C VDD VSS _10491_/D AOI31X1
XFILLER_136_943 VDD VSS FILLER4
XFILLER_5_205 VDD VSS FILLER4
XFILLER_108_678 VSS VDD FILLER2
XFILLER_135_464 VDD VSS FILLER1
XTAP_TAPCELL_ROW_1_25 VDD VSS WELLTAP
X_12160_ _12160_/A _14465_/B _12160_/C _12160_/D VDD VSS _12329_/A OAOI211X2
XFILLER_108_689 VDD VSS DECAPHV8
XFILLER_123_626 VDD VSS FILLER1
XFILLER_135_497 VDD VSS DECAPHV16
XFILLER_2_923 VSS VDD FILLER2
X_11111_ _11132_/A _11111_/B VDD VSS _11113_/B XNOR2X1
XFILLER_123_648 VSS VDD FILLER2
X_12091_ _12116_/A _12116_/B _12091_/C VDD VSS _14434_/C AOI21X1
XFILLER_104_862 VDD VSS FILLER1
XFILLER_110_309 VDD VSS FILLER1
XFILLER_49_404 VSS VDD FILLER2
X_11042_ _18704_/Q _18758_/Q VDD VSS _11043_/C AND2X1
XFILLER_76_201 VDD VSS DECAPHV16
X_15850_ _15867_/A _15850_/B VDD VSS _19462_/D NOR2X1
XFILLER_39_96 VSS VDD FILLER2
XFILLER_92_716 VSS VDD FILLER2
X_14801_ _14801_/A _14810_/C VDD VSS _15707_/B XNOR2X1
XFILLER_17_301 VDD VSS FILLER4
XFILLER_64_429 VSS VDD FILLER2
X_12993_ _12994_/B _12994_/C _18966_/Q VDD VSS _13171_/B AOI21X1
X_15781_ _15793_/A _15781_/B VDD VSS _19401_/D AND2X1
XFILLER_45_643 VDD VSS DECAPHV8
X_11944_ _11944_/A _11944_/B _14335_/B VDD VSS _11945_/B MIN3X1
X_17520_ _17522_/A _17520_/B _17520_/C VDD VSS _19863_/D AOI21X1
X_14732_ _14737_/A _14737_/B VDD VSS _15829_/B XNOR2X1
XFILLER_32_304 VDD VSS FILLER1
XFILLER_44_164 VDD VSS FILLER4
XFILLER_45_698 VDD VSS FILLER4
XFILLER_72_473 VDD VSS FILLER4
XTAP_TAPCELL_ROW_90_917 VDD VSS WELLTAP
X_11875_ _11979_/A _14490_/B _11979_/C VDD VSS _14492_/B OAI21X1
X_14663_ _19387_/Q _15765_/B VDD VSS _14664_/B XNOR2X1
X_17451_ _19849_/Q _19817_/Q VDD VSS _17453_/B XOR2X1
X_10826_ _10861_/C _10827_/B VDD VSS _10826_/Y NOR2X1
X_13614_ _19111_/Q _13614_/B _13614_/C VDD VSS _13623_/B XOR3X1
X_16402_ _16402_/A _16402_/B VDD VSS _16403_/B _16402_/C NAND3X1
X_14594_ _14594_/A _15856_/B VDD VSS _14595_/B NAND2X1
X_19121_ _19121_/CK _19121_/D _19121_/Q VDD VSS DFFQX1
X_17382_ _19834_/Q _19802_/Q _17382_/C VDD VSS _19834_/D AOI21X1
XFILLER_40_381 VDD VSS DECAPHV16
XFILLER_71_72 VSS VDD FILLER2
XFILLER_71_83 VDD VSS DECAPHV8
XFILLER_9_533 VDD VSS DECAPHV16
X_10757_ _18669_/Q _18777_/Q _10757_/C VDD VSS _10801_/A AO21X2
X_13545_ _13546_/A _13546_/B _13546_/D _13546_/C VDD VSS _13640_/B OAOI211X1
X_16333_ _19691_/Q _16852_/B VDD VSS _16352_/A NOR2X1
XFILLER_9_566 VDD VSS FILLER1
X_10688_ _18641_/Q _18803_/Q VDD VSS _10689_/B XOR2X1
X_13476_ _13509_/A _13509_/B VDD VSS _14260_/B _13509_/C NAND3X1
X_19052_ _19064_/CK _19052_/D _19052_/Q VDD VSS DFFQX1
X_16264_ _16264_/A _16281_/B VDD VSS _16815_/B XNOR2X1
XFILLER_139_781 VDD VSS FILLER1
X_12427_ _18960_/Q _12440_/B _14211_/B VDD VSS _14180_/B XNOR3X1
X_18003_ _18548_/Q _18055_/B VDD VSS _18057_/C NOR2BX1
X_15215_ _15297_/A _18107_/B VDD VSS _19288_/D AND2X1
XFILLER_126_431 VDD VSS FILLER1
X_16195_ _19718_/Q _16882_/B VDD VSS _16199_/B XNOR2X1
XFILLER_114_615 VDD VSS FILLER1
XFILLER_114_637 VDD VSS FILLER1
XFILLER_99_326 VSS VDD FILLER2
X_12358_ _19071_/Q VDD VSS _12421_/A INVX1
X_15146_ _19535_/Q _19536_/Q VDD VSS _15186_/B _15146_/C NAND3X1
XFILLER_99_359 VSS VDD FILLER2
X_11309_ _11379_/A _11319_/B VDD VSS _11310_/B NOR2X1
X_12289_ _19042_/Q _14279_/A _14278_/B VDD VSS _12361_/B MIN3X1
X_19954_ _19957_/CK _19954_/D _19954_/Q VDD VSS DFFQX1
X_15077_ _19313_/Q _15684_/B VDD VSS _15078_/B XNOR2X1
XFILLER_68_724 VDD VSS FILLER1
X_14028_ _14038_/A _14169_/B _14054_/C VDD VSS _14170_/B OA21X2
X_19885_ clkload7/A _19885_/D _19885_/Q VDD VSS DFFQX1
X_18905_ _18908_/CK _18905_/D _18905_/Q VDD VSS DFFQX1
XFILLER_122_692 VDD VSS FILLER4
X_18836_ _19951_/CK _18836_/D _18836_/Q VDD VSS DFFQX1
XTAP_TAPCELL_ROW_78_796 VDD VSS WELLTAP
X_18767_ _18768_/CK _18767_/D _18767_/Q VDD VSS DFFQX1
X_15979_ _15979_/A _15979_/B VDD VSS _16834_/B XNOR2X1
XFILLER_36_643 VDD VSS FILLER1
X_18698_ _18779_/CK _18698_/D _18698_/Q VDD VSS DFFQX1
X_17718_ _17719_/B _17718_/B VDD VSS _17720_/B NOR2BX1
XFILLER_24_827 VDD VSS FILLER1
XFILLER_91_760 VDD VSS FILLER1
X_17649_ _19891_/Q _19859_/Q VDD VSS _17651_/B XOR2X1
XFILLER_17_890 VDD VSS FILLER4
XFILLER_50_123 VSS VDD FILLER2
XFILLER_51_635 VDD VSS FILLER1
XFILLER_32_860 VSS VDD FILLER2
XTAP_TAPCELL_ROW_33_343 VDD VSS WELLTAP
XTAP_TAPCELL_ROW_61_630 VDD VSS WELLTAP
X_19319_ _19322_/CK _19319_/D _19319_/Q VDD VSS DFFQX1
XFILLER_136_217 VDD VSS FILLER1
Xclkbuf_leaf_0_clk_regs clkbuf_leaf_9_clk_regs/A VDD VSS clkload7/A BUFX12
XFILLER_104_103 VSS VDD FILLER2
XFILLER_133_913 VDD VSS FILLER4
XTAP_TAPCELL_ROW_131_1328 VDD VSS WELLTAP
XFILLER_120_607 VSS VDD FILLER2
XFILLER_132_478 VDD VSS FILLER4
X_09905_ _18560_/Q _09941_/C VDD VSS _09929_/B XNOR2X1
XFILLER_76_17 VSS VDD FILLER2
X_20025_ _20045_/CK _20025_/D _20025_/Q _20031_/RB VDD VSS DFFRQX1
XFILLER_47_919 VDD VSS FILLER4
X_09836_ _18558_/Q _18559_/Q VDD VSS _09941_/C _10247_/A AND3X2
XFILLER_101_898 VSS VDD FILLER2
X_09767_ _20113_/A _09767_/B _09811_/B _18436_/Q VDD VSS _09768_/D AOI22X1
XFILLER_132_67 VDD VSS FILLER1
XFILLER_27_643 VDD VSS FILLER1
XFILLER_55_941 VDD VSS FILLER1
X_09698_ _09698_/A _09698_/B _09812_/C VDD VSS _09699_/E AOI21X1
XFILLER_26_142 VDD VSS FILLER4
XFILLER_70_922 VDD VSS FILLER1
XFILLER_92_49 VDD VSS FILLER4
XTAP_TAPCELL_ROW_142_1435 VDD VSS WELLTAP
XFILLER_25_54 VDD VSS DECAPHV8
X_11660_ _18799_/Q _11669_/B VDD VSS _18826_/D AND2X1
XFILLER_23_882 VSS VDD FILLER2
XFILLER_41_189 VDD VSS DECAPHV8
X_10611_ _10642_/D _10642_/C VDD VSS _10613_/C NAND2BX1
X_11591_ _18736_/Q _11600_/B VDD VSS _18763_/D AND2X1
X_10542_ _18558_/Q _10542_/B VDD VSS _10544_/D XNOR2X1
X_13330_ _19193_/Q _13466_/A _13466_/B VDD VSS _13331_/D XNOR3X1
XFILLER_6_514 VDD VSS FILLER4
X_13261_ _20013_/Q _19277_/Q VDD VSS _13345_/D XOR2X1
X_10473_ _10471_/Y _10474_/C VDD VSS _18556_/D NOR2BX1
X_12212_ _12214_/A _12214_/B _12214_/C VDD VSS _12213_/B AOI21X1
X_15000_ wire161/Y _15000_/B _15000_/C _15000_/D VDD VSS _15836_/B OAI211X1
X_13192_ _13192_/A _13192_/B _13192_/C _13192_/D VDD VSS _13395_/B AOAI211X1
XFILLER_9_0 VDD VSS DECAPHV8
X_12143_ _14373_/B _14373_/C _19096_/Q VDD VSS _12210_/B AOI21X1
XFILLER_2_753 VSS VDD FILLER2
XFILLER_96_307 VDD VSS FILLER4
X_12074_ _19066_/Q VDD VSS _12080_/A INVX1
X_16951_ _16953_/C _16951_/B _16951_/C VDD VSS _19745_/D AOI21X1
XFILLER_2_786 VDD VSS FILLER4
XFILLER_49_212 VDD VSS DECAPHV8
X_11025_ _11021_/B _18571_/Q VDD VSS _11055_/A NAND2BX1
X_15902_ _15906_/A _15902_/B VDD VSS _19508_/D NOR2X1
XFILLER_103_191 VDD VSS FILLER1
X_19670_ _19703_/CK _19670_/D _19670_/Q VDD VSS DFFQX1
X_16882_ _16891_/A _16882_/B VDD VSS _19718_/D NOR2X1
XFILLER_92_502 VSS VDD FILLER2
X_18621_ _18622_/CK _18621_/D _18621_/Q VDD VSS DFFQX1
X_15833_ _17010_/A _15833_/B _15833_/C VDD VSS _19448_/D NOR3X1
XFILLER_46_941 VDD VSS FILLER1
X_18552_ _18571_/CK _18552_/D _18552_/Q VDD VSS DFFQX1
X_15764_ _15770_/A _15764_/B VDD VSS _19386_/D AND2X1
XTAP_TAPCELL_ROW_75_766 VDD VSS WELLTAP
X_12976_ _19050_/Q _13091_/B _13091_/C VDD VSS _13270_/B XNOR3X1
X_17503_ _19859_/Q _19827_/Q _17503_/C VDD VSS _17507_/C MIN3X1
X_14715_ _14785_/A _14746_/B VDD VSS _14781_/B XNOR2X1
XFILLER_45_484 VSS VDD FILLER2
XFILLER_60_421 VDD VSS DECAPHV8
XTAP_TAPCELL_ROW_106_1076 VDD VSS WELLTAP
X_11927_ _11933_/A _14525_/B _11980_/C VDD VSS _14526_/B AO21X2
X_18483_ _18487_/CK _18499_/D _20128_/A _18485_/RB VDD VSS DFFRQX1
X_15695_ _15710_/A _15695_/B VDD VSS _19323_/D NOR2X1
XFILLER_32_156 VDD VSS FILLER1
X_11858_ _19063_/Q _11944_/B _11861_/C VDD VSS _14303_/B XNOR3X1
X_14646_ _19524_/Q _14646_/B VDD VSS _14655_/B XNOR2X1
X_17434_ _17439_/C _17439_/B VDD VSS _17436_/B NAND2BX1
XANTENNA_19 _15836_/C VDD VSS ANTENNA2
XFILLER_14_871 VDD VSS FILLER4
X_10809_ _10658_/B _10808_/Y _10843_/A VDD VSS _10809_/Y MUXI2X1
X_11789_ _19116_/Q _14394_/B VDD VSS _11790_/B OR2X2
X_14577_ _19520_/Q _19519_/Q VDD VSS _14578_/C NAND2X1
X_17365_ _19830_/Q _19798_/Q VDD VSS _17366_/C NAND2X1
XTAP_TAPCELL_ROW_30_313 VDD VSS WELLTAP
X_13528_ _13528_/A _14355_/A _13528_/C _13528_/D VDD VSS _13696_/A AOAI211X1
Xclkbuf_1_0__f__09179_ clkbuf_0__09179_/Y VDD VSS _20020_/CK BUFX12
X_19104_ _19129_/CK _19104_/D _19104_/Q VDD VSS DFFQX1
X_16316_ _19595_/Q _16745_/B VDD VSS _16337_/B XOR2X1
X_19035_ _19050_/CK _19035_/D _19035_/Q VDD VSS DFFQX1
X_17296_ _19815_/Q _19783_/Q _17296_/C VDD VSS _17300_/C MIN3X1
X_13459_ _13459_/A _13459_/B _13459_/C _13459_/D VDD VSS _13637_/A AOAI211X1
X_16247_ _16250_/B _16247_/B VDD VSS _16248_/B XOR2X1
XFILLER_114_401 VDD VSS FILLER4
XFILLER_127_795 VSS VDD FILLER2
Xoutput115 _20184_/Y VDD VSS o_tst_ctrl[3] BUFX3
Xoutput104 _20179_/Y VDD VSS o_rst_ctrl_b[0] BUFX3
X_16178_ _19621_/Q VDD VSS _16179_/A INVX1
XFILLER_88_808 VDD VSS FILLER4
XTAP_TAPCELL_ROW_117_1183 VDD VSS WELLTAP
Xoutput148 _20203_/Y VDD VSS o_uwb_tx_cfg[6] BUFX3
Xoutput137 _20220_/Y VDD VSS o_uwb_tx_cfg[23] BUFX3
Xoutput126 _20210_/Y VDD VSS o_uwb_tx_cfg[13] BUFX3
X_15129_ _15132_/B _15129_/B VDD VSS _18100_/B XNOR2X1
XFILLER_102_607 VDD VSS DECAPHV8
XFILLER_114_456 VDD VSS FILLER4
XFILLER_87_318 VSS VDD FILLER2
X_19937_ _19937_/CK _19937_/D _19937_/Q VDD VSS DFFQX1
XFILLER_29_908 VSS VDD FILLER2
X_19868_ _19903_/CK _19868_/D _19868_/Q VDD VSS DFFQX1
XFILLER_110_662 VSS VDD FILLER2
XFILLER_55_215 VDD VSS FILLER1
XFILLER_83_513 VDD VSS FILLER4
X_09621_ _18299_/Q _09812_/B _09784_/B _18459_/Q VDD VSS _09636_/A AOI22X1
X_19799_ _19833_/CK _19799_/D _19799_/Q VDD VSS DFFQX1
X_18819_ _18820_/CK _18819_/D _18819_/Q VDD VSS DFFQX1
X_09552_ _18344_/Q VDD VSS _20212_/A INVX1
XFILLER_24_602 VSS VDD FILLER2
XFILLER_64_771 VDD VSS DECAPHV8
XFILLER_83_579 VDD VSS FILLER1
XFILLER_70_229 VSS VDD FILLER2
X_09483_ _18455_/D _09483_/B _09483_/C VDD VSS _18242_/D AOI21X1
XFILLER_12_808 VDD VSS DECAPHV16
XFILLER_51_432 VDD VSS FILLER1
XTAP_TAPCELL_ROW_18_192 VDD VSS WELLTAP
XFILLER_11_329 VSS VDD FILLER2
XFILLER_23_167 VSS VDD FILLER2
XFILLER_51_476 VDD VSS FILLER4
XFILLER_109_239 VDD VSS FILLER4
XFILLER_127_8 VSS VDD FILLER2
XFILLER_137_526 VDD VSS FILLER1
XFILLER_20_863 VDD VSS FILLER1
XFILLER_20_874 VSS VDD FILLER2
XFILLER_118_740 VDD VSS FILLER4
XFILLER_11_12 VSS VDD FILLER2
XFILLER_118_773 VDD VSS FILLER1
XFILLER_3_528 VSS VDD FILLER2
XFILLER_117_272 VSS VDD FILLER2
XFILLER_121_905 VDD VSS FILLER4
XFILLER_87_38 VDD VSS DECAPHV8
XFILLER_121_949 VDD VSS FILLER1
XFILLER_101_640 VDD VSS FILLER1
XFILLER_143_44 VDD VSS FILLER4
XFILLER_86_340 VSS VDD FILLER2
XFILLER_46_204 VSS VDD FILLER2
XFILLER_86_384 VDD VSS DECAPHV16
X_09819_ _09819_/A _09819_/B _09819_/C VDD VSS _18295_/D OAI21X1
X_20008_ _20008_/CK _20008_/D _20008_/Q VDD VSS DFFQX1
XFILLER_36_20 VSS VDD FILLER2
X_12830_ _19216_/Q VDD VSS _12945_/A INVX1
XFILLER_42_421 VSS VDD FILLER2
XFILLER_55_793 VDD VSS FILLER4
XTAP_TAPCELL_ROW_72_736 VDD VSS WELLTAP
X_12761_ _19244_/Q VDD VSS _12967_/C INVX1
XFILLER_14_134 VDD VSS FILLER4
X_11712_ _19170_/Q _14455_/B VDD VSS _11761_/B NOR2X1
X_12692_ _12710_/A _12896_/D VDD VSS _14251_/B XNOR2X1
X_14500_ _14491_/Y _14500_/B _14500_/C VDD VSS _19209_/D AND3BX1
X_15480_ _19491_/Q _15884_/B VDD VSS _15481_/B XOR2X1
XFILLER_14_189 VDD VSS FILLER4
XFILLER_30_638 VDD VSS FILLER1
XFILLER_70_774 VDD VSS DECAPHV8
X_11643_ _18784_/Q _11647_/B VDD VSS _18811_/D AND2X1
X_14431_ _14456_/A _14431_/B VDD VSS _19148_/D NOR2X1
XTAP_TAPCELL_ROW_99_1009 VDD VSS WELLTAP
X_17150_ _19784_/Q VDD VSS _17300_/B INVX1
XFILLER_10_351 VSS VDD FILLER2
XFILLER_11_874 VDD VSS FILLER1
XFILLER_128_537 VDD VSS FILLER1
X_11574_ _18721_/Q _11578_/B VDD VSS _18748_/D AND2X1
X_14362_ _14415_/A _14362_/B VDD VSS _19086_/D AND2X1
X_16101_ _16776_/A VDD VSS _16512_/A BUFX3
X_10525_ _10525_/A _10525_/B _10525_/C _10525_/D VDD VSS _10563_/A AOAI211X1
X_13313_ _13406_/A _13406_/B _13406_/C VDD VSS _13370_/B AOI21X1
X_14293_ _14294_/A _14293_/B _14293_/C VDD VSS _19026_/D NOR3X1
X_17081_ _19770_/Q _19738_/Q _17081_/C VDD VSS _17082_/C OAI21X1
XFILLER_109_773 VDD VSS FILLER4
XFILLER_143_529 VSS VDD FILLER2
X_10456_ _18688_/Q _18742_/Q VDD VSS _10460_/D AND2X1
X_13244_ _13244_/A _14541_/B _14541_/C VDD VSS _13444_/C NOR3X1
X_16032_ _16767_/B _19615_/Q VDD VSS _16033_/C NOR2BX1
X_13175_ _18912_/Q _13286_/B _14157_/B VDD VSS _13184_/C XNOR3X1
XFILLER_42_8 VDD VSS FILLER1
X_10387_ _10625_/A _10511_/A VDD VSS _10427_/B _10701_/C NAND3X1
X_12126_ _18956_/Q _12131_/B _14207_/B VDD VSS _14176_/B XNOR3X1
XFILLER_111_426 VDD VSS DECAPHV8
XFILLER_97_638 VDD VSS DECAPHV8
X_17983_ _18871_/Q _17983_/B _17983_/C VDD VSS _17987_/C NOR3X1
XFILLER_77_60 VDD VSS FILLER1
XFILLER_78_852 VSS VDD FILLER2
X_12057_ _19235_/Q _12108_/C _12101_/C VDD VSS _12234_/B XNOR3X1
X_19722_ _19724_/CK _19722_/D _19722_/Q VDD VSS DFFQX1
X_16934_ _16937_/A _16937_/B _17081_/C VDD VSS _16935_/C OAI21X1
XFILLER_37_204 VDD VSS DECAPHV8
XFILLER_93_833 VDD VSS FILLER4
X_11008_ _11009_/A _11009_/B VDD VSS _11033_/C NOR2X1
X_19653_ _19737_/CK _19653_/D _19653_/Q VDD VSS DFFQX1
X_16865_ _16865_/A _16865_/B VDD VSS _19703_/D NOR2X1
XFILLER_65_557 VDD VSS FILLER1
XFILLER_77_395 VDD VSS DECAPHV32
XFILLER_92_343 VDD VSS DECAPHV8
XFILLER_93_844 VDD VSS FILLER1
XTAP_TAPCELL_ROW_88_891 VDD VSS WELLTAP
X_18604_ _18608_/CK _18604_/D _18604_/Q VDD VSS DFFQX1
X_15816_ _15816_/A _15816_/B VDD VSS _19432_/D NOR2X1
XFILLER_37_259 VDD VSS DECAPHV8
XFILLER_65_568 VDD VSS FILLER1
X_19584_ _19591_/CK _19584_/D _19584_/Q VDD VSS DFFQX1
X_16796_ _16843_/A _16796_/B VDD VSS _19641_/D AND2X1
XFILLER_46_793 VDD VSS DECAPHV16
XFILLER_80_549 VDD VSS FILLER1
XFILLER_93_92 VDD VSS FILLER1
X_12959_ _20010_/Q _19274_/Q VDD VSS _13150_/B NAND2X1
X_18535_ _18550_/CK _18535_/D _18535_/Q VDD VSS DFFQX1
X_15747_ _15770_/A _15747_/B VDD VSS _19370_/D AND2X1
X_18466_ _18468_/CK _18498_/D _18466_/Q _20075_/RB VDD VSS DFFRQX1
X_15678_ _15817_/A VDD VSS _15693_/A BUFX3
XFILLER_21_616 VSS VDD FILLER2
XFILLER_33_487 VDD VSS FILLER4
XFILLER_60_251 VSS VDD FILLER2
XFILLER_61_774 VSS VDD FILLER2
X_14629_ _14658_/A _14658_/B VDD VSS _14671_/C XOR2X1
X_17417_ _19841_/Q _19809_/Q _17417_/C VDD VSS _17420_/B MIN3X1
XFILLER_119_504 VDD VSS FILLER1
XTAP_TAPCELL_ROW_15_162 VDD VSS WELLTAP
X_18397_ _18400_/CK _18477_/D _20138_/A _09380_/B VDD VSS DFFRQX1
XTAP_TAPCELL_ROW_119_1201 VDD VSS WELLTAP
X_17348_ _19826_/Q _19794_/Q _17348_/C VDD VSS _17353_/C AO21X2
XFILLER_9_193 VSS VDD FILLER2
X_17279_ _17281_/A _17281_/B _17279_/C VDD VSS _19812_/D AOI21X1
XFILLER_61_0 VDD VSS FILLER4
X_19018_ _19045_/CK _19018_/D _19018_/Q VDD VSS DFFQX1
XFILLER_115_743 VDD VSS FILLER1
XFILLER_114_242 VDD VSS FILLER1
XFILLER_102_415 VSS VDD FILLER2
XFILLER_115_798 VDD VSS FILLER1
XFILLER_87_115 VSS VDD FILLER2
XFILLER_88_638 VSS VDD FILLER2
XFILLER_102_448 VDD VSS FILLER4
XFILLER_114_297 VDD VSS FILLER1
Xclkbuf_leaf_2__000_ clkload77/A VDD VSS _19533_/CK BUFX12
XFILLER_29_727 VDD VSS DECAPHV16
XFILLER_68_351 VSS VDD FILLER2
XFILLER_83_332 VDD VSS DECAPHV32
X_09604_ _18442_/Q VDD VSS _20154_/A INVX1
XFILLER_44_708 VSS VDD FILLER2
XFILLER_56_568 VDD VSS FILLER1
XFILLER_24_410 VDD VSS FILLER4
XFILLER_24_421 VDD VSS FILLER1
XFILLER_43_218 VDD VSS FILLER1
X_09535_ _20030_/Q _18199_/A VDD VSS _20031_/D NOR2BX1
X_09466_ _18447_/D _09468_/B _09466_/C VDD VSS _18250_/D AOI21X1
XFILLER_24_487 VSS VDD FILLER2
XFILLER_40_925 VDD VSS FILLER1
X_09397_ _11273_/A VDD VSS _11378_/A BUFX3
XFILLER_137_345 VDD VSS FILLER1
XFILLER_138_868 VDD VSS FILLER1
XFILLER_22_44 VSS VDD FILLER2
XFILLER_4_804 VDD VSS FILLER4
XFILLER_4_815 VSS VDD FILLER2
XTAP_TAPCELL_ROW_137_1389 VDD VSS WELLTAP
X_10310_ _10312_/B _10310_/B _10310_/C VDD VSS _18552_/D AOI21X1
X_11290_ _11152_/Y _11363_/B _11370_/A VDD VSS _11291_/A MUXI2X1
X_10241_ _18624_/Q _11436_/C VDD VSS _10314_/C NOR2X1
XFILLER_79_627 VDD VSS FILLER4
X_10172_ _10172_/A _10172_/B _10172_/C _10172_/D VDD VSS _10173_/C AOAI211X1
XFILLER_121_779 VDD VSS FILLER1
XFILLER_78_137 VSS VDD FILLER2
XFILLER_78_148 VDD VSS FILLER4
X_14980_ _15026_/C _15026_/B VDD VSS _14981_/B NOR2BX1
XFILLER_87_682 VSS VDD FILLER2
XTAP_TAPCELL_ROW_49_508 VDD VSS WELLTAP
X_13931_ _13977_/A _13931_/B _13981_/D VDD VSS _13941_/C XNOR3X1
XFILLER_101_481 VDD VSS FILLER4
XFILLER_19_226 VDD VSS FILLER1
XFILLER_74_332 VSS VDD FILLER2
XFILLER_86_192 VDD VSS FILLER4
Xfanout194 _18508_/Q VDD VSS _09776_/A BUFX3
XFILLER_47_557 VDD VSS FILLER1
XFILLER_47_74 VSS VDD FILLER2
XFILLER_47_96 VDD VSS DECAPHV8
XFILLER_62_505 VDD VSS FILLER4
XTAP_TAPCELL_ROW_85_861 VDD VSS WELLTAP
X_13862_ _19032_/Q _13862_/B _13901_/D VDD VSS _13951_/C XOR3X1
X_16650_ _19607_/Q _16758_/B VDD VSS _16657_/A OR2X2
XFILLER_28_793 VSS VDD FILLER2
XTAP_TAPCELL_ROW_57_585 VDD VSS WELLTAP
X_12813_ _12813_/A _12813_/B _12813_/C VDD VSS _12819_/B XNOR3X1
X_13793_ _14392_/A _14392_/B _19114_/Q VDD VSS _13857_/C OAI21X1
X_16581_ _19669_/Q _16828_/B VDD VSS _16595_/B XOR2X1
X_15601_ _15576_/A _15601_/B _15601_/C VDD VSS _15824_/B AOI2B1X1
XFILLER_43_741 VSS VDD FILLER2
XFILLER_43_752 VDD VSS FILLER4
X_12744_ _19187_/Q _12827_/A _12827_/B VDD VSS _12746_/D XNOR3X1
X_18320_ _18324_/CK _18517_/Q _18320_/Q _09380_/B VDD VSS DFFRQX1
X_15532_ _15532_/A _15535_/B VDD VSS _18153_/B XNOR2X1
XFILLER_30_413 VDD VSS FILLER4
XTAP_TAPCELL_ROW_103_1046 VDD VSS WELLTAP
X_18251_ _18257_/CK _18251_/D _18266_/D _20078_/RB VDD VSS DFFRQX1
X_12675_ _12759_/A _12763_/C _12675_/C VDD VSS _12832_/C XNOR3X1
X_17202_ _17204_/C _17202_/B _17202_/C VDD VSS _19795_/D AOI21X1
X_15463_ _19378_/Q _15755_/B VDD VSS _15492_/A NOR2BX1
XTAP_TAPCELL_ROW_12_132 VDD VSS WELLTAP
X_11626_ _18768_/Q _11635_/B VDD VSS _18795_/D AND2X1
X_14414_ _14381_/Y _14414_/B _14414_/C VDD VSS _19134_/D AND3BX1
X_18182_ _18185_/C _18185_/B VDD VSS _18183_/B NAND2BX1
X_15394_ _15394_/A _15848_/B _15394_/C VDD VSS _15430_/B OAI21X1
X_11557_ _11648_/A VDD VSS _11567_/B BUFX3
X_14345_ _14352_/A _14345_/B _14345_/C VDD VSS _19072_/D NOR3X1
X_17133_ _19781_/Q _19749_/Q VDD VSS _17140_/C NOR2X1
XFILLER_128_389 VDD VSS DECAPHV8
XFILLER_144_838 VSS VDD FILLER2
X_10508_ _10544_/C _10544_/B VDD VSS _10509_/B NAND2BX1
X_17064_ _17064_/A _17064_/B VDD VSS _17066_/B _17064_/C _17064_/D NAND4X2
XFILLER_109_592 VSS VDD FILLER2
XFILLER_6_185 VSS VDD FILLER2
X_11488_ _18643_/Q _11496_/B VDD VSS _18670_/D AND2X1
X_14276_ _14285_/A _14276_/B VDD VSS _19012_/D NOR2X1
X_16015_ _16015_/A _16015_/B VDD VSS _16871_/B XNOR2X1
XTAP_TAPCELL_ROW_114_1153 VDD VSS WELLTAP
X_10439_ _18634_/Q _18796_/Q VDD VSS _10441_/C AND2X1
X_13227_ _13316_/A _13316_/B _13316_/D _13316_/C VDD VSS _14416_/B OAOI211X1
XFILLER_69_104 VDD VSS FILLER1
X_13158_ _19108_/Q _13219_/B _13231_/C VDD VSS _13364_/B XNOR3X1
X_12109_ _20000_/Q _19264_/Q VDD VSS _12233_/C XOR2X1
X_13089_ _18995_/Q _14257_/B VDD VSS _13192_/C _14257_/C AND3X2
X_17966_ _17966_/A _17966_/B _17966_/C _17966_/D VDD VSS _17967_/C OAI211X1
XFILLER_66_811 VSS VDD FILLER2
X_19705_ _19737_/CK _19705_/D _19705_/Q VDD VSS DFFQX1
X_16917_ _17047_/B VDD VSS _17073_/B BUFX3
XFILLER_38_524 VDD VSS DECAPHV8
XFILLER_78_693 VDD VSS FILLER4
XFILLER_93_630 VDD VSS DECAPHV16
X_17897_ _17898_/B _17898_/C _17901_/C _18087_/D VDD VSS _17898_/D AOAI211X1
XFILLER_26_708 VDD VSS FILLER4
XFILLER_38_568 VDD VSS FILLER1
XFILLER_92_151 VDD VSS FILLER1
X_19636_ _19636_/CK _19636_/D _19636_/Q VDD VSS DFFQX1
X_16848_ _16859_/A _16848_/B VDD VSS _19687_/D AND2X1
XFILLER_19_782 VSS VDD FILLER2
XFILLER_25_218 VSS VDD FILLER2
XFILLER_81_847 VDD VSS DECAPHV16
X_19567_ _19604_/CK _19567_/D _19567_/Q VDD VSS DFFQX1
X_16779_ _16793_/A _16779_/B VDD VSS _19625_/D AND2X1
X_09320_ _18290_/Q _18518_/Q _09299_/Y VDD VSS _09320_/Y MUXI2X1
X_18518_ _18518_/CK _18518_/D _18518_/Q _09322_/Y VDD VSS DFFRQX1
XFILLER_34_763 VDD VSS FILLER1
X_09251_ _18278_/Q _18277_/Q VDD VSS _09408_/C _18276_/Q AND3X2
X_19498_ _19521_/CK _19498_/D _19498_/Q VDD VSS DFFQX1
XFILLER_22_947 VSS VDD FILLER2
X_18449_ _18455_/CK _18449_/D _18449_/Q _18452_/RB VDD VSS DFFRQX1
XFILLER_134_304 VDD VSS DECAPHV8
XFILLER_135_827 VDD VSS FILLER4
XFILLER_108_14 VDD VSS FILLER4
XFILLER_108_36 VDD VSS FILLER1
XFILLER_115_573 VSS VDD FILLER2
XFILLER_115_584 VDD VSS DECAPHV16
XFILLER_130_521 VDD VSS FILLER1
XFILLER_88_402 VSS VDD FILLER2
XFILLER_130_576 VDD VSS DECAPHV8
XFILLER_84_641 VSS VDD FILLER2
XFILLER_17_33 VSS VDD FILLER2
XFILLER_44_538 VSS VDD FILLER2
XFILLER_140_45 VDD VSS FILLER1
XFILLER_140_67 VDD VSS DECAPHV8
XFILLER_44_549 VSS VDD FILLER2
XTAP_TAPCELL_ROW_54_555 VDD VSS WELLTAP
XTAP_TAPCELL_ROW_82_831 VDD VSS WELLTAP
X_09518_ _20018_/Q _20017_/Q _09520_/D VDD VSS _09519_/C OAI21X1
XFILLER_40_700 VDD VSS DECAPHV16
XTAP_TAPCELL_ROW_26_279 VDD VSS WELLTAP
X_10790_ _10790_/A _10790_/B _10790_/C _10790_/D VDD VSS _10856_/B OAI211X1
XFILLER_52_582 VSS VDD FILLER2
XTAP_TAPCELL_ROW_139_1407 VDD VSS WELLTAP
X_09449_ _09482_/C VDD VSS _09483_/B BUFX3
XFILLER_12_468 VDD VSS FILLER1
XFILLER_33_54 VDD VSS DECAPHV16
XFILLER_8_417 VDD VSS FILLER1
X_12460_ _12460_/A _14345_/B _14345_/C VDD VSS _12461_/D NOR3X1
XFILLER_123_2 VDD VSS FILLER1
XTAP_TAPCELL_ROW_4_58 VDD VSS WELLTAP
X_11411_ _11422_/A _17990_/B _11411_/C VDD VSS _18605_/D NOR3X1
X_12391_ _12391_/A _12391_/B _12391_/C _12391_/D VDD VSS _12571_/B AOAI211X1
XFILLER_138_687 VDD VSS DECAPHV8
X_11342_ _11343_/B _11342_/B VDD VSS _11345_/B NAND2X1
X_14130_ _14158_/A _14130_/B VDD VSS _18889_/D AND2X1
XFILLER_119_890 VDD VSS FILLER1
XFILLER_109_0 VDD VSS FILLER1
X_11273_ _11273_/A VDD VSS _11383_/A BUFX3
X_14061_ wire153/Y _14061_/B VDD VSS _14171_/B XOR2X1
XFILLER_134_882 VDD VSS FILLER1
X_10224_ _10224_/A _10224_/B _10224_/C _18621_/Q VDD VSS _10229_/B AOI211X1
X_13012_ _13021_/A _13021_/B _13091_/C VDD VSS _14320_/C NOR3X1
XFILLER_106_595 VDD VSS FILLER4
XFILLER_121_554 VDD VSS FILLER4
X_10155_ _10155_/A _10190_/C _10155_/C _10166_/D VDD VSS _10156_/C AOI211X1
X_17820_ _17823_/A _17823_/B _17828_/C VDD VSS _17821_/C OAI21X1
XFILLER_95_928 VSS VDD FILLER2
XFILLER_0_895 VDD VSS FILLER1
XFILLER_48_822 VDD VSS FILLER1
XFILLER_75_630 VDD VSS DECAPHV8
X_10086_ _10097_/A _10086_/B VDD VSS _10087_/B XNOR2X1
X_17751_ _17754_/C _17752_/B _17828_/C VDD VSS _17752_/C OAI21X1
X_14963_ _14966_/A _14966_/B _14966_/C VDD VSS _14963_/Y AOI21X1
XFILLER_47_365 VSS VDD FILLER2
X_13914_ _13967_/C _13965_/B _13914_/C VDD VSS _13958_/B XNOR3X1
X_17682_ _19898_/Q _19866_/Q _17746_/C VDD VSS _17683_/C OAI21X1
X_16702_ _19908_/Q _16702_/B VDD VSS _19556_/D AND2X1
X_14894_ _19309_/Q _15680_/B VDD VSS _14897_/A XNOR2X1
XFILLER_48_899 VDD VSS FILLER1
XFILLER_62_324 VDD VSS FILLER1
XFILLER_90_611 VSS VDD FILLER2
X_13845_ _13845_/A _14229_/B _13845_/C _13845_/D VDD VSS _13955_/A OAOI211X1
X_19421_ _19489_/CK _19421_/D _19421_/Q VDD VSS DFFQX1
X_16633_ _19639_/Q _16793_/B VDD VSS _16634_/B XNOR2X1
XFILLER_90_655 VDD VSS FILLER4
X_19352_ _19385_/CK _19352_/D _19352_/Q VDD VSS DFFQX1
X_10988_ _11364_/A _11235_/B _10988_/C VDD VSS _11026_/B OA21X2
X_13776_ _13783_/A _14297_/B _13783_/C VDD VSS _14298_/C NOR3X1
X_18303_ _18311_/CK _18516_/Q _18303_/Q _18471_/RB VDD VSS DFFRQX1
X_16564_ _16566_/B _16564_/B VDD VSS _16565_/B XOR2X1
XFILLER_15_284 VDD VSS FILLER1
X_12727_ _12809_/A _12819_/A _12910_/B VDD VSS _12729_/C XNOR3X1
X_19283_ _19290_/CK _19283_/D _19283_/Q VDD VSS DFFQX1
X_16495_ _19633_/Q _16495_/B _16787_/B VDD VSS _16521_/B MIN3X1
X_15515_ _15515_/A _15515_/B _15515_/C VDD VSS _15885_/B AOI21X1
X_12658_ _12840_/A _12840_/B _12658_/C VDD VSS _14473_/B NOR3X1
Xclkbuf_2_1__f__001_ clkbuf_0__001_/Y VDD VSS clkbuf_2_1__f__001_/Y BUFX12
Xclkbuf_leaf_1__001_ clkbuf_leaf_5__001_/A VDD VSS _20006_/CK BUFX12
X_18234_ _18234_/CK _18234_/E _18234_/ECK VDD VSS CGX3
X_15446_ _15469_/B _15446_/B VDD VSS _15819_/B XNOR2X1
XFILLER_128_120 VSS VDD FILLER2
XFILLER_129_632 VSS VDD FILLER2
XFILLER_129_654 VDD VSS FILLER4
X_11609_ _11609_/A _11641_/B VDD VSS _18780_/D NOR2X1
X_18165_ _19299_/Q _18169_/B VDD VSS _18167_/C XOR2X1
XFILLER_128_153 VDD VSS DECAPHV8
XFILLER_129_676 VDD VSS DECAPHV8
X_12589_ _19186_/Q _12649_/B _12658_/C VDD VSS _12655_/C XNOR3X1
X_17116_ _17118_/C _17117_/B _17164_/C VDD VSS _17117_/C OAI21X1
X_15377_ _15425_/B _15377_/B VDD VSS _15722_/B NOR2BX1
XFILLER_7_472 VDD VSS FILLER1
X_14328_ _14339_/A _14328_/B VDD VSS _19057_/D NOR2X1
X_18096_ _18096_/A _18096_/B VDD VSS _18100_/C NAND2X1
XFILLER_98_700 VDD VSS DECAPHV8
XFILLER_99_80 VDD VSS FILLER1
X_14259_ _14294_/A _14259_/B _14259_/C VDD VSS _18997_/D NOR3X1
X_17047_ _19763_/Q _17047_/B VDD VSS _17064_/B XOR2X1
XFILLER_131_318 VDD VSS DECAPHV8
XFILLER_143_189 VDD VSS DECAPHV8
Xmax_cap169 _09426_/A VDD VSS _09446_/A BUFX4
XFILLER_140_852 VSS VDD FILLER2
XFILLER_97_221 VDD VSS DECAPHV8
XFILLER_100_705 VDD VSS FILLER1
XFILLER_24_0 VSS VDD FILLER2
XFILLER_85_416 VDD VSS DECAPHV8
XFILLER_98_788 VSS VDD FILLER2
X_18998_ _19001_/CK _18998_/D _18998_/Q VDD VSS DFFQX1
XFILLER_39_833 VDD VSS FILLER4
XFILLER_39_844 VSS VDD FILLER2
XFILLER_57_129 VDD VSS FILLER1
XFILLER_85_449 VDD VSS FILLER4
X_17949_ _18866_/Q _17949_/B VDD VSS _17958_/A NOR2BX1
XTAP_TAPCELL_ROW_96_978 VDD VSS WELLTAP
XFILLER_53_324 VDD VSS FILLER4
XFILLER_81_611 VSS VDD FILLER2
XFILLER_81_622 VDD VSS FILLER1
X_19619_ _19678_/CK _19619_/D _19619_/Q VDD VSS DFFQX1
XFILLER_65_184 VSS VDD FILLER2
XFILLER_22_700 VDD VSS FILLER4
XTAP_TAPCELL_ROW_51_525 VDD VSS WELLTAP
X_09303_ _18456_/D _09300_/Y _09302_/Y VDD VSS _18525_/D MUXI2X1
XTAP_TAPCELL_ROW_23_249 VDD VSS WELLTAP
X_09234_ _18516_/Q VDD VSS _18351_/D INVX1
Xclkbuf_leaf_20__000_ clkload79/A VDD VSS _19606_/CK BUFX12
XFILLER_107_359 VDD VSS FILLER4
XFILLER_123_819 VDD VSS FILLER4
XTAP_TAPCELL_ROW_134_1359 VDD VSS WELLTAP
Xclkbuf_leaf_35__000_ clkload77/A VDD VSS _19435_/CK BUFX12
XFILLER_122_318 VSS VDD FILLER2
XFILLER_0_114 VDD VSS FILLER1
Xclkbuf_1_1__f_clk clkbuf_0_clk/Y VDD VSS _232_/CK BUFX12
XFILLER_76_405 VSS VDD FILLER2
XTAP_TAPCELL_ROW_59_603 VDD VSS WELLTAP
X_09998_ _18600_/Q _09998_/B _09998_/C VDD VSS _10011_/B AOI21X1
X_20187_ _20187_/A VDD VSS _20187_/Y BUFX3
XFILLER_48_129 VDD VSS DECAPHV8
X_11960_ _19065_/Q _11960_/B _12014_/B VDD VSS _12080_/B MIN3X1
XFILLER_28_87 VDD VSS FILLER1
XFILLER_44_302 VDD VSS DECAPHV16
XFILLER_57_674 VSS VDD FILLER2
X_10911_ _10876_/Y _10910_/Y _10945_/A VDD VSS _10911_/Y MUXI2X1
XFILLER_45_869 VDD VSS FILLER4
XFILLER_72_655 VDD VSS FILLER4
X_11891_ _19176_/Q _11891_/B _11918_/C VDD VSS _12035_/C XNOR3X1
XFILLER_32_508 VSS VDD FILLER2
X_10842_ _10699_/Y _10841_/Y _10843_/A VDD VSS _10845_/B MUXI2X1
X_13630_ _13640_/A _13640_/B _13630_/C VDD VSS _14422_/C OAI21X1
XFILLER_44_75 VDD VSS FILLER4
X_10773_ _11116_/A _10773_/B VDD VSS _10774_/B NOR2X1
X_13561_ _19168_/Q _13637_/D _13561_/C VDD VSS _13630_/C XNOR3X1
XFILLER_9_715 VSS VDD FILLER2
XFILLER_9_726 VDD VSS FILLER1
XTAP_TAPCELL_ROW_100_1016 VDD VSS WELLTAP
X_12512_ _12512_/A _12512_/B _14343_/B VDD VSS _14310_/B XNOR3X1
X_16280_ _19625_/Q _16779_/B VDD VSS _16292_/A NAND2BX1
X_15300_ _19346_/Q _15720_/B _15300_/C VDD VSS _15341_/B AOI21X1
XFILLER_40_574 VDD VSS FILLER4
XFILLER_40_596 VDD VSS FILLER1
X_13492_ _13492_/A _13502_/D VDD VSS _14128_/B XNOR2X1
X_15231_ _15275_/A _15275_/C _15193_/B VDD VSS _15232_/C AOI21BX1
X_12443_ _19044_/Q VDD VSS _12515_/C INVX1
XFILLER_126_624 VSS VDD FILLER2
X_12374_ _19154_/Q _14437_/B _14437_/C VDD VSS _12378_/D OR3BX1
X_15162_ _19399_/Q _15778_/B VDD VSS _15178_/B XNOR2X1
X_11325_ _11364_/B _11325_/B _11325_/C _11325_/D VDD VSS _11333_/B OAOI211X1
X_14113_ _14158_/A _14113_/B VDD VSS _18873_/D AND2X1
X_19970_ _19986_/CK _19970_/D _19970_/Q VDD VSS DFFQX1
X_15093_ _15139_/A _15139_/B VDD VSS _15116_/A NAND2X1
XFILLER_140_115 VDD VSS FILLER1
XFILLER_5_69 VDD VSS FILLER1
X_11256_ _11181_/Y _11298_/B _11298_/A VDD VSS _11341_/B MUXI2X1
X_14044_ _18979_/Q _14235_/B VDD VSS _14068_/A NOR2X1
X_18921_ _18950_/CK _18921_/D _18921_/Q VDD VSS DFFQX1
XFILLER_140_137 VSS VDD FILLER2
XTAP_TAPCELL_ROW_111_1123 VDD VSS WELLTAP
X_10207_ _18619_/Q _10207_/B VDD VSS _10217_/B NAND2X1
X_11187_ _11217_/B _11217_/C VDD VSS _11188_/B NAND2BX1
X_18852_ _18878_/CK _18852_/D _18852_/Q VDD VSS DFFQX1
XFILLER_95_747 VDD VSS FILLER4
X_10138_ _18588_/Q _10138_/B VDD VSS _10163_/C NOR2BX1
X_18783_ _18785_/CK _18783_/D _18783_/Q VDD VSS DFFQX1
X_17803_ _17803_/A _17803_/B _17803_/C VDD VSS _17807_/C MIN3X1
X_15995_ _15965_/A _15995_/B _15995_/C VDD VSS _16038_/C AOI2B1X1
XFILLER_85_60 VDD VSS DECAPHV16
X_10069_ _10055_/Y _10068_/Y _10127_/A VDD VSS _10069_/Y MUX2X1
X_17734_ _17738_/A _17735_/B _17746_/C VDD VSS _17735_/C OAI21X1
X_14946_ _14952_/B _14946_/B VDD VSS _15681_/B XNOR2X1
XFILLER_48_696 VDD VSS FILLER1
XTAP_TAPCELL_ROW_93_948 VDD VSS WELLTAP
XFILLER_36_858 VDD VSS FILLER1
XFILLER_47_184 VSS VDD FILLER2
X_17665_ _17667_/A _17667_/B _17665_/C VDD VSS _19894_/D AOI21X1
X_14877_ _19529_/Q _19530_/Q _14877_/C _19531_/Q VDD VSS _14921_/C AOI31X1
XFILLER_23_519 VDD VSS FILLER1
X_13828_ _13845_/A _14229_/B _13845_/C VDD VSS _14230_/B OAI21X1
X_19404_ _19425_/CK _19404_/D _19404_/Q VDD VSS DFFQX1
X_17596_ _19879_/Q _19847_/Q _17596_/C VDD VSS _17600_/C MIN3X1
X_16616_ _16616_/A _16616_/B _16616_/C VDD VSS _16643_/B OA21X2
XFILLER_16_582 VDD VSS FILLER1
XFILLER_62_198 VDD VSS FILLER1
X_13759_ _18974_/Q VDD VSS _13770_/A INVX1
X_19335_ _19337_/CK _19335_/D _19335_/Q VDD VSS DFFQX1
X_16547_ _19603_/Q _16754_/B VDD VSS _16548_/C NOR2X1
X_19266_ _20005_/CK _19266_/D _19266_/Q VDD VSS DFFQX1
XFILLER_31_585 VDD VSS FILLER4
XFILLER_86_2 VDD VSS FILLER1
XTAP_TAPCELL_ROW_20_219 VDD VSS WELLTAP
X_18217_ _18217_/CK _18217_/E _18217_/ECK VDD VSS CGX3
X_16478_ _16498_/C _16478_/B VDD VSS _16501_/A XNOR2X1
X_19197_ _19197_/CK _19197_/D _19197_/Q VDD VSS DFFQX1
X_15429_ _15429_/A _15429_/B VDD VSS _15449_/B AND2X1
XFILLER_116_112 VDD VSS FILLER1
XFILLER_117_613 VDD VSS FILLER4
X_18148_ _19295_/Q _18149_/B VDD VSS _18150_/B NOR2X1
XFILLER_116_123 VSS VDD FILLER2
XFILLER_144_443 VDD VSS FILLER4
X_18079_ _19282_/Q _18079_/B VDD VSS _18083_/A NAND2X1
XFILLER_144_498 VDD VSS DECAPHV32
X_09921_ _18563_/Q _10927_/C VDD VSS _09922_/B XNOR2X1
X_20110_ _20110_/A VDD VSS _20110_/Y BUFX3
Xhold258 hold261/Y VDD VSS hold262/A BUFX3
XFILLER_112_362 VDD VSS FILLER4
XFILLER_113_885 VDD VSS FILLER4
XFILLER_131_159 VSS VDD FILLER2
X_09852_ _10268_/B VDD VSS _10927_/C BUFX3
X_20041_ _20043_/CK _20041_/D _20041_/Q _20043_/RB VDD VSS DFFRQX1
Xclkbuf_1_1__f__09175_ clkbuf_0__09175_/Y VDD VSS _18272_/CK BUFX12
XFILLER_105_26 VDD VSS FILLER1
XFILLER_140_693 VDD VSS FILLER4
XFILLER_85_213 VDD VSS FILLER4
X_09783_ _18405_/Q _09783_/B _09783_/C VDD VSS _09784_/E OAI21X1
XFILLER_26_346 VDD VSS FILLER1
XFILLER_27_847 VSS VDD FILLER2
XFILLER_121_69 VDD VSS FILLER4
XFILLER_42_817 VDD VSS FILLER4
XFILLER_81_463 VSS VDD FILLER2
XTAP_TAPCELL_ROW_36_374 VDD VSS WELLTAP
XFILLER_14_12 VDD VSS FILLER1
XFILLER_22_585 VDD VSS FILLER4
XFILLER_50_894 VSS VDD FILLER2
XFILLER_108_602 VSS VDD FILLER2
X_09217_ _18500_/D VDD VSS _18404_/D INVX1
XFILLER_135_476 VDD VSS FILLER1
XTAP_TAPCELL_ROW_1_26 VDD VSS WELLTAP
X_11110_ _11132_/D _11132_/B VDD VSS _11111_/B NAND2BX1
XFILLER_107_189 VDD VSS FILLER4
X_12090_ _19178_/Q _14464_/B VDD VSS _12116_/A NAND2X1
X_11041_ _11067_/C _11041_/B _11041_/C _11041_/D VDD VSS _11047_/C OAOI211X1
XFILLER_103_395 VSS VDD FILLER2
XFILLER_49_427 VSS VDD FILLER2
XFILLER_77_747 VDD VSS FILLER4
XFILLER_76_235 VDD VSS DECAPHV8
XFILLER_76_257 VDD VSS FILLER1
Xclkbuf_leaf_0__002_ clkload17/A VDD VSS _19937_/CK BUFX12
X_14800_ _14800_/A _14800_/B _15737_/B VDD VSS _14810_/C MIN3X1
XFILLER_73_920 VDD VSS FILLER4
XFILLER_76_279 VDD VSS DECAPHV8
X_12992_ _12992_/A _12992_/B _14186_/B VDD VSS _13086_/B MIN3X1
X_15780_ _15780_/A _15780_/B VDD VSS _19400_/D NOR2X1
XFILLER_45_633 VDD VSS FILLER4
X_11943_ _19091_/Q _11943_/B _14367_/B VDD VSS _14335_/B XNOR3X1
X_14731_ _19446_/Q VDD VSS _14778_/A INVX1
XFILLER_45_677 VDD VSS FILLER1
XFILLER_55_96 VDD VSS DECAPHV16
XTAP_TAPCELL_ROW_90_918 VDD VSS WELLTAP
X_11874_ _11874_/A _11874_/B _11874_/C _11874_/D VDD VSS _12035_/B OAOI211X1
X_14662_ _19415_/Q _14669_/B _15797_/B VDD VSS _15765_/B XNOR3X1
X_17450_ _17600_/B _17450_/B _17450_/C VDD VSS _17455_/C MIN3X1
X_10825_ _18699_/Q _18753_/Q VDD VSS _10827_/B XNOR2X1
X_13613_ _19029_/Q VDD VSS _13839_/A INVX1
X_17381_ _19834_/Q _19802_/Q _17452_/C VDD VSS _17382_/C OAI21X1
X_16401_ _16402_/A _16402_/B _16402_/C VDD VSS _16429_/B AOI21X1
XFILLER_13_552 VDD VSS FILLER1
XFILLER_25_390 VDD VSS FILLER1
X_14593_ _19440_/Q _15825_/B VDD VSS _14639_/B NOR2X1
X_19120_ _19121_/CK _19120_/D _19120_/Q VDD VSS DFFQX1
X_16332_ _16329_/B _16332_/B _16332_/C VDD VSS _16355_/A AOI2B1X1
X_10756_ _10798_/A _10756_/B VDD VSS _10762_/B XNOR2X1
X_13544_ _19167_/Q _13637_/A _13549_/B VDD VSS _13546_/C XNOR3X1
X_10687_ _18640_/Q _18802_/Q _10687_/C VDD VSS _10715_/A MIN3X1
X_13475_ _18999_/Q _13607_/A _13683_/B VDD VSS _13594_/D XNOR3X1
X_19051_ _19064_/CK _19051_/D _19051_/Q VDD VSS DFFQX1
X_16263_ _19625_/Q _16779_/B VDD VSS _16281_/B XNOR2X1
X_12426_ _12441_/A _12441_/B _14248_/B VDD VSS _14211_/B XNOR3X1
X_18002_ _18546_/Q _18547_/Q VDD VSS _18055_/B _18052_/B NAND3X1
X_16194_ _16201_/B _16194_/B VDD VSS _16882_/B XNOR2X1
X_15214_ _15217_/B _15214_/B VDD VSS _18107_/B XNOR2X1
X_15145_ _15145_/A _15145_/B _15145_/C _15145_/D VDD VSS _15191_/B OAOI211X1
XFILLER_126_465 VSS VDD FILLER2
X_12357_ _12357_/A _12357_/B _14281_/B VDD VSS _12442_/B MIN3X1
XFILLER_113_137 VDD VSS FILLER4
X_11308_ _11308_/A _11308_/B VDD VSS _11319_/B _11308_/C AND3X2
X_12288_ _12288_/A _14309_/B _12288_/C VDD VSS _14279_/A MIN3X1
X_19953_ _19957_/CK _19953_/D _19953_/Q VDD VSS DFFQX1
X_15076_ _15126_/B _15076_/B VDD VSS _15684_/B XNOR2X1
XFILLER_122_660 VDD VSS FILLER4
XFILLER_141_457 VDD VSS DECAPHV8
XFILLER_141_468 VSS VDD FILLER2
X_11239_ _11249_/C _11239_/B _11239_/C VDD VSS _18578_/D AOI21X1
X_14027_ _18923_/Q VDD VSS _14054_/A INVX1
X_19884_ clkload8/A _19884_/D _19884_/Q VDD VSS DFFQX1
X_18904_ _18935_/CK _18904_/D _18904_/Q VDD VSS DFFQX1
XFILLER_122_671 VDD VSS DECAPHV8
XFILLER_95_522 VSS VDD FILLER2
X_18835_ _19951_/CK _18835_/D _18835_/Q VDD VSS DFFQX1
XFILLER_67_235 VDD VSS FILLER1
XFILLER_96_81 VDD VSS FILLER4
XFILLER_55_419 VDD VSS FILLER4
XFILLER_82_216 VDD VSS FILLER4
XTAP_TAPCELL_ROW_78_797 VDD VSS WELLTAP
X_18766_ _18820_/CK _18766_/D _18766_/Q VDD VSS DFFQX1
X_15978_ _19643_/Q _16800_/B VDD VSS _15979_/B XNOR2X1
XFILLER_75_290 VSS VDD FILLER2
X_18697_ _18779_/CK _18697_/D _18697_/Q VDD VSS DFFQX1
X_17717_ _19906_/Q _19874_/Q VDD VSS _17718_/B XOR2X1
X_14929_ _19478_/Q _15869_/B VDD VSS _14957_/B XOR2X1
X_17648_ _19890_/Q _19858_/Q _17648_/C VDD VSS _17653_/C AO21X2
Xclkbuf_leaf_34__001_ clkbuf_2_1__f__001_/Y VDD VSS _19126_/CK BUFX12
XFILLER_91_0 VSS VDD FILLER2
XTAP_TAPCELL_ROW_33_344 VDD VSS WELLTAP
X_17579_ _17581_/A _17581_/B _17579_/C VDD VSS _19876_/D AOI21X1
XFILLER_31_371 VDD VSS FILLER1
X_19318_ _19322_/CK _19318_/D _19318_/Q VDD VSS DFFQX1
X_19249_ _20013_/CK _19249_/D _19249_/Q VDD VSS DFFQX1
XFILLER_144_251 VDD VSS FILLER1
XFILLER_144_273 VDD VSS FILLER4
XTAP_TAPCELL_ROW_131_1329 VDD VSS WELLTAP
XFILLER_120_619 VDD VSS FILLER1
X_09904_ _09899_/Y _10005_/B _09944_/A VDD VSS _09915_/B MUX2X1
XFILLER_116_69 VSS VDD FILLER2
XFILLER_86_533 VSS VDD FILLER2
XFILLER_98_382 VDD VSS DECAPHV8
XFILLER_99_894 VDD VSS FILLER1
X_09835_ _10258_/D VDD VSS _10803_/A BUFX3
X_20024_ _20045_/CK _20024_/D _20024_/Q _20031_/RB VDD VSS DFFRQX1
XFILLER_100_332 VDD VSS FILLER1
XFILLER_58_235 VDD VSS FILLER1
XFILLER_39_460 VDD VSS FILLER4
XFILLER_55_920 VDD VSS DECAPHV8
XFILLER_58_279 VDD VSS FILLER4
XFILLER_86_588 VDD VSS DECAPHV16
X_09766_ _18308_/Q _09797_/B _09766_/C _18468_/Q VDD VSS _09768_/C AOI22X1
X_09697_ _18463_/Q _09766_/C _09770_/C _20089_/A _09697_/E VDD VSS _09698_/B AOI221X1
XFILLER_15_817 VDD VSS FILLER4
XFILLER_92_28 VDD VSS FILLER1
XTAP_TAPCELL_ROW_142_1436 VDD VSS WELLTAP
XFILLER_25_22 VDD VSS DECAPHV32
XFILLER_27_699 VDD VSS FILLER1
XFILLER_42_647 VDD VSS FILLER1
XFILLER_54_474 VSS VDD FILLER2
XFILLER_10_500 VSS VDD FILLER2
X_10610_ _18666_/Q _18774_/Q VDD VSS _10642_/C NAND2X1
X_11590_ _11648_/A VDD VSS _11600_/B BUFX3
X_10541_ _10548_/C _10541_/B VDD VSS _10542_/B XOR2X1
XFILLER_109_911 VDD VSS DECAPHV16
XFILLER_109_933 VDD VSS DECAPHV16
XFILLER_6_504 VDD VSS FILLER4
X_13260_ _13260_/A _13343_/A _13345_/C VDD VSS _13262_/B AOI21BX1
XFILLER_108_421 VSS VDD FILLER2
XFILLER_108_432 VDD VSS FILLER1
XFILLER_6_548 VDD VSS DECAPHV8
X_10472_ _10472_/A _10472_/B _10472_/C VDD VSS _10474_/C AOI21X1
X_12211_ _19098_/Q VDD VSS _12299_/A INVX1
XFILLER_108_454 VSS VDD FILLER2
XFILLER_135_262 VDD VSS DECAPHV8
X_13191_ _13192_/A _13192_/B _13192_/D _13192_/C VDD VSS _14219_/C AOI211X1
Xdelaybuf_4_clk clk VDD VSS delaybuf_5_clk/A BUFX12
XFILLER_97_809 VDD VSS FILLER1
X_12142_ _12149_/A _12149_/B _12149_/C VDD VSS _14373_/C OR3X2
X_12073_ _19038_/Q VDD VSS _12076_/A INVX1
X_16950_ _16953_/C _16951_/B _17081_/C VDD VSS _16951_/C OAI21X1
XFILLER_1_286 VSS VDD FILLER2
XFILLER_49_224 VSS VDD FILLER2
XFILLER_77_522 VDD VSS FILLER1
XFILLER_77_533 VDD VSS DECAPHV8
X_11024_ _11378_/A _11024_/B _11055_/B VDD VSS _18571_/D AND3BX1
X_15901_ _15906_/A _15901_/B VDD VSS _19507_/D NOR2X1
XFILLER_49_246 VDD VSS FILLER4
X_16881_ _16891_/A _16881_/B VDD VSS _19717_/D NOR2X1
XFILLER_18_611 VSS VDD FILLER2
XFILLER_66_40 VSS VDD FILLER2
XFILLER_77_588 VDD VSS DECAPHV8
X_18620_ _18622_/CK _18620_/D _18620_/Q VDD VSS DFFQX1
X_15832_ _15849_/A _15832_/B VDD VSS _19447_/D AND2X1
X_12975_ _13020_/A _12975_/B _13102_/D VDD VSS _13091_/C XNOR3X1
X_18551_ _18571_/CK _18551_/D _18551_/Q VDD VSS DFFQX1
X_15763_ _15780_/A _15763_/B VDD VSS _19385_/D NOR2X1
XTAP_TAPCELL_ROW_75_767 VDD VSS WELLTAP
X_11926_ _11933_/A _14525_/B VDD VSS _14526_/A _11980_/C NAND3X1
X_18482_ _18487_/CK _18498_/D _20127_/A _18485_/RB VDD VSS DFFRQX1
X_17502_ _19860_/Q _19828_/Q VDD VSS _17505_/A XNOR2X1
X_14714_ _14785_/B VDD VSS _14746_/B INVX1
XFILLER_18_688 VDD VSS DECAPHV8
XFILLER_60_400 VDD VSS FILLER1
XTAP_TAPCELL_ROW_106_1077 VDD VSS WELLTAP
X_17433_ _19845_/Q _19813_/Q VDD VSS _17439_/B NAND2X1
X_15694_ _15817_/A VDD VSS _15710_/A BUFX3
XFILLER_32_146 VSS VDD FILLER2
XFILLER_33_647 VDD VSS FILLER4
XFILLER_33_658 VSS VDD FILLER2
XFILLER_60_433 VSS VDD FILLER2
X_11857_ _11908_/A _11943_/B _14367_/B VDD VSS _11861_/C XNOR3X1
X_14645_ _14645_/A _14645_/B _14645_/C _14645_/D VDD VSS _14652_/A AOAI211X1
X_10808_ _11255_/A _10808_/B _10808_/C VDD VSS _10808_/Y OA21X2
X_11788_ _19118_/Q VDD VSS _11865_/A INVX1
X_14576_ _19467_/Q VDD VSS _14594_/A INVX1
X_17364_ _17366_/A _17366_/B _17364_/C VDD VSS _19830_/D AOI21X1
XFILLER_13_371 VDD VSS FILLER1
XFILLER_41_680 VDD VSS DECAPHV8
XTAP_TAPCELL_ROW_30_314 VDD VSS WELLTAP
X_10739_ _10960_/A _11018_/B _10739_/C VDD VSS _10785_/B OAI21X1
X_13527_ _19110_/Q _14388_/B _14388_/C VDD VSS _13528_/D OR3BX1
Xclkbuf_1_0__f__09178_ clkbuf_0__09178_/Y VDD VSS _20045_/CK BUFX12
X_19103_ _19129_/CK _19103_/D _19103_/Q VDD VSS DFFQX1
X_17295_ _19816_/Q _19784_/Q VDD VSS _17298_/A XNOR2X1
X_16315_ _16340_/C _16315_/B VDD VSS _16745_/B XNOR2X1
X_19034_ _19172_/CK _19034_/D _19034_/Q VDD VSS DFFQX1
X_16246_ _19720_/Q _16884_/B VDD VSS _16247_/B XNOR2X1
X_13458_ _19194_/Q _14481_/B _14481_/C VDD VSS _13459_/D OR3BX1
XFILLER_127_763 VSS VDD FILLER2
XFILLER_142_700 VSS VDD FILLER2
X_12409_ _12577_/A _12577_/B _12577_/D VDD VSS _12413_/B AOI21X1
X_13389_ _13578_/A _13578_/B _13578_/C VDD VSS _13492_/A AOI21X1
Xoutput116 _20185_/Y VDD VSS o_tst_ctrl[4] BUFX3
Xoutput105 _20180_/Y VDD VSS o_rst_ctrl_b[1] BUFX3
X_16177_ _16177_/A _16177_/B _16177_/C VDD VSS _16203_/B OA21X2
XTAP_TAPCELL_ROW_117_1184 VDD VSS WELLTAP
Xoutput149 _20204_/Y VDD VSS o_uwb_tx_cfg[7] BUFX3
Xoutput138 _20221_/Y VDD VSS o_uwb_tx_cfg[24] BUFX3
Xoutput127 _20211_/Y VDD VSS o_uwb_tx_cfg[14] BUFX3
X_15128_ _19314_/Q _15685_/B VDD VSS _15129_/B XNOR2X1
XFILLER_142_777 VDD VSS FILLER1
XFILLER_99_168 VSS VDD FILLER2
X_19936_ clkload3/A _19936_/D _19936_/Q VDD VSS DFFQX1
X_15059_ _19535_/Q _15146_/C VDD VSS _15144_/B XOR2X1
XFILLER_141_298 VDD VSS FILLER4
XFILLER_110_652 VDD VSS FILLER4
X_19867_ _19903_/CK _19867_/D _19867_/Q VDD VSS DFFQX1
XFILLER_68_599 VDD VSS FILLER4
XFILLER_96_886 VSS VDD FILLER2
X_09620_ _18443_/Q VDD VSS _20155_/A INVX1
X_19798_ _19830_/CK _19798_/D _19798_/Q VDD VSS DFFQX1
X_18818_ _19963_/CK _18818_/D _18818_/Q VDD VSS DFFQX1
X_09551_ _18440_/Q VDD VSS _20152_/A INVX1
X_18749_ _18828_/CK _18749_/D _18749_/Q VDD VSS DFFQX1
XFILLER_52_912 VSS VDD FILLER2
XTAP_TAPCELL_ROW_128_1291 VDD VSS WELLTAP
XFILLER_24_636 VSS VDD FILLER2
XFILLER_51_422 VDD VSS DECAPHV8
X_09482_ _19980_/Q _09490_/B _09482_/C VDD VSS _09483_/C AOI21X1
XFILLER_23_146 VDD VSS FILLER1
XTAP_TAPCELL_ROW_18_193 VDD VSS WELLTAP
XTAP_TAPCELL_ROW_46_480 VDD VSS WELLTAP
XFILLER_11_24 VDD VSS DECAPHV8
XFILLER_20_897 VDD VSS DECAPHV8
XFILLER_106_925 VDD VSS FILLER1
XFILLER_117_295 VDD VSS DECAPHV8
XFILLER_105_468 VSS VDD FILLER2
XFILLER_132_254 VDD VSS FILLER4
XFILLER_133_755 VDD VSS FILLER1
XFILLER_133_777 VSS VDD FILLER2
X_09818_ _20081_/Q _09818_/B _09818_/C _18275_/Q _09818_/E VDD VSS _09819_/C AOI221X1
X_20007_ _20008_/CK _20007_/D _20007_/Q VDD VSS DFFQX1
X_09749_ _20174_/A _09784_/C _09797_/C _20223_/A VDD VSS _09751_/C AOI22X1
XFILLER_55_761 VSS VDD FILLER2
XFILLER_14_102 VDD VSS DECAPHV8
XFILLER_14_113 VDD VSS DECAPHV8
XFILLER_55_783 VDD VSS FILLER4
XFILLER_61_219 VDD VSS FILLER1
XTAP_TAPCELL_ROW_72_737 VDD VSS WELLTAP
X_12760_ _12835_/A _14506_/B _12835_/D _12760_/D VDD VSS _12968_/A OAOI211X1
XFILLER_15_647 VDD VSS FILLER1
XFILLER_70_753 VDD VSS FILLER1
X_11711_ _19198_/Q _11739_/B _11714_/C VDD VSS _14455_/B XNOR3X1
X_12691_ _12892_/A _12868_/A _12709_/C VDD VSS _12896_/D XNOR3X1
X_11642_ _18783_/Q _11647_/B VDD VSS _18810_/D AND2X1
X_14430_ _14467_/A _14430_/B VDD VSS _19147_/D AND2X1
XFILLER_11_820 VDD VSS FILLER1
XFILLER_11_842 VDD VSS FILLER1
XFILLER_139_0 VDD VSS DECAPHV16
X_14361_ _14368_/A _14361_/B VDD VSS _19085_/D NOR2X1
XFILLER_10_330 VDD VSS FILLER1
X_11573_ _18720_/Q _11578_/B VDD VSS _18747_/D AND2X1
X_13312_ _14324_/B _13416_/C _19053_/Q VDD VSS _13406_/C AND3BX1
X_16100_ _16100_/A _16100_/B VDD VSS _19522_/D NOR2X1
XFILLER_7_868 VDD VSS FILLER4
X_10524_ _18690_/Q _18744_/Q VDD VSS _10525_/D NAND2X1
X_14292_ _14311_/A _14292_/B VDD VSS _19025_/D NOR2X1
X_17080_ _17095_/A _17080_/B VDD VSS _19769_/D NOR2X1
XFILLER_124_700 VDD VSS FILLER4
XFILLER_6_378 VDD VSS FILLER1
X_10455_ _10521_/B _10455_/B _10721_/D VDD VSS _10462_/C OR3BX1
X_13243_ _14541_/B _14541_/C _13244_/A VDD VSS _13444_/B OAI21X1
X_16031_ _19647_/Q _16031_/B _16804_/B VDD VSS _16057_/A MIN3X1
XFILLER_123_210 VDD VSS DECAPHV8
XFILLER_124_733 VDD VSS DECAPHV8
X_13174_ _13290_/A _13290_/B VDD VSS _14157_/B XNOR2X1
XFILLER_97_617 VDD VSS FILLER4
X_10386_ _10512_/A _10435_/A _10435_/B _10386_/D VDD VSS _10701_/C OAI31X1
X_12125_ _12132_/A _12132_/B _14242_/B VDD VSS _14207_/B XNOR3X1
XFILLER_117_90 VSS VDD FILLER2
XFILLER_124_788 VSS VDD FILLER2
XFILLER_2_584 VDD VSS DECAPHV8
X_17982_ _18872_/Q _17982_/B VDD VSS _17989_/A XOR2X1
XFILLER_111_438 VDD VSS DECAPHV16
XFILLER_78_842 VDD VSS FILLER1
X_12056_ _12108_/A _12108_/B VDD VSS _12101_/C NOR2X1
X_19721_ _19736_/CK _19721_/D _19721_/Q VDD VSS DFFQX1
X_16933_ _19741_/Q wire163/Y _16933_/C VDD VSS _16937_/B MIN3X1
XFILLER_65_503 VSS VDD FILLER2
X_11007_ _11007_/A _11007_/B _11007_/C VDD VSS _11009_/B AO21X2
X_19652_ _19737_/CK _19652_/D _19652_/Q VDD VSS DFFQX1
X_16864_ _16899_/A _16864_/B VDD VSS _19702_/D AND2X1
XFILLER_65_547 VDD VSS DECAPHV8
XFILLER_92_322 VSS VDD FILLER2
XTAP_TAPCELL_ROW_88_892 VDD VSS WELLTAP
X_18603_ _18608_/CK _18603_/D _18603_/Q VDD VSS DFFQX1
X_15815_ _15816_/A _15815_/B VDD VSS _19431_/D NOR2X1
XFILLER_92_355 VDD VSS FILLER1
X_19583_ _19615_/CK _19583_/D _19583_/Q VDD VSS DFFQX1
X_16795_ _16795_/A VDD VSS _16843_/A BUFX3
XFILLER_80_539 VDD VSS DECAPHV8
X_12958_ _20010_/Q _19274_/Q VDD VSS _13255_/A OR2X2
X_18534_ _18550_/CK _18534_/D _18534_/Q VDD VSS DFFQX1
X_15746_ _15770_/A _15746_/B VDD VSS _19369_/D AND2X1
XFILLER_33_433 VDD VSS FILLER4
XFILLER_73_591 VSS VDD FILLER2
X_11909_ _19092_/Q _11909_/B _11958_/C VDD VSS _12023_/B MIN3X1
X_12889_ _13004_/B _12890_/C _18965_/Q VDD VSS _12891_/B AOI21X1
X_18465_ _18468_/CK _18465_/D _18465_/Q _18465_/RB VDD VSS DFFRQX1
X_15677_ _15706_/A _15677_/B VDD VSS _19307_/D AND2X1
XTAP_TAPCELL_ROW_43_450 VDD VSS WELLTAP
X_14628_ _14676_/A _14652_/B VDD VSS _14658_/B XNOR2X1
X_18396_ _18400_/CK _18513_/Q _20137_/A _18444_/RB VDD VSS DFFRQX1
X_17416_ _17417_/C _17416_/B _17416_/C VDD VSS _19841_/D AOI21X1
XTAP_TAPCELL_ROW_15_163 VDD VSS WELLTAP
X_17347_ _17348_/C _17469_/B _17347_/C VDD VSS _19826_/D AND3BX1
XTAP_TAPCELL_ROW_119_1202 VDD VSS WELLTAP
X_14559_ _16273_/A VDD VSS _14569_/B BUFX3
X_17278_ _17281_/A _17281_/B _17306_/C VDD VSS _17279_/C OAI21X1
X_19017_ _19045_/CK _19017_/D _19017_/Q VDD VSS DFFQX1
X_16229_ _19655_/Q _16229_/B _16813_/B VDD VSS _16243_/A MIN3X1
XFILLER_54_0 VDD VSS DECAPHV8
XFILLER_142_530 VDD VSS FILLER1
XFILLER_130_714 VSS VDD FILLER2
X_19919_ clkload7/A _19919_/D _19919_/Q VDD VSS DFFQX1
XFILLER_29_717 VDD VSS FILLER1
XFILLER_3_91 VSS VDD FILLER2
XFILLER_84_856 VDD VSS FILLER1
XFILLER_96_694 VSS VDD FILLER2
X_09603_ _18346_/Q VDD VSS _20214_/A INVX1
XFILLER_37_761 VDD VSS FILLER4
X_09534_ _20029_/Q _18199_/A VDD VSS _20030_/D NOR2BX1
X_09465_ _19972_/Q _09467_/B _09476_/C VDD VSS _09466_/C AOI21X1
XFILLER_40_915 VDD VSS DECAPHV8
XFILLER_51_252 VDD VSS FILLER1
XFILLER_11_116 VSS VDD FILLER2
X_09396_ _18623_/Q _11433_/B wire166/Y VDD VSS _11273_/A OAI21X1
XFILLER_137_313 VDD VSS FILLER1
XFILLER_22_12 VSS VDD FILLER2
XFILLER_106_700 VDD VSS FILLER4
XFILLER_138_45 VDD VSS FILLER1
X_09975__245 _20079_/CK VDD VSS _18522_/CK INVX1
X_10240_ _18624_/Q _10247_/A _10240_/C _10240_/D VDD VSS _10358_/B AOI211X1
XFILLER_105_232 VDD VSS FILLER1
XFILLER_106_744 VDD VSS FILLER1
XFILLER_133_563 VDD VSS FILLER1
X_10171_ _18006_/C VDD VSS _16273_/A BUFX3
XFILLER_121_747 VDD VSS FILLER4
XFILLER_19_205 VSS VDD FILLER2
XFILLER_47_20 VDD VSS FILLER1
XFILLER_47_31 VDD VSS FILLER4
XTAP_TAPCELL_ROW_49_509 VDD VSS WELLTAP
X_13930_ _18893_/Q VDD VSS _13977_/A INVX1
XFILLER_59_396 VDD VSS FILLER4
XFILLER_86_171 VSS VDD FILLER2
Xfanout195 _18504_/Q VDD VSS _09630_/C BUFX3
XTAP_TAPCELL_ROW_85_862 VDD VSS WELLTAP
X_13861_ _19060_/Q _13910_/A _13910_/B VDD VSS _13901_/D XNOR3X1
X_15600_ _19466_/Q _15855_/B VDD VSS _15601_/C NOR2BX1
XFILLER_74_388 VDD VSS FILLER1
XTAP_TAPCELL_ROW_57_586 VDD VSS WELLTAP
X_12812_ _12916_/A _12916_/B _12916_/D VDD VSS _12865_/B AOI21X1
X_13792_ _19114_/Q _14392_/A _14392_/B VDD VSS _13857_/B NOR3X1
X_16580_ _16597_/B _16580_/B VDD VSS _16828_/B XNOR2X1
XFILLER_103_92 VDD VSS FILLER1
XFILLER_27_282 VSS VDD FILLER2
X_12743_ _12910_/A _12910_/B _12910_/C VDD VSS _12775_/B AOI21X1
X_15531_ _19324_/Q _15696_/B VDD VSS _15535_/B XOR2X1
XFILLER_63_52 VDD VSS DECAPHV8
XTAP_TAPCELL_ROW_103_1047 VDD VSS WELLTAP
X_18250_ _18257_/CK _18250_/D _18267_/D _20079_/RB VDD VSS DFFRQX1
X_15462_ _15457_/A _15462_/B _15462_/C VDD VSS _15495_/A AOI2B1X1
XFILLER_31_948 VSS VDD FILLER2
XFILLER_42_285 VDD VSS DECAPHV8
X_12674_ _12763_/A _12763_/B _12763_/D VDD VSS _12675_/C OAI21X1
X_14413_ _14449_/A _14413_/B _14413_/C VDD VSS _19133_/D NOR3X1
X_17201_ _17204_/C _17202_/B _17229_/C VDD VSS _17202_/C OAI21X1
XTAP_TAPCELL_ROW_12_133 VDD VSS WELLTAP
XTAP_TAPCELL_ROW_40_420 VDD VSS WELLTAP
X_11625_ _11648_/A VDD VSS _11635_/B BUFX3
X_18181_ _19302_/Q _18181_/B VDD VSS _18185_/B OR2X2
X_15393_ _15393_/A _15393_/B VDD VSS _15394_/C NAND2X1
XFILLER_128_324 VDD VSS FILLER1
XFILLER_129_847 VDD VSS FILLER1
X_11556_ _11556_/A _11641_/B VDD VSS _18732_/D NOR2X1
X_14344_ _14368_/A _14344_/B VDD VSS _19071_/D NOR2X1
X_17132_ _17132_/A _17132_/B _17132_/C VDD VSS _17140_/A OA21X2
XFILLER_144_806 VDD VSS FILLER4
XFILLER_7_654 VDD VSS FILLER4
XFILLER_7_676 VDD VSS DECAPHV16
X_10507_ _18557_/Q _10507_/B VDD VSS _10544_/B OR2X2
X_14275_ _14275_/A _14275_/B VDD VSS _14276_/B XNOR2X1
X_17063_ _19766_/Q _17073_/B VDD VSS _17066_/C XNOR2X1
X_11487_ _18642_/Q _11496_/B VDD VSS _18669_/D AND2X1
X_13226_ _13355_/A _13331_/A _13443_/B VDD VSS _13316_/C XNOR3X1
X_16014_ _16872_/B VDD VSS _16024_/B INVX1
XTAP_TAPCELL_ROW_114_1154 VDD VSS WELLTAP
X_10438_ _10476_/A _10476_/B _10476_/D _10476_/C VDD VSS _10443_/B OAI211X1
XFILLER_98_948 VSS VDD FILLER2
X_10369_ _18633_/Q _18795_/Q VDD VSS _10402_/C XOR2X1
X_13157_ _13230_/A _13157_/B _13315_/D VDD VSS _13231_/C XNOR3X1
XFILLER_111_213 VDD VSS FILLER1
XFILLER_111_224 VDD VSS FILLER1
XFILLER_69_149 VSS VDD FILLER2
X_12108_ _12108_/A _12108_/B _12108_/C _12108_/D VDD VSS _12236_/A OAOI211X2
X_13088_ _13097_/A _13097_/B _13097_/C VDD VSS _14257_/C OR3X2
X_17965_ _17966_/A _17966_/B _17966_/D _17966_/C VDD VSS _17976_/B OAOI211X1
XFILLER_26_4 VDD VSS FILLER4
X_12039_ _19178_/Q _12113_/A _12113_/B VDD VSS _12040_/D XNOR3X1
X_19704_ _19737_/CK _19704_/D _19704_/Q VDD VSS DFFQX1
X_16916_ _17011_/B VDD VSS _17047_/B BUFX3
XFILLER_77_182 VDD VSS FILLER4
X_17896_ _18857_/Q _17901_/B VDD VSS _17898_/C OR2X2
X_19635_ _19636_/CK _19635_/D _19635_/Q VDD VSS DFFQX1
X_16847_ _16859_/A _16847_/B VDD VSS _19686_/D AND2X1
XFILLER_53_539 VSS VDD FILLER2
XFILLER_80_314 VDD VSS FILLER1
X_19566_ _19604_/CK _19566_/D _19566_/Q VDD VSS DFFQX1
X_16778_ _16793_/A _16778_/B VDD VSS _19624_/D AND2X1
XFILLER_18_282 VDD VSS DECAPHV16
XTAP_TAPCELL_ROW_125_1261 VDD VSS WELLTAP
X_18517_ _18517_/CK _18517_/D _18517_/Q _09325_/Y VDD VSS DFFRQX1
X_15729_ _15743_/A _15729_/B VDD VSS _19354_/D AND2X1
XFILLER_22_915 VSS VDD FILLER2
XFILLER_34_775 VDD VSS FILLER1
XFILLER_61_561 VDD VSS DECAPHV8
X_09250_ _20043_/RB _09349_/B VDD VSS _09250_/Y NOR2BX1
X_19497_ _19521_/CK _19497_/D _19497_/Q VDD VSS DFFQX1
XFILLER_34_797 VSS VDD FILLER2
X_18448_ _18455_/CK _18448_/D _18448_/Q _18452_/RB VDD VSS DFFRQX1
X_18379_ _18391_/CK _18512_/Q _20184_/A _20064_/RB VDD VSS DFFRQX1
XFILLER_119_346 VDD VSS DECAPHV8
X_09959__229 _18259_/CK VDD VSS _18506_/CK INVX1
XFILLER_1_808 VDD VSS FILLER1
XFILLER_89_948 VSS VDD FILLER2
XFILLER_103_747 VDD VSS DECAPHV16
XFILLER_130_533 VDD VSS FILLER1
XFILLER_130_588 VSS VDD FILLER2
XFILLER_84_29 VDD VSS FILLER1
XFILLER_17_709 VDD VSS FILLER4
XFILLER_44_506 VDD VSS FILLER1
XFILLER_56_344 VSS VDD FILLER2
XFILLER_57_856 VDD VSS FILLER4
XFILLER_57_867 VSS VDD FILLER2
XFILLER_16_219 VDD VSS FILLER1
XFILLER_17_45 VSS VDD FILLER2
XFILLER_71_314 VSS VDD FILLER2
XFILLER_83_185 VDD VSS FILLER1
XTAP_TAPCELL_ROW_82_832 VDD VSS WELLTAP
X_09517_ _20017_/Q _18197_/D VDD VSS _20017_/D NOR2X1
XFILLER_24_263 VDD VSS FILLER4
XFILLER_80_881 VSS VDD FILLER2
XTAP_TAPCELL_ROW_54_556 VDD VSS WELLTAP
XFILLER_12_414 VDD VSS FILLER1
XFILLER_12_425 VSS VDD FILLER2
XTAP_TAPCELL_ROW_139_1408 VDD VSS WELLTAP
X_09448_ _18386_/Q VDD VSS _20191_/A INVX1
XFILLER_130_4 VSS VDD FILLER2
XFILLER_8_407 VDD VSS DECAPHV8
X_09379_ _18526_/Q _09818_/B VDD VSS _18224_/E AND2X1
XFILLER_137_121 VSS VDD FILLER2
XFILLER_138_633 VDD VSS DECAPHV16
XTAP_TAPCELL_ROW_4_59 VDD VSS WELLTAP
X_11410_ _11422_/A _17990_/B _11410_/C VDD VSS _18604_/D NOR3X1
X_12390_ _12391_/A _12391_/B _12391_/D _12391_/C VDD VSS _14503_/C AOI211X1
XFILLER_20_480 VDD VSS DECAPHV16
X_11341_ _11370_/A _11341_/B _11370_/C VDD VSS _11343_/B OAI21X1
XFILLER_125_327 VDD VSS FILLER1
XFILLER_126_839 VDD VSS FILLER1
XFILLER_125_349 VSS VDD FILLER2
X_11272_ _11272_/A _11272_/B VDD VSS _18581_/D NOR2X1
X_14060_ _17959_/A wire152/Y _17960_/C _14060_/D VDD VSS _14093_/A OAOI211X1
XFILLER_133_371 VDD VSS FILLER1
X_10223_ _10224_/A _10224_/B _10224_/C _18621_/Q VDD VSS _10229_/C AOAI211X1
X_13011_ _13021_/A _13021_/B _13091_/C VDD VSS _14320_/B OA21X2
XFILLER_133_382 VDD VSS DECAPHV16
XFILLER_3_189 VSS VDD FILLER2
X_10154_ _10155_/A _10154_/B _10154_/C VDD VSS _10155_/C NOR3X1
XFILLER_0_863 VDD VSS FILLER4
XFILLER_121_566 VDD VSS DECAPHV8
XFILLER_48_812 VDD VSS DECAPHV8
XFILLER_58_74 VDD VSS FILLER4
XFILLER_94_417 VDD VSS FILLER1
XFILLER_0_885 VSS VDD FILLER2
XFILLER_47_322 VDD VSS FILLER1
XFILLER_58_85 VSS VDD FILLER2
X_10085_ _18607_/Q _10098_/B VDD VSS _10086_/B XNOR2X1
X_17750_ _17838_/A VDD VSS _17828_/C BUFX3
X_14962_ wire161/Y _15000_/B _15000_/D VDD VSS _14975_/B OAI21X1
XFILLER_48_867 VDD VSS FILLER1
XFILLER_59_193 VDD VSS FILLER1
XFILLER_63_804 VSS VDD FILLER2
X_13913_ _13965_/A _13965_/C VDD VSS _13914_/C NAND2X1
X_17681_ _17806_/A _17681_/B VDD VSS _19897_/D NOR2X1
X_16701_ _16701_/A _16704_/B VDD VSS _19555_/D NOR2X1
X_14893_ _14901_/B _14893_/B VDD VSS _15680_/B XNOR2X1
XFILLER_75_675 VDD VSS FILLER1
X_13844_ _13903_/B _14265_/C _19003_/Q VDD VSS _13845_/D AND3BX1
X_19420_ _19461_/CK _19420_/D _19420_/Q VDD VSS DFFQX1
X_16632_ _16657_/B _16632_/B VDD VSS _16793_/B NOR2BX1
XFILLER_62_336 VSS VDD FILLER2
XFILLER_90_645 VSS VDD FILLER2
X_19351_ _19362_/CK _19351_/D _19351_/Q VDD VSS DFFQX1
XFILLER_31_712 VDD VSS FILLER1
XFILLER_43_561 VDD VSS DECAPHV8
XFILLER_50_509 VSS VDD FILLER2
X_10987_ _11364_/A _10987_/B VDD VSS _10988_/C NAND2X1
X_13775_ _13783_/A _14297_/B _13783_/C VDD VSS _14298_/B OA21X2
X_18302_ _18311_/CK _18515_/Q _18302_/Q _18471_/RB VDD VSS DFFRQX1
X_16563_ _19732_/Q _16897_/B VDD VSS _16564_/B XOR2X1
XFILLER_71_881 VSS VDD FILLER2
X_12726_ _19103_/Q VDD VSS _12809_/A INVX1
Xclkbuf_2_1__f__000_ clkbuf_0__000_/Y VDD VSS clkload78/A BUFX12
X_19282_ _19290_/CK _19282_/D _19282_/Q VDD VSS DFFQX1
X_16494_ _16494_/A _16494_/B _16494_/C VDD VSS _16518_/B AOI21X1
X_15514_ _19518_/Q _15514_/B _15514_/C VDD VSS _15515_/C MIN3X1
XFILLER_90_61 VSS VDD FILLER2
X_12657_ _12748_/A _14409_/B VDD VSS _12813_/B NOR2X1
Xclkbuf_leaf_1__000_ clkload77/A VDD VSS _19489_/CK BUFX12
X_18233_ _18233_/CK _18233_/E _18233_/ECK VDD VSS CGX3
X_15445_ _15469_/A _15468_/A VDD VSS _15446_/B XNOR2X1
X_11608_ _18752_/Q _11612_/B VDD VSS _18779_/D AND2X1
X_18164_ _19298_/Q _18164_/B VDD VSS _18167_/A NOR2BX1
X_15376_ _15376_/A _15376_/B _15376_/C VDD VSS _15377_/B NOR3X1
X_12588_ _19214_/Q _12648_/B _12837_/C VDD VSS _12658_/C XNOR3X1
X_14327_ _14352_/A _14327_/B _14327_/C VDD VSS _19056_/D NOR3X1
X_17115_ _19777_/Q _19745_/Q VDD VSS _17117_/B XOR2X1
XFILLER_129_699 VDD VSS FILLER1
X_11539_ _18690_/Q _11542_/B VDD VSS _18717_/D AND2X1
X_18095_ _18095_/A _18095_/B VDD VSS _18096_/B NAND2X1
XFILLER_99_92 VDD VSS FILLER1
X_14258_ _14270_/A _14258_/B VDD VSS _18996_/D AND2X1
X_17046_ _17536_/A _17046_/B _17064_/A VDD VSS _19762_/D NOR3X1
X_13209_ _19024_/Q _14291_/B VDD VSS _13373_/E _14291_/C NAND3X1
X_14189_ _14218_/A _14189_/B VDD VSS _18939_/D NOR2X1
XFILLER_97_233 VDD VSS FILLER1
XFILLER_98_767 VDD VSS FILLER1
XFILLER_140_864 VDD VSS FILLER1
XFILLER_97_277 VSS VDD FILLER2
X_18997_ _19050_/CK _18997_/D _18997_/Q VDD VSS DFFQX1
XFILLER_38_322 VSS VDD FILLER2
X_17948_ _17948_/A _17948_/B _17948_/C _17948_/D VDD VSS _19956_/D AOI31X1
XFILLER_17_0 VSS VDD FILLER2
XFILLER_39_878 VDD VSS DECAPHV8
XTAP_TAPCELL_ROW_96_979 VDD VSS WELLTAP
X_17879_ _17880_/C _17879_/B _17879_/C VDD VSS _19943_/D AOI21X1
X_19618_ _19678_/CK _19618_/D _19618_/Q VDD VSS DFFQX1
XFILLER_53_336 VDD VSS DECAPHV16
XFILLER_93_494 VSS VDD FILLER2
X_09302_ _09302_/A VDD VSS _09302_/Y BUFX3
X_19549_ _19615_/CK _19549_/D _19549_/Q VDD VSS DFFQX1
XFILLER_110_38 VDD VSS DECAPHV8
XFILLER_110_49 VDD VSS FILLER4
XFILLER_62_881 VSS VDD FILLER2
XTAP_TAPCELL_ROW_51_526 VDD VSS WELLTAP
XFILLER_22_756 VDD VSS DECAPHV8
X_09233_ _18496_/D VDD VSS _18352_/D INVX1
XFILLER_119_110 VDD VSS FILLER4
XFILLER_21_266 VDD VSS DECAPHV8
XFILLER_103_522 VDD VSS FILLER1
XFILLER_115_371 VDD VSS FILLER1
XFILLER_116_894 VDD VSS FILLER4
XFILLER_0_148 VDD VSS FILLER1
XFILLER_130_330 VDD VSS FILLER1
XFILLER_76_417 VDD VSS FILLER1
XFILLER_88_255 VDD VSS FILLER1
XFILLER_89_767 VDD VSS DECAPHV8
XTAP_TAPCELL_ROW_59_604 VDD VSS WELLTAP
X_09997_ _17906_/C _09997_/B _09998_/C VDD VSS _18528_/D NOR3X1
X_20186_ _20186_/A VDD VSS _20186_/Y BUFX3
XFILLER_76_439 VDD VSS FILLER4
XFILLER_56_163 VDD VSS FILLER4
XFILLER_72_601 VSS VDD FILLER2
XFILLER_84_461 VSS VDD FILLER2
X_10910_ _11078_/A _18728_/Q _10910_/C _10910_/D VDD VSS _10910_/Y AO211X2
XFILLER_71_100 VSS VDD FILLER2
XTAP_TAPCELL_ROW_67_681 VDD VSS WELLTAP
X_11890_ _19204_/Q _12048_/A _12048_/B VDD VSS _11918_/C XNOR3X1
XFILLER_72_667 VDD VSS FILLER1
X_10841_ _10774_/Y _10840_/Y _10947_/A VDD VSS _10841_/Y MUX2X1
XFILLER_52_380 VSS VDD FILLER2
X_10772_ _11039_/C _10772_/B _10772_/C _10772_/D VDD VSS _10773_/B AOI211X1
X_13560_ _13637_/A _13637_/B _13637_/C VDD VSS _13561_/C AO21X2
XFILLER_40_542 VDD VSS FILLER4
XTAP_TAPCELL_ROW_100_1017 VDD VSS WELLTAP
X_12511_ _19042_/Q VDD VSS _14278_/A INVX1
X_13491_ _18915_/Q _13656_/A _13656_/B VDD VSS _13502_/D XNOR3X1
XFILLER_100_71 VDD VSS FILLER1
XFILLER_40_586 VSS VDD FILLER2
XFILLER_8_226 VSS VDD FILLER2
X_12442_ _19016_/Q _12442_/B _14282_/B VDD VSS _12894_/A MIN3X1
X_15230_ _15193_/B _15275_/C _15275_/A VDD VSS _15232_/B AND3BX1
XFILLER_121_0 VDD VSS DECAPHV8
X_12373_ _19154_/Q _12373_/B _12373_/C VDD VSS _12378_/B XNOR3X1
X_15161_ _15180_/B _15161_/B VDD VSS _15778_/B XOR2X1
XFILLER_4_421 VDD VSS FILLER1
X_11324_ _11364_/B _11325_/B _11325_/C _11325_/D VDD VSS _11333_/C OAI211X1
X_14112_ _14118_/A _17982_/B VDD VSS _18872_/D NOR2X1
X_15092_ _15092_/A _15092_/B _15092_/C _15092_/D VDD VSS _15139_/B AOAI211X1
XFILLER_5_59 VDD VSS DECAPHV8
X_11255_ _11255_/A _11255_/B _11255_/C VDD VSS _11298_/B AOI21X1
X_14043_ _14043_/A _14043_/B VDD VSS _14235_/B XOR2X1
X_18920_ _18950_/CK _18920_/D _18920_/Q VDD VSS DFFQX1
XFILLER_106_371 VSS VDD FILLER2
XFILLER_122_842 VDD VSS DECAPHV8
XFILLER_69_84 VDD VSS FILLER1
XFILLER_79_211 VSS VDD FILLER2
XTAP_TAPCELL_ROW_111_1124 VDD VSS WELLTAP
X_10206_ _18619_/Q _10207_/B VDD VSS _10217_/C NOR2X1
XFILLER_122_886 VDD VSS FILLER1
X_11186_ _11184_/Y _18576_/Q VDD VSS _11217_/C NAND2BX1
X_18851_ _18878_/CK _18851_/D _18851_/Q VDD VSS DFFQX1
XFILLER_0_682 VDD VSS DECAPHV8
XFILLER_122_897 VDD VSS FILLER1
XFILLER_39_119 VDD VSS FILLER1
XFILLER_79_277 VSS VDD FILLER2
X_10137_ _10180_/A _11417_/C VDD VSS _18539_/D NOR2X1
X_18782_ _18782_/CK _18782_/D _18782_/Q VDD VSS DFFQX1
X_17802_ _17802_/A _17803_/C _17802_/C VDD VSS _19924_/D AOI21X1
X_15994_ _19902_/Q _19550_/Q VDD VSS _15995_/C NOR2BX1
XFILLER_125_90 VSS VDD FILLER2
XFILLER_94_258 VDD VSS DECAPHV8
X_10068_ _11302_/A _10068_/B VDD VSS _10068_/Y XNOR2X1
X_17733_ _17738_/C _17738_/B VDD VSS _17735_/B NAND2BX1
X_14945_ _19338_/Q _15711_/B VDD VSS _14946_/B XOR2X1
XFILLER_48_686 VSS VDD FILLER2
XTAP_TAPCELL_ROW_93_949 VDD VSS WELLTAP
X_19403_ _19425_/CK _19403_/D _19403_/Q VDD VSS DFFQX1
X_17664_ _17667_/A _17667_/B _17746_/C VDD VSS _17665_/C OAI21X1
X_14876_ _19529_/Q _19530_/Q _19531_/Q _14877_/C VDD VSS _15009_/C AND4X2
XTAP_TAPCELL_ROW_122_1231 VDD VSS WELLTAP
X_13827_ _13827_/A _13827_/B _13845_/C VDD VSS _13921_/B XNOR3X1
X_17595_ _19880_/Q _19848_/Q VDD VSS _17598_/A XNOR2X1
X_16615_ _16616_/A _16616_/B _16616_/C VDD VSS _16617_/B NOR3X1
XFILLER_44_881 VSS VDD FILLER2
XFILLER_44_892 VDD VSS FILLER1
X_13758_ _18973_/Q _14228_/B VDD VSS _13816_/A NAND2X1
X_19334_ _19358_/CK _19334_/D _19334_/Q VDD VSS DFFQX1
X_16546_ _19635_/Q _16546_/B _16789_/B VDD VSS _16571_/B MIN3X1
XFILLER_31_553 VDD VSS FILLER4
X_12709_ _19019_/Q _12868_/A _12709_/C VDD VSS _12717_/D XNOR3X1
X_19265_ _20005_/CK _19265_/D _19265_/Q VDD VSS DFFQX1
X_13689_ _13771_/A _14195_/B VDD VSS _13739_/B NOR2X1
X_18216_ _18223_/CK _18216_/E _18216_/ECK VDD VSS CGX3
X_16477_ _19569_/Q _19921_/Q VDD VSS _16478_/B XNOR2X1
X_19196_ _19196_/CK _19196_/D _19196_/Q VDD VSS DFFQX1
X_15428_ _19433_/Q _15818_/B VDD VSS _15449_/A NOR2BX1
XFILLER_117_625 VDD VSS DECAPHV8
X_18147_ _19296_/Q _18153_/B VDD VSS _18152_/A XOR2X1
X_15359_ _15359_/A _15359_/B _15359_/C _15359_/D VDD VSS _15398_/C OAOI211X1
XFILLER_8_793 VDD VSS FILLER4
X_18078_ _18076_/B _18078_/B _18078_/C VDD VSS _19990_/D AOI2B1X1
XFILLER_104_308 VDD VSS FILLER1
XFILLER_116_179 VDD VSS FILLER4
XFILLER_132_617 VSS VDD FILLER2
XFILLER_144_488 VDD VSS FILLER4
X_09920_ _09944_/A _09990_/B _09920_/C VDD VSS _10048_/B OAI21X1
Xhold259 hold263/Y VDD VSS hold259/Y BUFX3
X_17029_ _19760_/Q _17047_/B VDD VSS _17040_/A XOR2X1
XFILLER_131_127 VDD VSS DECAPHV16
X_20040_ _20043_/CK _20040_/D _20040_/Q _20043_/RB VDD VSS DFFRQX1
XFILLER_113_864 VDD VSS FILLER1
XFILLER_59_918 VSS VDD FILLER2
X_09851_ _11435_/A _11435_/B _11438_/A VDD VSS _10268_/B OR3BX1
Xclkbuf_1_1__f__09174_ clkbuf_0__09174_/Y VDD VSS _18295_/CK BUFX12
XFILLER_100_503 VDD VSS DECAPHV8
XFILLER_100_514 VDD VSS DECAPHV8
XFILLER_140_672 VSS VDD FILLER2
XFILLER_98_586 VDD VSS DECAPHV8
X_09782_ _18309_/Q _09797_/B _09788_/B _20114_/A _09782_/E VDD VSS _09783_/C AOI221X1
XFILLER_26_303 VSS VDD FILLER2
XFILLER_54_601 VSS VDD FILLER2
XFILLER_66_472 VSS VDD FILLER2
XFILLER_38_196 VDD VSS FILLER1
XFILLER_81_475 VDD VSS DECAPHV8
XTAP_TAPCELL_ROW_64_651 VDD VSS WELLTAP
XFILLER_22_520 VDD VSS FILLER1
XFILLER_81_497 VSS VDD FILLER2
XTAP_TAPCELL_ROW_36_375 VDD VSS WELLTAP
XFILLER_139_216 VDD VSS DECAPHV8
X_09216_ _18469_/D VDD VSS _18405_/D INVX1
XFILLER_135_444 VDD VSS DECAPHV16
XTAP_TAPCELL_ROW_1_27 VDD VSS WELLTAP
XFILLER_116_691 VDD VSS FILLER1
XFILLER_122_138 VDD VSS FILLER1
X_11040_ _11070_/C _11040_/B _11040_/C VDD VSS _11041_/D AOI21X1
XFILLER_104_886 VSS VDD FILLER2
XFILLER_76_225 VDD VSS FILLER4
XFILLER_77_737 VDD VSS FILLER4
X_20169_ _20169_/A VDD VSS _20169_/Y BUFX3
XFILLER_130_182 VSS VDD FILLER2
Xclkbuf_leaf_0__001_ clkbuf_leaf_5__001_/A VDD VSS _20005_/CK BUFX12
XFILLER_57_450 VSS VDD FILLER2
XFILLER_85_781 VSS VDD FILLER2
X_12991_ _18966_/Q _13171_/A _14217_/B VDD VSS _14186_/B XOR3X1
XFILLER_44_111 VDD VSS FILLER1
X_11942_ _19063_/Q VDD VSS _11944_/A INVX1
X_14730_ _14730_/A _14730_/B _15799_/B VDD VSS _14774_/B MIN3X1
XFILLER_44_155 VDD VSS FILLER4
XFILLER_55_64 VDD VSS DECAPHV8
XFILLER_72_442 VDD VSS FILLER4
XTAP_TAPCELL_ROW_90_919 VDD VSS WELLTAP
X_11873_ _19175_/Q _14461_/B VDD VSS _12035_/A AND2X1
X_14661_ _14701_/A _14701_/B _14673_/C VDD VSS _15797_/B XNOR3X1
XFILLER_26_870 VDD VSS DECAPHV8
XFILLER_32_328 VDD VSS DECAPHV8
XFILLER_60_615 VDD VSS FILLER1
XFILLER_60_637 VDD VSS FILLER4
X_10824_ _18698_/Q _18752_/Q _10804_/C VDD VSS _10861_/C AOI21BX1
X_13612_ _13840_/A _13840_/B VDD VSS _13652_/B NOR2X1
X_14592_ _19468_/Q _14616_/B _14595_/C VDD VSS _15825_/B XNOR3X1
X_17380_ _17390_/A _17380_/B VDD VSS _19833_/D NOR2X1
X_16400_ _19630_/Q _16784_/B VDD VSS _16402_/C XOR2X1
XFILLER_111_70 VDD VSS FILLER1
XFILLER_111_92 VDD VSS FILLER1
XFILLER_13_542 VDD VSS DECAPHV8
XFILLER_25_380 VDD VSS FILLER4
X_13543_ _19166_/Q _14451_/B _14451_/C VDD VSS _13546_/D OR3BX1
X_16331_ _19723_/Q _16887_/B VDD VSS _16332_/C NOR2X1
XFILLER_41_884 VDD VSS DECAPHV8
X_10755_ _10798_/D _10798_/B VDD VSS _10756_/B NAND2BX1
XFILLER_127_901 VDD VSS FILLER4
XFILLER_71_96 VDD VSS FILLER4
XFILLER_9_557 VDD VSS FILLER1
X_10686_ _10722_/A _10686_/B _10686_/C _10686_/D VDD VSS _10696_/C OAI211X1
X_13474_ _19027_/Q _13599_/B _13599_/C VDD VSS _13683_/B XNOR3X1
X_19050_ _19050_/CK _19050_/D _19050_/Q VDD VSS DFFQX1
X_16262_ _16283_/B _16262_/B VDD VSS _16779_/B XNOR2X1
XFILLER_9_579 VSS VDD FILLER2
X_12425_ _19016_/Q _12442_/B _14282_/B VDD VSS _14248_/B XNOR3X1
X_18001_ _18544_/Q _18545_/Q VDD VSS _18052_/B _18048_/B AND3X2
X_16193_ _19686_/Q _16847_/B VDD VSS _16194_/B XNOR2X1
X_15213_ _19316_/Q _15687_/B VDD VSS _15214_/B XNOR2X1
XFILLER_5_741 VSS VDD FILLER2
X_12356_ _18987_/Q _12356_/B _14247_/B VDD VSS _12441_/B MIN3X1
X_15144_ _19508_/Q _15144_/B VDD VSS _15145_/D AND2X1
X_11307_ _11364_/A _11307_/B _11356_/C VDD VSS _11319_/A AOI21X1
XFILLER_107_680 VDD VSS FILLER1
XFILLER_99_328 VDD VSS FILLER1
X_12287_ _19040_/Q _14275_/A _12287_/C VDD VSS _12288_/C MIN3X1
X_19952_ _19957_/CK _19952_/D _19952_/Q VDD VSS DFFQX1
X_15075_ _19341_/Q _15715_/B VDD VSS _15076_/B XNOR2X1
XFILLER_106_190 VSS VDD FILLER2
X_11238_ _11249_/C _11239_/B _11386_/C VDD VSS _11239_/C OAI21X1
X_14026_ _18895_/Q _14138_/B VDD VSS _17959_/A AND2X1
X_19883_ clkload8/A _19883_/D _19883_/Q VDD VSS DFFQX1
X_18903_ _18908_/CK _18903_/D _18903_/Q VDD VSS DFFQX1
XFILLER_121_171 VDD VSS FILLER4
XFILLER_122_683 VDD VSS FILLER1
X_11169_ _11195_/A _11169_/B _11169_/C _11169_/D VDD VSS _11179_/A AOI31X1
X_18834_ _19951_/CK _18834_/D _18834_/Q VDD VSS DFFQX1
XFILLER_0_490 VDD VSS FILLER1
XFILLER_83_707 VSS VDD FILLER2
XFILLER_76_770 VSS VDD FILLER2
X_18765_ _18820_/CK _18765_/D _18765_/Q VDD VSS DFFQX1
X_15977_ _15977_/A _15977_/B VDD VSS _16835_/B XNOR2X1
XFILLER_36_623 VSS VDD FILLER2
XFILLER_63_420 VSS VDD FILLER2
XTAP_TAPCELL_ROW_78_798 VDD VSS WELLTAP
X_18696_ _19948_/CK _18696_/D _18696_/Q VDD VSS DFFQX1
X_17716_ _19905_/Q _19873_/Q _17716_/C VDD VSS _17719_/B MIN3X1
X_14928_ _15868_/B _14928_/B _14966_/C VDD VSS _15869_/B XNOR3X1
XFILLER_90_250 VDD VSS DECAPHV32
Xclkbuf_leaf_34__000_ clkload77/A VDD VSS _19461_/CK BUFX12
X_17647_ _17648_/C _18127_/B _17647_/C VDD VSS _19890_/D AND3BX1
X_14859_ _19420_/Q VDD VSS _14861_/A INVX1
XFILLER_23_317 VSS VDD FILLER2
XFILLER_23_339 VDD VSS FILLER1
XFILLER_50_114 VSS VDD FILLER2
XFILLER_50_125 VDD VSS FILLER1
XTAP_TAPCELL_ROW_33_345 VDD VSS WELLTAP
XTAP_TAPCELL_ROW_61_621 VDD VSS WELLTAP
X_19317_ _19337_/CK _19317_/D _19317_/Q VDD VSS DFFQX1
X_17578_ _17581_/A _17581_/B _17597_/C VDD VSS _17579_/C OAI21X1
XFILLER_32_862 VDD VSS FILLER1
XFILLER_50_158 VDD VSS FILLER4
X_16529_ _19603_/Q _16754_/B VDD VSS _16548_/B XOR2X1
XFILLER_84_0 VSS VDD FILLER2
X_19248_ _20013_/CK _19248_/D _19248_/Q VDD VSS DFFQX1
XFILLER_117_400 VDD VSS FILLER1
X_19179_ _19215_/CK _19179_/D _19179_/Q VDD VSS DFFQX1
XFILLER_129_282 VDD VSS DECAPHV16
XFILLER_144_230 VDD VSS FILLER1
XFILLER_132_414 VDD VSS FILLER4
XFILLER_132_425 VDD VSS FILLER1
XFILLER_113_650 VDD VSS FILLER1
XFILLER_132_458 VDD VSS FILLER4
XFILLER_132_469 VSS VDD FILLER2
X_09903_ _09940_/B _09902_/Y _09885_/A VDD VSS _10005_/B MUXI2X1
XFILLER_113_661 VDD VSS FILLER1
XFILLER_113_683 VDD VSS DECAPHV8
XFILLER_58_203 VDD VSS FILLER1
XTAP_TAPCELL_ROW_69_710 VDD VSS WELLTAP
X_09834_ _11435_/A _11435_/B _11438_/A VDD VSS _10258_/D NOR3BX1
X_20023_ _20045_/CK _20023_/D _20023_/Q _20031_/RB VDD VSS DFFRQX1
XFILLER_100_322 VSS VDD FILLER2
XFILLER_132_25 VDD VSS DECAPHV8
X_09765_ _18404_/Q VDD VSS _20145_/A INVX1
XFILLER_73_228 VSS VDD FILLER2
X_09696_ _18431_/Q _09696_/B VDD VSS _09697_/E NOR2X1
XFILLER_26_133 VDD VSS FILLER4
XFILLER_54_453 VDD VSS DECAPHV8
XFILLER_82_773 VDD VSS DECAPHV8
XTAP_TAPCELL_ROW_142_1437 VDD VSS WELLTAP
XFILLER_14_328 VDD VSS DECAPHV8
XFILLER_41_103 VDD VSS FILLER4
XFILLER_42_626 VDD VSS FILLER1
XFILLER_54_497 VDD VSS DECAPHV8
XFILLER_23_840 VDD VSS DECAPHV8
XFILLER_23_884 VDD VSS FILLER1
XFILLER_50_670 VDD VSS FILLER4
XFILLER_22_383 VDD VSS DECAPHV32
XFILLER_50_692 VDD VSS FILLER4
X_10540_ _10548_/A _10548_/B _10595_/A VDD VSS _10541_/B OAI21X1
XFILLER_10_567 VDD VSS DECAPHV8
X_10471_ _10472_/A _10472_/B _10472_/C _11378_/A VDD VSS _10471_/Y AOI31X1
X_12210_ _12210_/A _12210_/B _12210_/C _12210_/D VDD VSS _12300_/B OAOI211X1
XFILLER_136_786 VDD VSS FILLER4
XFILLER_2_700 VSS VDD FILLER2
X_13190_ _13290_/A _13290_/B _13290_/D VDD VSS _13280_/A OAI21X1
X_12141_ _12149_/A _12149_/B _12149_/C VDD VSS _14373_/B OAI21X1
XFILLER_123_447 VDD VSS DECAPHV16
X_12072_ _18983_/Q _12072_/B _12072_/C VDD VSS _12132_/B MIN3X1
XFILLER_103_160 VSS VDD FILLER2
XFILLER_104_661 VSS VDD FILLER2
XFILLER_1_276 VSS VDD FILLER2
XFILLER_89_383 VDD VSS FILLER1
X_11023_ _11023_/A _11023_/B _11023_/C _11023_/D VDD VSS _11055_/B AO211X2
X_15900_ _15906_/A _15900_/B VDD VSS _19506_/D NOR2X1
XFILLER_103_182 VDD VSS FILLER4
XFILLER_77_556 VSS VDD FILLER2
X_16880_ _16899_/A _16880_/B VDD VSS _19716_/D AND2X1
XFILLER_64_206 VDD VSS FILLER4
XFILLER_65_707 VDD VSS DECAPHV8
X_15831_ _17010_/A _15831_/B _15831_/C VDD VSS _19446_/D NOR3X1
XFILLER_64_228 VDD VSS FILLER4
X_12974_ _19106_/Q _13113_/A _13314_/B VDD VSS _13102_/D XNOR3X1
X_18550_ _18550_/CK _18550_/D _18550_/Q VDD VSS DFFQX1
X_15762_ _15780_/A _15762_/B VDD VSS _19384_/D NOR2X1
XFILLER_18_656 VDD VSS DECAPHV8
XFILLER_73_762 VDD VSS FILLER1
XTAP_TAPCELL_ROW_75_768 VDD VSS WELLTAP
X_11925_ _11987_/A _14462_/B VDD VSS _11937_/B NOR2X1
X_18481_ _18487_/CK _18518_/Q _20126_/A _18485_/RB VDD VSS DFFRQX1
X_17501_ _17503_/C _17501_/B _17501_/C VDD VSS _19859_/D AOI21X1
X_14713_ _19500_/Q _15893_/B VDD VSS _14785_/B XOR2X1
XFILLER_122_80 VDD VSS DECAPHV8
XFILLER_45_486 VDD VSS FILLER1
XFILLER_45_497 VDD VSS FILLER4
XFILLER_60_412 VDD VSS FILLER4
XFILLER_72_261 VSS VDD FILLER2
XFILLER_73_784 VDD VSS FILLER4
X_17432_ _19845_/Q _19813_/Q VDD VSS _17439_/C NOR2X1
X_15693_ _15693_/A _15693_/B VDD VSS _19322_/D NOR2X1
XFILLER_32_125 VDD VSS DECAPHV8
XTAP_TAPCELL_ROW_106_1078 VDD VSS WELLTAP
X_11856_ _11899_/B _11866_/B VDD VSS _14367_/B XNOR2X1
X_14644_ _14644_/A _15889_/B VDD VSS _14645_/D OR2X2
X_10807_ _11255_/A _10807_/B _10807_/C VDD VSS _10808_/C OR3BX1
X_11787_ _19089_/Q _14365_/B VDD VSS _11864_/B NOR2X1
X_14575_ _20013_/Q _16702_/B VDD VSS _19277_/D AND2X1
Xclkbuf_1_0__f__09177_ clkbuf_0__09177_/Y VDD VSS _18257_/CK BUFX12
X_17363_ _17366_/A _17366_/B _17363_/C VDD VSS _17364_/C OAI21X1
XFILLER_14_895 VSS VDD FILLER2
XTAP_TAPCELL_ROW_30_315 VDD VSS WELLTAP
X_10738_ _11267_/A _10738_/B _10738_/C _10960_/A VDD VSS _10739_/C OAI211X1
X_13526_ _19082_/Q _14358_/B _14358_/C VDD VSS _13531_/D OR3BX1
X_19102_ _19129_/CK _19102_/D _19102_/Q VDD VSS DFFQX1
X_17294_ _17296_/C _17294_/B _17294_/C VDD VSS _19815_/D AOI21X1
X_16314_ _19563_/Q _19915_/Q VDD VSS _16315_/B XOR2X1
X_13457_ _13457_/A _13457_/B _13457_/C _13457_/D VDD VSS _14481_/C OAOI211X1
X_19033_ _19172_/CK _19033_/D _19033_/Q VDD VSS DFFQX1
X_16245_ _16251_/B _16245_/B VDD VSS _16884_/B XNOR2X1
X_10669_ _10667_/Y _10671_/B _11431_/A VDD VSS _18561_/D AND3BX1
X_12408_ _20003_/Q _19267_/Q VDD VSS _12577_/D AND2X1
XFILLER_56_4 VDD VSS FILLER4
X_13388_ _18914_/Q _14159_/B VDD VSS _13578_/C _14159_/C AND3X2
Xoutput106 _20181_/Y VDD VSS o_tst_ctrl[0] BUFX3
X_16176_ _19653_/Q _16810_/B VDD VSS _16177_/C OR2X2
XFILLER_127_797 VDD VSS FILLER1
XFILLER_142_723 VDD VSS FILLER1
XFILLER_142_745 VDD VSS FILLER4
XFILLER_99_125 VDD VSS DECAPHV8
XTAP_TAPCELL_ROW_117_1185 VDD VSS WELLTAP
X_12339_ _18987_/Q _12356_/B _14247_/B VDD VSS _14210_/B XNOR3X1
Xoutput139 _20222_/Y VDD VSS o_uwb_tx_cfg[25] BUFX3
Xoutput128 _20212_/Y VDD VSS o_uwb_tx_cfg[15] BUFX3
Xoutput117 _20186_/Y VDD VSS o_tst_ctrl[5] BUFX3
X_15127_ _15127_/A _15133_/C VDD VSS _15685_/B XNOR2X1
X_19935_ clkload3/A _19935_/D _19935_/Q VDD VSS DFFQX1
X_15058_ _19534_/Q _15058_/B VDD VSS _15146_/C NOR2BX1
X_14009_ _19007_/Q _14269_/B VDD VSS _14043_/A XOR2X1
X_19866_ _19903_/CK _19866_/D _19866_/Q VDD VSS DFFQX1
XFILLER_95_364 VDD VSS DECAPHV8
XFILLER_95_375 VSS VDD FILLER2
X_19797_ _19828_/CK _19797_/D _19797_/Q VDD VSS DFFQX1
X_18817_ _18817_/CK _18817_/D _18817_/Q VDD VSS DFFQX1
XFILLER_37_921 VSS VDD FILLER2
XFILLER_49_781 VDD VSS FILLER4
XFILLER_55_228 VDD VSS FILLER4
X_09550_ _20044_/Q _18201_/A VDD VSS _20045_/D NOR2BX1
Xdelaybuf_3_sclk delaybuf_3_sclk/A VDD VSS delaybuf_4_sclk/A BUFX12
X_18748_ _18828_/CK _18748_/D _18748_/Q VDD VSS DFFQX1
XFILLER_70_209 VSS VDD FILLER2
XTAP_TAPCELL_ROW_128_1292 VDD VSS WELLTAP
X_09481_ _18454_/D _09483_/B _09481_/C VDD VSS _18243_/D AOI21X1
XFILLER_24_615 VSS VDD FILLER2
X_18679_ _18811_/CK _18679_/D _18679_/Q VDD VSS DFFQX1
XTAP_TAPCELL_ROW_18_194 VDD VSS WELLTAP
XFILLER_23_169 VDD VSS FILLER1
XFILLER_32_692 VDD VSS FILLER4
XFILLER_118_720 VDD VSS FILLER1
XFILLER_117_252 VDD VSS FILLER1
XFILLER_106_948 VSS VDD FILLER2
XFILLER_117_274 VDD VSS FILLER1
XFILLER_127_58 VSS VDD FILLER2
XFILLER_121_929 VDD VSS FILLER1
XFILLER_87_810 VSS VDD FILLER2
XFILLER_101_620 VDD VSS FILLER4
XFILLER_46_206 VDD VSS FILLER1
XFILLER_59_589 VSS VDD FILLER2
XFILLER_86_342 VDD VSS FILLER1
X_09817_ _09817_/A _09817_/B _09817_/C _09817_/D VDD VSS _09818_/E AOI31X1
X_20006_ _20006_/CK _20006_/D _20006_/Q VDD VSS DFFQX1
X_09748_ _18339_/Q VDD VSS _20093_/A INVX1
XFILLER_27_453 VDD VSS FILLER4
XFILLER_55_751 VSS VDD FILLER2
XFILLER_15_626 VDD VSS FILLER4
XFILLER_27_464 VDD VSS FILLER1
XFILLER_36_88 VDD VSS FILLER4
XTAP_TAPCELL_ROW_72_738 VDD VSS WELLTAP
X_09679_ _20072_/Q _09770_/B _09769_/C _20088_/A _09679_/E VDD VSS _09680_/C AOI221X1
X_11710_ _11745_/A _11768_/B VDD VSS _11714_/C XNOR2X1
XFILLER_42_423 VDD VSS FILLER1
XFILLER_42_445 VDD VSS FILLER4
X_12690_ _19047_/Q _12714_/B _12731_/C VDD VSS _12709_/C XNOR3X1
XFILLER_42_478 VSS VDD FILLER2
XFILLER_70_798 VDD VSS DECAPHV16
X_11641_ _11641_/A _11641_/B VDD VSS _18809_/D NOR2X1
XFILLER_11_810 VDD VSS FILLER1
XFILLER_52_54 VDD VSS DECAPHV8
X_11572_ _18719_/Q _11578_/B VDD VSS _18746_/D AND2X1
X_14360_ _14316_/Y _14360_/B _14360_/C VDD VSS _19084_/D AND3BX1
XFILLER_7_803 VSS VDD FILLER2
X_10523_ _10576_/A _10576_/B _10721_/D VDD VSS _10528_/B AOI21X1
X_13311_ _14323_/A _14323_/B _14323_/C VDD VSS _13416_/C AO21X2
XFILLER_109_742 VSS VDD FILLER2
XFILLER_7_858 VDD VSS FILLER4
X_14291_ _14255_/Y _14291_/B _14291_/C VDD VSS _19024_/D AND3BX1
X_10454_ _10454_/A _10454_/B _10454_/C _10454_/D VDD VSS _10455_/B AOI211X1
X_13242_ _13255_/A _13255_/C _13150_/D VDD VSS _14541_/C AOI21BX1
X_16030_ _16030_/A _16030_/B _16030_/C VDD VSS _16049_/A AOI21X1
X_10385_ _10581_/A _10385_/B _10385_/C _10512_/A VDD VSS _10386_/D OAI211X1
X_13173_ _18940_/Q _13295_/B _13173_/C VDD VSS _13290_/B XNOR3X1
XFILLER_124_745 VSS VDD FILLER2
XFILLER_124_767 VDD VSS FILLER4
X_12124_ _19012_/Q _12134_/B _12134_/C VDD VSS _14242_/B XNOR3X1
Xclkbuf_leaf_33__001_ clkbuf_2_1__f__001_/Y VDD VSS _19096_/CK BUFX12
X_19720_ _19730_/CK _19720_/D _19720_/Q VDD VSS DFFQX1
X_17981_ _17983_/B _17983_/C _18871_/Q VDD VSS _17987_/B OAI21X1
XFILLER_78_854 VDD VSS FILLER1
X_12055_ _12055_/A _12055_/B _12055_/C _12055_/D VDD VSS _12108_/B OAOI211X1
X_16932_ _19742_/Q wire163/Y VDD VSS _16937_/A XNOR2X1
XFILLER_77_84 VDD VSS FILLER4
XFILLER_78_876 VSS VDD FILLER2
X_11006_ _18677_/Q _18785_/Q VDD VSS _11009_/A XNOR2X1
X_19651_ _19678_/CK _19651_/D _19651_/Q VDD VSS DFFQX1
X_16863_ _16899_/A _16863_/B VDD VSS _19701_/D AND2X1
XFILLER_19_910 VDD VSS DECAPHV16
XTAP_TAPCELL_ROW_88_893 VDD VSS WELLTAP
X_19582_ _19615_/CK _19582_/D _19582_/Q VDD VSS DFFQX1
X_18602_ _18608_/CK _18602_/D _18602_/Q VDD VSS DFFQX1
X_15814_ _15816_/A _15814_/B VDD VSS _19430_/D NOR2X1
XFILLER_18_453 VSS VDD FILLER2
X_18533_ _18543_/CK _18533_/D _18533_/Q VDD VSS DFFQX1
X_16794_ _16794_/A _16794_/B VDD VSS _19640_/D NOR2X1
XFILLER_18_464 VDD VSS FILLER4
XFILLER_46_773 VSS VDD FILLER2
X_12957_ _13049_/A _13049_/B _13049_/C VDD VSS _13150_/A AOI21X1
X_15745_ _16795_/A VDD VSS _15770_/A BUFX3
XFILLER_61_743 VDD VSS FILLER1
X_11908_ _11908_/A _11943_/B _14367_/B VDD VSS _11909_/B MIN3X1
X_12888_ _18937_/Q _14185_/B _12888_/C VDD VSS _12992_/B MIN3X1
X_18464_ _18471_/CK _18496_/D _18464_/Q _18464_/RB VDD VSS DFFRQX1
X_15676_ _16795_/A VDD VSS _15706_/A BUFX3
XFILLER_61_776 VDD VSS FILLER1
X_11839_ _11839_/A _11839_/B _11839_/C _11839_/D VDD VSS _14490_/B OAOI211X1
X_14627_ _19497_/Q _15890_/B VDD VSS _14652_/B XNOR2X1
X_18395_ _18400_/CK _18512_/Q _20136_/A _09380_/B VDD VSS DFFRQX1
X_17415_ _17417_/C _17416_/B _17452_/C VDD VSS _17416_/C OAI21X1
XTAP_TAPCELL_ROW_15_164 VDD VSS WELLTAP
X_17346_ _17346_/A _17346_/B _17346_/C _17346_/D VDD VSS _17347_/C AOAI211X1
XFILLER_119_517 VDD VSS DECAPHV16
XTAP_TAPCELL_ROW_119_1203 VDD VSS WELLTAP
X_14558_ _19998_/Q _14558_/B VDD VSS _19262_/D AND2X1
X_13509_ _13509_/A _13509_/B _13509_/C _13509_/D VDD VSS _13683_/A AO31X2
X_14489_ _14493_/A _14489_/B VDD VSS _19201_/D NOR2X1
X_17277_ _19811_/Q _19779_/Q _17277_/C VDD VSS _17281_/B MIN3X1
XFILLER_127_561 VSS VDD FILLER2
XFILLER_134_509 VSS VDD FILLER2
XFILLER_9_195 VDD VSS FILLER1
X_19016_ _19045_/CK _19016_/D _19016_/Q VDD VSS DFFQX1
X_16228_ _16228_/A VDD VSS _16229_/B INVX1
XFILLER_127_583 VSS VDD FILLER2
X_16159_ _16159_/A _19908_/Q _16159_/C VDD VSS _16185_/C MIN3X1
XFILLER_102_417 VDD VSS FILLER1
XFILLER_87_117 VDD VSS FILLER1
XFILLER_96_640 VDD VSS FILLER1
X_19918_ clkload7/A _19918_/D _19918_/Q VDD VSS DFFQX1
XFILLER_68_353 VDD VSS FILLER1
XFILLER_96_673 VDD VSS FILLER4
X_19849_ _19863_/CK _19849_/D _19849_/Q VDD VSS DFFQX1
XFILLER_95_172 VSS VDD FILLER2
X_09602_ _18490_/Q VDD VSS _20103_/A INVX1
XFILLER_113_38 VSS VDD FILLER2
X_09533_ _20028_/Q _18199_/A VDD VSS _20029_/D NOR2BX1
XFILLER_25_913 VDD VSS FILLER4
XFILLER_25_924 VSS VDD FILLER2
XFILLER_37_773 VDD VSS DECAPHV16
XFILLER_71_529 VDD VSS DECAPHV8
XFILLER_36_294 VDD VSS FILLER4
X_09464_ _18446_/D _09468_/B _09464_/C VDD VSS _18251_/D AOI21X1
XFILLER_12_607 VDD VSS FILLER4
X_09395_ _18624_/Q _11436_/C VDD VSS _11433_/B NAND2X1
XFILLER_11_139 VDD VSS FILLER1
XFILLER_132_8 VSS VDD FILLER2
XTAP_TAPCELL_ROW_98_1000 VDD VSS WELLTAP
XFILLER_137_358 VDD VSS FILLER4
XFILLER_138_57 VDD VSS FILLER1
XFILLER_118_572 VSS VDD FILLER2
XFILLER_105_244 VDD VSS DECAPHV8
XFILLER_106_789 VDD VSS FILLER1
XFILLER_121_726 VDD VSS FILLER4
X_10170_ _10172_/A _10172_/B _10172_/D _10172_/C VDD VSS _10174_/C AOI211X1
XFILLER_120_247 VDD VSS FILLER4
XFILLER_87_662 VDD VSS FILLER4
XFILLER_87_673 VSS VDD FILLER2
Xfanout174 _11196_/A VDD VSS _11438_/A BUFX3
XFILLER_101_472 VDD VSS FILLER1
XFILLER_59_375 VSS VDD FILLER2
XFILLER_75_835 VSS VDD FILLER2
Xfanout196 _09414_/D VDD VSS _09349_/B BUFX3
XFILLER_74_334 VDD VSS FILLER1
XTAP_TAPCELL_ROW_85_863 VDD VSS WELLTAP
X_13860_ _13860_/A _14329_/B _13860_/C _13860_/D VDD VSS _13910_/B AOAI211X1
XTAP_TAPCELL_ROW_57_587 VDD VSS WELLTAP
X_12811_ _19076_/Q _14349_/B VDD VSS _12916_/D _14349_/C AND3X2
X_13791_ _13791_/A _13791_/B _13791_/C VDD VSS _14392_/B NOR3X1
XFILLER_43_743 VDD VSS FILLER1
XFILLER_55_592 VDD VSS FILLER1
XFILLER_63_20 VDD VSS FILLER1
X_12742_ _12813_/A _14410_/B _14410_/C VDD VSS _12910_/C NOR3X1
X_15530_ _15539_/A _15539_/B VDD VSS _15696_/B XOR2X1
XTAP_TAPCELL_ROW_103_1048 VDD VSS WELLTAP
X_12673_ _12673_/A _12673_/B _12673_/C _12673_/D VDD VSS _12763_/A OAI31X1
Xclkbuf_leaf_18_clk_regs clkbuf_leaf_9_clk_regs/A VDD VSS _19928_/CK BUFX12
X_15461_ _19350_/Q _15724_/B VDD VSS _15462_/C NOR2BX1
XFILLER_30_437 VDD VSS FILLER1
XFILLER_42_297 VSS VDD FILLER2
X_11624_ _18767_/Q _11624_/B VDD VSS _18794_/D AND2X1
X_14412_ _17566_/A VDD VSS _14449_/A BUFX3
X_17200_ _19795_/Q _19763_/Q VDD VSS _17202_/B XOR2X1
XTAP_TAPCELL_ROW_12_134 VDD VSS WELLTAP
X_18180_ _19302_/Q _18181_/B VDD VSS _18185_/C AND2X1
X_15392_ _19460_/Q VDD VSS _15394_/A INVX1
XFILLER_128_336 VSS VDD FILLER2
XFILLER_7_633 VSS VDD FILLER2
X_11555_ _18704_/Q _11555_/B VDD VSS _18731_/D AND2X1
X_14343_ _14368_/A _14343_/B VDD VSS _19070_/D NOR2X1
X_17131_ _19780_/Q _19748_/Q VDD VSS _17132_/C NAND2X1
XFILLER_128_369 VDD VSS FILLER4
XFILLER_144_818 VDD VSS DECAPHV16
XFILLER_6_132 VSS VDD FILLER2
X_10506_ _18557_/Q _10507_/B VDD VSS _10544_/C AND2X1
X_11486_ _18641_/Q _11496_/B VDD VSS _18668_/D AND2X1
X_14274_ _14285_/A _14274_/B VDD VSS _19011_/D NOR2X1
X_17062_ _17208_/B _17062_/B _17062_/C _17062_/D VDD VSS _17062_/Y AOAI211X1
XFILLER_109_572 VDD VSS DECAPHV8
XFILLER_109_594 VDD VSS FILLER1
X_10437_ _18634_/Q _18796_/Q VDD VSS _10476_/C NAND2X1
X_13225_ _19164_/Q VDD VSS _13355_/A INVX1
X_16013_ _16013_/A _16013_/B VDD VSS _16872_/B XNOR2X1
XFILLER_6_187 VDD VSS FILLER1
XTAP_TAPCELL_ROW_114_1155 VDD VSS WELLTAP
X_10368_ _18632_/Q _18794_/Q VDD VSS _10402_/A AND2X1
X_13156_ _19164_/Q _13331_/A _13443_/B VDD VSS _13315_/D XNOR3X1
XFILLER_111_236 VDD VSS FILLER1
XFILLER_88_83 VDD VSS FILLER4
X_10299_ _10538_/A _10550_/A _10465_/B VDD VSS _10299_/Y NOR3X1
X_12107_ _19999_/Q _19263_/Q VDD VSS _12108_/D AND2X1
X_13087_ _13097_/A _13097_/B _13097_/C VDD VSS _14257_/B OAI21X1
X_17964_ _18869_/Q _17964_/B _17964_/C VDD VSS _17966_/C XNOR3X1
XFILLER_111_269 VDD VSS FILLER4
X_12038_ _19206_/Q _12038_/B _12099_/C VDD VSS _12113_/B XOR3X1
X_19703_ _19703_/CK _19703_/D _19703_/Q VDD VSS DFFQX1
X_16915_ _16978_/B VDD VSS _17011_/B BUFX3
XFILLER_78_684 VSS VDD FILLER2
X_19634_ _19636_/CK _19634_/D _19634_/Q VDD VSS DFFQX1
X_17895_ _18857_/Q _17901_/B VDD VSS _17898_/B NAND2X1
XFILLER_66_879 VDD VSS FILLER4
XFILLER_77_194 VDD VSS DECAPHV16
X_16846_ _16865_/A _16846_/B VDD VSS _19685_/D NOR2X1
XFILLER_18_261 VSS VDD FILLER2
XFILLER_19_784 VDD VSS FILLER1
XFILLER_46_570 VDD VSS FILLER1
XFILLER_65_367 VDD VSS FILLER4
XFILLER_92_164 VSS VDD FILLER2
X_13989_ _13989_/A _14198_/B _14198_/C VDD VSS _13990_/D NOR3X1
X_19565_ _19604_/CK _19565_/D _19565_/Q VDD VSS DFFQX1
X_16777_ _16794_/A _16777_/B VDD VSS _19623_/D NOR2X1
XFILLER_34_743 VDD VSS DECAPHV16
XFILLER_80_348 VDD VSS FILLER1
XTAP_TAPCELL_ROW_125_1262 VDD VSS WELLTAP
X_19496_ _19521_/CK _19496_/D _19496_/Q VDD VSS DFFQX1
X_18516_ _18516_/CK _18516_/D _18516_/Q _09328_/Y VDD VSS DFFRQX1
X_15728_ _15739_/A _15728_/B VDD VSS _19353_/D NOR2X1
XTAP_TAPCELL_ROW_8_91 VDD VSS WELLTAP
X_18447_ _18453_/CK _18447_/D _18447_/Q _18455_/RB VDD VSS DFFRQX1
XFILLER_22_949 VDD VSS FILLER1
XFILLER_61_573 VDD VSS FILLER1
X_15659_ _19330_/Q _15702_/B VDD VSS _15660_/B XNOR2X1
XFILLER_21_459 VDD VSS FILLER4
X_18378_ _18391_/CK _18511_/Q _20183_/A _20064_/RB VDD VSS DFFRQX1
X_17329_ _17479_/B _17329_/B _17329_/C VDD VSS _17334_/C MIN3X1
XFILLER_119_358 VSS VDD FILLER2
XTAP_TAPCELL_ROW_136_1380 VDD VSS WELLTAP
XFILLER_103_726 VDD VSS FILLER4
XFILLER_143_884 VDD VSS FILLER1
XFILLER_88_404 VDD VSS FILLER1
XFILLER_89_916 VDD VSS FILLER4
XFILLER_102_225 VSS VDD FILLER2
XFILLER_88_437 VDD VSS DECAPHV8
XFILLER_124_37 VDD VSS FILLER1
XFILLER_57_802 VDD VSS FILLER1
XFILLER_111_770 VDD VSS FILLER4
XFILLER_29_515 VDD VSS FILLER1
XFILLER_68_161 VDD VSS FILLER1
XFILLER_69_695 VDD VSS DECAPHV16
XFILLER_84_19 VDD VSS DECAPHV8
XFILLER_110_280 VSS VDD FILLER2
XFILLER_84_643 VDD VSS FILLER1
XFILLER_84_654 VDD VSS FILLER1
XFILLER_17_35 VDD VSS FILLER1
XFILLER_44_518 VDD VSS FILLER1
XTAP_TAPCELL_ROW_82_833 VDD VSS WELLTAP
X_09516_ _20014_/Q _09516_/B VDD VSS _18197_/D OR2X2
XFILLER_24_231 VDD VSS FILLER1
XFILLER_52_540 VSS VDD FILLER2
XTAP_TAPCELL_ROW_54_557 VDD VSS WELLTAP
X_09447_ _09624_/B _09447_/B VDD VSS _18222_/E NOR2X1
XFILLER_12_404 VSS VDD FILLER2
XFILLER_52_595 VSS VDD FILLER2
XFILLER_12_448 VSS VDD FILLER2
XTAP_TAPCELL_ROW_139_1409 VDD VSS WELLTAP
X_09378_ _09410_/B VDD VSS _09818_/B BUFX3
XFILLER_20_470 VSS VDD FILLER2
X_11340_ _11340_/A _11342_/B _11364_/B VDD VSS _11357_/A OA21X2
XFILLER_4_603 VDD VSS FILLER1
XFILLER_4_647 VDD VSS FILLER1
X_11271_ _11271_/A _11275_/B VDD VSS _11272_/B XOR2X1
X_13010_ _19050_/Q VDD VSS _13091_/A INVX1
XFILLER_106_575 VDD VSS DECAPHV8
X_10222_ _10224_/A _10222_/B VDD VSS _10224_/C NOR2X1
X_10153_ _11229_/A _10153_/B VDD VSS _10154_/C NOR2X1
XFILLER_58_42 VDD VSS FILLER4
XFILLER_79_459 VDD VSS FILLER4
XFILLER_48_835 VDD VSS FILLER4
X_10084_ _09952_/B _10175_/D _10131_/A VDD VSS _10098_/B MUXI2X1
X_16700_ _19906_/Q _16702_/B VDD VSS _19554_/D AND2X1
X_14961_ _19478_/Q _15869_/B VDD VSS _15000_/D NAND2X1
XFILLER_75_665 VDD VSS DECAPHV8
X_13912_ _13912_/A _13912_/B _14332_/B _13912_/D _13912_/E VDD VSS _13965_/C OAI221X1
X_17680_ _17680_/A _17680_/B VDD VSS _17681_/B XNOR2X1
X_14892_ _19337_/Q _15710_/B VDD VSS _14893_/B XNOR2X1
XFILLER_114_92 VSS VDD FILLER2
XFILLER_47_367 VDD VSS FILLER1
XFILLER_63_827 VSS VDD FILLER2
XFILLER_74_142 VDD VSS DECAPHV8
XFILLER_90_602 VSS VDD FILLER2
XFILLER_90_624 VDD VSS FILLER1
X_13843_ _13843_/A _13843_/B _13843_/C _13843_/D VDD VSS _14265_/C OAI211X1
X_16631_ _16631_/A _16631_/B _16631_/C VDD VSS _16632_/B NOR3X1
X_19350_ _19362_/CK _19350_/D _19350_/Q VDD VSS DFFQX1
X_16562_ _16585_/B _16562_/B VDD VSS _16897_/B NAND2BX1
XFILLER_15_231 VDD VSS FILLER4
XFILLER_16_754 VDD VSS FILLER4
XFILLER_62_359 VDD VSS FILLER1
X_10986_ _10841_/Y _11119_/B _11118_/A VDD VSS _11235_/B MUXI2X1
X_13774_ _13845_/A _14229_/B VDD VSS _13827_/B NOR2X1
X_18301_ _18310_/CK _18477_/D _18301_/Q _20075_/RB VDD VSS DFFRQX1
X_15513_ _15913_/B VDD VSS _15514_/C INVX1
XFILLER_31_735 VDD VSS FILLER1
X_12725_ _19102_/Q _14379_/B _14379_/C VDD VSS _12729_/D OR3BX1
X_19281_ _19290_/CK _19281_/D _19281_/Q VDD VSS DFFQX1
X_16493_ _19665_/Q _16823_/B VDD VSS _16494_/C NOR2X1
XFILLER_90_40 VSS VDD FILLER2
XTAP_TAPCELL_ROW_25_270 VDD VSS WELLTAP
X_12656_ _12656_/A _12656_/B _12656_/C _12656_/D VDD VSS _14409_/B OAOI211X1
X_18232_ _18232_/CK _18232_/E _18232_/ECK VDD VSS CGX3
X_15444_ _15471_/B _15444_/B VDD VSS _15468_/A XNOR2X1
XFILLER_129_634 VDD VSS FILLER1
X_11607_ _18751_/Q _11612_/B VDD VSS _18778_/D AND2X1
X_12587_ _19242_/Q _12666_/A _12678_/C VDD VSS _12837_/C XNOR3X1
X_18163_ _18163_/A _18163_/B _18167_/B VDD VSS _20006_/D NOR3X1
X_15375_ _15376_/A _15376_/B _15376_/C VDD VSS _15425_/B OAI21X1
XFILLER_128_122 VDD VSS FILLER1
X_14326_ _14316_/Y _14326_/B _14326_/C VDD VSS _19055_/D AND3BX1
X_17114_ _17263_/B _17114_/B _17114_/C VDD VSS _17118_/C MIN3X1
X_11538_ _18689_/Q _11542_/B VDD VSS _18716_/D AND2X1
X_18094_ _19285_/Q _18094_/B VDD VSS _18096_/A NAND2X1
XFILLER_143_147 VDD VSS FILLER1
X_11469_ _11469_/A _11641_/B VDD VSS _18653_/D NOR2X1
X_14257_ _14255_/Y _14257_/B _14257_/C VDD VSS _18995_/D AND3BX1
X_17045_ _17045_/A _17045_/B _17045_/C _17045_/D VDD VSS _17064_/A OAOI211X1
XFILLER_112_501 VSS VDD FILLER2
XFILLER_125_884 VDD VSS DECAPHV8
X_13208_ _13415_/A _13415_/B _13208_/C VDD VSS _14291_/C OAI21X1
X_14188_ _14457_/A VDD VSS _14218_/A BUFX3
XFILLER_124_372 VSS VDD FILLER2
X_13139_ _13444_/A _13139_/B VDD VSS _14512_/B XNOR2X1
X_18996_ _19050_/CK _18996_/D _18996_/Q VDD VSS DFFQX1
XFILLER_85_429 VDD VSS FILLER1
X_17947_ _17958_/B _18087_/D VDD VSS _17948_/D NAND2BX1
XFILLER_39_846 VDD VSS FILLER1
X_17878_ _17880_/C _17879_/B _17917_/C VDD VSS _17879_/C OAI21X1
XFILLER_26_507 VDD VSS FILLER4
XFILLER_26_529 VSS VDD FILLER2
XFILLER_38_367 VDD VSS DECAPHV8
XFILLER_65_164 VDD VSS FILLER4
X_19617_ _19678_/CK _19617_/D _19617_/Q VDD VSS DFFQX1
X_16829_ _16838_/A _16829_/B VDD VSS _19670_/D NOR2X1
X_19548_ _19615_/CK _19548_/D _19548_/Q VDD VSS DFFQX1
XFILLER_0_93 VDD VSS FILLER1
X_09301_ _09301_/A _09301_/B VDD VSS _09302_/A NOR2X2
XFILLER_21_212 VSS VDD FILLER2
XFILLER_80_178 VDD VSS FILLER1
XTAP_TAPCELL_ROW_51_527 VDD VSS WELLTAP
X_19479_ _19483_/CK _19479_/D _19479_/Q VDD VSS DFFQX1
X_09232_ _18498_/D VDD VSS _18354_/D INVX1
XFILLER_21_278 VDD VSS FILLER1
XFILLER_119_26 VDD VSS DECAPHV8
XFILLER_107_306 VDD VSS FILLER1
XFILLER_107_328 VDD VSS FILLER4
XFILLER_119_166 VDD VSS DECAPHV8
XFILLER_119_59 VDD VSS FILLER1
XFILLER_135_648 VSS VDD FILLER2
XFILLER_115_361 VDD VSS DECAPHV8
XFILLER_134_158 VSS VDD FILLER2
XFILLER_115_394 VDD VSS FILLER1
XFILLER_135_36 VSS VDD FILLER2
XFILLER_103_556 VSS VDD FILLER2
XFILLER_131_876 VDD VSS DECAPHV8
XFILLER_77_908 VDD VSS DECAPHV8
XFILLER_89_779 VSS VDD FILLER2
X_09996_ _09996_/A _09996_/B _09996_/C VDD VSS _09998_/C OA21X2
X_20185_ _20185_/A VDD VSS _20185_/Y BUFX3
XFILLER_103_578 VDD VSS DECAPHV16
XTAP_TAPCELL_ROW_59_605 VDD VSS WELLTAP
XFILLER_17_529 VSS VDD FILLER2
XFILLER_38_890 VSS VDD FILLER2
XTAP_TAPCELL_ROW_67_682 VDD VSS WELLTAP
X_10840_ _11116_/A _10840_/B _10840_/C VDD VSS _10840_/Y OAI21X1
XFILLER_53_871 VSS VDD FILLER2
XFILLER_71_178 VDD VSS DECAPHV8
XFILLER_71_189 VSS VDD FILLER2
X_10771_ _11229_/D _10771_/B _10771_/C VDD VSS _10772_/D OAI21X1
XFILLER_12_245 VSS VDD FILLER2
XFILLER_9_717 VDD VSS FILLER1
XTAP_TAPCELL_ROW_100_1018 VDD VSS WELLTAP
X_12510_ _12510_/A _12510_/B _12510_/C _12510_/D VDD VSS _12600_/B AOAI211X1
X_13490_ _18943_/Q _13490_/B _13516_/C VDD VSS _13656_/B XNOR3X1
XFILLER_12_267 VDD VSS DECAPHV8
XFILLER_139_921 VDD VSS DECAPHV8
XFILLER_13_779 VDD VSS DECAPHV8
XFILLER_40_565 VSS VDD FILLER2
XFILLER_60_21 VDD VSS FILLER1
XTAP_TAPCELL_ROW_22_240 VDD VSS WELLTAP
X_12441_ _12441_/A _12441_/B _14248_/B VDD VSS _12537_/B MIN3X1
XFILLER_138_431 VDD VSS FILLER1
XFILLER_21_790 VDD VSS FILLER4
XFILLER_126_626 VDD VSS FILLER1
X_12372_ _12372_/A _12372_/B _12372_/C _12372_/D VDD VSS _12378_/A AOI31X1
X_15160_ _19427_/Q _15811_/B VDD VSS _15161_/B XOR2X1
XFILLER_107_840 VDD VSS FILLER1
XFILLER_114_0 VSS VDD FILLER2
XFILLER_125_125 VDD VSS DECAPHV16
XFILLER_126_648 VSS VDD FILLER2
X_11323_ _18586_/Q VDD VSS _11325_/D INVX1
X_14111_ _17977_/A _17977_/B _17978_/B _14111_/D VDD VSS _17982_/B OAOI211X1
X_15091_ _19453_/Q _15838_/B VDD VSS _15139_/A NAND2X1
XFILLER_122_810 VDD VSS DECAPHV16
X_11254_ _11264_/A _11264_/B _11364_/B VDD VSS _11258_/A OA21X2
X_14042_ _18980_/Q _14236_/B VDD VSS _14068_/B XNOR2X1
XFILLER_121_320 VSS VDD FILLER2
XTAP_TAPCELL_ROW_111_1125 VDD VSS WELLTAP
X_10205_ _10130_/Y _10204_/Y _10224_/A VDD VSS _10207_/B MUXI2X1
X_18850_ _18878_/CK _18850_/D _18850_/Q VDD VSS DFFQX1
XFILLER_122_854 VDD VSS FILLER1
XFILLER_133_180 VDD VSS FILLER4
XFILLER_69_96 VDD VSS DECAPHV8
X_11185_ _11184_/Y _18576_/Q VDD VSS _11217_/B NOR2BX1
X_17801_ _17802_/A _17803_/C _17828_/C VDD VSS _17802_/C OAI21X1
XFILLER_121_375 VSS VDD FILLER2
XFILLER_95_738 VDD VSS FILLER4
X_10136_ _10150_/A _10136_/B VDD VSS _11417_/C XNOR2X1
X_18781_ _18782_/CK _18781_/D _18781_/Q VDD VSS DFFQX1
X_15993_ _15993_/A _15993_/B _15993_/C VDD VSS _15999_/A AOI21X1
XFILLER_48_632 VDD VSS DECAPHV8
X_10067_ _18583_/Q _10079_/C VDD VSS _10068_/B NAND2X1
X_17732_ _19909_/Q _19877_/Q VDD VSS _17738_/B NAND2X1
X_14944_ _14954_/B _14944_/B VDD VSS _15711_/B XNOR2X1
XFILLER_35_304 VDD VSS FILLER1
XFILLER_63_602 VSS VDD FILLER2
XFILLER_75_462 VSS VDD FILLER2
XFILLER_91_922 VDD VSS DECAPHV8
X_17663_ _19893_/Q _19861_/Q _17663_/C VDD VSS _17667_/B MIN3X1
X_19402_ _19425_/CK _19402_/D _19402_/Q VDD VSS DFFQX1
X_16614_ _19734_/Q _16899_/B VDD VSS _16616_/C XNOR2X1
X_14875_ _15015_/C VDD VSS _14881_/C INVX1
XFILLER_16_551 VDD VSS FILLER1
XFILLER_62_156 VDD VSS FILLER4
X_13826_ _18975_/Q VDD VSS _13827_/A INVX1
X_17594_ _17596_/C _17594_/B _17594_/C VDD VSS _19879_/D AOI21X1
XFILLER_31_510 VDD VSS FILLER1
XFILLER_62_189 VDD VSS FILLER1
XTAP_TAPCELL_ROW_122_1232 VDD VSS WELLTAP
X_10969_ _18676_/Q _18784_/Q VDD VSS _11007_/B NAND2X1
X_13757_ _13771_/A _14195_/B _13771_/C VDD VSS _14196_/B OAI21X1
X_19333_ _19358_/CK _19333_/D _19333_/Q VDD VSS DFFQX1
X_16545_ _16545_/A _16545_/B _16825_/B VDD VSS _16558_/A MIN3X1
XFILLER_31_521 VDD VSS FILLER1
X_12708_ _18935_/Q _12708_/B _12708_/C VDD VSS _12877_/B MIN3X1
X_19264_ _20005_/CK _19264_/D _19264_/Q VDD VSS DFFQX1
X_16476_ _16476_/A _19920_/Q _16476_/C VDD VSS _16498_/C MIN3X1
X_13688_ _13688_/A _13688_/B _13688_/C _13688_/D VDD VSS _14195_/B OAOI211X1
X_18215_ _18223_/CK _18215_/E _18215_/ECK VDD VSS CGX3
X_15427_ _15427_/A _15427_/B _15427_/C VDD VSS _15465_/A AOI21X1
XTAP_TAPCELL_ROW_5_70 VDD VSS WELLTAP
X_12639_ _12732_/A _12732_/C _12732_/B VDD VSS _14379_/C AOI21X1
X_19195_ _19202_/CK _19195_/D _19195_/Q VDD VSS DFFQX1
XFILLER_144_412 VSS VDD FILLER2
X_18146_ _18150_/A _18146_/B _18146_/C VDD VSS _20003_/D AOI21X1
X_15358_ _19515_/Q _15910_/B VDD VSS _15360_/A XNOR2X1
XFILLER_117_648 VSS VDD FILLER2
X_14309_ _14311_/A _14309_/B VDD VSS _19041_/D NOR2X1
X_18077_ _18087_/D _18083_/B VDD VSS _18078_/C NAND2X1
X_15289_ _15289_/A _15305_/C VDD VSS _15751_/B XOR2X1
XFILLER_116_158 VSS VDD FILLER2
XFILLER_132_607 VSS VDD FILLER2
XTAP_TAPCELL_ROW_133_1350 VDD VSS WELLTAP
Xclkbuf_leaf_2_sclk clkbuf_leaf_3_sclk/A VDD VSS _18233_/CK BUFX12
X_17028_ _17028_/A _17030_/A _17030_/B _17028_/D VDD VSS _19759_/D AOI31X1
XFILLER_98_510 VDD VSS FILLER1
X_09850_ _09855_/B _09850_/B VDD VSS _09850_/Y NOR2X1
Xclkbuf_1_1__f__09173_ clkbuf_0__09173_/Y VDD VSS _18310_/CK BUFX12
XFILLER_86_749 VDD VSS FILLER4
X_09781_ _18373_/Q _09787_/B _09810_/B _18341_/Q VDD VSS _09782_/E OAI22X1
X_18979_ _19171_/CK _18979_/D _18979_/Q VDD VSS DFFQX1
XFILLER_39_643 VSS VDD FILLER2
XFILLER_39_654 VDD VSS FILLER1
XFILLER_38_142 VDD VSS FILLER4
XFILLER_27_849 VDD VSS FILLER1
XFILLER_121_38 VSS VDD FILLER2
XFILLER_35_860 VDD VSS FILLER4
XFILLER_54_668 VSS VDD FILLER2
XTAP_TAPCELL_ROW_64_652 VDD VSS WELLTAP
XFILLER_41_307 VSS VDD FILLER2
XFILLER_53_178 VDD VSS FILLER4
XFILLER_53_189 VDD VSS FILLER1
XTAP_TAPCELL_ROW_36_376 VDD VSS WELLTAP
XFILLER_50_841 VDD VSS DECAPHV16
XFILLER_139_228 VSS VDD FILLER2
X_09215_ _18470_/D VDD VSS _18406_/D INVX1
XFILLER_136_902 VDD VSS FILLER1
XFILLER_135_401 VSS VDD FILLER2
XFILLER_136_935 VDD VSS DECAPHV8
XFILLER_123_607 VSS VDD FILLER2
XTAP_TAPCELL_ROW_1_28 VDD VSS WELLTAP
XFILLER_122_106 VDD VSS FILLER4
XFILLER_135_489 VSS VDD FILLER2
XFILLER_77_705 VDD VSS DECAPHV16
XFILLER_89_554 VDD VSS FILLER4
XFILLER_103_353 VSS VDD FILLER2
XFILLER_130_150 VDD VSS FILLER4
XFILLER_131_662 VDD VSS FILLER4
XFILLER_131_684 VDD VSS FILLER1
X_20168_ _20168_/A VDD VSS _20168_/Y BUFX3
Xclkbuf_1_1__f__002_ clkbuf_0__002_/Y VDD VSS clkbuf_leaf_9__002_/A BUFX12
Xclkbuf_leaf_0__000_ clkload77/A VDD VSS _19521_/CK BUFX12
X_12990_ _18910_/Q _13076_/B _13076_/C VDD VSS _13178_/B MIN3X1
X_20099_ _20099_/A VDD VSS _20099_/Y BUFX3
XFILLER_57_484 VSS VDD FILLER2
XFILLER_84_281 VSS VDD FILLER2
X_11941_ _19065_/Q _12023_/B _12018_/B VDD VSS _12014_/A XNOR3X1
X_11872_ _11918_/A _11915_/C VDD VSS _14461_/B XNOR2X1
X_14660_ _19471_/Q _14700_/B _15862_/B VDD VSS _14673_/C XOR3X1
XFILLER_72_487 VDD VSS DECAPHV16
X_10823_ _10823_/A _10823_/B VDD VSS _10838_/B XNOR2X1
X_13611_ _19028_/Q _14295_/B VDD VSS _13840_/A AND2X1
X_14591_ _14615_/A _14615_/B _14615_/C VDD VSS _14595_/C XNOR3X1
X_13542_ _13542_/A _13542_/B _13542_/C VDD VSS _13546_/B XNOR3X1
X_16330_ _16512_/A _16330_/B VDD VSS _19531_/D NOR2X1
XFILLER_71_42 VSS VDD FILLER2
X_10754_ _18643_/Q _18805_/Q VDD VSS _10798_/B NAND2X1
XFILLER_139_751 VSS VDD FILLER2
X_10685_ _10722_/A _10686_/B VDD VSS _10686_/C NAND2X1
X_13473_ _19055_/Q _13473_/B _13601_/D VDD VSS _13599_/C XNOR3X1
X_18000_ _18543_/Q _18044_/B VDD VSS _18048_/B AND2X1
X_16261_ _19593_/Q _16743_/B VDD VSS _16262_/B XNOR2X1
XFILLER_127_913 VDD VSS FILLER4
X_12424_ _19044_/Q _12510_/A _14313_/B VDD VSS _14282_/B XNOR3X1
X_16192_ _16203_/B _16192_/B VDD VSS _16847_/B XNOR2X1
X_15212_ _15218_/B _15212_/B VDD VSS _15687_/B XNOR2X1
XFILLER_126_445 VDD VSS DECAPHV16
X_12355_ _18988_/Q VDD VSS _12441_/A INVX1
X_15143_ _15183_/A _15183_/B VDD VSS _15157_/B NAND2X1
X_11306_ _11370_/A _11379_/B VDD VSS _11356_/C AND2X1
X_12286_ _12448_/B _12286_/B VDD VSS _12287_/C XNOR2X1
X_19951_ _19951_/CK _19951_/D _19951_/Q VDD VSS DFFQX1
X_15074_ _15081_/B _15074_/B VDD VSS _15715_/B XOR2X1
X_11237_ _18578_/Q _11249_/B VDD VSS _11239_/B XOR2X1
X_14025_ _14058_/A _14085_/B VDD VSS _14138_/B XNOR2X1
X_19882_ clkload7/A _19882_/D _19882_/Q VDD VSS DFFQX1
X_18902_ _18935_/CK _18902_/D _18902_/Q VDD VSS DFFQX1
XFILLER_68_716 VDD VSS DECAPHV8
XFILLER_95_524 VDD VSS FILLER1
X_11168_ _11229_/D _11168_/B _11200_/C VDD VSS _11169_/D NOR3X1
X_18833_ _19951_/CK _18833_/D _18833_/Q VDD VSS DFFQX1
XFILLER_67_248 VSS VDD FILLER2
X_10119_ _18610_/Q _10126_/B VDD VSS _10123_/C XNOR2X1
X_18764_ _18764_/CK _18764_/D _18764_/Q VDD VSS DFFQX1
XFILLER_36_602 VSS VDD FILLER2
X_11099_ _11497_/A _11677_/A _11099_/C VDD VSS _11136_/C MIN3X1
X_17715_ _17716_/C _17715_/B _17715_/C VDD VSS _19905_/D AOI21X1
X_15976_ _16836_/B VDD VSS _15986_/B INVX1
XFILLER_75_270 VDD VSS DECAPHV8
XFILLER_76_793 VDD VSS DECAPHV16
XFILLER_82_229 VSS VDD FILLER2
XTAP_TAPCELL_ROW_78_799 VDD VSS WELLTAP
X_18695_ _19948_/CK _18695_/D _18695_/Q VDD VSS DFFQX1
X_14927_ _15016_/A _15017_/C VDD VSS _14966_/C NAND2X1
XFILLER_90_240 VSS VDD FILLER2
X_17646_ _17646_/A _17646_/B _17646_/C _17646_/D VDD VSS _17647_/C AOAI211X1
X_14858_ _19392_/Q _14858_/B _15770_/B VDD VSS _14904_/B MIN3X1
XFILLER_17_882 VDD VSS DECAPHV8
XFILLER_35_189 VDD VSS FILLER4
X_13809_ _13873_/A _13809_/B _13918_/D VDD VSS _13876_/C XNOR3X1
X_17577_ _19875_/Q _19843_/Q _17577_/C VDD VSS _17581_/B MIN3X1
XFILLER_50_137 VSS VDD FILLER2
XTAP_TAPCELL_ROW_61_622 VDD VSS WELLTAP
X_19316_ _19337_/CK _19316_/D _19316_/Q VDD VSS DFFQX1
X_16528_ _16551_/C _16528_/B VDD VSS _16754_/B XNOR2X1
X_14789_ _19502_/Q _14789_/B VDD VSS _14872_/D NAND2X1
XFILLER_91_2 VDD VSS FILLER1
XTAP_TAPCELL_ROW_33_346 VDD VSS WELLTAP
X_19247_ _19250_/CK _19247_/D _19247_/Q VDD VSS DFFQX1
X_16459_ _16459_/A _16459_/B VDD VSS _16460_/B _16459_/C NAND3X1
XFILLER_77_0 VSS VDD FILLER2
X_19178_ _19187_/CK _19178_/D _19178_/Q VDD VSS DFFQX1
XFILLER_117_412 VDD VSS DECAPHV16
XFILLER_118_946 VDD VSS FILLER4
X_18129_ _19292_/Q _18133_/B VDD VSS _18131_/C XNOR2X1
XFILLER_133_905 VDD VSS DECAPHV8
XFILLER_104_128 VDD VSS FILLER4
XFILLER_133_949 VDD VSS FILLER1
X_09902_ _11014_/A _09902_/B _09902_/C VDD VSS _09902_/Y OAI21X1
X_09833_ _10383_/A VDD VSS _11195_/A BUFX3
X_20022_ _20022_/CK _20022_/D _20022_/Q _20031_/RB VDD VSS DFFRQX1
XFILLER_113_695 VSS VDD FILLER2
XFILLER_58_259 VDD VSS DECAPHV16
XFILLER_73_207 VSS VDD FILLER2
XFILLER_74_708 VDD VSS FILLER4
X_09764_ _18372_/Q VDD VSS _20209_/A INVX1
XFILLER_132_37 VDD VSS FILLER1
XFILLER_27_635 VDD VSS DECAPHV8
XFILLER_55_933 VDD VSS FILLER4
XFILLER_94_590 VSS VDD FILLER2
X_09695_ _18303_/Q _09812_/B _09811_/C _20204_/A VDD VSS _09698_/A AOI22X1
XTAP_TAPCELL_ROW_142_1438 VDD VSS WELLTAP
XFILLER_26_156 VSS VDD FILLER2
XFILLER_54_476 VDD VSS FILLER1
XFILLER_81_262 VDD VSS FILLER1
XFILLER_23_852 VDD VSS FILLER4
XFILLER_10_557 VDD VSS FILLER4
X_10470_ _18556_/Q _10474_/B VDD VSS _10472_/C XNOR2X1
XFILLER_10_579 VSS VDD FILLER2
XFILLER_124_916 VDD VSS FILLER1
X_12140_ _19068_/Q _12188_/A _12140_/C VDD VSS _12283_/B MIN3X1
XFILLER_124_949 VDD VSS FILLER1
XFILLER_136_798 VSS VDD FILLER2
XFILLER_2_723 VDD VSS FILLER4
X_12071_ _18984_/Q VDD VSS _12132_/A INVX1
X_11022_ _11023_/A _11023_/B _11023_/D _11023_/C VDD VSS _11024_/B AOAI211X1
XFILLER_49_226 VDD VSS FILLER1
XFILLER_66_20 VDD VSS FILLER1
X_15830_ _15830_/A _15830_/B VDD VSS _19445_/D NOR2X1
XFILLER_77_579 VSS VDD FILLER2
XFILLER_45_421 VSS VDD FILLER2
XFILLER_58_793 VDD VSS DECAPHV16
XFILLER_85_590 VDD VSS FILLER4
XFILLER_92_527 VSS VDD FILLER2
X_12973_ _19134_/Q _12973_/B _13041_/C VDD VSS _13314_/B XNOR3X1
X_15761_ _15780_/A _15761_/B VDD VSS _19383_/D NOR2X1
XTAP_TAPCELL_ROW_75_769 VDD VSS WELLTAP
X_11924_ _19204_/Q _14493_/B VDD VSS _11987_/A NOR2BX1
X_18480_ _18487_/CK _18496_/D _20125_/A _18496_/RB VDD VSS DFFRQX1
X_17500_ _17503_/C _17501_/B _17509_/C VDD VSS _17501_/C OAI21X1
X_15692_ _15706_/A _15692_/B VDD VSS _19321_/D AND2X1
X_14712_ _19527_/Q _14712_/B VDD VSS _15893_/B XOR2X1
XFILLER_122_92 VDD VSS FILLER1
XFILLER_72_251 VSS VDD FILLER2
XFILLER_73_774 VSS VDD FILLER2
X_14643_ _14671_/A _14671_/B _15861_/B VDD VSS _14700_/B MIN3X1
X_17431_ _17431_/A _17431_/B _17431_/C VDD VSS _17439_/A OA21X2
XFILLER_17_189 VSS VDD FILLER2
XFILLER_32_137 VSS VDD FILLER2
XFILLER_60_435 VDD VSS FILLER1
XFILLER_72_284 VSS VDD FILLER2
XTAP_TAPCELL_ROW_106_1079 VDD VSS WELLTAP
X_11855_ _19119_/Q _11966_/A _11966_/B VDD VSS _11866_/B XNOR3X1
X_10806_ _10773_/B _10839_/B _10945_/A VDD VSS _10808_/B MUX2X1
X_11786_ _19117_/Q _11819_/B _11790_/C VDD VSS _14365_/B XNOR3X1
X_14574_ _20012_/Q _16702_/B VDD VSS _19276_/D AND2X1
Xclkbuf_1_0__f__09176_ clkbuf_0__09176_/Y VDD VSS _18240_/CK BUFX12
X_19101_ _19126_/CK _19101_/D _19101_/Q VDD VSS DFFQX1
X_17362_ _19829_/Q _19797_/Q _17362_/C VDD VSS _17366_/B MIN3X1
XFILLER_40_170 VSS VDD FILLER2
XTAP_TAPCELL_ROW_30_316 VDD VSS WELLTAP
X_10737_ _10843_/A _10737_/B _10737_/C _10737_/D VDD VSS _11018_/B OAI31X1
X_13525_ _13683_/A _13683_/B _13683_/C VDD VSS _13567_/B AOI21X1
X_17293_ _17296_/C _17294_/B _17306_/C VDD VSS _17294_/C OAI21X1
X_16313_ _16313_/A _19914_/Q _16313_/C VDD VSS _16340_/C MIN3X1
X_13456_ _19221_/Q _14514_/B VDD VSS _13457_/C _14514_/C NAND3X1
X_19032_ _19115_/CK _19032_/D _19032_/Q VDD VSS DFFQX1
X_16244_ _19688_/Q _16849_/B VDD VSS _16245_/B XNOR2X1
XFILLER_126_220 VDD VSS FILLER1
XFILLER_139_592 VSS VDD FILLER2
X_10668_ _10668_/A _10668_/B VDD VSS _10671_/B NAND2X1
X_12407_ _12407_/A _14531_/B _12407_/C _12407_/D VDD VSS _12577_/B AOI31X1
XFILLER_5_550 VDD VSS DECAPHV8
X_10599_ _18693_/Q _18747_/Q VDD VSS _10601_/C XNOR2X1
X_13387_ _13393_/A _13393_/B _13393_/C VDD VSS _14159_/C OR3X2
Xoutput107 _20191_/Y VDD VSS o_tst_ctrl[10] BUFX3
X_16175_ _19685_/Q _16175_/B _16846_/B VDD VSS _16201_/B MIN3X1
XFILLER_115_949 VDD VSS FILLER1
XFILLER_127_787 VDD VSS DECAPHV8
XFILLER_5_561 VDD VSS DECAPHV8
XTAP_TAPCELL_ROW_117_1186 VDD VSS WELLTAP
X_12338_ _12357_/A _12357_/B _14281_/B VDD VSS _14247_/B XNOR3X1
Xoutput129 _20213_/Y VDD VSS o_uwb_tx_cfg[16] BUFX3
Xoutput118 _20187_/Y VDD VSS o_tst_ctrl[6] BUFX3
X_15126_ _15126_/A _15126_/B _15715_/B VDD VSS _15133_/C MIN3X1
XFILLER_130_919 VDD VSS FILLER4
XFILLER_99_137 VDD VSS FILLER4
XTAP_TAPCELL_ROW_130_1320 VDD VSS WELLTAP
X_12269_ _13283_/A _17843_/B VDD VSS _18846_/D AND2X1
X_19934_ clkload3/A _19934_/D _19934_/Q VDD VSS DFFQX1
X_15057_ _15145_/A _15145_/B VDD VSS _15064_/B NOR2X1
XFILLER_96_811 VDD VSS FILLER1
X_14008_ _19034_/Q _14302_/B _14268_/A VDD VSS _14269_/B AO21X2
XFILLER_122_470 VDD VSS DECAPHV16
XFILLER_96_855 VDD VSS FILLER4
X_19865_ clkload8/A _19865_/D _19865_/Q VDD VSS DFFQX1
XFILLER_83_505 VDD VSS DECAPHV8
XFILLER_96_877 VDD VSS FILLER1
XFILLER_96_888 VDD VSS FILLER1
X_19796_ _19828_/CK _19796_/D _19796_/Q VDD VSS DFFQX1
X_18816_ _18817_/CK _18816_/D _18816_/Q VDD VSS DFFQX1
X_18747_ _18801_/CK _18747_/D _18747_/Q VDD VSS DFFQX1
X_15959_ _19646_/Q VDD VSS _15988_/A INVX1
XFILLER_48_281 VDD VSS DECAPHV8
XTAP_TAPCELL_ROW_128_1293 VDD VSS WELLTAP
X_09480_ _19979_/Q _09490_/B _09482_/C VDD VSS _09481_/C AOI21X1
X_18678_ _18811_/CK _18678_/D _18678_/Q VDD VSS DFFQX1
XFILLER_23_104 VSS VDD FILLER2
XFILLER_36_476 VDD VSS FILLER4
XFILLER_63_262 VDD VSS DECAPHV16
XFILLER_51_446 VSS VDD FILLER2
XTAP_TAPCELL_ROW_46_471 VDD VSS WELLTAP
X_17629_ _17776_/B _17629_/B _17629_/C VDD VSS _17634_/C MIN3X1
XFILLER_51_468 VDD VSS DECAPHV8
XTAP_TAPCELL_ROW_18_195 VDD VSS WELLTAP
XFILLER_20_822 VDD VSS FILLER4
XFILLER_20_833 VDD VSS DECAPHV16
XFILLER_109_209 VDD VSS FILLER4
XFILLER_118_765 VDD VSS DECAPHV8
XFILLER_132_212 VDD VSS FILLER4
XFILLER_133_713 VDD VSS FILLER1
XFILLER_133_724 VDD VSS FILLER4
XFILLER_133_779 VDD VSS FILLER1
XFILLER_99_682 VSS VDD FILLER2
XFILLER_143_36 VDD VSS DECAPHV8
X_20005_ _20005_/CK _20005_/D _20005_/Q VDD VSS DFFQX1
XFILLER_101_654 VSS VDD FILLER2
X_09816_ _18455_/Q _09816_/B _09816_/C _09816_/D VDD VSS _09817_/D OA211X2
XFILLER_36_12 VDD VSS DECAPHV8
XFILLER_74_549 VDD VSS FILLER1
X_09747_ _18403_/Q VDD VSS _20144_/A INVX1
XFILLER_36_34 VDD VSS FILLER4
XFILLER_54_240 VDD VSS FILLER1
XFILLER_70_700 VSS VDD FILLER2
X_09678_ _18430_/Q _09696_/B VDD VSS _09679_/E NOR2X1
XFILLER_14_126 VDD VSS DECAPHV8
XTAP_TAPCELL_ROW_72_739 VDD VSS WELLTAP
XFILLER_42_468 VSS VDD FILLER2
X_11640_ _18781_/Q _11647_/B VDD VSS _18808_/D AND2X1
XFILLER_23_682 VSS VDD FILLER2
X_11571_ _18718_/Q _11578_/B VDD VSS _18745_/D AND2X1
X_10522_ _10576_/A _10576_/B VDD VSS _10522_/Y NOR2X1
X_13310_ _14323_/A _14323_/B VDD VSS _14324_/B _14323_/C AND3X2
XFILLER_7_826 VDD VSS FILLER1
X_14290_ _14255_/Y _14290_/B _14290_/C VDD VSS _19023_/D AND3BX1
XFILLER_6_336 VDD VSS FILLER1
X_10453_ _10454_/A _10454_/B _10454_/D _10454_/C VDD VSS _10521_/B AOAI211X1
X_13241_ _13150_/D _13255_/C _13255_/A VDD VSS _14541_/B AND3BX1
XFILLER_108_275 VSS VDD FILLER2
XFILLER_136_562 VDD VSS FILLER4
X_10384_ _10579_/D _10395_/B _10395_/C _10395_/D VDD VSS _10435_/B AND4X2
X_13172_ _13295_/A _13295_/C VDD VSS _13173_/C AND2X1
XFILLER_7_0 VDD VSS FILLER4
X_12123_ _14239_/A _14240_/A _14274_/B VDD VSS _12134_/C MIN3X1
Xclkbuf_leaf_33__000_ clkload78/A VDD VSS _19425_/CK BUFX12
X_17980_ _17987_/A _17980_/B _17980_/C VDD VSS _19961_/D AOI21X1
XFILLER_78_800 VDD VSS DECAPHV8
X_12054_ _19999_/Q _19263_/Q VDD VSS _12108_/C XOR2X1
X_16931_ _16933_/C _16931_/B _16931_/C VDD VSS _19741_/D AOI21X1
XFILLER_117_92 VDD VSS FILLER1
XFILLER_19_900 VDD VSS FILLER4
XFILLER_38_708 VDD VSS FILLER4
XFILLER_77_96 VDD VSS DECAPHV8
X_11005_ _11037_/A _11037_/B _11095_/C VDD VSS _11011_/C AOI21X1
X_19650_ _19678_/CK _19650_/D _19650_/Q VDD VSS DFFQX1
X_16862_ _16865_/A _16862_/B VDD VSS _19700_/D NOR2X1
XFILLER_92_324 VDD VSS FILLER1
XTAP_TAPCELL_ROW_88_894 VDD VSS WELLTAP
X_19581_ _19615_/CK _19581_/D _19581_/Q VDD VSS DFFQX1
X_18601_ _18608_/CK _18601_/D _18601_/Q VDD VSS DFFQX1
X_16793_ _16793_/A _16793_/B VDD VSS _19639_/D AND2X1
X_15813_ _15816_/A _15813_/B VDD VSS _19429_/D NOR2X1
XFILLER_46_741 VSS VDD FILLER2
X_18532_ _18543_/CK _18532_/D _18532_/Q VDD VSS DFFQX1
X_15744_ _15758_/A _15744_/B VDD VSS _19368_/D NOR2X1
X_12956_ _20009_/Q _19273_/Q VDD VSS _13049_/C AND2X1
XFILLER_18_498 VDD VSS FILLER4
XFILLER_73_593 VDD VSS FILLER1
X_11907_ _19036_/Q _11907_/B _11907_/C VDD VSS _12015_/B MIN3X1
X_12887_ _18938_/Q VDD VSS _12992_/A INVX1
X_18463_ _18468_/CK _18516_/Q _18463_/Q _18464_/RB VDD VSS DFFRQX1
X_15675_ _18006_/C VDD VSS _16795_/A BUFX3
XFILLER_61_766 VDD VSS DECAPHV8
XTAP_TAPCELL_ROW_43_441 VDD VSS WELLTAP
X_11838_ _11876_/A wire165/Y _11838_/C VDD VSS _11839_/D XNOR3X1
X_14626_ _19524_/Q _14646_/B VDD VSS _15890_/B XOR2X1
X_18394_ _18400_/CK _18394_/D _18394_/Q _09380_/B VDD VSS DFFRQX1
X_17414_ _19841_/Q _19809_/Q VDD VSS _17416_/B XOR2X1
XTAP_TAPCELL_ROW_15_165 VDD VSS WELLTAP
X_14557_ _19997_/Q _14558_/B VDD VSS _19261_/D AND2X1
X_17345_ _17346_/A _17346_/B _17346_/D _17346_/C VDD VSS _17348_/C AOI211X1
XFILLER_9_152 VDD VSS FILLER1
XTAP_TAPCELL_ROW_119_1204 VDD VSS WELLTAP
X_11769_ _11769_/A _11769_/B _11769_/C _11769_/D VDD VSS _14521_/B AOAI211X1
X_13508_ _13656_/A _13656_/B _13656_/E VDD VSS _13580_/B OA21X2
X_14488_ _14493_/A _14488_/B VDD VSS _19200_/D NOR2X1
X_19015_ _19045_/CK _19015_/D _19015_/Q VDD VSS DFFQX1
X_17276_ _19812_/Q _19780_/Q VDD VSS _17281_/A XNOR2X1
X_13439_ _19138_/Q _14419_/B VDD VSS _13548_/A AND2X1
X_16227_ _16219_/A _16227_/B _16227_/C VDD VSS _16251_/B AOI2B1X1
X_16158_ _19556_/Q VDD VSS _16159_/A INVX1
X_15109_ _15191_/A _15155_/B VDD VSS _15183_/B XNOR2X1
XFILLER_103_919 VDD VSS FILLER4
X_16089_ _16089_/A _16112_/C VDD VSS _16735_/B XNOR2X1
X_19917_ clkload7/A _19917_/D _19917_/Q VDD VSS DFFQX1
XFILLER_3_82 VSS VDD FILLER2
XFILLER_84_803 VSS VDD FILLER2
X_19848_ _19863_/CK _19848_/D _19848_/Q VDD VSS DFFQX1
XFILLER_84_825 VDD VSS FILLER4
XFILLER_96_696 VDD VSS FILLER1
X_09601_ _09819_/A _09601_/B _09601_/C _09601_/D VDD VSS _18281_/D OAI211X1
XFILLER_37_752 VDD VSS FILLER4
X_09532_ _20027_/Q _18199_/A VDD VSS _20028_/D NOR2BX1
X_19779_ clkload2/A _19779_/D _19779_/Q VDD VSS DFFQX1
XFILLER_51_221 VDD VSS FILLER4
XFILLER_52_744 VSS VDD FILLER2
X_09463_ _19971_/Q _09467_/B _09476_/C VDD VSS _09464_/C AOI21X1
XFILLER_24_457 VDD VSS FILLER4
X_09394_ _18629_/Q wire166/A VDD VSS _18231_/E NAND2BX1
XFILLER_11_118 VDD VSS FILLER1
XFILLER_51_276 VSS VDD FILLER2
XFILLER_138_805 VSS VDD FILLER2
XFILLER_20_674 VDD VSS DECAPHV8
XFILLER_118_584 VDD VSS FILLER4
XFILLER_133_521 VDD VSS FILLER1
XFILLER_106_779 VDD VSS FILLER4
XFILLER_79_619 VDD VSS DECAPHV8
XFILLER_78_118 VSS VDD FILLER2
XFILLER_75_803 VDD VSS FILLER4
XFILLER_101_462 VSS VDD FILLER2
XFILLER_19_207 VDD VSS FILLER1
XFILLER_87_696 VDD VSS DECAPHV16
Xfanout197 _09346_/B VDD VSS _09414_/D BUFX3
Xfanout175 _18628_/Q VDD VSS _11196_/A BUFX3
XFILLER_47_549 VDD VSS DECAPHV8
XFILLER_86_184 VDD VSS DECAPHV8
X_12810_ _12913_/A _12821_/B _12821_/C VDD VSS _14349_/C OR3BX1
XTAP_TAPCELL_ROW_85_864 VDD VSS WELLTAP
X_13790_ _13791_/A _13791_/C _13791_/B VDD VSS _14392_/A OA21X2
XFILLER_103_61 VDD VSS FILLER4
XFILLER_27_284 VDD VSS FILLER1
XTAP_TAPCELL_ROW_57_588 VDD VSS WELLTAP
X_12741_ _12748_/A _14409_/B _12813_/C VDD VSS _14410_/C NOR3X1
XFILLER_15_468 VDD VSS FILLER1
XTAP_TAPCELL_ROW_103_1049 VDD VSS WELLTAP
X_12672_ _20005_/Q _19269_/Q VDD VSS _12673_/D NAND2X1
X_15460_ _15674_/A _18143_/B VDD VSS _19294_/D AND2X1
XFILLER_144_0 VDD VSS DECAPHV32
XFILLER_30_405 VDD VSS DECAPHV8
X_11623_ _18766_/Q _11624_/B VDD VSS _18793_/D AND2X1
X_14411_ _14415_/A _14411_/B VDD VSS _19132_/D AND2X1
XFILLER_11_630 VSS VDD FILLER2
XFILLER_129_816 VDD VSS FILLER4
XTAP_TAPCELL_ROW_12_135 VDD VSS WELLTAP
XTAP_TAPCELL_ROW_40_411 VDD VSS WELLTAP
X_17130_ _17132_/A _17132_/B _17130_/C VDD VSS _19780_/D AOI21X1
X_15391_ _15391_/A _15391_/B _15816_/B VDD VSS _15429_/A MIN3X1
XFILLER_11_685 VSS VDD FILLER2
X_11554_ _18703_/Q _11555_/B VDD VSS _18730_/D AND2X1
X_14342_ _14368_/A _14342_/B VDD VSS _19069_/D NOR2X1
XFILLER_10_162 VDD VSS DECAPHV16
X_10505_ _10548_/A _10505_/B VDD VSS _10507_/B XNOR2X1
X_11485_ _16860_/A VDD VSS _11496_/B BUFX3
X_14273_ _14334_/A _14273_/B VDD VSS _19010_/D AND2X1
X_17061_ _17095_/A _17061_/B VDD VSS _19765_/D NOR2X1
XFILLER_6_177 VDD VSS DECAPHV8
X_10436_ _18635_/Q _18797_/Q VDD VSS _10476_/D XNOR2X1
X_13224_ _13365_/A _13365_/B _13365_/D VDD VSS _13268_/B OAI21X1
X_16012_ _16012_/A _16836_/B VDD VSS _16013_/B XNOR2X1
XFILLER_124_532 VSS VDD FILLER2
XFILLER_128_91 VSS VDD FILLER2
XFILLER_3_873 VDD VSS FILLER4
XFILLER_88_51 VDD VSS FILLER1
XTAP_TAPCELL_ROW_114_1156 VDD VSS WELLTAP
X_10367_ _10413_/A _10413_/B _10413_/C _10763_/A VDD VSS _10375_/B AOI31X1
X_13155_ _19192_/Q _13155_/B _13329_/C VDD VSS _13443_/B XNOR3X1
XFILLER_124_587 VSS VDD FILLER2
XFILLER_124_598 VDD VSS FILLER4
XFILLER_97_427 VSS VDD FILLER2
X_10298_ _10550_/A _10465_/B VDD VSS _10298_/Y OR2X2
X_12106_ _19236_/Q VDD VSS _12222_/A INVX1
X_13086_ _18939_/Q _13086_/B _13086_/C VDD VSS _13290_/A MIN3X1
X_17963_ _18868_/Q _17963_/B VDD VSS _17966_/D _17963_/C NAND3X1
XFILLER_66_803 VDD VSS DECAPHV8
X_12037_ _19177_/Q _14463_/B VDD VSS _12040_/C _14463_/C NAND3X1
X_19702_ _19703_/CK _19702_/D _19702_/Q VDD VSS DFFQX1
X_16914_ wire163/Y VDD VSS _16978_/B BUFX3
XFILLER_65_313 VDD VSS FILLER1
XFILLER_77_173 VSS VDD FILLER2
XTAP_TAPCELL_ROW_48_500 VDD VSS WELLTAP
X_19633_ _19696_/CK _19633_/D _19633_/Q VDD VSS DFFQX1
X_17894_ _17894_/A _17894_/B _17894_/C VDD VSS _17901_/C MIN3X1
XFILLER_66_869 VSS VDD FILLER2
X_16845_ _16859_/A _16845_/B VDD VSS _19684_/D AND2X1
XFILLER_19_752 VDD VSS FILLER1
XFILLER_34_700 VDD VSS FILLER4
XFILLER_34_711 VDD VSS DECAPHV32
XFILLER_53_508 VSS VDD FILLER2
XFILLER_93_699 VDD VSS DECAPHV8
X_13988_ _14198_/B _14198_/C _13989_/A VDD VSS _13990_/C OAI21X1
X_19564_ _19604_/CK _19564_/D _19564_/Q VDD VSS DFFQX1
X_16776_ _16776_/A VDD VSS _16794_/A BUFX3
XFILLER_61_530 VDD VSS DECAPHV16
XTAP_TAPCELL_ROW_125_1263 VDD VSS WELLTAP
X_12939_ _12939_/A _12939_/B _12939_/C _12939_/D VDD VSS _13113_/A OAOI211X1
X_19495_ _19495_/CK _19495_/D _19495_/Q VDD VSS DFFQX1
X_18515_ _18515_/CK _18515_/D _18515_/Q _09331_/Y VDD VSS DFFRQX1
X_15727_ _15743_/A _15727_/B VDD VSS _19352_/D AND2X1
XFILLER_22_917 VDD VSS FILLER1
XTAP_TAPCELL_ROW_8_92 VDD VSS WELLTAP
X_18446_ _18455_/CK _18446_/D _18446_/Q _18455_/RB VDD VSS DFFRQX1
X_15658_ _15658_/A _15662_/C VDD VSS _15702_/B XNOR2X1
XFILLER_21_405 VSS VDD FILLER2
X_14609_ _19441_/Q _14639_/B _14613_/C VDD VSS _15795_/B XNOR3X1
XFILLER_14_490 VDD VSS FILLER4
X_18377_ _18390_/CK _18510_/Q _20182_/A _20064_/RB VDD VSS DFFRQX1
X_15589_ _15672_/A _18164_/B VDD VSS _19298_/D NOR2X1
XFILLER_119_337 VSS VDD FILLER2
X_17328_ _19822_/Q VDD VSS _17479_/B INVX1
XFILLER_135_819 VDD VSS DECAPHV8
X_17259_ _19808_/Q _19776_/Q VDD VSS _17261_/B XNOR2X1
XFILLER_115_510 VDD VSS FILLER1
XFILLER_130_546 VDD VSS FILLER4
XFILLER_124_49 VDD VSS DECAPHV8
XFILLER_96_471 VDD VSS FILLER1
XFILLER_56_324 VDD VSS FILLER1
XFILLER_57_869 VDD VSS FILLER1
XFILLER_71_316 VDD VSS FILLER1
XFILLER_37_593 VDD VSS DECAPHV8
XFILLER_65_880 VDD VSS FILLER1
XTAP_TAPCELL_ROW_82_834 VDD VSS WELLTAP
X_09515_ output5/A _09515_/B _18201_/C VDD VSS _20069_/D NOR3BX1
XFILLER_25_755 VSS VDD FILLER2
XFILLER_25_766 VDD VSS FILLER1
XFILLER_52_530 VDD VSS FILLER4
XFILLER_80_850 VDD VSS DECAPHV16
XTAP_TAPCELL_ROW_54_558 VDD VSS WELLTAP
X_09446_ _09446_/A _09810_/B VDD VSS _18221_/E NOR2X1
XFILLER_52_574 VDD VSS DECAPHV8
XFILLER_80_894 VDD VSS FILLER1
Xclkbuf_leaf_32__001_ clkbuf_2_1__f__001_/Y VDD VSS _19045_/CK BUFX12
XFILLER_12_438 VSS VDD FILLER2
XFILLER_40_769 VDD VSS FILLER1
X_09377_ _09576_/B _09753_/A VDD VSS _09410_/B NOR2BX1
XFILLER_137_134 VSS VDD FILLER2
XFILLER_138_668 VSS VDD FILLER2
XFILLER_106_521 VDD VSS DECAPHV16
X_11270_ _18581_/Q _11274_/B VDD VSS _11275_/B XNOR2X1
XFILLER_3_136 VSS VDD FILLER2
X_10221_ _18594_/Q _10230_/B VDD VSS _10224_/B XNOR2X1
XFILLER_0_821 VDD VSS DECAPHV8
X_10152_ _18612_/Q _10152_/B _10152_/C VDD VSS _10172_/A AOI21X1
XFILLER_0_843 VSS VDD FILLER2
X_10083_ _10033_/Y _10130_/B _10167_/A VDD VSS _10175_/D MUXI2X1
X_14960_ _14995_/A _14995_/B VDD VSS _14976_/B NOR2X1
XFILLER_102_782 VSS VDD FILLER2
XFILLER_58_87 VDD VSS FILLER1
X_13911_ _13912_/D _14332_/B VDD VSS _13965_/A NAND2X1
XFILLER_102_793 VSS VDD FILLER2
XFILLER_59_184 VSS VDD FILLER2
XFILLER_75_644 VDD VSS FILLER1
X_14891_ _14902_/B _14891_/B VDD VSS _15710_/B XNOR2X1
XFILLER_114_82 VSS VDD FILLER2
XFILLER_16_700 VDD VSS DECAPHV8
XFILLER_47_379 VSS VDD FILLER2
XFILLER_63_806 VDD VSS FILLER1
X_13842_ _13843_/A _13843_/B _13843_/D _13843_/C VDD VSS _13903_/B OAOI211X1
X_16630_ _16631_/A _16631_/B _16631_/C VDD VSS _16657_/B OAI21X1
XFILLER_90_647 VDD VSS FILLER1
X_13773_ _19002_/Q _14264_/B VDD VSS _13845_/A AND2X1
X_16561_ _16561_/A _16561_/B VDD VSS _16562_/B _16561_/C NAND3X1
XFILLER_31_703 VDD VSS FILLER1
XFILLER_43_541 VDD VSS FILLER1
XFILLER_71_850 VDD VSS FILLER1
X_10985_ _10911_/Y _10984_/Y _10947_/Y VDD VSS _11119_/B MUX2X1
X_12724_ _19102_/Q _12732_/B _12724_/C VDD VSS _12729_/B XNOR3X1
X_19280_ _19290_/CK _19280_/D _19280_/Q VDD VSS DFFQX1
X_18300_ _18311_/CK _18513_/Q _18300_/Q _18471_/RB VDD VSS DFFRQX1
X_15512_ _19491_/Q _15512_/B _15884_/B VDD VSS _15547_/B MIN3X1
XFILLER_30_213 VDD VSS FILLER4
X_18231_ _18232_/CK _18231_/E _18231_/ECK VDD VSS CGX3
X_16492_ _16486_/B _16492_/B _16492_/C VDD VSS _16509_/A AOI2B1X1
XFILLER_30_235 VDD VSS FILLER4
XFILLER_90_63 VDD VSS FILLER1
X_12655_ _12737_/A _12771_/A _12655_/C VDD VSS _12656_/D XNOR3X1
X_15443_ _19490_/Q _15883_/B VDD VSS _15444_/B XNOR2X1
XFILLER_128_112 VDD VSS DECAPHV8
XFILLER_129_624 VDD VSS DECAPHV8
X_11606_ _18750_/Q _11612_/B VDD VSS _18777_/D AND2X1
X_12586_ _12763_/D _12763_/B VDD VSS _12678_/C NOR2BX1
X_18162_ _18162_/A _18162_/B _18162_/C VDD VSS _18167_/B OA21X2
X_15374_ _19376_/Q _15753_/B VDD VSS _15376_/C XOR2X1
XFILLER_128_134 VDD VSS FILLER1
X_11537_ _18688_/Q _11542_/B VDD VSS _18715_/D AND2X1
X_14325_ _14334_/A _14325_/B VDD VSS _19054_/D AND2X1
X_18093_ _18173_/A _18093_/B VDD VSS _19993_/D NOR2X1
X_17113_ _19776_/Q VDD VSS _17263_/B INVX1
XFILLER_143_104 VDD VSS FILLER4
X_17044_ _17045_/A _17045_/B _17045_/C _17045_/D VDD VSS _17046_/B OA211X2
X_11468_ _17812_/A VDD VSS _11641_/B BUFX3
X_14256_ _14255_/Y _14256_/B _14256_/C VDD VSS _18994_/D AND3BX1
XFILLER_124_351 VDD VSS FILLER1
XFILLER_143_159 VSS VDD FILLER2
X_10419_ _10448_/A _10448_/B _10686_/D VDD VSS _10419_/Y OAI21X1
X_11399_ _11398_/Y wire166/Y _11399_/C VDD VSS _18598_/D AND3BX1
X_13207_ _13274_/A _13415_/B _13208_/C VDD VSS _14291_/B OR3BX1
X_14187_ _17906_/C VDD VSS _14457_/A BUFX3
X_13138_ _13138_/A _13138_/B _13138_/C _13138_/D VDD VSS _13331_/A OAOI211X1
XFILLER_97_246 VDD VSS DECAPHV16
X_18995_ _19050_/CK _18995_/D _18995_/Q VDD VSS DFFQX1
XFILLER_112_579 VSS VDD FILLER2
X_13069_ _19023_/Q _13069_/B _13270_/D VDD VSS _13097_/C XNOR3X1
X_17946_ _17946_/A _17946_/B _17948_/A _17948_/C VDD VSS _17958_/B OAOI211X1
XFILLER_17_2 VDD VSS FILLER1
XFILLER_38_324 VDD VSS FILLER1
XFILLER_66_633 VDD VSS FILLER1
X_17877_ _18853_/Q _17880_/B VDD VSS _17879_/B XOR2X1
XFILLER_38_379 VDD VSS FILLER1
XFILLER_54_828 VSS VDD FILLER2
XFILLER_66_688 VSS VDD FILLER2
X_19616_ _19678_/CK _19616_/D _19616_/Q VDD VSS DFFQX1
X_16828_ _16838_/A _16828_/B VDD VSS _19669_/D NOR2X1
XFILLER_19_571 VSS VDD FILLER2
XFILLER_81_647 VDD VSS FILLER4
XFILLER_93_496 VDD VSS FILLER1
X_19547_ _19547_/CK _19547_/D _19547_/Q VDD VSS DFFQX1
XFILLER_34_530 VSS VDD FILLER2
X_09300_ _18280_/Q input2/Y _09299_/Y VDD VSS _09300_/Y MUXI2X1
X_09965__235 _20054_/CK VDD VSS _18512_/CK INVX1
X_16759_ _16759_/A _16759_/B VDD VSS _19608_/D NOR2X1
XTAP_TAPCELL_ROW_51_528 VDD VSS WELLTAP
X_19478_ _19483_/CK _19478_/D _19478_/Q VDD VSS DFFQX1
X_09231_ _18500_/D VDD VSS _18356_/D INVX1
X_18429_ _18439_/CK _18429_/D _18429_/Q _20078_/RB VDD VSS DFFRQX1
XFILLER_119_156 VDD VSS FILLER1
XFILLER_119_178 VSS VDD FILLER2
XFILLER_119_38 VDD VSS FILLER1
XFILLER_128_690 VSS VDD FILLER2
XFILLER_134_126 VSS VDD FILLER2
Xclkbuf_leaf_3_clk_regs clkload1/A VDD VSS _19907_/CK BUFX12
XFILLER_115_340 VSS VDD FILLER2
XFILLER_131_833 VDD VSS FILLER4
XFILLER_143_693 VSS VDD FILLER2
XFILLER_88_213 VDD VSS FILLER4
X_20184_ _20184_/A VDD VSS _20184_/Y BUFX3
XFILLER_142_192 VDD VSS FILLER1
XFILLER_88_235 VSS VDD FILLER2
X_09995_ _09996_/A _09996_/B _09996_/C VDD VSS _09997_/B NOR3X1
XTAP_TAPCELL_ROW_59_606 VDD VSS WELLTAP
XFILLER_28_24 VDD VSS FILLER4
XFILLER_72_603 VDD VSS FILLER1
XFILLER_84_463 VDD VSS FILLER1
XTAP_TAPCELL_ROW_95_970 VDD VSS WELLTAP
XFILLER_56_198 VDD VSS DECAPHV8
XFILLER_57_699 VDD VSS DECAPHV8
XFILLER_71_124 VDD VSS FILLER4
XTAP_TAPCELL_ROW_67_683 VDD VSS WELLTAP
XFILLER_13_714 VSS VDD FILLER2
XFILLER_44_45 VDD VSS FILLER1
X_10770_ _11078_/A _18724_/Q VDD VSS _10771_/C NAND2X1
XFILLER_13_736 VDD VSS DECAPHV8
XFILLER_13_747 VDD VSS FILLER4
XFILLER_52_382 VDD VSS FILLER1
XFILLER_80_691 VDD VSS FILLER1
XTAP_TAPCELL_ROW_100_1019 VDD VSS WELLTAP
X_09429_ _09447_/B _09751_/B VDD VSS _18235_/E NOR2X1
XFILLER_139_933 VDD VSS DECAPHV16
X_12440_ _18960_/Q _12440_/B _14211_/B VDD VSS _12535_/B MIN3X1
XFILLER_100_95 VDD VSS FILLER4
XFILLER_138_421 VDD VSS DECAPHV8
XFILLER_138_487 VDD VSS FILLER1
X_12371_ _12544_/A _12544_/B _12544_/C VDD VSS _12419_/B AOI21X1
X_14110_ _18899_/Q _14142_/B VDD VSS _14111_/D NOR2BX1
X_11322_ _11325_/B _11322_/B _11331_/A VDD VSS _11325_/C OAI21X1
X_15090_ _15090_/A _15776_/B VDD VSS _15138_/B NOR2X1
XFILLER_107_0 VSS VDD FILLER2
XFILLER_107_852 VSS VDD FILLER2
XFILLER_109_82 VDD VSS FILLER4
X_11253_ _11253_/A _11253_/B _11253_/C _11253_/D VDD VSS _11262_/B AOAI211X1
X_14041_ _14041_/A _14043_/B _14041_/C VDD VSS _14236_/B OA21X2
XFILLER_106_373 VDD VSS FILLER1
XFILLER_4_478 VSS VDD FILLER2
XFILLER_69_53 VDD VSS FILLER1
XTAP_TAPCELL_ROW_111_1126 VDD VSS WELLTAP
X_10204_ _18592_/Q _10220_/C VDD VSS _10204_/Y XNOR2X1
XFILLER_106_395 VDD VSS FILLER4
XFILLER_95_706 VSS VDD FILLER2
X_11184_ _11184_/A _11221_/B VDD VSS _11184_/Y XOR2X1
X_17800_ _19923_/Q _19891_/Q _17800_/C VDD VSS _17803_/C MIN3X1
XFILLER_121_365 VDD VSS FILLER1
XFILLER_48_600 VDD VSS FILLER4
XFILLER_48_611 VSS VDD FILLER2
X_10135_ _10150_/D _10150_/B VDD VSS _10136_/B NOR2BX1
X_18780_ _18782_/CK _18780_/D _18780_/Q VDD VSS DFFQX1
X_15992_ _19582_/Q _16731_/B VDD VSS _15993_/C NOR2X1
XFILLER_0_695 VDD VSS DECAPHV8
XFILLER_125_92 VDD VSS FILLER1
XFILLER_76_942 VDD VSS DECAPHV8
XFILLER_87_290 VDD VSS FILLER1
X_10066_ _18584_/Q VDD VSS _11302_/A INVX1
X_17731_ _19909_/Q _19877_/Q VDD VSS _17738_/C NOR2X1
X_14943_ _19366_/Q _15742_/B VDD VSS _14944_/B XNOR2X1
XFILLER_48_655 VDD VSS DECAPHV16
XFILLER_75_452 VSS VDD FILLER2
X_17662_ _19894_/Q _19862_/Q VDD VSS _17667_/A XNOR2X1
X_14874_ _19503_/Q _14874_/B VDD VSS _15015_/C NAND2X1
XFILLER_29_880 VDD VSS DECAPHV8
XFILLER_47_176 VDD VSS FILLER1
X_13825_ _18948_/Q VDD VSS _13989_/A INVX1
X_19401_ _19425_/CK _19401_/D _19401_/Q VDD VSS DFFQX1
X_16613_ _16613_/A _16620_/C VDD VSS _16899_/B XNOR2X1
XFILLER_28_390 VDD VSS DECAPHV8
XFILLER_35_349 VDD VSS FILLER4
XFILLER_62_146 VDD VSS FILLER1
XFILLER_63_658 VSS VDD FILLER2
X_17593_ _17596_/C _17594_/B _17597_/C VDD VSS _17594_/C OAI21X1
XTAP_TAPCELL_ROW_122_1233 VDD VSS WELLTAP
X_10968_ _18676_/Q _18784_/Q VDD VSS _11007_/C NOR2X1
X_13756_ _14132_/A _14132_/B VDD VSS _13802_/B NOR2X1
X_19332_ _19358_/CK _19332_/D _19332_/Q VDD VSS DFFQX1
X_16544_ _19699_/Q _16861_/B VDD VSS _16561_/A NAND2BX1
XFILLER_43_382 VDD VSS FILLER4
X_12707_ _12789_/A _12789_/B _14151_/B VDD VSS _12883_/B MIN3X1
X_13687_ _18973_/Q _13830_/A _13830_/B VDD VSS _13688_/D XNOR3X1
X_19263_ _20008_/CK _19263_/D _19263_/Q VDD VSS DFFQX1
X_16475_ _19568_/Q VDD VSS _16476_/A INVX1
XFILLER_31_577 VDD VSS DECAPHV8
X_10899_ _18673_/Q _18781_/Q _10899_/C VDD VSS _10936_/C MIN3X1
X_12638_ _12732_/A _12732_/B VDD VSS _14379_/B _12732_/C AND3X2
X_19194_ _19194_/CK _19194_/D _19194_/Q VDD VSS DFFQX1
X_18214_ _18235_/CK _18214_/E _18214_/ECK VDD VSS CGX3
X_15426_ _19405_/Q _15786_/B VDD VSS _15427_/C NOR2BX1
XFILLER_79_4 VDD VSS DECAPHV8
XFILLER_117_605 VDD VSS FILLER4
XFILLER_11_290 VSS VDD FILLER2
XFILLER_144_402 VSS VDD FILLER2
X_12569_ _19240_/Q _14534_/A _14534_/B VDD VSS _12571_/C NOR3X1
X_18145_ _18150_/A _18146_/B _18187_/C VDD VSS _18146_/C OAI21X1
X_15357_ _19542_/Q _15357_/B VDD VSS _15910_/B XOR2X1
XFILLER_144_435 VDD VSS DECAPHV8
X_14308_ _14311_/A _14308_/B VDD VSS _19040_/D NOR2X1
Xwire170 wire170/A VDD VSS wire170/Y BUFX6
X_18076_ _18078_/B _18076_/B VDD VSS _18083_/B NAND2BX1
X_15288_ _15304_/A _15783_/B VDD VSS _15305_/C XNOR2X1
X_14239_ _14239_/A _14274_/B VDD VSS _14240_/B XNOR2X1
X_17027_ _17028_/A _17030_/A _17030_/B _18087_/D VDD VSS _17028_/D AOAI211X1
XFILLER_124_170 VSS VDD FILLER2
XFILLER_125_693 VSS VDD FILLER2
XFILLER_98_544 VSS VDD FILLER2
Xclkbuf_1_1__f__09172_ clkbuf_0__09172_/Y VDD VSS _18324_/CK BUFX12
XFILLER_140_674 VDD VSS FILLER1
XFILLER_22_0 VDD VSS FILLER4
XFILLER_85_205 VDD VSS DECAPHV8
X_09780_ _18373_/Q VDD VSS _20210_/A INVX1
X_18978_ _19171_/CK _18978_/D _18978_/Q VDD VSS DFFQX1
XFILLER_38_110 VSS VDD FILLER2
X_17929_ _18863_/Q _17929_/B VDD VSS _17941_/A AND2X1
XFILLER_54_603 VDD VSS FILLER1
XFILLER_26_305 VDD VSS FILLER1
XFILLER_54_647 VDD VSS FILLER1
XFILLER_66_474 VDD VSS FILLER1
XFILLER_93_260 VDD VSS FILLER1
XFILLER_93_271 VDD VSS DECAPHV8
XFILLER_93_282 VDD VSS FILLER4
XFILLER_42_809 VDD VSS DECAPHV8
XTAP_TAPCELL_ROW_64_653 VDD VSS WELLTAP
XTAP_TAPCELL_ROW_92_940 VDD VSS WELLTAP
XFILLER_35_872 VDD VSS FILLER1
XTAP_TAPCELL_ROW_36_377 VDD VSS WELLTAP
XFILLER_22_577 VDD VSS DECAPHV8
XFILLER_50_886 VDD VSS DECAPHV8
X_09214_ _18477_/D VDD VSS _18413_/D INVX1
XFILLER_5_209 VSS VDD FILLER2
XFILLER_107_104 VDD VSS FILLER4
XFILLER_136_947 VSS VDD FILLER2
XTAP_TAPCELL_ROW_1_29 VDD VSS WELLTAP
XFILLER_1_404 VDD VSS FILLER1
XFILLER_2_949 VDD VSS FILLER1
XFILLER_131_641 VSS VDD FILLER2
XFILLER_104_888 VDD VSS FILLER1
X_20167_ _20167_/A VDD VSS _20167_/Y BUFX3
XFILLER_103_387 VDD VSS DECAPHV8
XFILLER_76_249 VDD VSS DECAPHV8
X_20098_ _20098_/A VDD VSS _20098_/Y BUFX3
XFILLER_29_132 VDD VSS FILLER1
XFILLER_57_452 VDD VSS FILLER1
XFILLER_57_463 VSS VDD FILLER2
X_11940_ _19093_/Q _11963_/A _12022_/B VDD VSS _12018_/B XNOR3X1
XFILLER_17_305 VSS VDD FILLER2
XFILLER_55_22 VDD VSS DECAPHV16
XFILLER_84_271 VSS VDD FILLER2
XFILLER_85_783 VDD VSS FILLER1
X_11871_ _19203_/Q _11871_/B _11979_/C VDD VSS _11915_/C XNOR3X1
XFILLER_25_360 VDD VSS FILLER1
X_10822_ _10856_/D _10856_/C VDD VSS _10823_/B NAND2BX1
X_13610_ _13733_/A _13610_/B VDD VSS _14295_/B XNOR2X1
X_14590_ _14601_/A _14601_/B _14601_/D VDD VSS _14615_/C AOI21X1
XFILLER_25_371 VDD VSS FILLER1
XFILLER_26_894 VDD VSS FILLER1
XFILLER_53_691 VDD VSS FILLER4
XFILLER_71_10 VDD VSS FILLER1
X_10753_ _18643_/Q _18805_/Q VDD VSS _10798_/D NOR2X1
X_13541_ _13696_/A _13696_/B _13696_/C VDD VSS _13564_/B AOI21X1
XFILLER_41_864 VDD VSS FILLER1
XFILLER_71_65 VSS VDD FILLER2
X_16260_ _16285_/C _16260_/B VDD VSS _16743_/B XNOR2X1
XFILLER_139_741 VSS VDD FILLER2
X_10684_ _10722_/B _10725_/A VDD VSS _10686_/B NAND2BX1
X_13472_ _19083_/Q _13623_/A _13696_/B VDD VSS _13601_/D XNOR3X1
X_15211_ _15218_/A _15718_/B VDD VSS _15212_/B XNOR2X1
XFILLER_138_262 VDD VSS FILLER4
X_12423_ _12519_/B _12519_/C VDD VSS _14313_/B OR2X2
X_16191_ _19654_/Q _16202_/A VDD VSS _16192_/B XNOR2X1
X_12354_ _12354_/A _12354_/B _14210_/B VDD VSS _12440_/B MIN3X1
Xdelaybuf_7_clk delaybuf_7_clk/A VDD VSS delaybuf_7_clk/Y BUFX12
X_15142_ _15198_/A _15198_/B VDD VSS _15158_/B NOR2X1
XFILLER_4_220 VDD VSS FILLER1
XFILLER_5_743 VDD VSS FILLER1
X_11305_ _11383_/A _11305_/B VDD VSS _18584_/D NOR2X1
X_19950_ _19951_/CK _19950_/D _19950_/Q VDD VSS DFFQX1
X_15073_ _19369_/Q _15746_/B VDD VSS _15074_/B XNOR2X1
XFILLER_141_405 VDD VSS FILLER4
XFILLER_5_798 VDD VSS FILLER4
X_12285_ _12285_/A _12285_/B _14307_/B VDD VSS _14275_/A MIN3X1
X_14024_ _14163_/A wire152/Y _17957_/C VDD VSS _18867_/D NOR3X1
X_18901_ _18935_/CK _18901_/D _18901_/Q VDD VSS DFFQX1
XFILLER_122_652 VDD VSS DECAPHV8
XFILLER_20_80 VSS VDD FILLER2
X_11236_ _11236_/A _11241_/B VDD VSS _11249_/B XNOR2X1
X_19881_ clkload8/A _19881_/D _19881_/Q VDD VSS DFFQX1
XFILLER_95_514 VDD VSS DECAPHV8
X_11167_ _11167_/A _11167_/B _11167_/C _11167_/D VDD VSS _11200_/C OAOI211X1
X_18832_ _19949_/CK _18832_/D _18832_/Q VDD VSS DFFQX1
XFILLER_122_696 VDD VSS FILLER1
X_10118_ _10018_/Y _10117_/Y _10131_/A VDD VSS _10126_/B MUXI2X1
X_18763_ _19937_/CK _18763_/D _18763_/Q VDD VSS DFFQX1
XFILLER_48_452 VDD VSS FILLER1
XFILLER_82_208 VDD VSS DECAPHV8
XFILLER_83_709 VDD VSS FILLER1
X_11098_ _18814_/Q VDD VSS _11677_/A INVX1
X_17714_ _17716_/C _17715_/B _17746_/C VDD VSS _17715_/C OAI21X1
X_15975_ _15975_/A _15975_/B VDD VSS _16836_/B XOR2X1
XFILLER_36_625 VDD VSS FILLER1
XFILLER_75_282 VDD VSS DECAPHV8
X_10049_ _10053_/A _10053_/B VDD VSS _10051_/A XNOR2X1
X_18694_ _18828_/CK _18694_/D _18694_/Q VDD VSS DFFQX1
X_14926_ _19505_/Q _15899_/B VDD VSS _15017_/C NAND2BX1
XFILLER_90_230 VSS VDD FILLER2
X_17645_ _17646_/A _17646_/B _17646_/D _17646_/C VDD VSS _17648_/C AOI211X1
X_14857_ _14857_/A _14857_/B _15739_/B VDD VSS _14902_/B MIN3X1
X_13808_ _18919_/Q VDD VSS _13873_/A INVX1
X_17576_ _19876_/Q _19844_/Q VDD VSS _17581_/A XNOR2X1
X_14788_ _15895_/B VDD VSS _14789_/B INVX1
XFILLER_17_894 VSS VDD FILLER2
XFILLER_32_831 VDD VSS FILLER1
XTAP_TAPCELL_ROW_61_623 VDD VSS WELLTAP
X_13739_ _18946_/Q _13739_/B _13771_/C VDD VSS _13918_/B XNOR3X1
X_19315_ _19337_/CK _19315_/D _19315_/Q VDD VSS DFFQX1
X_16527_ _19571_/Q _19923_/Q VDD VSS _16528_/B XNOR2X1
XTAP_TAPCELL_ROW_33_347 VDD VSS WELLTAP
XFILLER_84_2 VDD VSS FILLER1
X_19246_ _20008_/CK _19246_/D _19246_/Q VDD VSS DFFQX1
X_16458_ _16459_/A _16459_/B _16459_/C VDD VSS _16470_/C AO21X2
X_19177_ _19202_/CK _19177_/D _19177_/Q VDD VSS DFFQX1
X_16389_ _19661_/Q _16819_/B VDD VSS _16406_/A NOR2X1
X_15409_ _15429_/A _15429_/B VDD VSS _15786_/B XNOR2X1
X_18128_ _19291_/Q _18128_/B VDD VSS _18131_/A NOR2BX1
XFILLER_117_468 VDD VSS FILLER4
XFILLER_133_917 VSS VDD FILLER2
XFILLER_144_265 VDD VSS FILLER4
XFILLER_144_287 VDD VSS DECAPHV16
X_09901_ _11014_/A _09901_/B VDD VSS _09902_/C NAND2X1
X_18059_ _19278_/Q _18059_/B VDD VSS _18064_/A NOR2X1
XFILLER_99_853 VDD VSS FILLER1
XFILLER_59_706 VDD VSS FILLER4
XFILLER_86_514 VDD VSS FILLER4
XTAP_TAPCELL_ROW_69_701 VDD VSS WELLTAP
X_09832_ _11435_/B _11438_/A _11435_/A VDD VSS _10383_/A NOR3BX1
X_20021_ _20022_/CK _20021_/D _20021_/Q _20031_/RB VDD VSS DFFRQX1
XFILLER_100_324 VDD VSS FILLER1
XFILLER_101_836 VDD VSS FILLER1
XFILLER_112_173 VDD VSS FILLER1
X_09763_ _18356_/Q VDD VSS _20224_/A INVX1
Xclkbuf_0__09186_ _18235_/ECK VDD VSS clkbuf_0__09186_/Y BUFX12
XFILLER_67_783 VDD VSS FILLER1
X_09694_ _20140_/A _20188_/A _09816_/D VDD VSS _09699_/D MUX2X1
XFILLER_15_809 VDD VSS DECAPHV8
XFILLER_26_146 VDD VSS FILLER1
XFILLER_81_230 VDD VSS DECAPHV8
XTAP_TAPCELL_ROW_142_1439 VDD VSS WELLTAP
XFILLER_25_69 VDD VSS DECAPHV16
XFILLER_70_948 VSS VDD FILLER2
XFILLER_22_352 VDD VSS FILLER1
XFILLER_10_514 VSS VDD FILLER2
XFILLER_41_57 VDD VSS FILLER4
XFILLER_6_518 VDD VSS FILLER1
XFILLER_108_413 VDD VSS FILLER4
X_12070_ _12070_/A _12070_/B _14206_/B VDD VSS _12131_/B MIN3X1
XFILLER_104_663 VDD VSS FILLER1
XFILLER_49_205 VSS VDD FILLER2
X_11021_ _18571_/Q _11021_/B VDD VSS _11023_/C XOR2X1
X_20219_ _20219_/A VDD VSS _20219_/Y BUFX3
XFILLER_103_162 VDD VSS FILLER1
XFILLER_104_696 VDD VSS FILLER1
XFILLER_1_278 VDD VSS FILLER1
XFILLER_49_238 VDD VSS DECAPHV8
XFILLER_18_603 VDD VSS FILLER1
XFILLER_57_271 VDD VSS FILLER1
X_12972_ _19162_/Q _12972_/B _13108_/D VDD VSS _13041_/C XNOR3X1
X_15760_ _15817_/A VDD VSS _15780_/A BUFX3
X_11923_ _12048_/A _12048_/B VDD VSS _14493_/B XNOR2X1
X_15691_ _15693_/A _15691_/B VDD VSS _19320_/D NOR2X1
X_14711_ _19526_/Q _14742_/C VDD VSS _14712_/B NAND2X1
XFILLER_72_263 VDD VSS FILLER1
X_11854_ _11854_/A _11854_/B _14429_/B VDD VSS _11966_/B MIN3X1
X_14642_ _14658_/A _14658_/B VDD VSS _15861_/B XNOR2X1
X_17430_ _19844_/Q _19812_/Q VDD VSS _17431_/C NAND2X1
XFILLER_26_691 VDD VSS FILLER4
XFILLER_33_639 VDD VSS DECAPHV8
XFILLER_61_948 VSS VDD FILLER2
X_10805_ _10805_/A _10805_/B _10805_/C VDD VSS _10839_/B OA21X2
XFILLER_14_875 VSS VDD FILLER2
XFILLER_41_650 VDD VSS FILLER1
X_11785_ _19145_/Q _11818_/B _14427_/B VDD VSS _11790_/C XOR3X1
X_14573_ _20011_/Q _16702_/B VDD VSS _19275_/D AND2X1
Xclkbuf_1_0__f__09175_ clkbuf_0__09175_/Y VDD VSS _18275_/CK BUFX12
X_19100_ _19126_/CK _19100_/D _19100_/Q VDD VSS DFFQX1
X_17361_ _19830_/Q _19798_/Q VDD VSS _17366_/A XNOR2X1
XFILLER_13_363 VDD VSS DECAPHV8
XFILLER_14_886 VSS VDD FILLER2
XFILLER_14_897 VDD VSS FILLER1
XFILLER_41_694 VDD VSS FILLER1
XFILLER_9_334 VSS VDD FILLER2
XTAP_TAPCELL_ROW_30_317 VDD VSS WELLTAP
X_10736_ _10843_/A _10736_/B VDD VSS _10737_/D NAND2X1
X_13524_ _13599_/A _14294_/B _14294_/C VDD VSS _13683_/C NOR3X1
X_17292_ _19815_/Q _19783_/Q VDD VSS _17294_/B XOR2X1
X_16312_ _19562_/Q VDD VSS _16313_/A INVX1
X_10667_ _10668_/A _10668_/B VDD VSS _10667_/Y NOR2X1
X_13455_ _14514_/B _14514_/C _19221_/Q VDD VSS _13457_/B AOI21X1
X_19031_ _19115_/CK _19031_/D _19031_/Q VDD VSS DFFQX1
X_16243_ _16243_/A _16253_/B VDD VSS _16849_/B XOR2X1
X_12406_ _12497_/A _14503_/B VDD VSS _12486_/B NOR2X1
X_16174_ _19717_/Q _16174_/B _16881_/B VDD VSS _16196_/A MIN3X1
X_10598_ _18692_/Q _18746_/Q VDD VSS _10649_/A NAND2X1
X_13386_ _13393_/A _13393_/B _13393_/C VDD VSS _14159_/B OAI21X1
X_15125_ _19341_/Q VDD VSS _15126_/A INVX1
XFILLER_5_573 VSS VDD FILLER2
XTAP_TAPCELL_ROW_117_1187 VDD VSS WELLTAP
X_12337_ _12361_/A _12361_/B _12514_/C VDD VSS _14281_/B XNOR3X1
Xoutput119 _20188_/Y VDD VSS o_tst_ctrl[7] BUFX3
Xoutput108 _20192_/Y VDD VSS o_tst_ctrl[11] BUFX3
XFILLER_141_246 VDD VSS DECAPHV16
X_12268_ _18874_/Q _12349_/B _12272_/C VDD VSS _17843_/B XNOR3X1
X_19933_ clkload3/A _19933_/D _19933_/Q VDD VSS DFFQX1
X_15056_ _15056_/A _15056_/B _15056_/C _15056_/D VDD VSS _15145_/B OAOI211X1
XFILLER_110_600 VDD VSS FILLER4
XFILLER_68_503 VSS VDD FILLER2
XFILLER_68_514 VDD VSS FILLER1
X_11219_ _11219_/A _11220_/C _11219_/C _11431_/A VDD VSS _18577_/D OA211X2
X_14007_ wire154/Y _14010_/B _14010_/D _14010_/C VDD VSS _14268_/A OA211X2
X_19864_ clkload8/A _19864_/D _19864_/Q VDD VSS DFFQX1
XFILLER_110_622 VDD VSS FILLER4
XFILLER_96_834 VSS VDD FILLER2
X_12199_ _12199_/A _12199_/B _14208_/B VDD VSS _12277_/B MIN3X1
Xoutput90 _20174_/Y VDD VSS o_lf_cfg[11] BUFX3
X_18815_ _18817_/CK _18815_/D _18815_/Q VDD VSS DFFQX1
XFILLER_110_644 VDD VSS DECAPHV8
X_19795_ _19795_/CK _19795_/D _19795_/Q VDD VSS DFFQX1
XFILLER_64_720 VSS VDD FILLER2
XFILLER_83_517 VDD VSS FILLER1
XFILLER_95_377 VDD VSS FILLER1
X_18746_ _18773_/CK _18746_/D _18746_/Q VDD VSS DFFQX1
X_15958_ _15975_/B _15975_/A _15958_/C VDD VSS _15989_/A AOI2B1X1
XFILLER_48_293 VSS VDD FILLER2
XFILLER_64_742 VSS VDD FILLER2
X_18677_ _18811_/CK _18677_/D _18677_/Q VDD VSS DFFQX1
X_14909_ _14931_/A _14909_/B VDD VSS _15804_/B XNOR2X1
XTAP_TAPCELL_ROW_128_1294 VDD VSS WELLTAP
X_17628_ _19886_/Q VDD VSS _17776_/B INVX1
X_15889_ _15895_/A _15889_/B VDD VSS _19496_/D NOR2X1
XFILLER_52_948 VSS VDD FILLER2
XFILLER_63_296 VSS VDD FILLER2
XFILLER_91_583 VDD VSS FILLER4
XTAP_TAPCELL_ROW_46_472 VDD VSS WELLTAP
XFILLER_51_458 VDD VSS FILLER4
XTAP_TAPCELL_ROW_18_196 VDD VSS WELLTAP
X_17559_ _17562_/C _17560_/B _17597_/C VDD VSS _17560_/C OAI21X1
XFILLER_118_700 VDD VSS DECAPHV16
X_19229_ _19992_/CK _19229_/D _19229_/Q VDD VSS DFFQX1
XFILLER_118_744 VSS VDD FILLER2
XFILLER_133_736 VDD VSS DECAPHV8
XFILLER_121_909 VDD VSS FILLER1
XFILLER_132_235 VDD VSS FILLER4
XFILLER_132_246 VDD VSS DECAPHV8
XFILLER_133_747 VDD VSS DECAPHV8
XFILLER_133_769 VDD VSS DECAPHV8
XFILLER_87_812 VDD VSS FILLER1
XFILLER_113_493 VDD VSS DECAPHV16
X_09815_ _18359_/Q _09815_/B _09815_/C _18327_/Q _09815_/E VDD VSS _09816_/C AOI221X1
X_20004_ _20005_/CK _20004_/D _20004_/Q VDD VSS DFFQX1
XFILLER_100_121 VDD VSS DECAPHV8
XFILLER_143_48 VSS VDD FILLER2
XFILLER_47_709 VSS VDD FILLER2
XFILLER_59_569 VDD VSS FILLER4
XFILLER_101_677 VDD VSS FILLER4
XFILLER_74_539 VSS VDD FILLER2
X_09746_ _18451_/Q VDD VSS _20149_/A INVX1
Xclkbuf_0__09169_ _18218_/ECK VDD VSS clkbuf_0__09169_/Y BUFX12
XFILLER_39_282 VDD VSS DECAPHV16
XFILLER_55_753 VDD VSS FILLER1
X_09677_ _18302_/Q _09812_/B _09784_/B _18462_/Q VDD VSS _09680_/B AOI22X1
XFILLER_36_57 VDD VSS DECAPHV16
XFILLER_54_252 VSS VDD FILLER2
XFILLER_54_285 VDD VSS DECAPHV16
XFILLER_14_138 VDD VSS FILLER1
X_11570_ _18717_/Q _11578_/B VDD VSS _18744_/D AND2X1
XFILLER_7_805 VDD VSS FILLER1
X_10521_ _10521_/A _10521_/B _10521_/C _10521_/D VDD VSS _10576_/B AOAI211X1
X_13240_ _13240_/A _13240_/B _13240_/C _13240_/D VDD VSS _14513_/B OAOI211X1
XFILLER_109_766 VSS VDD FILLER2
X_10452_ _10452_/A VDD VSS _10454_/C INVX1
XFILLER_109_777 VDD VSS FILLER1
XFILLER_124_725 VSS VDD FILLER2
X_10383_ _10383_/A _10383_/B _10383_/C _10383_/D VDD VSS _10395_/D AOI31X1
X_13171_ _13171_/A _13171_/B _14218_/B _13171_/D _13171_/E VDD VSS _13295_/C OAI221X1
X_12122_ _12189_/B _14275_/B VDD VSS _12134_/B XNOR2X1
XFILLER_111_419 VSS VDD FILLER2
XFILLER_2_543 VSS VDD FILLER2
XFILLER_78_812 VSS VDD FILLER2
XFILLER_97_609 VDD VSS DECAPHV8
X_12053_ _12053_/A _14494_/B _12053_/C _12053_/D VDD VSS _12234_/A AOAI211X1
X_16930_ _16933_/C _16931_/B _17081_/C VDD VSS _16931_/C OAI21X1
XFILLER_96_119 VDD VSS FILLER4
X_11004_ _11004_/A _11004_/B _11004_/C VDD VSS _11037_/B AO21X2
XFILLER_131_290 VSS VDD FILLER2
XFILLER_77_333 VDD VSS FILLER1
XFILLER_78_878 VDD VSS FILLER1
X_16861_ _16899_/A _16861_/B VDD VSS _19699_/D AND2X1
XFILLER_77_366 VDD VSS FILLER4
XFILLER_93_826 VSS VDD FILLER2
XTAP_TAPCELL_ROW_88_895 VDD VSS WELLTAP
X_19580_ _19615_/CK _19580_/D _19580_/Q VDD VSS DFFQX1
X_18600_ _18608_/CK _18600_/D _18600_/Q VDD VSS DFFQX1
X_16792_ _16794_/A _16792_/B VDD VSS _19638_/D NOR2X1
X_15812_ _17010_/A _15812_/B _15812_/C VDD VSS _19428_/D NOR3X1
XFILLER_18_411 VDD VSS FILLER4
XFILLER_46_720 VSS VDD FILLER2
XFILLER_58_591 VDD VSS FILLER4
XFILLER_92_336 VSS VDD FILLER2
XFILLER_93_30 VDD VSS FILLER4
X_12955_ _12955_/A _12955_/B _12955_/C _12955_/D VDD VSS _13049_/B AOI31X1
X_18531_ _18543_/CK _18531_/D _18531_/Q VDD VSS DFFQX1
X_15743_ _15743_/A _15743_/B VDD VSS _19367_/D AND2X1
XFILLER_18_455 VDD VSS FILLER1
XFILLER_34_915 VDD VSS DECAPHV8
X_11906_ _19035_/Q _14303_/B VDD VSS _11907_/B OR2X2
X_12886_ _12886_/A _13180_/B _14153_/B VDD VSS _13076_/B MIN3X1
X_18462_ _18468_/CK _18515_/Q _18462_/Q _18465_/RB VDD VSS DFFRQX1
X_15674_ _15674_/A _15674_/B VDD VSS _19306_/D AND2X1
XTAP_TAPCELL_ROW_43_442 VDD VSS WELLTAP
X_11837_ _19229_/Q _14523_/B VDD VSS _11839_/C _14523_/C NAND3X1
X_14625_ _19523_/Q _14649_/C VDD VSS _14646_/B NAND2X1
X_18393_ _18400_/CK _18393_/D _18393_/Q _18444_/RB VDD VSS DFFRQX1
X_17413_ _17562_/B _17413_/B _17413_/C VDD VSS _17417_/C MIN3X1
XTAP_TAPCELL_ROW_15_166 VDD VSS WELLTAP
X_11768_ _11768_/A _11768_/B _11768_/C _14486_/B VDD VSS _11776_/B AOAI211X1
X_14556_ _19996_/Q _14558_/B VDD VSS _19260_/D AND2X1
X_17344_ _19826_/Q _19794_/Q VDD VSS _17346_/D XNOR2X1
XTAP_TAPCELL_ROW_119_1205 VDD VSS WELLTAP
X_10719_ _18669_/Q _18777_/Q VDD VSS _10721_/B XNOR2X1
X_13507_ _18943_/Q _14193_/B _14193_/C VDD VSS _13656_/E OR3BX1
X_11699_ _19224_/Q _14517_/B VDD VSS _11700_/B OR2X2
X_14487_ _14493_/A _14487_/B VDD VSS _19199_/D NOR2X1
X_19014_ _19045_/CK _19014_/D _19014_/Q VDD VSS DFFQX1
X_17275_ _17277_/C _17275_/B _17275_/C VDD VSS _19811_/D AOI21X1
XFILLER_127_530 VDD VSS FILLER1
X_13438_ _13546_/A _13617_/B VDD VSS _14419_/B XNOR2X1
X_16226_ _16848_/B _19687_/Q VDD VSS _16227_/C NOR2BX1
XFILLER_127_563 VDD VSS FILLER1
XFILLER_127_585 VDD VSS FILLER1
XFILLER_6_860 VSS VDD FILLER2
X_13369_ _19054_/Q _13601_/A _13531_/B VDD VSS _13406_/D XNOR3X1
X_16157_ _16157_/A _16157_/B _16157_/C VDD VSS _16163_/A OA21X2
XFILLER_115_747 VSS VDD FILLER2
XFILLER_5_370 VSS VDD FILLER2
X_16088_ _19553_/Q _16699_/A _16088_/C VDD VSS _16112_/C MIN3X1
X_15108_ _15108_/A _15108_/B _15108_/C _15108_/D VDD VSS _15155_/B AOAI211X1
X_19916_ clkload7/A _19916_/D _19916_/Q VDD VSS DFFQX1
X_15039_ _15039_/A _15039_/B _15744_/B VDD VSS _15081_/B MIN3X1
XFILLER_114_279 VDD VSS FILLER4
XFILLER_69_834 VSS VDD FILLER2
XFILLER_3_61 VDD VSS DECAPHV8
X_19847_ clkload9/A _19847_/D _19847_/Q VDD VSS DFFQX1
XFILLER_110_463 VDD VSS FILLER1
XFILLER_28_219 VDD VSS DECAPHV8
XFILLER_95_163 VSS VDD FILLER2
XFILLER_96_686 VDD VSS DECAPHV8
X_09600_ _18261_/Q _09716_/B _09600_/C _09812_/C _09600_/E VDD VSS _09601_/D AOI221X1
X_19778_ clkload2/A _19778_/D _19778_/Q VDD VSS DFFQX1
X_09531_ _20026_/Q _18199_/A VDD VSS _20027_/D NOR2BX1
X_18729_ _18785_/CK _18729_/D _18729_/Q VDD VSS DFFQX1
XFILLER_36_230 VSS VDD FILLER2
XFILLER_52_712 VDD VSS DECAPHV32
XFILLER_64_550 VSS VDD FILLER2
XFILLER_24_414 VDD VSS FILLER1
XFILLER_92_881 VSS VDD FILLER2
X_09462_ _18445_/D _09468_/B _09462_/C VDD VSS _18252_/D AOI21X1
X_09393_ wire166/Y VDD VSS _232_/E INVX1
XFILLER_22_59 VSS VDD FILLER2
XFILLER_118_574 VDD VSS FILLER1
XFILLER_133_511 VDD VSS FILLER4
XFILLER_105_224 VDD VSS DECAPHV8
XFILLER_114_780 VSS VDD FILLER2
XFILLER_59_300 VDD VSS FILLER1
XFILLER_87_631 VDD VSS FILLER4
XFILLER_47_12 VDD VSS FILLER1
XFILLER_86_130 VDD VSS DECAPHV8
XFILLER_59_377 VDD VSS FILLER1
XFILLER_59_388 VDD VSS DECAPHV8
XFILLER_86_163 VDD VSS DECAPHV8
XFILLER_87_675 VDD VSS FILLER1
Xfanout198 input4/Y VDD VSS _09346_/B BUFX3
Xfanout176 _18628_/Q VDD VSS _11078_/A BUFX3
XFILLER_101_496 VDD VSS DECAPHV8
XFILLER_28_731 VSS VDD FILLER2
XFILLER_47_89 VDD VSS FILLER4
XFILLER_86_196 VDD VSS FILLER1
X_09729_ _09729_/A _09729_/B _09729_/C _09812_/C VDD VSS _09730_/C AOI31X1
XFILLER_55_561 VDD VSS DECAPHV8
XFILLER_62_509 VSS VDD FILLER2
XTAP_TAPCELL_ROW_85_865 VDD VSS WELLTAP
XFILLER_103_84 VDD VSS DECAPHV8
XFILLER_27_274 VDD VSS FILLER4
XFILLER_27_296 VSS VDD FILLER2
XTAP_TAPCELL_ROW_57_589 VDD VSS WELLTAP
X_12740_ _12816_/A _12816_/B _12816_/C VDD VSS _14410_/B AOI21X1
XFILLER_43_756 VSS VDD FILLER2
XFILLER_63_66 VSS VDD FILLER2
X_12671_ _20007_/Q _19271_/Q VDD VSS _12763_/C XOR2X1
XFILLER_30_417 VDD VSS FILLER1
XFILLER_70_586 VSS VDD FILLER2
X_11622_ _18765_/Q _11624_/B VDD VSS _18792_/D AND2X1
X_14410_ _14410_/A _14410_/B _14410_/C VDD VSS _19131_/D NOR3X1
X_15390_ _19432_/Q VDD VSS _15391_/A INVX1
XFILLER_11_620 VDD VSS FILLER4
XFILLER_23_491 VDD VSS FILLER1
XTAP_TAPCELL_ROW_40_412 VDD VSS WELLTAP
X_14341_ _14368_/A _14341_/B VDD VSS _19068_/D NOR2X1
XFILLER_128_316 VDD VSS DECAPHV8
XTAP_TAPCELL_ROW_12_136 VDD VSS WELLTAP
X_11553_ _18702_/Q _11555_/B VDD VSS _18729_/D AND2X1
X_10504_ _10595_/A _10548_/B VDD VSS _10505_/B NAND2X1
X_11484_ _18640_/Q _11484_/B VDD VSS _18667_/D AND2X1
X_14272_ _15383_/A VDD VSS _14334_/A BUFX3
X_17060_ _17064_/D _17060_/B VDD VSS _17061_/B XNOR2X1
XFILLER_12_81 VDD VSS DECAPHV16
XFILLER_137_883 VDD VSS FILLER1
X_10435_ _10435_/A _10435_/B _10512_/A VDD VSS _10624_/B OAI21X1
X_13223_ _19108_/Q _14386_/B VDD VSS _13365_/D _14386_/C NAND3X1
X_16011_ _19709_/Q VDD VSS _16024_/A INVX1
X_13154_ _19220_/Q _13444_/D _13154_/C VDD VSS _13329_/C XNOR3X1
XFILLER_124_566 VSS VDD FILLER2
XTAP_TAPCELL_ROW_114_1157 VDD VSS WELLTAP
X_10366_ _10413_/A _10413_/B _10413_/C VDD VSS _10366_/Y AOI21X1
X_12105_ _12158_/A _12158_/B _12158_/D VDD VSS _12111_/B OAI21X1
XFILLER_112_739 VDD VSS FILLER4
X_10297_ _10581_/A _10385_/B _10385_/C _10655_/A VDD VSS _10465_/B OAI211X1
X_13085_ _13178_/A _13178_/B _14156_/B VDD VSS _13286_/B MIN3X1
X_17962_ _17966_/A _17966_/B _17962_/C VDD VSS _19958_/D OA21X2
XFILLER_111_249 VDD VSS FILLER4
X_12036_ _14463_/B _14463_/C _19177_/Q VDD VSS _12040_/B AOI21X1
X_19701_ _19703_/CK _19701_/D _19701_/Q VDD VSS DFFQX1
X_17893_ _18173_/A _17893_/B VDD VSS _19946_/D NOR2X1
X_16913_ _20057_/Q input1/Y _16913_/C VDD VSS wire164/A OAI21X1
X_19632_ _19696_/CK _19632_/D _19632_/Q VDD VSS DFFQX1
X_16844_ _16860_/A VDD VSS _16859_/A BUFX3
XFILLER_65_336 VDD VSS FILLER1
XFILLER_18_252 VDD VSS FILLER1
XFILLER_81_807 VSS VDD FILLER2
XFILLER_81_829 VDD VSS DECAPHV8
X_13987_ _13987_/A _13987_/B _13987_/C _13987_/D VDD VSS _14198_/C AOI211X1
X_19563_ _19604_/CK _19563_/D _19563_/Q VDD VSS DFFQX1
X_16775_ _16775_/A _16775_/B VDD VSS _19622_/D NOR2X1
XFILLER_73_380 VDD VSS DECAPHV32
XTAP_TAPCELL_ROW_125_1264 VDD VSS WELLTAP
X_12938_ _12938_/A _14413_/B _14413_/C VDD VSS _12939_/D NOR3X1
X_19494_ _19521_/CK _19494_/D _19494_/Q VDD VSS DFFQX1
X_18514_ _18514_/CK _18514_/D _18514_/Q _09334_/Y VDD VSS DFFRQX1
X_15726_ _16795_/A VDD VSS _15743_/A BUFX3
XTAP_TAPCELL_ROW_28_291 VDD VSS WELLTAP
XTAP_TAPCELL_ROW_8_93 VDD VSS WELLTAP
X_18445_ _18455_/CK _18445_/D _18445_/Q _18455_/RB VDD VSS DFFRQX1
X_15657_ _19357_/Q _15657_/B _15732_/B VDD VSS _15662_/C MIN3X1
X_12869_ _13005_/A _13005_/C VDD VSS _12997_/C AND2X1
X_14608_ _19469_/Q _14608_/B _14638_/C VDD VSS _14613_/C XNOR3X1
X_18376_ _18391_/CK _18525_/Q _20181_/A _18444_/RB VDD VSS DFFRQX1
X_15588_ _15591_/A _15591_/B VDD VSS _18164_/B XNOR2X1
X_14539_ _14539_/A _14539_/B VDD VSS _19245_/D NOR2X1
X_17327_ _17327_/A _17329_/C _17327_/C VDD VSS _19822_/D AOI21X1
X_17258_ _19807_/Q _19775_/Q _17258_/C VDD VSS _17263_/C AOI21X1
X_16209_ _19558_/Q _16704_/A _16209_/C VDD VSS _16236_/C OAI21X1
XFILLER_108_18 VSS VDD FILLER2
XFILLER_127_371 VDD VSS FILLER1
XFILLER_127_393 VDD VSS FILLER4
XFILLER_52_0 VSS VDD FILLER2
XTAP_TAPCELL_ROW_136_1371 VDD VSS WELLTAP
X_17189_ _17189_/A _17189_/B _17189_/C VDD VSS _17197_/A OA21X2
XFILLER_142_341 VDD VSS DECAPHV8
XFILLER_111_783 VDD VSS DECAPHV16
XFILLER_69_664 VDD VSS FILLER4
XFILLER_84_623 VSS VDD FILLER2
XFILLER_110_282 VDD VSS FILLER1
XFILLER_37_561 VDD VSS DECAPHV32
XFILLER_65_870 VSS VDD FILLER2
XFILLER_140_49 VDD VSS FILLER4
XTAP_TAPCELL_ROW_82_835 VDD VSS WELLTAP
X_09514_ _20064_/Q _09516_/B _20065_/Q VDD VSS _18201_/C OR3BX1
XFILLER_52_542 VDD VSS FILLER1
XTAP_TAPCELL_ROW_54_559 VDD VSS WELLTAP
X_09445_ _09447_/B _09810_/B VDD VSS _18220_/E NOR2X1
XFILLER_12_406 VDD VSS FILLER1
XFILLER_13_929 VDD VSS FILLER1
XFILLER_80_873 VDD VSS DECAPHV8
Xclkbuf_leaf_32__000_ clkload78/A VDD VSS _19547_/CK BUFX12
XFILLER_138_603 VDD VSS FILLER1
X_09376_ _09468_/B _09467_/B VDD VSS _18226_/E OR2X2
XFILLER_137_113 VDD VSS DECAPHV8
X_10220_ _18592_/Q _18593_/Q VDD VSS _10230_/B _10220_/C NAND3X1
XFILLER_106_599 VDD VSS FILLER1
XFILLER_121_503 VSS VDD FILLER2
X_10151_ _17906_/C _10151_/B _10152_/C VDD VSS _18540_/D NOR3X1
XFILLER_58_33 VSS VDD FILLER2
XFILLER_59_130 VSS VDD FILLER2
X_10082_ _10056_/Y _10081_/Y _10155_/A VDD VSS _10130_/B MUXI2X1
XFILLER_0_877 VDD VSS DECAPHV8
XFILLER_102_761 VSS VDD FILLER2
XFILLER_59_163 VDD VSS FILLER1
X_13910_ _13910_/A _13910_/B VDD VSS _14332_/B XNOR2X1
XFILLER_101_271 VDD VSS DECAPHV8
XFILLER_101_282 VSS VDD FILLER2
X_14890_ _19365_/Q _15740_/B VDD VSS _14891_/B XOR2X1
XFILLER_114_72 VDD VSS FILLER4
XFILLER_114_94 VDD VSS FILLER1
XFILLER_63_829 VDD VSS FILLER1
XFILLER_75_689 VDD VSS FILLER4
X_13841_ _19030_/Q _14298_/B _14298_/C VDD VSS _13843_/D OR3BX1
XFILLER_28_572 VSS VDD FILLER2
XFILLER_62_328 VDD VSS DECAPHV8
XFILLER_74_65 VSS VDD FILLER2
X_10984_ _10984_/A _10984_/B _10984_/C VDD VSS _10984_/Y OAI21X1
X_13772_ _13843_/A _13889_/B VDD VSS _14264_/B XNOR2X1
X_16560_ _16561_/A _16561_/B _16561_/C VDD VSS _16585_/B AOI21X1
XFILLER_15_244 VDD VSS DECAPHV16
XFILLER_71_840 VDD VSS DECAPHV8
XFILLER_90_659 VSS VDD FILLER2
X_12723_ _19048_/Q VDD VSS _12868_/D INVX1
X_15511_ _15511_/A _15511_/B VDD VSS _15520_/B AND2X1
XFILLER_130_71 VDD VSS FILLER4
XFILLER_90_20 VSS VDD FILLER2
X_18230_ _18232_/CK _18230_/E _18230_/ECK VDD VSS CGX3
X_16491_ _19697_/Q _16858_/B VDD VSS _16492_/C NOR2X1
XFILLER_90_53 VDD VSS DECAPHV8
XTAP_TAPCELL_ROW_25_261 VDD VSS WELLTAP
X_12654_ _19157_/Q _12654_/B VDD VSS _12656_/C _12654_/C NAND3X1
X_15442_ _15472_/A _15472_/B VDD VSS _15883_/B XNOR2X1
XFILLER_8_922 VDD VSS FILLER4
X_11605_ _18749_/Q _11612_/B VDD VSS _18776_/D AND2X1
X_12585_ _20006_/Q _19270_/Q VDD VSS _12763_/B AND2X1
X_18161_ _18162_/A _18162_/B _18162_/C VDD VSS _18163_/B NOR3X1
X_15373_ _15389_/A _15373_/B VDD VSS _15753_/B XNOR2X1
XFILLER_129_658 VSS VDD FILLER2
XFILLER_23_80 VDD VSS FILLER1
X_11536_ _18687_/Q _11542_/B VDD VSS _18714_/D AND2X1
X_14324_ _14352_/A _14324_/B _14324_/C VDD VSS _19053_/D NOR3X1
X_18092_ _18095_/A _18095_/B VDD VSS _18093_/B XNOR2X1
X_17112_ _17114_/C _17112_/B _17112_/C VDD VSS _19776_/D AOI21X1
XFILLER_139_80 VSS VDD FILLER2
XFILLER_139_91 VSS VDD FILLER2
XFILLER_144_628 VSS VDD FILLER2
X_14255_ _18163_/A VDD VSS _14255_/Y BUFX3
X_17043_ _19762_/Q _17047_/B VDD VSS _17045_/D XNOR2X1
XFILLER_137_680 VSS VDD FILLER2
X_11467_ _19959_/Q _11473_/B VDD VSS _18652_/D AND2X1
X_13206_ _14321_/B _19051_/Q VDD VSS _13274_/A NAND2BX1
XFILLER_140_801 VDD VSS FILLER4
X_10418_ _19941_/Q _18823_/Q VDD VSS _10448_/B XOR2X1
X_11398_ _11398_/A _11398_/B _11398_/C VDD VSS _11398_/Y NOR3X1
X_14186_ _14186_/A _14186_/B VDD VSS _18938_/D NOR2X1
XFILLER_112_503 VDD VSS FILLER1
XFILLER_3_671 VDD VSS FILLER1
X_10349_ _10512_/A _10349_/B VDD VSS _10500_/C _10579_/D NAND3X1
X_13137_ _13137_/A _14478_/B _14478_/C VDD VSS _13138_/D NOR3X1
X_18994_ _19050_/CK _18994_/D _18994_/Q VDD VSS DFFQX1
X_13068_ _19051_/Q _13271_/A _13098_/B VDD VSS _13270_/D XNOR3X1
X_17945_ _18866_/Q _17945_/B _17945_/C VDD VSS _17948_/C XNOR3X1
XFILLER_38_303 VDD VSS FILLER4
X_12019_ _12019_/A _14337_/B _12019_/C VDD VSS _12020_/B MIN3X1
XFILLER_65_100 VSS VDD FILLER2
X_17876_ _17876_/A _17876_/B _17876_/C VDD VSS _17880_/C MIN3X1
XFILLER_65_133 VDD VSS FILLER1
X_19615_ _19615_/CK _19615_/D _19615_/Q VDD VSS DFFQX1
X_16827_ _17391_/A VDD VSS _16838_/A BUFX3
XFILLER_47_870 VDD VSS FILLER1
XFILLER_80_103 VDD VSS DECAPHV16
XFILLER_93_486 VDD VSS DECAPHV8
X_19546_ _19615_/CK _19546_/D _19546_/Q VDD VSS DFFQX1
X_16758_ _16759_/A _16758_/B VDD VSS _19607_/D NOR2X1
XFILLER_80_136 VSS VDD FILLER2
X_15709_ _15725_/A _15709_/B VDD VSS _19336_/D AND2X1
XFILLER_62_873 VDD VSS DECAPHV8
X_09230_ _18469_/D VDD VSS _18357_/D INVX1
X_19477_ _19533_/CK _19477_/D _19477_/Q VDD VSS DFFQX1
X_16689_ _16690_/A _16690_/B _18168_/C VDD VSS _16690_/C OAI21X1
XTAP_TAPCELL_ROW_51_529 VDD VSS WELLTAP
X_18428_ _18438_/CK _18428_/D _18428_/Q _18471_/RB VDD VSS DFFRQX1
XTAP_TAPCELL_ROW_138_1400 VDD VSS WELLTAP
X_18359_ _18359_/CK _18471_/D _18359_/Q _20065_/RB VDD VSS DFFRQX1
XFILLER_116_831 VSS VDD FILLER2
XFILLER_116_886 VDD VSS DECAPHV8
XFILLER_135_38 VDD VSS FILLER1
X_09994_ _18600_/Q _09998_/B VDD VSS _09996_/C XOR2X1
X_20183_ _20183_/A VDD VSS _20183_/Y BUFX3
XFILLER_131_856 VDD VSS DECAPHV8
XTAP_TAPCELL_ROW_59_607 VDD VSS WELLTAP
XFILLER_29_336 VSS VDD FILLER2
XFILLER_56_111 VSS VDD FILLER2
XFILLER_57_645 VSS VDD FILLER2
XFILLER_29_358 VDD VSS FILLER1
XFILLER_56_133 VDD VSS FILLER4
XFILLER_56_155 VSS VDD FILLER2
XFILLER_56_177 VDD VSS FILLER1
XFILLER_72_615 VSS VDD FILLER2
XTAP_TAPCELL_ROW_67_684 VDD VSS WELLTAP
XFILLER_71_158 VDD VSS DECAPHV8
XFILLER_72_659 VDD VSS FILLER1
XFILLER_53_873 VDD VSS FILLER1
XFILLER_44_79 VSS VDD FILLER2
XFILLER_52_372 VDD VSS FILLER4
X_09428_ _09816_/B VDD VSS _09751_/B BUFX3
XFILLER_40_578 VSS VDD FILLER2
XTAP_TAPCELL_ROW_22_231 VDD VSS WELLTAP
X_09359_ _18506_/Q _18505_/Q _09354_/Y VDD VSS _18506_/D MUX2X1
XFILLER_60_45 VDD VSS FILLER1
X_12370_ _19099_/Q _14376_/B VDD VSS _12544_/C _14376_/C AND3X2
XFILLER_20_280 VDD VSS FILLER4
XFILLER_60_89 VDD VSS FILLER4
X_11321_ _11364_/B _11339_/A VDD VSS _11331_/A AND2X1
XFILLER_114_2 VDD VSS FILLER1
XFILLER_106_341 VSS VDD FILLER2
XFILLER_141_609 VSS VDD FILLER2
X_11252_ _18579_/Q _11252_/B VDD VSS _11253_/D NAND2X1
X_14040_ _19007_/Q _14269_/B VDD VSS _14041_/C NAND2X1
XFILLER_107_897 VSS VDD FILLER2
XFILLER_122_834 VSS VDD FILLER2
XFILLER_134_672 VDD VSS FILLER1
X_10203_ _18591_/Q _10203_/B VDD VSS _10220_/C NOR2BX1
X_11183_ _10913_/Y _11182_/Y _11289_/A VDD VSS _11221_/B MUXI2X1
XFILLER_121_322 VDD VSS FILLER1
XFILLER_69_76 VSS VDD FILLER2
XFILLER_79_258 VDD VSS FILLER4
XTAP_TAPCELL_ROW_111_1127 VDD VSS WELLTAP
X_10134_ _18611_/Q _10134_/B VDD VSS _10150_/B AND2X1
XFILLER_121_355 VDD VSS FILLER4
XFILLER_121_377 VDD VSS FILLER1
XFILLER_76_910 VDD VSS DECAPHV8
XFILLER_79_269 VDD VSS DECAPHV8
XFILLER_94_217 VDD VSS FILLER4
XFILLER_95_729 VDD VSS FILLER4
X_15991_ _19614_/Q _16766_/B _15991_/C VDD VSS _16033_/A MIN3X1
X_10065_ _10180_/A _11411_/C VDD VSS _18533_/D NOR2X1
X_17730_ _17730_/A _17730_/B _17730_/C VDD VSS _17738_/A OA21X2
X_14942_ _14955_/B _14942_/B VDD VSS _15742_/B XOR2X1
XFILLER_47_155 VDD VSS FILLER4
XFILLER_63_604 VDD VSS FILLER1
XFILLER_75_464 VDD VSS FILLER1
X_17661_ _17663_/C _17661_/B _17661_/C VDD VSS _19893_/D AOI21X1
X_14873_ _15897_/B VDD VSS _14874_/B INVX1
XFILLER_90_401 VDD VSS FILLER1
X_13824_ _13990_/A _14166_/B VDD VSS _13866_/B NOR2X1
X_19400_ _19547_/CK _19400_/D _19400_/Q VDD VSS DFFQX1
X_16612_ _19702_/Q _16864_/B VDD VSS _16620_/C XOR2X1
XFILLER_18_91 VDD VSS FILLER4
XFILLER_62_125 VDD VSS FILLER1
X_19331_ _19358_/CK _19331_/D _19331_/Q VDD VSS DFFQX1
X_17592_ _19879_/Q _19847_/Q VDD VSS _17594_/B XOR2X1
XFILLER_141_92 VDD VSS FILLER1
XTAP_TAPCELL_ROW_122_1234 VDD VSS WELLTAP
X_10967_ _18675_/Q _18783_/Q _10967_/C VDD VSS _11007_/A MIN3X1
X_13755_ _18918_/Q _14164_/B VDD VSS _14132_/A AND2X1
X_16543_ _16540_/A _16543_/B _16543_/C VDD VSS _16566_/B AOI2B1X1
XFILLER_71_692 VDD VSS FILLER1
X_10898_ _10925_/A _10898_/B VDD VSS _10909_/B XNOR2X1
X_12706_ _18935_/Q _12708_/B _12708_/C VDD VSS _14151_/B XNOR3X1
X_13686_ _13686_/A _13686_/B _13686_/C _13686_/D VDD VSS _13830_/A AOAI211X1
X_19262_ _19999_/CK _19262_/D _19262_/Q VDD VSS DFFQX1
X_16474_ _16454_/A _16474_/B _16474_/C VDD VSS _16502_/B AOI2B1X1
X_12637_ _12731_/A _12731_/B VDD VSS _12714_/B NOR2X1
X_19193_ _19194_/CK _19193_/D _19193_/Q VDD VSS DFFQX1
X_18213_ _18223_/CK _18213_/E _18213_/ECK VDD VSS CGX3
X_15425_ _15425_/A _15425_/B _15425_/C _15425_/D VDD VSS _15464_/A AOAI211X1
XFILLER_31_589 VDD VSS FILLER1
XTAP_TAPCELL_ROW_5_61 VDD VSS WELLTAP
X_18144_ _19295_/Q _18149_/B VDD VSS _18146_/B XNOR2X1
X_12568_ _14440_/A _14440_/B _14440_/C _12568_/D VDD VSS _12771_/A OAOI211X2
X_15356_ _19541_/Q _15399_/C VDD VSS _15357_/B NAND2X1
XFILLER_144_414 VDD VSS FILLER1
X_11519_ _18672_/Q _11519_/B VDD VSS _18699_/D AND2X1
X_12499_ _12499_/A _12499_/B _12499_/C _12673_/A VDD VSS _12583_/B OAOI211X1
X_14307_ _14311_/A _14307_/B VDD VSS _19039_/D NOR2X1
X_18075_ _19282_/Q _18079_/B VDD VSS _18078_/B XNOR2X1
X_15287_ _15347_/A _15287_/B VDD VSS _15783_/B XNOR2X1
XFILLER_144_447 VSS VDD FILLER2
XFILLER_144_469 VDD VSS FILLER4
XTAP_TAPCELL_ROW_133_1341 VDD VSS WELLTAP
X_14238_ _14251_/A _14238_/B VDD VSS _18982_/D NOR2X1
X_17026_ _19759_/Q _17047_/B VDD VSS _17030_/B XNOR2X1
XFILLER_113_834 VSS VDD FILLER2
X_14169_ _14219_/A _14169_/B _14169_/C VDD VSS _18922_/D NOR3X1
Xclkbuf_1_1__f__09171_ clkbuf_0__09171_/Y VDD VSS _18343_/CK BUFX12
XFILLER_112_311 VDD VSS FILLER1
XFILLER_113_856 VDD VSS DECAPHV8
Xclkbuf_leaf_31__001_ clkbuf_2_1__f__001_/Y VDD VSS _19040_/CK BUFX12
XFILLER_112_366 VDD VSS FILLER1
XFILLER_140_686 VDD VSS FILLER1
XFILLER_85_217 VDD VSS FILLER1
XFILLER_86_729 VDD VSS FILLER1
X_18977_ _19004_/CK _18977_/D _18977_/Q VDD VSS DFFQX1
XFILLER_39_645 VDD VSS FILLER1
XFILLER_78_280 VSS VDD FILLER2
X_17928_ _18132_/A _17928_/B _17941_/B VDD VSS _19953_/D NOR3X1
XFILLER_15_0 VSS VDD FILLER2
XFILLER_38_133 VSS VDD FILLER2
X_17859_ _17863_/C _17860_/B _17917_/C VDD VSS _17860_/C OAI21X1
XFILLER_35_840 VSS VDD FILLER2
XTAP_TAPCELL_ROW_144_1470 VDD VSS WELLTAP
XFILLER_53_158 VDD VSS FILLER4
XFILLER_62_670 VDD VSS FILLER4
XTAP_TAPCELL_ROW_64_654 VDD VSS WELLTAP
X_19529_ _19533_/CK _19529_/D _19529_/Q VDD VSS DFFQX1
XTAP_TAPCELL_ROW_36_378 VDD VSS WELLTAP
XFILLER_14_49 VDD VSS FILLER4
XFILLER_50_865 VSS VDD FILLER2
X_09213_ _18515_/Q VDD VSS _18414_/D INVX1
XFILLER_22_589 VSS VDD FILLER2
XFILLER_100_8 VDD VSS FILLER4
XFILLER_123_609 VDD VSS FILLER1
XFILLER_103_333 VDD VSS FILLER4
XFILLER_103_355 VDD VSS FILLER1
X_20166_ _20166_/A VDD VSS _20166_/Y BUFX3
XFILLER_130_174 VDD VSS DECAPHV8
XFILLER_57_420 VSS VDD FILLER2
XFILLER_76_217 VDD VSS DECAPHV8
X_20097_ _20097_/A VDD VSS _20097_/Y BUFX3
XFILLER_45_637 VDD VSS FILLER1
XFILLER_57_486 VDD VSS FILLER1
XFILLER_73_924 VSS VDD FILLER2
XFILLER_85_795 VDD VSS DECAPHV8
X_11870_ _19147_/Q _14430_/B _11966_/B VDD VSS _11973_/A MIN3X1
XFILLER_60_607 VDD VSS DECAPHV8
X_10821_ _19952_/Q _18834_/Q VDD VSS _10856_/C NAND2X1
XFILLER_71_22 VDD VSS FILLER4
X_10752_ _18642_/Q _18804_/Q _10717_/C VDD VSS _10798_/A AOI21BX1
X_13540_ _19111_/Q _14389_/B VDD VSS _13696_/C _14389_/C AND3X2
X_13471_ _19111_/Q _13614_/B _13614_/C VDD VSS _13696_/B XNOR3X1
XFILLER_9_549 VDD VSS DECAPHV8
X_10683_ _19948_/Q _18830_/Q VDD VSS _10725_/A NAND2X1
X_12422_ _12461_/A _12517_/B _12517_/C VDD VSS _12519_/C AND3BX1
X_15210_ _15220_/A _15220_/B VDD VSS _15718_/B XNOR2X1
XFILLER_138_230 VSS VDD FILLER2
XFILLER_138_252 VSS VDD FILLER2
XFILLER_139_753 VDD VSS FILLER1
XFILLER_139_775 VDD VSS FILLER4
XFILLER_40_397 VSS VDD FILLER2
X_16190_ _16205_/B _16190_/B VDD VSS _16202_/A XNOR2X1
XFILLER_126_425 VDD VSS FILLER4
XFILLER_5_700 VDD VSS FILLER4
X_12353_ _18931_/Q _14179_/B _12353_/C VDD VSS _12438_/B MIN3X1
Xclkbuf_1_1__f_clk_regs clkbuf_0_clk_regs/Y VDD VSS clkbuf_leaf_9_clk_regs/A BUFX12
X_15141_ _19482_/Q _15874_/B VDD VSS _15198_/A AND2X1
XFILLER_5_755 VDD VSS FILLER4
X_11304_ _11304_/A _11304_/B VDD VSS _11305_/B XOR2X1
X_12284_ _12284_/A _12284_/B _12284_/C VDD VSS _14307_/B XNOR3X1
X_15072_ _15072_/A _15083_/B VDD VSS _15746_/B XNOR2X1
XFILLER_4_243 VSS VDD FILLER2
X_11235_ _11364_/A _11235_/B _11235_/C VDD VSS _11241_/B AOI21X1
X_14023_ _17945_/B _17945_/C _14098_/D _14098_/C VDD VSS _17957_/C AOI211X1
X_18900_ _18935_/CK _18900_/D _18900_/Q VDD VSS DFFQX1
XFILLER_122_620 VDD VSS DECAPHV8
XFILLER_136_70 VDD VSS FILLER1
X_19880_ clkload9/A _19880_/D _19880_/Q VDD VSS DFFQX1
XFILLER_121_130 VDD VSS FILLER1
XFILLER_122_664 VSS VDD FILLER2
XFILLER_49_910 VDD VSS FILLER1
X_11166_ _11167_/A _11167_/B _11167_/D _11167_/C VDD VSS _11168_/B OA211X2
X_18831_ _19948_/CK _18831_/D _18831_/Q VDD VSS DFFQX1
XFILLER_0_471 VDD VSS DECAPHV8
XFILLER_96_63 VDD VSS DECAPHV8
X_10117_ _10070_/Y _10167_/B _10167_/A VDD VSS _10117_/Y MUX2X1
X_11097_ _18652_/Q VDD VSS _11497_/A INVX1
X_18762_ _19937_/CK _18762_/D _18762_/Q VDD VSS DFFQX1
X_18204__250 _18259_/CK VDD VSS _20046_/CK INVX1
X_15974_ _19677_/Q VDD VSS _16012_/A INVX1
XFILLER_76_740 VDD VSS DECAPHV16
X_10048_ _10131_/A _10048_/B _10048_/C VDD VSS _10053_/B OAI21X1
X_17713_ _19905_/Q _19873_/Q VDD VSS _17715_/B XOR2X1
X_14925_ _19505_/Q _14925_/B VDD VSS _15016_/A NAND2X1
XFILLER_63_412 VDD VSS DECAPHV8
XFILLER_91_710 VSS VDD FILLER2
X_18693_ _18801_/CK _18693_/D _18693_/Q VDD VSS DFFQX1
XFILLER_17_840 VSS VDD FILLER2
X_17644_ _19890_/Q _19858_/Q VDD VSS _17646_/D XNOR2X1
X_14856_ _19364_/Q VDD VSS _14857_/A INVX1
XFILLER_50_106 VDD VSS DECAPHV8
XFILLER_51_618 VSS VDD FILLER2
XFILLER_63_478 VDD VSS FILLER4
XFILLER_90_242 VDD VSS FILLER1
X_13807_ _13807_/A _13807_/B _13807_/C _13807_/D VDD VSS _14131_/B AOAI211X1
X_17575_ _17577_/C _17575_/B _17575_/C VDD VSS _19875_/D AOI21X1
X_14787_ _19529_/Q _14877_/C VDD VSS _15895_/B XNOR2X1
XFILLER_90_286 VSS VDD FILLER2
XTAP_TAPCELL_ROW_61_624 VDD VSS WELLTAP
X_11999_ _19150_/Q _11999_/B _12029_/D VDD VSS _12031_/C XNOR3X1
X_13738_ _18974_/Q _13760_/B _13830_/D VDD VSS _13771_/C XNOR3X1
X_19314_ _19337_/CK _19314_/D _19314_/Q VDD VSS DFFQX1
X_16526_ _19570_/Q _16718_/A _16526_/C VDD VSS _16551_/C OAI21X1
XTAP_TAPCELL_ROW_33_348 VDD VSS WELLTAP
X_19245_ _20008_/CK _19245_/D _19245_/Q VDD VSS DFFQX1
XFILLER_31_375 VDD VSS DECAPHV16
X_13669_ _18889_/Q _14130_/B VDD VSS _17920_/A AND2X1
X_16457_ _19664_/Q _16822_/B VDD VSS _16459_/C XNOR2X1
XFILLER_118_926 VDD VSS FILLER4
XFILLER_77_2 VDD VSS FILLER1
X_19176_ _19234_/CK _19176_/D _19176_/Q VDD VSS DFFQX1
X_16388_ _16388_/A _16388_/B _16388_/C _16388_/D VDD VSS _16409_/A AOAI211X1
X_15408_ _19433_/Q _15818_/B VDD VSS _15429_/B XNOR2X1
XFILLER_129_263 VDD VSS FILLER4
X_18127_ _18131_/B _18127_/B _18127_/C VDD VSS _19999_/D AND3BX1
X_15339_ _15672_/A _18128_/B VDD VSS _19291_/D NOR2X1
X_18058_ _18057_/Y _18058_/B VDD VSS _19986_/D NOR2BX1
X_09900_ _09850_/Y _09884_/B _10966_/A VDD VSS _09940_/B MUXI2X1
X_17009_ _17019_/B _17009_/B _17019_/A VDD VSS _17012_/C OA21X2
XFILLER_140_450 VDD VSS DECAPHV16
XFILLER_59_718 VSS VDD FILLER2
XTAP_TAPCELL_ROW_69_702 VDD VSS WELLTAP
X_09831_ _09928_/C VDD VSS _10190_/B BUFX3
X_20020_ _20020_/CK _20020_/D _20020_/Q _20031_/RB VDD VSS DFFRQX1
XFILLER_100_314 VDD VSS FILLER1
X_09762_ _18340_/Q VDD VSS _20094_/A INVX1
Xclkbuf_0__09185_ _18234_/ECK VDD VSS clkbuf_0__09185_/Y BUFX12
XFILLER_100_347 VDD VSS FILLER4
XFILLER_27_604 VSS VDD FILLER2
XFILLER_39_464 VDD VSS FILLER1
XFILLER_54_401 VSS VDD FILLER2
X_09693_ _18267_/Q _09818_/C _09693_/C _09776_/A _09693_/E VDD VSS _09700_/A AOI221X1
XFILLER_66_294 VDD VSS FILLER4
XFILLER_81_220 VDD VSS FILLER1
XFILLER_82_754 VDD VSS FILLER4
XTAP_TAPCELL_ROW_77_790 VDD VSS WELLTAP
XFILLER_42_607 VDD VSS FILLER4
XFILLER_42_618 VDD VSS DECAPHV8
XFILLER_70_916 VDD VSS FILLER4
XFILLER_81_242 VDD VSS FILLER1
XFILLER_35_670 VSS VDD FILLER2
XFILLER_41_139 VDD VSS FILLER4
XFILLER_81_275 VDD VSS FILLER4
XFILLER_34_180 VDD VSS FILLER4
XFILLER_50_640 VDD VSS FILLER1
XFILLER_50_651 VDD VSS FILLER1
XFILLER_41_25 VDD VSS DECAPHV32
XFILLER_6_508 VSS VDD FILLER2
XFILLER_131_450 VDD VSS DECAPHV8
XFILLER_1_268 VDD VSS DECAPHV8
XFILLER_89_342 VDD VSS FILLER1
XFILLER_89_364 VDD VSS DECAPHV8
X_11020_ _11020_/A _11026_/C VDD VSS _11021_/B XNOR2X1
X_20218_ _20218_/A VDD VSS _20218_/Y BUFX3
XFILLER_106_40 VDD VSS FILLER4
XFILLER_77_548 VDD VSS DECAPHV8
XFILLER_89_375 VDD VSS DECAPHV8
X_20149_ _20149_/A VDD VSS _20149_/Y BUFX3
XFILLER_46_924 VSS VDD FILLER2
XFILLER_58_784 VDD VSS FILLER4
XFILLER_85_581 VDD VSS FILLER1
X_12971_ _19190_/Q _13131_/A _13042_/B VDD VSS _13108_/D XNOR3X1
XFILLER_45_423 VDD VSS FILLER1
XFILLER_45_445 VDD VSS FILLER4
XFILLER_72_231 VDD VSS FILLER1
XFILLER_73_743 VDD VSS FILLER1
X_11922_ _11922_/A _11922_/B _11922_/C _11922_/D VDD VSS wire162/A AOAI211X1
X_15690_ _15693_/A _15690_/B VDD VSS _19319_/D NOR2X1
X_14710_ _14710_/A _14710_/B _14710_/C _14710_/D VDD VSS _14785_/A OAOI211X1
XFILLER_17_158 VSS VDD FILLER2
XFILLER_33_618 VDD VSS FILLER1
XFILLER_60_404 VDD VSS FILLER1
XFILLER_72_253 VDD VSS FILLER1
X_11853_ _11916_/A _11916_/B VDD VSS _14429_/B XNOR2X1
X_14641_ _19470_/Q VDD VSS _14671_/A INVX1
X_10804_ _11078_/A _18725_/Q _10804_/C _10804_/D _10804_/E VDD VSS _10805_/C AOI221X1
X_17360_ _17362_/C _17360_/B _17360_/C VDD VSS _19829_/D AOI21X1
XFILLER_41_640 VDD VSS FILLER1
XFILLER_60_448 VDD VSS FILLER4
X_11784_ _19173_/Q _11852_/B _11794_/C VDD VSS _14427_/B XNOR3X1
X_14572_ _20010_/Q _16702_/B VDD VSS _19274_/D AND2X1
Xclkbuf_1_0__f__09174_ clkbuf_0__09174_/Y VDD VSS _18291_/CK BUFX12
X_16311_ _16289_/A _16311_/B _16311_/C VDD VSS _16317_/A AOI2B1X1
XTAP_TAPCELL_ROW_30_318 VDD VSS WELLTAP
X_10735_ _10807_/B _10807_/C _10947_/A _10735_/D VDD VSS _10736_/B OAOI211X1
X_13523_ _13533_/A _14293_/B _13599_/C VDD VSS _14294_/C NOR3X1
X_17291_ _19814_/Q _19782_/Q _17291_/C VDD VSS _17296_/C AO21X2
X_10666_ _10666_/A _10666_/B _10666_/C VDD VSS _10668_/B AOI21X1
X_13454_ _13466_/A _13466_/B _13454_/C _13466_/E VDD VSS _14481_/B AOI211X1
X_19030_ _19115_/CK _19030_/D _19030_/Q VDD VSS DFFQX1
X_16242_ _19656_/Q _16814_/B VDD VSS _16253_/B XNOR2X1
XFILLER_139_594 VDD VSS FILLER1
X_12405_ _12405_/A _12405_/B _12405_/C _12405_/D VDD VSS _14503_/B OAOI211X1
X_13385_ _13494_/B _13385_/B _13385_/C VDD VSS _13578_/A OAI21X1
X_16173_ _16174_/B _16173_/B _16173_/C VDD VSS _19525_/D AOI21X1
XTAP_TAPCELL_ROW_2_40 VDD VSS WELLTAP
X_10597_ _11127_/A _10630_/A VDD VSS _10627_/A NAND2X1
X_15124_ _19342_/Q _15716_/B VDD VSS _15127_/A XOR2X1
XFILLER_114_417 VDD VSS FILLER1
XTAP_TAPCELL_ROW_117_1188 VDD VSS WELLTAP
X_12336_ _12360_/A _12366_/D VDD VSS _12514_/C XNOR2X1
Xoutput109 _20193_/Y VDD VSS o_tst_ctrl[12] BUFX3
XTAP_TAPCELL_ROW_130_1311 VDD VSS WELLTAP
X_12267_ _18902_/Q _12348_/B _14146_/B VDD VSS _12272_/C XNOR3X1
X_19932_ clkload3/A _19932_/D _19932_/Q VDD VSS DFFQX1
X_15055_ _19507_/Q _15901_/B VDD VSS _15145_/A NOR2BX1
X_11218_ _11219_/A _11220_/C VDD VSS _11219_/C NAND2X1
X_12198_ _18929_/Q _12198_/B _14177_/B VDD VSS _12341_/B MIN3X1
X_14006_ _14045_/A _14045_/B _14045_/E VDD VSS _14015_/B AOI21X1
X_19863_ _19863_/CK _19863_/D _19863_/Q VDD VSS DFFQX1
XFILLER_110_634 VDD VSS FILLER1
X_11149_ _11149_/A _11149_/B VDD VSS _11149_/Y _11149_/C NAND3X1
Xoutput80 _20154_/Y VDD VSS o_en_ctrl[2] BUFX3
Xoutput91 _20175_/Y VDD VSS o_lf_cfg[12] BUFX3
X_18814_ _19958_/CK _18814_/D _18814_/Q VDD VSS DFFQX1
XFILLER_110_656 VSS VDD FILLER2
XFILLER_1_791 VDD VSS FILLER1
X_19794_ _19795_/CK _19794_/D _19794_/Q VDD VSS DFFQX1
XFILLER_37_913 VDD VSS DECAPHV8
XFILLER_48_261 VDD VSS FILLER1
XFILLER_49_773 VDD VSS DECAPHV8
X_18745_ _18773_/CK _18745_/D _18745_/Q VDD VSS DFFQX1
X_15957_ _19645_/Q _16802_/B VDD VSS _15958_/C NOR2X1
X_18676_ _18811_/CK _18676_/D _18676_/Q VDD VSS DFFQX1
X_15888_ _16768_/A _15888_/B VDD VSS _19495_/D AND2X1
X_14908_ _14908_/A _14908_/B _14908_/C _14908_/D VDD VSS _14931_/A AOAI211X1
XFILLER_24_607 VDD VSS DECAPHV8
XFILLER_36_456 VSS VDD FILLER2
XFILLER_91_551 VSS VDD FILLER2
XTAP_TAPCELL_ROW_128_1295 VDD VSS WELLTAP
XTAP_TAPCELL_ROW_74_760 VDD VSS WELLTAP
X_17627_ _17627_/A _17629_/C _17627_/C VDD VSS _19886_/D AOI21X1
X_14839_ _19446_/Q _14839_/B VDD VSS _14840_/C _14839_/C NAND3X1
XFILLER_51_437 VDD VSS FILLER4
XTAP_TAPCELL_ROW_46_473 VDD VSS WELLTAP
XTAP_TAPCELL_ROW_18_197 VDD VSS WELLTAP
X_17558_ _19872_/Q _19840_/Q VDD VSS _17560_/B XNOR2X1
XFILLER_32_673 VDD VSS FILLER4
X_17489_ _19857_/Q _19825_/Q VDD VSS _17496_/C NOR2X1
X_16509_ _16509_/A _16517_/B VDD VSS _16895_/B XOR2X1
XFILLER_82_0 VSS VDD FILLER2
X_19228_ _19992_/CK _19228_/D _19228_/Q VDD VSS DFFQX1
X_19159_ _19187_/CK _19159_/D _19159_/Q VDD VSS DFFQX1
XFILLER_106_907 VSS VDD FILLER2
XFILLER_11_17 VSS VDD FILLER2
XFILLER_120_409 VSS VDD FILLER2
XFILLER_132_258 VSS VDD FILLER2
XFILLER_87_802 VDD VSS DECAPHV8
XFILLER_101_612 VDD VSS DECAPHV8
XFILLER_113_472 VDD VSS FILLER4
XFILLER_59_515 VDD VSS FILLER1
XFILLER_98_150 VSS VDD FILLER2
X_09814_ _20178_/A _09814_/B _09814_/C _20196_/A VDD VSS _09815_/E AO22X2
X_20003_ _20005_/CK _20003_/D _20003_/Q VDD VSS DFFQX1
XFILLER_100_133 VDD VSS FILLER1
X_09745_ _09791_/A _09745_/B _09745_/C _09745_/D VDD VSS _18290_/D OAI211X1
Xclkbuf_0__09168_ _18217_/ECK VDD VSS clkbuf_0__09168_/Y BUFX12
XFILLER_55_721 VDD VSS FILLER1
X_09676_ _20203_/A _09797_/C _09812_/C VDD VSS _09680_/A AOI21X1
XFILLER_15_618 VDD VSS DECAPHV8
XFILLER_55_787 VSS VDD FILLER2
XFILLER_70_713 VDD VSS FILLER4
XFILLER_43_938 VDD VSS FILLER4
XTAP_TAPCELL_ROW_105_1070 VDD VSS WELLTAP
XFILLER_22_150 VDD VSS FILLER1
XFILLER_23_684 VDD VSS FILLER1
XFILLER_11_846 VDD VSS DECAPHV16
XFILLER_50_481 VDD VSS FILLER4
X_10520_ _18663_/Q _18771_/Q VDD VSS _10521_/D NAND2X1
X_10451_ _18662_/Q _18770_/Q VDD VSS _10452_/A XNOR2X1
XFILLER_136_520 VDD VSS FILLER1
XFILLER_108_277 VDD VSS FILLER1
XFILLER_124_704 VDD VSS FILLER1
X_10382_ _11078_/A _18714_/Q VDD VSS _10383_/D AND2X1
X_13170_ _13171_/D _14218_/B VDD VSS _13295_/A NAND2X1
XFILLER_108_299 VDD VSS DECAPHV8
XFILLER_136_597 VDD VSS FILLER4
XFILLER_2_500 VSS VDD FILLER2
XFILLER_2_522 VDD VSS FILLER1
XTAP_TAPCELL_ROW_9_110 VDD VSS WELLTAP
X_12121_ _19040_/Q _12448_/B _12286_/B VDD VSS _14275_/B XNOR3X1
XFILLER_117_61 VDD VSS FILLER4
X_12052_ _14528_/A _14528_/B _19234_/Q VDD VSS _12053_/D OAI21X1
XFILLER_2_599 VDD VSS FILLER4
XFILLER_77_54 VDD VSS FILLER4
XFILLER_78_824 VDD VSS DECAPHV16
X_11003_ _19957_/Q _18839_/Q VDD VSS _11037_/A XNOR2X1
X_16860_ _16860_/A VDD VSS _16899_/A BUFX3
X_16791_ _16794_/A _16791_/B VDD VSS _19637_/D NOR2X1
X_15811_ _15816_/A _15811_/B VDD VSS _19427_/D NOR2X1
XFILLER_46_743 VDD VSS FILLER1
XTAP_TAPCELL_ROW_88_896 VDD VSS WELLTAP
X_12954_ _19218_/Q VDD VSS _13135_/A INVX1
X_18530_ _18543_/CK _18530_/D _18530_/Q VDD VSS DFFQX1
X_15742_ _15758_/A _15742_/B VDD VSS _19366_/D NOR2X1
XFILLER_18_445 VDD VSS DECAPHV8
XFILLER_34_905 VSS VDD FILLER2
XFILLER_46_765 VDD VSS FILLER1
X_11905_ _19037_/Q VDD VSS _12015_/A INVX1
X_18461_ _18468_/CK _18477_/D _18461_/Q _20075_/RB VDD VSS DFFRQX1
XFILLER_33_437 VSS VDD FILLER2
X_12885_ _18881_/Q _12885_/B _12885_/C VDD VSS _13077_/B MIN3X1
X_17412_ _19840_/Q VDD VSS _17562_/B INVX1
X_15673_ _15674_/A _15673_/B VDD VSS _19305_/D AND2X1
XTAP_TAPCELL_ROW_43_443 VDD VSS WELLTAP
XTAP_TAPCELL_ROW_71_730 VDD VSS WELLTAP
X_11836_ _14523_/B _14523_/C _19229_/Q VDD VSS _11839_/B AOI21X1
X_14624_ _14624_/A _14624_/B _14624_/C _14624_/D VDD VSS _14676_/A OAOI211X1
X_18392_ _18400_/CK _18392_/D _18392_/Q _09380_/B VDD VSS DFFRQX1
XTAP_TAPCELL_ROW_15_167 VDD VSS WELLTAP
X_11767_ _19227_/Q _11778_/A _11769_/B VDD VSS _14486_/B XNOR3X1
X_14555_ _19995_/Q _14558_/B VDD VSS _19259_/D AND2X1
X_17343_ _17346_/A _17343_/B _17343_/C VDD VSS _19825_/D AOI21X1
XTAP_TAPCELL_ROW_119_1206 VDD VSS WELLTAP
X_10718_ _10718_/A _10718_/B _10718_/C _10718_/D VDD VSS _10721_/C AOAI211X1
X_13506_ _13586_/A _14192_/B _13586_/C VDD VSS _14193_/C NOR3X1
X_17274_ _17277_/C _17275_/B _17306_/C VDD VSS _17275_/C OAI21X1
XFILLER_9_176 VDD VSS FILLER1
X_11698_ _19197_/Q _14484_/B VDD VSS _11739_/B NOR2X1
X_14486_ _14486_/A _14486_/B VDD VSS _14487_/B XNOR2X1
X_19013_ _19045_/CK _19013_/D _19013_/Q VDD VSS DFFQX1
X_16225_ _16225_/A _16225_/B VDD VSS _16250_/B NAND2X1
XFILLER_139_380 VDD VSS DECAPHV8
X_10649_ _10649_/A _10649_/B _10649_/C _10649_/D VDD VSS _10729_/D AOAI211X1
X_13437_ _13437_/A _13437_/B _13437_/C _13437_/D VDD VSS _13623_/A OAOI211X1
XFILLER_115_726 VDD VSS FILLER1
XFILLER_127_553 VDD VSS FILLER4
XFILLER_127_575 VDD VSS DECAPHV8
X_13368_ _14323_/A _13422_/B _13422_/C _13422_/D VDD VSS _13531_/B AO31X2
X_16156_ _19588_/Q _16738_/B VDD VSS _16157_/C OR2X2
XFILLER_115_737 VDD VSS FILLER4
XFILLER_6_894 VDD VSS FILLER1
X_12319_ _12407_/D _12407_/C VDD VSS _12396_/C NAND2BX1
X_16087_ _19905_/Q VDD VSS _16699_/A INVX1
X_15107_ _19508_/Q _15144_/B VDD VSS _15108_/C NOR2X1
XFILLER_5_393 VDD VSS FILLER4
X_13299_ _18996_/Q _14258_/B VDD VSS _13395_/A NAND2X1
X_19915_ _19928_/CK _19915_/D _19915_/Q VDD VSS DFFQX1
X_15038_ _19368_/Q VDD VSS _15039_/A INVX1
XFILLER_3_73 VSS VDD FILLER2
XFILLER_96_665 VDD VSS DECAPHV8
X_19846_ _19863_/CK _19846_/D _19846_/Q VDD VSS DFFQX1
XFILLER_110_475 VSS VDD FILLER2
XFILLER_3_84 VDD VSS FILLER1
XFILLER_56_529 VDD VSS FILLER4
XFILLER_68_378 VDD VSS FILLER1
XFILLER_83_315 VDD VSS FILLER4
X_19777_ clkload2/A _19777_/D _19777_/Q VDD VSS DFFQX1
X_16989_ _17391_/A VDD VSS _17095_/A BUFX3
XFILLER_37_743 VDD VSS FILLER1
XFILLER_49_592 VDD VSS DECAPHV16
X_09530_ _20025_/Q _18199_/A VDD VSS _20026_/D NOR2BX1
X_18728_ _18782_/CK _18728_/D _18728_/Q VDD VSS DFFQX1
XFILLER_25_905 VDD VSS DECAPHV8
XFILLER_37_765 VSS VDD FILLER2
X_09461_ _19970_/Q _09467_/B _09476_/C VDD VSS _09462_/C AOI21X1
XFILLER_25_949 VDD VSS FILLER1
XFILLER_37_798 VDD VSS DECAPHV8
XFILLER_64_573 VDD VSS FILLER4
XFILLER_64_595 VDD VSS FILLER4
XFILLER_91_381 VDD VSS FILLER4
X_18659_ _18799_/CK _18659_/D _18659_/Q VDD VSS DFFQX1
XFILLER_52_746 VDD VSS FILLER1
XFILLER_52_768 VDD VSS FILLER1
XFILLER_91_392 VDD VSS FILLER4
X_09392_ _18010_/A _11429_/B VDD VSS wire166/A NOR2X1
XFILLER_51_278 VDD VSS FILLER1
XFILLER_138_16 VDD VSS DECAPHV8
XFILLER_118_542 VDD VSS FILLER4
XFILLER_106_704 VSS VDD FILLER2
XFILLER_118_564 VDD VSS DECAPHV8
XFILLER_106_759 VDD VSS FILLER1
XFILLER_3_319 VSS VDD FILLER2
XFILLER_120_239 VDD VSS DECAPHV8
XFILLER_87_654 VDD VSS DECAPHV8
XFILLER_101_464 VDD VSS FILLER1
Xfanout199 _20071_/RB VDD VSS _20031_/RB BUFX3
Xfanout177 _18627_/Q VDD VSS _11435_/B BUFX3
X_09728_ _18465_/Q _09784_/B _09770_/C _20091_/A VDD VSS _09729_/C AOI22X1
XFILLER_28_765 VDD VSS DECAPHV8
XFILLER_55_551 VDD VSS FILLER4
XFILLER_90_808 VDD VSS FILLER1
XTAP_TAPCELL_ROW_85_866 VDD VSS WELLTAP
XFILLER_55_573 VSS VDD FILLER2
X_09659_ _20122_/A _09788_/B _09659_/C _09776_/A VDD VSS _09666_/A AOAI211X1
XFILLER_103_96 VDD VSS FILLER4
XFILLER_70_554 VDD VSS FILLER4
X_12670_ _19243_/Q VDD VSS _12759_/A INVX1
X_11621_ _18764_/Q _11624_/B VDD VSS _18791_/D AND2X1
XFILLER_11_632 VDD VSS FILLER1
XTAP_TAPCELL_ROW_40_413 VDD VSS WELLTAP
X_14340_ _14457_/A VDD VSS _14368_/A BUFX3
XFILLER_128_328 VDD VSS DECAPHV8
XTAP_TAPCELL_ROW_12_137 VDD VSS WELLTAP
X_11552_ _18701_/Q _11555_/B VDD VSS _18728_/D AND2X1
XFILLER_109_542 VSS VDD FILLER2
XFILLER_11_687 VDD VSS FILLER1
XFILLER_6_124 VDD VSS DECAPHV8
XFILLER_7_658 VSS VDD FILLER2
X_10503_ _10503_/A _10503_/B _10503_/C VDD VSS _10548_/B OR3X2
X_11483_ _18639_/Q _11484_/B VDD VSS _18666_/D AND2X1
X_14271_ _14285_/A _14271_/B VDD VSS _19009_/D NOR2X1
X_10434_ _18555_/Q _10434_/B VDD VSS _10472_/A NAND2X1
X_13222_ _13319_/A _14385_/B _13231_/C VDD VSS _14386_/C OR3BX1
X_16010_ _16010_/A _16010_/B VDD VSS _16873_/B XNOR2X1
X_10365_ _18687_/Q _18741_/Q VDD VSS _10413_/C XNOR2X1
X_13153_ _13240_/A _13240_/B _13240_/C VDD VSS _13154_/C OAI21X1
XFILLER_97_407 VDD VSS DECAPHV16
XTAP_TAPCELL_ROW_114_1158 VDD VSS WELLTAP
X_12104_ _19235_/Q _14529_/B VDD VSS _12158_/D _14529_/C NAND3X1
XFILLER_124_589 VDD VSS FILLER1
XFILLER_2_352 VDD VSS FILLER1
X_10296_ _10346_/A _10346_/B _10349_/B VDD VSS _10385_/C AO21X2
X_13084_ _18939_/Q _13086_/B _13086_/C VDD VSS _14156_/B XNOR3X1
X_17961_ _17966_/A _17966_/B _18163_/A VDD VSS _17962_/C AOI21X1
X_12035_ _12035_/A _12035_/B _12035_/C _12035_/D VDD VSS _12040_/A OAOI211X1
X_19700_ _19703_/CK _19700_/D _19700_/Q VDD VSS DFFQX1
X_17892_ _17892_/A _17894_/C VDD VSS _17893_/B XNOR2X1
X_16912_ _20069_/Q _16912_/B _16912_/C _20057_/Q VDD VSS _16913_/C OAI211X1
XFILLER_120_784 VDD VSS FILLER1
XFILLER_38_518 VDD VSS FILLER1
XFILLER_93_602 VDD VSS FILLER4
X_19631_ _19636_/CK _19631_/D _19631_/Q VDD VSS DFFQX1
X_16843_ _16843_/A _16843_/B VDD VSS _19683_/D AND2X1
XFILLER_93_646 VDD VSS FILLER1
X_19562_ _19606_/CK _19562_/D _19562_/Q VDD VSS DFFQX1
XFILLER_18_220 VDD VSS FILLER1
XFILLER_65_359 VDD VSS FILLER4
XFILLER_92_156 VDD VSS DECAPHV8
X_13986_ _18894_/Q _14137_/B VDD VSS _14018_/C _14137_/C NAND3X1
X_18513_ _18513_/CK _18513_/D _18513_/Q _09337_/Y VDD VSS DFFRQX1
X_16774_ _16793_/A _16774_/B VDD VSS _19621_/D AND2X1
XFILLER_61_510 VSS VDD FILLER2
XFILLER_92_189 VDD VSS FILLER1
XTAP_TAPCELL_ROW_125_1265 VDD VSS WELLTAP
X_12937_ _13107_/A _13107_/B _13107_/D _13107_/C VDD VSS _14413_/C AOI211X1
X_19493_ _19495_/CK _19493_/D _19493_/Q VDD VSS DFFQX1
X_15725_ _15725_/A _15725_/B VDD VSS _19351_/D AND2X1
XTAP_TAPCELL_ROW_28_292 VDD VSS WELLTAP
XTAP_TAPCELL_ROW_8_94 VDD VSS WELLTAP
X_12868_ _12868_/A _12868_/B _14318_/B _12868_/D _12868_/E VDD VSS _13005_/C OAI221X1
X_18444_ _18453_/CK _18444_/D _18444_/Q _18444_/RB VDD VSS DFFRQX1
X_15656_ _19358_/Q _15733_/B VDD VSS _15658_/A XNOR2X1
X_11819_ _11819_/A _11819_/B _14396_/B VDD VSS _11821_/B MIN3X1
X_14607_ _15859_/A _14607_/B _14645_/C VDD VSS _14638_/C XNOR3X1
X_18375_ _18375_/CK _18524_/Q _18375_/Q _18465_/RB VDD VSS DFFRQX1
X_12799_ _12868_/A _12868_/B _12868_/E _12799_/D VDD VSS _14286_/C OAOI211X1
X_17326_ _17327_/A _17329_/C _17363_/C VDD VSS _17327_/C OAI21X1
X_15587_ _19326_/Q _15698_/B VDD VSS _15591_/B XNOR2X1
X_14538_ _14538_/A _14538_/B _17827_/B VDD VSS _19244_/D AOI21X1
X_14469_ _14421_/Y _14469_/B _14469_/C VDD VSS _19183_/D AND3BX1
X_17257_ _17255_/B _17257_/B VDD VSS _17258_/C NOR2BX1
XFILLER_115_501 VSS VDD FILLER2
X_17188_ _19792_/Q _19760_/Q VDD VSS _17189_/C NAND2X1
X_16208_ _16208_/A _16208_/B VDD VSS _16209_/C NAND2X1
XTAP_TAPCELL_ROW_136_1372 VDD VSS WELLTAP
X_16139_ _19588_/Q _16738_/B VDD VSS _16157_/B XNOR2X1
XFILLER_103_707 VSS VDD FILLER2
XFILLER_142_353 VDD VSS FILLER1
XFILLER_45_0 VSS VDD FILLER2
XFILLER_103_718 VDD VSS DECAPHV8
XFILLER_124_29 VDD VSS FILLER1
XFILLER_96_440 VDD VSS FILLER4
XFILLER_69_687 VDD VSS FILLER4
XFILLER_96_451 VSS VDD FILLER2
X_19829_ _19830_/CK _19829_/D _19829_/Q VDD VSS DFFQX1
XFILLER_72_808 VDD VSS DECAPHV8
XFILLER_83_134 VDD VSS FILLER4
XFILLER_140_28 VDD VSS FILLER1
XFILLER_83_189 VSS VDD FILLER2
XTAP_TAPCELL_ROW_82_836 VDD VSS WELLTAP
X_09513_ _09421_/A _09527_/B _20014_/Q VDD VSS _09515_/B AOI2B1X1
XFILLER_25_757 VDD VSS FILLER1
XFILLER_52_554 VDD VSS FILLER4
XFILLER_64_392 VSS VDD FILLER2
X_09444_ _09630_/C _09578_/B VDD VSS _09810_/B OR2X2
XTAP_TAPCELL_ROW_102_1040 VDD VSS WELLTAP
X_09375_ _09496_/B VDD VSS _09467_/B BUFX3
XFILLER_119_884 VDD VSS FILLER4
XFILLER_106_556 VDD VSS FILLER4
XFILLER_133_342 VDD VSS FILLER1
XFILLER_3_138 VDD VSS FILLER1
XFILLER_0_801 VSS VDD FILLER2
XFILLER_133_375 VSS VDD FILLER2
X_10150_ _10150_/A _10150_/B _10150_/C _10150_/D VDD VSS _10152_/C OA211X2
X_10081_ _10068_/Y _10080_/Y _10127_/A VDD VSS _10081_/Y MUX2X1
XFILLER_0_867 VSS VDD FILLER2
XFILLER_48_827 VDD VSS DECAPHV8
XFILLER_75_613 VDD VSS FILLER4
XTAP_TAPCELL_ROW_98_991 VDD VSS WELLTAP
XFILLER_114_84 VDD VSS FILLER1
XFILLER_63_819 VDD VSS DECAPHV8
X_13840_ _13840_/A _13840_/B _13840_/C _13840_/D VDD VSS _13843_/B OAOI211X1
XFILLER_62_307 VSS VDD FILLER2
X_10983_ _10984_/A _10983_/B VDD VSS _10984_/C NAND2X1
X_13771_ _13771_/A _14195_/B _13771_/C _13771_/D VDD VSS _13921_/A OAOI211X1
XFILLER_15_223 VDD VSS DECAPHV8
XFILLER_74_88 VDD VSS FILLER4
X_12722_ _12868_/A _12868_/B _12868_/E VDD VSS _12778_/B OA21X2
X_16490_ _19729_/Q _16490_/B _16894_/B VDD VSS _16515_/B MIN3X1
X_15510_ _19463_/Q _15851_/B VDD VSS _15520_/A NOR2BX1
XFILLER_71_863 VSS VDD FILLER2
X_15441_ _15474_/A _15474_/B VDD VSS _15472_/B XNOR2X1
XTAP_TAPCELL_ROW_25_262 VDD VSS WELLTAP
X_12653_ _12654_/B _12654_/C _19157_/Q VDD VSS _12656_/B AOI21X1
X_11604_ _18748_/Q _11612_/B VDD VSS _18775_/D AND2X1
X_12584_ _20006_/Q _19270_/Q VDD VSS _12763_/D OR2X2
X_18160_ _19298_/Q _18164_/B VDD VSS _18162_/C XNOR2X1
X_15372_ _15389_/C _15389_/B VDD VSS _15373_/B NOR2BX1
XFILLER_11_484 VDD VSS DECAPHV16
XFILLER_7_433 VDD VSS FILLER1
X_11535_ _18686_/Q _11542_/B VDD VSS _18713_/D AND2X1
X_14323_ _14323_/A _14323_/B _14323_/C VDD VSS _14324_/C AOI21X1
X_18091_ _19285_/Q _18094_/B VDD VSS _18095_/B XOR2X1
X_17111_ _17114_/C _17112_/B _17164_/C VDD VSS _17112_/C OAI21X1
XFILLER_109_350 VSS VDD FILLER2
X_14254_ _14270_/A _14254_/B VDD VSS _18993_/D AND2X1
X_17042_ _19760_/Q _19761_/Q _17047_/B _17042_/D VDD VSS _17045_/C OAOI211X1
XFILLER_137_670 VDD VSS FILLER1
XFILLER_143_128 VDD VSS FILLER4
XFILLER_7_488 VDD VSS DECAPHV16
X_11466_ _19958_/Q _11473_/B VDD VSS _18651_/D AND2X1
X_13205_ _18997_/Q VDD VSS _13308_/A INVX1
XFILLER_125_876 VSS VDD FILLER2
XFILLER_99_96 VDD VSS FILLER4
X_10417_ _10417_/A _10417_/B _10417_/C _10417_/D VDD VSS _10448_/A AOAI211X1
X_11397_ _11398_/C _11397_/B VDD VSS _18597_/D NOR2X1
X_14185_ _14197_/A _14185_/B VDD VSS _18937_/D AND2X1
XFILLER_124_364 VDD VSS DECAPHV8
XFILLER_140_813 VSS VDD FILLER2
XFILLER_140_835 VDD VSS FILLER4
XFILLER_3_650 VDD VSS FILLER1
X_10348_ _10385_/B _10359_/B _10579_/D VDD VSS _10500_/B MUXI2X1
X_13136_ _13141_/A _13141_/B _13141_/D _13141_/C VDD VSS _14478_/C AOI211X1
X_18993_ _18993_/CK _18993_/D _18993_/Q VDD VSS DFFQX1
XFILLER_3_694 VDD VSS FILLER4
X_10279_ _18684_/Q _18738_/Q VDD VSS _10329_/A AND2X1
X_13067_ _19079_/Q _13067_/B _13212_/C VDD VSS _13098_/B XNOR3X1
X_17944_ _17942_/B _17946_/A _17944_/C VDD VSS _19955_/D AOI2B1X1
XFILLER_66_602 VSS VDD FILLER2
X_12018_ _12018_/A _12018_/B VDD VSS _14337_/B XNOR2X1
X_17875_ _18852_/Q VDD VSS _17876_/A INVX1
XFILLER_38_359 VSS VDD FILLER2
XFILLER_65_156 VDD VSS DECAPHV8
XFILLER_66_657 VDD VSS DECAPHV8
X_19614_ _19615_/CK _19614_/D _19614_/Q VDD VSS DFFQX1
X_16826_ _16826_/A _16826_/B VDD VSS _19668_/D NOR2X1
XFILLER_0_52 VDD VSS FILLER1
XFILLER_19_573 VDD VSS FILLER1
XFILLER_65_189 VDD VSS DECAPHV8
XFILLER_93_476 VDD VSS FILLER4
X_13969_ _19006_/Q _14010_/D _13969_/C VDD VSS _14004_/C XOR3X1
X_19545_ _19711_/CK _19545_/D _19545_/Q VDD VSS DFFQX1
X_16757_ _16759_/A _16757_/B VDD VSS _19606_/D NOR2X1
XFILLER_0_85 VDD VSS FILLER1
XFILLER_46_381 VDD VSS FILLER4
XFILLER_62_852 VSS VDD FILLER2
X_15708_ _16795_/A VDD VSS _15725_/A BUFX3
X_19476_ _19489_/CK _19476_/D _19476_/Q VDD VSS DFFQX1
X_16688_ _19737_/Q _16902_/B VDD VSS _16690_/B XNOR2X1
XFILLER_61_384 VSS VDD FILLER2
X_18427_ _18438_/CK _18427_/D _18427_/Q _18464_/RB VDD VSS DFFRQX1
X_15639_ _15639_/A VDD VSS _15641_/B INVX1
X_18358_ _18359_/CK _18470_/D _20226_/A _18471_/RB VDD VSS DFFRQX1
X_18289_ _18291_/CK _18289_/D _18289_/Q VDD VSS DFFQX1
X_17309_ _17309_/A _17309_/B _17309_/C VDD VSS _17318_/A OA21X2
XFILLER_116_821 VDD VSS FILLER1
XFILLER_115_375 VSS VDD FILLER2
XFILLER_135_28 VDD VSS DECAPHV8
X_09993_ _11226_/D _09993_/B _09993_/C VDD VSS _09998_/B OA21X2
X_20182_ _20182_/A VDD VSS _20182_/Y BUFX3
XFILLER_130_356 VSS VDD FILLER2
XFILLER_130_378 VSS VDD FILLER2
XFILLER_57_602 VDD VSS FILLER4
XFILLER_69_462 VSS VDD FILLER2
XTAP_TAPCELL_ROW_59_608 VDD VSS WELLTAP
XFILLER_29_315 VDD VSS FILLER1
XFILLER_57_613 VSS VDD FILLER2
XFILLER_57_635 VSS VDD FILLER2
XFILLER_85_933 VDD VSS FILLER1
XTAP_TAPCELL_ROW_95_961 VDD VSS WELLTAP
XFILLER_38_882 VDD VSS FILLER1
XFILLER_56_167 VSS VDD FILLER2
XTAP_TAPCELL_ROW_67_685 VDD VSS WELLTAP
XFILLER_13_716 VDD VSS FILLER1
XFILLER_25_565 VDD VSS FILLER4
X_09427_ _18505_/Q _09630_/C _18506_/Q VDD VSS _09816_/B OR3BX1
XFILLER_40_546 VSS VDD FILLER2
XTAP_TAPCELL_ROW_22_232 VDD VSS WELLTAP
X_09358_ _20071_/RB _09414_/D VDD VSS _09358_/Y NOR2BX1
XFILLER_126_607 VDD VSS FILLER1
XFILLER_5_904 VDD VSS FILLER4
X_09289_ _09349_/B _20048_/Q _09289_/C VDD VSS _20046_/D AOI2B1X1
X_11320_ _11318_/B _11322_/B VDD VSS _11339_/A NAND2BX1
Xclkbuf_1_0__f_clk_regs clkbuf_0_clk_regs/Y VDD VSS clkload1/A BUFX12
XFILLER_109_40 VDD VSS FILLER1
XFILLER_125_117 VDD VSS FILLER1
XFILLER_5_948 VSS VDD FILLER2
XFILLER_107_2 VDD VSS FILLER1
X_11251_ _11253_/A _11253_/C _11253_/B _11251_/D VDD VSS _18579_/D AOI31X1
XFILLER_140_109 VDD VSS FILLER4
XFILLER_69_44 VDD VSS FILLER1
X_10202_ _18618_/Q _10202_/B _10201_/B VDD VSS _10217_/A AOI21BX1
X_11182_ _11049_/Y _11181_/Y _11298_/A VDD VSS _11182_/Y MUXI2X1
XTAP_TAPCELL_ROW_111_1128 VDD VSS WELLTAP
X_10133_ _18611_/Q _10134_/B VDD VSS _10150_/D OR2X2
XFILLER_122_879 VDD VSS FILLER4
XFILLER_88_771 VSS VDD FILLER2
XFILLER_95_708 VDD VSS FILLER1
X_15990_ _15990_/A VDD VSS _15991_/C INVX1
X_10064_ _10075_/A _10064_/B VDD VSS _11411_/C XNOR2X1
X_14941_ _19394_/Q _15773_/B VDD VSS _14942_/B XNOR2X1
XFILLER_48_679 VDD VSS FILLER1
XFILLER_75_454 VDD VSS FILLER1
X_17660_ _17663_/C _17661_/B _17746_/C VDD VSS _17661_/C OAI21X1
X_14872_ _14872_/A _14872_/B _14872_/C _14872_/D VDD VSS _14881_/A AOAI211X1
XFILLER_29_871 VDD VSS FILLER4
XFILLER_91_947 VSS VDD FILLER2
X_13823_ _18947_/Q _14197_/B VDD VSS _13990_/A AND2X1
X_17591_ _19878_/Q _19846_/Q _17591_/C VDD VSS _17596_/C AO21X2
X_16611_ _16621_/B _16611_/B VDD VSS _16864_/B XNOR2X1
XFILLER_44_841 VDD VSS FILLER4
XFILLER_63_649 VSS VDD FILLER2
X_19330_ _19358_/CK _19330_/D _19330_/Q VDD VSS DFFQX1
X_16542_ _16896_/B _19731_/Q VDD VSS _16543_/C NOR2BX1
XFILLER_16_576 VDD VSS FILLER4
XFILLER_44_874 VDD VSS FILLER1
XFILLER_90_468 VDD VSS FILLER4
XTAP_TAPCELL_ROW_122_1235 VDD VSS WELLTAP
X_10966_ _10966_/A _10966_/B _10966_/C VDD VSS _10982_/A OAI21X1
X_13754_ _13818_/A _13918_/B VDD VSS _14164_/B XNOR2X1
X_10897_ _18647_/Q _18809_/Q VDD VSS _10898_/B XNOR2X1
X_12705_ _18963_/Q _12712_/B _12705_/C VDD VSS _12708_/C XNOR3X1
X_13685_ _19000_/Q _14262_/B VDD VSS _13686_/D _14262_/C NAND3X1
X_19261_ _19999_/CK _19261_/D _19261_/Q VDD VSS DFFQX1
X_16473_ _19600_/Q _16751_/B VDD VSS _16474_/C NOR2X1
XFILLER_31_557 VDD VSS FILLER1
X_12636_ _12719_/A _14347_/B VDD VSS _12731_/A NOR2X1
X_19192_ _19194_/CK _19192_/D _19192_/Q VDD VSS DFFQX1
X_15424_ _19377_/Q _15424_/B VDD VSS _15425_/D NAND2X1
XFILLER_12_760 VDD VSS FILLER1
XTAP_TAPCELL_ROW_5_62 VDD VSS WELLTAP
X_18143_ _19294_/Q _18143_/B _18143_/C VDD VSS _18150_/A MIN3X1
X_15355_ _15355_/A _15355_/B _15878_/B VDD VSS _15396_/A AOI21X1
XFILLER_144_404 VDD VSS FILLER1
X_12567_ _12840_/B _14472_/C _19185_/Q VDD VSS _12568_/D AND3BX1
X_14306_ _14311_/A _14306_/B VDD VSS _19038_/D NOR2X1
X_11518_ _18671_/Q _11519_/B VDD VSS _18698_/D AND2X1
X_12498_ _20005_/Q _19269_/Q VDD VSS _12677_/B XOR2X1
Xwire161 wire161/A VDD VSS wire161/Y BUFX4
X_18074_ _18074_/A _18074_/B _18074_/C VDD VSS _18076_/B AO21X2
X_15286_ _19430_/Q _15814_/B VDD VSS _15287_/B XNOR2X1
XTAP_TAPCELL_ROW_133_1342 VDD VSS WELLTAP
X_11449_ _18006_/C VDD VSS _16860_/A BUFX3
X_14237_ _14270_/A _14237_/B VDD VSS _18981_/D AND2X1
X_17025_ _19758_/Q _17049_/B VDD VSS _17028_/A NAND2X1
X_14168_ _14197_/A _14168_/B VDD VSS _18921_/D AND2X1
Xclkbuf_1_1__f__09170_ clkbuf_0__09170_/Y VDD VSS _18356_/CK BUFX12
Xclkbuf_leaf_11_clk_regs clkbuf_leaf_9_clk_regs/A VDD VSS _19830_/CK BUFX12
XFILLER_124_172 VDD VSS FILLER1
XFILLER_125_695 VDD VSS FILLER1
XFILLER_98_535 VDD VSS FILLER4
XFILLER_98_546 VDD VSS FILLER1
X_09971__241 _20054_/CK VDD VSS _18518_/CK INVX1
X_13119_ _13231_/A _14385_/B VDD VSS _13219_/B NOR2X1
Xclkbuf_leaf_31__000_ clkload78/A VDD VSS _19393_/CK BUFX12
XFILLER_86_708 VSS VDD FILLER2
X_14099_ _14139_/B _14139_/C _18896_/Q VDD VSS _14101_/C AOI21X1
X_18976_ _19004_/CK _18976_/D _18976_/Q VDD VSS DFFQX1
XFILLER_38_112 VDD VSS FILLER1
XFILLER_66_410 VDD VSS DECAPHV8
XFILLER_66_421 VSS VDD FILLER2
X_17927_ _17927_/A _17927_/B _17927_/C _17927_/D VDD VSS _17941_/B OAOI211X1
X_17858_ _18850_/Q _17869_/B VDD VSS _17860_/B XNOR2X1
X_16809_ _16843_/A _16809_/B VDD VSS _19652_/D AND2X1
XFILLER_53_126 VDD VSS FILLER4
XTAP_TAPCELL_ROW_144_1460 VDD VSS WELLTAP
XTAP_TAPCELL_ROW_144_1471 VDD VSS WELLTAP
XTAP_TAPCELL_ROW_92_931 VDD VSS WELLTAP
X_17789_ _17793_/A _17790_/B _17828_/C VDD VSS _17790_/C OAI21X1
XFILLER_81_468 VSS VDD FILLER2
XTAP_TAPCELL_ROW_64_655 VDD VSS WELLTAP
X_19528_ _19543_/CK _19528_/D _19528_/Q VDD VSS DFFQX1
XTAP_TAPCELL_ROW_36_379 VDD VSS WELLTAP
X_19459_ _19461_/CK _19459_/D _19459_/Q VDD VSS DFFQX1
XFILLER_14_39 VSS VDD FILLER2
XFILLER_22_546 VDD VSS DECAPHV16
X_09212_ _18516_/Q VDD VSS _18415_/D INVX1
XFILLER_108_618 VDD VSS FILLER4
XFILLER_135_437 VSS VDD FILLER2
XFILLER_136_949 VDD VSS FILLER1
XFILLER_30_38 VDD VSS FILLER4
XFILLER_107_139 VDD VSS FILLER4
XFILLER_30_49 VDD VSS FILLER1
XFILLER_104_857 VDD VSS FILLER1
XFILLER_131_643 VDD VSS FILLER1
XFILLER_130_142 VDD VSS DECAPHV8
XFILLER_131_654 VDD VSS DECAPHV8
XFILLER_58_911 VDD VSS FILLER1
X_20165_ _20165_/A VDD VSS _20165_/Y BUFX3
XFILLER_112_890 VDD VSS FILLER4
XFILLER_76_229 VSS VDD FILLER2
X_20096_ _20096_/A VDD VSS _20096_/Y BUFX3
XFILLER_130_197 VDD VSS FILLER4
XFILLER_85_741 VSS VDD FILLER2
XFILLER_55_46 VDD VSS FILLER4
XFILLER_57_498 VDD VSS FILLER1
XFILLER_72_446 VDD VSS FILLER1
XFILLER_84_295 VDD VSS DECAPHV8
XFILLER_53_660 VSS VDD FILLER2
XFILLER_55_79 VDD VSS FILLER4
XFILLER_72_457 VDD VSS DECAPHV16
X_10820_ _19952_/Q _18834_/Q VDD VSS _10856_/D NOR2X1
X_10751_ _10790_/A _10751_/B VDD VSS _10772_/B XNOR2X1
XFILLER_111_96 VDD VSS DECAPHV16
XFILLER_40_332 VSS VDD FILLER2
XFILLER_41_855 VDD VSS FILLER1
XFILLER_52_192 VSS VDD FILLER2
XFILLER_9_517 VDD VSS FILLER4
X_13470_ _19139_/Q _13470_/B _13617_/D VDD VSS _13614_/C XNOR3X1
XFILLER_139_721 VDD VSS DECAPHV8
XFILLER_139_743 VDD VSS FILLER1
XFILLER_71_78 VDD VSS FILLER1
XFILLER_9_528 VSS VDD FILLER2
X_10682_ _19948_/Q _18830_/Q VDD VSS _10722_/B NOR2X1
X_12421_ _12421_/A _14344_/B VDD VSS _12461_/A NOR2X1
XFILLER_127_905 VDD VSS FILLER1
XFILLER_127_949 VDD VSS FILLER1
XFILLER_139_798 VDD VSS DECAPHV8
X_12352_ _18875_/Q _12352_/B _12352_/C VDD VSS _12528_/B MIN3X1
X_15140_ _15183_/A _15183_/B VDD VSS _15874_/B XOR2X1
X_11303_ _11312_/B _11312_/C VDD VSS _11304_/B NOR2BX1
X_12283_ _12283_/A _12283_/B _12449_/C VDD VSS _14309_/B XNOR3X1
X_15071_ _15082_/A _15071_/B VDD VSS _15083_/B XNOR2X1
X_11234_ _11364_/A _11317_/B VDD VSS _11235_/C NOR2X1
X_14022_ _18894_/Q _14137_/B VDD VSS _14098_/C _14137_/C AND3X2
XFILLER_106_161 VSS VDD FILLER2
XFILLER_122_632 VSS VDD FILLER2
XFILLER_122_643 VSS VDD FILLER2
XFILLER_20_82 VDD VSS FILLER1
XFILLER_20_93 VDD VSS DECAPHV16
XFILLER_49_900 VDD VSS DECAPHV8
X_11165_ _18708_/Q _18762_/Q VDD VSS _11167_/C NAND2X1
X_18830_ _19947_/CK _18830_/D _18830_/Q VDD VSS DFFQX1
X_10116_ _10091_/Y _10145_/B _10155_/A VDD VSS _10167_/B MUXI2X1
X_11096_ _11142_/C _11096_/B _11096_/C VDD VSS _11096_/Y OAI21X1
X_18761_ _18785_/CK _18761_/D _18761_/Q VDD VSS DFFQX1
X_15973_ _15989_/A _15989_/B VDD VSS _16837_/B XNOR2X1
XFILLER_48_421 VDD VSS FILLER4
XFILLER_48_443 VDD VSS FILLER1
XFILLER_76_730 VDD VSS FILLER1
XFILLER_88_590 VDD VSS DECAPHV8
X_10047_ _11208_/A _10047_/B VDD VSS _10048_/C NAND2X1
X_17712_ _17712_/A _17712_/B _17712_/C VDD VSS _17716_/C MIN3X1
X_14924_ _15899_/B VDD VSS _14925_/B INVX1
XFILLER_29_91 VSS VDD FILLER2
XFILLER_64_925 VSS VDD FILLER2
X_18692_ _18801_/CK _18692_/D _18692_/Q VDD VSS DFFQX1
X_17643_ _17646_/A _17643_/B _17643_/C VDD VSS _19889_/D AOI21X1
X_14855_ _19336_/Q _15709_/B _14855_/C VDD VSS _14901_/B MIN3X1
XFILLER_63_468 VDD VSS FILLER4
X_11998_ _19178_/Q _12113_/A _12032_/B VDD VSS _12029_/D XNOR3X1
X_13806_ _18918_/Q _14164_/B VDD VSS _13876_/A NAND2X1
X_17574_ _17577_/C _17575_/B _17597_/C VDD VSS _17575_/C OAI21X1
X_14786_ _14826_/A _14826_/B VDD VSS _14792_/B NOR2X1
XFILLER_17_896 VDD VSS FILLER1
XFILLER_32_811 VSS VDD FILLER2
XTAP_TAPCELL_ROW_61_625 VDD VSS WELLTAP
X_10949_ _10808_/Y _10948_/Y _11118_/A VDD VSS _11213_/B MUX2X1
X_13737_ _19002_/Q _13843_/A _13889_/B VDD VSS _13830_/D XNOR3X1
X_19313_ _19337_/CK _19313_/D _19313_/Q VDD VSS DFFQX1
X_16525_ _16525_/A _16525_/B VDD VSS _16526_/C NAND2X1
XTAP_TAPCELL_ROW_33_349 VDD VSS WELLTAP
X_19244_ _20006_/CK _19244_/D _19244_/Q VDD VSS DFFQX1
X_16456_ _16472_/B _16456_/B VDD VSS _16822_/B XOR2X1
XFILLER_31_365 VDD VSS FILLER4
X_13668_ _13751_/A _13807_/B VDD VSS _14130_/B XNOR2X1
X_15407_ _15430_/B _15407_/B VDD VSS _15818_/B XNOR2X1
XFILLER_129_231 VDD VSS DECAPHV8
X_12619_ _18962_/Q _12619_/B _14213_/B VDD VSS _12712_/B MIN3X1
X_13599_ _13599_/A _13599_/B _13599_/C VDD VSS _13607_/B XNOR3X1
X_19175_ _19202_/CK _19175_/D _19175_/Q VDD VSS DFFQX1
X_16387_ _19693_/Q _16854_/B VDD VSS _16388_/D NAND2BX1
X_18126_ _18126_/A _18126_/B VDD VSS _18127_/C NAND2X1
X_15338_ _15338_/A _15340_/C VDD VSS _18128_/B XNOR2X1
XFILLER_144_223 VSS VDD FILLER2
X_18057_ _18549_/Q _18550_/Q _18057_/C _18163_/A VDD VSS _18057_/Y AOI31X1
X_15269_ _19512_/Q _15276_/B VDD VSS _15274_/C AND2X1
XFILLER_133_919 VDD VSS FILLER1
X_17008_ _17019_/A _17019_/B _17009_/B VDD VSS _17010_/B NOR3X1
XFILLER_99_844 VSS VDD FILLER2
XFILLER_112_131 VDD VSS FILLER4
X_09830_ _10313_/B VDD VSS _09928_/C BUFX3
XFILLER_112_186 VSS VDD FILLER2
XFILLER_58_229 VSS VDD FILLER2
XTAP_TAPCELL_ROW_69_703 VDD VSS WELLTAP
X_09761_ _09761_/A _09761_/B VDD VSS _18291_/D NAND2X1
Xclkbuf_0__09184_ _18233_/ECK VDD VSS clkbuf_0__09184_/Y BUFX12
X_18959_ _18993_/CK _18959_/D _18959_/Q VDD VSS DFFQX1
XFILLER_39_432 VSS VDD FILLER2
XFILLER_67_741 VSS VDD FILLER2
XFILLER_82_700 VDD VSS FILLER4
X_09692_ _09819_/A _09692_/B VDD VSS _09693_/E NOR2X1
XFILLER_26_137 VSS VDD FILLER2
XFILLER_81_210 VDD VSS DECAPHV8
XFILLER_81_254 VDD VSS DECAPHV8
XFILLER_41_107 VDD VSS FILLER1
XFILLER_22_321 VDD VSS FILLER4
XFILLER_50_674 VSS VDD FILLER2
XFILLER_50_696 VDD VSS FILLER1
XFILLER_109_927 VSS VDD FILLER2
XFILLER_109_949 VDD VSS FILLER1
XFILLER_135_234 VSS VDD FILLER2
XFILLER_1_203 VSS VDD FILLER2
X_20217_ _20217_/A VDD VSS _20217_/Y BUFX3
XFILLER_131_462 VSS VDD FILLER2
XFILLER_77_516 VSS VDD FILLER2
X_20148_ _20148_/A VDD VSS _20148_/Y BUFX3
XFILLER_100_882 VDD VSS FILLER1
XFILLER_73_700 VDD VSS FILLER1
XFILLER_92_519 VDD VSS DECAPHV8
X_12970_ _13135_/A _13133_/C _12970_/C VDD VSS _13042_/B XNOR3X1
X_20079_ _20079_/CK _20079_/D _20079_/Q _20079_/RB VDD VSS DFFRQX1
X_11921_ _19176_/Q _14462_/B _14462_/C VDD VSS _11922_/D OR3BX1
X_11852_ _11852_/A _11852_/B _14459_/B VDD VSS _11916_/A MIN3X1
X_14640_ _19442_/Q _14640_/B _14640_/C VDD VSS _14701_/B MIN3X1
XFILLER_14_811 VDD VSS FILLER1
XFILLER_60_416 VSS VDD FILLER2
XFILLER_72_276 VDD VSS FILLER1
XFILLER_82_66 VSS VDD FILLER2
X_10803_ _10803_/A _10803_/B _10866_/B _10803_/D VDD VSS _10804_/E AO31X2
X_14571_ _20009_/Q _16702_/B VDD VSS _19273_/D AND2X1
X_11783_ _11851_/A _11851_/B VDD VSS _11794_/C XOR2X1
X_13522_ _13604_/A _13604_/B _13599_/C VDD VSS _14294_/B AOI21BX1
Xclkbuf_1_0__f__09173_ clkbuf_0__09173_/Y VDD VSS _18311_/CK BUFX12
X_16310_ _19594_/Q _16744_/B VDD VSS _16311_/C NOR2X1
XTAP_TAPCELL_ROW_30_319 VDD VSS WELLTAP
X_10734_ _10947_/A _10734_/B VDD VSS _10735_/D NOR2X1
Xclkbuf_leaf_30__001_ clkbuf_2_1__f__001_/Y VDD VSS _19037_/CK BUFX12
X_17290_ _17291_/C _17469_/B _17290_/C VDD VSS _19814_/D AND3BX1
XFILLER_139_540 VDD VSS FILLER4
XFILLER_9_336 VDD VSS FILLER1
X_10665_ _18560_/Q _10665_/B VDD VSS _10666_/C NOR2X1
X_13453_ _13617_/A _13617_/B _13617_/C VDD VSS _13470_/B AOI21X1
X_16241_ _16255_/B _16241_/B VDD VSS _16814_/B XNOR2X1
XFILLER_127_713 VDD VSS FILLER4
X_12404_ _19239_/Q _12499_/A _12499_/B VDD VSS _12405_/D XNOR3X1
X_13384_ _18887_/Q VDD VSS _13497_/A INVX1
X_16172_ _16174_/B _16173_/B _18168_/C VDD VSS _16173_/C OAI21X1
X_10596_ _10596_/A _10596_/B VDD VSS _10630_/A NAND2X1
X_12335_ _19071_/Q _12457_/A _12544_/B VDD VSS _12366_/D XNOR3X1
X_15123_ _15134_/A _15123_/B VDD VSS _15716_/B XNOR2X1
XFILLER_56_8 VSS VDD FILLER2
XFILLER_99_107 VSS VDD FILLER2
XFILLER_107_470 VDD VSS FILLER1
XFILLER_114_429 VDD VSS FILLER4
XFILLER_5_575 VDD VSS FILLER1
XFILLER_5_597 VDD VSS DECAPHV8
XTAP_TAPCELL_ROW_117_1189 VDD VSS WELLTAP
XTAP_TAPCELL_ROW_130_1312 VDD VSS WELLTAP
X_12266_ _18930_/Q _12341_/B _14178_/B VDD VSS _14146_/B XNOR3X1
X_19931_ clkload3/A _19931_/D _19931_/Q VDD VSS DFFQX1
X_15054_ _15054_/A _15054_/B _15054_/C _15054_/D VDD VSS _15112_/A OAOI211X1
XFILLER_68_505 VDD VSS FILLER1
XFILLER_96_803 VDD VSS DECAPHV8
X_11217_ _11217_/A _11217_/B _11217_/C VDD VSS _11220_/C OA21X2
X_12197_ _12197_/A _12197_/B _14145_/B VDD VSS _12348_/B MIN3X1
X_14005_ _18978_/Q _14233_/B VDD VSS _14045_/E _14233_/C AND3X2
X_19862_ clkload8/A _19862_/D _19862_/Q VDD VSS DFFQX1
Xoutput70 _20136_/Y VDD VSS o_clk_cfg[3] BUFX3
XFILLER_96_836 VDD VSS FILLER1
XFILLER_96_847 VDD VSS DECAPHV8
X_11148_ _11167_/A _11167_/B _11148_/C VDD VSS _11149_/C OAI21X1
Xoutput81 _20155_/Y VDD VSS o_en_ctrl[3] BUFX3
Xoutput92 _20176_/Y VDD VSS o_lf_cfg[13] BUFX3
X_18813_ _19958_/CK _18813_/D _18813_/Q VDD VSS DFFQX1
XFILLER_95_335 VSS VDD FILLER2
X_19793_ _19795_/CK _19793_/D _19793_/Q VDD VSS DFFQX1
XFILLER_110_679 VDD VSS FILLER4
XFILLER_37_903 VDD VSS FILLER4
XFILLER_49_785 VSS VDD FILLER2
XFILLER_64_700 VDD VSS DECAPHV16
X_11079_ _11047_/Y _11115_/B _10984_/A VDD VSS _11079_/Y MUX2X1
X_18744_ _18773_/CK _18744_/D _18744_/Q VDD VSS DFFQX1
X_15956_ _19644_/Q _16801_/B _15956_/C VDD VSS _15975_/A OAI21X1
XFILLER_64_722 VDD VSS FILLER1
XFILLER_64_744 VDD VSS FILLER1
XFILLER_76_582 VDD VSS DECAPHV16
X_18675_ _18811_/CK _18675_/D _18675_/Q VDD VSS DFFQX1
X_15887_ _11641_/B _15887_/B _15887_/C VDD VSS _19494_/D AND3BX1
X_14907_ _19448_/Q _15833_/B _15833_/C VDD VSS _14908_/D OR3BX1
XFILLER_36_468 VDD VSS DECAPHV8
XTAP_TAPCELL_ROW_128_1296 VDD VSS WELLTAP
X_17626_ _17627_/A _17629_/C _17654_/C VDD VSS _17627_/C OAI21X1
X_14838_ _14839_/B _14839_/C _19446_/Q VDD VSS _14840_/B AOI21X1
XFILLER_23_118 VDD VSS DECAPHV8
XFILLER_64_799 VSS VDD FILLER2
XTAP_TAPCELL_ROW_141_1430 VDD VSS WELLTAP
XTAP_TAPCELL_ROW_46_474 VDD VSS WELLTAP
XFILLER_17_693 VSS VDD FILLER2
XTAP_TAPCELL_ROW_18_198 VDD VSS WELLTAP
X_17557_ _19871_/Q _19839_/Q _17557_/C VDD VSS _17562_/C AOI21X1
X_14769_ _19306_/Q _14769_/B _15674_/B VDD VSS _14809_/A MIN3X1
X_17488_ _17488_/A _17488_/B _17488_/C VDD VSS _17496_/A OA21X2
X_16508_ _19698_/Q _16859_/B VDD VSS _16517_/B XNOR2X1
XFILLER_32_696 VDD VSS FILLER1
X_19227_ _19992_/CK _19227_/D _19227_/Q VDD VSS DFFQX1
X_16439_ _19727_/Q _16891_/B VDD VSS _16441_/B XNOR2X1
X_19158_ _19182_/CK _19158_/D _19158_/Q VDD VSS DFFQX1
XFILLER_117_234 VSS VDD FILLER2
X_18109_ _18105_/A _18109_/B _18109_/C VDD VSS _18112_/B AOI2B1X1
XFILLER_105_407 VDD VSS FILLER4
XFILLER_118_779 VDD VSS FILLER4
XFILLER_127_18 VDD VSS DECAPHV32
X_19089_ _19121_/CK _19089_/D _19089_/Q VDD VSS DFFQX1
XFILLER_132_204 VDD VSS DECAPHV8
XFILLER_101_602 VDD VSS FILLER1
XFILLER_101_624 VSS VDD FILLER2
XFILLER_113_451 VDD VSS FILLER4
X_09813_ _18471_/Q _09813_/B _09813_/C _20148_/A VDD VSS _09817_/C AOI22X1
X_20002_ _20005_/CK _20002_/D _20002_/Q VDD VSS DFFQX1
XFILLER_140_270 VSS VDD FILLER2
XFILLER_59_549 VSS VDD FILLER2
X_09744_ _09744_/A _09744_/B _09791_/A VDD VSS _09745_/D OAI21X1
Xclkbuf_0__09167_ _18216_/ECK VDD VSS clkbuf_0__09167_/Y BUFX12
XFILLER_28_947 VSS VDD FILLER2
XFILLER_36_26 VDD VSS DECAPHV8
XFILLER_54_221 VDD VSS FILLER4
X_09675_ _18350_/Q _09772_/B _09675_/C _09776_/A VDD VSS _09681_/A OAI211X1
XFILLER_27_468 VSS VDD FILLER2
XFILLER_82_596 VDD VSS DECAPHV8
XFILLER_35_490 VSS VDD FILLER2
XFILLER_70_747 VDD VSS FILLER4
XFILLER_50_460 VDD VSS FILLER4
XFILLER_50_493 VDD VSS DECAPHV16
XFILLER_109_724 VDD VSS FILLER4
XFILLER_136_510 VDD VSS FILLER1
X_10450_ _18661_/Q _18769_/Q VDD VSS _10454_/D AND2X1
X_10381_ _18659_/Q _18767_/Q _10381_/C _10381_/D VDD VSS _10383_/C AOAI211X1
XFILLER_124_727 VDD VSS FILLER1
X_12120_ _19068_/Q _12210_/A _12447_/B VDD VSS _12286_/B XNOR3X1
XFILLER_123_248 VSS VDD FILLER2
XFILLER_2_545 VDD VSS FILLER1
X_12051_ _19234_/Q _14528_/A _14528_/B VDD VSS _12053_/C NOR3X1
XFILLER_120_900 VSS VDD FILLER2
XFILLER_132_771 VSS VDD FILLER2
XFILLER_132_793 VDD VSS FILLER4
X_11002_ _11043_/B _11002_/B VDD VSS _11013_/B XOR2X1
XFILLER_104_495 VDD VSS FILLER4
XFILLER_131_292 VDD VSS FILLER1
XFILLER_77_88 VDD VSS FILLER1
XFILLER_89_184 VSS VDD FILLER2
XFILLER_46_700 VDD VSS DECAPHV16
X_16790_ _16793_/A _16790_/B VDD VSS _19636_/D AND2X1
X_15810_ _15816_/A _15810_/B VDD VSS _19426_/D NOR2X1
XFILLER_133_83 VDD VSS FILLER1
XTAP_TAPCELL_ROW_88_897 VDD VSS WELLTAP
X_12953_ _12953_/A _14475_/B _13032_/C _12953_/D VDD VSS _13131_/A OAOI211X1
X_15741_ _15817_/A VDD VSS _15758_/A BUFX3
XFILLER_18_468 VSS VDD FILLER2
X_11904_ _19008_/Q _14270_/B VDD VSS _11950_/B NOR2X1
X_18460_ _18471_/CK _18513_/Q _18460_/Q _18471_/RB VDD VSS DFFRQX1
X_15672_ _15672_/A _18194_/A VDD VSS _19304_/D NOR2X1
XFILLER_46_788 VSS VDD FILLER2
XFILLER_73_574 VSS VDD FILLER2
X_12884_ _12884_/A _12884_/B _14121_/B VDD VSS _12885_/B MIN3X1
X_14623_ _14644_/A _15889_/B VDD VSS _14624_/D NOR2X1
X_17411_ _17413_/C _17411_/B _17411_/C VDD VSS _19840_/D AOI21X1
XFILLER_26_490 VSS VDD FILLER2
XFILLER_60_235 VDD VSS FILLER1
XFILLER_61_747 VDD VSS FILLER1
X_11835_ _11835_/A _11835_/B _11835_/C _11835_/D VDD VSS _11839_/A OAOI211X1
X_18391_ _18391_/CK _18471_/D _20196_/A _20065_/RB VDD VSS DFFRQX1
XFILLER_41_460 VDD VSS FILLER4
XTAP_TAPCELL_ROW_15_168 VDD VSS WELLTAP
XTAP_TAPCELL_ROW_43_444 VDD VSS WELLTAP
X_11766_ _19226_/Q _14519_/B VDD VSS _11768_/C _14519_/C AND3X2
X_14554_ _19994_/Q _14558_/B VDD VSS _19258_/D AND2X1
X_17342_ _17346_/A _17343_/B _17363_/C VDD VSS _17343_/C OAI21X1
XFILLER_13_184 VSS VDD FILLER2
X_10717_ _10803_/A _10717_/B _10717_/C _10717_/D VDD VSS _10747_/A AOI31X1
X_13505_ _13516_/A _13516_/B _13516_/C VDD VSS _14193_/B AOI21X1
X_14485_ _14493_/A _14485_/B VDD VSS _19198_/D NOR2X1
X_17273_ _19811_/Q _19779_/Q VDD VSS _17275_/B XOR2X1
XFILLER_42_80 VDD VSS FILLER4
XTAP_TAPCELL_ROW_119_1207 VDD VSS WELLTAP
X_11697_ _19225_/Q _11737_/B _11700_/C VDD VSS _14484_/B XNOR3X1
X_13436_ _13436_/A _14388_/B _14388_/C VDD VSS _13437_/D NOR3X1
X_19012_ _19040_/CK _19012_/D _19012_/Q VDD VSS DFFQX1
X_16224_ _19719_/Q _16883_/B VDD VSS _16225_/A NAND2BX1
X_10648_ _18693_/Q _18747_/Q VDD VSS _10649_/D NAND2X1
XFILLER_115_716 VSS VDD FILLER2
XFILLER_6_862 VDD VSS FILLER1
X_10579_ _10579_/A _10579_/B _10579_/C _10579_/D VDD VSS _10656_/C AOI31X1
X_13367_ _14355_/A _14355_/B _19081_/Q VDD VSS _13422_/D AOI21X1
X_16155_ _19620_/Q _16155_/B _16773_/B VDD VSS _16179_/B MIN3X1
X_12318_ _20002_/Q _19266_/Q VDD VSS _12407_/C NAND2X1
X_13298_ _13393_/A _13393_/B VDD VSS _13378_/B NOR2X1
X_16086_ _19554_/Q _19906_/Q VDD VSS _16089_/A XNOR2X1
X_15106_ _15191_/D _15155_/A VDD VSS _15191_/A NAND2X1
XFILLER_47_4 VDD VSS FILLER4
X_12249_ _19125_/Q _14404_/B VDD VSS _12298_/D _14404_/C NAND3X1
X_19914_ _19928_/CK _19914_/D _19914_/Q VDD VSS DFFQX1
X_15037_ _19340_/Q _15037_/B _15714_/B VDD VSS _15126_/B MIN3X1
XFILLER_111_922 VSS VDD FILLER2
XFILLER_69_836 VDD VSS FILLER1
XFILLER_110_421 VSS VDD FILLER2
XFILLER_68_335 VSS VDD FILLER2
X_19845_ _19863_/CK _19845_/D _19845_/Q VDD VSS DFFQX1
XFILLER_110_443 VDD VSS DECAPHV16
XFILLER_37_700 VDD VSS FILLER1
XFILLER_96_677 VSS VDD FILLER2
X_19776_ clkload2/A _19776_/D _19776_/Q VDD VSS DFFQX1
X_16988_ _16994_/A _16991_/C _16988_/C VDD VSS _19752_/D AOI21X1
X_18727_ _18782_/CK _18727_/D _18727_/Q VDD VSS DFFQX1
X_15939_ _15939_/A _15939_/B VDD VSS _15940_/C NAND2X1
XFILLER_64_552 VDD VSS FILLER1
X_09460_ _18444_/D _09468_/B _09460_/C VDD VSS _18253_/D AOI21X1
XFILLER_36_265 VDD VSS FILLER1
XFILLER_51_202 VDD VSS FILLER4
XFILLER_91_371 VDD VSS FILLER1
XFILLER_92_872 VDD VSS FILLER1
XFILLER_92_894 VDD VSS FILLER4
X_18658_ _18820_/CK _18658_/D _18658_/Q VDD VSS DFFQX1
X_09391_ _19936_/Q _09405_/B VDD VSS _11429_/B NOR2BX2
X_18589_ _18595_/CK _18589_/D _18589_/Q VDD VSS DFFQX1
X_17609_ _19882_/Q _19850_/Q VDD VSS _17610_/C NAND2X1
XFILLER_22_28 VDD VSS FILLER4
XFILLER_114_782 VDD VSS FILLER1
XFILLER_120_218 VDD VSS FILLER1
XFILLER_114_793 VDD VSS DECAPHV8
XFILLER_99_482 VDD VSS FILLER4
XFILLER_74_305 VDD VSS FILLER4
XFILLER_87_666 VDD VSS FILLER1
Xfanout178 _18626_/Q VDD VSS _11435_/A BUFX3
XFILLER_28_711 VDD VSS FILLER1
XFILLER_28_733 VDD VSS FILLER1
X_09727_ _18305_/Q _09812_/B _09797_/C _20206_/A VDD VSS _09729_/B AOI22X1
XFILLER_28_777 VDD VSS FILLER4
XFILLER_55_530 VDD VSS DECAPHV8
XTAP_TAPCELL_ROW_85_867 VDD VSS WELLTAP
XFILLER_42_202 VSS VDD FILLER2
X_09658_ _18445_/Q _09751_/B _09696_/B _18413_/Q _09658_/E VDD VSS _09659_/C OAI221X1
XFILLER_43_758 VDD VSS FILLER1
X_09589_ _18297_/Q _09812_/B _09769_/C _20083_/A VDD VSS _09593_/C AOI22X1
XFILLER_63_68 VDD VSS FILLER1
X_11620_ _18763_/Q _11624_/B VDD VSS _18790_/D AND2X1
XFILLER_129_808 VDD VSS DECAPHV8
XTAP_TAPCELL_ROW_40_414 VDD VSS WELLTAP
X_11551_ _18700_/Q _11555_/B VDD VSS _18727_/D AND2X1
XFILLER_50_290 VDD VSS FILLER4
XTAP_TAPCELL_ROW_12_138 VDD VSS WELLTAP
X_10502_ _10625_/A _10502_/B VDD VSS _10548_/A AND2X1
XFILLER_109_532 VSS VDD FILLER2
XFILLER_6_103 VDD VSS FILLER1
XFILLER_7_648 VSS VDD FILLER2
X_11482_ _18638_/Q _11484_/B VDD VSS _18665_/D AND2X1
X_14270_ _14270_/A _14270_/B VDD VSS _19008_/D AND2X1
XFILLER_109_554 VDD VSS FILLER4
X_10433_ _10503_/A _10433_/B VDD VSS _10434_/B XNOR2X1
X_13221_ _19135_/Q _14415_/B VDD VSS _13319_/A NAND2X1
XFILLER_128_61 VDD VSS FILLER1
XFILLER_3_810 VDD VSS FILLER1
X_10364_ _18686_/Q _18740_/Q VDD VSS _10413_/A NAND2X1
X_13152_ _19247_/Q _13152_/B VDD VSS _13240_/C _13152_/C NAND3X1
XFILLER_128_83 VDD VSS DECAPHV8
XTAP_TAPCELL_ROW_114_1159 VDD VSS WELLTAP
X_12103_ _12108_/A _12108_/C _12108_/B VDD VSS _14529_/C OR3X2
XFILLER_111_207 VDD VSS FILLER4
XFILLER_111_218 VSS VDD FILLER2
XFILLER_88_65 VSS VDD FILLER2
XFILLER_88_87 VDD VSS FILLER1
X_10295_ _10283_/Y _10295_/B _10295_/C VDD VSS _10385_/B OR3BX1
X_13083_ _13083_/A _13083_/B VDD VSS _13086_/C XNOR2X1
X_17960_ _18868_/Q _17960_/B _17960_/C VDD VSS _17966_/B XOR3X1
XFILLER_78_644 VSS VDD FILLER2
X_12034_ _12034_/A _14462_/B _14462_/C VDD VSS _12035_/D NOR3X1
X_17891_ _18855_/Q _17891_/B _17891_/C VDD VSS _17894_/C MIN3X1
X_16911_ _20068_/D _20069_/Q VDD VSS _16912_/C NAND2X1
XFILLER_144_93 VDD VSS DECAPHV16
XFILLER_65_305 VSS VDD FILLER2
XFILLER_66_828 VSS VDD FILLER2
X_19630_ _19636_/CK _19630_/D _19630_/Q VDD VSS DFFQX1
X_16842_ _16865_/A _16842_/B VDD VSS _19682_/D NOR2X1
XFILLER_92_113 VSS VDD FILLER2
X_19561_ _19606_/CK _19561_/D _19561_/Q VDD VSS DFFQX1
XFILLER_18_243 VDD VSS FILLER1
XFILLER_46_530 VDD VSS DECAPHV8
X_13985_ _14137_/B _14137_/C _18894_/Q VDD VSS _14018_/B AOI21X1
X_18512_ _18512_/CK _18512_/D _18512_/Q _09340_/Y VDD VSS DFFRQX1
X_16773_ _16775_/A _16773_/B VDD VSS _19620_/D NOR2X1
XFILLER_18_276 VSS VDD FILLER2
X_12936_ _12936_/A _14444_/B _14444_/C VDD VSS _13107_/C NOR3X1
X_19492_ _19492_/CK _19492_/D _19492_/Q VDD VSS DFFQX1
X_15724_ _15739_/A _15724_/B VDD VSS _19350_/D NOR2X1
XFILLER_18_298 VDD VSS DECAPHV8
XTAP_TAPCELL_ROW_125_1266 VDD VSS WELLTAP
XTAP_TAPCELL_ROW_56_580 VDD VSS WELLTAP
XTAP_TAPCELL_ROW_8_95 VDD VSS WELLTAP
X_12867_ _12868_/D _14318_/B VDD VSS _13005_/A NAND2X1
X_18443_ _18453_/CK _18443_/D _18443_/Q _18453_/RB VDD VSS DFFRQX1
X_15655_ _15655_/A _15763_/B _15655_/C VDD VSS _15733_/B OAI21X1
XFILLER_61_588 VSS VDD FILLER2
XTAP_TAPCELL_ROW_28_293 VDD VSS WELLTAP
X_11818_ _19145_/Q _11818_/B _14427_/B VDD VSS _14396_/B XNOR3X1
X_14606_ _14644_/A _15889_/B VDD VSS _14645_/C XNOR2X1
X_18374_ _18375_/CK _18470_/D _20211_/A _18465_/RB VDD VSS DFFRQX1
X_15586_ _15592_/A _15592_/B VDD VSS _15698_/B XNOR2X1
X_12798_ _12868_/A _12868_/B _12799_/D _12868_/E VDD VSS _14286_/B OA211X2
X_14537_ _15806_/A _14537_/B _14537_/C VDD VSS _19243_/D NOR3X1
X_17325_ _19821_/Q _19789_/Q _17325_/C VDD VSS _17329_/C MIN3X1
X_11749_ _19228_/Q _11749_/B _11769_/D VDD VSS _11835_/C XNOR3X1
X_14468_ _14490_/A _14468_/B _14468_/C VDD VSS _19182_/D NOR3X1
X_17256_ _17390_/A _17256_/B VDD VSS _19807_/D NOR2X1
XFILLER_127_351 VDD VSS FILLER4
XFILLER_143_800 VDD VSS DECAPHV8
X_13419_ _19054_/Q _13531_/A _13531_/B VDD VSS _13420_/D XNOR3X1
X_14399_ _14426_/A _14399_/B VDD VSS _19120_/D NOR2X1
X_17187_ _17189_/A _17189_/B _17187_/C VDD VSS _19792_/D AOI21X1
X_16207_ _19910_/Q VDD VSS _16704_/A INVX1
XFILLER_52_2 VDD VSS FILLER1
XTAP_TAPCELL_ROW_136_1373 VDD VSS WELLTAP
X_16138_ _16138_/A _16159_/C VDD VSS _16738_/B XNOR2X1
XFILLER_115_557 VDD VSS FILLER1
X_16069_ _19649_/Q _16806_/B VDD VSS _16070_/B XNOR2X1
XFILLER_111_730 VDD VSS FILLER1
XFILLER_38_0 VSS VDD FILLER2
XFILLER_111_774 VSS VDD FILLER2
XFILLER_29_508 VSS VDD FILLER2
X_19828_ _19828_/CK _19828_/D _19828_/Q VDD VSS DFFQX1
XFILLER_84_625 VDD VSS FILLER1
XFILLER_96_496 VDD VSS FILLER4
X_09512_ _20021_/Q _20022_/Q VDD VSS _09527_/B _09526_/B AND3X2
X_19759_ _19795_/CK _19759_/D _19759_/Q VDD VSS DFFQX1
XFILLER_25_714 VDD VSS FILLER4
XFILLER_65_872 VDD VSS FILLER1
XFILLER_24_235 VDD VSS FILLER4
XFILLER_25_747 VDD VSS DECAPHV8
XFILLER_80_831 VSS VDD FILLER2
XTAP_TAPCELL_ROW_82_837 VDD VSS WELLTAP
X_09443_ _18506_/Q _18505_/Q VDD VSS _09578_/B NAND2X1
XFILLER_80_886 VDD VSS DECAPHV8
X_09374_ _20054_/Q output5/A _18386_/Q VDD VSS _09496_/B MUX2X1
XFILLER_138_627 VSS VDD FILLER2
XFILLER_138_649 VDD VSS DECAPHV8
XFILLER_20_496 VDD VSS DECAPHV8
XFILLER_4_607 VDD VSS FILLER1
XFILLER_118_395 VDD VSS FILLER1
XFILLER_134_844 VDD VSS FILLER4
XFILLER_134_855 VDD VSS FILLER1
XFILLER_121_505 VDD VSS FILLER1
XFILLER_0_835 VDD VSS DECAPHV8
XFILLER_133_398 VDD VSS DECAPHV8
XFILLER_58_35 VDD VSS FILLER1
XFILLER_87_430 VDD VSS FILLER1
X_10080_ _18585_/Q _10089_/B VDD VSS _10080_/Y XOR2X1
XFILLER_102_752 VSS VDD FILLER2
XFILLER_102_763 VDD VSS FILLER1
XFILLER_102_774 VDD VSS FILLER1
XFILLER_59_132 VDD VSS FILLER1
XFILLER_47_316 VDD VSS FILLER4
XFILLER_48_839 VSS VDD FILLER2
XFILLER_75_625 VDD VSS FILLER1
XTAP_TAPCELL_ROW_98_992 VDD VSS WELLTAP
XFILLER_28_530 VDD VSS DECAPHV8
XFILLER_16_725 VSS VDD FILLER2
XFILLER_55_360 VDD VSS FILLER1
XFILLER_74_168 VDD VSS FILLER1
XFILLER_74_45 VDD VSS FILLER1
X_10982_ _10982_/A _10982_/B _10982_/C VDD VSS _10983_/B NOR3X1
X_13770_ _13770_/A _14229_/B _14229_/C VDD VSS _13771_/D NOR3X1
XFILLER_15_235 VDD VSS FILLER1
XFILLER_16_758 VDD VSS FILLER1
XFILLER_43_533 VDD VSS DECAPHV8
X_12721_ _19047_/Q _14317_/B VDD VSS _12868_/E _14317_/C NAND3X1
XFILLER_15_268 VDD VSS FILLER4
XFILLER_43_555 VSS VDD FILLER2
XFILLER_70_352 VSS VDD FILLER2
XTAP_TAPCELL_ROW_53_550 VDD VSS WELLTAP
X_12652_ _14440_/A _14440_/B _14440_/C VDD VSS _12654_/B OAI21X1
X_15440_ _19516_/Q _15440_/B _15440_/C VDD VSS _15474_/B MIN3X1
XFILLER_142_0 VDD VSS DECAPHV32
XFILLER_90_22 VDD VSS FILLER1
XTAP_TAPCELL_ROW_25_263 VDD VSS WELLTAP
X_11603_ _18747_/Q _11612_/B VDD VSS _18774_/D AND2X1
X_12583_ _12583_/A _12583_/B _12677_/B _12583_/D VDD VSS _12666_/A OAOI211X1
X_15371_ _19404_/Q _15785_/B VDD VSS _15389_/B NOR2X1
XFILLER_129_649 VSS VDD FILLER2
XFILLER_8_935 VSS VDD FILLER2
X_11534_ _18685_/Q _11542_/B VDD VSS _18712_/D AND2X1
X_14322_ _14316_/Y _14323_/B _14322_/C VDD VSS _19052_/D AND3BX1
X_18090_ _18090_/A _18090_/B _18090_/C _18090_/D VDD VSS _18095_/A AOAI211X1
X_17110_ _17172_/A VDD VSS _17164_/C BUFX3
X_11465_ _19957_/Q _11473_/B VDD VSS _18650_/D AND2X1
X_14253_ _14285_/A _14253_/B VDD VSS _18992_/D NOR2X1
X_17041_ _17041_/A VDD VSS _17042_/D INVX1
XFILLER_137_682 VDD VSS FILLER1
X_10416_ _19940_/Q _18822_/Q VDD VSS _10417_/D NAND2X1
X_13204_ _14221_/A _14221_/B VDD VSS _13278_/B NOR2X1
XFILLER_109_395 VDD VSS FILLER4
XFILLER_136_181 VSS VDD FILLER2
XFILLER_99_86 VDD VSS FILLER4
X_11396_ _11396_/A _11396_/B wire166/Y VDD VSS _11397_/B OAI21X1
X_14184_ _14186_/A _14184_/B VDD VSS _18936_/D NOR2X1
XFILLER_125_899 VDD VSS DECAPHV8
X_10347_ _10347_/A VDD VSS _10579_/D BUFX3
X_13135_ _13135_/A _14511_/B _14511_/C VDD VSS _13141_/C NOR3X1
X_18992_ _19037_/CK _18992_/D _18992_/Q VDD VSS DFFQX1
X_10278_ _10346_/A _10346_/B VDD VSS _10581_/A NAND2X1P5
X_13066_ _19107_/Q _13104_/B _13314_/D VDD VSS _13212_/C XNOR3X1
X_17943_ _18087_/D _17948_/B VDD VSS _17944_/C NAND2X1
X_12017_ _19065_/Q VDD VSS _12019_/A INVX1
XFILLER_65_102 VDD VSS FILLER1
XFILLER_66_625 VDD VSS DECAPHV8
XFILLER_93_400 VSS VDD FILLER2
XFILLER_93_422 VSS VDD FILLER2
X_19613_ _19615_/CK _19613_/D _19613_/Q VDD VSS DFFQX1
X_17874_ _18132_/A _17874_/B _17874_/C VDD VSS _19942_/D NOR3X1
XFILLER_120_593 VDD VSS DECAPHV8
XFILLER_48_90 VDD VSS FILLER1
XFILLER_54_809 VDD VSS FILLER4
X_16825_ _16843_/A _16825_/B VDD VSS _19667_/D AND2X1
XFILLER_19_552 VDD VSS FILLER1
XFILLER_53_308 VDD VSS DECAPHV16
X_13968_ wire154/Y _14010_/B _14010_/C VDD VSS _13969_/C OAI21X1
X_19544_ _19716_/CK _19544_/D _19544_/Q VDD VSS DFFQX1
X_16756_ _16759_/A _16756_/B VDD VSS _19605_/D NOR2X1
XFILLER_19_585 VDD VSS DECAPHV32
XFILLER_74_691 VDD VSS FILLER4
XFILLER_80_138 VDD VSS FILLER1
XFILLER_80_149 VSS VDD FILLER2
X_12919_ _13017_/A _13102_/B VDD VSS _14351_/B XNOR2X1
X_19475_ _19489_/CK _19475_/D _19475_/Q VDD VSS DFFQX1
X_15707_ _15710_/A _15707_/B VDD VSS _19335_/D NOR2X1
X_13899_ _13998_/A _13998_/B _13998_/C VDD VSS _13916_/B AOI21X1
X_18426_ _18439_/CK _18426_/D _18426_/Q _20078_/RB VDD VSS DFFRQX1
X_16687_ _16687_/A _16687_/B VDD VSS _16902_/B XNOR2X1
XFILLER_22_728 VSS VDD FILLER2
X_15638_ _19385_/Q VDD VSS _15655_/A INVX1
XFILLER_21_238 VDD VSS FILLER1
XFILLER_9_62 VDD VSS FILLER1
X_18357_ _18359_/CK _18357_/D _18357_/Q _18471_/RB VDD VSS DFFRQX1
X_15569_ _15569_/A _15569_/B VDD VSS _15570_/C NOR2X1
X_18288_ _18295_/CK _18288_/D _18288_/Q VDD VSS DFFQX1
X_17308_ _19818_/Q _19786_/Q VDD VSS _17309_/C NAND2X1
X_17239_ _19804_/Q _19772_/Q VDD VSS _17240_/B XOR2X1
XFILLER_116_833 VDD VSS FILLER1
XFILLER_128_682 VDD VSS DECAPHV8
XFILLER_103_505 VDD VSS FILLER4
XFILLER_116_877 VDD VSS FILLER4
XFILLER_143_685 VDD VSS FILLER1
X_09992_ _11226_/D _09992_/B VDD VSS _09993_/C NAND2X1
X_20181_ _20181_/A VDD VSS _20181_/Y BUFX3
XFILLER_115_398 VSS VDD FILLER2
XTAP_TAPCELL_ROW_59_609 VDD VSS WELLTAP
XFILLER_28_16 VDD VSS DECAPHV8
XFILLER_56_113 VDD VSS FILLER1
XFILLER_85_945 VDD VSS FILLER4
XFILLER_57_658 VDD VSS DECAPHV16
XFILLER_25_500 VDD VSS FILLER1
XFILLER_56_157 VDD VSS FILLER1
XFILLER_72_617 VDD VSS FILLER1
XFILLER_84_477 VSS VDD FILLER2
XTAP_TAPCELL_ROW_67_686 VDD VSS WELLTAP
XTAP_TAPCELL_ROW_95_962 VDD VSS WELLTAP
XFILLER_37_371 VDD VSS FILLER1
XFILLER_13_706 VDD VSS DECAPHV8
XFILLER_53_853 VSS VDD FILLER2
X_09426_ _09426_/A _09819_/A VDD VSS _18234_/E NOR2X1
XFILLER_40_503 VDD VSS FILLER1
XFILLER_100_43 VSS VDD FILLER2
XFILLER_138_402 VDD VSS DECAPHV16
XTAP_TAPCELL_ROW_22_233 VDD VSS WELLTAP
XTAP_TAPCELL_ROW_50_520 VDD VSS WELLTAP
X_09357_ _18507_/Q _18506_/Q _09354_/Y VDD VSS _18507_/D MUX2X1
X_09288_ _20046_/Q _09414_/B VDD VSS _09289_/C NOR2X1
XFILLER_21_794 VSS VDD FILLER2
XFILLER_109_30 VDD VSS DECAPHV8
XFILLER_118_170 VDD VSS FILLER4
XFILLER_134_641 VDD VSS FILLER1
X_11250_ _11253_/A _11253_/B _11253_/C _11386_/C VDD VSS _11251_/D AOAI211X1
XFILLER_106_343 VDD VSS FILLER1
XFILLER_109_96 VSS VDD FILLER2
XFILLER_122_803 VDD VSS FILLER1
X_10201_ _10199_/Y _10201_/B _17172_/A VDD VSS _18546_/D AND3BX1
X_11181_ _11116_/Y _11180_/Y _10947_/Y VDD VSS _11181_/Y MUXI2X1
XFILLER_122_836 VDD VSS FILLER1
XFILLER_133_184 VSS VDD FILLER2
XFILLER_69_78 VDD VSS FILLER1
XTAP_TAPCELL_ROW_111_1129 VDD VSS WELLTAP
X_10132_ _10035_/Y _10130_/Y _10224_/A VDD VSS _10134_/B MUXI2X1
XFILLER_102_582 VDD VSS FILLER4
XFILLER_75_422 VDD VSS FILLER4
XFILLER_85_22 VSS VDD FILLER2
X_10063_ _10075_/D _10075_/B VDD VSS _10064_/B NOR2BX1
X_14940_ _14940_/A _14940_/B VDD VSS _15773_/B XNOR2X1
XFILLER_47_135 VDD VSS DECAPHV8
XFILLER_87_282 VSS VDD FILLER2
X_14871_ _14918_/A _14918_/B VDD VSS _14884_/B NAND2X1
XFILLER_18_60 VDD VSS FILLER4
XFILLER_62_105 VDD VSS FILLER1
XFILLER_63_617 VDD VSS DECAPHV16
X_13822_ _13921_/A _13987_/B VDD VSS _14197_/B XNOR2X1
X_17590_ _17591_/C _18127_/B _17590_/C VDD VSS _19878_/D AND3BX1
X_16610_ _19670_/Q _16829_/B VDD VSS _16611_/B XOR2X1
XFILLER_56_680 VDD VSS FILLER4
XFILLER_62_138 VDD VSS FILLER1
XFILLER_75_499 VDD VSS DECAPHV8
X_13753_ _17920_/A _17920_/B _17921_/C _13753_/D VDD VSS _13868_/A OAOI211X1
X_16541_ _16735_/A _16541_/B VDD VSS _19539_/D NOR2X1
XFILLER_43_330 VDD VSS DECAPHV16
XFILLER_71_650 VDD VSS FILLER1
XTAP_TAPCELL_ROW_122_1236 VDD VSS WELLTAP
X_10965_ _11078_/A _18730_/Q VDD VSS _10966_/C NAND2X1
X_12704_ _18907_/Q VDD VSS _12789_/A INVX1
XFILLER_44_886 VDD VSS FILLER4
XFILLER_70_160 VSS VDD FILLER2
X_10896_ _18646_/Q _18808_/Q _10896_/C VDD VSS _10925_/A MIN3X1
X_13684_ _14262_/B _14262_/C _19000_/Q VDD VSS _13686_/C AOI21X1
X_19260_ _19999_/CK _19260_/D _19260_/Q VDD VSS DFFQX1
X_16472_ _16456_/B _16472_/B _16472_/C VDD VSS _16495_/B AOI2B1X1
X_12635_ _12804_/A _12804_/B VDD VSS _14347_/B XNOR2X1
X_19191_ _19250_/CK _19191_/D _19191_/Q VDD VSS DFFQX1
X_15423_ _15754_/B VDD VSS _15424_/B INVX1
XFILLER_8_721 VDD VSS DECAPHV8
XTAP_TAPCELL_ROW_5_63 VDD VSS WELLTAP
X_12566_ _12566_/A _12566_/B _12566_/C _12566_/D VDD VSS _14472_/C OAI211X1
X_18142_ _18173_/A _18142_/B VDD VSS _20002_/D NOR2X1
X_15354_ _15359_/A _15359_/B _15354_/C VDD VSS _15355_/B OR3X2
XFILLER_11_282 VDD VSS DECAPHV8
X_11517_ _18670_/Q _11519_/B VDD VSS _18697_/D AND2X1
X_14305_ _14311_/A _14305_/B VDD VSS _19037_/D NOR2X1
X_12497_ _12497_/A _14503_/B _12497_/C _12497_/D VDD VSS _12755_/A OAOI211X1
Xwire162 wire162/A VDD VSS wire162/Y BUFX6
X_18073_ _19281_/Q _18073_/B VDD VSS _18074_/C AND2X1
X_15285_ _15285_/A _15306_/C VDD VSS _15814_/B XOR2X1
XFILLER_109_181 VDD VSS FILLER4
XFILLER_144_449 VDD VSS FILLER1
X_11448_ _19943_/Q _17990_/A VDD VSS _18636_/D AND2X1
X_14236_ _14251_/A _14236_/B VDD VSS _18980_/D NOR2X1
X_17024_ _17022_/B _17024_/B _17024_/C VDD VSS _19758_/D AOI2B1X1
XFILLER_125_663 VDD VSS FILLER4
XFILLER_140_600 VDD VSS FILLER4
XTAP_TAPCELL_ROW_133_1343 VDD VSS WELLTAP
X_11379_ _11379_/A _11379_/B _11379_/C VDD VSS _11390_/B AOI21X1
X_14167_ _14136_/Y _14167_/B _14167_/C VDD VSS _18920_/D AND3BX1
XFILLER_112_335 VDD VSS FILLER4
XFILLER_113_836 VDD VSS FILLER1
XFILLER_124_162 VDD VSS DECAPHV8
X_13118_ _19135_/Q _14415_/B VDD VSS _13231_/A AND2X1
XFILLER_113_869 VDD VSS DECAPHV16
XFILLER_67_901 VDD VSS FILLER4
X_14098_ _17945_/B _17945_/C _14098_/C _14098_/D VDD VSS _14101_/B AOAI211X1
X_18975_ _19004_/CK _18975_/D _18975_/Q VDD VSS DFFQX1
XFILLER_39_614 VDD VSS FILLER4
XFILLER_78_260 VSS VDD FILLER2
X_13049_ _13049_/A _13049_/B _13049_/C _13049_/D VDD VSS _14540_/B AOAI211X1
X_17926_ _17927_/A _17927_/B _17927_/D _17927_/C VDD VSS _17928_/B OA211X2
XFILLER_15_2 VDD VSS FILLER1
XFILLER_66_433 VDD VSS FILLER1
XFILLER_78_282 VDD VSS FILLER1
X_17857_ _18849_/Q _17868_/B _17857_/C VDD VSS _17863_/C AO21X2
XFILLER_26_319 VDD VSS FILLER1
XFILLER_94_786 VDD VSS FILLER4
X_16808_ _16811_/A _16808_/B VDD VSS _19651_/D NOR2X1
XFILLER_19_371 VDD VSS FILLER1
XFILLER_54_639 VDD VSS FILLER1
XTAP_TAPCELL_ROW_144_1461 VDD VSS WELLTAP
XTAP_TAPCELL_ROW_92_932 VDD VSS WELLTAP
X_19527_ _19543_/CK _19527_/D _19527_/Q VDD VSS DFFQX1
X_17788_ _17793_/C _17793_/B VDD VSS _17790_/B NAND2BX1
XFILLER_35_864 VDD VSS FILLER1
XFILLER_62_661 VSS VDD FILLER2
XTAP_TAPCELL_ROW_64_656 VDD VSS WELLTAP
X_16739_ _16768_/A _16739_/B VDD VSS _19589_/D AND2X1
XFILLER_22_503 VDD VSS FILLER1
XFILLER_61_171 VDD VSS DECAPHV8
X_19458_ _19643_/CK _19458_/D _19458_/Q VDD VSS DFFQX1
XFILLER_50_867 VDD VSS FILLER1
X_09211_ _18471_/D VDD VSS _18423_/D INVX1
X_19389_ _19435_/CK _19389_/D _19389_/Q VDD VSS DFFQX1
X_18409_ _18423_/CK _18510_/Q _20164_/A _18444_/RB VDD VSS DFFRQX1
XFILLER_131_600 VDD VSS DECAPHV16
XFILLER_115_162 VDD VSS FILLER4
XFILLER_131_633 VDD VSS DECAPHV8
XFILLER_131_666 VSS VDD FILLER2
X_20164_ _20164_/A VDD VSS _20164_/Y BUFX3
XFILLER_130_154 VSS VDD FILLER2
XFILLER_39_59 VSS VDD FILLER2
XFILLER_97_580 VDD VSS DECAPHV8
X_20095_ _20095_/A VDD VSS _20095_/Y BUFX3
XFILLER_18_809 VSS VDD FILLER2
XFILLER_69_282 VSS VDD FILLER2
XFILLER_55_58 VDD VSS FILLER1
XFILLER_73_948 VSS VDD FILLER2
XFILLER_53_650 VDD VSS FILLER1
XTAP_TAPCELL_ROW_108_1091 VDD VSS WELLTAP
XFILLER_13_503 VDD VSS FILLER1
XFILLER_13_525 VSS VDD FILLER2
XFILLER_26_886 VDD VSS DECAPHV8
X_10750_ _19950_/Q _18832_/Q VDD VSS _10751_/B XNOR2X1
X_09409_ _09409_/A _09414_/B _09409_/C VDD VSS _20048_/D OAI21X1
X_10681_ _10634_/B _10681_/B _10681_/C VDD VSS _10722_/A AOI2B1X1
XFILLER_139_733 VSS VDD FILLER2
X_12420_ _12517_/A _12517_/B _12517_/C VDD VSS _12519_/B AOI21X1
XFILLER_127_917 VSS VDD FILLER2
XFILLER_138_243 VSS VDD FILLER2
XFILLER_126_416 VSS VDD FILLER2
XFILLER_138_254 VDD VSS FILLER1
X_12351_ _12429_/A _12429_/B _14147_/B VDD VSS _12352_/C XNOR3X1
XFILLER_4_212 VDD VSS FILLER4
X_11302_ _11302_/A _11302_/B VDD VSS _11312_/C NOR2X1
X_12282_ _19041_/Q VDD VSS _12288_/A INVX1
X_15070_ _15776_/B _15776_/C VDD VSS _15071_/B NOR2X1
XFILLER_107_674 VDD VSS FILLER4
XFILLER_4_245 VDD VSS FILLER1
XFILLER_5_768 VSS VDD FILLER2
X_11233_ _11118_/B _11278_/B _11298_/A VDD VSS _11317_/B MUXI2X1
X_14021_ _18895_/Q _14058_/A _14085_/B VDD VSS _14098_/D XNOR3X1
XFILLER_122_666 VDD VSS FILLER1
XFILLER_95_506 VDD VSS FILLER4
X_11164_ _18709_/Q _18763_/Q VDD VSS _11167_/D XNOR2X1
XFILLER_110_839 VDD VSS DECAPHV8
X_10115_ _10103_/Y _10127_/B _10127_/A VDD VSS _10145_/B MUX2X1
X_11095_ _11142_/C _11096_/B _11095_/C VDD VSS _11096_/C AOI21X1
X_18760_ _19937_/CK _18760_/D _18760_/Q VDD VSS DFFQX1
X_15972_ _15988_/A _16803_/B VDD VSS _15989_/B XNOR2X1
X_10046_ _09989_/B _10045_/Y _10167_/A VDD VSS _10047_/B MUXI2X1
X_18691_ _18773_/CK _18691_/D _18691_/Q VDD VSS DFFQX1
X_17711_ _17712_/C _17711_/B _17711_/C VDD VSS _19904_/D AOI21X1
X_14923_ _19532_/Q _15009_/C VDD VSS _15899_/B XNOR2X1
X_17642_ _17646_/A _17643_/B _17654_/C VDD VSS _17643_/C OAI21X1
XFILLER_90_211 VDD VSS DECAPHV8
X_14854_ _15297_/A _18068_/B VDD VSS _19280_/D AND2X1
X_11997_ _19206_/Q _12038_/B _12099_/C VDD VSS _12032_/B XNOR3X1
X_13805_ _14132_/A _14132_/B _14132_/C VDD VSS _13812_/B OAI21X1
X_17573_ _19875_/Q _19843_/Q VDD VSS _17575_/B XOR2X1
X_14785_ _14785_/A _14785_/B _14785_/C _14785_/D VDD VSS _14826_/B OAOI211X1
XFILLER_16_385 VSS VDD FILLER2
XFILLER_32_801 VDD VSS FILLER4
XFILLER_44_694 VSS VDD FILLER2
XTAP_TAPCELL_ROW_61_626 VDD VSS WELLTAP
X_10948_ _10877_/Y _10946_/Y _10947_/Y VDD VSS _10948_/Y MUX2X1
X_13736_ _13736_/A _14262_/B _13736_/C _13736_/D VDD VSS _13889_/B AOAI211X1
X_19312_ _19337_/CK _19312_/D _19312_/Q VDD VSS DFFQX1
X_16524_ _19922_/Q VDD VSS _16718_/A INVX1
XFILLER_32_856 VDD VSS FILLER4
X_19243_ _20006_/CK _19243_/D _19243_/Q VDD VSS DFFQX1
X_16455_ _19632_/Q _16786_/B VDD VSS _16456_/B XNOR2X1
XFILLER_31_355 VDD VSS FILLER4
X_10879_ _10736_/B _10878_/Y _11118_/A VDD VSS _10881_/B MUXI2X1
X_13667_ _14522_/A VDD VSS _18196_/A BUFX3
X_15406_ _19461_/Q _15849_/B VDD VSS _15407_/B XOR2X1
X_12618_ _18963_/Q VDD VSS _12712_/A INVX1
X_13598_ _13675_/A _13675_/B _13675_/C VDD VSS _13654_/B AOI21X1
X_19174_ _19202_/CK _19174_/D _19174_/Q VDD VSS DFFQX1
X_16386_ _16383_/A _16386_/B _16386_/C VDD VSS _16411_/A AOI2B1X1
X_12549_ _12625_/A _14346_/B _14346_/C VDD VSS _12803_/C NOR3X1
X_18211__256 _18259_/CK VDD VSS _18278_/CK INVX1
X_18125_ _18126_/A _18126_/B VDD VSS _18131_/B NOR2X1
X_15337_ _19318_/Q _15337_/B _15337_/C VDD VSS _15340_/C MIN3X1
XANTENNA_1 _18354_/Q VDD VSS ANTENNA2
XFILLER_129_298 VSS VDD FILLER2
XFILLER_144_235 VDD VSS DECAPHV16
X_18056_ _18056_/A _18056_/B _18056_/C VDD VSS _19985_/D OAI21X1
X_15268_ _15307_/A _15307_/B VDD VSS _15308_/A AND2X1
XFILLER_144_257 VDD VSS DECAPHV8
XFILLER_99_812 VSS VDD FILLER2
X_14219_ _14219_/A _14221_/B _14219_/C VDD VSS _18968_/D NOR3X1
X_17007_ _19754_/Q _19755_/Q _17011_/B VDD VSS _17009_/B OA21X2
Xclkbuf_0_sclk_regs clkbuf_regs_1_sclk/Y VDD VSS clkbuf_0_sclk_regs/Y BUFX12
X_15199_ _19455_/Q _15841_/B _15841_/C VDD VSS _15200_/C NOR3BX1
XFILLER_99_878 VDD VSS DECAPHV16
XFILLER_140_474 VDD VSS FILLER4
XFILLER_58_219 VSS VDD FILLER2
XFILLER_86_539 VDD VSS DECAPHV32
XFILLER_98_399 VDD VSS DECAPHV8
XTAP_TAPCELL_ROW_69_704 VDD VSS WELLTAP
X_09760_ _18271_/Q _09818_/C _09760_/C _09788_/B _09760_/E VDD VSS _09761_/B AOI221X1
Xclkbuf_0__09183_ _18232_/ECK VDD VSS clkbuf_0__09183_/Y BUFX12
X_18958_ _18993_/CK _18958_/D _18958_/Q VDD VSS DFFQX1
XFILLER_140_496 VDD VSS DECAPHV8
X_09691_ _20108_/A _20124_/A _09776_/A VDD VSS _09692_/B MUXI2X1
X_17909_ _18860_/Q VDD VSS _17914_/A INVX1
XFILLER_27_606 VDD VSS FILLER1
XFILLER_55_904 VDD VSS DECAPHV16
XFILLER_67_775 VDD VSS DECAPHV8
X_18889_ _18917_/CK _18889_/D _18889_/Q VDD VSS DFFQX1
XFILLER_55_937 VDD VSS FILLER1
XFILLER_66_274 VDD VSS DECAPHV8
XTAP_TAPCELL_ROW_77_781 VDD VSS WELLTAP
XFILLER_54_469 VDD VSS FILLER1
XFILLER_23_812 VSS VDD FILLER2
XFILLER_35_672 VDD VSS FILLER1
XFILLER_23_856 VDD VSS FILLER1
XFILLER_136_714 VDD VSS FILLER4
XFILLER_135_213 VSS VDD FILLER2
X_09978__248 _20054_/CK VDD VSS _18525_/CK INVX1
XFILLER_144_780 VSS VDD FILLER2
X_20216_ _20216_/A VDD VSS _20216_/Y BUFX3
XFILLER_104_688 VDD VSS FILLER1
XFILLER_106_31 VDD VSS FILLER1
XFILLER_106_53 VSS VDD FILLER2
X_20147_ _20147_/A VDD VSS _20147_/Y BUFX3
XFILLER_100_861 VDD VSS FILLER1
XFILLER_46_926 VDD VSS FILLER1
XFILLER_57_252 VSS VDD FILLER2
X_09889_ _10803_/A VDD VSS _11014_/A BUFX3
X_20078_ _20079_/CK _20078_/D _20078_/Q _20078_/RB VDD VSS DFFRQX1
XFILLER_57_296 VDD VSS FILLER1
XFILLER_85_594 VDD VSS FILLER1
X_11920_ _14462_/B _14462_/C _12034_/A VDD VSS _11922_/C OA21X2
XFILLER_122_63 VSS VDD FILLER2
X_11851_ _11851_/A _11851_/B VDD VSS _14459_/B XNOR2X1
Xclkbuf_1_1__f_sclk clkbuf_0_sclk/Y VDD VSS clkbuf_leaf_3_sclk/A BUFX12
XFILLER_26_683 VSS VDD FILLER2
X_10802_ _10800_/Y _11195_/A _10871_/B VDD VSS _10803_/D AND3BX1
X_11782_ _19201_/Q _11828_/A _11828_/B VDD VSS _11851_/B XNOR3X1
X_14570_ _16273_/A VDD VSS _16702_/B BUFX3
XFILLER_82_89 VDD VSS DECAPHV16
X_10733_ _10945_/A _10733_/B VDD VSS _10807_/C NOR2X1
X_13521_ _19054_/Q _14325_/B VDD VSS _13604_/A NAND2X1
Xclkbuf_1_0__f__09172_ clkbuf_0__09172_/Y VDD VSS _18327_/CK BUFX12
Xclkbuf_leaf_30__000_ clkload78/A VDD VSS _19362_/CK BUFX12
X_10664_ _18560_/Q _10665_/B VDD VSS _10666_/B NAND2X1
X_13452_ _13542_/A _14451_/B _14451_/C VDD VSS _13617_/C NOR3X1
X_16240_ _19624_/Q _16778_/B VDD VSS _16241_/B XNOR2X1
X_10595_ _10595_/A VDD VSS _11127_/A BUFX3
X_12403_ _20003_/Q _19267_/Q VDD VSS _12499_/A XNOR2X1
X_13383_ _15383_/A VDD VSS _14158_/A BUFX3
X_16171_ _17172_/A VDD VSS _18168_/C BUFX3
XFILLER_126_235 VDD VSS FILLER1
XFILLER_127_736 VDD VSS DECAPHV8
XTAP_TAPCELL_ROW_2_31 VDD VSS WELLTAP
X_12334_ _19099_/Q _12334_/B _12380_/C VDD VSS _12544_/B XNOR3X1
X_15122_ _15134_/C _15134_/B VDD VSS _15123_/B NOR2BX1
XFILLER_126_257 VSS VDD FILLER2
X_19930_ clkload3/A _19930_/D _19930_/Q VDD VSS DFFQX1
X_15053_ _19480_/Q _15872_/B VDD VSS _15054_/D _15872_/C AND3X2
XFILLER_107_482 VSS VDD FILLER2
XFILLER_141_216 VDD VSS FILLER1
XFILLER_49_8 VSS VDD FILLER2
XTAP_TAPCELL_ROW_130_1313 VDD VSS WELLTAP
X_12265_ _18958_/Q _12277_/B _14209_/B VDD VSS _14178_/B XNOR3X1
X_14004_ _14004_/A _14004_/B _14004_/C VDD VSS _14233_/C OAI21X1
X_11216_ _11220_/A _11220_/B VDD VSS _11219_/A XNOR2X1
X_12196_ _18873_/Q _14113_/B VDD VSS _12349_/B NOR2X1
X_19861_ _19863_/CK _19861_/D _19861_/Q VDD VSS DFFQX1
Xoutput60 _20144_/Y VDD VSS o_clk_cfg[11] BUFX3
XFILLER_96_826 VDD VSS DECAPHV8
X_11147_ _11167_/A _11167_/B _11229_/D VDD VSS _11148_/C AOI21X1
X_19792_ _19792_/CK _19792_/D _19792_/Q VDD VSS DFFQX1
Xoutput71 _20137_/Y VDD VSS o_clk_cfg[4] BUFX3
Xoutput82 _20156_/Y VDD VSS o_en_ctrl[4] BUFX3
Xoutput93 _20177_/Y VDD VSS o_lf_cfg[14] BUFX3
X_18812_ _19958_/CK _18812_/D _18812_/Q VDD VSS DFFQX1
XFILLER_96_859 VDD VSS FILLER1
X_18743_ _18797_/CK _18743_/D _18743_/Q VDD VSS DFFQX1
X_11078_ _11078_/A _18733_/Q _11078_/C _11078_/D VDD VSS _11115_/B AOI211X1
X_15955_ _15977_/A _15977_/B VDD VSS _15956_/C NAND2X1
XFILLER_37_948 VSS VDD FILLER2
X_10029_ _18581_/Q _10029_/B VDD VSS _10029_/Y XOR2X1
X_18674_ _18809_/CK _18674_/D _18674_/Q VDD VSS DFFQX1
X_15886_ _16768_/A _15886_/B VDD VSS _19493_/D AND2X1
X_14906_ _15833_/B _15833_/C _14906_/C VDD VSS _14908_/C OA21X2
XFILLER_36_447 VSS VDD FILLER2
XFILLER_36_458 VDD VSS FILLER1
XFILLER_91_553 VDD VSS FILLER1
XTAP_TAPCELL_ROW_128_1297 VDD VSS WELLTAP
XTAP_TAPCELL_ROW_74_751 VDD VSS WELLTAP
X_17625_ _19885_/Q _19853_/Q _17625_/C VDD VSS _17629_/C MIN3X1
X_14837_ _14837_/A _14837_/B _14837_/C VDD VSS _14839_/C OR3X2
XFILLER_51_406 VDD VSS DECAPHV16
XFILLER_91_575 VDD VSS DECAPHV8
XTAP_TAPCELL_ROW_46_475 VDD VSS WELLTAP
X_17556_ _17554_/B _17556_/B VDD VSS _17557_/C NOR2BX1
XTAP_TAPCELL_ROW_18_199 VDD VSS WELLTAP
X_16507_ _16518_/B _16507_/B VDD VSS _16859_/B XNOR2X1
X_14768_ _14768_/A VDD VSS _14769_/B INVX1
X_13719_ _13719_/A _13719_/B VDD VSS _14423_/B XNOR2X1
X_17487_ _19856_/Q _19824_/Q VDD VSS _17488_/C NAND2X1
X_14699_ _19445_/Q VDD VSS _14776_/A INVX1
XFILLER_82_2 VDD VSS FILLER1
Xclkbuf_2_0__f_sclk_regs clkbuf_0_sclk_regs/Y VDD VSS _18259_/CK BUFX12
X_19226_ _19988_/CK _19226_/D _19226_/Q VDD VSS DFFQX1
X_16438_ _16469_/B _16438_/B VDD VSS _16891_/B NAND2X1
X_19157_ _19182_/CK _19157_/D _19157_/Q VDD VSS DFFQX1
X_16369_ _19564_/Q _16711_/A _16369_/C VDD VSS _16395_/C OAI21X1
XFILLER_68_0 VSS VDD FILLER2
X_18108_ _18112_/C _18112_/A VDD VSS _18110_/A NOR2BX1
XFILLER_117_268 VDD VSS FILLER4
X_19088_ _19115_/CK _19088_/D _19088_/Q VDD VSS DFFQX1
XFILLER_114_920 VDD VSS FILLER4
X_18039_ _18042_/B _18045_/B _18039_/C _18049_/D VDD VSS _19977_/D OAI31X1
XFILLER_98_152 VDD VSS FILLER1
X_09812_ _18311_/Q _09812_/B _09812_/C VDD VSS _09817_/B AOI21X1
X_20001_ _20005_/CK _20001_/D _20001_/Q VDD VSS DFFQX1
XFILLER_98_196 VDD VSS FILLER4
Xclkbuf_0__09166_ _18215_/ECK VDD VSS clkbuf_0__09166_/Y BUFX12
XFILLER_100_168 VSS VDD FILLER2
XFILLER_67_550 VSS VDD FILLER2
XFILLER_67_561 VSS VDD FILLER2
XFILLER_86_369 VDD VSS FILLER1
X_09743_ _20173_/A _09784_/C _09769_/C _18322_/Q VDD VSS _09744_/B AO22X2
XFILLER_39_263 VSS VDD FILLER2
XFILLER_54_211 VDD VSS FILLER1
X_09674_ _18266_/Q _09770_/B _09770_/C _18318_/Q _09674_/E VDD VSS _09675_/C AOI221X1
XFILLER_36_38 VDD VSS FILLER1
XFILLER_36_49 VSS VDD FILLER2
XFILLER_82_542 VDD VSS DECAPHV8
XFILLER_42_417 VDD VSS FILLER1
XTAP_TAPCELL_ROW_105_1061 VDD VSS WELLTAP
XFILLER_7_819 VSS VDD FILLER2
XFILLER_108_213 VDD VSS FILLER4
XFILLER_109_747 VDD VSS FILLER1
XFILLER_124_717 VDD VSS DECAPHV8
XFILLER_136_566 VSS VDD FILLER2
X_10380_ _10406_/A _10381_/C _10381_/D VDD VSS _10383_/B OR3BX1
XFILLER_117_780 VDD VSS FILLER1
XTAP_TAPCELL_ROW_9_101 VDD VSS WELLTAP
X_12050_ _12055_/A _12055_/B _12055_/C _12050_/D VDD VSS _14528_/B OAOI211X1
XFILLER_104_452 VDD VSS FILLER4
XFILLER_117_96 VSS VDD FILLER2
X_11001_ _18703_/Q _18757_/Q _11001_/C VDD VSS _11002_/B MIN3X1
XFILLER_131_282 VDD VSS DECAPHV8
XFILLER_78_848 VDD VSS FILLER4
XFILLER_18_403 VDD VSS DECAPHV8
XFILLER_19_926 VDD VSS FILLER1
XFILLER_58_583 VDD VSS DECAPHV8
XFILLER_92_328 VDD VSS FILLER1
XFILLER_93_22 VDD VSS DECAPHV8
XTAP_TAPCELL_ROW_88_898 VDD VSS WELLTAP
X_12952_ _19217_/Q _14510_/B VDD VSS _12953_/D _14510_/C AND3X2
X_15740_ _15743_/A _15740_/B VDD VSS _19365_/D AND2X1
XFILLER_34_907 VDD VSS FILLER1
X_11903_ _19036_/Q _11954_/B _11907_/C VDD VSS _14270_/B XNOR3X1
X_15671_ _19331_/Q _15671_/B _15671_/C VDD VSS _18194_/A MIN3X1
XFILLER_61_715 VDD VSS FILLER1
X_12883_ _18908_/Q _12883_/B _12883_/C VDD VSS _14121_/B XNOR3X1
X_14622_ _14644_/A _15889_/B VDD VSS _14624_/C NAND2X1
X_17410_ _17413_/C _17411_/B _17452_/C VDD VSS _17411_/C OAI21X1
XFILLER_33_439 VDD VSS FILLER1
XFILLER_60_247 VDD VSS FILLER4
XTAP_TAPCELL_ROW_71_721 VDD VSS WELLTAP
X_11834_ _11804_/B _14521_/C _19228_/Q VDD VSS _11835_/D AND3BX1
X_18390_ _18390_/CK _18470_/D _20195_/A _20064_/RB VDD VSS DFFRQX1
XTAP_TAPCELL_ROW_43_445 VDD VSS WELLTAP
X_11765_ _11797_/A _11797_/B _11797_/C VDD VSS _11851_/A OA21X2
X_14553_ _19993_/Q _14558_/B VDD VSS _19257_/D AND2X1
X_17341_ _17346_/C _17346_/B VDD VSS _17343_/B NAND2BX1
XFILLER_41_472 VDD VSS FILLER4
XTAP_TAPCELL_ROW_15_169 VDD VSS WELLTAP
X_10716_ _11078_/A _18723_/Q VDD VSS _10717_/D AND2X1
X_11696_ _11736_/A _11716_/D VDD VSS _11700_/C XNOR2X1
X_13504_ _14224_/B _18970_/Q VDD VSS _13516_/A NAND2BX1
X_14484_ _14766_/A _14484_/B VDD VSS _19197_/D AND2X1
X_17272_ _19810_/Q _19778_/Q _17272_/C VDD VSS _17277_/C AO21X2
XTAP_TAPCELL_ROW_119_1208 VDD VSS WELLTAP
X_10647_ _18693_/Q _18747_/Q VDD VSS _10649_/C NOR2X1
X_13435_ _13616_/A _13616_/B _13616_/D _13616_/C VDD VSS _14388_/C AOI211X1
X_19011_ _19040_/CK _19011_/D _19011_/Q VDD VSS DFFQX1
X_16223_ _16221_/Y _16225_/B _17986_/C VDD VSS _19527_/D AND3BX1
XFILLER_139_371 VDD VSS FILLER1
X_10578_ _10578_/A _10578_/B VDD VSS _10656_/B _10578_/C _10578_/D NAND4X2
X_13366_ _19081_/Q _14355_/A VDD VSS _13422_/C _14355_/B NAND3X1
X_16154_ _16144_/A _16154_/B _16154_/C VDD VSS _16177_/A AOI2B1X1
X_12317_ _20002_/Q _19266_/Q VDD VSS _12407_/D NOR2X1
X_13297_ _18941_/Q _14191_/B VDD VSS _13393_/A AND2X1
X_16085_ _16085_/A _16085_/B _16734_/B VDD VSS _16109_/B MIN3X1
X_15105_ _19509_/Q _15903_/B VDD VSS _15155_/A NAND2BX1
X_12248_ _14404_/B _14404_/C _19125_/Q VDD VSS _12298_/B AOI21X1
X_19913_ _19928_/CK _19913_/D _19913_/Q VDD VSS DFFQX1
X_15036_ _15036_/A _15036_/B _15683_/B VDD VSS _15080_/B MIN3X1
XFILLER_110_400 VDD VSS FILLER1
XFILLER_69_826 VDD VSS DECAPHV8
XFILLER_96_601 VSS VDD FILLER2
XTAP_TAPCELL_ROW_79_810 VDD VSS WELLTAP
X_19844_ _19907_/CK _19844_/D _19844_/Q VDD VSS DFFQX1
XFILLER_122_293 VDD VSS DECAPHV8
X_12179_ _12214_/A _12214_/B VDD VSS _14435_/B XNOR2X1
XFILLER_3_75 VDD VSS FILLER1
XFILLER_84_829 VSS VDD FILLER2
X_19775_ _19843_/CK _19775_/D _19775_/Q VDD VSS DFFQX1
X_16987_ _16994_/A _16991_/C _17081_/C VDD VSS _16988_/C OAI21X1
XFILLER_37_734 VDD VSS FILLER1
X_18726_ _18782_/CK _18726_/D _18726_/Q VDD VSS DFFQX1
X_15938_ _19900_/Q VDD VSS _16693_/A INVX1
XFILLER_37_767 VDD VSS FILLER1
X_18657_ _19937_/CK _18657_/D _18657_/Q VDD VSS DFFQX1
XFILLER_37_789 VDD VSS FILLER4
X_17608_ _17610_/A _17610_/B _17608_/C VDD VSS _19882_/D AOI21X1
X_15869_ _15879_/A _15869_/B VDD VSS _19478_/D AND2X1
XFILLER_51_225 VSS VDD FILLER2
X_09390_ _19935_/Q _09390_/B VDD VSS _09405_/B NAND2X1
X_18588_ _18595_/CK _18588_/D _18588_/Q VDD VSS DFFQX1
X_17539_ _17541_/B _17539_/B VDD VSS _17540_/B XOR2X1
XFILLER_20_656 VSS VDD FILLER2
X_19209_ _20006_/CK _19209_/D _19209_/Q VDD VSS DFFQX1
XFILLER_118_522 VSS VDD FILLER2
XFILLER_118_533 VSS VDD FILLER2
XFILLER_133_569 VDD VSS FILLER4
Xclkbuf_leaf_6_clk_regs clkload1/A VDD VSS clkload2/A BUFX12
XFILLER_114_761 VDD VSS DECAPHV8
XFILLER_99_472 VDD VSS FILLER1
XFILLER_113_271 VSS VDD FILLER2
XFILLER_87_623 VDD VSS DECAPHV8
XFILLER_59_369 VSS VDD FILLER2
XFILLER_75_807 VSS VDD FILLER2
Xfanout179 _18625_/Q VDD VSS _11436_/C BUFX3
XFILLER_74_328 VDD VSS FILLER4
X_09726_ _20075_/Q _09770_/B _09784_/C _18433_/Q VDD VSS _09729_/A AOI22X1
XFILLER_28_756 VSS VDD FILLER2
XFILLER_55_542 VSS VDD FILLER2
XFILLER_67_391 VDD VSS FILLER1
XTAP_TAPCELL_ROW_85_868 VDD VSS WELLTAP
XFILLER_103_65 VDD VSS FILLER1
XFILLER_27_266 VDD VSS DECAPHV8
XFILLER_55_575 VDD VSS FILLER1
XFILLER_82_361 VDD VSS FILLER4
X_09657_ _20186_/A _09813_/C _09770_/C _18317_/Q _09657_/E VDD VSS _09658_/E AOI221X1
X_09588_ _09815_/C VDD VSS _09769_/C BUFX3
XFILLER_70_578 VDD VSS DECAPHV8
XFILLER_23_472 VSS VDD FILLER2
XTAP_TAPCELL_ROW_40_415 VDD VSS WELLTAP
X_11550_ _11550_/A _11641_/B VDD VSS _18726_/D NOR2X1
XTAP_TAPCELL_ROW_12_139 VDD VSS WELLTAP
X_10501_ _10511_/A _10659_/B _10659_/C _10501_/D VDD VSS _10502_/B AO31X2
X_11481_ _18637_/Q _11484_/B VDD VSS _18664_/D AND2X1
X_13220_ _13231_/A _14385_/B _13231_/C VDD VSS _14386_/B OAI21X1
X_10432_ _10472_/B _10432_/B VDD VSS _18555_/D AND2X1
X_10363_ _10417_/A _10417_/B _10417_/C _10363_/D VDD VSS _10395_/B AOAI211X1
X_13151_ _13152_/B _13152_/C _19247_/Q VDD VSS _13240_/B AOI21X1
X_12102_ _12108_/A _12108_/B _12108_/C VDD VSS _14529_/B OAI21X1
X_13082_ _18911_/Q VDD VSS _13178_/A INVX1
X_10294_ _10721_/D _10294_/B _10294_/C _10362_/D VDD VSS _10295_/C OAI22X1
X_12033_ _19178_/Q _14464_/B VDD VSS _12155_/A AND2X1
X_16910_ _20068_/Q VDD VSS _20068_/D INVX1
X_17890_ _17894_/A _17894_/B VDD VSS _17892_/A XNOR2X1
XFILLER_38_509 VSS VDD FILLER2
X_16841_ _16865_/A _16841_/B VDD VSS _19681_/D NOR2X1
XFILLER_65_328 VDD VSS DECAPHV8
X_19560_ _19606_/CK _19560_/D _19560_/Q VDD VSS DFFQX1
X_16772_ _16793_/A _16772_/B VDD VSS _19619_/D AND2X1
XFILLER_19_734 VDD VSS FILLER4
XFILLER_58_391 VSS VDD FILLER2
X_13984_ _13995_/A _13995_/B VDD VSS _14137_/C _13995_/C NAND3X1
X_18511_ _18511_/CK _18511_/D _18511_/Q _09343_/Y VDD VSS DFFRQX1
X_15723_ _15725_/A _15723_/B VDD VSS _19349_/D AND2X1
XFILLER_19_778 VDD VSS FILLER4
XFILLER_34_704 VSS VDD FILLER2
XFILLER_46_553 VDD VSS FILLER1
XFILLER_46_564 VDD VSS FILLER4
XFILLER_61_512 VDD VSS FILLER1
X_12935_ _14444_/B _14444_/C _12936_/A VDD VSS _13107_/B OAI21X1
X_19491_ _19492_/CK _19491_/D _19491_/Q VDD VSS DFFQX1
XFILLER_15_940 VDD VSS FILLER4
XFILLER_34_759 VDD VSS FILLER4
XTAP_TAPCELL_ROW_125_1267 VDD VSS WELLTAP
XTAP_TAPCELL_ROW_8_96 VDD VSS WELLTAP
X_12866_ _12916_/A _12916_/B VDD VSS _14318_/B XNOR2X1
X_18442_ _18453_/CK _18442_/D _18442_/Q _18453_/RB VDD VSS DFFRQX1
X_15654_ _15654_/A _15654_/B VDD VSS _15655_/C NAND2X1
XFILLER_61_556 VSS VDD FILLER2
XTAP_TAPCELL_ROW_28_294 VDD VSS WELLTAP
X_11817_ _19117_/Q VDD VSS _11819_/A INVX1
X_14605_ _19523_/Q _14649_/C VDD VSS _15889_/B XNOR2X1
X_18373_ _18375_/CK _18373_/D _18373_/Q _18373_/RB VDD VSS DFFRQX1
X_15585_ _19354_/Q _15729_/B VDD VSS _15592_/B XNOR2X1
XFILLER_42_770 VDD VSS FILLER1
X_12797_ _12779_/Y _12872_/B _18992_/Q VDD VSS _12903_/B NAND3BX1
X_14536_ _14766_/A _14536_/B VDD VSS _19242_/D AND2X1
X_17324_ _19822_/Q _19790_/Q VDD VSS _17327_/A XNOR2X1
XFILLER_14_494 VSS VDD FILLER2
X_11748_ _19992_/Q _19256_/Q VDD VSS _11769_/D XOR2X1
X_11679_ _18816_/Q _14547_/B VDD VSS _18843_/D AND2X1
X_14467_ _14467_/A _14467_/B VDD VSS _19181_/D AND2X1
X_17255_ _17257_/B _17255_/B VDD VSS _17256_/B XOR2X1
X_13418_ _13427_/A _13418_/B _13437_/C VDD VSS _13531_/A XNOR3X1
X_14398_ _14426_/A _14398_/B VDD VSS _19119_/D NOR2X1
X_17186_ _17189_/A _17189_/B _17229_/C VDD VSS _17187_/C OAI21X1
X_16206_ _19590_/Q _16206_/B _16740_/B VDD VSS _16233_/A MIN3X1
XFILLER_128_886 VSS VDD FILLER2
XTAP_TAPCELL_ROW_136_1374 VDD VSS WELLTAP
X_13349_ _19250_/Q _14545_/B VDD VSS _13464_/B XNOR2X1
X_16137_ _19555_/Q _16701_/A _16137_/C VDD VSS _16159_/C MIN3X1
XFILLER_143_856 VDD VSS FILLER1
XFILLER_6_693 VDD VSS FILLER4
XFILLER_103_709 VDD VSS FILLER1
XFILLER_115_569 VDD VSS FILLER4
XFILLER_142_366 VDD VSS FILLER1
XFILLER_45_2 VDD VSS FILLER1
XFILLER_88_409 VDD VSS FILLER4
X_16068_ _16083_/A _16083_/B VDD VSS _16806_/B XNOR2X1
X_15019_ _15056_/A _15056_/B _15056_/D _15056_/C VDD VSS _15052_/D OAI211X1
XFILLER_111_742 VSS VDD FILLER2
XFILLER_68_133 VDD VSS FILLER4
XFILLER_68_155 VDD VSS FILLER4
X_19827_ _19828_/CK _19827_/D _19827_/Q VDD VSS DFFQX1
XFILLER_56_306 VSS VDD FILLER2
XFILLER_56_328 VSS VDD FILLER2
XFILLER_68_177 VDD VSS FILLER4
X_09511_ _20018_/Q _20017_/Q _20019_/Q _20020_/Q VDD VSS _09526_/B AND4X2
X_19758_ _19795_/CK _19758_/D _19758_/Q VDD VSS DFFQX1
XFILLER_52_501 VDD VSS FILLER1
XFILLER_83_158 VDD VSS DECAPHV16
X_19689_ _19703_/CK _19689_/D _19689_/Q VDD VSS DFFQX1
X_18709_ _19937_/CK _18709_/D _18709_/Q VDD VSS DFFQX1
XFILLER_24_225 VSS VDD FILLER2
XTAP_TAPCELL_ROW_82_838 VDD VSS WELLTAP
X_09442_ _09446_/A _09772_/B VDD VSS _18219_/E NOR2X1
X_09373_ _09482_/C VDD VSS _09468_/B BUFX3
XTAP_TAPCELL_ROW_102_1031 VDD VSS WELLTAP
XFILLER_133_300 VDD VSS FILLER1
XFILLER_134_801 VDD VSS FILLER4
XFILLER_134_867 VSS VDD FILLER2
XFILLER_133_377 VDD VSS FILLER1
XFILLER_134_878 VDD VSS FILLER4
XFILLER_102_720 VSS VDD FILLER2
XFILLER_0_858 VDD VSS FILLER1
XFILLER_0_869 VDD VSS FILLER1
XFILLER_59_155 VDD VSS FILLER1
XFILLER_87_464 VDD VSS FILLER1
XFILLER_47_328 VDD VSS FILLER4
XFILLER_74_114 VDD VSS DECAPHV16
XTAP_TAPCELL_ROW_98_993 VDD VSS WELLTAP
XFILLER_114_64 VDD VSS DECAPHV8
XFILLER_28_542 VSS VDD FILLER2
XFILLER_28_564 VDD VSS FILLER1
XFILLER_56_862 VSS VDD FILLER2
XFILLER_62_309 VDD VSS FILLER1
XFILLER_90_607 VDD VSS FILLER4
X_09709_ _18320_/Q _09769_/C VDD VSS _09711_/C NAND2X1
X_10981_ _11095_/C _10981_/B _10981_/C _11229_/D VDD VSS _10982_/C OAI22X1
XFILLER_130_30 VSS VDD FILLER2
X_12720_ _12807_/A _12731_/B _12731_/C VDD VSS _14317_/C OR3BX1
XFILLER_71_865 VDD VSS FILLER1
X_12651_ _12737_/A _14442_/B VDD VSS _12748_/A NOR2X1
XFILLER_130_96 VDD VSS FILLER1
XFILLER_30_206 VDD VSS FILLER4
XFILLER_30_217 VSS VDD FILLER2
XTAP_TAPCELL_ROW_25_264 VDD VSS WELLTAP
X_11602_ _18746_/Q _11612_/B VDD VSS _18773_/D AND2X1
XFILLER_12_943 VDD VSS FILLER4
XFILLER_30_239 VSS VDD FILLER2
X_12582_ _20005_/Q _19269_/Q VDD VSS _12583_/D AND2X1
X_15370_ _19404_/Q _15785_/B VDD VSS _15389_/C NAND2X1
XFILLER_11_464 VDD VSS FILLER1
XFILLER_135_0 VSS VDD FILLER2
X_11533_ _18684_/Q _11542_/B VDD VSS _18711_/D AND2X1
X_14321_ _14339_/A _14321_/B VDD VSS _19051_/D NOR2X1
XFILLER_7_457 VDD VSS DECAPHV8
X_11464_ _19956_/Q _11473_/B VDD VSS _18649_/D AND2X1
X_14252_ _14457_/A VDD VSS _14285_/A BUFX3
X_17040_ _17040_/A _17040_/B VDD VSS _17045_/B NAND2X1
XFILLER_109_352 VDD VSS FILLER1
XFILLER_7_468 VDD VSS FILLER4
XFILLER_99_65 VSS VDD FILLER2
X_10415_ _10460_/A _10460_/B VDD VSS _10421_/B NAND2X1
X_13203_ _13203_/A _13203_/B _13203_/C _13203_/D VDD VSS _14221_/B OAOI211X1
XFILLER_125_856 VSS VDD FILLER2
X_11395_ _232_/E _11396_/A _11395_/C VDD VSS _18596_/D NOR3X1
X_14183_ _14186_/A _14183_/B VDD VSS _18935_/D NOR2X1
XFILLER_98_729 VDD VSS DECAPHV32
X_10346_ _10346_/A _10346_/B VDD VSS _10347_/A AND2X1
X_13134_ _14511_/B _14511_/C _13135_/A VDD VSS _13141_/B OAI21X1
X_18991_ _18993_/CK _18991_/D _18991_/Q VDD VSS DFFQX1
XFILLER_31_8 VDD VSS FILLER4
X_10277_ _18552_/Q VDD VSS _10312_/A INVX1
X_13065_ _19135_/Q _13316_/A _13315_/B VDD VSS _13314_/D XNOR3X1
X_17942_ _17946_/A _17942_/B VDD VSS _17948_/B NAND2BX1
X_12016_ _19038_/Q _12016_/B _12016_/C VDD VSS _12285_/B MIN3X1
X_17873_ _17872_/B _17876_/C VDD VSS _17874_/C NOR2BX1
XFILLER_120_583 VSS VDD FILLER2
XFILLER_38_328 VSS VDD FILLER2
XFILLER_93_412 VDD VSS FILLER1
XFILLER_94_946 VDD VSS FILLER4
X_19612_ _19643_/CK _19612_/D _19612_/Q VDD VSS DFFQX1
X_16824_ _16826_/A _16824_/B VDD VSS _19666_/D NOR2X1
XFILLER_65_125 VDD VSS DECAPHV8
XFILLER_0_32 VDD VSS FILLER1
XFILLER_46_361 VSS VDD FILLER2
XFILLER_47_862 VDD VSS DECAPHV8
XFILLER_81_607 VDD VSS FILLER4
X_13967_ _14301_/A _14301_/B _13967_/C VDD VSS _14010_/C AO21X2
X_19543_ _19543_/CK _19543_/D _19543_/Q VDD VSS DFFQX1
X_16755_ _16759_/A _16755_/B VDD VSS _19604_/D NOR2X1
XFILLER_80_128 VDD VSS DECAPHV8
X_12918_ _13005_/A _13005_/B _13005_/C _13005_/D VDD VSS _13095_/A AOI31X1
X_19474_ _19489_/CK _19474_/D _19474_/Q VDD VSS DFFQX1
X_16686_ _19705_/Q _16868_/B VDD VSS _16687_/B XNOR2X1
X_15706_ _15706_/A _15706_/B VDD VSS _19334_/D AND2X1
X_13898_ _13951_/A _14266_/B _14266_/C VDD VSS _13998_/C NOR3X1
X_18425_ _18438_/CK _18425_/D _18425_/Q _18471_/RB VDD VSS DFFRQX1
X_15637_ _15637_/A _15637_/B _15637_/C VDD VSS _15657_/B AO21X2
XFILLER_61_375 VSS VDD FILLER2
XFILLER_61_386 VDD VSS FILLER1
X_12849_ _20009_/Q _19273_/Q VDD VSS _13049_/A XOR2X1
X_18356_ _18356_/CK _18356_/D _18356_/Q _18492_/RB VDD VSS DFFRQX1
X_15568_ _15568_/A _15568_/B _15568_/C VDD VSS _15584_/A AOI21X1
XFILLER_9_96 VSS VDD FILLER2
X_14519_ _14491_/Y _14519_/B _14519_/C VDD VSS _19226_/D AND3BX1
X_18287_ _18295_/CK _18287_/D _18287_/Q VDD VSS DFFQX1
X_17307_ _17309_/A _17309_/B _17307_/C VDD VSS _19818_/D AOI21X1
X_15499_ _15499_/A _15502_/C VDD VSS _18149_/B XNOR2X1
X_17238_ _19803_/Q _19771_/Q _17238_/C VDD VSS _17242_/B AOI21X1
XFILLER_116_801 VDD VSS FILLER4
XFILLER_128_661 VDD VSS DECAPHV8
XFILLER_127_193 VSS VDD FILLER2
X_17169_ _17170_/C _17469_/B _17169_/C VDD VSS _19788_/D AND3BX1
XFILLER_131_804 VSS VDD FILLER2
XFILLER_131_826 VSS VDD FILLER2
XFILLER_143_664 VDD VSS FILLER4
X_09991_ _09930_/B _09919_/B _10034_/A VDD VSS _09992_/B MUXI2X1
X_20180_ _20180_/A VDD VSS _20180_/Y BUFX3
XFILLER_115_377 VDD VSS FILLER1
XFILLER_130_314 VDD VSS FILLER1
XFILLER_88_217 VSS VDD FILLER2
XFILLER_111_561 VDD VSS FILLER1
XFILLER_28_28 VDD VSS FILLER1
XFILLER_69_464 VDD VSS FILLER1
XFILLER_69_475 VDD VSS FILLER1
XFILLER_38_862 VDD VSS DECAPHV16
XFILLER_56_169 VDD VSS FILLER1
XFILLER_72_607 VDD VSS DECAPHV8
XTAP_TAPCELL_ROW_95_963 VDD VSS WELLTAP
XFILLER_37_383 VDD VSS FILLER4
XFILLER_71_128 VDD VSS FILLER1
XTAP_TAPCELL_ROW_67_687 VDD VSS WELLTAP
XFILLER_64_191 VSS VDD FILLER2
X_09425_ _09447_/B _09819_/A VDD VSS _18233_/E NOR2X1
XFILLER_12_228 VSS VDD FILLER2
XFILLER_52_397 VDD VSS DECAPHV8
X_09356_ _09362_/AB _09414_/D VDD VSS _09356_/Y NOR2BX1
XTAP_TAPCELL_ROW_22_234 VDD VSS WELLTAP
X_09287_ _09296_/A _09301_/B _09349_/B _09351_/B VDD VSS _09414_/B AOI211X1
XFILLER_138_458 VSS VDD FILLER2
XFILLER_119_650 VDD VSS FILLER1
XFILLER_106_333 VDD VSS DECAPHV8
X_10200_ _10200_/A _10200_/B _10200_/C _10200_/D VDD VSS _10201_/B OAI211X1
XFILLER_106_355 VDD VSS DECAPHV16
XFILLER_134_664 VDD VSS DECAPHV8
X_11180_ _11149_/Y _11179_/Y _10984_/A VDD VSS _11180_/Y MUXI2X1
XFILLER_0_611 VDD VSS DECAPHV8
XFILLER_106_399 VDD VSS FILLER1
XFILLER_122_826 VDD VSS DECAPHV8
XFILLER_133_163 VDD VSS FILLER4
XFILLER_69_68 VDD VSS FILLER1
X_10131_ _10131_/A VDD VSS _10224_/A BUFX3
XFILLER_0_633 VSS VDD FILLER2
X_10062_ _18605_/Q _10062_/B VDD VSS _10075_/B NOR2BX1
XFILLER_75_401 VDD VSS FILLER1
XFILLER_87_250 VSS VDD FILLER2
XFILLER_88_773 VDD VSS FILLER1
XFILLER_94_209 VDD VSS DECAPHV8
XFILLER_125_96 VSS VDD FILLER2
XFILLER_29_840 VDD VSS FILLER1
X_14870_ _14920_/A _15833_/B VDD VSS _14885_/B NOR2X1
XFILLER_47_147 VDD VSS FILLER1
X_13821_ _13876_/A _14131_/B _13876_/C _13821_/D VDD VSS _13981_/A AOAI211X1
XFILLER_91_949 VDD VSS FILLER1
X_13752_ _14132_/B _14131_/C _18890_/Q VDD VSS _13753_/D AND3BX1
X_16540_ _16540_/A _16543_/B VDD VSS _16541_/B XOR2X1
XFILLER_16_545 VDD VSS FILLER4
XFILLER_43_353 VDD VSS FILLER4
XTAP_TAPCELL_ROW_122_1237 VDD VSS WELLTAP
X_10964_ _10998_/C _10964_/B VDD VSS _10966_/B XNOR2X1
X_12703_ _18879_/Q _12703_/B _12703_/C VDD VSS _12884_/B MIN3X1
XFILLER_31_504 VDD VSS FILLER4
XFILLER_31_515 VDD VSS FILLER1
XFILLER_43_386 VDD VSS FILLER1
X_10895_ _10931_/A _10895_/B _10895_/C _11095_/C VDD VSS _10910_/C AOI211X1
X_13683_ _13683_/A _13683_/B _13683_/C _13683_/D VDD VSS _14262_/B AOAI211X1
X_16471_ _19632_/Q _16786_/B VDD VSS _16472_/C NOR2X1
XFILLER_31_537 VDD VSS DECAPHV16
X_12634_ _12634_/A _12634_/B _12634_/C _12634_/D VDD VSS _12804_/A AOAI211X1
X_19190_ _19250_/CK _19190_/D _19190_/Q VDD VSS DFFQX1
X_15422_ _15419_/A _15422_/B _15422_/C VDD VSS _15498_/B AOI2B1X1
XFILLER_12_773 VDD VSS FILLER1
XTAP_TAPCELL_ROW_5_64 VDD VSS WELLTAP
X_12565_ _12566_/A _12566_/B _12566_/D _12566_/C VDD VSS _12840_/B OAOI211X1
X_18141_ _18143_/C _18141_/B VDD VSS _18142_/B XNOR2X1
X_15353_ _15359_/A _15359_/B _15354_/C VDD VSS _15355_/A OAI21X1
XFILLER_129_458 VSS VDD FILLER2
XFILLER_8_744 VDD VSS FILLER4
XFILLER_8_755 VDD VSS FILLER4
X_11516_ _18669_/Q _11519_/B VDD VSS _18696_/D AND2X1
X_14304_ _14311_/A _14304_/B VDD VSS _19036_/D NOR2X1
X_18072_ _18173_/A _18072_/B VDD VSS _19989_/D NOR2X1
XFILLER_116_119 VDD VSS FILLER4
XFILLER_8_788 VSS VDD FILLER2
X_12496_ _14534_/A _14534_/B _19240_/Q VDD VSS _12497_/D OA21X2
Xwire152 wire152/A VDD VSS wire152/Y BUFX4
Xwire163 wire164/Y VDD VSS wire163/Y BUFX6
X_17023_ _18187_/C _17030_/A VDD VSS _17024_/C NAND2X1
X_15284_ _15284_/A _15284_/B _15284_/C _15284_/D VDD VSS _15306_/C AOAI211X1
XFILLER_109_160 VDD VSS FILLER1
XFILLER_137_491 VSS VDD FILLER2
X_11447_ _19942_/Q _17990_/A VDD VSS _18635_/D AND2X1
X_14235_ _14270_/A _14235_/B VDD VSS _18979_/D AND2X1
XFILLER_109_193 VDD VSS FILLER1
XFILLER_98_504 VDD VSS FILLER4
XTAP_TAPCELL_ROW_133_1344 VDD VSS WELLTAP
X_11378_ _11378_/A _11378_/B _11378_/C VDD VSS _18592_/D NOR3X1
X_14166_ _14219_/A _14166_/B _14166_/C VDD VSS _18919_/D NOR3X1
XFILLER_113_826 VDD VSS DECAPHV8
XFILLER_124_185 VDD VSS FILLER4
XFILLER_125_686 VSS VDD FILLER2
X_10329_ _10329_/A _10329_/B _10329_/C _10329_/D VDD VSS _10413_/B AOAI211X1
X_13117_ _13316_/A _13315_/B VDD VSS _14415_/B XNOR2X1
X_14097_ _18898_/Q _14141_/B VDD VSS _17977_/A NOR2X1
X_18974_ _19004_/CK _18974_/D _18974_/Q VDD VSS DFFQX1
XFILLER_79_784 VDD VSS FILLER1
X_13048_ _13255_/A _13150_/B VDD VSS _13049_/D NAND2X1
X_17925_ _18862_/Q _17925_/B VDD VSS _17927_/C _17925_/C NAND3X1
XFILLER_66_423 VDD VSS FILLER1
XFILLER_93_220 VSS VDD FILLER2
X_17856_ _18132_/A _17856_/B _17857_/C VDD VSS _19939_/D NOR3X1
XFILLER_54_607 VDD VSS DECAPHV32
XFILLER_94_765 VDD VSS DECAPHV16
X_17787_ _19921_/Q _19889_/Q VDD VSS _17793_/B NAND2X1
X_16807_ _16811_/A _16807_/B VDD VSS _19650_/D NOR2X1
XFILLER_19_361 VDD VSS FILLER1
XFILLER_82_949 VDD VSS FILLER1
XFILLER_93_286 VSS VDD FILLER2
XFILLER_94_798 VDD VSS FILLER4
XTAP_TAPCELL_ROW_144_1451 VDD VSS WELLTAP
XTAP_TAPCELL_ROW_144_1462 VDD VSS WELLTAP
XTAP_TAPCELL_ROW_92_933 VDD VSS WELLTAP
X_19526_ _19543_/CK _19526_/D _19526_/Q VDD VSS DFFQX1
X_16738_ _16748_/A _16738_/B VDD VSS _19588_/D NOR2X1
X_14999_ wire161/Y _15000_/B _15000_/D _15000_/C VDD VSS _15054_/B OAOI211X1
XFILLER_46_180 VDD VSS DECAPHV8
XTAP_TAPCELL_ROW_64_657 VDD VSS WELLTAP
XFILLER_22_526 VDD VSS FILLER1
X_19457_ _19643_/CK _19457_/D _19457_/Q VDD VSS DFFQX1
X_16669_ _16669_/A VDD VSS _16867_/B INVX1
XFILLER_50_857 VSS VDD FILLER2
XFILLER_61_183 VSS VDD FILLER2
XFILLER_98_0 VSS VDD FILLER2
X_09210_ _18525_/Q VDD VSS _18424_/D INVX1
X_19388_ _19435_/CK _19388_/D _19388_/Q VDD VSS DFFQX1
X_18408_ _18420_/CK _18525_/Q _20163_/A _09380_/B VDD VSS DFFRQX1
XFILLER_50_879 VDD VSS FILLER4
X_18339_ _18343_/CK _18339_/D _18339_/Q _18373_/RB VDD VSS DFFRQX1
XFILLER_107_108 VSS VDD FILLER2
XFILLER_135_428 VSS VDD FILLER2
XFILLER_104_815 VDD VSS FILLER4
XFILLER_103_325 VDD VSS DECAPHV8
XFILLER_104_848 VSS VDD FILLER2
XFILLER_115_185 VDD VSS FILLER1
XFILLER_89_515 VDD VSS FILLER4
X_20163_ _20163_/A VDD VSS _20163_/Y BUFX3
XFILLER_57_412 VDD VSS DECAPHV8
X_20094_ _20094_/A VDD VSS _20094_/Y BUFX3
XFILLER_85_743 VDD VSS FILLER1
XFILLER_97_592 VDD VSS FILLER1
XFILLER_38_681 VDD VSS FILLER1
XFILLER_72_426 VDD VSS DECAPHV16
XFILLER_41_802 VDD VSS DECAPHV16
XTAP_TAPCELL_ROW_108_1092 VDD VSS WELLTAP
XFILLER_111_76 VDD VSS DECAPHV8
XFILLER_40_334 VDD VSS FILLER1
XFILLER_52_194 VDD VSS FILLER1
XFILLER_80_492 VSS VDD FILLER2
XTAP_TAPCELL_ROW_35_370 VDD VSS WELLTAP
X_09408_ _09349_/B _20047_/Q _09408_/C _18279_/Q VDD VSS _09409_/C NAND4BX1
X_10680_ _19947_/Q _18829_/Q VDD VSS _10681_/C AND2X1
X_09339_ _18444_/D _09338_/Y _09302_/A VDD VSS _18513_/D MUXI2X1
XFILLER_138_266 VSS VDD FILLER2
X_12350_ _18903_/Q VDD VSS _12429_/A INVX1
XFILLER_107_620 VDD VSS FILLER1
XFILLER_5_747 VDD VSS DECAPHV8
X_11301_ _11302_/A _11302_/B VDD VSS _11312_/B NAND2X1
X_12281_ _19043_/Q VDD VSS _12361_/A INVX1
XFILLER_4_235 VDD VSS DECAPHV8
X_11232_ _11180_/Y _11255_/B _10947_/Y VDD VSS _11278_/B MUXI2X1
X_14020_ _14020_/A _14135_/B _14020_/C _14020_/D VDD VSS _14058_/A OAOI211X1
XFILLER_122_601 VSS VDD FILLER2
XFILLER_122_634 VDD VSS FILLER1
X_11163_ _18681_/Q _18789_/Q _11163_/C _11163_/D VDD VSS _11169_/C AO211X2
XFILLER_122_645 VDD VSS FILLER1
X_10114_ _18588_/Q _10138_/B VDD VSS _10127_/B XOR2X1
XFILLER_103_870 VDD VSS FILLER1
XFILLER_121_144 VDD VSS FILLER4
X_11094_ _19960_/Q _18842_/Q VDD VSS _11096_/B XNOR2X1
X_15971_ _15971_/A _15990_/A VDD VSS _16803_/B XNOR2X1
XFILLER_102_391 VSS VDD FILLER2
XFILLER_121_199 VSS VDD FILLER2
X_10045_ _10015_/Y _10044_/Y _10155_/A VDD VSS _10045_/Y MUXI2X1
X_18690_ _18773_/CK _18690_/D _18690_/Q VDD VSS DFFQX1
X_17710_ _17712_/C _17711_/B _17746_/C VDD VSS _17711_/C OAI21X1
X_14922_ _14966_/A _14966_/B VDD VSS _14928_/B NAND2X1
XFILLER_36_607 VDD VSS DECAPHV16
XFILLER_75_242 VDD VSS FILLER4
X_17641_ _17646_/C _17646_/B VDD VSS _17643_/B NAND2BX1
X_14853_ _14896_/B _14853_/B VDD VSS _18068_/B XNOR2X1
XFILLER_63_426 VSS VDD FILLER2
XFILLER_75_297 VDD VSS DECAPHV8
XFILLER_90_223 VDD VSS FILLER1
XFILLER_91_724 VDD VSS DECAPHV16
X_13804_ _14158_/A _17929_/B VDD VSS _18863_/D AND2X1
XFILLER_91_768 VDD VSS FILLER1
X_11996_ _19234_/Q _11996_/B _12050_/D VDD VSS _12099_/C XOR3X1
X_19311_ _19337_/CK _19311_/D _19311_/Q VDD VSS DFFQX1
X_17572_ _19874_/Q _19842_/Q _17572_/C VDD VSS _17577_/C AO21X2
X_14784_ _19501_/Q _15894_/B VDD VSS _14826_/A NOR2BX1
XTAP_TAPCELL_ROW_61_627 VDD VSS WELLTAP
X_10947_ _10947_/A VDD VSS _10947_/Y BUFX3
X_13735_ _19029_/Q _13735_/B VDD VSS _13736_/D _13735_/C NAND3X1
X_16523_ _19602_/Q _16753_/B _16523_/C VDD VSS _16548_/A OAI21X1
X_13666_ _14163_/A _17920_/B _17915_/B VDD VSS _18861_/D NOR3X1
X_19242_ _19242_/CK _19242_/D _19242_/Q VDD VSS DFFQX1
X_16454_ _16454_/A _16474_/B VDD VSS _16786_/B XOR2X1
X_10878_ _10808_/B _10877_/Y _10947_/A VDD VSS _10878_/Y MUXI2X1
X_12617_ _12617_/A _12617_/B _14182_/B VDD VSS _12708_/B MIN3X1
X_19173_ _19202_/CK _19173_/D _19173_/Q VDD VSS DFFQX1
X_15405_ _15405_/A _15433_/B VDD VSS _15849_/B XNOR2X1
X_13597_ _14227_/B _13682_/C _18972_/Q VDD VSS _13675_/C AND3BX1
X_18124_ _19291_/Q _18128_/B VDD VSS _18126_/B XOR2X1
X_16385_ _16889_/B _19725_/Q VDD VSS _16386_/C NOR2BX1
XFILLER_118_918 VDD VSS DECAPHV8
X_12548_ _12558_/A _14345_/B _12625_/C VDD VSS _14346_/C NOR3X1
X_15336_ _15689_/B VDD VSS _15337_/C INVX1
XANTENNA_2 _18455_/Q VDD VSS ANTENNA2
XFILLER_117_428 VDD VSS DECAPHV8
X_12479_ _19156_/Q _14439_/B VDD VSS _12480_/D _14439_/C NAND3X1
X_18055_ _18548_/Q _18055_/B VDD VSS _18056_/B XOR2X1
X_15267_ _19485_/Q _15877_/B VDD VSS _15281_/A AND2X1
XFILLER_125_450 VDD VSS DECAPHV8
XFILLER_144_269 VDD VSS FILLER1
X_14218_ _14218_/A _14218_/B VDD VSS _18967_/D NOR2X1
X_17006_ _17006_/A _17006_/B VDD VSS _17019_/B AND2X1
XFILLER_113_623 VDD VSS FILLER4
XFILLER_6_86 VDD VSS DECAPHV8
XFILLER_99_846 VDD VSS FILLER1
X_15198_ _15198_/A _15198_/B _15198_/C VDD VSS _15841_/C NOR3X1
XFILLER_98_345 VDD VSS DECAPHV8
X_14149_ _14154_/A _14149_/B VDD VSS _18905_/D NOR2X1
XFILLER_100_306 VDD VSS DECAPHV8
XFILLER_86_507 VDD VSS FILLER4
XFILLER_86_518 VSS VDD FILLER2
XFILLER_86_529 VDD VSS FILLER4
XTAP_TAPCELL_ROW_69_705 VDD VSS WELLTAP
Xclkbuf_0__09182_ _18231_/ECK VDD VSS clkbuf_0__09182_/Y BUFX12
X_18957_ _18970_/CK _18957_/D _18957_/Q VDD VSS DFFQX1
XFILLER_100_328 VDD VSS FILLER4
XFILLER_112_188 VDD VSS FILLER1
XFILLER_39_434 VDD VSS FILLER1
XFILLER_67_743 VDD VSS FILLER1
X_09690_ _18319_/Q _09769_/C _09690_/C _09690_/D VDD VSS _09693_/C AO211X2
X_17908_ _17906_/B _17911_/C _17908_/C VDD VSS _19949_/D AOI2B1X1
XFILLER_13_0 VDD VSS FILLER1
X_18888_ _18888_/CK _18888_/D _18888_/Q VDD VSS DFFQX1
XFILLER_39_489 VDD VSS DECAPHV16
XFILLER_82_724 VDD VSS FILLER4
XTAP_TAPCELL_ROW_77_782 VDD VSS WELLTAP
X_17839_ _19935_/Q _17842_/C _17917_/C VDD VSS _17840_/C OAI21X1
XFILLER_62_470 VDD VSS DECAPHV16
X_19509_ _19707_/CK _19509_/D _19509_/Q VDD VSS DFFQX1
XFILLER_50_621 VSS VDD FILLER2
XFILLER_10_507 VDD VSS FILLER4
XFILLER_50_676 VDD VSS FILLER1
XTAP_TAPCELL_ROW_32_340 VDD VSS WELLTAP
XFILLER_108_417 VDD VSS FILLER1
XFILLER_109_929 VDD VSS FILLER1
XFILLER_108_428 VDD VSS FILLER4
XFILLER_136_748 VDD VSS FILLER4
XFILLER_103_100 VSS VDD FILLER2
XFILLER_104_623 VDD VSS DECAPHV8
X_20215_ _20215_/A VDD VSS _20215_/Y BUFX3
XFILLER_103_133 VDD VSS FILLER4
XFILLER_106_21 VDD VSS FILLER1
XFILLER_131_464 VDD VSS FILLER1
X_20146_ _20146_/A VDD VSS _20146_/Y BUFX3
XFILLER_58_743 VDD VSS FILLER1
XFILLER_66_36 VDD VSS FILLER4
X_20077_ _20079_/CK _20077_/D _20077_/Q _20080_/RB VDD VSS DFFRQX1
XFILLER_18_607 VDD VSS FILLER4
XFILLER_46_916 VDD VSS DECAPHV8
X_09888_ _11435_/B _11196_/A VDD VSS _09928_/A NOR2X1
XFILLER_17_117 VDD VSS FILLER1
X_11850_ _19173_/Q VDD VSS _11852_/A INVX1
XFILLER_32_109 VDD VSS FILLER1
XFILLER_60_429 VDD VSS FILLER4
X_10801_ _10801_/A _10801_/B _10801_/C _10801_/D VDD VSS _10871_/B OAI211X1
X_11781_ _19229_/Q _11781_/B _11804_/C VDD VSS _11828_/B XNOR3X1
XFILLER_26_695 VSS VDD FILLER2
X_10732_ _10945_/A _10747_/A _10747_/B _10747_/C VDD VSS _10807_/B AND4X2
X_13520_ _19027_/Q VDD VSS _13599_/A INVX1
Xclkbuf_1_0__f__09171_ clkbuf_0__09171_/Y VDD VSS _18342_/CK BUFX12
XFILLER_15_51 VSS VDD FILLER2
XFILLER_40_142 VSS VDD FILLER2
XFILLER_41_654 VSS VDD FILLER2
X_09961__231 _20054_/CK VDD VSS _18508_/CK INVX1
X_10663_ _18561_/Q _10670_/B VDD VSS _10668_/A XOR2X1
X_13451_ _13451_/A _14449_/B _13542_/C VDD VSS _14451_/C NOR3X1
X_10594_ _10594_/A _10594_/B VDD VSS _10666_/A NOR2X1
X_12402_ _12402_/A _12402_/B _19238_/Q VDD VSS _12405_/C OAI21X1
X_13382_ _18006_/C VDD VSS _15383_/A BUFX3
X_16170_ _19717_/Q _16881_/B VDD VSS _16173_/B XNOR2X1
X_12333_ _19127_/Q _12333_/B _12471_/D VDD VSS _12380_/C XNOR3X1
X_15121_ _19370_/Q _15747_/B VDD VSS _15134_/B NOR2X1
XTAP_TAPCELL_ROW_2_32 VDD VSS WELLTAP
X_15052_ _15052_/A _15052_/B _15108_/B _15052_/D VDD VSS _15872_/C AO22X2
XFILLER_135_781 VSS VDD FILLER2
XFILLER_5_588 VSS VDD FILLER2
XTAP_TAPCELL_ROW_130_1314 VDD VSS WELLTAP
X_12264_ _12278_/A _12278_/B _14246_/B VDD VSS _14209_/B XNOR3X1
X_14003_ _14013_/A _14004_/B _14004_/C VDD VSS _14233_/B OR3BX1
X_11215_ _11215_/A _11222_/B VDD VSS _11220_/B XNOR2X1
X_12195_ _12197_/A _12197_/B _14145_/B VDD VSS _14113_/B XNOR3X1
X_19860_ _19892_/CK _19860_/D _19860_/Q VDD VSS DFFQX1
Xoutput50 _20132_/Y VDD VSS o_bias_cfg[34] BUFX3
Xoutput61 _20145_/Y VDD VSS o_clk_cfg[12] BUFX3
XFILLER_110_615 VSS VDD FILLER2
X_11146_ _18707_/Q _18761_/Q _11146_/C VDD VSS _11167_/B MIN3X1
X_19791_ _19792_/CK _19791_/D _19791_/Q VDD VSS DFFQX1
Xoutput72 _20138_/Y VDD VSS o_clk_cfg[5] BUFX3
Xoutput83 _20157_/Y VDD VSS o_en_ctrl[5] BUFX3
Xoutput94 _20178_/Y VDD VSS o_lf_cfg[15] BUFX3
X_18811_ _18811_/CK _18811_/D _18811_/Q VDD VSS DFFQX1
XFILLER_110_626 VSS VDD FILLER2
XFILLER_122_486 VSS VDD FILLER2
XFILLER_122_497 VDD VSS DECAPHV8
X_11077_ _11226_/A _11077_/B _11077_/C VDD VSS _11078_/D OAI21X1
X_18742_ _18797_/CK _18742_/D _18742_/Q VDD VSS DFFQX1
X_15954_ _19644_/Q _16801_/B VDD VSS _15977_/B XOR2X1
X_10028_ _18580_/Q _10042_/C VDD VSS _10029_/B NAND2X1
X_14905_ _19421_/Q VDD VSS _14910_/A INVX1
XFILLER_49_787 VDD VSS FILLER1
X_18673_ _18809_/CK _18673_/D _18673_/Q VDD VSS DFFQX1
X_15885_ _16768_/A _15885_/B VDD VSS _19492_/D AND2X1
XFILLER_56_91 VDD VSS DECAPHV16
XFILLER_64_779 VDD VSS FILLER4
XTAP_TAPCELL_ROW_128_1298 VDD VSS WELLTAP
X_17624_ _19886_/Q _19854_/Q VDD VSS _17627_/A XNOR2X1
X_14836_ _14837_/A _14837_/B _14837_/C VDD VSS _14839_/B OAI21X1
XFILLER_17_662 VDD VSS FILLER4
XFILLER_63_278 VDD VSS FILLER1
XFILLER_91_587 VSS VDD FILLER2
XTAP_TAPCELL_ROW_141_1421 VDD VSS WELLTAP
XTAP_TAPCELL_ROW_46_476 VDD VSS WELLTAP
XTAP_TAPCELL_ROW_74_752 VDD VSS WELLTAP
X_17555_ _17675_/A _17555_/B VDD VSS _19871_/D NOR2X1
X_14767_ _15383_/A VDD VSS _15297_/A BUFX3
XFILLER_17_695 VDD VSS FILLER1
XFILLER_60_930 VSS VDD FILLER2
X_11979_ _11979_/A _14490_/B _11979_/C _11979_/D VDD VSS _11985_/A OAOI211X1
X_13718_ _19142_/Q _14424_/B VDD VSS _13791_/B XNOR2X1
X_16506_ _19666_/Q _16824_/B VDD VSS _16507_/B XOR2X1
XFILLER_32_665 VDD VSS DECAPHV8
X_17486_ _17488_/A _17488_/B _17486_/C VDD VSS _19856_/D AOI21X1
X_14698_ _19416_/Q _14698_/B _14698_/C VDD VSS _14730_/B MIN3X1
XFILLER_20_849 VDD VSS DECAPHV8
X_13649_ _19056_/Q _13649_/B VDD VSS _13733_/D _13649_/C NAND3X1
X_19225_ _19988_/CK _19225_/D _19225_/Q VDD VSS DFFQX1
X_16437_ _16437_/A _16437_/B _16437_/C VDD VSS _16438_/B OR3X2
XFILLER_9_861 VDD VSS FILLER1
X_19156_ _19182_/CK _19156_/D _19156_/Q VDD VSS DFFQX1
X_16368_ _16368_/A _16368_/B VDD VSS _16369_/C NAND2X1
X_19087_ _19115_/CK _19087_/D _19087_/Q VDD VSS DFFQX1
X_18107_ _19288_/Q _18107_/B VDD VSS _18112_/A NOR2X1
X_15319_ _19487_/Q _15879_/B VDD VSS _15364_/B XNOR2X1
X_18038_ _18540_/Q _18038_/B VDD VSS _18039_/C NOR2X1
X_16299_ _16299_/A _16307_/B VDD VSS _16886_/B XNOR2X1
XFILLER_132_239 VSS VDD FILLER2
XFILLER_59_507 VDD VSS DECAPHV8
XFILLER_98_142 VDD VSS DECAPHV8
XFILLER_99_698 VSS VDD FILLER2
X_09811_ _18439_/Q _09811_/B _09811_/C _18375_/Q _09811_/E VDD VSS _09817_/A AOI221X1
X_20000_ _20008_/CK _20000_/D _20000_/Q VDD VSS DFFQX1
XFILLER_140_272 VDD VSS FILLER1
XFILLER_86_315 VSS VDD FILLER2
XFILLER_98_175 VDD VSS FILLER4
X_09742_ _18450_/Q _09751_/B _09772_/B _18354_/Q VDD VSS _09744_/A OAI22X1
X_19989_ _19992_/CK _19989_/D _19989_/Q VDD VSS DFFQX1
Xclkbuf_0__09165_ _18214_/ECK VDD VSS clkbuf_0__09165_/Y BUFX12
XFILLER_28_949 VDD VSS FILLER1
X_09673_ _18446_/Q _09816_/B _09673_/C _18414_/Q VDD VSS _09674_/E OAI22X1
XFILLER_82_532 VSS VDD FILLER2
XFILLER_82_554 VDD VSS FILLER1
XFILLER_54_267 VSS VDD FILLER2
XFILLER_23_621 VDD VSS DECAPHV16
XTAP_TAPCELL_ROW_105_1062 VDD VSS WELLTAP
XFILLER_50_473 VDD VSS DECAPHV8
XFILLER_109_715 VSS VDD FILLER2
XFILLER_108_247 VDD VSS FILLER1
XFILLER_105_921 VDD VSS FILLER1
XTAP_TAPCELL_ROW_9_102 VDD VSS WELLTAP
XTAP_TAPCELL_ROW_116_1180 VDD VSS WELLTAP
XFILLER_120_902 VDD VSS FILLER1
XFILLER_132_773 VDD VSS FILLER1
XFILLER_89_164 VDD VSS FILLER4
X_11000_ _18704_/Q _18758_/Q VDD VSS _11043_/B XOR2X1
XFILLER_131_261 VSS VDD FILLER2
XFILLER_77_68 VDD VSS DECAPHV16
X_20129_ _20129_/A VDD VSS _20129_/Y BUFX3
XFILLER_18_415 VSS VDD FILLER2
XFILLER_19_949 VDD VSS FILLER1
XFILLER_58_573 VDD VSS FILLER4
XFILLER_86_882 VDD VSS FILLER1
XTAP_TAPCELL_ROW_88_899 VDD VSS WELLTAP
X_12951_ _12951_/A _12951_/B _12951_/C _12951_/D VDD VSS _14510_/C AOAI211X1
XFILLER_133_96 VSS VDD FILLER2
XFILLER_73_521 VDD VSS FILLER4
XFILLER_93_34 VSS VDD FILLER2
X_11902_ _19064_/Q _11959_/B _11953_/C VDD VSS _11907_/C XNOR3X1
X_12882_ _18882_/Q VDD VSS _13077_/A INVX1
X_15670_ _15703_/B VDD VSS _15671_/B INVX1
XFILLER_45_267 VDD VSS FILLER1
XFILLER_61_727 VDD VSS DECAPHV16
XFILLER_73_576 VDD VSS FILLER1
XFILLER_73_587 VDD VSS FILLER4
X_11833_ _11876_/A _14524_/B VDD VSS _11979_/A NOR2X1
X_14621_ _15859_/A _15858_/A _15858_/B VDD VSS _14658_/A NOR3X1
XFILLER_60_226 VDD VSS FILLER1
XTAP_TAPCELL_ROW_71_722 VDD VSS WELLTAP
X_17340_ _19825_/Q _19793_/Q VDD VSS _17346_/B NAND2X1
XFILLER_14_643 VDD VSS FILLER1
XTAP_TAPCELL_ROW_43_446 VDD VSS WELLTAP
X_11764_ _19200_/Q _11764_/B VDD VSS _11797_/C _11764_/C NAND3X1
X_14552_ _19992_/Q _14558_/B VDD VSS _19256_/D AND2X1
XFILLER_13_153 VDD VSS FILLER4
X_10715_ _10715_/A _10715_/B _10715_/C _10715_/D VDD VSS _10717_/C AO211X2
X_11695_ _19989_/Q _19253_/Q VDD VSS _11716_/D XOR2X1
X_13503_ _13662_/A _13662_/B VDD VSS _13572_/B NOR2X1
X_14483_ _14493_/A _14483_/B VDD VSS _19196_/D NOR2X1
X_17271_ _17536_/A _17271_/B _17272_/C VDD VSS _19810_/D NOR3X1
XTAP_TAPCELL_ROW_119_1209 VDD VSS WELLTAP
X_10646_ _18694_/Q _18748_/Q VDD VSS _10729_/C XOR2X1
X_13434_ _19137_/Q _14417_/B VDD VSS _13616_/C _14417_/C AND3X2
X_19010_ _19040_/CK _19010_/D _19010_/Q VDD VSS DFFQX1
X_16222_ _16222_/A _16222_/B _16222_/C VDD VSS _16225_/B OAI21X1
XFILLER_10_860 VSS VDD FILLER2
XFILLER_127_512 VSS VDD FILLER2
X_16153_ _16809_/B _19652_/Q VDD VSS _16154_/C NOR2BX1
X_10577_ _10642_/B _10577_/B _10721_/D VDD VSS _10578_/D OR3BX1
X_13365_ _13365_/A _13365_/B _13365_/C _13365_/D VDD VSS _14355_/B OAI211X1
X_15104_ _19509_/Q _15104_/B VDD VSS _15191_/D NAND2X1
XFILLER_6_875 VDD VSS DECAPHV8
XFILLER_6_886 VDD VSS DECAPHV8
X_12316_ _12407_/A _14531_/B VDD VSS _14532_/A _12397_/C NAND3X1
X_13296_ _13402_/A _13391_/B VDD VSS _14191_/B XNOR2X1
X_16084_ _19585_/Q VDD VSS _16085_/A INVX1
X_12247_ _12372_/A _12372_/C _12372_/B VDD VSS _14404_/C AO21X2
X_19912_ clkload9/A _19912_/D _19912_/Q VDD VSS DFFQX1
X_15035_ _19312_/Q VDD VSS _15036_/A INVX1
XFILLER_68_304 VSS VDD FILLER2
X_19843_ _19843_/CK _19843_/D _19843_/Q VDD VSS DFFQX1
XFILLER_110_423 VDD VSS FILLER1
XFILLER_111_924 VDD VSS FILLER1
XFILLER_123_795 VDD VSS DECAPHV16
X_12178_ _19152_/Q VDD VSS _12181_/D INVX1
XFILLER_96_657 VSS VDD FILLER2
XFILLER_96_679 VDD VSS FILLER1
X_11129_ _11364_/B _11159_/A VDD VSS _11154_/A NAND2X1
X_19774_ _19843_/CK _19774_/D _19774_/Q VDD VSS DFFQX1
X_16986_ _16996_/A _16996_/D VDD VSS _16991_/C NAND2X1
XFILLER_36_201 VDD VSS FILLER4
XFILLER_49_584 VDD VSS FILLER4
XFILLER_76_370 VDD VSS FILLER1
XFILLER_95_189 VSS VDD FILLER2
X_18725_ _18779_/CK _18725_/D _18725_/Q VDD VSS DFFQX1
X_15937_ _19580_/Q _16729_/B _15937_/C VDD VSS _15960_/A OAI21X1
X_18656_ _19963_/CK _18656_/D _18656_/Q VDD VSS DFFQX1
X_15868_ _17010_/A _15868_/B _15868_/C VDD VSS _19477_/D NOR3X1
X_17607_ _17610_/A _17610_/B _17654_/C VDD VSS _17608_/C OAI21X1
X_14819_ _19475_/Q _15866_/B VDD VSS _14865_/D NAND2X1
XFILLER_33_941 VDD VSS FILLER4
X_18587_ _18595_/CK _18587_/D _18587_/Q VDD VSS DFFQX1
X_15799_ _15800_/A _15799_/B VDD VSS _19417_/D NOR2X1
X_17538_ _19868_/Q _19836_/Q VDD VSS _17539_/B XOR2X1
XFILLER_20_613 VDD VSS FILLER4
X_17469_ _17470_/C _17469_/B _17469_/C VDD VSS _19852_/D AND3BX1
XFILLER_80_0 VSS VDD FILLER2
X_19208_ _20006_/CK _19208_/D _19208_/Q VDD VSS DFFQX1
X_19139_ _19194_/CK _19139_/D _19139_/Q VDD VSS DFFQX1
XFILLER_133_515 VDD VSS FILLER1
XFILLER_114_740 VDD VSS DECAPHV16
XFILLER_86_101 VSS VDD FILLER2
X_09725_ _18449_/Q _09751_/B _09725_/C _09725_/D VDD VSS _09730_/B OAI211X1
XFILLER_83_830 VDD VSS FILLER1
XTAP_TAPCELL_ROW_85_869 VDD VSS WELLTAP
X_09656_ _18349_/Q _09787_/B VDD VSS _09657_/E NOR2X1
XFILLER_16_919 VDD VSS DECAPHV8
XFILLER_27_245 VDD VSS FILLER4
XFILLER_43_716 VDD VSS FILLER1
XFILLER_27_278 VDD VSS FILLER1
XFILLER_63_26 VSS VDD FILLER2
XFILLER_70_546 VDD VSS DECAPHV8
X_09587_ _20102_/A _20118_/A _09812_/C VDD VSS _09601_/B MUXI2X1
XFILLER_11_624 VDD VSS FILLER1
XFILLER_51_771 VDD VSS FILLER1
XTAP_TAPCELL_ROW_40_416 VDD VSS WELLTAP
XFILLER_137_4 VDD VSS DECAPHV16
X_10500_ _10512_/A _10500_/B _10500_/C _10511_/A VDD VSS _10501_/D OAOI211X1
XFILLER_109_512 VDD VSS DECAPHV16
XFILLER_137_832 VDD VSS FILLER4
X_11480_ _18636_/Q _11484_/B VDD VSS _18663_/D AND2X1
XFILLER_10_178 VDD VSS FILLER4
XFILLER_6_138 VDD VSS FILLER1
X_10431_ _10431_/A _10431_/B _10431_/C _11273_/A VDD VSS _10432_/B AOI31X1
X_10362_ _10417_/A _10417_/B _10417_/C _10362_/D VDD VSS _10363_/D AOI31X1
X_13150_ _13150_/A _13150_/B _13150_/C _13150_/D VDD VSS _13152_/C AOAI211X1
XFILLER_136_386 VSS VDD FILLER2
X_10293_ _10343_/A _10343_/B VDD VSS _10294_/C XNOR2X1
X_12101_ _12101_/A _12108_/C _12101_/C VDD VSS _12158_/B XNOR3X1
X_13081_ _18883_/Q _13081_/B _13081_/C VDD VSS _13287_/B MIN3X1
XFILLER_78_602 VSS VDD FILLER2
X_12032_ _12113_/A _12032_/B VDD VSS _14464_/B XNOR2X1
XFILLER_144_40 VDD VSS FILLER4
XFILLER_78_635 VSS VDD FILLER2
XFILLER_78_646 VDD VSS FILLER1
XFILLER_144_73 VDD VSS DECAPHV16
X_16840_ _16865_/A _16840_/B VDD VSS _19680_/D NOR2X1
XFILLER_65_307 VDD VSS FILLER1
XFILLER_92_115 VDD VSS FILLER1
X_13983_ _14019_/A _13983_/B _13983_/C VDD VSS _13995_/C XNOR3X1
X_16771_ _16795_/A VDD VSS _16793_/A BUFX3
XFILLER_19_757 VSS VDD FILLER2
X_12934_ _12940_/A _12940_/C _12940_/B VDD VSS _14444_/C AOI21X1
X_18510_ _18510_/CK _18510_/D _18510_/Q _09346_/Y VDD VSS DFFRQX1
X_15722_ _15725_/A _15722_/B VDD VSS _19348_/D AND2X1
X_19490_ _19492_/CK _19490_/D _19490_/Q VDD VSS DFFQX1
XFILLER_18_278 VDD VSS FILLER1
XTAP_TAPCELL_ROW_125_1268 VDD VSS WELLTAP
XTAP_TAPCELL_ROW_56_571 VDD VSS WELLTAP
X_12865_ _19049_/Q _12865_/B _12916_/C VDD VSS _13005_/B XNOR3X1
X_18441_ _18453_/CK _18441_/D _18441_/Q _18444_/RB VDD VSS DFFRQX1
X_15653_ _15653_/A VDD VSS _15763_/B INVX1
XFILLER_61_546 VDD VSS FILLER4
XTAP_TAPCELL_ROW_28_295 VDD VSS WELLTAP
XTAP_TAPCELL_ROW_8_97 VDD VSS WELLTAP
X_11816_ _19090_/Q _11816_/B _11816_/C VDD VSS _11943_/B MIN3X1
X_12796_ _18964_/Q _12796_/B _14215_/B VDD VSS _12891_/A MIN3X1
X_14604_ _19520_/Q _19519_/Q _19521_/Q _19522_/Q VDD VSS _14649_/C AND4X2
X_18372_ _18375_/CK _18372_/D _18372_/Q _18492_/RB VDD VSS DFFRQX1
X_15584_ _15584_/A _15595_/B VDD VSS _15729_/B XNOR2X1
X_11747_ _11769_/A _11769_/B _11769_/C VDD VSS _11749_/B AOI21X1
X_14535_ _15806_/A _14535_/B _14535_/C VDD VSS _19241_/D NOR3X1
X_17323_ _17325_/C _17323_/B _17323_/C VDD VSS _19821_/D AOI21X1
XFILLER_30_944 VSS VDD FILLER2
XFILLER_42_793 VDD VSS DECAPHV16
X_17254_ _19807_/Q _19775_/Q VDD VSS _17255_/B XOR2X1
XFILLER_128_821 VDD VSS FILLER1
X_11678_ _18815_/Q _14547_/B VDD VSS _18842_/D AND2X1
X_14466_ _14421_/Y _14466_/B _14466_/C VDD VSS _19180_/D AND3BX1
X_16205_ _19622_/Q _16205_/B _16775_/B VDD VSS _16230_/A MIN3X1
XFILLER_127_320 VDD VSS DECAPHV8
XFILLER_128_854 VDD VSS FILLER1
X_10629_ _11431_/A _10629_/B VDD VSS _18560_/D AND2X1
X_13417_ _19082_/Q VDD VSS _13427_/A INVX1
X_14397_ _14426_/A _14397_/B VDD VSS _19118_/D NOR2X1
X_17185_ _19791_/Q _19759_/Q _17185_/C VDD VSS _17189_/B MIN3X1
XFILLER_127_375 VDD VSS FILLER4
XFILLER_143_824 VDD VSS DECAPHV8
XTAP_TAPCELL_ROW_136_1375 VDD VSS WELLTAP
X_13348_ _20013_/Q _19277_/Q _14544_/A VDD VSS _14545_/B AOI21X1
X_16136_ _19907_/Q VDD VSS _16701_/A INVX1
XFILLER_127_397 VSS VDD FILLER2
X_16067_ _19617_/Q _16769_/B VDD VSS _16083_/B XNOR2X1
X_13279_ _18941_/Q _13391_/A _13391_/B VDD VSS _13290_/C XNOR3X1
X_15018_ _19506_/Q _15018_/B VDD VSS _15056_/B NOR2X1
XFILLER_123_581 VDD VSS DECAPHV8
XFILLER_38_2 VDD VSS FILLER1
XFILLER_96_421 VDD VSS FILLER4
XFILLER_97_944 VDD VSS FILLER4
XFILLER_57_819 VDD VSS DECAPHV8
XFILLER_96_432 VDD VSS DECAPHV8
X_19826_ _19828_/CK _19826_/D _19826_/Q VDD VSS DFFQX1
XFILLER_96_465 VDD VSS FILLER4
X_19757_ _19795_/CK _19757_/D _19757_/Q VDD VSS DFFQX1
XFILLER_110_297 VDD VSS DECAPHV8
XFILLER_37_510 VDD VSS DECAPHV16
XFILLER_49_381 VDD VSS FILLER1
X_09510_ _20071_/Q _20070_/Q _09510_/C VDD VSS _20071_/D AOI21X1
X_18708_ _19937_/CK _18708_/D _18708_/Q VDD VSS DFFQX1
X_16969_ _16971_/B _16969_/B VDD VSS _16970_/B XOR2X1
XFILLER_80_800 VDD VSS FILLER1
X_19688_ _19736_/CK _19688_/D _19688_/Q VDD VSS DFFQX1
XFILLER_64_373 VDD VSS FILLER1
XFILLER_80_833 VDD VSS FILLER1
XFILLER_92_682 VSS VDD FILLER2
XTAP_TAPCELL_ROW_82_839 VDD VSS WELLTAP
X_09441_ _09447_/B _09772_/B VDD VSS _18218_/E NOR2X1
X_18639_ _18828_/CK _18639_/D _18639_/Q VDD VSS DFFQX1
XFILLER_80_866 VSS VDD FILLER2
X_09372_ _09770_/B _09426_/A VDD VSS _09482_/C NOR2BX1
XFILLER_21_922 VDD VSS FILLER1
XTAP_TAPCELL_ROW_102_1032 VDD VSS WELLTAP
XFILLER_138_607 VSS VDD FILLER2
XFILLER_106_537 VDD VSS FILLER4
XFILLER_133_334 VDD VSS DECAPHV8
XTAP_TAPCELL_ROW_113_1150 VDD VSS WELLTAP
XFILLER_102_710 VSS VDD FILLER2
XFILLER_58_26 VSS VDD FILLER2
XFILLER_75_638 VSS VDD FILLER2
XTAP_TAPCELL_ROW_98_994 VDD VSS WELLTAP
XFILLER_114_76 VSS VDD FILLER2
XFILLER_28_510 VDD VSS FILLER1
XFILLER_74_137 VSS VDD FILLER2
X_09708_ _18464_/Q _09784_/B _09769_/C _20090_/A _09708_/E VDD VSS _09717_/B AOI221X1
X_10980_ _11001_/C _10980_/B VDD VSS _10981_/C XNOR2X1
XFILLER_16_727 VDD VSS FILLER1
XFILLER_43_513 VDD VSS FILLER4
X_09639_ _20086_/A _09815_/C VDD VSS _09641_/C NAND2X1
XFILLER_43_557 VDD VSS FILLER1
XFILLER_70_354 VDD VSS FILLER1
XFILLER_71_855 VDD VSS DECAPHV8
XTAP_TAPCELL_ROW_53_541 VDD VSS WELLTAP
X_12650_ _12771_/A _12771_/B VDD VSS _14442_/B XNOR2X1
XTAP_TAPCELL_ROW_25_265 VDD VSS WELLTAP
X_11601_ _11648_/A VDD VSS _11612_/B BUFX3
XFILLER_11_432 VDD VSS FILLER1
X_12581_ _12837_/A _12837_/B _12837_/D VDD VSS _12648_/B AOI21X1
X_14320_ _14352_/A _14320_/B _14320_/C VDD VSS _19050_/D NOR3X1
XFILLER_128_106 VSS VDD FILLER2
XFILLER_8_926 VSS VDD FILLER2
X_11532_ _16860_/A VDD VSS _11542_/B BUFX3
XFILLER_128_0 VDD VSS FILLER1
X_11463_ _19955_/Q _11473_/B VDD VSS _18648_/D AND2X1
X_14251_ _14251_/A _14251_/B VDD VSS _18991_/D NOR2X1
XFILLER_109_342 VDD VSS DECAPHV8
X_10414_ _10460_/A _10460_/B wire170/A VDD VSS _10414_/Y OAI21X1
X_13202_ _18996_/Q _13373_/A _13373_/B VDD VSS _13203_/D XNOR3X1
X_14182_ _14186_/A _14182_/B VDD VSS _18934_/D NOR2X1
XFILLER_109_386 VDD VSS FILLER4
XFILLER_124_323 VSS VDD FILLER2
XFILLER_125_835 VSS VDD FILLER2
XFILLER_136_183 VDD VSS FILLER1
X_11394_ _09932_/B _18596_/Q VDD VSS _11395_/C NOR2BX1
X_13133_ _13133_/A _13133_/B _13133_/C VDD VSS _14511_/C AOI21X1
XFILLER_124_345 VDD VSS FILLER4
XFILLER_140_805 VSS VDD FILLER2
X_10345_ _10345_/A _10345_/B VDD VSS _10359_/B _10345_/C _10345_/D OR4X1
X_18990_ _18993_/CK _18990_/D _18990_/Q VDD VSS DFFQX1
XFILLER_140_827 VSS VDD FILLER2
XFILLER_97_229 VDD VSS FILLER4
X_10276_ _10272_/Y _10312_/B _11431_/A VDD VSS _18551_/D AND3BX1
X_13064_ _19163_/Q _13122_/B _13138_/C VDD VSS _13315_/B XNOR3X1
X_17941_ _17941_/A _17941_/B _17941_/C _17941_/D VDD VSS _17946_/A OAOI211X1
X_12015_ _12015_/A _12015_/B _14305_/B VDD VSS _12016_/B MIN3X1
X_17872_ _17876_/C _17872_/B VDD VSS _17874_/B NOR2BX1
XFILLER_120_573 VSS VDD FILLER2
XFILLER_38_307 VSS VDD FILLER2
XFILLER_38_318 VDD VSS FILLER4
XFILLER_48_70 VDD VSS FILLER1
XFILLER_93_402 VDD VSS FILLER1
X_19611_ _19643_/CK _19611_/D _19611_/Q VDD VSS DFFQX1
X_16823_ _16826_/A _16823_/B VDD VSS _19665_/D NOR2X1
XFILLER_46_351 VSS VDD FILLER2
XFILLER_93_468 VDD VSS DECAPHV8
X_13966_ _19033_/Q _14301_/A _14301_/B VDD VSS _14010_/B AND3BX1
X_19542_ _19716_/CK _19542_/D _19542_/Q VDD VSS DFFQX1
X_16754_ _16759_/A _16754_/B VDD VSS _19603_/D NOR2X1
XFILLER_46_373 VDD VSS DECAPHV8
XFILLER_62_844 VDD VSS DECAPHV8
X_12917_ _19049_/Q _14319_/B _14319_/C VDD VSS _13005_/D NOR3BX1
X_13897_ _13903_/A _13903_/B _13951_/C VDD VSS _14266_/C NOR3X1
X_19473_ _19489_/CK _19473_/D _19473_/Q VDD VSS DFFQX1
X_16685_ _16685_/A _16685_/B VDD VSS _16868_/B XNOR2X1
X_15705_ _15710_/A _15705_/B VDD VSS _19333_/D NOR2X1
X_12848_ _12951_/A _12951_/B _12951_/C VDD VSS _12854_/B AOI21X1
X_18424_ _18439_/CK _18424_/D _18424_/Q _20078_/RB VDD VSS DFFRQX1
X_15636_ _19356_/Q _15731_/B VDD VSS _15637_/C NOR2BX1
X_12779_ _12801_/A _12801_/B _12801_/C VDD VSS _12779_/Y AOI21X1
X_18355_ _18359_/CK _18520_/Q _20223_/A _20065_/RB VDD VSS DFFRQX1
X_15567_ _19381_/Q _15758_/B VDD VSS _15568_/C NOR2BX1
X_14518_ _14539_/A _14518_/B VDD VSS _19225_/D NOR2X1
X_18286_ _18295_/CK _18286_/D _18286_/Q VDD VSS DFFQX1
X_17306_ _17309_/A _17309_/B _17306_/C VDD VSS _17307_/C OAI21X1
X_15498_ _15498_/A _15498_/B _15693_/B VDD VSS _15502_/C MIN3X1
X_14449_ _14449_/A _14449_/B _14449_/C VDD VSS _19165_/D NOR3X1
X_17237_ _17536_/A _17237_/B _17238_/C VDD VSS _19803_/D NOR3X1
X_17168_ _17168_/A _17168_/B _17168_/C _17168_/D VDD VSS _17169_/C AOAI211X1
XFILLER_143_632 VSS VDD FILLER2
X_16119_ _19651_/Q _16808_/B VDD VSS _16131_/B XOR2X1
XFILLER_142_142 VDD VSS FILLER1
X_09990_ _10034_/A _09990_/B _09990_/C VDD VSS _09993_/B OAI21X1
X_17099_ _19774_/Q _19742_/Q VDD VSS _17100_/B XOR2X1
XFILLER_130_348 VDD VSS DECAPHV8
XFILLER_111_573 VDD VSS DECAPHV8
X_19809_ clkload2/A _19809_/D _19809_/Q VDD VSS DFFQX1
XFILLER_56_137 VSS VDD FILLER2
XFILLER_84_457 VDD VSS FILLER4
XTAP_TAPCELL_ROW_95_964 VDD VSS WELLTAP
XTAP_TAPCELL_ROW_67_688 VDD VSS WELLTAP
XFILLER_25_557 VDD VSS FILLER1
X_09424_ _09626_/C VDD VSS _09819_/A BUFX3
XFILLER_100_12 VDD VSS FILLER1
XFILLER_52_354 VSS VDD FILLER2
XFILLER_80_663 VSS VDD FILLER2
XFILLER_100_45 VDD VSS FILLER1
XTAP_TAPCELL_ROW_50_511 VDD VSS WELLTAP
X_09355_ _09753_/A input2/Y _09354_/Y VDD VSS _18508_/D MUX2X1
XFILLER_100_67 VDD VSS FILLER4
XFILLER_139_949 VDD VSS FILLER1
XTAP_TAPCELL_ROW_22_235 VDD VSS WELLTAP
X_09286_ _09256_/C _20046_/Q _18258_/Q VDD VSS _09301_/B NOR3BX1
XFILLER_21_796 VDD VSS FILLER1
XFILLER_60_49 VDD VSS DECAPHV32
XFILLER_118_150 VDD VSS FILLER4
XFILLER_125_109 VDD VSS DECAPHV8
XFILLER_107_846 VSS VDD FILLER2
XFILLER_69_36 VDD VSS DECAPHV8
XFILLER_79_207 VDD VSS FILLER4
X_10130_ _10166_/D _10130_/B _10130_/C VDD VSS _10130_/Y AOI21X1
X_10061_ _18605_/Q _10062_/B VDD VSS _10075_/D NAND2BX1
XFILLER_0_667 VDD VSS DECAPHV8
XFILLER_125_53 VDD VSS FILLER4
XFILLER_125_86 VDD VSS FILLER4
XFILLER_130_860 VDD VSS FILLER1
XFILLER_47_104 VSS VDD FILLER2
XTAP_TAPCELL_ROW_58_600 VDD VSS WELLTAP
XFILLER_47_159 VDD VSS FILLER1
X_13820_ _18919_/Q _14166_/B _14166_/C VDD VSS _13821_/D OR3BX1
XFILLER_56_671 VDD VSS FILLER4
X_10963_ _18649_/Q _18811_/Q VDD VSS _10964_/B XOR2X1
X_13751_ _13751_/A _13751_/B _13751_/C _13751_/D VDD VSS _14131_/C OAI211X1
XFILLER_141_96 VDD VSS FILLER1
X_12702_ _17861_/A _17862_/A _14118_/B VDD VSS _12703_/B MIN3X1
X_16470_ _19664_/Q _16822_/B _16470_/C VDD VSS _16494_/A OAI21X1
XFILLER_16_568 VDD VSS DECAPHV8
XTAP_TAPCELL_ROW_122_1238 VDD VSS WELLTAP
X_10894_ _10931_/A _10895_/B VDD VSS _10895_/C NOR2X1
X_13682_ _18972_/Q _13682_/B VDD VSS _13688_/C _13682_/C NAND3X1
X_15421_ _19321_/Q _15692_/B VDD VSS _15422_/C AND2X1
X_12633_ _19101_/Q _14378_/B _14378_/C VDD VSS _12634_/D OR3BX1
XFILLER_129_426 VDD VSS FILLER4
XTAP_TAPCELL_ROW_5_65 VDD VSS WELLTAP
X_12564_ _12643_/A _12643_/B _12643_/C VDD VSS _12591_/B AOI21X1
X_18140_ _19294_/Q _18143_/B VDD VSS _18141_/B XOR2X1
X_15352_ _19487_/Q _15879_/B VDD VSS _15364_/D NAND2X1
XFILLER_11_262 VDD VSS DECAPHV16
X_11515_ _18668_/Q _11519_/B VDD VSS _18695_/D AND2X1
X_14303_ _14334_/A _14303_/B VDD VSS _19035_/D AND2X1
X_18071_ _18074_/A _18074_/B VDD VSS _18072_/B XNOR2X1
X_15283_ _19458_/Q _15306_/B VDD VSS _15285_/A XNOR2X1
XFILLER_7_233 VDD VSS FILLER4
X_12495_ _12499_/A _12499_/B _12499_/C _12495_/D VDD VSS _14534_/B OAOI211X1
X_14234_ _15383_/A VDD VSS _14270_/A BUFX3
Xwire153 wire153/A VDD VSS wire153/Y BUFX4
Xwire164 wire164/A VDD VSS wire164/Y BUFX6
X_17022_ _17024_/B _17022_/B VDD VSS _17030_/A NAND2BX1
XFILLER_50_82 VSS VDD FILLER2
X_11446_ _19941_/Q _17990_/A VDD VSS _18634_/D AND2X1
XFILLER_4_940 VSS VDD FILLER2
XTAP_TAPCELL_ROW_133_1345 VDD VSS WELLTAP
X_11377_ _11381_/B _11377_/B VDD VSS _11378_/C NOR2BX1
X_14165_ _17812_/A VDD VSS _14219_/A BUFX3
XFILLER_3_472 VDD VSS DECAPHV16
X_10328_ _10329_/A _10329_/B _10329_/D _10329_/C VDD VSS _10328_/Y AOI211X1
X_13116_ _13161_/A _13161_/B _13161_/C _13116_/D VDD VSS _13364_/A AOAI211X1
X_14096_ _14096_/A _14104_/B VDD VSS _14141_/B XOR2X1
X_18973_ _19001_/CK _18973_/D _18973_/Q VDD VSS DFFQX1
XFILLER_140_668 VDD VSS FILLER4
X_13047_ _13054_/A _13054_/B _13047_/C _13054_/D VDD VSS _14540_/A OAI211X1
X_17924_ _18863_/Q _17924_/B _17924_/C VDD VSS _17927_/D XNOR3X1
XFILLER_59_91 VSS VDD FILLER2
XFILLER_94_700 VDD VSS FILLER4
X_10259_ _11438_/A _11435_/B _11435_/A VDD VSS _10263_/A AND3BX1
X_17855_ _17868_/C _17855_/B VDD VSS _17857_/C NOR2BX1
XFILLER_93_232 VSS VDD FILLER2
XFILLER_93_254 VDD VSS FILLER4
XFILLER_93_265 VDD VSS FILLER1
X_17786_ _19921_/Q _19889_/Q VDD VSS _17793_/C NOR2X1
X_16806_ _16811_/A _16806_/B VDD VSS _19649_/D NOR2X1
XFILLER_19_384 VDD VSS FILLER4
XFILLER_93_298 VDD VSS DECAPHV8
XTAP_TAPCELL_ROW_144_1452 VDD VSS WELLTAP
XTAP_TAPCELL_ROW_92_934 VDD VSS WELLTAP
X_19525_ _19716_/CK _19525_/D _19525_/Q VDD VSS DFFQX1
X_16737_ _16776_/A VDD VSS _16748_/A BUFX3
X_14998_ _19424_/Q VDD VSS _15044_/A INVX1
XFILLER_19_395 VSS VDD FILLER2
XTAP_TAPCELL_ROW_144_1463 VDD VSS WELLTAP
XTAP_TAPCELL_ROW_64_658 VDD VSS WELLTAP
X_13949_ _13949_/A _13949_/B _13993_/D VDD VSS _13983_/B AOI21BX1
XFILLER_35_888 VSS VDD FILLER2
XFILLER_62_663 VDD VSS FILLER1
X_19456_ _19643_/CK _19456_/D _19456_/Q VDD VSS DFFQX1
X_16668_ _19736_/Q _16668_/B _16901_/B VDD VSS _16690_/A MIN3X1
X_19387_ _19435_/CK _19387_/D _19387_/Q VDD VSS DFFQX1
X_18407_ _18407_/CK _18471_/D _20148_/A _09380_/B VDD VSS DFFRQX1
X_16599_ _16578_/A _16599_/B VDD VSS _16606_/B NOR2BX1
X_15619_ _19383_/Q _15619_/B VDD VSS _15620_/D NAND2X1
X_18338_ _18343_/CK _18338_/D _18338_/Q _18373_/RB VDD VSS DFFRQX1
XFILLER_136_919 VDD VSS DECAPHV16
X_18269_ _18272_/CK _18269_/D _18269_/Q _18485_/RB VDD VSS DFFRQX1
XFILLER_143_451 VDD VSS DECAPHV8
XFILLER_103_315 VSS VDD FILLER2
X_20162_ _20162_/A VDD VSS _20162_/Y BUFX3
XFILLER_115_197 VSS VDD FILLER2
XTAP_TAPCELL_ROW_110_1120 VDD VSS WELLTAP
X_20093_ _20093_/A VDD VSS output9/A BUFX3
XFILLER_111_370 VSS VDD FILLER2
XFILLER_112_882 VDD VSS FILLER1
XFILLER_130_189 VDD VSS DECAPHV8
XFILLER_29_126 VDD VSS FILLER1
XFILLER_69_295 VDD VSS FILLER4
XFILLER_84_210 VDD VSS FILLER1
XFILLER_85_755 VSS VDD FILLER2
XFILLER_85_777 VDD VSS FILLER4
XFILLER_26_800 VSS VDD FILLER2
XFILLER_55_38 VDD VSS DECAPHV8
XFILLER_65_490 VDD VSS FILLER4
XFILLER_111_55 VDD VSS FILLER4
XFILLER_80_471 VDD VSS FILLER1
XTAP_TAPCELL_ROW_108_1093 VDD VSS WELLTAP
XFILLER_111_66 VDD VSS FILLER1
XFILLER_111_88 VDD VSS FILLER4
XFILLER_52_184 VDD VSS FILLER1
XFILLER_71_26 VSS VDD FILLER2
X_09407_ _20048_/Q VDD VSS _09409_/A INVX1
XFILLER_139_702 VSS VDD FILLER2
XFILLER_40_357 VSS VDD FILLER2
X_09338_ _18284_/Q _18512_/Q _09354_/B VDD VSS _09338_/Y MUXI2X1
XFILLER_139_735 VDD VSS FILLER1
XFILLER_127_919 VDD VSS FILLER1
XFILLER_139_779 VSS VDD FILLER2
X_09269_ _09408_/C _09273_/A _09269_/C _09269_/D VDD VSS _18278_/D OAI31X1
X_11300_ _11300_/A _11308_/C VDD VSS _11302_/B XOR2X1
XFILLER_126_429 VSS VDD FILLER2
X_12280_ _19014_/Q _12280_/B _12280_/C VDD VSS _12357_/B MIN3X1
XFILLER_107_665 VDD VSS FILLER4
XFILLER_5_759 VSS VDD FILLER2
X_11231_ _11209_/Y _11379_/B _10984_/A VDD VSS _11255_/B MUXI2X1
XFILLER_136_41 VDD VSS FILLER1
X_11162_ _18681_/Q _18789_/Q _11163_/C _11163_/D VDD VSS _11169_/B AOAI211X1
XFILLER_121_112 VSS VDD FILLER2
X_10113_ _18586_/Q _18587_/Q VDD VSS _10138_/B _10113_/C NAND3X1
XFILLER_103_860 VDD VSS DECAPHV8
XFILLER_122_679 VDD VSS FILLER4
X_11093_ _19959_/Q _18841_/Q _11093_/C VDD VSS _11142_/C AOI21X1
X_15970_ _19613_/Q _15970_/B _16765_/B VDD VSS _15990_/A MIN3X1
XFILLER_48_413 VDD VSS FILLER4
X_10044_ _10029_/Y _10043_/Y _10127_/A VDD VSS _10044_/Y MUX2X1
X_14921_ _19504_/Q _15009_/C _14921_/C VDD VSS _14966_/A OR3BX1
XFILLER_64_917 VDD VSS DECAPHV8
XFILLER_75_254 VDD VSS DECAPHV16
X_17640_ _19889_/Q _19857_/Q VDD VSS _17646_/B NAND2X1
X_14852_ _19308_/Q _15679_/B VDD VSS _14853_/B XNOR2X1
XFILLER_76_788 VSS VDD FILLER2
X_13803_ _13868_/A _17924_/C VDD VSS _17929_/B XNOR2X1
XFILLER_91_747 VDD VSS FILLER1
X_11995_ _12055_/D _12108_/A VDD VSS _12050_/D NOR2X1
X_19310_ _19337_/CK _19310_/D _19310_/Q VDD VSS DFFQX1
X_17571_ _18132_/A _17571_/B _17572_/C VDD VSS _19874_/D NOR3X1
X_14783_ _14837_/A _14837_/B _14837_/C _14783_/D VDD VSS _14865_/A OAOI211X1
X_10946_ _10910_/Y _10984_/B _10984_/A VDD VSS _10946_/Y MUXI2X1
X_13734_ _13735_/B _13735_/C _19029_/Q VDD VSS _13736_/C AOI21X1
X_16522_ _16503_/A _16522_/B VDD VSS _16523_/C NAND2BX1
XFILLER_44_696 VDD VSS FILLER1
XTAP_TAPCELL_ROW_61_628 VDD VSS WELLTAP
X_10877_ _10840_/B _10876_/Y _10945_/A VDD VSS _10877_/Y MUXI2X1
X_13665_ _13869_/A _13869_/B _13869_/D _13869_/C VDD VSS _17915_/B AOI211X1
X_19241_ _19242_/CK _19241_/D _19241_/Q VDD VSS DFFQX1
X_16453_ _19599_/Q _16453_/B _16750_/B VDD VSS _16474_/B MIN3X1
X_12616_ _18906_/Q _12701_/B _12701_/C VDD VSS _12789_/B MIN3X1
X_19172_ _19172_/CK _19172_/D _19172_/Q VDD VSS DFFQX1
X_16384_ _16512_/A _16384_/B VDD VSS _19533_/D NOR2X1
X_15404_ _19489_/Q _15882_/B VDD VSS _15433_/B XNOR2X1
XFILLER_61_70 VDD VSS DECAPHV8
X_13596_ _13686_/A wire155/Y _14226_/C VDD VSS _13682_/C OR3BX1
X_18123_ _19290_/Q _18123_/B _18123_/C VDD VSS _18126_/A AOI21X1
X_15335_ _15335_/A VDD VSS _15337_/B INVX1
XFILLER_129_267 VSS VDD FILLER2
X_12547_ _12634_/A _12634_/B _12634_/C VDD VSS _14346_/B AOI21X1
XANTENNA_3 _19937_/D VDD VSS ANTENNA2
XFILLER_126_930 VDD VSS FILLER1
XFILLER_144_215 VDD VSS DECAPHV8
X_12478_ _14439_/B _14439_/C _19156_/Q VDD VSS _12480_/C AOI21X1
X_18054_ _18054_/A _18054_/B _18056_/A VDD VSS _19984_/D AOI21X1
X_15266_ _15307_/A _15307_/B VDD VSS _15877_/B XOR2X1
XFILLER_6_54 VDD VSS DECAPHV32
X_11429_ _14163_/A _11429_/B _11429_/C VDD VSS _18622_/D NOR3X1
X_14217_ _14231_/A _14217_/B VDD VSS _18966_/D AND2X1
X_17005_ _19756_/Q _17011_/B VDD VSS _17019_/A XOR2X1
X_15197_ _15198_/A _15198_/B _15198_/C VDD VSS _15841_/B OA21X2
XFILLER_113_602 VDD VSS FILLER4
XFILLER_141_933 VDD VSS DECAPHV16
XFILLER_98_302 VSS VDD FILLER2
XFILLER_99_814 VDD VSS FILLER1
XFILLER_99_836 VDD VSS FILLER1
X_14148_ _14154_/A _14148_/B VDD VSS _18904_/D NOR2X1
XFILLER_113_635 VSS VDD FILLER2
XFILLER_4_781 VSS VDD FILLER2
XFILLER_67_711 VSS VDD FILLER2
XTAP_TAPCELL_ROW_69_706 VDD VSS WELLTAP
X_14079_ _14140_/B _14140_/C _18897_/Q VDD VSS _14093_/B AOI21X1
Xclkbuf_0__09181_ _18230_/ECK VDD VSS clkbuf_0__09181_/Y BUFX12
X_18956_ _18970_/CK _18956_/D _18956_/Q VDD VSS DFFQX1
XFILLER_39_424 VDD VSS DECAPHV8
XFILLER_67_733 VDD VSS DECAPHV8
X_18887_ _18888_/CK _18887_/D _18887_/Q VDD VSS DFFQX1
X_17907_ _17907_/A VDD VSS _17908_/C INVX1
XFILLER_39_446 VSS VDD FILLER2
X_17838_ _17838_/A VDD VSS _17917_/C BUFX3
XFILLER_54_416 VSS VDD FILLER2
XFILLER_55_928 VSS VDD FILLER2
XFILLER_67_799 VDD VSS FILLER4
XFILLER_82_736 VSS VDD FILLER2
XTAP_TAPCELL_ROW_77_783 VDD VSS WELLTAP
XFILLER_66_298 VSS VDD FILLER2
X_17769_ _19917_/Q _19885_/Q VDD VSS _17770_/B XOR2X1
XFILLER_23_814 VDD VSS FILLER1
X_19508_ _19543_/CK _19508_/D _19508_/Q VDD VSS DFFQX1
XFILLER_22_313 VDD VSS DECAPHV8
XFILLER_34_184 VDD VSS FILLER1
XFILLER_50_611 VSS VDD FILLER2
X_19439_ _19466_/CK _19439_/D _19439_/Q VDD VSS DFFQX1
XFILLER_22_357 VSS VDD FILLER2
XFILLER_108_407 VSS VDD FILLER2
XFILLER_135_226 VDD VSS DECAPHV8
XFILLER_135_248 VDD VSS FILLER4
X_20214_ _20214_/A VDD VSS _20214_/Y BUFX3
XFILLER_143_292 VDD VSS DECAPHV8
XFILLER_106_44 VSS VDD FILLER2
XFILLER_58_700 VSS VDD FILLER2
X_09956_ _10180_/A _11403_/C VDD VSS _18527_/D NOR2X1
X_20145_ _20145_/A VDD VSS _20145_/Y BUFX3
XFILLER_103_189 VSS VDD FILLER2
XFILLER_106_55 VDD VSS FILLER1
X_09887_ _09944_/A _09887_/B VDD VSS _09895_/C NOR2X1
X_20076_ _20079_/CK _20076_/D _20076_/Q _20080_/RB VDD VSS DFFRQX1
XFILLER_57_243 VSS VDD FILLER2
XFILLER_57_254 VDD VSS FILLER1
XFILLER_57_287 VDD VSS FILLER1
XFILLER_58_788 VSS VDD FILLER2
XFILLER_73_714 VDD VSS FILLER4
XFILLER_73_725 VSS VDD FILLER2
XFILLER_122_65 VDD VSS FILLER1
XFILLER_61_909 VDD VSS FILLER1
XFILLER_72_235 VDD VSS FILLER1
X_10800_ _10801_/A _10801_/B _10801_/D _10801_/C VDD VSS _10800_/Y OAOI211X1
X_11780_ _19993_/Q _19257_/Q VDD VSS _11804_/C XOR2X1
Xclkbuf_1_0__f__09170_ clkbuf_0__09170_/Y VDD VSS _18359_/CK BUFX12
XFILLER_26_685 VDD VSS FILLER1
XFILLER_53_493 VSS VDD FILLER2
X_10731_ _10765_/A _10765_/B _10765_/C _10731_/D VDD VSS _10747_/C OAI31X1
XFILLER_40_132 VDD VSS FILLER4
X_13450_ _13459_/A _13459_/B _13459_/C VDD VSS _14451_/B AOI21X1
XFILLER_41_688 VDD VSS FILLER1
X_10662_ _10662_/A _10709_/B VDD VSS _10670_/B XNOR2X1
X_12401_ _12401_/A _12401_/B _12401_/C _12401_/D VDD VSS _12405_/B OAOI211X1
XFILLER_139_576 VDD VSS DECAPHV16
XFILLER_40_187 VDD VSS FILLER4
X_10593_ _11378_/A _10593_/B _10594_/B VDD VSS _18559_/D NOR3X1
X_13381_ _14118_/A _17905_/B VDD VSS _18858_/D NOR2X1
XFILLER_126_204 VSS VDD FILLER2
X_12332_ _19155_/Q _12483_/A _12472_/B VDD VSS _12471_/D XNOR3X1
X_15120_ _19370_/Q _15747_/B VDD VSS _15134_/C NAND2X1
XFILLER_110_0 VSS VDD FILLER2
XTAP_TAPCELL_ROW_2_33 VDD VSS WELLTAP
X_12263_ _19014_/Q _12280_/B _12280_/C VDD VSS _14246_/B XNOR3X1
X_15051_ _15052_/A _15052_/B VDD VSS _15872_/B _15108_/B _15052_/D NAND4X2
XFILLER_107_451 VDD VSS FILLER1
X_11214_ _11289_/A _11307_/B _11214_/C VDD VSS _11222_/B AOI21X1
X_14002_ _14267_/B _19005_/Q VDD VSS _14013_/A NAND2BX1
Xoutput5 output5/A VDD VSS adc_conv BUFX3
XFILLER_122_421 VDD VSS DECAPHV8
XFILLER_134_292 VDD VSS FILLER4
XTAP_TAPCELL_ROW_130_1315 VDD VSS WELLTAP
X_12194_ _18929_/Q _12198_/B _14177_/B VDD VSS _14145_/B XNOR3X1
Xoutput40 _20123_/Y VDD VSS o_bias_cfg[25] BUFX3
Xoutput51 _20101_/Y VDD VSS o_bias_cfg[3] BUFX3
XFILLER_122_454 VDD VSS FILLER4
X_11145_ _18708_/Q _18762_/Q VDD VSS _11167_/A XNOR2X1
X_19790_ _19792_/CK _19790_/D _19790_/Q VDD VSS DFFQX1
Xoutput62 _20146_/Y VDD VSS o_clk_cfg[13] BUFX3
Xoutput73 _20139_/Y VDD VSS o_clk_cfg[6] BUFX3
Xoutput84 _20158_/Y VDD VSS o_en_ctrl[6] BUFX3
X_18810_ _18811_/CK _18810_/D _18810_/Q VDD VSS DFFQX1
XFILLER_0_250 VDD VSS FILLER1
XFILLER_0_261 VDD VSS DECAPHV8
XFILLER_49_711 VDD VSS FILLER1
XFILLER_95_327 VDD VSS DECAPHV8
X_11076_ _11093_/C _11076_/B _11076_/C _11178_/C VDD VSS _11077_/C AOI2B2X1
Xoutput95 _20164_/Y VDD VSS o_lf_cfg[1] BUFX3
X_18741_ _18768_/CK _18741_/D _18741_/Q VDD VSS DFFQX1
X_15953_ _19643_/Q _16800_/B _15979_/A VDD VSS _15977_/A MIN3X1
X_10027_ _09946_/Y _09953_/B _10166_/D VDD VSS _10027_/Y MUXI2X1
X_14904_ _14904_/A _14904_/B _15771_/B VDD VSS _14955_/B MIN3X1
XFILLER_49_799 VDD VSS DECAPHV8
XFILLER_76_574 VDD VSS FILLER4
X_18672_ _18809_/CK _18672_/D _18672_/Q VDD VSS DFFQX1
X_15884_ _16768_/A _15884_/B VDD VSS _19491_/D AND2X1
XTAP_TAPCELL_ROW_128_1299 VDD VSS WELLTAP
X_17623_ _17625_/C _17623_/B _17623_/C VDD VSS _19885_/D AOI21X1
X_14835_ _19447_/Q _15832_/B VDD VSS _14867_/A AND2X1
XFILLER_32_600 VDD VSS FILLER4
XTAP_TAPCELL_ROW_141_1422 VDD VSS WELLTAP
XTAP_TAPCELL_ROW_74_753 VDD VSS WELLTAP
X_11978_ _19231_/Q _14525_/B VDD VSS _11979_/D _14525_/C AND3X2
X_17554_ _17556_/B _17554_/B VDD VSS _17555_/B XOR2X1
X_14766_ _14766_/A _18059_/B VDD VSS _19278_/D AND2X1
XFILLER_44_460 VDD VSS FILLER1
XTAP_TAPCELL_ROW_46_477 VDD VSS WELLTAP
X_10929_ _19955_/Q _18837_/Q VDD VSS _10931_/C XNOR2X1
X_13717_ _19169_/Q _14454_/B _13719_/B VDD VSS _14424_/B MIN3X1
X_16505_ _16521_/B _16505_/B VDD VSS _16824_/B XOR2X1
X_19224_ _19988_/CK _19224_/D _19224_/Q VDD VSS DFFQX1
X_17485_ _17488_/A _17488_/B _17509_/C VDD VSS _17486_/C OAI21X1
X_14697_ _19444_/Q _14733_/B _14702_/C VDD VSS _14698_/C XNOR3X1
XFILLER_20_817 VDD VSS FILLER1
X_13648_ _13649_/B _13649_/C _19056_/Q VDD VSS _13733_/B AOI21X1
X_16436_ _16437_/A _16437_/B _16437_/C VDD VSS _16469_/B OAI21X1
XFILLER_118_716 VDD VSS FILLER4
XFILLER_9_840 VDD VSS FILLER4
X_13579_ _18916_/Q VDD VSS _13661_/A INVX1
X_19155_ _19182_/CK _19155_/D _19155_/Q VDD VSS DFFQX1
X_16367_ _19916_/Q VDD VSS _16711_/A INVX1
X_19086_ _19115_/CK _19086_/D _19086_/Q VDD VSS DFFQX1
X_18106_ _19288_/Q _18107_/B VDD VSS _18112_/C NAND2X1
X_16298_ _19690_/Q _16851_/B VDD VSS _16307_/B XNOR2X1
X_15318_ _15878_/B _15318_/B _15354_/C VDD VSS _15879_/B XNOR3X1
XFILLER_68_2 VDD VSS FILLER1
X_18037_ _18038_/B _18045_/B _18037_/C _18049_/D VDD VSS _19976_/D OAI31X1
X_15249_ _19401_/Q _15781_/B VDD VSS _15262_/B XOR2X1
XFILLER_99_633 VSS VDD FILLER2
X_09810_ _18343_/Q _09810_/B VDD VSS _09811_/E NOR2X1
X_19988_ _19988_/CK _19988_/D _19988_/Q VDD VSS DFFQX1
XFILLER_113_476 VDD VSS FILLER1
XFILLER_140_262 VDD VSS DECAPHV8
X_09741_ _20076_/Q _09818_/B _09818_/C _18270_/Q _09741_/E VDD VSS _09745_/C AOI221X1
Xclkbuf_0__09164_ _18213_/ECK VDD VSS clkbuf_0__09164_/Y BUFX12
X_18939_ _18970_/CK _18939_/D _18939_/Q VDD VSS DFFQX1
XFILLER_67_563 VDD VSS FILLER1
X_09672_ _20107_/A _20123_/A _09776_/A VDD VSS _09682_/C MUXI2X1
XFILLER_27_427 VSS VDD FILLER2
XFILLER_39_298 VDD VSS FILLER4
XFILLER_55_747 VDD VSS FILLER4
XFILLER_70_717 VDD VSS FILLER1
XFILLER_63_791 VDD VSS FILLER1
XTAP_TAPCELL_ROW_105_1063 VDD VSS WELLTAP
XTAP_TAPCELL_ROW_17_190 VDD VSS WELLTAP
XFILLER_50_485 VSS VDD FILLER2
XFILLER_136_502 VDD VSS DECAPHV8
XFILLER_136_568 VDD VSS FILLER1
XFILLER_123_218 VSS VDD FILLER2
XTAP_TAPCELL_ROW_9_103 VDD VSS WELLTAP
XFILLER_104_421 VSS VDD FILLER2
XFILLER_105_933 VDD VSS FILLER1
XFILLER_117_43 VSS VDD FILLER2
XFILLER_89_110 VDD VSS FILLER1
XFILLER_104_465 VDD VSS FILLER4
XFILLER_117_65 VDD VSS FILLER1
XFILLER_132_752 VSS VDD FILLER2
XFILLER_89_143 VSS VDD FILLER2
XFILLER_120_947 VSS VDD FILLER2
XFILLER_132_785 VDD VSS FILLER4
XFILLER_77_58 VSS VDD FILLER2
X_20128_ _20128_/A VDD VSS _20128_/Y BUFX3
Xdelaybuf_0_clk _232_/CK VDD VSS delaybuf_1_clk/A BUFX12
X_09939_ _10190_/B _09939_/B VDD VSS _09940_/C NAND2X1
XFILLER_85_371 VDD VSS FILLER1
X_12950_ _12951_/A _12951_/B _12951_/D _12951_/C VDD VSS _14510_/B AO211X2
X_20059_ clkload5/A _20059_/D _20060_/D _20064_/RB VDD VSS DFFRQX1
X_11901_ _19092_/Q _11962_/B _11958_/C VDD VSS _11953_/C XNOR3X1
X_12881_ _13283_/A _17880_/B VDD VSS _18853_/D AND2X1
X_11832_ wire165/Y _11838_/C VDD VSS _14524_/B XOR2X1
X_14620_ _14624_/A _14645_/B _14645_/C VDD VSS _15858_/B AND3BX1
XFILLER_14_622 VSS VDD FILLER2
XTAP_TAPCELL_ROW_71_723 VDD VSS WELLTAP
X_14551_ _19991_/Q _14558_/B VDD VSS _19255_/D AND2X1
XTAP_TAPCELL_ROW_43_447 VDD VSS WELLTAP
X_11763_ _11764_/B _11764_/C _19200_/Q VDD VSS _11797_/B AOI21X1
XFILLER_41_452 VDD VSS DECAPHV8
X_10714_ _10715_/A _10715_/B _10715_/D _10715_/C VDD VSS _10717_/B AOAI211X1
X_11694_ _11716_/A _11716_/B _11716_/C VDD VSS _11736_/A AOI21X1
X_13502_ _13502_/A _13502_/B _13502_/C _13502_/D VDD VSS _13662_/B OAOI211X1
X_14482_ _14482_/A _14482_/B _17827_/B VDD VSS _19195_/D AOI21X1
X_17270_ _17269_/B _17270_/B VDD VSS _17272_/C NOR2BX1
X_10645_ _10639_/Y _10645_/B _10675_/B _10645_/D VDD VSS _10653_/C OAI2B2BX1
X_13433_ _14417_/B _14417_/C _19137_/Q VDD VSS _13616_/B AO21X2
X_16221_ _16222_/A _16222_/B _16222_/C VDD VSS _16221_/Y NOR3X1
XFILLER_6_821 VDD VSS DECAPHV16
X_13364_ _13364_/A _13364_/B _13364_/C _13364_/D VDD VSS _14355_/A AOAI211X1
X_16152_ _16146_/A _16152_/B _16152_/C VDD VSS _16175_/B AOI2B1X1
XFILLER_10_894 VDD VSS FILLER1
XFILLER_127_535 VSS VDD FILLER2
XFILLER_127_557 VDD VSS FILLER1
XFILLER_139_395 VDD VSS DECAPHV8
X_10576_ _10576_/A _10576_/B _10576_/C _10576_/D VDD VSS _10577_/B AOI211X1
X_12315_ _20001_/Q _19265_/Q VDD VSS _12407_/A NAND2X1
X_15103_ _15903_/B VDD VSS _15104_/B INVX1
X_13295_ _13295_/A _13295_/B _13295_/C _13295_/D VDD VSS _13402_/A AOI31X1
X_16083_ _16083_/A _16083_/B _16083_/C VDD VSS _16108_/B OA21X2
XFILLER_5_375 VDD VSS FILLER4
XFILLER_5_397 VSS VDD FILLER2
X_12246_ _12372_/A _12372_/B VDD VSS _14404_/B _12372_/C NAND3X1
X_19911_ clkload9/A _19911_/D _19911_/Q VDD VSS DFFQX1
X_15034_ _15297_/A _18089_/B VDD VSS _19284_/D AND2X1
XFILLER_69_817 VSS VDD FILLER2
XFILLER_96_603 VDD VSS FILLER1
XTAP_TAPCELL_ROW_79_801 VDD VSS WELLTAP
X_12177_ _19153_/Q _12177_/B VDD VSS _12183_/B XNOR2X1
X_19842_ _19843_/CK _19842_/D _19842_/Q VDD VSS DFFQX1
XFILLER_123_785 VSS VDD FILLER2
XFILLER_96_636 VDD VSS FILLER4
X_11128_ _11128_/A _11128_/B VDD VSS _11159_/A NAND2X1
X_19773_ _19843_/CK _19773_/D _19773_/Q VDD VSS DFFQX1
X_16985_ _19750_/Q _19751_/Q _17011_/B VDD VSS _16996_/D OAI21X1
XFILLER_83_319 VDD VSS FILLER1
X_11059_ _18706_/Q _18760_/Q VDD VSS _11064_/A XOR2X1
X_18724_ _18779_/CK _18724_/D _18724_/Q VDD VSS DFFQX1
X_15936_ _15936_/A _15936_/B VDD VSS _15937_/C NAND2X1
XFILLER_36_235 VSS VDD FILLER2
XFILLER_37_747 VDD VSS FILLER1
XFILLER_92_831 VDD VSS FILLER4
X_09968__238 _20079_/CK VDD VSS _18515_/CK INVX1
X_18655_ _19963_/CK _18655_/D _18655_/Q VDD VSS DFFQX1
X_15867_ _15867_/A _15867_/B VDD VSS _19476_/D NOR2X1
XFILLER_64_577 VSS VDD FILLER2
XFILLER_92_886 VDD VSS DECAPHV8
X_17606_ _19881_/Q _19849_/Q _17606_/C VDD VSS _17610_/B MIN3X1
X_14818_ _14818_/A _14818_/B _14818_/C _14818_/D VDD VSS _14908_/B AOAI211X1
XFILLER_91_385 VSS VDD FILLER2
XFILLER_91_396 VSS VDD FILLER2
X_18586_ _18595_/CK _18586_/D _18586_/Q VDD VSS DFFQX1
X_15798_ _15800_/A _15798_/B VDD VSS _19416_/D NOR2X1
XFILLER_83_90 VSS VDD FILLER2
X_17537_ _19867_/Q _19835_/Q _17537_/C VDD VSS _17541_/B AOI21X1
X_14749_ _14785_/A _14785_/B _14785_/D _14785_/C VDD VSS _14781_/D OAI211X1
X_17468_ _17468_/A _17468_/B _17468_/C _17468_/D VDD VSS _17469_/C AOAI211X1
XFILLER_20_647 VDD VSS FILLER4
XFILLER_20_658 VDD VSS FILLER1
XTAP_TAPCELL_ROW_14_160 VDD VSS WELLTAP
X_19207_ _20006_/CK _19207_/D _19207_/Q VDD VSS DFFQX1
X_16419_ _19598_/Q _16748_/B VDD VSS _16420_/C NOR2X1
XFILLER_118_524 VDD VSS FILLER1
XFILLER_73_0 VSS VDD FILLER2
X_19138_ _19194_/CK _19138_/D _19138_/Q VDD VSS DFFQX1
X_17399_ _19838_/Q _19806_/Q VDD VSS _17400_/B XOR2X1
XFILLER_118_546 VSS VDD FILLER2
X_19069_ _19096_/CK _19069_/D _19069_/Q VDD VSS DFFQX1
XFILLER_113_273 VDD VSS FILLER1
XFILLER_101_468 VDD VSS FILLER4
XFILLER_68_894 VSS VDD FILLER2
X_09724_ _20221_/A _09811_/C _09770_/C _18321_/Q VDD VSS _09725_/D AOI22X1
XFILLER_55_544 VDD VSS FILLER1
XFILLER_67_382 VSS VDD FILLER2
X_09655_ _18365_/Q VDD VSS _20202_/A INVX1
XFILLER_55_555 VSS VDD FILLER2
XFILLER_82_341 VDD VSS FILLER1
XFILLER_36_780 VDD VSS DECAPHV8
XFILLER_70_514 VDD VSS FILLER4
XFILLER_82_396 VDD VSS FILLER4
X_09586_ _18393_/Q VDD VSS _20134_/A INVX1
XFILLER_23_474 VDD VSS FILLER1
XFILLER_50_260 VDD VSS DECAPHV8
XTAP_TAPCELL_ROW_40_417 VDD VSS WELLTAP
XFILLER_10_113 VSS VDD FILLER2
XFILLER_11_647 VDD VSS FILLER4
XFILLER_50_282 VDD VSS DECAPHV8
XFILLER_109_502 VSS VDD FILLER2
X_10430_ _10431_/A _10431_/B _10431_/C VDD VSS _10472_/B AO21X2
XFILLER_12_97 VSS VDD FILLER2
X_10361_ _19940_/Q _18822_/Q VDD VSS _10417_/C XNOR2X1
XFILLER_2_323 VSS VDD FILLER2
X_10292_ _19938_/Q _18820_/Q VDD VSS _10343_/B XOR2X1
X_12100_ _19235_/Q VDD VSS _12101_/A INVX1
X_13080_ _18884_/Q VDD VSS _13287_/A INVX1
X_12031_ _12031_/A _12031_/B _12031_/C _12031_/D VDD VSS _12181_/A OAOI211X1
XFILLER_105_774 VDD VSS FILLER4
XFILLER_120_700 VSS VDD FILLER2
XFILLER_104_284 VSS VDD FILLER2
XFILLER_120_744 VDD VSS DECAPHV8
XFILLER_58_360 VDD VSS FILLER4
XFILLER_59_883 VDD VSS FILLER4
XFILLER_93_606 VSS VDD FILLER2
X_13982_ _18922_/Q VDD VSS _14019_/A INVX1
X_16770_ _16775_/A _16770_/B VDD VSS _19618_/D NOR2X1
XFILLER_58_371 VDD VSS FILLER4
XFILLER_58_393 VDD VSS FILLER1
XFILLER_92_149 VSS VDD FILLER2
X_12933_ _12940_/A _12940_/B VDD VSS _14444_/B _12940_/C AND3X2
X_15721_ _15739_/A _15721_/B VDD VSS _19347_/D NOR2X1
XFILLER_18_268 VDD VSS DECAPHV8
X_18440_ _18453_/CK _18440_/D _18440_/Q _18444_/RB VDD VSS DFFRQX1
XTAP_TAPCELL_ROW_125_1269 VDD VSS WELLTAP
XTAP_TAPCELL_ROW_56_572 VDD VSS WELLTAP
X_12864_ _19077_/Q _13017_/A _13102_/B VDD VSS _12916_/C XNOR3X1
X_15652_ _15652_/A _15652_/B _15652_/C VDD VSS _15660_/A AOI21X1
XFILLER_33_249 VSS VDD FILLER2
XFILLER_61_569 VDD VSS FILLER4
XTAP_TAPCELL_ROW_28_296 VDD VSS WELLTAP
XTAP_TAPCELL_ROW_8_98 VDD VSS WELLTAP
X_11815_ _19089_/Q _14365_/B VDD VSS _11816_/B OR2X2
X_12795_ _18908_/Q _12883_/B _12883_/C VDD VSS _13180_/B MIN3X1
X_14603_ _19496_/Q VDD VSS _14644_/A INVX1
X_18371_ _18375_/CK _18499_/D _20208_/A _18465_/RB VDD VSS DFFRQX1
X_15583_ _19382_/Q _15759_/B VDD VSS _15595_/B XOR2X1
X_11746_ _19991_/Q _19255_/Q VDD VSS _11769_/C AND2X1
X_14534_ _14534_/A _14534_/B _15836_/C VDD VSS _19240_/D OA21X2
X_17322_ _17325_/C _17323_/B _17363_/C VDD VSS _17323_/C OAI21X1
XFILLER_14_496 VDD VSS FILLER1
XFILLER_41_271 VDD VSS FILLER1
XFILLER_41_282 VDD VSS FILLER4
X_17253_ _19806_/Q _19774_/Q _17253_/C VDD VSS _17257_/B AOI21X1
XTAP_TAPCELL_ROW_11_130 VDD VSS WELLTAP
X_11677_ _11677_/A _16704_/B VDD VSS _18841_/D NOR2X1
X_14465_ _14490_/A _14465_/B _14465_/C VDD VSS _19179_/D NOR3X1
X_16204_ _16204_/A VDD VSS _16775_/B INVX1
XFILLER_127_332 VSS VDD FILLER2
X_10628_ _18560_/Q _10666_/A _10665_/B VDD VSS _10629_/B XNOR3X1
X_13416_ _19053_/Q _13416_/B VDD VSS _13420_/C _13416_/C NAND3X1
X_14396_ _14426_/A _14396_/B VDD VSS _19117_/D NOR2X1
X_17184_ _19792_/Q _19760_/Q VDD VSS _17189_/A XNOR2X1
XFILLER_127_365 VDD VSS FILLER4
XTAP_TAPCELL_ROW_136_1376 VDD VSS WELLTAP
X_10559_ _18691_/Q _18745_/Q VDD VSS _10563_/D AND2X1
X_13347_ _13347_/A _14513_/B _13347_/C _13347_/D VDD VSS _13464_/A OAOI211X1
X_16135_ _19556_/Q _19908_/Q VDD VSS _16138_/A XNOR2X1
XFILLER_115_549 VDD VSS DECAPHV8
X_13278_ _18969_/Q _13278_/B _14221_/C VDD VSS _13391_/B XNOR3X1
X_16066_ _16085_/B _16066_/B VDD VSS _16769_/B XNOR2X1
XFILLER_5_183 VSS VDD FILLER2
X_12229_ _12396_/A _12396_/B VDD VSS _12231_/B NOR2X1
X_15017_ _15017_/A _15017_/B _15017_/C _15017_/D VDD VSS _15056_/A OAOI211X1
XFILLER_130_519 VSS VDD FILLER2
XFILLER_96_411 VDD VSS FILLER4
Xclkbuf_leaf_14_clk_regs clkload1/A VDD VSS clkload3/A BUFX12
XFILLER_69_647 VDD VSS FILLER4
XFILLER_69_658 VDD VSS FILLER1
X_19825_ _19828_/CK _19825_/D _19825_/Q VDD VSS DFFQX1
XFILLER_110_243 VSS VDD FILLER2
XFILLER_111_799 VSS VDD FILLER2
X_19756_ _19792_/CK _19756_/D _19756_/Q VDD VSS DFFQX1
X_16968_ _19748_/Q _17078_/B _16968_/C VDD VSS _16969_/B MIN3X1
XFILLER_110_276 VDD VSS FILLER4
X_18707_ _18817_/CK _18707_/D _18707_/Q VDD VSS DFFQX1
X_15919_ _19579_/Q _16728_/B VDD VSS _15929_/B XOR2X1
XFILLER_25_706 VDD VSS DECAPHV8
X_09440_ _09787_/B VDD VSS _09772_/B BUFX3
X_19687_ _19736_/CK _19687_/D _19687_/Q VDD VSS DFFQX1
X_16899_ _16899_/A _16899_/B VDD VSS _19734_/D AND2X1
XFILLER_24_205 VDD VSS FILLER4
XFILLER_24_227 VDD VSS FILLER1
XFILLER_91_160 VDD VSS DECAPHV8
X_18638_ _18828_/CK _18638_/D _18638_/Q VDD VSS DFFQX1
XFILLER_91_182 VDD VSS FILLER4
X_09371_ _09816_/D _09422_/B VDD VSS _09426_/A _09624_/B NAND3X1
X_18569_ _18571_/CK _18569_/D _18569_/Q VDD VSS DFFQX1
XTAP_TAPCELL_ROW_102_1033 VDD VSS WELLTAP
XFILLER_138_619 VDD VSS DECAPHV8
XFILLER_119_855 VSS VDD FILLER2
XFILLER_119_877 VSS VDD FILLER2
XFILLER_119_888 VSS VDD FILLER2
XFILLER_134_825 VSS VDD FILLER2
XFILLER_102_700 VDD VSS FILLER4
XFILLER_102_722 VDD VSS FILLER1
XFILLER_88_945 VDD VSS FILLER4
XFILLER_58_49 VSS VDD FILLER2
XFILLER_99_282 VDD VSS FILLER4
XFILLER_101_243 VDD VSS DECAPHV16
XFILLER_75_617 VSS VDD FILLER2
XFILLER_101_298 VDD VSS FILLER4
XTAP_TAPCELL_ROW_98_995 VDD VSS WELLTAP
X_09707_ _09707_/A _09707_/B VDD VSS _09708_/E NAND2X1
XFILLER_71_801 VDD VSS FILLER4
XFILLER_16_717 VDD VSS DECAPHV8
XFILLER_83_672 VSS VDD FILLER2
X_09638_ _18444_/Q VDD VSS _20156_/A INVX1
XFILLER_43_547 VDD VSS DECAPHV8
X_09569_ _09569_/A _09569_/B VDD VSS _09581_/A _09569_/C NAND3X1
XFILLER_130_65 VSS VDD FILLER2
XFILLER_24_750 VSS VDD FILLER2
XFILLER_24_772 VSS VDD FILLER2
XFILLER_90_36 VDD VSS FILLER4
XTAP_TAPCELL_ROW_25_266 VDD VSS WELLTAP
XTAP_TAPCELL_ROW_53_542 VDD VSS WELLTAP
X_11600_ _18745_/Q _11600_/B VDD VSS _18772_/D AND2X1
X_12580_ _12677_/A _14535_/B _14535_/C VDD VSS _12837_/D NOR3X1
XFILLER_129_608 VDD VSS DECAPHV16
XFILLER_23_282 VDD VSS DECAPHV16
X_11531_ _18683_/Q _11531_/B VDD VSS _18710_/D AND2X1
XFILLER_23_63 VDD VSS FILLER1
XFILLER_23_96 VDD VSS DECAPHV8
X_11462_ _19954_/Q _11473_/B VDD VSS _18647_/D AND2X1
X_14250_ _14251_/A _14250_/B VDD VSS _18990_/D NOR2X1
XFILLER_125_803 VSS VDD FILLER2
XFILLER_139_96 VDD VSS DECAPHV16
X_10413_ _10413_/A _10413_/B _10413_/C _10413_/D VDD VSS _10460_/B AOAI211X1
X_11393_ _11391_/Y _11393_/B _11431_/A VDD VSS _18595_/D AND3BX1
X_13201_ _19024_/Q _13201_/B _13208_/C VDD VSS _13373_/B XOR3X1
X_14181_ _14197_/A _14181_/B VDD VSS _18933_/D AND2X1
XFILLER_125_858 VDD VSS FILLER1
XFILLER_99_78 VSS VDD FILLER2
X_10344_ _10342_/Y _10417_/B _10686_/D VDD VSS _10345_/D AND3BX1
X_13132_ _13133_/A _13133_/C VDD VSS _14511_/B _13133_/B AND3X2
XFILLER_3_654 VDD VSS FILLER4
XFILLER_140_839 VDD VSS FILLER1
XFILLER_3_698 VSS VDD FILLER2
X_10275_ _11386_/C VDD VSS _11431_/A BUFX3
X_13063_ _13137_/A _13141_/D _13125_/C VDD VSS _13138_/C XNOR3X1
X_17940_ _17940_/A _17940_/B _17940_/C VDD VSS _17941_/D NOR3X1
XFILLER_105_582 VDD VSS DECAPHV8
XFILLER_120_541 VSS VDD FILLER2
X_12014_ _12014_/A _12014_/B VDD VSS _14305_/B XNOR2X1
X_17871_ _18852_/Q _17876_/B VDD VSS _17872_/B XNOR2X1
XFILLER_78_455 VSS VDD FILLER2
X_19610_ _19643_/CK _19610_/D _19610_/Q VDD VSS DFFQX1
X_16822_ _16826_/A _16822_/B VDD VSS _19664_/D NOR2X1
XFILLER_47_831 VDD VSS FILLER4
X_19541_ _19707_/CK _19541_/D _19541_/Q VDD VSS DFFQX1
XFILLER_19_544 VDD VSS FILLER1
XFILLER_62_801 VDD VSS FILLER1
XFILLER_74_661 VSS VDD FILLER2
X_13965_ _13965_/A _13965_/B VDD VSS _14301_/B _13965_/C NAND3X1
X_16753_ _16759_/A _16753_/B VDD VSS _19602_/D NOR2X1
XFILLER_46_363 VDD VSS FILLER1
XFILLER_46_385 VDD VSS FILLER1
XFILLER_61_300 VDD VSS FILLER4
XFILLER_80_119 VDD VSS FILLER4
X_12916_ _12916_/A _12916_/B _12916_/C _12916_/D VDD VSS _14319_/C AOI211X1
X_13896_ _13903_/A _13903_/B _13951_/C VDD VSS _14266_/B OA21X2
X_19472_ _19521_/CK _19472_/D _19472_/Q VDD VSS DFFQX1
X_16684_ _19673_/Q _16832_/B VDD VSS _16685_/B XOR2X1
X_15704_ _15706_/A _15704_/B VDD VSS _19332_/D AND2X1
XFILLER_64_81 VSS VDD FILLER2
X_12847_ _14538_/A _14538_/B _12967_/C VDD VSS _12951_/C AOI21X1
X_18423_ _18423_/CK _18423_/D _18423_/Q _18444_/RB VDD VSS DFFRQX1
X_15635_ _15635_/A _15635_/B _15700_/B VDD VSS _15652_/A MIN3X1
X_18354_ _18356_/CK _18354_/D _18354_/Q _18492_/RB VDD VSS DFFRQX1
XFILLER_14_271 VDD VSS FILLER4
X_12778_ _19020_/Q _12778_/B _12799_/D VDD VSS _12801_/C XNOR3X1
X_17305_ _19817_/Q _19785_/Q _17305_/C VDD VSS _17309_/B MIN3X1
X_15566_ _15566_/A _15566_/B _15566_/C VDD VSS _15592_/A AOI21X1
XFILLER_119_118 VDD VSS DECAPHV8
XFILLER_9_87 VDD VSS FILLER1
X_11729_ _19171_/Q _11761_/B _11733_/C VDD VSS _14425_/B XNOR3X1
X_14517_ _14766_/A _14517_/B VDD VSS _19224_/D AND2X1
X_18285_ _18291_/CK _18285_/D _18285_/Q VDD VSS DFFQX1
X_15497_ _19322_/Q VDD VSS _15498_/A INVX1
XFILLER_9_98 VDD VSS FILLER1
X_14448_ _14456_/A _14448_/B VDD VSS _19164_/D NOR2X1
X_17236_ _19802_/Q _19770_/Q VDD VSS _17238_/C _17236_/C AND3X2
XFILLER_128_674 VSS VDD FILLER2
X_17167_ _17168_/A _17168_/B _17168_/D _17168_/C VDD VSS _17170_/C AOI211X1
XFILLER_115_324 VDD VSS DECAPHV16
XFILLER_127_173 VDD VSS FILLER4
X_14379_ _14410_/A _14379_/B _14379_/C VDD VSS _19102_/D NOR3X1
X_16118_ _16133_/B _16118_/B VDD VSS _16808_/B XNOR2X1
XFILLER_116_869 VDD VSS DECAPHV8
X_17098_ _19773_/Q _19741_/Q _17098_/C VDD VSS _17102_/B AOI21X1
XFILLER_88_219 VDD VSS FILLER1
X_16049_ _16049_/A _16049_/B VDD VSS _16875_/B XNOR2X1
XFILLER_36_0 VDD VSS FILLER4
XFILLER_57_606 VSS VDD FILLER2
XFILLER_69_455 VSS VDD FILLER2
XFILLER_96_263 VSS VDD FILLER2
XFILLER_97_775 VDD VSS FILLER4
X_19808_ clkload2/A _19808_/D _19808_/Q VDD VSS DFFQX1
XFILLER_111_585 VDD VSS DECAPHV16
XFILLER_96_285 VDD VSS FILLER4
XFILLER_97_797 VDD VSS DECAPHV8
XFILLER_56_149 VSS VDD FILLER2
XFILLER_65_650 VDD VSS FILLER1
XTAP_TAPCELL_ROW_95_965 VDD VSS WELLTAP
X_19739_ clkload4/A _19739_/D _19739_/Q VDD VSS DFFQX1
XFILLER_38_886 VDD VSS FILLER4
XFILLER_52_311 VDD VSS FILLER4
XFILLER_53_834 VSS VDD FILLER2
XFILLER_65_683 VDD VSS DECAPHV8
XTAP_TAPCELL_ROW_67_689 VDD VSS WELLTAP
XFILLER_53_845 VDD VSS DECAPHV8
XFILLER_64_193 VDD VSS FILLER1
X_09423_ _09630_/C _18505_/Q _18506_/Q VDD VSS _09626_/C OR3BX1
XFILLER_25_569 VSS VDD FILLER2
X_09354_ _09354_/A _09354_/B VDD VSS _09354_/Y NOR2X2
XFILLER_100_35 VDD VSS DECAPHV8
XFILLER_21_720 VDD VSS DECAPHV8
XTAP_TAPCELL_ROW_50_512 VDD VSS WELLTAP
XFILLER_100_79 VDD VSS DECAPHV16
XTAP_TAPCELL_ROW_22_236 VDD VSS WELLTAP
X_09285_ _09362_/AB _09349_/B VDD VSS _09285_/Y NOR2BX1
XFILLER_121_8 VDD VSS FILLER4
XFILLER_5_908 VDD VSS FILLER1
XFILLER_107_836 VDD VSS FILLER1
XFILLER_109_55 VDD VSS FILLER1
XFILLER_106_379 VDD VSS DECAPHV16
XFILLER_87_230 VDD VSS DECAPHV8
X_10060_ _09915_/B _10159_/B _10131_/A VDD VSS _10062_/B MUXI2X1
XFILLER_87_252 VDD VSS FILLER1
XFILLER_102_574 VDD VSS DECAPHV8
XFILLER_125_98 VDD VSS FILLER1
XFILLER_130_894 VDD VSS FILLER4
XFILLER_75_414 VDD VSS DECAPHV8
XFILLER_87_296 VSS VDD FILLER2
XFILLER_91_918 VDD VSS FILLER1
XFILLER_16_503 VSS VDD FILLER2
X_10962_ _10962_/A _10962_/B _10962_/C VDD VSS _10998_/C OAI21X1
X_13750_ _13751_/A _13751_/B _13751_/D _13751_/C VDD VSS _14132_/B OAOI211X1
XFILLER_44_845 VSS VDD FILLER2
XFILLER_71_620 VDD VSS FILLER1
XTAP_TAPCELL_ROW_38_391 VDD VSS WELLTAP
X_12701_ _18906_/Q _12701_/B _12701_/C VDD VSS _14118_/B XNOR3X1
XFILLER_34_40 VSS VDD FILLER2
XTAP_TAPCELL_ROW_122_1239 VDD VSS WELLTAP
X_10893_ _10931_/D _10931_/B VDD VSS _10895_/B NAND2BX1
X_13681_ _13682_/B _13682_/C _18972_/Q VDD VSS _13688_/B AOI21X1
X_15420_ _15674_/A _18138_/B VDD VSS _19293_/D AND2X1
XFILLER_70_185 VDD VSS DECAPHV16
X_12632_ _12632_/A _12632_/B _12632_/C _12632_/D VDD VSS _12868_/A OAOI211X2
XFILLER_11_230 VDD VSS DECAPHV32
XTAP_TAPCELL_ROW_5_66 VDD VSS WELLTAP
X_12563_ _14441_/B _12654_/C _19157_/Q VDD VSS _12643_/C AND3BX1
X_15351_ _15351_/A _15351_/B _15351_/C VDD VSS _15393_/A OAI21X1
X_11514_ _18667_/Q _11519_/B VDD VSS _18694_/D AND2X1
X_12494_ _12499_/A _12499_/B _12495_/D _12499_/C VDD VSS _14534_/A OA211X2
X_14302_ _14334_/A _14302_/B VDD VSS _19034_/D AND2X1
X_18070_ _19281_/Q _18073_/B VDD VSS _18074_/B XOR2X1
X_15282_ _15844_/B _15844_/C VDD VSS _15306_/B NOR2X1
XFILLER_144_408 VDD VSS FILLER4
XFILLER_144_419 VDD VSS DECAPHV16
X_11445_ _19940_/Q _17990_/A VDD VSS _18633_/D AND2X1
X_14233_ _14136_/Y _14233_/B _14233_/C VDD VSS _18978_/D AND3BX1
Xwire154 wire154/A VDD VSS wire154/Y BUFX4
Xwire165 wire165/A VDD VSS wire165/Y BUFX4
X_17021_ _17838_/A VDD VSS _18187_/C BUFX3
XFILLER_125_611 VDD VSS FILLER1
XFILLER_125_644 VSS VDD FILLER2
XFILLER_137_493 VDD VSS FILLER1
XTAP_TAPCELL_ROW_133_1346 VDD VSS WELLTAP
X_11376_ _11377_/B _11381_/B VDD VSS _11378_/B NOR2BX1
X_14164_ _14197_/A _14164_/B VDD VSS _18918_/D AND2X1
XFILLER_106_880 VSS VDD FILLER2
XFILLER_98_539 VDD VSS FILLER1
X_10327_ _18685_/Q _18739_/Q VDD VSS _10329_/C AND2X1
X_13115_ _19107_/Q _14385_/B _14385_/C VDD VSS _13116_/D OR3BX1
X_14095_ _14118_/A _17969_/B VDD VSS _18870_/D NOR2X1
X_18972_ _19001_/CK _18972_/D _18972_/Q VDD VSS DFFQX1
XFILLER_106_891 VSS VDD FILLER2
XFILLER_140_636 VDD VSS FILLER4
XFILLER_79_720 VDD VSS FILLER1
XFILLER_79_742 VSS VDD FILLER2
X_10258_ _10266_/C _10258_/B _10258_/C _10258_/D VDD VSS _10264_/A AOI22X1
X_13046_ _20009_/Q _19273_/Q VDD VSS _13054_/D NAND2X1
X_17923_ _17990_/A _17923_/B VDD VSS _19952_/D AND2X1
XFILLER_39_606 VSS VDD FILLER2
XFILLER_59_81 VDD VSS FILLER4
XFILLER_120_371 VDD VSS FILLER1
XFILLER_67_948 VSS VDD FILLER2
X_10189_ _10189_/A _10189_/B _10189_/C VDD VSS _10200_/A OAI21X1
X_17854_ _17855_/B _17868_/C VDD VSS _17856_/B NOR2BX1
X_17785_ _17785_/A _17785_/B _17785_/C VDD VSS _17793_/A OA21X2
X_16805_ _16811_/A _16805_/B VDD VSS _19648_/D NOR2X1
X_14997_ _15045_/A _15045_/B _15045_/C VDD VSS _15024_/A AOI21X1
XFILLER_35_812 VSS VDD FILLER2
XFILLER_47_672 VDD VSS FILLER1
XTAP_TAPCELL_ROW_144_1453 VDD VSS WELLTAP
XTAP_TAPCELL_ROW_92_935 VDD VSS WELLTAP
X_13948_ _18949_/Q _14199_/B _14199_/C VDD VSS _13993_/D OR3BX1
X_19524_ _19543_/CK _19524_/D _19524_/Q VDD VSS DFFQX1
X_16736_ _16768_/A _16736_/B VDD VSS _19587_/D AND2X1
XFILLER_34_333 VDD VSS FILLER1
XFILLER_35_834 VSS VDD FILLER2
XTAP_TAPCELL_ROW_144_1464 VDD VSS WELLTAP
XTAP_TAPCELL_ROW_64_659 VDD VSS WELLTAP
X_19455_ _19483_/CK _19455_/D _19455_/Q VDD VSS DFFQX1
XFILLER_50_815 VDD VSS FILLER4
X_13879_ _14163_/A _17940_/B _17940_/C VDD VSS _18864_/D NOR3X1
X_18406_ _18407_/CK _18406_/D _18406_/Q _18452_/RB VDD VSS DFFRQX1
X_16667_ _16668_/B _16667_/B _16667_/C VDD VSS _19544_/D AOI21X1
XFILLER_50_859 VDD VSS FILLER1
XFILLER_61_185 VDD VSS FILLER1
XFILLER_98_2 VDD VSS FILLER1
X_19386_ _19435_/CK _19386_/D _19386_/Q VDD VSS DFFQX1
X_16598_ _19605_/Q _16756_/B VDD VSS _16606_/A NOR2X1
X_15618_ _15761_/B VDD VSS _15619_/B INVX1
X_18337_ _18342_/CK _18337_/D _18337_/Q _18373_/RB VDD VSS DFFRQX1
X_15549_ _15574_/B _15549_/B VDD VSS _15822_/B XNOR2X1
X_18268_ _18275_/CK _18268_/D _18268_/Q _20080_/RB VDD VSS DFFRQX1
X_17219_ _17221_/B _17219_/B VDD VSS _17220_/B XOR2X1
X_18199_ _18199_/A _18199_/B VDD VSS _20015_/D NOR2X1
XFILLER_115_132 VSS VDD FILLER2
XFILLER_116_633 VDD VSS FILLER4
X_20161_ _20161_/A VDD VSS _20161_/Y BUFX3
XFILLER_103_349 VDD VSS FILLER4
XFILLER_57_403 VSS VDD FILLER2
XFILLER_85_701 VSS VDD FILLER2
XFILLER_97_561 VSS VDD FILLER2
X_20092_ _20092_/A VDD VSS output8/A BUFX3
XFILLER_26_878 VDD VSS FILLER1
XTAP_TAPCELL_ROW_108_1094 VDD VSS WELLTAP
XFILLER_25_388 VSS VDD FILLER2
XFILLER_80_494 VDD VSS FILLER1
XTAP_TAPCELL_ROW_35_361 VDD VSS WELLTAP
X_09406_ _09390_/B _13283_/A VDD VSS _230_/E NAND2BX1
X_09337_ _20071_/RB _09414_/D VDD VSS _09337_/Y NOR2BX1
XFILLER_139_747 VDD VSS FILLER4
XFILLER_21_561 VDD VSS FILLER4
X_09268_ _18278_/Q _09354_/A VDD VSS _09269_/D NAND2X1
XFILLER_138_268 VDD VSS FILLER1
XFILLER_112_4 VSS VDD FILLER2
X_09199_ _18512_/Q VDD VSS _18443_/D INVX1
XFILLER_106_110 VSS VDD FILLER2
X_11230_ _11230_/A _11230_/B VDD VSS _11379_/B OR2X2
XFILLER_122_603 VDD VSS FILLER1
XFILLER_136_53 VDD VSS DECAPHV8
X_11161_ _18682_/Q _18790_/Q VDD VSS _11163_/D XOR2X1
X_10112_ _10180_/A _11415_/C VDD VSS _18537_/D NOR2X1
XFILLER_136_97 VDD VSS FILLER4
X_11092_ _11118_/A VDD VSS _11298_/A BUFX3
XFILLER_130_691 VDD VSS FILLER1
X_10043_ _18582_/Q _10054_/B VDD VSS _10043_/Y XOR2X1
X_14920_ _14920_/A _15833_/B _14920_/C _14920_/D VDD VSS wire161/A OAOI211X1
XFILLER_102_393 VDD VSS FILLER1
XFILLER_76_756 VDD VSS DECAPHV8
X_14851_ _14851_/A _14855_/C VDD VSS _15679_/B XNOR2X1
XFILLER_29_661 VDD VSS FILLER4
X_13802_ _18891_/Q _13802_/B _14132_/C VDD VSS _17924_/C XNOR3X1
X_17570_ _17569_/B _17570_/B VDD VSS _17572_/C NOR2BX1
XFILLER_16_300 VDD VSS FILLER4
XFILLER_16_322 VSS VDD FILLER2
XFILLER_17_834 VSS VDD FILLER2
X_11994_ _19998_/Q _19262_/Q VDD VSS _12108_/A AND2X1
X_16521_ _16505_/B _16521_/B _16521_/C VDD VSS _16546_/B AOI2B1X1
X_14782_ _19474_/Q _15865_/B VDD VSS _14783_/D _15865_/C AND3X2
XFILLER_45_61 VDD VSS FILLER4
X_10945_ _10945_/A VDD VSS _10984_/A BUFX3
X_13733_ _13733_/A _13733_/B _13733_/C _13733_/D VDD VSS _13735_/C OAI211X1
Xclkbuf_leaf_42__001_ clkbuf_leaf_5__001_/A VDD VSS _19242_/CK BUFX12
XFILLER_32_848 VDD VSS DECAPHV8
XFILLER_43_174 VSS VDD FILLER2
XTAP_TAPCELL_ROW_61_629 VDD VSS WELLTAP
X_10876_ _11095_/C _10876_/B _10876_/C VDD VSS _10876_/Y OAI21X1
X_13664_ _18888_/Q _14129_/B VDD VSS _13869_/C _14129_/C AND3X2
X_19240_ _19242_/CK _19240_/D _19240_/Q VDD VSS DFFQX1
X_16452_ _19600_/Q _16751_/B VDD VSS _16454_/A XNOR2X1
XFILLER_31_347 VDD VSS DECAPHV8
XFILLER_31_369 VSS VDD FILLER2
X_12615_ _12617_/A _12617_/B _14182_/B VDD VSS _12701_/C XNOR3X1
X_19171_ _19171_/CK _19171_/D _19171_/Q VDD VSS DFFQX1
X_16383_ _16383_/A _16386_/B VDD VSS _16384_/B XOR2X1
X_15403_ _15434_/A _15434_/B VDD VSS _15882_/B XNOR2X1
X_13595_ _13686_/A _13686_/B _14226_/C VDD VSS _14227_/B AOI21BX1
X_18122_ _18132_/A _18122_/B _18123_/C VDD VSS _19998_/D NOR3X1
X_15334_ _15340_/A _15690_/B VDD VSS _15338_/A XNOR2X1
X_12546_ _12557_/A _12546_/B _12546_/C VDD VSS _12634_/C XNOR3X1
X_12477_ _12483_/A _12483_/B _12483_/D _12483_/C VDD VSS _14439_/C OAI211X1
X_18053_ _18547_/Q _18053_/B VDD VSS _18054_/B XOR2X1
X_15265_ _15265_/A _15265_/B _15813_/B VDD VSS _15347_/A MIN3X1
XANTENNA_4 _18087_/D VDD VSS ANTENNA2
XFILLER_125_430 VDD VSS FILLER1
XFILLER_99_804 VDD VSS FILLER4
X_11428_ _18549_/D _11428_/B VDD VSS _18621_/D NOR2BX1
X_14216_ _14218_/A _14216_/B VDD VSS _18965_/D NOR2X1
X_17004_ _17002_/Y _17004_/B _17986_/C VDD VSS _19755_/D AND3BX1
X_15196_ _19456_/Q _15842_/B VDD VSS _15227_/B XOR2X1
XFILLER_113_614 VDD VSS FILLER1
X_11359_ _11359_/A _11364_/D VDD VSS _11367_/C XOR2X1
X_14147_ _14154_/A _14147_/B VDD VSS _18903_/D NOR2X1
XFILLER_98_336 VSS VDD FILLER2
Xclkbuf_0__09180_ _18229_/ECK VDD VSS clkbuf_0__09180_/Y BUFX12
XFILLER_140_466 VDD VSS DECAPHV8
XTAP_TAPCELL_ROW_69_707 VDD VSS WELLTAP
X_14078_ _14078_/A _14078_/B _14078_/C VDD VSS _14140_/C OAI21X1
X_18955_ _18970_/CK _18955_/D _18955_/Q VDD VSS DFFQX1
X_13029_ _13111_/A _14413_/B _13041_/C VDD VSS _14414_/C OR3BX1
X_18886_ _18888_/CK _18886_/D _18886_/Q VDD VSS DFFQX1
X_17906_ _17911_/C _17906_/B _17906_/C VDD VSS _17907_/A AOI2B1X1
X_17837_ _17842_/C _17837_/B VDD VSS _19934_/D NOR2X1
XFILLER_82_704 VDD VSS FILLER1
XFILLER_94_597 VDD VSS FILLER4
XTAP_TAPCELL_ROW_77_784 VDD VSS WELLTAP
XFILLER_47_491 VDD VSS FILLER4
X_17768_ _19916_/Q _19884_/Q _17768_/C VDD VSS _17773_/C AO21X2
X_19507_ _19543_/CK _19507_/D _19507_/Q VDD VSS DFFQX1
X_17699_ _19902_/Q _19870_/Q VDD VSS _17700_/B XOR2X1
X_16719_ _19923_/Q _16726_/B VDD VSS _19571_/D AND2X1
XFILLER_62_494 VDD VSS FILLER4
X_19438_ _19466_/CK _19438_/D _19438_/Q VDD VSS DFFQX1
XFILLER_50_645 VDD VSS FILLER4
XTAP_TAPCELL_ROW_32_331 VDD VSS WELLTAP
X_19369_ _19547_/CK _19369_/D _19369_/Q VDD VSS DFFQX1
XFILLER_135_205 VDD VSS DECAPHV8
XFILLER_129_791 VDD VSS FILLER1
XFILLER_144_750 VDD VSS FILLER4
XFILLER_144_761 VDD VSS FILLER4
X_20213_ _20213_/A VDD VSS _20213_/Y BUFX3
XFILLER_103_102 VDD VSS FILLER1
XFILLER_131_433 VDD VSS FILLER1
XFILLER_143_271 VSS VDD FILLER2
X_09955_ _09955_/A _09981_/C VDD VSS _11403_/C XOR2X1
X_20144_ _20144_/A VDD VSS _20144_/Y BUFX3
XFILLER_57_200 VDD VSS FILLER4
XFILLER_98_881 VSS VDD FILLER2
X_09886_ _09925_/B _09884_/Y _10032_/A VDD VSS _09887_/B MUXI2X1
X_20075_ _20081_/CK _20075_/D _20075_/Q _20075_/RB VDD VSS DFFRQX1
XFILLER_85_553 VDD VSS FILLER4
XFILLER_97_391 VDD VSS DECAPHV8
XFILLER_100_886 VSS VDD FILLER2
XFILLER_122_88 VDD VSS FILLER4
XFILLER_14_826 VSS VDD FILLER2
X_10730_ _10765_/A _10765_/C _10765_/B _10763_/A VDD VSS _10731_/D OAOI211X1
XFILLER_40_144 VDD VSS FILLER1
XFILLER_41_656 VDD VSS FILLER1
X_10661_ _10960_/A _10661_/B _10661_/C VDD VSS _10709_/B OAI21X1
X_12400_ _12396_/B _14531_/C _19237_/Q VDD VSS _12401_/D AND3BX1
XFILLER_139_544 VDD VSS FILLER1
XFILLER_22_892 VDD VSS FILLER1
X_10592_ _10592_/A _10592_/B _10594_/A _10592_/D VDD VSS _10594_/B AOI211X1
X_13380_ _13486_/A _13486_/B _13496_/C VDD VSS _17905_/B XNOR3X1
XFILLER_127_717 VSS VDD FILLER2
XFILLER_139_599 VDD VSS DECAPHV8
X_12331_ _12331_/A _12474_/B _12473_/C VDD VSS _12472_/B XNOR3X1
XTAP_TAPCELL_ROW_2_34 VDD VSS WELLTAP
X_12262_ _19042_/Q _12513_/B _14278_/B VDD VSS _12280_/C XNOR3X1
X_15050_ _15092_/A _15092_/B _15092_/C VDD VSS _15088_/A AOI21X1
XFILLER_103_0 VSS VDD FILLER2
XFILLER_135_783 VDD VSS FILLER1
X_11213_ _11289_/A _11213_/B VDD VSS _11214_/C NOR2X1
X_14001_ _14001_/A _14001_/B _14001_/C _14001_/D VDD VSS _14045_/A AOAI211X1
Xoutput6 output6/A VDD VSS miso BUFX3
XFILLER_134_271 VDD VSS FILLER4
XFILLER_134_282 VSS VDD FILLER2
XTAP_TAPCELL_ROW_130_1316 VDD VSS WELLTAP
X_12193_ _12199_/A _12199_/B _14208_/B VDD VSS _14177_/B XNOR3X1
Xoutput30 _20114_/Y VDD VSS o_bias_cfg[16] BUFX3
Xoutput41 _20124_/Y VDD VSS o_bias_cfg[26] BUFX3
Xoutput52 _20102_/Y VDD VSS o_bias_cfg[4] BUFX3
XFILLER_1_730 VSS VDD FILLER2
XFILLER_1_763 VSS VDD FILLER2
X_11144_ _11171_/C _11144_/B _11144_/C _11208_/A VDD VSS _11149_/B AOI2B2X1
Xoutput63 _20147_/Y VDD VSS o_clk_cfg[14] BUFX3
Xoutput74 _20140_/Y VDD VSS o_clk_cfg[7] BUFX3
Xoutput85 _20159_/Y VDD VSS o_en_ctrl[7] BUFX3
XFILLER_110_628 VDD VSS FILLER1
XFILLER_1_796 VDD VSS FILLER4
X_11075_ _11075_/A _11099_/C VDD VSS _11076_/C XNOR2X1
Xoutput96 _20165_/Y VDD VSS o_lf_cfg[2] BUFX3
X_18740_ _18768_/CK _18740_/D _18740_/Q VDD VSS DFFQX1
X_15952_ _19642_/Q _16797_/B VDD VSS _15979_/A NOR2BX1
X_10026_ _10026_/A _10026_/B _10026_/C VDD VSS _10050_/B OAI21X1
X_18671_ _18809_/CK _18671_/D _18671_/Q VDD VSS DFFQX1
X_14903_ _19393_/Q VDD VSS _14904_/A INVX1
X_17622_ _17625_/C _17623_/B _17654_/C VDD VSS _17623_/C OAI21X1
X_15883_ _15895_/A _15883_/B VDD VSS _19490_/D NOR2X1
X_14834_ _14908_/A _14908_/B _14867_/C VDD VSS _14861_/B AOI21BX1
XTAP_TAPCELL_ROW_141_1423 VDD VSS WELLTAP
XTAP_TAPCELL_ROW_74_754 VDD VSS WELLTAP
X_11977_ wire162/Y _12029_/B _12029_/C VDD VSS _11999_/B AOI21X1
X_17553_ _19871_/Q _19839_/Q VDD VSS _17554_/B XOR2X1
X_14765_ _14768_/A _14765_/B VDD VSS _18059_/B XNOR2X1
XFILLER_32_623 VDD VSS FILLER4
XFILLER_72_781 VDD VSS FILLER1
XFILLER_91_589 VDD VSS FILLER1
XTAP_TAPCELL_ROW_46_478 VDD VSS WELLTAP
X_10928_ _10962_/A _10962_/B _10928_/C VDD VSS _10944_/A OAI21X1
X_13716_ _13716_/A _13716_/B _13716_/C _13716_/D VDD VSS _13857_/A OAOI211X1
X_17484_ _19855_/Q _19823_/Q _17484_/C VDD VSS _17488_/B MIN3X1
X_16504_ _19634_/Q _16788_/B VDD VSS _16505_/B XNOR2X1
X_19223_ _19234_/CK _19223_/D _19223_/Q VDD VSS DFFQX1
X_16435_ _19695_/Q _16856_/B VDD VSS _16437_/C XNOR2X1
X_14696_ _19388_/Q _14696_/B _15766_/B VDD VSS _14758_/B MIN3X1
X_10859_ _18699_/Q VDD VSS _11550_/A INVX1
X_13647_ _13727_/A _13728_/B _13728_/C VDD VSS _13649_/C OR3BX1
X_13578_ _13578_/A _13578_/B _13578_/C _13578_/D VDD VSS _13591_/B AOAI211X1
X_19154_ _19182_/CK _19154_/D _19154_/Q VDD VSS DFFQX1
X_16366_ _19596_/Q _16366_/B _16746_/B VDD VSS _16398_/A MIN3X1
X_12529_ _12612_/A _12532_/B _12532_/C VDD VSS _17868_/B XNOR3X1
X_19085_ _19085_/CK _19085_/D _19085_/Q VDD VSS DFFQX1
X_18105_ _18105_/A _18105_/B _18105_/C VDD VSS _19995_/D AOI21X1
X_16297_ _16308_/C _16297_/B VDD VSS _16851_/B AND2X1
X_15317_ _15359_/D _15359_/C VDD VSS _15354_/C NAND2BX1
X_18036_ _18538_/Q _18036_/B _18539_/Q VDD VSS _18037_/C AOI21X1
X_15248_ _15265_/A _15265_/B _15813_/B VDD VSS _15781_/B XNOR3X1
XFILLER_114_912 VDD VSS FILLER1
XFILLER_99_601 VSS VDD FILLER2
XFILLER_125_282 VDD VSS DECAPHV16
X_15179_ _19427_/Q _15811_/B VDD VSS _15180_/C NOR2BX1
XFILLER_113_455 VDD VSS FILLER1
XFILLER_140_230 VSS VDD FILLER2
XFILLER_4_590 VDD VSS FILLER1
XFILLER_87_829 VDD VSS DECAPHV8
X_19987_ _19988_/CK _19987_/D _19987_/Q VDD VSS DFFQX1
XFILLER_86_317 VDD VSS FILLER1
XFILLER_98_188 VDD VSS DECAPHV8
X_09740_ _09753_/D _09740_/B _09740_/C _09819_/A VDD VSS _09741_/E OAI22X1
X_18938_ _18970_/CK _18938_/D _18938_/Q VDD VSS DFFQX1
.ends
