* SPDX-FileCopyrightText: 2026 Michael Koefinger
* SPDX-License-Identifier: Apache-2.0 WITH SHL-2.1
* sg13cmos5l_ip__cut_vdd: IO ring cell without the vdd band, no devices, the LVS reference

.SUBCKT sg13cmos5l_ip__cut_vdd vss iovdd iovss
*.PININFO vss:B iovdd:B iovss:B
.ENDS
