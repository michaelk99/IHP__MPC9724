* NGSPICE file created from decimator_top.ext - technology: ihp-sg13cmos5l

* Black-box entry subcircuit for FILLER4 abstract view
.subckt FILLER4 VDD VSS
.ends

* Black-box entry subcircuit for WELLTAP abstract view
.subckt WELLTAP VDD VSS
.ends

* Black-box entry subcircuit for NOR3X1 abstract view
.subckt NOR3X1 A B C VDD VSS Y
.ends

* Black-box entry subcircuit for DFFQX1 abstract view
.subckt DFFQX1 CK D Q VDD VSS
.ends

* Black-box entry subcircuit for FILLER2 abstract view
.subckt FILLER2 VSS VDD
.ends

* Black-box entry subcircuit for DECAPHV32 abstract view
.subckt DECAPHV32 VDD VSS
.ends

* Black-box entry subcircuit for FILLER1 abstract view
.subckt FILLER1 VDD VSS
.ends

* Black-box entry subcircuit for XNOR2X1 abstract view
.subckt XNOR2X1 A B VDD VSS Y
.ends

* Black-box entry subcircuit for BUFX12 abstract view
.subckt BUFX12 A VDD VSS Y
.ends

* Black-box entry subcircuit for DECAPHV16 abstract view
.subckt DECAPHV16 VDD VSS
.ends

* Black-box entry subcircuit for XOR2X1 abstract view
.subckt XOR2X1 A B VDD VSS Y
.ends

* Black-box entry subcircuit for AND2X1 abstract view
.subckt AND2X1 A B VDD VSS Y
.ends

* Black-box entry subcircuit for INVX1 abstract view
.subckt INVX1 A VDD VSS Y
.ends

* Black-box entry subcircuit for XOR3X1 abstract view
.subckt XOR3X1 A B C VDD VSS Y
.ends

* Black-box entry subcircuit for DECAPHV8 abstract view
.subckt DECAPHV8 VDD VSS
.ends

* Black-box entry subcircuit for OAOI211X1 abstract view
.subckt OAOI211X1 A B C D VDD VSS Y
.ends

* Black-box entry subcircuit for XNOR3X1 abstract view
.subckt XNOR3X1 A B C VDD VSS Y
.ends

* Black-box entry subcircuit for NOR2X1 abstract view
.subckt NOR2X1 A B VDD VSS Y
.ends

* Black-box entry subcircuit for MUXI2X1 abstract view
.subckt MUXI2X1 A0 A1 S0 VDD VSS Y
.ends

* Black-box entry subcircuit for AND3BX1 abstract view
.subckt AND3BX1 AB B C VDD VSS Y
.ends

* Black-box entry subcircuit for NAND2X1 abstract view
.subckt NAND2X1 A B VDD VSS Y
.ends

* Black-box entry subcircuit for AOAI211X1 abstract view
.subckt AOAI211X1 A B C D VDD VSS Y
.ends

* Black-box entry subcircuit for OAI21X1 abstract view
.subckt OAI21X1 A B C VDD VSS Y
.ends

* Black-box entry subcircuit for OA21X2 abstract view
.subckt OA21X2 A B C VDD VSS Y
.ends

* Black-box entry subcircuit for AND4X2 abstract view
.subckt AND4X2 A B C D VDD VSS Y
.ends

* Black-box entry subcircuit for BUFX4 abstract view
.subckt BUFX4 A VDD VSS Y
.ends

* Black-box entry subcircuit for AOI31X1 abstract view
.subckt AOI31X1 A B C D VDD VSS Y
.ends

* Black-box entry subcircuit for MIN3X1 abstract view
.subckt MIN3X1 A B C VDD VSS Y
.ends

* Black-box entry subcircuit for OR3BX1 abstract view
.subckt OR3BX1 AB B C VDD VSS Y
.ends

* Black-box entry subcircuit for AOI21X1 abstract view
.subckt AOI21X1 A B C VDD VSS Y
.ends

* Black-box entry subcircuit for NOR2BX1 abstract view
.subckt NOR2BX1 AB B VDD VSS Y
.ends

* Black-box entry subcircuit for BUFX3 abstract view
.subckt BUFX3 A VDD VSS Y
.ends

* Black-box entry subcircuit for MUX2X1 abstract view
.subckt MUX2X1 A0 A1 S0 VDD VSS Y
.ends

* Black-box entry subcircuit for NAND3X1 abstract view
.subckt NAND3X1 A B VDD VSS Y C
.ends

* Black-box entry subcircuit for AO21X2 abstract view
.subckt AO21X2 A B C VDD VSS Y
.ends

* Black-box entry subcircuit for AOI211X1 abstract view
.subckt AOI211X1 A B C D VDD VSS Y
.ends

* Black-box entry subcircuit for NAND2BX1 abstract view
.subckt NAND2BX1 AB B VDD VSS Y
.ends

* Black-box entry subcircuit for OAI211X1 abstract view
.subckt OAI211X1 A B C D VDD VSS Y
.ends

* Black-box entry subcircuit for AO22X2 abstract view
.subckt AO22X2 A B C D VDD VSS Y
.ends

* Black-box entry subcircuit for INVX2 abstract view
.subckt INVX2 A VDD VSS Y
.ends

* Black-box entry subcircuit for OAI31X1 abstract view
.subckt OAI31X1 A B C D VDD VSS Y
.ends

* Black-box entry subcircuit for OR3X2 abstract view
.subckt OR3X2 A B C VDD VSS Y
.ends

* Black-box entry subcircuit for AOI2B1X1 abstract view
.subckt AOI2B1X1 AB B C VDD VSS Y
.ends

* Black-box entry subcircuit for AND3X2 abstract view
.subckt AND3X2 A B VDD VSS Y C
.ends

* Black-box entry subcircuit for ANTENNA2 abstract view
.subckt ANTENNA2 A VDD VSS
.ends

* Black-box entry subcircuit for AOI22X1 abstract view
.subckt AOI22X1 A B C D VDD VSS Y
.ends

* Black-box entry subcircuit for AO211X2 abstract view
.subckt AO211X2 A B C D VDD VSS Y
.ends

* Black-box entry subcircuit for OR2X2 abstract view
.subckt OR2X2 A B VDD VSS Y
.ends

* Black-box entry subcircuit for OA211X2 abstract view
.subckt OA211X2 A B C D VDD VSS Y
.ends

* Black-box entry subcircuit for AOI21BX1 abstract view
.subckt AOI21BX1 A B CB VDD VSS Y
.ends

* Black-box entry subcircuit for OAOI211X2 abstract view
.subckt OAOI211X2 A B C D VDD VSS Y
.ends

* Black-box entry subcircuit for INVX4 abstract view
.subckt INVX4 A VDD VSS Y
.ends

* Black-box entry subcircuit for AOI2B2X1 abstract view
.subckt AOI2B2X1 AB B C D VDD VSS Y
.ends

* Black-box entry subcircuit for NOR3BX1 abstract view
.subckt NOR3BX1 AB B C VDD VSS Y
.ends

* Black-box entry subcircuit for AO31X2 abstract view
.subckt AO31X2 A B C D VDD VSS Y
.ends

* Black-box entry subcircuit for AOAI211X2 abstract view
.subckt AOAI211X2 A B C D VDD VSS Y
.ends

* Black-box entry subcircuit for AOI221X1 abstract view
.subckt AOI221X1 A B C D E VDD VSS Y
.ends

* Black-box entry subcircuit for INVX14 abstract view
.subckt INVX14 A VDD VSS Y
.ends

* Black-box entry subcircuit for NAND4X2 abstract view
.subckt NAND4X2 A B VDD VSS Y C D
.ends

* Black-box entry subcircuit for OAI22X1 abstract view
.subckt OAI22X1 A B C D VDD VSS Y
.ends

* Black-box entry subcircuit for NOR4X1 abstract view
.subckt NOR4X1 A B C D VDD VSS Y
.ends

* Black-box entry subcircuit for AOI2B2BX1 abstract view
.subckt AOI2B2BX1 AB B CB D VDD VSS Y
.ends

* Black-box entry subcircuit for INVX6 abstract view
.subckt INVX6 A VDD VSS Y
.ends

* Black-box entry subcircuit for INVX8 abstract view
.subckt INVX8 A VDD VSS Y
.ends

* Black-box entry subcircuit for OAI221X1 abstract view
.subckt OAI221X1 A B C D E VDD VSS Y
.ends

* Black-box entry subcircuit for NOR2X2 abstract view
.subckt NOR2X2 A B VDD VSS Y
.ends

* Black-box entry subcircuit for OR4X1 abstract view
.subckt OR4X1 A B VDD VSS Y C D
.ends

* Black-box entry subcircuit for INVX16 abstract view
.subckt INVX16 A VDD VSS Y
.ends

* Black-box entry subcircuit for NOR4BX1 abstract view
.subckt NOR4BX1 AB B C D VDD VSS Y
.ends

* Black-box entry subcircuit for NAND3BX1 abstract view
.subckt NAND3BX1 AB B C VDD VSS Y
.ends

* Black-box entry subcircuit for AND3BX2 abstract view
.subckt AND3BX2 AB B C VDD VSS Y
.ends

* Black-box entry subcircuit for CGX3 abstract view
.subckt CGX3 CK E ECK VDD VSS
.ends

* Black-box entry subcircuit for BUFX6 abstract view
.subckt BUFX6 A VDD VSS Y
.ends

* Black-box entry subcircuit for OAI2B2BX1 abstract view
.subckt OAI2B2BX1 AB B CB D VDD VSS Y
.ends

* Black-box entry subcircuit for INVX3 abstract view
.subckt INVX3 A VDD VSS Y
.ends

* Black-box entry subcircuit for NOR3BX1P5 abstract view
.subckt NOR3BX1P5 AB B C VDD VSS Y
.ends

* Black-box entry subcircuit for NAND2X1P5 abstract view
.subckt NAND2X1P5 A B VDD VSS Y
.ends

.subckt decimator_top VDD VSS clk_fs data_in data_out[0] data_out[10] data_out[11]
+ data_out[12] data_out[13] data_out[14] data_out[15] data_out[16] data_out[17] data_out[18]
+ data_out[19] data_out[1] data_out[20] data_out[21] data_out[2] data_out[3] data_out[4]
+ data_out[5] data_out[6] data_out[7] data_out[8] data_out[9] rst_b valid_strobe
XFILLER_39_244 VDD VSS FILLER4
XFILLER_55_715 VDD VSS FILLER4
XTAP_TAPCELL_ROW_107_1307 VDD VSS WELLTAP
X_09671_ _09671_/A _09671_/B _09671_/C VDD VSS _09672_/B NOR3X1
X_18869_ _18950_/CK _18869_/D _18869_/Q VDD VSS DFFQX1
XFILLER_54_225 VDD VSS FILLER4
XFILLER_70_729 VSS VDD FILLER2
XTAP_TAPCELL_ROW_37_467 VDD VSS WELLTAP
XTAP_TAPCELL_ROW_65_798 VDD VSS WELLTAP
XFILLER_126_1104 VDD VSS DECAPHV32
XFILLER_23_645 VDD VSS FILLER1
XFILLER_74_1036 VDD VSS FILLER1
XFILLER_11_818 VDD VSS FILLER1
XFILLER_23_689 VSS VDD FILLER2
XFILLER_108_216 VDD VSS FILLER1
XFILLER_109_728 VDD VSS FILLER1
XTAP_TAPCELL_ROW_118_1436 VDD VSS WELLTAP
X_09105_ _09129_/C _09105_/B VDD VSS _17462_/B XNOR2X1
X_09036_ _17634_/Q _17427_/B VDD VSS _09038_/A XNOR2X1
XFILLER_117_772 VDD VSS FILLER1
XFILLER_124_709 VDD VSS FILLER1
XFILLER_116_282 VDD VSS FILLER1
XFILLER_132_720 VSS VDD FILLER2
XTAP_TAPCELL_ROW_9_126 VDD VSS WELLTAP
XFILLER_104_444 VDD VSS FILLER1
XFILLER_78_818 VDD VSS FILLER4
Xclkbuf_leaf_41__002_ clkload26/A VDD VSS _18505_/CK BUFX12
XFILLER_104_499 VDD VSS FILLER4
XFILLER_132_797 VDD VSS FILLER1
XFILLER_133_1119 VDD VSS DECAPHV16
X_09938_ _17794_/Q _09945_/A VDD VSS _09943_/C XOR2X1
XFILLER_133_32 VDD VSS DECAPHV32
XFILLER_19_907 VDD VSS FILLER4
XFILLER_18_417 VDD VSS FILLER1
XFILLER_19_918 VDD VSS FILLER1
XFILLER_19_929 VDD VSS FILLER1
XFILLER_46_726 VDD VSS FILLER1
XFILLER_58_586 VDD VSS DECAPHV16
XFILLER_86_862 VDD VSS DECAPHV16
XTAP_TAPCELL_ROW_129_1565 VDD VSS WELLTAP
X_09869_ _17392_/A _10087_/B VDD VSS _17811_/D AND2X1
XFILLER_46_748 VDD VSS DECAPHV16
X_11900_ _18463_/Q VDD VSS _12096_/A INVX1
X_12880_ _18159_/Q wire27/Y _12880_/C VDD VSS _12899_/C XOR3X1
X_11831_ _18305_/Q VDD VSS _11916_/A INVX1
XFILLER_14_601 VSS VDD FILLER2
XFILLER_26_472 VDD VSS DECAPHV8
XFILLER_60_217 VDD VSS FILLER1
XFILLER_61_729 VSS VDD FILLER2
X_14550_ _18556_/Q VDD VSS _14699_/A INVX1
X_11762_ wire28/Y _11763_/B _11763_/D _11763_/C VDD VSS _11931_/B OAOI211X1
X_13501_ _18426_/Q _13598_/B _13598_/C VDD VSS _13597_/B XNOR3X1
XFILLER_13_166 VDD VSS DECAPHV8
XFILLER_41_464 VDD VSS FILLER1
X_10713_ _10731_/A _10846_/A VDD VSS _17929_/D NOR2X1
X_11693_ _11693_/A _11693_/B _11760_/C _11693_/D VDD VSS _11853_/A OAOI211X1
X_14481_ _15300_/A _14481_/B VDD VSS _18497_/D AND2X1
XFILLER_42_40 VDD VSS FILLER4
X_10644_ _17889_/Q _10648_/B VDD VSS _10645_/B XOR2X1
X_16220_ _16181_/B _16263_/B _16554_/A VDD VSS _16222_/B MUXI2X1
X_13432_ _14053_/A _13432_/B VDD VSS _18047_/D NOR2X1
XFILLER_107_1092 VSS VDD FILLER2
XFILLER_127_503 VDD VSS FILLER1
X_10575_ _10571_/B _10575_/B _17876_/Q VDD VSS _10576_/D AND3BX1
X_16151_ _18902_/Q _16527_/B VDD VSS _16152_/C NAND2X1
X_13363_ _13373_/A _13363_/B _13466_/D VDD VSS _13455_/C XNOR3X1
X_12314_ _12419_/A _12506_/B VDD VSS _14232_/B XNOR2X1
X_15102_ _15240_/A _18673_/Q VDD VSS _18646_/D AND2X1
X_13294_ _13294_/A _13294_/B _13294_/C _13294_/D VDD VSS _13416_/B AOAI211X1
X_16082_ _16082_/A _16082_/B _16082_/C _16082_/D VDD VSS _16169_/B AOAI211X1
X_12245_ _12545_/B _14115_/C _18179_/Q VDD VSS _12246_/D AND3BX1
X_15033_ _15037_/A _15034_/B _17255_/D VDD VSS _15034_/C OAI21X1
XFILLER_122_230 VSS VDD FILLER2
XFILLER_69_807 VDD VSS FILLER1
X_12176_ _12179_/B _12179_/C _12176_/C VDD VSS _12213_/B OA21X2
X_11127_ _11127_/A _11127_/B _11127_/C VDD VSS _11132_/C OA21X2
XFILLER_114_1030 VDD VSS DECAPHV8
XFILLER_122_285 VDD VSS FILLER1
XFILLER_1_593 VDD VSS DECAPHV32
XFILLER_68_339 VSS VDD FILLER2
XFILLER_77_840 VDD VSS FILLER1
X_16984_ _16984_/A _16984_/B VDD VSS _17019_/B AND2X1
XFILLER_67_92 VDD VSS FILLER1
XFILLER_77_862 VDD VSS FILLER1
XFILLER_95_169 VDD VSS FILLER1
X_11058_ _11062_/A _11190_/B VDD VSS _17995_/D AND2X1
X_18723_ _18858_/CK _18723_/D _18723_/Q VDD VSS DFFQX1
X_15935_ _16180_/A _15980_/A _15980_/B _15980_/C VDD VSS _16021_/B AND4X2
XFILLER_92_832 VDD VSS FILLER4
X_10009_ _10009_/A _10013_/B VDD VSS _10214_/C XNOR2X1
X_18654_ _18844_/CK _18654_/D _18654_/Q VDD VSS DFFQX1
X_15866_ _16062_/A _15902_/D VDD VSS _15867_/B NAND2X1
X_18585_ clkload8/A _18585_/D _18585_/Q VDD VSS DFFQX1
Xwire29 wire29/A VDD VSS wire29/Y BUFX4
X_17605_ _17701_/CK _17605_/D _17605_/Q VDD VSS DFFQX1
X_14817_ _14819_/B _14817_/B VDD VSS _14818_/B XOR2X1
XFILLER_18_984 VDD VSS DECAPHV8
XFILLER_51_217 VDD VSS FILLER4
XFILLER_83_80 VDD VSS DECAPHV8
XFILLER_91_375 VDD VSS FILLER1
X_17536_ _17536_/A _17536_/B _17536_/C _17536_/D VDD VSS _17536_/Y AOI31X1
X_15797_ _15800_/A _15874_/D VDD VSS _15800_/D NOR2X1
XFILLER_51_239 VDD VSS FILLER1
XFILLER_60_751 VDD VSS FILLER1
XTAP_TAPCELL_ROW_102_1237 VDD VSS WELLTAP
XTAP_TAPCELL_ROW_34_426 VDD VSS WELLTAP
XTAP_TAPCELL_ROW_62_757 VDD VSS WELLTAP
X_14748_ _14751_/A _14751_/B _17266_/C VDD VSS _14749_/C OAI21X1
XFILLER_32_453 VSS VDD FILLER2
XFILLER_32_475 VDD VSS DECAPHV8
XTAP_TAPCELL_ROW_102_1248 VDD VSS WELLTAP
XTAP_TAPCELL_ROW_62_768 VDD VSS WELLTAP
X_17467_ _17479_/A _17467_/B VDD VSS _17672_/D NOR2X1
X_14679_ _18552_/Q _18584_/Q VDD VSS _14684_/A NAND2X1
XFILLER_34_1020 VSS VDD FILLER2
X_17398_ _17434_/A _17398_/B VDD VSS _17607_/D AND2X1
X_16418_ _18909_/Q _16418_/B _16422_/B VDD VSS _16420_/B XNOR3X1
XTAP_TAPCELL_ROW_14_183 VDD VSS WELLTAP
X_16349_ _16349_/A _16349_/B _16349_/C _16349_/D VDD VSS _16424_/A AND4X2
XFILLER_66_0 VDD VSS DECAPHV32
X_18019_ _18024_/CK _18019_/D _18019_/Q VDD VSS DFFQX1
XFILLER_99_442 VSS VDD FILLER2
XFILLER_102_937 VDD VSS FILLER4
XFILLER_113_252 VDD VSS FILLER1
XFILLER_113_263 VDD VSS FILLER1
XFILLER_59_306 VDD VSS FILLER4
XFILLER_99_464 VDD VSS FILLER1
XTAP_TAPCELL_ROW_113_1377 VDD VSS WELLTAP
XFILLER_28_715 VDD VSS FILLER1
XFILLER_80_1062 VDD VSS FILLER4
XFILLER_80_1095 VDD VSS FILLER1
X_09723_ _17691_/Q _17487_/B VDD VSS _09741_/B XOR2X1
XFILLER_67_383 VSS VDD FILLER2
XFILLER_83_832 VDD VSS FILLER4
X_09654_ _09681_/B _09654_/B VDD VSS _17779_/D NOR2X1
Xclkbuf_2_0__f__002_ clkbuf_0__002_/Y VDD VSS clkload25/A BUFX12
X_09585_ _17685_/Q _09585_/B _17481_/B VDD VSS _09604_/B MIN3X1
XFILLER_24_932 VDD VSS FILLER4
XFILLER_24_965 VDD VSS FILLER1
XFILLER_42_239 VDD VSS FILLER4
XFILLER_51_740 VDD VSS FILLER4
XFILLER_10_158 VDD VSS DECAPHV8
XFILLER_12_32 VDD VSS DECAPHV8
XFILLER_6_129 VDD VSS DECAPHV8
XFILLER_124_506 VDD VSS FILLER4
XFILLER_128_32 VDD VSS DECAPHV8
XFILLER_12_87 VSS VDD FILLER2
X_10360_ _10371_/A _10553_/B _10551_/C VDD VSS _10556_/C OR3BX1
X_09019_ _17631_/Q _17423_/B VDD VSS _09020_/B XNOR2X1
X_10291_ _10516_/A _10487_/B VDD VSS _17867_/D NOR2X1
XFILLER_104_230 VSS VDD FILLER2
XFILLER_117_591 VDD VSS FILLER4
X_12030_ _18203_/Q _12234_/A _12035_/B VDD VSS _12032_/C XNOR3X1
XFILLER_104_285 VDD VSS DECAPHV16
XFILLER_59_840 VDD VSS FILLER4
XFILLER_77_136 VDD VSS DECAPHV16
XFILLER_120_789 VDD VSS FILLER1
XFILLER_59_873 VSS VDD FILLER2
X_13981_ _18945_/Q _13981_/B _18946_/Q VDD VSS _13982_/C AOI21X1
X_12932_ _18341_/Q _14300_/B _14300_/C VDD VSS _12933_/D OR3BX1
X_15720_ _18933_/Q _15720_/B VDD VSS _15730_/C NOR2BX1
X_15651_ _15651_/A VDD VSS _15651_/Y BUFX3
XFILLER_73_386 VSS VDD FILLER2
X_12863_ _12863_/A _12863_/B _12863_/C _12863_/D VDD VSS _13071_/A AOAI211X1
X_14602_ _14602_/A _14602_/B _14602_/C VDD VSS _14607_/C OAI21X1
XFILLER_27_792 VDD VSS FILLER1
X_11814_ _11816_/A _11816_/B _14408_/B VDD VSS _14437_/B XNOR3X1
X_12794_ _12834_/A _12825_/B _12843_/C VDD VSS _12947_/A XNOR3X1
X_18370_ _18397_/CK _18370_/D _18370_/Q VDD VSS DFFQX1
X_15582_ _15569_/Y _15581_/Y _15648_/A VDD VSS _15662_/B MUX2X1
XFILLER_18_1026 VDD VSS FILLER1
X_11745_ _18278_/Q _11835_/B _11835_/C VDD VSS _12077_/A MIN3X1
X_17321_ _17323_/A _17321_/B VDD VSS _19022_/D NOR2X1
X_14533_ _18521_/Q _18553_/Q VDD VSS _14534_/D NAND2X1
XFILLER_14_497 VDD VSS FILLER4
XFILLER_42_795 VDD VSS FILLER1
X_17252_ _17250_/Y _17256_/B _17255_/D VDD VSS _19007_/D AND3BX1
X_14464_ _17388_/A _14464_/B VDD VSS _18486_/D AND2X1
X_11676_ _11801_/A _11801_/B VDD VSS _14166_/B XNOR2X1
X_16203_ _16257_/C _16257_/D _16257_/E _16204_/C VDD VSS _16205_/B AOAI211X1
X_13415_ _18292_/Q _14241_/B VDD VSS _13417_/C _14241_/C NAND3X1
XTAP_TAPCELL_ROW_11_153 VDD VSS WELLTAP
X_10627_ _10628_/A _10628_/B _10628_/C VDD VSS _10638_/B OAI21X1
X_17183_ _17183_/A _17193_/A _17193_/B _17183_/D VDD VSS _18994_/D AOI31X1
X_14395_ _14361_/Y _14395_/B _14395_/C VDD VSS _18423_/D AND3BX1
X_10558_ _10382_/Y _10570_/B _10704_/B VDD VSS _17901_/D AND3BX1
X_16134_ _16169_/A _16169_/B _16169_/C _16326_/A VDD VSS _16135_/D AOI31X1
X_13346_ _18476_/Q _13346_/B VDD VSS _13440_/C _13346_/C NAND3X1
XFILLER_115_517 VSS VDD FILLER2
X_13277_ _14367_/B _14366_/C _18397_/Q VDD VSS _13278_/D AND3BX1
X_16065_ _16934_/A _16121_/C VDD VSS _16066_/B NAND2X1
XFILLER_5_184 VSS VDD FILLER2
X_10489_ _17868_/Q _10489_/B _10489_/C VDD VSS _10509_/B XNOR3X1
X_12228_ _12334_/B _14201_/C _18257_/Q VDD VSS _12229_/D AND3BX1
X_15016_ _18624_/Q _19002_/Q _15016_/C VDD VSS _15020_/B MIN3X1
XFILLER_123_561 VSS VDD FILLER2
XFILLER_64_1024 VDD VSS FILLER1
XFILLER_97_935 VDD VSS FILLER1
XFILLER_25_1008 VDD VSS DECAPHV8
XFILLER_69_648 VSS VDD FILLER2
XFILLER_96_423 VDD VSS FILLER1
X_12159_ _12159_/A _14085_/B _12239_/C _12159_/D VDD VSS _12446_/A OAOI211X1
X_16967_ _18936_/Q _16972_/B VDD VSS _16968_/C NAND2X1
XFILLER_83_128 VDD VSS DECAPHV8
XTAP_TAPCELL_ROW_67_827 VDD VSS WELLTAP
X_18706_ _18787_/CK _18706_/D _18706_/Q VDD VSS DFFQX1
X_15918_ _18781_/Q _18727_/Q VDD VSS _15919_/D NAND2X1
XFILLER_92_651 VSS VDD FILLER2
X_16898_ _18928_/Q _16898_/B _16898_/C VDD VSS _16907_/B AO21X2
XTAP_TAPCELL_ROW_19_242 VDD VSS WELLTAP
X_18637_ _19019_/CK _18637_/D _18637_/Q VDD VSS DFFQX1
X_15849_ _15850_/A _15850_/B _15850_/D _15850_/C VDD VSS _15849_/Y AOI211X1
XFILLER_52_537 VDD VSS DECAPHV8
XTAP_TAPCELL_ROW_47_584 VDD VSS WELLTAP
X_09370_ _09399_/B _09370_/B VDD VSS _17405_/B NAND2BX1
X_18568_ clkload2/A _18568_/D _18568_/Q VDD VSS DFFQX1
X_18499_ _18500_/CK _18499_/D _18499_/Q VDD VSS DFFQX1
X_17519_ _17523_/A _17753_/Q VDD VSS _17721_/D AND2X1
XFILLER_33_784 VDD VSS FILLER4
XFILLER_20_434 VSS VDD FILLER2
XFILLER_119_878 VSS VDD FILLER2
XFILLER_118_377 VDD VSS FILLER1
XFILLER_133_314 VDD VSS DECAPHV32
XFILLER_82_1113 VDD VSS FILLER4
XFILLER_87_401 VDD VSS FILLER1
XFILLER_88_913 VSS VDD FILLER2
XFILLER_99_250 VDD VSS FILLER4
XFILLER_102_789 VDD VSS FILLER1
XFILLER_75_618 VDD VSS FILLER4
XFILLER_88_979 VDD VSS FILLER4
XFILLER_56_810 VDD VSS FILLER1
XFILLER_68_692 VDD VSS FILLER4
X_09706_ _09707_/A _09707_/B _09707_/C VDD VSS _09706_/Y NOR3X1
XFILLER_56_854 VDD VSS FILLER4
XFILLER_74_49 VDD VSS DECAPHV32
XFILLER_83_640 VSS VDD FILLER2
XTAP_TAPCELL_ROW_126_1535 VDD VSS WELLTAP
XFILLER_55_375 VSS VDD FILLER2
XFILLER_70_312 VSS VDD FILLER2
XFILLER_83_662 VDD VSS FILLER4
X_09637_ _09637_/A _09664_/C VDD VSS _17484_/B XNOR2X1
XFILLER_130_44 VSS VDD FILLER2
XFILLER_43_548 VDD VSS FILLER1
X_09568_ _09575_/B _09568_/B VDD VSS _17345_/B XOR2X1
XFILLER_12_913 VDD VSS DECAPHV32
X_09499_ _09484_/A _09499_/B VDD VSS _09510_/B NOR2BX1
X_11530_ _14219_/A _11530_/B _14190_/B VDD VSS _11535_/B MIN3X1
XFILLER_12_957 VDD VSS FILLER4
XFILLER_17_1070 VDD VSS FILLER1
X_11461_ _18222_/Q _14163_/B _11529_/C VDD VSS _14219_/B XNOR3X1
XFILLER_104_1084 VDD VSS FILLER4
X_10412_ _10582_/B _10412_/B _10412_/C _10412_/D VDD VSS _10420_/B OAOI211X1
X_11392_ _18115_/Q _14046_/B _14046_/C VDD VSS _11399_/C OR3BX1
X_13200_ _13200_/A _14240_/B _13200_/C _13200_/D VDD VSS _13395_/A OAOI211X1
X_14180_ _14149_/Y _14180_/B _14180_/C VDD VSS _18238_/D AND3BX1
XFILLER_124_314 VDD VSS FILLER1
XFILLER_48_1008 VDD VSS FILLER1
X_10343_ _10343_/A _10343_/B _10343_/C VDD VSS _10541_/B XNOR3X1
X_13131_ _13182_/A _13171_/B _13171_/C VDD VSS _13273_/C XNOR3X1
XFILLER_112_509 VSS VDD FILLER2
XFILLER_133_870 VDD VSS FILLER4
XFILLER_79_924 VDD VSS FILLER1
X_10274_ _10922_/A VDD VSS _10516_/A BUFX3
X_13062_ _13183_/A _14331_/B VDD VSS _13273_/B NOR2X1
X_12013_ _12013_/A _12013_/B _12013_/C _12013_/D VDD VSS _12216_/A AOAI211X1
X_17870_ _17871_/CK _17870_/D _17870_/Q VDD VSS DFFQX1
X_16821_ _16869_/A _16821_/B _16821_/C VDD VSS _16908_/B OAI21X1
X_16752_ _18831_/Q _18723_/Q VDD VSS _16753_/B XOR2X1
XFILLER_24_1074 VDD VSS FILLER1
X_15703_ _18885_/Q _15703_/B _15703_/C VDD VSS _15707_/C MIN3X1
X_13964_ _13999_/A _13964_/B _14011_/A _17533_/A VDD VSS _18063_/D OAOI211X1
XFILLER_19_567 VDD VSS FILLER1
XFILLER_46_375 VDD VSS FILLER1
XFILLER_47_898 VSS VDD FILLER2
XFILLER_59_1115 VDD VSS FILLER1
X_12915_ _12920_/A _14483_/B VDD VSS _12919_/A XNOR2X1
X_16683_ _18057_/Q _18667_/Q VDD VSS _16686_/A XNOR2X1
X_13895_ _13895_/A _14406_/B _13895_/C VDD VSS _14436_/B MIN3X1
XFILLER_62_868 VDD VSS DECAPHV8
XTAP_TAPCELL_ROW_16_212 VDD VSS WELLTAP
X_12846_ _12846_/A _12846_/B _12846_/C _12846_/D VDD VSS _12848_/C OAI211X1
X_18422_ _18448_/CK _18422_/D _18422_/Q VDD VSS DFFQX1
X_15634_ _15648_/B _15633_/Y _15648_/A VDD VSS _15661_/B MUXI2X1
XTAP_TAPCELL_ROW_44_543 VDD VSS WELLTAP
X_18353_ _18408_/CK _18353_/D _18353_/Q VDD VSS DFFQX1
X_15565_ _18874_/Q _15792_/D _15752_/C _16989_/A VDD VSS _18874_/D AO22X2
XTAP_TAPCELL_ROW_72_885 VDD VSS WELLTAP
X_12777_ _12899_/A _12899_/B _12899_/D VDD VSS _12787_/B OAI21X1
X_17304_ _17306_/A _17305_/B _17318_/C VDD VSS _17305_/C OAI21X1
X_14516_ _14518_/B _14516_/B VDD VSS _14517_/B XOR2X1
XFILLER_9_88 VDD VSS FILLER1
X_11728_ _11728_/A _11728_/B _14345_/B VDD VSS _11729_/B MIN3X1
X_18284_ _18309_/CK _18284_/D _18284_/Q VDD VSS DFFQX1
X_15496_ _18920_/Q _15496_/B VDD VSS _15496_/Y XOR2X1
XFILLER_80_81 VDD VSS DECAPHV32
X_11659_ _18302_/Q VDD VSS _11664_/A INVX1
X_17235_ _17323_/A _17235_/B VDD VSS _19004_/D NOR2X1
X_14447_ _14451_/A _14447_/B VDD VSS _18470_/D NOR2X1
XFILLER_128_653 VSS VDD FILLER2
XFILLER_31_1034 VDD VSS FILLER1
X_17166_ _17224_/A _17166_/B VDD VSS _18991_/D NOR2X1
X_14378_ _14378_/A _14378_/B VDD VSS _18408_/D NOR2X1
X_16117_ _18901_/Q _16527_/B VDD VSS _16118_/C NAND2X1
X_13329_ _18449_/Q _14423_/B VDD VSS _13511_/A NAND2X1
XFILLER_115_336 VDD VSS FILLER4
X_17097_ _18015_/Q _17098_/A VDD VSS _17107_/A NOR2BX1
XFILLER_9_1013 VDD VSS DECAPHV8
X_16048_ _18839_/Q _18677_/Q VDD VSS _16049_/B XOR2X1
XFILLER_130_328 VDD VSS DECAPHV32
XTAP_TAPCELL_ROW_110_1336 VDD VSS WELLTAP
X_08870_ _18028_/Q _18030_/Q _08870_/C VDD VSS _08876_/B NOR3X1
XFILLER_29_0 VDD VSS DECAPHV32
XFILLER_56_128 VDD VSS FILLER4
XFILLER_84_415 VSS VDD FILLER2
X_17999_ _18000_/CK _17999_/D _17999_/Q VDD VSS DFFQX1
XFILLER_37_320 VDD VSS FILLER1
XFILLER_84_448 VDD VSS FILLER4
XFILLER_25_515 VDD VSS DECAPHV8
XFILLER_37_375 VDD VSS FILLER4
XFILLER_53_824 VSS VDD FILLER2
XFILLER_37_386 VDD VSS FILLER1
X_09422_ _17743_/Q VDD VSS _17508_/B INVX1
X_09353_ _09812_/A _09353_/B VDD VSS _17768_/D NOR2X1
XTAP_TAPCELL_ROW_121_1465 VDD VSS WELLTAP
XTAP_TAPCELL_ROW_121_1476 VDD VSS WELLTAP
XFILLER_127_1073 VDD VSS DECAPHV32
X_09284_ _17503_/B _17706_/Q _09284_/C VDD VSS _09312_/C OAI21X1
XFILLER_20_275 VDD VSS FILLER4
XFILLER_118_174 VDD VSS DECAPHV16
XFILLER_4_408 VDD VSS DECAPHV8
XFILLER_115_870 VDD VSS FILLER4
XFILLER_47_1030 VSS VDD FILLER2
Xclkload90 _17698_/CK VDD VSS clkload90/Y INVX2
XFILLER_121_339 VSS VDD FILLER2
XFILLER_134_1011 VDD VSS DECAPHV32
XFILLER_88_743 VDD VSS DECAPHV16
XFILLER_114_391 VDD VSS FILLER4
XFILLER_48_607 VDD VSS DECAPHV8
XFILLER_88_776 VDD VSS DECAPHV8
XFILLER_102_575 VDD VSS FILLER4
XFILLER_125_88 VDD VSS FILLER4
X_08999_ _17663_/Q _17457_/B VDD VSS _09000_/B XNOR2X1
XFILLER_18_53 VDD VSS FILLER1
XFILLER_28_320 VDD VSS FILLER4
XFILLER_29_854 VDD VSS FILLER1
XFILLER_29_876 VDD VSS FILLER1
XFILLER_55_161 VDD VSS FILLER4
XTAP_TAPCELL_ROW_87_1062 VDD VSS WELLTAP
X_10961_ _17952_/Q _10965_/B VDD VSS _10962_/B XNOR2X1
XFILLER_16_548 VDD VSS DECAPHV8
X_12700_ _12700_/A _12700_/B _12704_/B _14423_/A VDD VSS _12701_/C OAI31X1
X_13680_ _13680_/A _14401_/B _14401_/C VDD VSS _13681_/D NOR3X1
XFILLER_43_367 VDD VSS FILLER4
XFILLER_70_142 VDD VSS FILLER1
X_10892_ _17938_/Q _10897_/B VDD VSS _10896_/B XNOR2X1
X_12631_ _12631_/A _12631_/B _12631_/C _12631_/D VDD VSS _14264_/B OAOI211X1
XFILLER_24_581 VDD VSS FILLER4
XFILLER_70_186 VSS VDD FILLER2
XFILLER_93_1072 VDD VSS FILLER4
XTAP_TAPCELL_ROW_41_513 VDD VSS WELLTAP
XFILLER_106_1113 VDD VSS FILLER1
XFILLER_129_417 VDD VSS FILLER1
XFILLER_12_732 VDD VSS DECAPHV32
X_12562_ _18131_/Q VDD VSS _12680_/D INVX1
X_15350_ _18864_/Q _18863_/Q _16784_/A VDD VSS _15815_/C OR3X2
XFILLER_133_0 VDD VSS DECAPHV32
XTAP_TAPCELL_ROW_5_78 VDD VSS WELLTAP
X_11513_ _11600_/A _11600_/B _14191_/B VDD VSS _11594_/C XNOR3X1
X_12493_ _18390_/Q _12601_/B _12601_/C VDD VSS _12714_/A MIN3X1
X_15281_ _15281_/A _18849_/Q VDD VSS _18822_/D AND2X1
X_14301_ _14243_/Y _14301_/B _14301_/C VDD VSS _18342_/D AND3BX1
XFILLER_50_40 VDD VSS FILLER4
XTAP_TAPCELL_ROW_21_270 VDD VSS WELLTAP
X_11444_ _11537_/A _11537_/B _11537_/C VDD VSS _11455_/B AOI21X1
X_17020_ _17999_/Q _17020_/B VDD VSS _17026_/A NOR2X1
X_14232_ _15300_/A _14232_/B VDD VSS _18284_/D AND2X1
XFILLER_109_174 VDD VSS FILLER1
XTAP_TAPCELL_ROW_98_1191 VDD VSS WELLTAP
X_11375_ _18220_/Q VDD VSS _11417_/A INVX1
X_14163_ _14191_/A _14163_/B VDD VSS _18222_/D NOR2X1
XFILLER_3_463 VSS VDD FILLER2
XFILLER_79_710 VDD VSS FILLER4
XFILLER_98_507 VDD VSS FILLER4
X_10326_ _10498_/B _10329_/B _10329_/D _10329_/C VDD VSS _10521_/B OAI211X1
X_13114_ _14067_/A _14067_/B _18135_/Q VDD VSS _13115_/D OAI21X1
X_18971_ _18971_/CK _18971_/D _18971_/Q VDD VSS DFFQX1
X_14094_ _14129_/A _14094_/B VDD VSS _18159_/D NOR2X1
XFILLER_106_881 VSS VDD FILLER2
XFILLER_112_328 VSS VDD FILLER2
X_10257_ _10254_/A _10257_/B _10257_/C VDD VSS _10262_/C AOI2B1X1
X_13045_ _18369_/Q VDD VSS _13058_/A INVX1
X_17922_ _18000_/CK _17922_/D _17922_/Q VDD VSS DFFQX1
XFILLER_79_765 VDD VSS FILLER1
XFILLER_113_1128 VDD VSS FILLER4
XFILLER_120_383 VDD VSS DECAPHV32
XFILLER_39_629 VDD VSS FILLER4
XFILLER_66_415 VSS VDD FILLER2
XFILLER_78_264 VSS VDD FILLER2
XFILLER_79_787 VDD VSS FILLER1
XTAP_TAPCELL_ROW_49_602 VDD VSS WELLTAP
X_10188_ _10192_/A _10364_/B _10376_/C VDD VSS _10379_/C OR3BX1
X_17853_ _17861_/CK _17853_/D _17853_/Q VDD VSS DFFQX1
XFILLER_93_223 VDD VSS FILLER1
XTAP_TAPCELL_ROW_77_944 VDD VSS WELLTAP
X_17784_ _19051_/CK _17784_/D _17784_/Q VDD VSS DFFQX1
X_16804_ _16947_/A _16804_/B VDD VSS _16805_/C NOR2X1
X_14996_ _18621_/Q _18999_/Q VDD VSS _15000_/A XOR2X1
XFILLER_19_353 VSS VDD FILLER2
XFILLER_19_375 VSS VDD FILLER2
XFILLER_35_813 VDD VSS DECAPHV16
XFILLER_47_662 VDD VSS FILLER4
X_16735_ _16594_/Y _16821_/B _16869_/A VDD VSS _16736_/B MUX2X1
X_13947_ _18953_/Q _13998_/B VDD VSS _14002_/B NOR2BX1
XFILLER_75_92 VDD VSS FILLER1
XFILLER_90_941 VDD VSS FILLER4
XTAP_TAPCELL_ROW_29_370 VDD VSS WELLTAP
X_16666_ _16594_/B _16665_/Y _16819_/A VDD VSS _16667_/B MUXI2X1
X_18405_ _18406_/CK _18405_/D _18405_/Q VDD VSS DFFQX1
X_15617_ _15617_/A _15617_/B _15617_/C _15617_/D VDD VSS _15618_/B AOAI211X1
X_13878_ _14405_/A _14405_/B _18432_/Q VDD VSS _13898_/C OAI21X1
X_12829_ _18340_/Q _14299_/B VDD VSS _12933_/A NAND2X1
X_16597_ _16597_/A _16602_/B VDD VSS _16637_/C XNOR2X1
XFILLER_30_540 VSS VDD FILLER2
XFILLER_61_197 VDD VSS DECAPHV16
XFILLER_91_80 VDD VSS DECAPHV8
X_18336_ _18337_/CK _18336_/D _18336_/Q VDD VSS DFFQX1
X_15548_ _15572_/A _15548_/B _15548_/C VDD VSS _15551_/B AOI21X1
X_18267_ _18267_/CK _18267_/D _18267_/Q VDD VSS DFFQX1
X_15479_ _15458_/Y _15478_/Y _16757_/D VDD VSS _15479_/Y MUX2X1
XFILLER_129_962 VSS VDD FILLER2
X_17218_ _17221_/B _17218_/B VDD VSS _17219_/B XOR2X1
X_18198_ _18199_/CK _18198_/D _18198_/Q VDD VSS DFFQX1
X_17149_ _17149_/A _17152_/B _17151_/A _17149_/D VDD VSS _18986_/D AOI31X1
XFILLER_116_667 VSS VDD FILLER2
X_09971_ _09971_/A VDD VSS _09972_/B INVX1
XFILLER_115_199 VDD VSS FILLER1
X_08922_ _08922_/A _17564_/A _08922_/C _08922_/D VDD VSS _08923_/C AOAI211X1
XFILLER_58_949 VDD VSS FILLER1
XFILLER_69_275 VDD VSS FILLER4
XFILLER_69_286 VSS VDD FILLER2
XFILLER_111_383 VSS VDD FILLER2
XFILLER_84_245 VDD VSS FILLER1
XFILLER_44_109 VDD VSS DECAPHV16
XFILLER_72_407 VDD VSS FILLER4
XFILLER_72_429 VDD VSS FILLER4
XFILLER_26_857 VDD VSS FILLER4
XFILLER_37_161 VDD VSS FILLER4
XFILLER_38_695 VSS VDD FILLER2
XFILLER_81_941 VSS VDD FILLER2
XFILLER_129_1135 VDD VSS FILLER1
XFILLER_26_868 VSS VDD FILLER2
XFILLER_26_879 VDD VSS FILLER4
XFILLER_52_142 VSS VDD FILLER2
XFILLER_80_440 VDD VSS FILLER4
X_09405_ _09405_/A _09405_/B VDD VSS _09406_/B _09405_/C NAND3X1
XFILLER_52_175 VDD VSS FILLER1
XFILLER_52_197 VDD VSS FILLER4
X_09336_ _09336_/A _09336_/B VDD VSS _09360_/B NAND2X1
X_09267_ _09275_/B _09267_/B VDD VSS _17333_/B XNOR2X1
XFILLER_107_623 VDD VSS DECAPHV8
XTAP_TAPCELL_ROW_134_1623 VDD VSS WELLTAP
X_09198_ _17398_/B _17607_/Q VDD VSS _09199_/C NOR2BX1
XFILLER_134_431 VSS VDD FILLER2
XFILLER_135_965 VDD VSS DECAPHV32
XFILLER_20_32 VDD VSS DECAPHV8
XFILLER_136_32 VDD VSS DECAPHV8
XFILLER_20_65 VSS VDD FILLER2
X_11160_ _11160_/A VDD VSS _11161_/B INVX1
XFILLER_136_1128 VDD VSS FILLER4
X_10111_ _10111_/A _10111_/B VDD VSS _10121_/B NOR2X1
X_11091_ _11094_/A _11091_/B VDD VSS _17031_/B XNOR2X1
X_10042_ _10042_/A _10042_/B _10042_/C VDD VSS _10043_/B OAI21X1
XFILLER_102_372 VDD VSS FILLER4
XFILLER_48_415 VSS VDD FILLER2
XFILLER_49_927 VSS VDD FILLER2
XFILLER_75_201 VDD VSS FILLER1
XFILLER_88_584 VDD VSS DECAPHV8
XFILLER_29_74 VDD VSS DECAPHV8
XFILLER_29_96 VDD VSS FILLER1
X_14850_ _14850_/A _14998_/A _14850_/C VDD VSS _14853_/C MIN3X1
XFILLER_17_802 VDD VSS FILLER1
XFILLER_75_278 VDD VSS FILLER1
XFILLER_91_716 VDD VSS DECAPHV16
XTAP_TAPCELL_ROW_74_903 VDD VSS WELLTAP
Xhold96 hold96/A VDD VSS hold96/Y BUFX3
X_14781_ _18574_/Q _18606_/Q VDD VSS _14782_/B XNOR2X1
X_13801_ _18404_/Q _14374_/B VDD VSS _13847_/E _14374_/C AND3X2
XFILLER_21_1055 VDD VSS DECAPHV8
XFILLER_28_183 VDD VSS FILLER4
XFILLER_57_993 VDD VSS FILLER4
XFILLER_91_738 VDD VSS FILLER1
XFILLER_95_1134 VSS VDD FILLER2
X_11993_ _18464_/Q VDD VSS _12194_/A INVX1
X_16520_ _16445_/Y _16593_/B _16630_/A VDD VSS _16520_/Y MUX2X1
X_13732_ _18481_/Q _14459_/B _14459_/C VDD VSS _13733_/D OR3BX1
XFILLER_43_131 VDD VSS FILLER1
X_10944_ _10947_/C _10944_/B VDD VSS _11081_/B XNOR2X1
XTAP_TAPCELL_ROW_54_671 VDD VSS WELLTAP
X_10875_ _17935_/Q _10878_/A VDD VSS _10876_/B XNOR2X1
X_16451_ _16452_/A _16452_/B VDD VSS _16490_/D NOR2X1
X_13663_ _13733_/A _14493_/B VDD VSS _13713_/B NAND2X1
XFILLER_31_359 VSS VDD FILLER2
X_12614_ _12614_/A _12614_/B _12614_/C _12614_/D VDD VSS _12944_/B AOI211X1
X_16382_ _18908_/Q _16927_/B _16423_/B _16382_/D VDD VSS _18908_/D AO22X2
X_15402_ _18864_/Q _18863_/Q _16784_/A VDD VSS _16018_/C OR3BX1
X_13594_ _13602_/A _14456_/B _13602_/C VDD VSS _14457_/B AOI21X1
XFILLER_12_551 VDD VSS DECAPHV8
X_12545_ _12545_/A _12545_/B _12545_/C _12545_/D VDD VSS _12550_/B OAOI211X1
X_18121_ _18982_/CK _18121_/D _18121_/Q VDD VSS DFFQX1
X_15333_ _18861_/Q _18860_/Q VDD VSS _15784_/A NOR2BX1
X_18052_ _18850_/CK _18052_/D _18052_/Q VDD VSS DFFQX1
XFILLER_129_269 VDD VSS DECAPHV8
X_12476_ _12594_/A _12594_/B _12486_/C VDD VSS _14478_/B XNOR3X1
X_17003_ _18952_/Q _17007_/B VDD VSS _17004_/C NAND2X1
X_15264_ _15295_/A _18832_/Q VDD VSS _18805_/D AND2X1
XANTENNA_5 _17533_/A VDD VSS ANTENNA2
XFILLER_125_431 VDD VSS FILLER1
X_11427_ _11448_/B _14075_/C _18142_/Q VDD VSS _11428_/D AND3BX1
X_15195_ _15250_/A _18764_/Q VDD VSS _18737_/D AND2X1
X_14215_ _14217_/A _14215_/B VDD VSS _18271_/D NOR2X1
XFILLER_125_464 VDD VSS FILLER1
X_11358_ _11362_/A _11362_/B _11389_/C VDD VSS _14046_/C NOR3X1
X_14146_ _14108_/Y _14146_/B _14146_/C VDD VSS _18207_/D AND3BX1
X_10309_ _10309_/A _10309_/B _10470_/C VDD VSS _10315_/A MIN3X1
XFILLER_112_158 VDD VSS DECAPHV8
XFILLER_3_282 VDD VSS DECAPHV32
X_11289_ _11289_/A _11289_/B VDD VSS _14042_/B XNOR2X1
X_18954_ _18958_/CK _18954_/D _18954_/Q VDD VSS DFFQX1
X_14077_ _14083_/A _14077_/B VDD VSS _18144_/D NOR2X1
X_13028_ _18447_/Q _13260_/A _14421_/B VDD VSS _14484_/B XNOR3X1
X_18885_ _18958_/CK _18885_/D _18885_/Q VDD VSS DFFQX1
X_17905_ _17932_/CK _17905_/D _17905_/Q VDD VSS DFFQX1
XFILLER_39_437 VSS VDD FILLER2
X_17836_ _17861_/CK _17836_/D _17836_/Q VDD VSS DFFQX1
XFILLER_81_204 VDD VSS FILLER4
X_17767_ _19036_/CK _17767_/D _17767_/Q VDD VSS DFFQX1
X_14979_ _18617_/Q _18995_/Q VDD VSS _14983_/C XNOR2X1
XFILLER_34_120 VSS VDD FILLER2
XFILLER_34_142 VSS VDD FILLER2
XFILLER_35_654 VDD VSS FILLER4
XFILLER_62_451 VSS VDD FILLER2
XFILLER_63_952 VDD VSS FILLER1
X_17698_ _17698_/CK _17698_/D _17698_/Q VDD VSS DFFQX1
X_16718_ _16719_/B _16718_/B VDD VSS _16725_/B NAND2BX1
XFILLER_22_304 VDD VSS FILLER4
XFILLER_90_793 VDD VSS DECAPHV8
XTAP_TAPCELL_ROW_105_1279 VDD VSS WELLTAP
X_16649_ _18055_/Q _18665_/Q _16649_/C VDD VSS _16684_/A MIN3X1
XFILLER_22_348 VDD VSS DECAPHV8
XFILLER_96_0 VDD VSS DECAPHV32
X_09121_ _17573_/Q VDD VSS _09147_/A INVX1
X_18319_ _18397_/CK _18319_/D _18319_/Q VDD VSS DFFQX1
XTAP_TAPCELL_ROW_32_398 VDD VSS WELLTAP
XFILLER_108_409 VDD VSS FILLER1
XFILLER_117_910 VDD VSS FILLER4
XFILLER_129_770 VDD VSS FILLER1
XFILLER_136_718 VSS VDD FILLER2
X_09052_ _17568_/Q _17357_/B _09052_/C VDD VSS _09086_/A MIN3X1
XFILLER_116_486 VDD VSS FILLER4
XFILLER_103_136 VDD VSS FILLER4
XFILLER_103_147 VSS VDD FILLER2
XFILLER_131_456 VSS VDD FILLER2
XFILLER_132_979 VDD VSS FILLER4
X_09954_ _17796_/Q _09969_/B VDD VSS _09959_/C XOR2X1
XFILLER_103_169 VDD VSS FILLER1
XFILLER_112_681 VDD VSS FILLER1
XFILLER_98_893 VSS VDD FILLER2
X_08905_ _17542_/A _17542_/B _08905_/C VDD VSS _17545_/A OAI21X1
X_09885_ _17787_/Q _09885_/B VDD VSS _09888_/A AND2X1
XFILLER_111_191 VDD VSS FILLER1
XFILLER_58_757 VDD VSS FILLER4
XFILLER_131_1058 VDD VSS DECAPHV32
XFILLER_57_278 VDD VSS FILLER1
XFILLER_58_779 VDD VSS DECAPHV8
Xdelaybuf_2_clk_fs delaybuf_2_clk_fs/A VDD VSS delaybuf_3_clk_fs/A BUFX12
XFILLER_25_120 VDD VSS DECAPHV16
XTAP_TAPCELL_ROW_84_1021 VDD VSS WELLTAP
XTAP_TAPCELL_ROW_84_1032 VDD VSS WELLTAP
XFILLER_15_32 VDD VSS DECAPHV16
XFILLER_82_49 VDD VSS DECAPHV32
XFILLER_13_359 VDD VSS DECAPHV8
XFILLER_15_54 VDD VSS FILLER1
XFILLER_40_112 VDD VSS FILLER4
XTAP_TAPCELL_ROW_51_630 VDD VSS WELLTAP
X_10660_ _17894_/Q VDD VSS _10665_/A INVX1
XFILLER_16_1135 VDD VSS FILLER1
XFILLER_41_679 VDD VSS FILLER4
XFILLER_51_1004 VDD VSS DECAPHV8
X_09319_ _09319_/A _09334_/B VDD VSS _17403_/B XOR2X1
XFILLER_51_1026 VDD VSS FILLER1
X_10591_ _10630_/A _10728_/B VDD VSS _17905_/D NOR2X1
XFILLER_126_206 VDD VSS DECAPHV16
X_12330_ _12429_/A _12436_/A _12522_/B VDD VSS _12331_/D XNOR3X1
XFILLER_107_420 VDD VSS FILLER4
XTAP_TAPCELL_ROW_2_46 VDD VSS WELLTAP
X_12261_ _12261_/A _12261_/B _12360_/B _12261_/D VDD VSS _12453_/A OAOI211X1
XFILLER_107_464 VDD VSS FILLER1
XFILLER_108_987 VSS VDD FILLER2
XTAP_TAPCELL_ROW_95_1161 VDD VSS WELLTAP
X_11212_ _18027_/Q _18026_/Q _18028_/Q _17392_/A VDD VSS _11213_/D AOAI211X1
X_14000_ _18954_/Q _14002_/B VDD VSS _14001_/B XNOR2X1
XFILLER_107_486 VDD VSS FILLER1
X_12192_ _18466_/Q VDD VSS _12398_/A INVX1
Xoutput20 _18067_/Q VDD VSS data_out[5] BUFX3
Xoutput7 output7/A VDD VSS data_out[13] BUFX3
XFILLER_110_607 VDD VSS DECAPHV16
XFILLER_1_742 VSS VDD FILLER2
X_11143_ _11205_/A _17086_/B VDD VSS _18012_/D NOR2X1
XFILLER_122_489 VSS VDD FILLER2
XFILLER_49_702 VSS VDD FILLER2
XFILLER_88_370 VSS VDD FILLER2
XFILLER_95_307 VSS VDD FILLER2
X_11074_ _11076_/A _11074_/B VDD VSS _17020_/B XNOR2X1
X_15951_ _18783_/Q _18729_/Q VDD VSS _15952_/A XNOR2X1
XTAP_TAPCELL_ROW_59_730 VDD VSS WELLTAP
X_10025_ _17804_/Q _10030_/B VDD VSS _10029_/B XOR2X1
X_18670_ _18780_/CK _18670_/D _18670_/Q VDD VSS DFFQX1
X_15882_ _15925_/A _15925_/B _15925_/C _16326_/A VDD VSS _15883_/D AOI31X1
X_14902_ _14906_/C _14902_/B VDD VSS _14903_/B XNOR2X1
XFILLER_37_919 VDD VSS FILLER4
XFILLER_48_245 VDD VSS DECAPHV8
XFILLER_64_716 VDD VSS DECAPHV8
XFILLER_76_565 VSS VDD FILLER2
X_17621_ _17656_/CK _17621_/D _17621_/Q VDD VSS DFFQX1
XFILLER_48_289 VDD VSS DECAPHV8
X_14833_ _14835_/A _14835_/B _14835_/C _14833_/D VDD VSS _18585_/D AOI31X1
XFILLER_17_654 VDD VSS DECAPHV32
XFILLER_91_557 VDD VSS FILLER1
X_11976_ _18255_/Q _11976_/B _12034_/C VDD VSS _12216_/B XNOR3X1
X_17552_ _08912_/C _17552_/B _17561_/C VDD VSS _17738_/D AND3BX1
X_14764_ _14769_/C _14769_/B VDD VSS _14766_/B NAND2BX1
XFILLER_16_142 VDD VSS DECAPHV8
XFILLER_16_164 VSS VDD FILLER2
X_10927_ _17944_/Q VDD VSS _10928_/A INVX1
X_17483_ _17499_/A _17483_/B VDD VSS _17687_/D NOR2X1
X_16503_ _16503_/A _16503_/B VDD VSS _16545_/C NAND2X1
X_14695_ _14699_/C _14695_/B VDD VSS _14696_/B XNOR2X1
X_13715_ _15310_/A _13773_/B VDD VSS _13716_/C NAND2X1
XFILLER_16_186 VSS VDD FILLER2
X_16434_ _16463_/A _16463_/B _16434_/C VDD VSS _16444_/C OAI21X1
X_13646_ _18454_/Q _13646_/B _14428_/C VDD VSS _13784_/B XNOR3X1
X_10858_ _10858_/A _10858_/B _10858_/C _10858_/D VDD VSS _10863_/A AOAI211X1
XFILLER_31_189 VSS VDD FILLER2
XFILLER_40_690 VDD VSS FILLER4
X_10789_ _10789_/A _10792_/C VDD VSS _10918_/B XNOR2X1
X_16365_ _16396_/A _16396_/B _16365_/C _16365_/D VDD VSS _16370_/C AOI31X1
X_13577_ _18479_/Q _13588_/B _13653_/C VDD VSS _13655_/B XNOR3X1
XFILLER_117_217 VDD VSS DECAPHV8
X_12528_ _12528_/A _12528_/B _12528_/C _12528_/D VDD VSS _14204_/C OAI211X1
X_18104_ _18985_/CK _18104_/D _18104_/Q VDD VSS DFFQX1
X_16296_ _16537_/A _18764_/Q _16547_/D _16296_/D VDD VSS _16297_/C AOI22X1
X_15316_ _17525_/B _18055_/Q VDD VSS _18854_/D AND2X1
X_12459_ _18983_/Q _18104_/Q VDD VSS _12678_/C XOR2X1
X_18035_ _18838_/CK _18035_/D _18035_/Q VDD VSS DFFQX1
X_15247_ _15274_/A _18815_/Q VDD VSS _18788_/D AND2X1
XFILLER_114_913 VDD VSS FILLER1
XFILLER_126_784 VDD VSS FILLER1
X_15178_ _15318_/A _18747_/Q VDD VSS _18720_/D AND2X1
XFILLER_114_979 VDD VSS DECAPHV8
XFILLER_98_123 VDD VSS FILLER1
X_14129_ _14129_/A _14129_/B VDD VSS _18192_/D NOR2X1
XFILLER_101_629 VSS VDD FILLER2
XFILLER_113_489 VDD VSS FILLER4
X_18937_ _18940_/CK _18937_/D _18937_/Q VDD VSS DFFQX1
XFILLER_95_830 VDD VSS FILLER4
X_09670_ _09671_/A _09671_/B _09671_/C VDD VSS _09690_/B OAI21X1
XFILLER_11_0 VDD VSS DECAPHV32
XFILLER_67_554 VDD VSS FILLER4
X_18868_ _18950_/CK _18868_/D _18868_/Q VDD VSS DFFQX1
XFILLER_27_429 VDD VSS DECAPHV16
XFILLER_36_930 VSS VDD FILLER2
XFILLER_39_278 VDD VSS FILLER1
XTAP_TAPCELL_ROW_107_1308 VDD VSS WELLTAP
X_18799_ _18853_/CK _18799_/D _18799_/Q VDD VSS DFFQX1
X_17819_ _19036_/CK _17819_/D _17819_/Q VDD VSS DFFQX1
XFILLER_36_963 VDD VSS DECAPHV8
XTAP_TAPCELL_ROW_37_457 VDD VSS WELLTAP
XFILLER_39_1113 VSS VDD FILLER2
XFILLER_39_1135 VDD VSS FILLER1
XFILLER_51_911 VSS VDD FILLER2
XFILLER_74_1026 VDD VSS DECAPHV8
XTAP_TAPCELL_ROW_37_468 VDD VSS WELLTAP
XTAP_TAPCELL_ROW_65_799 VDD VSS WELLTAP
XFILLER_22_101 VDD VSS FILLER1
XFILLER_51_966 VDD VSS DECAPHV16
X_09104_ _17732_/Q _17700_/Q VDD VSS _09105_/B XNOR2X1
XTAP_TAPCELL_ROW_118_1437 VDD VSS WELLTAP
X_09035_ _09062_/B _09035_/B VDD VSS _17427_/B XNOR2X1
XFILLER_50_1092 VDD VSS DECAPHV16
XTAP_TAPCELL_ROW_9_127 VDD VSS WELLTAP
XFILLER_132_743 VSS VDD FILLER2
XFILLER_89_145 VSS VDD FILLER2
Xclkbuf_leaf_41__001_ clkload73/A VDD VSS _17725_/CK BUFX12
XFILLER_120_927 VDD VSS FILLER1
XFILLER_131_253 VDD VSS DECAPHV16
XFILLER_132_787 VSS VDD FILLER2
X_09937_ _17793_/Q _09943_/B VDD VSS _09939_/A NOR2BX1
XFILLER_86_841 VDD VSS FILLER1
XFILLER_46_716 VDD VSS DECAPHV8
X_09868_ _09880_/C _09868_/B _09887_/A VDD VSS _10087_/B XNOR3X1
XFILLER_100_695 VSS VDD FILLER2
XFILLER_133_88 VDD VSS FILLER4
XFILLER_85_384 VDD VSS FILLER1
XTAP_TAPCELL_ROW_129_1566 VDD VSS WELLTAP
X_09799_ _17762_/Q _17763_/Q VDD VSS _09899_/C _09891_/B NAND3X1
XFILLER_73_546 VDD VSS FILLER4
X_11830_ _18331_/Q VDD VSS _11833_/A INVX1
XFILLER_26_53 VSS VDD FILLER2
X_11761_ _18199_/Q _14137_/B _14137_/C VDD VSS _11763_/D OR3BX1
XFILLER_54_793 VDD VSS FILLER1
X_10712_ _10712_/A _10715_/D VDD VSS _10846_/A XOR2X1
X_13500_ _18400_/Q _13534_/B _13639_/D VDD VSS _13598_/C XNOR3X1
X_11692_ _11786_/B _14109_/C _18173_/Q VDD VSS _11693_/D AND3BX1
X_14480_ _14480_/A _14480_/B VDD VSS _18496_/D NOR2X1
X_10643_ _10643_/A _10643_/B _10643_/C VDD VSS _10648_/C AO21X2
X_13431_ _13437_/B _13431_/B VDD VSS _13432_/B XNOR2X1
X_10574_ _10630_/A _10714_/B VDD VSS _17903_/D NOR2X1
X_16150_ _18902_/Q _16153_/B _16153_/C VDD VSS _16152_/B XNOR3X1
X_13362_ _18372_/Q VDD VSS _13373_/A INVX1
X_12313_ _12379_/A _12379_/B _12379_/C _12313_/D VDD VSS _12617_/A AOAI211X1
X_16081_ _16082_/A _16082_/B _16082_/D _16082_/C VDD VSS _16084_/B AO211X2
X_15101_ _15240_/A _18672_/Q VDD VSS _18645_/D AND2X1
X_13293_ _18266_/Q _14210_/B _14210_/C VDD VSS _13294_/D OR3BX1
X_15032_ _15037_/C _15037_/B VDD VSS _15034_/B NAND2BX1
XFILLER_108_784 VDD VSS FILLER4
X_12244_ _12244_/A _12244_/B _12244_/C _12244_/D VDD VSS _14115_/C OAI211X1
XFILLER_123_743 VDD VSS FILLER1
X_12175_ _18307_/Q _12175_/B _12175_/C VDD VSS _12213_/A MIN3X1
XFILLER_111_927 VSS VDD FILLER2
XFILLER_1_561 VDD VSS DECAPHV32
X_11126_ _17983_/Q _11126_/B VDD VSS _11127_/C NAND2X1
XFILLER_110_437 VDD VSS DECAPHV8
X_18722_ _18857_/CK _18722_/D _18722_/Q VDD VSS DFFQX1
X_16983_ _16983_/A _17006_/B _16983_/C VDD VSS _18939_/D OAI21X1
XFILLER_49_554 VDD VSS FILLER1
XFILLER_76_351 VSS VDD FILLER2
X_11057_ _11055_/Y _11057_/B VDD VSS _11190_/B NOR2BX1
X_15934_ _15934_/A _15934_/B _15934_/C _16161_/C VDD VSS _15980_/C AOI22X1
XFILLER_97_1026 VDD VSS DECAPHV8
X_10008_ _10017_/A _10017_/B VDD VSS _10013_/B XNOR2X1
X_18653_ _18844_/CK _18653_/D _18653_/Q VDD VSS DFFQX1
X_15865_ _15865_/A _16147_/B _15865_/C VDD VSS _15902_/D OA21X2
X_18584_ _18994_/CK _18584_/D _18584_/Q VDD VSS DFFQX1
X_17604_ _17701_/CK _17604_/D _17604_/Q VDD VSS DFFQX1
X_14816_ _18582_/Q _18614_/Q VDD VSS _14817_/B XOR2X1
XFILLER_18_996 VSS VDD FILLER2
X_17535_ _08899_/B _17535_/B _17535_/C VDD VSS _17731_/D AOI2B1X1
X_15796_ _18894_/Q VDD VSS _15834_/A INVX1
XFILLER_32_421 VDD VSS DECAPHV32
XFILLER_33_933 VSS VDD FILLER2
XFILLER_83_92 VDD VSS FILLER1
XTAP_TAPCELL_ROW_34_427 VDD VSS WELLTAP
XTAP_TAPCELL_ROW_62_758 VDD VSS WELLTAP
X_11959_ _12064_/A _14083_/B VDD VSS _12063_/A NOR2X1
X_14747_ _18566_/Q _18598_/Q _14747_/C VDD VSS _14751_/B MIN3X1
XFILLER_33_977 VDD VSS DECAPHV16
XTAP_TAPCELL_ROW_102_1238 VDD VSS WELLTAP
X_17466_ _17479_/A _17466_/B VDD VSS _17671_/D NOR2X1
X_14678_ _14676_/B _14678_/B _14678_/C VDD VSS _18552_/D AOI2B1X1
X_17397_ _17410_/A _17397_/B VDD VSS _17606_/D NOR2X1
X_16417_ _16417_/A _16457_/B VDD VSS _16422_/B XOR2X1
X_13629_ _18297_/Q _14247_/A _14247_/B VDD VSS _13631_/C NOR3X1
XFILLER_9_650 VDD VSS FILLER1
XTAP_TAPCELL_ROW_14_184 VDD VSS WELLTAP
X_16348_ _18907_/Q _16348_/B VDD VSS _16381_/A NAND2X1
XFILLER_118_559 VDD VSS FILLER1
X_16279_ _18817_/Q _18709_/Q VDD VSS _16280_/D AND2X1
XFILLER_59_0 VDD VSS DECAPHV32
X_18018_ _18024_/CK _18018_/D _18018_/Q VDD VSS DFFQX1
XFILLER_102_905 VDD VSS FILLER1
XFILLER_113_231 VDD VSS FILLER4
XFILLER_102_916 VDD VSS FILLER4
XFILLER_87_605 VSS VDD FILLER2
XFILLER_87_616 VSS VDD FILLER2
XTAP_TAPCELL_ROW_113_1378 VDD VSS WELLTAP
XFILLER_102_949 VSS VDD FILLER2
XFILLER_113_286 VSS VDD FILLER2
XFILLER_59_329 VDD VSS FILLER4
XFILLER_86_137 VSS VDD FILLER2
X_09722_ _09743_/C _09722_/B VDD VSS _17487_/B XNOR2X1
XFILLER_67_340 VDD VSS FILLER1
XFILLER_68_874 VDD VSS FILLER1
XFILLER_83_844 VDD VSS FILLER1
X_09653_ _09653_/A _09653_/B _17453_/A VDD VSS _09654_/B OAI21X1
Xclkbuf_2_0__f__001_ clkbuf_0__001_/Y VDD VSS clkload73/A BUFX12
XFILLER_27_248 VSS VDD FILLER2
X_09584_ _09584_/A VDD VSS _17481_/B INVX1
XFILLER_35_270 VDD VSS FILLER4
XFILLER_50_251 VDD VSS FILLER4
XFILLER_50_262 VSS VDD FILLER2
XFILLER_51_796 VDD VSS FILLER4
XFILLER_109_548 VDD VSS FILLER4
XFILLER_12_44 VSS VDD FILLER2
XFILLER_128_44 VSS VDD FILLER2
XTAP_TAPCELL_ROW_92_1120 VDD VSS WELLTAP
X_09018_ _09018_/A _09018_/B VDD VSS _17390_/B XNOR2X1
X_10290_ _10480_/A _10315_/D VDD VSS _10487_/B XNOR2X1
XFILLER_105_743 VDD VSS FILLER1
XFILLER_58_340 VSS VDD FILLER2
X_13980_ _13999_/A _13980_/B _14008_/C _14013_/D VDD VSS _18068_/D OAOI211X1
XFILLER_101_993 VDD VSS FILLER4
XFILLER_46_502 VSS VDD FILLER2
XFILLER_58_362 VDD VSS FILLER1
XFILLER_74_822 VSS VDD FILLER2
XFILLER_86_671 VDD VSS FILLER4
XFILLER_86_693 VDD VSS FILLER4
X_12931_ _12931_/A _12931_/B _12931_/C _12931_/D VDD VSS _13023_/B AOAI211X1
XFILLER_100_481 VDD VSS FILLER4
XFILLER_18_237 VDD VSS FILLER1
XFILLER_74_877 VDD VSS FILLER4
X_12862_ _18210_/Q _14150_/B VDD VSS _12863_/D _14150_/C NAND3X1
X_15650_ _15674_/A _15650_/B _15650_/C VDD VSS _15650_/Y OAI21X1
XFILLER_33_218 VSS VDD FILLER2
XFILLER_34_719 VSS VDD FILLER2
XFILLER_37_96 VSS VDD FILLER2
X_11813_ _12103_/A _12103_/B _11822_/C VDD VSS _14408_/B XNOR3X1
X_14601_ _18535_/Q _18567_/Q VDD VSS _14602_/C NAND2X1
XFILLER_26_281 VDD VSS DECAPHV8
X_12793_ _18341_/Q _12831_/B _13009_/D VDD VSS _12843_/C XNOR3X1
X_15581_ _18926_/Q _15581_/B VDD VSS _15581_/Y XOR2X1
XFILLER_30_903 VSS VDD FILLER2
XFILLER_41_240 VDD VSS FILLER1
X_11744_ _11800_/A _11843_/B VDD VSS _11835_/C XNOR2X1
X_17320_ _17323_/A _17320_/B VDD VSS _19021_/D NOR2X1
X_14532_ _14534_/A _14534_/B _14534_/C _14532_/D VDD VSS _18521_/D AOI31X1
XFILLER_42_785 VDD VSS FILLER4
X_11675_ _11675_/A _11675_/B _11675_/C _11675_/D VDD VSS _11801_/A AOAI211X1
X_17251_ _17259_/A _17259_/D _17251_/C VDD VSS _17256_/B OAI21X1
X_14463_ _14361_/Y _14463_/B _14463_/C VDD VSS _18485_/D AND3BX1
X_10626_ _17886_/Q _10631_/B VDD VSS _10628_/C XOR2X1
X_17182_ _17183_/A _17193_/A _17193_/B _17182_/D VDD VSS _17183_/D AOAI211X1
X_16202_ _18843_/Q _18681_/Q VDD VSS _16204_/C XOR2X1
X_13414_ _14241_/B _14241_/C _18292_/Q VDD VSS _13417_/B AOI21X1
XFILLER_10_671 VDD VSS DECAPHV16
XTAP_TAPCELL_ROW_11_154 VDD VSS WELLTAP
X_16133_ _18841_/Q _18679_/Q VDD VSS _16169_/C XNOR2X1
X_14394_ _14394_/A _14394_/B _14394_/C VDD VSS _18422_/D NOR3X1
XFILLER_127_334 VDD VSS FILLER1
X_10557_ _10560_/A _10560_/B _10560_/D _10560_/C VDD VSS _10704_/B OAI211X1
X_13345_ _13346_/B _13346_/C _18476_/Q VDD VSS _13440_/B AOI21X1
X_10488_ _10488_/A _10488_/B VDD VSS _10489_/B NOR2X1
X_13276_ _13276_/A _13276_/B _13276_/C _13276_/D VDD VSS _14366_/C OAI211X1
X_16064_ _16064_/A _16303_/B _16064_/C _16064_/D VDD VSS _16121_/C OAI211X1
XFILLER_108_581 VDD VSS FILLER4
XFILLER_136_890 VDD VSS DECAPHV8
XFILLER_64_1014 VDD VSS FILLER1
X_12227_ _12227_/A _12227_/B _12227_/C _12227_/D VDD VSS _14201_/C OAI211X1
X_15015_ _18625_/Q _19003_/Q VDD VSS _15020_/A XNOR2X1
XFILLER_64_1036 VDD VSS FILLER4
XFILLER_97_925 VDD VSS FILLER4
XFILLER_2_881 VSS VDD FILLER2
XFILLER_78_81 VDD VSS DECAPHV16
X_12158_ _14057_/A _14057_/B _18126_/Q VDD VSS _12159_/D OA21X2
XTAP_TAPCELL_ROW_67_817 VDD VSS WELLTAP
X_11109_ _17980_/Q _11112_/B VDD VSS _11110_/B XOR2X1
X_12089_ _12089_/A _12089_/B _14410_/B VDD VSS _12193_/C MIN3X1
X_16966_ _16969_/C _16966_/B VDD VSS _16968_/B XNOR2X1
XFILLER_37_502 VDD VSS FILLER1
XFILLER_76_170 VDD VSS DECAPHV8
XFILLER_77_671 VDD VSS DECAPHV8
XTAP_TAPCELL_ROW_67_828 VDD VSS WELLTAP
X_18705_ _18787_/CK _18705_/D _18705_/Q VDD VSS DFFQX1
X_15917_ _15917_/A VDD VSS _16778_/A BUFX3
XFILLER_64_343 VDD VSS FILLER4
XFILLER_92_641 VDD VSS FILLER4
X_18636_ _19019_/CK _18636_/D _18636_/Q VDD VSS DFFQX1
X_16897_ _16926_/A _16898_/C _16897_/C _16897_/D VDD VSS _18928_/D OAI31X1
XFILLER_37_568 VDD VSS FILLER4
XFILLER_64_376 VDD VSS FILLER4
XFILLER_91_151 VDD VSS DECAPHV8
XTAP_TAPCELL_ROW_19_243 VDD VSS WELLTAP
X_15848_ _18779_/Q _18725_/Q VDD VSS _15850_/C AND2X1
XFILLER_17_270 VSS VDD FILLER2
XFILLER_45_590 VDD VSS FILLER1
XTAP_TAPCELL_ROW_47_585 VDD VSS WELLTAP
X_18567_ clkload2/A _18567_/D _18567_/Q VDD VSS DFFQX1
X_15779_ _18033_/Q _18643_/Q VDD VSS _15780_/D XOR2X1
XFILLER_21_903 VDD VSS DECAPHV16
XFILLER_33_763 VDD VSS FILLER1
X_18498_ _18500_/CK _18498_/D _18498_/Q VDD VSS DFFQX1
Xclkbuf_leaf_40__002_ clkload26/A VDD VSS _18496_/CK BUFX12
X_17518_ _17518_/A _17518_/B VDD VSS _17720_/D NOR2X1
XFILLER_60_560 VDD VSS FILLER4
X_17449_ _17463_/A _17449_/B VDD VSS _17655_/D NOR2X1
XFILLER_123_1119 VDD VSS DECAPHV16
XFILLER_118_356 VDD VSS FILLER1
XFILLER_59_104 VSS VDD FILLER2
XFILLER_87_413 VSS VDD FILLER2
XFILLER_102_757 VDD VSS FILLER1
XFILLER_87_457 VDD VSS FILLER1
X_09705_ _19049_/Q _17350_/B VDD VSS _09707_/C XNOR2X1
XFILLER_28_546 VDD VSS DECAPHV16
XFILLER_83_630 VDD VSS FILLER1
XTAP_TAPCELL_ROW_126_1525 VDD VSS WELLTAP
XTAP_TAPCELL_ROW_126_1536 VDD VSS WELLTAP
X_09636_ _17751_/Q _09636_/B _09636_/C VDD VSS _09664_/C MIN3X1
XFILLER_71_814 VSS VDD FILLER2
XFILLER_36_590 VDD VSS FILLER1
X_09567_ _17589_/Q _17378_/B VDD VSS _09568_/B XNOR2X1
X_09498_ _17443_/B _17650_/Q VDD VSS _09510_/A NOR2BX1
XFILLER_23_273 VDD VSS FILLER1
XFILLER_24_774 VDD VSS FILLER1
XFILLER_90_49 VDD VSS DECAPHV32
XFILLER_23_32 VDD VSS FILLER4
XFILLER_7_439 VDD VSS DECAPHV16
X_11460_ _11460_/A _11460_/B _14162_/B VDD VSS _11529_/C MIN3X1
XFILLER_87_1014 VSS VDD FILLER2
X_10411_ _17853_/Q _10411_/B VDD VSS _10420_/A NOR2BX1
X_11391_ _11440_/A _11446_/A _11397_/B VDD VSS _11399_/D XNOR3X1
X_10342_ _17846_/Q VDD VSS _10343_/A INVX1
X_13130_ _18318_/Q _14269_/B VDD VSS _13171_/C XNOR2X1
X_13061_ _18343_/Q _14302_/B VDD VSS _13183_/A AND2X1
X_10273_ _14310_/C _10476_/B VDD VSS _17864_/D AND2X1
X_12012_ _18254_/Q _14197_/B _14197_/C VDD VSS _12013_/D OR3BX1
XFILLER_120_510 VDD VSS FILLER1
XFILLER_133_882 VDD VSS FILLER1
XFILLER_78_435 VDD VSS FILLER1
XFILLER_120_543 VDD VSS DECAPHV16
XFILLER_48_40 VDD VSS FILLER4
XFILLER_94_906 VDD VSS FILLER1
X_16820_ _16869_/A _16869_/B VDD VSS _16821_/C NAND2X1
XFILLER_120_598 VDD VSS FILLER4
XFILLER_19_513 VDD VSS FILLER4
XFILLER_93_438 VDD VSS DECAPHV8
X_16751_ _18830_/Q _18722_/Q _16751_/C VDD VSS _16780_/C AOI21X1
XFILLER_19_557 VDD VSS FILLER1
XFILLER_47_844 VDD VSS FILLER4
XFILLER_59_693 VDD VSS FILLER4
XFILLER_74_641 VDD VSS FILLER1
X_15702_ _15707_/A _15707_/B VDD VSS _15704_/A XNOR2X1
X_13963_ _18940_/Q _13963_/B VDD VSS _13964_/B XOR2X1
XFILLER_47_888 VDD VSS FILLER1
X_12914_ _13037_/A _13037_/B _12925_/C VDD VSS _14483_/B XNOR3X1
X_16682_ _16682_/A _16717_/C VDD VSS _16697_/B XNOR2X1
X_13894_ _18433_/Q VDD VSS _13895_/A INVX1
XFILLER_34_527 VDD VSS DECAPHV8
XFILLER_61_324 VDD VSS FILLER1
XFILLER_74_696 VDD VSS FILLER1
XTAP_TAPCELL_ROW_16_213 VDD VSS WELLTAP
X_12845_ _12845_/A _12845_/B _12845_/C _12845_/D VDD VSS _12965_/B AOAI211X1
X_18421_ _18448_/CK _18421_/D _18421_/Q VDD VSS DFFQX1
X_15633_ _18930_/Q _15645_/B VDD VSS _15633_/Y XOR2X1
XFILLER_15_763 VSS VDD FILLER2
XTAP_TAPCELL_ROW_44_544 VDD VSS WELLTAP
X_12776_ _18158_/Q _14093_/B VDD VSS _12899_/D _14093_/C NAND3X1
X_18352_ _18406_/CK _18352_/D _18352_/Q VDD VSS DFFQX1
X_15564_ _15564_/A _15567_/C VDD VSS _16989_/A XNOR2X1
XFILLER_30_700 VSS VDD FILLER2
XFILLER_30_722 VSS VDD FILLER2
XFILLER_42_571 VSS VDD FILLER2
XTAP_TAPCELL_ROW_72_886 VDD VSS WELLTAP
X_11727_ _11732_/A _11732_/B _11727_/C VDD VSS _14345_/B XNOR3X1
X_17303_ _19017_/Q _17315_/B VDD VSS _17305_/B XOR2X1
X_14515_ _18518_/Q _18550_/Q VDD VSS _14516_/B XOR2X1
X_18283_ _18309_/CK _18283_/D _18283_/Q VDD VSS DFFQX1
X_15495_ _18919_/Q _15512_/C VDD VSS _15496_/B NAND2X1
X_11658_ _18355_/Q _11658_/B _11727_/C VDD VSS _11828_/B MIN3X1
X_17234_ _17237_/B _17234_/B VDD VSS _17235_/B XOR2X1
X_14446_ _14451_/A _14446_/B VDD VSS _18469_/D NOR2X1
XFILLER_11_991 VSS VDD FILLER2
XFILLER_70_1095 VDD VSS FILLER1
X_10609_ _17883_/Q _10614_/B VDD VSS _10611_/C XOR2X1
X_11589_ _18327_/Q VDD VSS _11592_/A INVX1
X_17165_ _17168_/C _17165_/B VDD VSS _17166_/B XNOR2X1
X_14377_ _14377_/A _14377_/B VDD VSS _18407_/D AND2X1
XFILLER_10_490 VDD VSS DECAPHV16
XFILLER_31_1068 VDD VSS FILLER1
X_16116_ _16116_/A _16116_/B VDD VSS _16118_/B XNOR2X1
X_13328_ _13512_/A _13512_/B _13512_/C VDD VSS _13346_/B OAI21X1
XFILLER_116_849 VDD VSS DECAPHV32
XFILLER_131_808 VSS VDD FILLER2
X_17096_ _17094_/Y _17103_/B _17122_/D VDD VSS _18976_/D AND3BX1
XFILLER_89_80 VDD VSS DECAPHV8
X_13259_ _13261_/B _13261_/C _18448_/Q VDD VSS _13262_/A AOI21X1
X_16047_ _16047_/A _16047_/B _16047_/C _16047_/D VDD VSS _16082_/A AOAI211X1
XFILLER_69_413 VDD VSS FILLER1
XTAP_TAPCELL_ROW_110_1337 VDD VSS WELLTAP
XFILLER_69_446 VDD VSS FILLER4
XFILLER_69_468 VDD VSS DECAPHV8
XFILLER_97_766 VDD VSS FILLER1
XFILLER_56_107 VDD VSS FILLER1
X_17998_ _18024_/CK _17998_/D _17998_/Q VDD VSS DFFQX1
X_16949_ _16957_/A _16950_/B _16957_/C _18934_/Q VDD VSS _16959_/C AOAI211X1
XFILLER_65_674 VDD VSS FILLER1
XFILLER_93_994 VDD VSS FILLER4
XFILLER_37_398 VSS VDD FILLER2
XFILLER_52_324 VDD VSS FILLER1
XFILLER_52_335 VSS VDD FILLER2
XFILLER_53_836 VDD VSS FILLER1
XFILLER_53_858 VDD VSS FILLER1
XFILLER_92_482 VDD VSS FILLER1
X_09421_ _17744_/Q _17712_/Q VDD VSS _09449_/A XNOR2X1
X_18619_ clkload8/A _18619_/D _18619_/Q VDD VSS DFFQX1
XFILLER_52_368 VSS VDD FILLER2
XFILLER_80_666 VDD VSS FILLER1
X_09352_ _09352_/A _09379_/B VDD VSS _09353_/B XOR2X1
XFILLER_127_1041 VDD VSS DECAPHV32
XTAP_TAPCELL_ROW_121_1466 VDD VSS WELLTAP
XFILLER_21_733 VDD VSS FILLER4
XFILLER_60_390 VDD VSS DECAPHV8
X_09283_ _09283_/A _09283_/B VDD VSS _09284_/C NAND2X1
XFILLER_119_632 VDD VSS DECAPHV16
XFILLER_119_654 VDD VSS DECAPHV8
XFILLER_107_816 VDD VSS FILLER1
XFILLER_118_142 VDD VSS DECAPHV32
XFILLER_119_676 VSS VDD FILLER2
Xclkload80 _19038_/CK VDD VSS clkload80/Y BUFX12
XFILLER_47_1020 VSS VDD FILLER2
XFILLER_88_700 VDD VSS FILLER4
Xclkload91 _17701_/CK VDD VSS clkload91/Y INVX1
XFILLER_133_189 VDD VSS DECAPHV32
XFILLER_47_1075 VDD VSS FILLER1
XFILLER_130_874 VDD VSS FILLER4
XFILLER_134_1067 VSS VDD FILLER2
XFILLER_48_619 VDD VSS FILLER1
XFILLER_87_276 VSS VDD FILLER2
XFILLER_88_788 VSS VDD FILLER2
X_08998_ _09007_/B _08998_/B VDD VSS _17425_/B XNOR2X1
XFILLER_18_32 VDD VSS DECAPHV8
XFILLER_28_310 VSS VDD FILLER2
XFILLER_29_844 VDD VSS DECAPHV8
XFILLER_29_866 VDD VSS DECAPHV8
X_10960_ _17951_/Q _10960_/B _10960_/C VDD VSS _10965_/C MIN3X1
XFILLER_71_644 VDD VSS FILLER4
XTAP_TAPCELL_ROW_87_1063 VDD VSS WELLTAP
X_09619_ _09620_/A _09620_/B _09620_/C VDD VSS _09648_/B AO21X2
X_10891_ _10891_/A _10891_/B _10891_/C VDD VSS _10896_/A OAI21X1
X_12630_ _18287_/Q _12845_/A _12845_/B VDD VSS _12631_/D XNOR3X1
XFILLER_12_700 VDD VSS DECAPHV32
XTAP_TAPCELL_ROW_41_514 VDD VSS WELLTAP
XFILLER_129_407 VDD VSS DECAPHV8
X_12561_ _12667_/A _12667_/B _12667_/C VDD VSS _12568_/B AOI21X1
XFILLER_89_1109 VSS VDD FILLER2
XTAP_TAPCELL_ROW_5_79 VDD VSS WELLTAP
X_11512_ _11579_/B _11534_/B VDD VSS _14191_/B XNOR2X1
X_12492_ _18364_/Q _12614_/A _14326_/B VDD VSS _12601_/C XOR3X1
X_15280_ _15281_/A _18848_/Q VDD VSS _18821_/D AND2X1
X_14300_ _14332_/A _14300_/B _14300_/C VDD VSS _18341_/D NOR3X1
XFILLER_11_276 VSS VDD FILLER2
XFILLER_126_0 VDD VSS DECAPHV32
XTAP_TAPCELL_ROW_21_271 VDD VSS WELLTAP
X_11443_ _11478_/A _14076_/B _14076_/C VDD VSS _11537_/C NOR3X1
X_14231_ _14236_/A _14231_/B _14231_/C VDD VSS _18283_/D NOR3X1
XFILLER_125_602 VDD VSS DECAPHV8
XFILLER_7_269 VDD VSS DECAPHV8
X_14162_ _14191_/A _14162_/B VDD VSS _18221_/D NOR2X1
XFILLER_125_646 VDD VSS FILLER4
XTAP_TAPCELL_ROW_98_1192 VDD VSS WELLTAP
X_11374_ _18246_/Q _11374_/B _11374_/C VDD VSS _11473_/B MIN3X1
X_13113_ _18135_/Q _14067_/A _14067_/B VDD VSS _13115_/C NOR3X1
X_10325_ _17843_/Q _10325_/B VDD VSS _10329_/C _10325_/C NAND3X1
X_18970_ _18971_/CK _18970_/D _18970_/Q VDD VSS DFFQX1
X_14093_ _14074_/Y _14093_/B _14093_/C VDD VSS _18158_/D AND3BX1
X_10256_ _17834_/Q _10256_/B VDD VSS _10257_/C NOR2BX1
X_13044_ _18368_/Q _14330_/B VDD VSS _13159_/A NAND2X1
X_17921_ _18000_/CK _17921_/D _17921_/Q VDD VSS DFFQX1
XFILLER_121_863 VDD VSS FILLER1
XFILLER_39_608 VDD VSS DECAPHV8
XFILLER_61_1006 VDD VSS FILLER1
X_17852_ _17908_/CK _17852_/D _17852_/Q VDD VSS DFFQX1
XFILLER_94_725 VDD VSS DECAPHV16
XTAP_TAPCELL_ROW_49_603 VDD VSS WELLTAP
X_10187_ _10187_/A _10187_/B VDD VSS _10192_/A OR2X2
X_16803_ _16701_/B _16857_/B _16869_/A VDD VSS _16899_/B MUXI2X1
XFILLER_78_298 VSS VDD FILLER2
XFILLER_94_758 VDD VSS DECAPHV16
XTAP_TAPCELL_ROW_77_945 VDD VSS WELLTAP
X_17783_ _19051_/CK _17783_/D _17783_/Q VDD VSS DFFQX1
X_14995_ _15093_/A _14995_/B VDD VSS _18620_/D NOR2X1
XFILLER_35_803 VDD VSS FILLER1
XFILLER_81_408 VDD VSS FILLER1
X_16734_ _16665_/Y _16786_/B _16819_/A VDD VSS _16821_/B MUXI2X1
X_13946_ _18951_/Q _18952_/Q VDD VSS _13998_/B _13995_/B NAND3X1
XTAP_TAPCELL_ROW_29_371 VDD VSS WELLTAP
X_16665_ _16628_/B _16664_/Y _16629_/A VDD VSS _16665_/Y MUX2X1
XFILLER_34_357 VDD VSS DECAPHV16
XFILLER_90_975 VDD VSS FILLER1
X_18404_ _18431_/CK _18404_/D _18404_/Q VDD VSS DFFQX1
X_15616_ _15617_/A _15617_/B _15617_/D _15617_/C VDD VSS _15621_/C AO211X2
X_13877_ _18432_/Q _14405_/A _14405_/B VDD VSS _13898_/B NOR3X1
XFILLER_72_1102 VDD VSS FILLER1
X_12828_ _12949_/A _12949_/B VDD VSS _12911_/B NOR2X1
X_16596_ _16302_/B _16595_/Y _16800_/A VDD VSS _16602_/B MUXI2X1
XFILLER_30_530 VDD VSS FILLER4
XFILLER_72_1135 VDD VSS FILLER1
XFILLER_91_92 VDD VSS FILLER1
X_12759_ _18157_/Q _14092_/B VDD VSS _12760_/D _14092_/C NAND3X1
X_18335_ _18337_/CK _18335_/D _18335_/Q VDD VSS DFFQX1
X_15547_ _15572_/A _15599_/B VDD VSS _15548_/C NOR2X1
X_18266_ _18267_/CK _18266_/D _18266_/Q VDD VSS DFFQX1
X_15478_ _18919_/Q _15512_/C VDD VSS _15478_/Y XNOR2X1
XFILLER_128_440 VDD VSS FILLER1
X_17217_ _19001_/Q _17232_/B VDD VSS _17218_/B XNOR2X1
X_14429_ _14431_/A _14429_/B _14429_/C VDD VSS _18454_/D NOR3X1
XFILLER_116_613 VDD VSS DECAPHV16
XFILLER_128_451 VDD VSS FILLER1
X_18197_ _18199_/CK _18197_/D _18197_/Q VDD VSS DFFQX1
XFILLER_116_657 VSS VDD FILLER2
X_17148_ _17152_/B _17151_/A _17149_/A _17154_/A VDD VSS _17149_/D AOAI211X1
X_09970_ _09970_/A _10164_/B _09970_/C _09970_/D VDD VSS _10184_/A AOAI211X1
X_17079_ _17079_/A _17079_/B VDD VSS _18973_/D NOR2X1
XFILLER_112_830 VSS VDD FILLER2
XFILLER_115_189 VDD VSS DECAPHV8
XFILLER_41_0 VDD VSS DECAPHV32
X_08921_ _08922_/A _17564_/A _08922_/C _08922_/D VDD VSS _08926_/C AOI211X1
XFILLER_111_340 VDD VSS FILLER1
XFILLER_130_137 VSS VDD FILLER2
XFILLER_84_202 VDD VSS FILLER4
XFILLER_84_235 VDD VSS DECAPHV8
XFILLER_26_803 VDD VSS DECAPHV8
XFILLER_129_1114 VSS VDD FILLER2
XFILLER_25_346 VDD VSS DECAPHV16
XFILLER_92_290 VDD VSS FILLER4
X_09404_ _09405_/A _09405_/B _09405_/C VDD VSS _09414_/C AO21X2
XFILLER_40_316 VSS VDD FILLER2
XFILLER_33_390 VDD VSS DECAPHV16
X_09335_ _17676_/Q _17471_/B VDD VSS _09336_/A NAND2BX1
X_09266_ _17578_/Q _09275_/C VDD VSS _09267_/B XNOR2X1
XFILLER_4_206 VDD VSS DECAPHV16
XFILLER_5_718 VDD VSS DECAPHV16
X_09197_ _09197_/A _09197_/B _17364_/B VDD VSS _09215_/A MIN3X1
XFILLER_134_421 VSS VDD FILLER2
XFILLER_135_933 VDD VSS DECAPHV32
XFILLER_49_1104 VDD VSS FILLER1
XTAP_TAPCELL_ROW_134_1624 VDD VSS WELLTAP
XFILLER_107_668 VDD VSS FILLER1
XFILLER_136_44 VDD VSS FILLER1
X_10110_ _10310_/A _10310_/B _10110_/C _10110_/D VDD VSS _10296_/A AOAI211X1
X_11090_ _11094_/C _11094_/B VDD VSS _11091_/B NOR2BX1
XFILLER_136_88 VSS VDD FILLER2
X_10041_ _17805_/Q _10042_/B _10042_/C VDD VSS _10046_/D OR3BX1
XFILLER_103_874 VDD VSS FILLER4
XFILLER_60_1050 VDD VSS DECAPHV8
XFILLER_88_596 VSS VDD FILLER2
XFILLER_1_1106 VDD VSS DECAPHV8
XFILLER_21_1034 VDD VSS FILLER4
XTAP_TAPCELL_ROW_74_904 VDD VSS WELLTAP
X_11992_ _18490_/Q VDD VSS _12095_/A INVX1
X_14780_ _14780_/A _14780_/B _14780_/C VDD VSS _14787_/C OA21X2
X_13800_ _13809_/A _13809_/B _13800_/C VDD VSS _14374_/C AO21X2
XFILLER_17_836 VDD VSS FILLER1
X_10943_ _17948_/Q _10947_/B VDD VSS _10944_/B XNOR2X1
X_13731_ _13784_/A _13784_/B _13784_/D _13784_/C VDD VSS _14459_/C AOI211X1
XFILLER_17_869 VDD VSS FILLER1
XTAP_TAPCELL_ROW_26_330 VDD VSS WELLTAP
XFILLER_44_688 VDD VSS DECAPHV8
XTAP_TAPCELL_ROW_54_661 VDD VSS WELLTAP
XTAP_TAPCELL_ROW_54_672 VDD VSS WELLTAP
X_10874_ _10874_/A _10874_/B _10874_/C VDD VSS _10879_/C OAI21X1
X_16450_ _16450_/A _16457_/C VDD VSS _16452_/B XOR2X1
X_13662_ _18480_/Q _14458_/B VDD VSS _13733_/A NAND2X1
X_12613_ _18365_/Q _14327_/B VDD VSS _12799_/A NAND2X1
X_16381_ _16381_/A _16381_/B _16381_/C _16926_/A VDD VSS _16382_/D AOI31X1
X_15401_ _15801_/B _15401_/B _15401_/C VDD VSS _15401_/Y AOI21X1
X_13593_ _18453_/Q _13593_/B _13605_/D VDD VSS _13602_/C XNOR3X1
XFILLER_101_80 VDD VSS DECAPHV8
XFILLER_12_563 VSS VDD FILLER2
XFILLER_8_501 VDD VSS DECAPHV8
X_12544_ _12455_/B _14089_/C _18154_/Q VDD VSS _12545_/D AND3BX1
X_18120_ _18985_/CK _18120_/D _18120_/Q VDD VSS DFFQX1
X_15332_ _18861_/Q _15337_/B wire30/A _15768_/B VDD VSS _18861_/D AO22X2
XFILLER_12_596 VDD VSS DECAPHV8
X_18051_ _18850_/CK _18051_/D _18051_/Q VDD VSS DFFQX1
XFILLER_8_589 VDD VSS DECAPHV8
X_12475_ _18442_/Q _12593_/B _14416_/B VDD VSS _12486_/C XNOR3X1
X_17002_ _17002_/A _17006_/B _17002_/C VDD VSS _18951_/D OAI21X1
X_15263_ _17182_/D _18831_/Q VDD VSS _18804_/D AND2X1
XANTENNA_6 _17533_/A VDD VSS ANTENNA2
XFILLER_125_410 VDD VSS FILLER1
XFILLER_126_944 VDD VSS FILLER1
X_11426_ _11426_/A _14103_/B _14103_/C VDD VSS _11430_/C NOR3X1
X_15194_ _15304_/A _18763_/Q VDD VSS _18736_/D AND2X1
X_14214_ _14214_/A _14214_/B _14372_/A VDD VSS _18270_/D OA21X2
X_11357_ _18967_/Q _18088_/Q VDD VSS _11362_/A AND2X1
X_14145_ _14160_/A _14145_/B VDD VSS _18206_/D NOR2X1
XFILLER_113_616 VSS VDD FILLER2
X_10308_ _17043_/A _10506_/B VDD VSS _17869_/D AND2X1
X_18953_ _18958_/CK _18953_/D _18953_/Q VDD VSS DFFQX1
X_14076_ _14079_/A _14076_/B _14076_/C VDD VSS _18143_/D NOR3X1
XFILLER_112_137 VSS VDD FILLER2
X_11288_ _18111_/Q VDD VSS _11290_/A INVX1
X_13027_ _13258_/B _13142_/C VDD VSS _14421_/B NAND2X1
X_17904_ _17932_/CK _17904_/D _17904_/Q VDD VSS DFFQX1
XFILLER_79_585 VDD VSS FILLER4
XFILLER_94_500 VSS VDD FILLER2
X_10239_ _10239_/A _10419_/C _10239_/C _10239_/D VDD VSS _10242_/C AOAI211X1
X_18884_ _18958_/CK _18884_/D _18884_/Q VDD VSS DFFQX1
XFILLER_86_81 VDD VSS DECAPHV32
X_17835_ _17861_/CK _17835_/D _17835_/Q VDD VSS DFFQX1
X_17766_ _19033_/CK _17766_/D _17766_/Q VDD VSS DFFQX1
XFILLER_35_611 VDD VSS FILLER4
XFILLER_48_983 VSS VDD FILLER2
X_16717_ _18856_/Q _18694_/Q _16717_/C VDD VSS _16718_/B MIN3X1
X_14978_ _18616_/Q _18994_/Q VDD VSS _14983_/A NAND2X1
XFILLER_35_644 VDD VSS FILLER4
X_17697_ _17698_/CK _17697_/D _17697_/Q VDD VSS DFFQX1
X_13929_ _13929_/A _13929_/B _13929_/C _13929_/D VDD VSS _14501_/B OAOI211X1
XFILLER_23_828 VDD VSS DECAPHV8
XFILLER_50_603 VDD VSS FILLER1
XFILLER_50_625 VDD VSS FILLER4
X_16648_ _16693_/C _16648_/B VDD VSS _16664_/B XNOR2X1
XFILLER_37_1030 VSS VDD FILLER2
XFILLER_50_658 VDD VSS FILLER4
X_16579_ _18825_/Q _18717_/Q _16579_/C VDD VSS _16616_/A AOI21X1
XFILLER_31_850 VDD VSS FILLER1
XFILLER_89_0 VDD VSS DECAPHV32
X_09120_ _17572_/Q _17361_/B _09120_/C VDD VSS _09148_/A OA21X2
X_18318_ _18368_/CK _18318_/D _18318_/Q VDD VSS DFFQX1
XFILLER_37_1096 VDD VSS FILLER4
XTAP_TAPCELL_ROW_32_399 VDD VSS WELLTAP
X_09051_ _09082_/A VDD VSS _09052_/C INVX1
XFILLER_124_1077 VDD VSS DECAPHV32
X_18249_ _18249_/CK _18249_/D _18249_/Q VDD VSS DFFQX1
XFILLER_116_421 VDD VSS DECAPHV16
XFILLER_117_933 VDD VSS DECAPHV16
XFILLER_117_999 VDD VSS DECAPHV8
XFILLER_89_305 VDD VSS FILLER4
XFILLER_44_1001 VDD VSS DECAPHV8
XFILLER_98_861 VDD VSS DECAPHV16
X_09953_ _17795_/Q _09959_/B VDD VSS _09955_/A NOR2BX1
XFILLER_100_811 VDD VSS FILLER4
XFILLER_131_468 VDD VSS DECAPHV8
XFILLER_97_371 VDD VSS FILLER1
X_08904_ _17734_/Q _18523_/Q VDD VSS _08905_/C NAND2X1
X_09884_ _09976_/A _10106_/B VDD VSS _17813_/D NOR2X1
XFILLER_131_1026 VDD VSS DECAPHV32
XFILLER_57_246 VDD VSS FILLER4
XFILLER_58_769 VDD VSS FILLER4
XFILLER_79_1108 VDD VSS DECAPHV8
XFILLER_79_1119 VDD VSS FILLER1
XFILLER_85_577 VDD VSS FILLER4
XFILLER_100_899 VDD VSS FILLER4
XFILLER_72_227 VDD VSS FILLER4
XTAP_TAPCELL_ROW_84_1022 VDD VSS WELLTAP
XFILLER_53_463 VSS VDD FILLER2
XFILLER_13_338 VDD VSS DECAPHV8
XFILLER_80_293 VDD VSS DECAPHV16
XTAP_TAPCELL_ROW_23_300 VDD VSS WELLTAP
XTAP_TAPCELL_ROW_51_631 VDD VSS WELLTAP
XFILLER_51_1016 VSS VDD FILLER2
X_09318_ _17644_/Q _17437_/B VDD VSS _09334_/B XNOR2X1
XFILLER_22_894 VDD VSS FILLER1
X_10590_ _17879_/Q _10590_/B _10590_/C VDD VSS _10728_/B XOR3X1
XFILLER_127_719 VDD VSS DECAPHV16
XFILLER_31_32 VDD VSS DECAPHV16
X_09249_ _17641_/Q VDD VSS _09250_/A INVX1
XFILLER_107_410 VSS VDD FILLER2
XFILLER_119_270 VDD VSS FILLER1
X_12260_ _18980_/Q _18101_/Q VDD VSS _12261_/D AND2X1
XFILLER_5_548 VDD VSS DECAPHV8
XTAP_TAPCELL_ROW_2_47 VDD VSS WELLTAP
XTAP_TAPCELL_ROW_95_1162 VDD VSS WELLTAP
X_11211_ _18027_/Q _18026_/Q _11211_/C VDD VSS _18027_/D AOI21X1
X_12191_ _18491_/Q _12191_/B _12191_/C VDD VSS _12281_/B MIN3X1
X_11142_ _11150_/B _11142_/B VDD VSS _17086_/B NAND2X1
Xoutput10 _18078_/Q VDD VSS data_out[16] BUFX3
Xoutput21 _18068_/Q VDD VSS data_out[6] BUFX3
Xoutput8 output8/A VDD VSS data_out[14] BUFX3
XFILLER_123_969 VSS VDD FILLER2
XFILLER_49_714 VDD VSS DECAPHV16
X_11073_ _17973_/Q _11077_/B VDD VSS _11074_/B XOR2X1
X_15950_ _15950_/A _15950_/B _15950_/C VDD VSS _16030_/A AOI21X1
XFILLER_48_235 VDD VSS FILLER4
XFILLER_49_736 VDD VSS DECAPHV8
XFILLER_49_747 VDD VSS DECAPHV8
XFILLER_88_393 VDD VSS FILLER4
XTAP_TAPCELL_ROW_59_731 VDD VSS WELLTAP
X_10024_ _17803_/Q _10024_/B VDD VSS _10029_/A NAND2X1
X_15881_ _18835_/Q _18673_/Q VDD VSS _15925_/C XNOR2X1
X_14901_ _18600_/Q _18632_/Q VDD VSS _14902_/B XNOR2X1
XFILLER_56_40 VDD VSS FILLER4
X_17620_ _17656_/CK _17620_/D _17620_/Q VDD VSS DFFQX1
X_14832_ _14835_/A _14835_/B _14835_/C _17544_/C VDD VSS _14833_/D AOAI211X1
XFILLER_17_600 VDD VSS FILLER4
XFILLER_57_791 VSS VDD FILLER2
XFILLER_16_110 VDD VSS DECAPHV16
XFILLER_17_644 VDD VSS FILLER4
XFILLER_45_953 VSS VDD FILLER2
XFILLER_63_238 VSS VDD FILLER2
XFILLER_72_750 VSS VDD FILLER2
XFILLER_91_569 VSS VDD FILLER2
X_11975_ _18229_/Q _11975_/B _12123_/D VDD VSS _12034_/C XNOR3X1
X_17551_ _17551_/A _17551_/B _17551_/C _17551_/D VDD VSS _17552_/B AOAI211X1
X_14763_ _18570_/Q _18602_/Q VDD VSS _14769_/B NAND2X1
XFILLER_71_260 VDD VSS FILLER1
X_10926_ _11024_/A _11066_/B VDD VSS _17970_/D NOR2X1
X_17482_ _17499_/A _17482_/B VDD VSS _17686_/D NOR2X1
X_16502_ _18796_/Q _18742_/Q VDD VSS _16503_/A NAND2X1
X_14694_ _18556_/Q _18588_/Q VDD VSS _14695_/B XNOR2X1
X_13714_ _13774_/A _13774_/B VDD VSS _13773_/B OR2X2
X_10857_ _17931_/Q _10857_/B VDD VSS _10858_/D NAND2X1
X_16433_ _16463_/A _16463_/B _16783_/D VDD VSS _16434_/C AOI21X1
X_13645_ _13680_/A _13738_/D _13665_/C VDD VSS _14428_/C XNOR3X1
XFILLER_13_861 VDD VSS FILLER1
XFILLER_31_135 VDD VSS FILLER1
XFILLER_31_157 VDD VSS FILLER1
XFILLER_12_371 VDD VSS FILLER4
X_10788_ _10787_/B _17916_/Q _10788_/C VDD VSS _10792_/C AOI2B1X1
X_18103_ _18982_/CK _18103_/D _18103_/Q VDD VSS DFFQX1
X_16364_ _16396_/A _16396_/B _16365_/C _16547_/D VDD VSS _16365_/D AOAI211X1
X_13576_ _18453_/Q _13593_/B _13597_/D VDD VSS _13653_/C XNOR3X1
XFILLER_118_719 VDD VSS FILLER4
X_12527_ _12528_/A _12528_/B _12528_/D _12528_/C VDD VSS _12652_/B OAOI211X1
X_16295_ _16321_/A _16321_/B VDD VSS _16296_/D XOR2X1
X_15315_ _17079_/A _16608_/A VDD VSS _18853_/D NOR2X1
X_12458_ _12566_/A _14060_/B VDD VSS _12678_/B NAND2X1
X_18034_ _18838_/CK _18034_/D _18034_/Q VDD VSS DFFQX1
X_15246_ _15274_/A _18814_/Q VDD VSS _18787_/D AND2X1
X_11409_ _18221_/Q _11531_/A _11531_/B VDD VSS _11423_/B XNOR3X1
XFILLER_98_113 VDD VSS DECAPHV8
X_12389_ _12400_/A _12484_/B _14414_/B VDD VSS _14475_/B XNOR3X1
X_15177_ _15318_/A _18746_/Q VDD VSS _18719_/D AND2X1
XFILLER_113_457 VDD VSS FILLER1
XFILLER_119_1135 VDD VSS FILLER1
XFILLER_28_1029 VDD VSS FILLER1
XFILLER_67_1078 VDD VSS FILLER4
X_14128_ _14343_/A _14128_/B VDD VSS _18191_/D AND2X1
XFILLER_97_80 VDD VSS DECAPHV8
X_18936_ _18940_/CK _18936_/D _18936_/Q VDD VSS DFFQX1
X_14059_ _14107_/A _14059_/B VDD VSS _18128_/D AND2X1
XFILLER_100_129 VDD VSS DECAPHV8
XFILLER_39_202 VSS VDD FILLER2
XFILLER_67_522 VSS VDD FILLER2
XFILLER_79_382 VDD VSS DECAPHV16
XFILLER_95_820 VSS VDD FILLER2
X_18867_ _18950_/CK _18867_/D _18867_/Q VDD VSS DFFQX1
XFILLER_94_352 VDD VSS FILLER1
XFILLER_95_864 VSS VDD FILLER2
X_17818_ _19036_/CK _17818_/D _17818_/Q VDD VSS DFFQX1
XFILLER_55_728 VDD VSS FILLER4
XFILLER_82_514 VDD VSS FILLER1
X_18798_ _18852_/CK _18798_/D _18798_/Q VDD VSS DFFQX1
X_17749_ clkload3/A _17749_/D _17749_/Q VDD VSS DFFQX1
XFILLER_36_986 VDD VSS FILLER1
XTAP_TAPCELL_ROW_37_458 VDD VSS WELLTAP
XFILLER_62_282 VDD VSS FILLER4
XFILLER_10_308 VDD VSS FILLER1
XFILLER_50_455 VDD VSS FILLER1
XFILLER_50_488 VDD VSS DECAPHV16
X_09103_ _17495_/B _17699_/Q _09103_/C VDD VSS _09129_/C MIN3X1
XFILLER_11_1022 VDD VSS FILLER1
XFILLER_136_538 VSS VDD FILLER2
XTAP_TAPCELL_ROW_118_1438 VDD VSS WELLTAP
X_09034_ _17666_/Q _17460_/B VDD VSS _09035_/B XNOR2X1
XFILLER_132_700 VDD VSS DECAPHV16
XTAP_TAPCELL_ROW_9_128 VDD VSS WELLTAP
XFILLER_116_295 VDD VSS FILLER4
XFILLER_117_68 VDD VSS DECAPHV16
XFILLER_131_221 VDD VSS DECAPHV32
XFILLER_104_468 VSS VDD FILLER2
X_09936_ _17792_/Q _09936_/B _09936_/C VDD VSS _10138_/A OR3BX1
XFILLER_85_341 VDD VSS FILLER4
XFILLER_86_886 VSS VDD FILLER2
X_09867_ _17785_/Q _09879_/B VDD VSS _09887_/A NOR2X1
XFILLER_27_920 VDD VSS DECAPHV8
XTAP_TAPCELL_ROW_129_1567 VDD VSS WELLTAP
X_09798_ _17762_/Q _09891_/B _17763_/Q VDD VSS _09899_/B AO21X2
XFILLER_26_32 VDD VSS DECAPHV8
XFILLER_61_709 VDD VSS DECAPHV16
XFILLER_14_603 VDD VSS FILLER1
X_11760_ _11760_/A _11760_/B _11760_/C VDD VSS _11763_/B XNOR3X1
X_10711_ _17903_/Q _10711_/B _10711_/C VDD VSS _10715_/D XNOR3X1
XFILLER_42_989 VDD VSS FILLER1
X_11691_ _11691_/A _11691_/B _11691_/C _11691_/D VDD VSS _14109_/C OAI211X1
XFILLER_107_1050 VDD VSS FILLER1
XFILLER_41_499 VDD VSS FILLER1
XFILLER_9_128 VSS VDD FILLER2
X_10642_ _17888_/Q _10642_/B VDD VSS _10643_/C NOR2BX1
X_13430_ _18503_/Q _14490_/B VDD VSS _13431_/B XNOR2X1
X_10573_ _10711_/B _10711_/C VDD VSS _10714_/B XNOR2X1
X_13361_ _18371_/Q _14333_/B VDD VSS _13455_/A NAND2X1
X_12312_ _18310_/Q _14261_/B _14261_/C VDD VSS _12313_/D OR3BX1
X_13292_ _13392_/A _13392_/B VDD VSS _14272_/A NAND2X1
X_16080_ _18839_/Q _18677_/Q VDD VSS _16082_/C AND2X1
X_15100_ _15240_/A _18671_/Q VDD VSS _18644_/D AND2X1
XFILLER_108_741 VSS VDD FILLER2
XFILLER_6_857 VDD VSS DECAPHV16
X_12243_ _12244_/A _12244_/B _12244_/D _12244_/C VDD VSS _12545_/B OAOI211X1
X_15031_ _18628_/Q _19006_/Q VDD VSS _15037_/B NAND2X1
X_12174_ _12174_/A _12174_/B _14257_/B VDD VSS _12175_/B MIN3X1
X_11125_ _11135_/A _17071_/B VDD VSS _18009_/D NOR2X1
X_16982_ _18939_/Q _17007_/B VDD VSS _16983_/C NAND2X1
XFILLER_110_416 VSS VDD FILLER2
XFILLER_49_522 VSS VDD FILLER2
XFILLER_89_691 VDD VSS FILLER4
X_11056_ _11056_/A _11056_/B _11056_/C VDD VSS _11057_/B NOR3X1
X_18721_ _18857_/CK _18721_/D _18721_/Q VDD VSS DFFQX1
X_15933_ _15961_/A _15961_/B VDD VSS _15934_/C XOR2X1
X_10007_ _17802_/Q VDD VSS _10017_/A INVX1
XFILLER_64_514 VDD VSS DECAPHV8
XFILLER_77_886 VDD VSS FILLER4
XFILLER_91_300 VDD VSS FILLER1
X_18652_ _18841_/CK _18652_/D _18652_/Q VDD VSS DFFQX1
X_15864_ _15802_/B _15864_/B VDD VSS _16062_/A NAND2BX1
X_18583_ _18994_/CK _18583_/D _18583_/Q VDD VSS DFFQX1
X_17603_ _17701_/CK _17603_/D _17603_/Q VDD VSS DFFQX1
X_15795_ _16926_/A VDD VSS _16456_/A BUFX3
X_14815_ _18581_/Q _18613_/Q _14815_/C VDD VSS _14819_/B AOI21X1
XFILLER_17_452 VDD VSS DECAPHV8
XFILLER_45_783 VDD VSS FILLER4
X_17534_ _17534_/A _17536_/B VDD VSS _17535_/C NAND2X1
X_14746_ _18567_/Q _18599_/Q VDD VSS _14751_/A XNOR2X1
XFILLER_44_271 VSS VDD FILLER2
XFILLER_60_720 VSS VDD FILLER2
XFILLER_91_399 VDD VSS FILLER4
XTAP_TAPCELL_ROW_34_428 VDD VSS WELLTAP
X_11958_ _12052_/A _12052_/B VDD VSS _14083_/B XNOR2X1
XFILLER_32_455 VDD VSS FILLER1
XFILLER_44_293 VSS VDD FILLER2
XTAP_TAPCELL_ROW_102_1239 VDD VSS WELLTAP
XTAP_TAPCELL_ROW_62_759 VDD VSS WELLTAP
X_10909_ _10914_/A _11048_/B VDD VSS _17967_/D NOR2X1
X_11889_ _12013_/A _12013_/B VDD VSS _12079_/C _12013_/C NAND3X1
X_17465_ _17501_/A VDD VSS _17479_/A BUFX3
X_14677_ _17544_/C _14684_/B VDD VSS _14678_/C NAND2X1
XFILLER_20_628 VDD VSS DECAPHV16
X_17396_ _17396_/A VDD VSS _17410_/A BUFX3
X_16416_ _16110_/Y _16415_/Y _16459_/A VDD VSS _16457_/B MUXI2X1
X_13628_ _13628_/A _13628_/B _13628_/C _13628_/D VDD VSS _14247_/B OAOI211X1
XTAP_TAPCELL_ROW_14_185 VDD VSS WELLTAP
X_16347_ _18907_/Q _16927_/B _16381_/B _16347_/D VDD VSS _18907_/D AO22X2
X_13559_ _13628_/A _13559_/B VDD VSS _14246_/B XNOR2X1
XFILLER_118_549 VDD VSS DECAPHV8
XFILLER_121_1036 VDD VSS DECAPHV16
X_18017_ _18024_/CK _18017_/D _18017_/Q VDD VSS DFFQX1
X_16278_ _16327_/A _16284_/B wire35/Y VDD VSS _16284_/C OAI21X1
XFILLER_99_411 VDD VSS FILLER1
X_15229_ _18798_/Q VDD VSS _16570_/A INVX1
XFILLER_99_488 VDD VSS FILLER4
XTAP_TAPCELL_ROW_113_1379 VDD VSS WELLTAP
XFILLER_114_799 VDD VSS FILLER1
X_09721_ _17755_/Q _17723_/Q VDD VSS _09722_/B XNOR2X1
XFILLER_28_706 VSS VDD FILLER2
XFILLER_41_1004 VDD VSS FILLER4
XFILLER_41_1026 VDD VSS DECAPHV16
XFILLER_95_661 VDD VSS FILLER1
X_18919_ _18959_/CK _18919_/D _18919_/Q VDD VSS DFFQX1
XFILLER_110_983 VDD VSS FILLER1
XFILLER_27_205 VDD VSS DECAPHV8
XFILLER_55_525 VDD VSS FILLER4
XFILLER_67_385 VDD VSS FILLER1
XFILLER_68_886 VSS VDD FILLER2
XFILLER_82_300 VDD VSS FILLER4
XFILLER_95_683 VDD VSS FILLER1
X_09652_ _09652_/A _09652_/B VDD VSS _09653_/A NAND2X1
XFILLER_82_322 VSS VDD FILLER2
XFILLER_82_333 VDD VSS DECAPHV16
X_09583_ _17686_/Q _17482_/B VDD VSS _09604_/A XOR2X1
XFILLER_82_377 VDD VSS FILLER4
XFILLER_51_720 VSS VDD FILLER2
XFILLER_63_591 VDD VSS FILLER1
XFILLER_136_313 VSS VDD FILLER2
X_09017_ _09037_/A _09017_/B VDD VSS _17391_/B XOR2X1
XFILLER_3_827 VDD VSS DECAPHV8
XFILLER_104_210 VSS VDD FILLER2
XFILLER_2_315 VDD VSS DECAPHV8
XFILLER_88_49 VDD VSS DECAPHV32
XTAP_TAPCELL_ROW_92_1121 VDD VSS WELLTAP
XFILLER_59_820 VDD VSS FILLER1
XFILLER_78_639 VDD VSS FILLER1
XFILLER_101_950 VDD VSS FILLER1
X_09919_ _10111_/A _10111_/B _10121_/C _09919_/D VDD VSS _10117_/B OAOI211X1
XFILLER_100_471 VSS VDD FILLER2
XFILLER_101_983 VDD VSS FILLER1
XFILLER_46_514 VDD VSS DECAPHV8
X_12930_ _18393_/Q _14360_/B VDD VSS _13023_/A NAND2X1
XFILLER_18_249 VSS VDD FILLER2
XFILLER_37_64 VDD VSS DECAPHV16
XFILLER_46_547 VDD VSS FILLER4
XFILLER_58_396 VDD VSS FILLER4
XFILLER_85_171 VDD VSS FILLER4
X_12861_ _14150_/B _14150_/C _18210_/Q VDD VSS _12863_/C AOI21X1
XFILLER_46_569 VDD VSS DECAPHV8
X_11812_ _18383_/Q _12102_/B _12102_/C VDD VSS _11822_/C XNOR3X1
X_14600_ _14602_/A _14602_/B _14600_/C VDD VSS _18535_/D AOI21X1
XFILLER_42_731 VSS VDD FILLER2
XFILLER_54_591 VDD VSS DECAPHV8
XFILLER_73_388 VDD VSS FILLER1
X_12792_ _18315_/Q _13011_/A _13010_/B VDD VSS _13009_/D XNOR3X1
X_15580_ _18925_/Q _15593_/C VDD VSS _15581_/B NAND2X1
X_11743_ _11743_/A _11743_/B _14194_/B VDD VSS _11800_/A MIN3X1
X_14531_ _14534_/A _14534_/B _14534_/C _17544_/C VDD VSS _14532_/D AOAI211X1
XFILLER_53_96 VDD VSS FILLER4
X_11674_ _18198_/Q _14136_/B VDD VSS _11675_/D _14136_/C NAND3X1
X_17250_ _17251_/C _17259_/A _17259_/D VDD VSS _17250_/Y NOR3X1
X_14462_ _14361_/Y _14462_/B _14462_/C VDD VSS _18484_/D AND3BX1
X_10625_ _10625_/A _10625_/B VDD VSS _10628_/B AND2X1
X_17181_ _18994_/Q _17232_/B VDD VSS _17193_/B XOR2X1
X_16201_ _18842_/Q _18680_/Q VDD VSS _16257_/E AND2X1
X_13413_ _18321_/Q _14276_/B VDD VSS _13467_/B XNOR2X1
XTAP_TAPCELL_ROW_11_155 VDD VSS WELLTAP
X_16132_ _18840_/Q _18678_/Q VDD VSS _16169_/A NAND2X1
X_14393_ _14423_/A _14393_/B VDD VSS _18421_/D AND2X1
X_10556_ _17874_/Q _10556_/B VDD VSS _10560_/C _10556_/C NAND3X1
X_13344_ _18475_/Q _13344_/B _13344_/C VDD VSS _13440_/A MIN3X1
XFILLER_6_687 VDD VSS DECAPHV8
X_10487_ _10487_/A _10487_/B _10487_/C VDD VSS _10509_/A MIN3X1
X_13275_ _13276_/A _13276_/B _13276_/D _13276_/C VDD VSS _14367_/B OAOI211X1
X_16063_ _16109_/A _16063_/B _16063_/C VDD VSS _16303_/B OA21X2
X_12226_ _12227_/A _12227_/B _12227_/D _12227_/C VDD VSS _12334_/B OAOI211X1
X_15014_ _15016_/C _15014_/B _15014_/C VDD VSS _18624_/D AOI21X1
XFILLER_123_541 VDD VSS FILLER1
XFILLER_123_563 VDD VSS FILLER1
XFILLER_29_1135 VDD VSS FILLER1
X_12157_ _12161_/A _12161_/B _12161_/C _12157_/D VDD VSS _14057_/B OAOI211X1
XFILLER_111_736 VDD VSS DECAPHV8
XFILLER_111_747 VDD VSS FILLER4
XFILLER_1_370 VSS VDD FILLER2
XFILLER_64_1059 VDD VSS FILLER4
X_11108_ _11108_/A _11108_/B _11108_/C VDD VSS _11112_/C MIN3X1
X_12088_ _12202_/A _12202_/B _12106_/C VDD VSS _14411_/B XNOR3X1
X_16965_ _16969_/A _16970_/B VDD VSS _16966_/B XNOR2X1
XFILLER_110_279 VSS VDD FILLER2
XTAP_TAPCELL_ROW_67_818 VDD VSS WELLTAP
X_11039_ _11039_/A _11039_/B _11039_/C VDD VSS _11045_/C OAI21X1
X_18704_ _18787_/CK _18704_/D _18704_/Q VDD VSS DFFQX1
X_16896_ _18928_/Q _16905_/B VDD VSS _16897_/D NAND2X1
X_15916_ _15972_/A _15972_/B _15916_/C VDD VSS _15980_/A OAI21X1
XFILLER_65_867 VDD VSS FILLER4
XFILLER_76_182 VSS VDD FILLER2
XFILLER_76_193 VDD VSS DECAPHV8
XFILLER_94_81 VDD VSS DECAPHV32
X_18635_ _19019_/CK _18635_/D _18635_/Q VDD VSS DFFQX1
X_15847_ _18780_/Q _18726_/Q VDD VSS _15850_/D XOR2X1
XFILLER_91_163 VSS VDD FILLER2
XTAP_TAPCELL_ROW_19_244 VDD VSS WELLTAP
XFILLER_75_1111 VDD VSS FILLER1
XTAP_TAPCELL_ROW_47_586 VDD VSS WELLTAP
X_18566_ clkload2/A _18566_/D _18566_/Q VDD VSS DFFQX1
X_15778_ _16084_/A _15778_/B _15778_/C _15785_/B VDD VSS _15781_/C AOI22X1
XFILLER_33_753 VDD VSS DECAPHV8
X_18497_ _18500_/CK _18497_/D _18497_/Q VDD VSS DFFQX1
Xclkbuf_leaf_40__001_ clkload73/A VDD VSS _17722_/CK BUFX12
X_17517_ _17523_/A _17751_/Q VDD VSS _17719_/D AND2X1
X_14729_ _14729_/A _14878_/A _14729_/C VDD VSS _14732_/C MIN3X1
XFILLER_123_1109 VDD VSS FILLER4
XFILLER_32_263 VSS VDD FILLER2
X_17448_ _17463_/A _17448_/B VDD VSS _17654_/D NOR2X1
XFILLER_71_0 VDD VSS DECAPHV32
X_17379_ _17446_/A _17379_/B VDD VSS _17590_/D AND2X1
XFILLER_106_519 VDD VSS DECAPHV8
X_19049_ _19051_/CK _19049_/D _19049_/Q VDD VSS DFFQX1
XFILLER_126_390 VDD VSS FILLER1
XFILLER_0_808 VSS VDD FILLER2
XFILLER_88_915 VDD VSS FILLER1
XFILLER_101_213 VDD VSS FILLER4
XFILLER_59_138 VDD VSS DECAPHV8
X_09704_ _09704_/A _09712_/C VDD VSS _17350_/B XNOR2X1
XFILLER_83_642 VDD VSS FILLER1
XFILLER_95_480 VSS VDD FILLER2
XTAP_TAPCELL_ROW_126_1526 VDD VSS WELLTAP
X_09635_ _17719_/Q VDD VSS _09636_/B INVX1
XFILLER_55_355 VDD VSS FILLER4
XFILLER_15_219 VDD VSS DECAPHV8
XFILLER_43_528 VDD VSS FILLER4
XFILLER_70_314 VDD VSS FILLER1
XFILLER_83_697 VSS VDD FILLER2
X_09566_ _09577_/A _09577_/B VDD VSS _17378_/B XNOR2X1
X_09497_ _09497_/A _09497_/B VDD VSS _09514_/B AND2X1
XFILLER_8_919 VDD VSS DECAPHV8
XFILLER_7_407 VDD VSS DECAPHV32
X_10410_ _10516_/A _10590_/B VDD VSS _17879_/D NOR2X1
X_11390_ _18116_/Q VDD VSS _11440_/A INVX1
XFILLER_109_379 VSS VDD FILLER2
XFILLER_87_1026 VDD VSS FILLER4
X_10341_ _17043_/A _10532_/B VDD VSS _17872_/D AND2X1
X_10272_ _17838_/Q _10278_/B _10282_/C VDD VSS _10476_/B XNOR3X1
X_13060_ _13060_/A _13234_/B VDD VSS _14302_/B XNOR2X1
XFILLER_105_552 VDD VSS FILLER4
X_12011_ _12011_/A _12011_/B _14258_/B VDD VSS _12171_/A MIN3X1
XFILLER_105_585 VSS VDD FILLER2
XFILLER_132_360 VDD VSS DECAPHV8
XFILLER_111_1002 VDD VSS FILLER4
XFILLER_4_1104 VDD VSS DECAPHV32
XFILLER_63_1092 VDD VSS DECAPHV8
XFILLER_98_1100 VSS VDD FILLER2
X_16750_ _16777_/C _16750_/B VDD VSS _16762_/B XNOR2X1
X_13962_ _18939_/Q _18938_/Q VDD VSS _13963_/B NAND2X1
X_12913_ _18446_/Q _13036_/B _14420_/B VDD VSS _12925_/C XNOR3X1
X_15701_ _15614_/B _15684_/B _15651_/Y VDD VSS _15707_/B MUXI2X1
XFILLER_0_48 VDD VSS DECAPHV32
XFILLER_47_878 VDD VSS DECAPHV8
X_18420_ _18448_/CK _18420_/D _18420_/Q VDD VSS DFFQX1
X_16681_ _16681_/A _16681_/B _16681_/C VDD VSS _16717_/C MIN3X1
X_13893_ _14463_/B _14463_/C _18485_/Q VDD VSS _13905_/B AOI21X1
XFILLER_34_539 VDD VSS FILLER1
XFILLER_46_399 VDD VSS FILLER1
XFILLER_64_40 VDD VSS FILLER4
XTAP_TAPCELL_ROW_16_214 VDD VSS WELLTAP
X_12844_ _12844_/A _12844_/B _12844_/C _12844_/D VDD VSS _12849_/B AOAI211X1
X_15632_ _18928_/Q _18929_/Q VDD VSS _15645_/B _15632_/C NAND3X1
XFILLER_15_742 VSS VDD FILLER2
XTAP_TAPCELL_ROW_44_545 VDD VSS WELLTAP
X_12775_ _12781_/A _12781_/C _12781_/B VDD VSS _14093_/C AO21X2
X_18351_ _18406_/CK _18351_/D _18351_/Q VDD VSS DFFQX1
X_15563_ _18873_/Q _15563_/B _15563_/C VDD VSS _15567_/C MIN3X1
XFILLER_30_712 VDD VSS FILLER4
XFILLER_70_870 VDD VSS DECAPHV8
XTAP_TAPCELL_ROW_72_887 VDD VSS WELLTAP
X_11726_ _18355_/Q VDD VSS _11732_/A INVX1
X_18282_ _18309_/CK _18282_/D _18282_/Q VDD VSS DFFQX1
X_17302_ _17302_/A _17302_/B _17302_/C _17302_/D VDD VSS _17306_/A OA211X2
X_14514_ _18517_/Q _18549_/Q _14514_/C VDD VSS _14518_/B AOI21X1
XFILLER_30_745 VDD VSS DECAPHV16
X_17233_ _17228_/B _17237_/A _17238_/C VDD VSS _17234_/B AOI2B1X1
X_15494_ _15669_/A _16980_/A _15494_/C VDD VSS _18869_/D OAI21X1
XFILLER_70_1052 VDD VSS FILLER1
X_11657_ _11657_/A _11657_/B _14313_/B VDD VSS _11658_/B MIN3X1
X_14445_ _14451_/A _14445_/B VDD VSS _18468_/D NOR2X1
X_10608_ _17882_/Q _10608_/B VDD VSS _10611_/A NOR2BX1
X_11588_ _18354_/Q _11588_/B _11588_/C VDD VSS _11732_/B MIN3X1
X_17164_ _18991_/Q _17232_/B VDD VSS _17165_/B XOR2X1
X_14376_ _17534_/A _14376_/B VDD VSS _18406_/D AND2X1
XFILLER_31_1058 VDD VSS DECAPHV8
X_10539_ _10539_/A _10553_/B VDD VSS _10551_/B NOR2X1
X_17095_ _17095_/A _17095_/B _17095_/C VDD VSS _17103_/B OAI21X1
X_16115_ _16119_/D _16119_/C VDD VSS _16116_/B NOR2BX1
X_13327_ _18450_/Q _13332_/B _13444_/D VDD VSS _13512_/C XNOR3X1
XFILLER_127_176 VDD VSS DECAPHV8
X_16046_ _18838_/Q _18676_/Q VDD VSS _16047_/D NAND2X1
XFILLER_124_861 VSS VDD FILLER2
XFILLER_89_92 VDD VSS FILLER1
X_13258_ _13258_/A _13258_/B VDD VSS _13261_/C _13258_/C NAND3X1
XFILLER_9_1026 VDD VSS FILLER1
XTAP_TAPCELL_ROW_110_1338 VDD VSS WELLTAP
X_12209_ _18282_/Q _14230_/B _14229_/C VDD VSS _12210_/D OR3BX1
X_13189_ _18292_/Q _14241_/B VDD VSS _13287_/C _14241_/C AND3X2
XFILLER_96_222 VDD VSS FILLER1
XFILLER_97_756 VDD VSS DECAPHV8
XFILLER_9_1059 VDD VSS FILLER4
X_17997_ _18011_/CK _17997_/D _17997_/Q VDD VSS DFFQX1
XFILLER_37_300 VSS VDD FILLER2
XFILLER_38_801 VDD VSS FILLER4
XFILLER_78_981 VDD VSS FILLER1
XFILLER_84_417 VDD VSS FILLER1
X_16948_ _16948_/A _16948_/B VDD VSS _16957_/C AND2X1
X_16879_ _16957_/A _16889_/B VDD VSS _16880_/B NOR2X1
XFILLER_64_185 VSS VDD FILLER2
X_09420_ _09420_/A _09420_/B VDD VSS _09446_/B NAND2X1
X_18618_ clkload8/A _18618_/D _18618_/Q VDD VSS DFFQX1
XFILLER_80_656 VDD VSS FILLER4
X_09351_ _19036_/Q _17336_/B VDD VSS _09379_/B XOR2X1
X_18549_ _18990_/CK _18549_/D _18549_/Q VDD VSS DFFQX1
XTAP_TAPCELL_ROW_121_1467 VDD VSS WELLTAP
X_09282_ _17738_/Q VDD VSS _17503_/B INVX1
XFILLER_100_49 VDD VSS DECAPHV32
XFILLER_21_767 VSS VDD FILLER2
XFILLER_119_666 VSS VDD FILLER2
XFILLER_134_614 VDD VSS FILLER1
Xclkload70 _18436_/CK VDD VSS clkload70/Y INVX2
XFILLER_134_669 VSS VDD FILLER2
Xclkload92 _17669_/CK VDD VSS clkload92/Y INVX2
Xclkload81 _19042_/CK VDD VSS clkload81/Y BUFX12
XFILLER_47_1032 VDD VSS FILLER1
XFILLER_88_734 VSS VDD FILLER2
XFILLER_130_853 VDD VSS DECAPHV16
XFILLER_130_886 VSS VDD FILLER2
XFILLER_29_823 VDD VSS FILLER4
X_08997_ _17664_/Q _17458_/B VDD VSS _08998_/B XNOR2X1
XFILLER_18_44 VSS VDD FILLER2
XFILLER_18_77 VDD VSS FILLER1
XFILLER_56_675 VDD VSS FILLER1
XFILLER_43_314 VSS VDD FILLER2
XFILLER_43_325 VDD VSS DECAPHV16
XFILLER_84_995 VDD VSS DECAPHV8
XTAP_TAPCELL_ROW_87_1064 VDD VSS WELLTAP
X_09618_ _17591_/Q _17380_/B VDD VSS _09620_/C XOR2X1
X_10890_ _10914_/A _11025_/B VDD VSS _17963_/D NOR2X1
XFILLER_43_347 VDD VSS DECAPHV16
X_09549_ _17588_/Q _17377_/B VDD VSS _09550_/D NAND2BX1
XFILLER_24_550 VDD VSS DECAPHV16
XFILLER_31_509 VSS VDD FILLER2
XFILLER_34_32 VDD VSS DECAPHV8
XTAP_TAPCELL_ROW_41_515 VDD VSS WELLTAP
XFILLER_34_65 VDD VSS DECAPHV8
XFILLER_54_1058 VDD VSS FILLER4
XFILLER_70_188 VDD VSS FILLER1
X_12560_ _14061_/A _14061_/B _12679_/C VDD VSS _12667_/C AOI21X1
XFILLER_11_244 VSS VDD FILLER2
XFILLER_12_789 VDD VSS FILLER1
X_11511_ _18223_/Q _11607_/D _11752_/B VDD VSS _11534_/B XNOR3X1
X_12491_ _18416_/Q _12491_/B _12491_/C VDD VSS _12712_/B MIN3X1
XTAP_TAPCELL_ROW_21_272 VDD VSS WELLTAP
X_11442_ _11448_/A _11448_/B _11478_/C VDD VSS _14076_/C NOR3X1
X_14230_ _14230_/A _14230_/B _14230_/C VDD VSS _14231_/C NOR3X1
XFILLER_119_0 VDD VSS DECAPHV32
X_11373_ _18245_/Q _14187_/B VDD VSS _11374_/B OR2X2
X_14161_ _14253_/A VDD VSS _14191_/A BUFX3
XFILLER_124_113 VDD VSS DECAPHV16
XFILLER_125_625 VSS VDD FILLER2
XTAP_TAPCELL_ROW_98_1193 VDD VSS WELLTAP
X_10324_ _10333_/A _10324_/B _10330_/B VDD VSS _10329_/D XNOR3X1
X_13112_ _13112_/A _13112_/B _13112_/C _13112_/D VDD VSS _14067_/B OAOI211X1
XFILLER_4_966 VDD VSS DECAPHV8
X_14092_ _14074_/Y _14092_/B _14092_/C VDD VSS _18157_/D AND3BX1
XFILLER_1_0 VDD VSS DECAPHV32
XFILLER_78_200 VDD VSS FILLER4
X_10255_ _10268_/A _10444_/B VDD VSS _17859_/D NOR2X1
X_13043_ _18422_/Q VDD VSS _13163_/A INVX1
X_17920_ _17972_/CK _17920_/D _17920_/Q VDD VSS DFFQX1
X_10186_ _10364_/A _10364_/B _10376_/C VDD VSS _10379_/B OAI21X1
X_17851_ _17851_/CK _17851_/D _17851_/Q VDD VSS DFFQX1
XFILLER_66_417 VDD VSS FILLER1
XFILLER_78_266 VDD VSS FILLER1
XFILLER_94_715 VSS VDD FILLER2
XTAP_TAPCELL_ROW_49_604 VDD VSS WELLTAP
X_16802_ _16802_/A _16802_/B _16819_/C VDD VSS _16857_/B AOI21BX1
XFILLER_19_322 VDD VSS DECAPHV8
XTAP_TAPCELL_ROW_77_946 VDD VSS WELLTAP
X_17782_ _19051_/CK _17782_/D _17782_/Q VDD VSS DFFQX1
X_14994_ _14998_/C _14994_/B VDD VSS _14995_/B XNOR2X1
XFILLER_19_355 VDD VSS FILLER1
XFILLER_46_130 VSS VDD FILLER2
X_16733_ _16697_/Y _16732_/Y _16629_/A VDD VSS _16786_/B MUX2X1
X_13945_ _18950_/Q _13991_/B VDD VSS _13995_/B NOR2BX1
XFILLER_74_472 VDD VSS FILLER4
XFILLER_90_921 VDD VSS FILLER4
XTAP_TAPCELL_ROW_29_361 VDD VSS WELLTAP
XTAP_TAPCELL_ROW_29_372 VDD VSS WELLTAP
X_16664_ _16778_/A _16664_/B _16664_/C _16664_/D VDD VSS _16664_/Y OAI211X1
X_13876_ _13876_/A _13876_/B _13876_/C VDD VSS _14405_/B NOR3X1
XFILLER_61_133 VDD VSS FILLER4
X_12827_ _12827_/A _12827_/B _12827_/C _12926_/B VDD VSS _12949_/B OAOI211X1
X_18403_ _18431_/CK _18403_/D _18403_/Q VDD VSS DFFQX1
X_15615_ _15621_/A _15621_/B VDD VSS _15617_/D XNOR2X1
XFILLER_15_561 VDD VSS DECAPHV8
XFILLER_50_829 VSS VDD FILLER2
XFILLER_61_166 VDD VSS DECAPHV16
X_18334_ _18337_/CK _18334_/D _18334_/Q VDD VSS DFFQX1
X_16595_ _16446_/Y _16594_/Y _16869_/A VDD VSS _16595_/Y MUXI2X1
XFILLER_42_380 VSS VDD FILLER2
X_12758_ _14092_/B _14092_/C _18157_/Q VDD VSS _12760_/C AOI21X1
X_15546_ _15514_/Y _15545_/Y _15596_/A VDD VSS _15548_/B MUXI2X1
XFILLER_129_920 VDD VSS FILLER1
X_11709_ _18148_/Q _11709_/B _11847_/D VDD VSS _11845_/C XNOR3X1
X_12689_ _18340_/Q _12840_/A _13009_/B VDD VSS _12940_/C XNOR3X1
X_18265_ _18292_/CK _18265_/D _18265_/Q VDD VSS DFFQX1
X_15477_ _18918_/Q _15477_/B VDD VSS _15512_/C NOR2BX1
XFILLER_129_964 VDD VSS FILLER1
X_18196_ _18247_/CK _18196_/D _18196_/Q VDD VSS DFFQX1
X_17216_ _17216_/A _17216_/B _17216_/C _17216_/D VDD VSS _17221_/B OA211X2
X_14428_ _14428_/A _14428_/B _14428_/C VDD VSS _14429_/C NOR3X1
XFILLER_116_603 VDD VSS FILLER1
XFILLER_129_975 VDD VSS FILLER1
X_17147_ _18024_/Q _17147_/B VDD VSS _17151_/A NAND2BX1
XFILLER_116_636 VDD VSS FILLER4
X_14359_ _14378_/A _14359_/B VDD VSS _18392_/D NOR2X1
XFILLER_131_606 VDD VSS FILLER4
X_17078_ _17082_/C _17078_/B VDD VSS _17079_/B XOR2X1
X_08920_ _17744_/Q _18533_/Q VDD VSS _08922_/D XNOR2X1
X_16029_ _16030_/A _16030_/B _16030_/D _16030_/C VDD VSS _16069_/B OAOI211X1
XFILLER_112_842 VDD VSS DECAPHV16
XFILLER_34_0 VDD VSS DECAPHV32
XFILLER_58_907 VDD VSS FILLER4
XFILLER_97_531 VDD VSS FILLER1
XFILLER_29_108 VSS VDD FILLER2
XFILLER_111_385 VDD VSS FILLER1
XFILLER_133_1090 VDD VSS DECAPHV16
XFILLER_38_653 VDD VSS FILLER1
XFILLER_65_450 VDD VSS FILLER4
XFILLER_66_973 VSS VDD FILLER2
XFILLER_84_258 VDD VSS DECAPHV16
XFILLER_1_80 VDD VSS DECAPHV8
XFILLER_77_1003 VDD VSS FILLER1
XFILLER_37_196 VSS VDD FILLER2
XFILLER_52_133 VDD VSS FILLER4
XFILLER_53_667 VDD VSS FILLER4
X_09403_ _17583_/Q _17372_/B VDD VSS _09405_/C XNOR2X1
XFILLER_41_829 VDD VSS DECAPHV8
XFILLER_52_155 VDD VSS DECAPHV16
XFILLER_21_531 VDD VSS FILLER1
XFILLER_40_328 VSS VDD FILLER2
X_09334_ _09319_/A _09334_/B VDD VSS _09345_/B NAND2BX1
X_09265_ _17367_/B _17367_/C VDD VSS _09275_/C NOR2X1
XFILLER_119_430 VDD VSS FILLER4
X_09196_ _17575_/Q VDD VSS _09197_/A INVX1
XFILLER_119_463 VSS VDD FILLER2
XFILLER_106_113 VDD VSS DECAPHV16
XTAP_TAPCELL_ROW_134_1625 VDD VSS WELLTAP
XFILLER_106_146 VSS VDD FILLER2
XFILLER_20_67 VDD VSS FILLER1
XFILLER_84_1029 VDD VSS DECAPHV16
XFILLER_106_168 VSS VDD FILLER2
XFILLER_103_831 VDD VSS FILLER4
XFILLER_114_190 VDD VSS DECAPHV8
XFILLER_49_907 VDD VSS FILLER4
XFILLER_96_49 VDD VSS DECAPHV32
X_10040_ _17806_/Q _10047_/A VDD VSS _10042_/C XOR2X1
XFILLER_130_661 VDD VSS DECAPHV8
XFILLER_29_32 VDD VSS DECAPHV16
XFILLER_48_417 VDD VSS FILLER1
XFILLER_49_918 VDD VSS FILLER1
XFILLER_49_929 VDD VSS FILLER1
XFILLER_76_704 VSS VDD FILLER2
XFILLER_21_1002 VDD VSS DECAPHV8
XFILLER_48_439 VSS VDD FILLER2
XFILLER_75_236 VDD VSS FILLER4
XFILLER_56_450 VSS VDD FILLER2
XFILLER_60_1062 VDD VSS FILLER1
XTAP_TAPCELL_ROW_74_905 VDD VSS WELLTAP
X_11991_ _18489_/Q _11991_/B _11991_/C VDD VSS _12095_/B MIN3X1
XFILLER_43_100 VDD VSS FILLER4
XFILLER_56_483 VDD VSS DECAPHV8
XFILLER_84_781 VDD VSS FILLER1
XFILLER_90_206 VDD VSS FILLER4
X_10942_ _10942_/A _10942_/B _10942_/C VDD VSS _10947_/C OA21X2
X_13730_ _13730_/A _13730_/B _13730_/C _13730_/D VDD VSS _14459_/B OAOI211X1
XFILLER_45_64 VDD VSS DECAPHV16
XTAP_TAPCELL_ROW_26_331 VDD VSS WELLTAP
XTAP_TAPCELL_ROW_54_662 VDD VSS WELLTAP
X_10873_ _11062_/A _11008_/B VDD VSS _17960_/D AND2X1
X_15400_ _15801_/B _15461_/B VDD VSS _15401_/C NOR2X1
X_13661_ _13730_/A _13784_/B VDD VSS _14458_/B XNOR2X1
X_12612_ _12796_/A _12940_/B VDD VSS _14327_/B XNOR2X1
X_16380_ _16381_/A _16381_/B _16381_/C VDD VSS _16423_/B AO21X2
X_13592_ _18427_/Q _13738_/A _13603_/B VDD VSS _13605_/D XNOR3X1
XFILLER_101_92 VDD VSS FILLER1
X_12543_ _14089_/B _14089_/C _18154_/Q VDD VSS _12545_/C AO21X2
X_15331_ _18860_/Q _18861_/Q VDD VSS _15768_/B XOR2X1
XFILLER_8_546 VDD VSS DECAPHV16
X_18050_ _18846_/CK _18050_/D _18050_/Q VDD VSS DFFQX1
X_15262_ _17182_/D _18830_/Q VDD VSS _18803_/D AND2X1
XFILLER_61_96 VDD VSS DECAPHV16
X_12474_ _12602_/A _12602_/B _12491_/C VDD VSS _14416_/B XNOR3X1
X_17001_ _18951_/Q _17007_/B VDD VSS _17002_/C NAND2X1
X_14213_ _14236_/A _14213_/B _14213_/C VDD VSS _18269_/D NOR3X1
XANTENNA_7 _17533_/A VDD VSS ANTENNA2
XFILLER_126_934 VDD VSS DECAPHV8
X_11425_ _14103_/B _14103_/C _11426_/A VDD VSS _11430_/B OAI21X1
X_15193_ _15250_/A _18762_/Q VDD VSS _18735_/D AND2X1
X_11356_ _11356_/A _14045_/B _11389_/C VDD VSS _14046_/B AOI21BX1
X_14144_ _14174_/A _14144_/B _14144_/C VDD VSS _18205_/D NOR3X1
XFILLER_98_328 VDD VSS FILLER1
X_10307_ _10498_/B _10503_/B VDD VSS _10506_/B XNOR2X1
X_18952_ _18958_/CK _18952_/D _18952_/Q VDD VSS DFFQX1
X_14075_ _14074_/Y _14075_/B _14075_/C VDD VSS _18142_/D AND3BX1
X_11287_ _11287_/A _14044_/B VDD VSS _11345_/A OR2X2
X_13026_ _13137_/A _13137_/B _13137_/D _13137_/C VDD VSS _13142_/C OAI211X1
X_17903_ _17932_/CK _17903_/D _17903_/Q VDD VSS DFFQX1
XFILLER_39_417 VDD VSS DECAPHV16
X_10238_ _10268_/A _10423_/B VDD VSS _17855_/D NOR2X1
X_18883_ _18950_/CK _18883_/D _18883_/Q VDD VSS DFFQX1
XFILLER_0_980 VDD VSS DECAPHV8
XFILLER_94_545 VDD VSS FILLER1
X_10169_ _10268_/A _10359_/B VDD VSS _17847_/D NOR2X1
X_17834_ _17861_/CK _17834_/D _17834_/Q VDD VSS DFFQX1
XFILLER_48_962 VDD VSS DECAPHV8
X_17765_ _19033_/CK _17765_/D _17765_/Q VDD VSS DFFQX1
X_14977_ _14975_/B _14977_/B _14977_/C VDD VSS _18616_/D AOI2B1X1
X_16716_ _18857_/Q _18695_/Q VDD VSS _16719_/B XOR2X1
X_13928_ _18487_/Q _14465_/B VDD VSS _13929_/D NOR2BX1
XFILLER_34_122 VDD VSS FILLER1
XFILLER_81_239 VDD VSS FILLER4
X_17696_ _17698_/CK _17696_/D _17696_/Q VDD VSS DFFQX1
XFILLER_23_807 VDD VSS FILLER1
XFILLER_23_818 VSS VDD FILLER2
XFILLER_34_144 VDD VSS FILLER1
XFILLER_50_615 VSS VDD FILLER2
XFILLER_62_453 VDD VSS FILLER1
XFILLER_90_784 VDD VSS FILLER4
X_16647_ _18801_/Q _18747_/Q VDD VSS _16648_/B XOR2X1
X_13859_ _18510_/Q _14497_/B _14497_/C VDD VSS _13884_/D OR3BX1
XFILLER_22_328 VDD VSS FILLER4
X_16578_ _16608_/C _16578_/B VDD VSS _16582_/B XNOR2X1
XFILLER_31_840 VDD VSS DECAPHV8
XFILLER_37_1075 VDD VSS FILLER1
XTAP_TAPCELL_ROW_6_90 VDD VSS WELLTAP
X_18317_ _18368_/CK _18317_/D _18317_/Q VDD VSS DFFQX1
X_15529_ _15513_/Y _15528_/Y _16757_/D VDD VSS _15529_/Y MUX2X1
X_09050_ _17567_/Q _17355_/B _09083_/A VDD VSS _09082_/A MIN3X1
X_18248_ _18249_/CK _18248_/D _18248_/Q VDD VSS DFFQX1
X_18179_ _18200_/CK _18179_/D _18179_/Q VDD VSS DFFQX1
XFILLER_132_904 VDD VSS DECAPHV8
XFILLER_104_639 VSS VDD FILLER2
X_09952_ _17534_/A _10160_/B VDD VSS _17820_/D AND2X1
XFILLER_103_149 VDD VSS FILLER1
XFILLER_131_458 VDD VSS FILLER1
XFILLER_44_1013 VDD VSS FILLER1
X_08903_ _17733_/Q _18522_/Q _17540_/A VDD VSS _17542_/B MIN3X1
X_09883_ _09897_/A _09897_/B _09888_/C VDD VSS _10106_/B XNOR3X1
XFILLER_100_845 VDD VSS DECAPHV8
XFILLER_111_160 VDD VSS FILLER4
XFILLER_131_1005 VDD VSS DECAPHV16
XFILLER_44_1068 VDD VSS FILLER1
XFILLER_98_895 VDD VSS FILLER1
XFILLER_57_258 VDD VSS DECAPHV8
XFILLER_38_483 VDD VSS FILLER4
XTAP_TAPCELL_ROW_84_1023 VDD VSS WELLTAP
XFILLER_41_615 VDD VSS FILLER4
XFILLER_53_475 VSS VDD FILLER2
XFILLER_25_177 VSS VDD FILLER2
XFILLER_81_795 VDD VSS FILLER1
XFILLER_22_862 VDD VSS FILLER4
XFILLER_40_158 VDD VSS FILLER4
XFILLER_90_1044 VDD VSS DECAPHV8
XTAP_TAPCELL_ROW_51_632 VDD VSS WELLTAP
X_09317_ _09336_/B _09317_/B VDD VSS _17437_/B NOR2BX1
XFILLER_21_350 VDD VSS FILLER4
XFILLER_22_873 VDD VSS FILLER1
X_09248_ _09236_/A _09248_/B VDD VSS _09264_/B NOR2BX1
XFILLER_119_282 VSS VDD FILLER2
XFILLER_135_720 VSS VDD FILLER2
XFILLER_31_66 VDD VSS FILLER1
XTAP_TAPCELL_ROW_2_37 VDD VSS WELLTAP
X_09179_ _17702_/Q VDD VSS _09180_/B INVX1
XFILLER_134_230 VSS VDD FILLER2
XTAP_TAPCELL_ROW_2_48 VDD VSS WELLTAP
XTAP_TAPCELL_ROW_95_1163 VDD VSS WELLTAP
X_11210_ _18027_/Q _18026_/Q _17392_/A VDD VSS _11211_/C OAI21X1
X_12190_ _12191_/B _12190_/B _12190_/C VDD VSS _18035_/D AOI21X1
XFILLER_123_926 VDD VSS FILLER4
XFILLER_123_937 VSS VDD FILLER2
X_11141_ _11141_/A _11141_/B _11141_/C _11141_/D VDD VSS _11142_/B AO211X2
Xoutput11 _18079_/Q VDD VSS data_out[17] BUFX3
Xoutput22 _18069_/Q VDD VSS data_out[7] BUFX3
Xoutput9 output9/A VDD VSS data_out[15] BUFX3
XFILLER_122_458 VSS VDD FILLER2
XFILLER_95_309 VDD VSS FILLER1
X_11072_ _17972_/Q _11072_/B VDD VSS _11076_/A NOR2X1
XFILLER_49_759 VSS VDD FILLER2
XTAP_TAPCELL_ROW_59_721 VDD VSS WELLTAP
X_10023_ _10023_/A VDD VSS _10024_/B INVX1
X_15880_ _18834_/Q _18672_/Q VDD VSS _15925_/A NAND2X1
X_14900_ _14900_/A _14900_/B _14900_/C VDD VSS _14906_/C OA21X2
XFILLER_76_567 VDD VSS FILLER1
XTAP_TAPCELL_ROW_59_732 VDD VSS WELLTAP
X_14831_ _18585_/Q _18617_/Q VDD VSS _14835_/C XNOR2X1
X_17550_ _17565_/A _17550_/B VDD VSS _17737_/D NOR2X1
X_11974_ _18203_/Q _12139_/A _12035_/B VDD VSS _12123_/D XNOR3X1
X_16501_ _16588_/A _16501_/B _16501_/C VDD VSS _16518_/A OAI21X1
X_14762_ _18570_/Q _18602_/Q VDD VSS _14769_/C NOR2X1
XFILLER_32_615 VSS VDD FILLER2
XFILLER_44_464 VDD VSS FILLER4
XFILLER_60_902 VDD VSS FILLER4
X_10925_ _10925_/A _10928_/C VDD VSS _11066_/B XNOR2X1
X_17481_ _17499_/A _17481_/B VDD VSS _17685_/D NOR2X1
X_14693_ _14693_/A _14693_/B _14693_/C VDD VSS _14699_/C OA21X2
X_13713_ _18507_/Q _13713_/B _13777_/C VDD VSS _13774_/B XNOR3X1
XFILLER_108_1029 VDD VSS FILLER1
XFILLER_60_946 VDD VSS FILLER4
XFILLER_71_272 VDD VSS FILLER4
XFILLER_72_40 VDD VSS FILLER4
X_10856_ _11148_/A _10990_/B VDD VSS _17957_/D AND2X1
X_16432_ _18821_/Q _18713_/Q _16432_/C VDD VSS _16463_/B MIN3X1
X_13644_ _13673_/A _13673_/B _13673_/C VDD VSS _13665_/C OAI21X1
XFILLER_31_147 VDD VSS DECAPHV8
XFILLER_60_979 VDD VSS DECAPHV8
XTAP_TAPCELL_ROW_104_1270 VDD VSS WELLTAP
X_16363_ _18793_/Q _18739_/Q VDD VSS _16365_/C XNOR2X1
X_10787_ _17916_/Q _10787_/B _10787_/C VDD VSS _10788_/C AOI2B1X1
X_18102_ _18982_/CK _18102_/D _18102_/Q VDD VSS DFFQX1
X_15314_ _18054_/Q VDD VSS _16608_/A INVX1
X_13575_ _18427_/Q _13673_/A _13603_/B VDD VSS _13597_/D XNOR3X1
X_12526_ _18234_/Q _12742_/A _12742_/B VDD VSS _12528_/C XNOR3X1
X_16294_ _18791_/Q _18737_/Q VDD VSS _16321_/B XOR2X1
X_12457_ _18982_/Q _18103_/Q VDD VSS _12566_/A NAND2X1
X_18033_ _18838_/CK _18033_/D _18033_/Q VDD VSS DFFQX1
X_15245_ _15274_/A _18813_/Q VDD VSS _18786_/D AND2X1
XFILLER_67_1013 VDD VSS FILLER4
X_11408_ _18195_/Q _11408_/B _11437_/D VDD VSS _11531_/B XNOR3X1
X_15176_ _15318_/A _18745_/Q VDD VSS _18718_/D AND2X1
XFILLER_119_1103 VDD VSS DECAPHV8
XFILLER_67_1046 VSS VDD FILLER2
X_12388_ _12490_/A _12490_/B _12404_/C VDD VSS _14414_/B XNOR3X1
X_14127_ _14129_/A _14127_/B VDD VSS _18190_/D NOR2X1
XFILLER_113_447 VDD VSS FILLER4
XFILLER_28_1019 VDD VSS DECAPHV8
XFILLER_99_659 VDD VSS FILLER1
X_11339_ _18141_/Q VDD VSS _11382_/A INVX1
XFILLER_97_92 VDD VSS FILLER1
X_18935_ _18940_/CK _18935_/D _18935_/Q VDD VSS DFFQX1
X_14058_ _14079_/A _14058_/B _14058_/C VDD VSS _18127_/D NOR3X1
X_13009_ _13009_/A _13009_/B _13009_/C _13009_/D VDD VSS _13014_/B AOAI211X1
X_18866_ _18958_/CK _18866_/D _18866_/Q VDD VSS DFFQX1
X_17817_ _19036_/CK _17817_/D _17817_/Q VDD VSS DFFQX1
XFILLER_54_217 VDD VSS FILLER1
XFILLER_95_898 VDD VSS DECAPHV8
X_18797_ _18852_/CK _18797_/D _18797_/Q VDD VSS DFFQX1
XFILLER_54_239 VSS VDD FILLER2
X_17748_ clkload3/A _17748_/D _17748_/Q VDD VSS DFFQX1
XFILLER_35_475 VDD VSS FILLER1
XFILLER_39_1115 VDD VSS FILLER1
XFILLER_51_913 VDD VSS FILLER1
XFILLER_63_762 VDD VSS DECAPHV16
XTAP_TAPCELL_ROW_37_459 VDD VSS WELLTAP
X_17679_ _17680_/CK _17679_/D _17679_/Q VDD VSS DFFQX1
XFILLER_50_412 VDD VSS FILLER1
XFILLER_51_946 VDD VSS DECAPHV8
XFILLER_22_169 VDD VSS FILLER1
X_09102_ _17731_/Q VDD VSS _17495_/B INVX1
XFILLER_136_506 VDD VSS FILLER4
XFILLER_50_1061 VDD VSS FILLER1
XFILLER_50_1072 VDD VSS FILLER4
XTAP_TAPCELL_ROW_118_1439 VDD VSS WELLTAP
X_09033_ _09033_/A _09064_/B VDD VSS _17460_/B XNOR2X1
XFILLER_117_36 VDD VSS DECAPHV32
XTAP_TAPCELL_ROW_9_129 VDD VSS WELLTAP
XFILLER_132_745 VDD VSS FILLER1
XFILLER_132_767 VDD VSS DECAPHV16
XFILLER_132_789 VDD VSS FILLER1
X_09935_ _17536_/D VDD VSS _09935_/Y BUFX3
XFILLER_131_277 VSS VDD FILLER2
XFILLER_58_534 VDD VSS DECAPHV16
XFILLER_98_692 VDD VSS FILLER4
XTAP_TAPCELL_ROW_90_1093 VDD VSS WELLTAP
X_09866_ _17786_/Q VDD VSS _09880_/C INVX1
XFILLER_97_180 VDD VSS FILLER4
XFILLER_100_675 VDD VSS FILLER4
XFILLER_85_375 VDD VSS FILLER1
XTAP_TAPCELL_ROW_129_1568 VDD VSS WELLTAP
X_09797_ _17501_/A VDD VSS _17565_/A BUFX3
XFILLER_26_44 VSS VDD FILLER2
XFILLER_26_55 VDD VSS FILLER1
XFILLER_27_965 VDD VSS FILLER1
XFILLER_42_913 VSS VDD FILLER2
XFILLER_42_935 VDD VSS FILLER1
XFILLER_81_581 VSS VDD FILLER2
X_10710_ _10715_/A _10715_/B _10715_/C VDD VSS _10712_/A OAI21X1
XTAP_TAPCELL_ROW_64_790 VDD VSS WELLTAP
X_11690_ _11691_/A _11691_/B _11691_/D _11691_/C VDD VSS _11786_/B OAOI211X1
XFILLER_42_32 VDD VSS DECAPHV8
X_10641_ _10731_/A _10777_/B VDD VSS _17914_/D NOR2X1
X_10572_ _17877_/Q _10572_/B _10572_/C VDD VSS _10711_/C XNOR3X1
X_13360_ _13460_/A _14424_/B VDD VSS _13517_/B NOR2X1
XFILLER_6_825 VDD VSS DECAPHV32
X_12311_ _12503_/A _12503_/B _12503_/D _12503_/C VDD VSS _14261_/C AOI211X1
X_13291_ _18293_/Q _14242_/B VDD VSS _13392_/A NAND2X1
XFILLER_5_346 VDD VSS DECAPHV16
X_12242_ _12344_/A _12446_/A _12352_/B VDD VSS _12244_/C XNOR3X1
X_15030_ _18628_/Q _19006_/Q VDD VSS _15037_/C NOR2X1
XFILLER_101_0 VDD VSS DECAPHV32
XFILLER_108_775 VDD VSS FILLER4
XFILLER_123_712 VDD VSS FILLER4
XFILLER_122_222 VDD VSS DECAPHV8
X_12173_ _12173_/A _12173_/B _14227_/B VDD VSS _14257_/B XNOR3X1
XFILLER_104_970 VDD VSS FILLER4
XFILLER_111_918 VDD VSS FILLER4
XFILLER_111_929 VDD VSS FILLER1
XFILLER_96_607 VSS VDD FILLER2
XFILLER_96_629 VSS VDD FILLER2
X_11124_ _11127_/A _11127_/B VDD VSS _17071_/B XNOR2X1
X_16981_ _17016_/B VDD VSS _17007_/B BUFX3
XFILLER_107_80 VDD VSS DECAPHV8
XFILLER_66_1090 VDD VSS DECAPHV8
XFILLER_7_1135 VDD VSS FILLER1
X_11055_ _11056_/A _11056_/B _11056_/C VDD VSS _11055_/Y OAI21X1
X_18720_ _18801_/CK _18720_/D _18720_/Q VDD VSS DFFQX1
X_15932_ _18809_/Q _18701_/Q VDD VSS _15961_/B XNOR2X1
XFILLER_103_480 VSS VDD FILLER2
X_10006_ _17801_/Q _10006_/B VDD VSS _10009_/A NOR2BX1
XFILLER_114_1088 VDD VSS FILLER1
XFILLER_64_526 VSS VDD FILLER2
XFILLER_76_353 VDD VSS FILLER1
XFILLER_76_375 VDD VSS DECAPHV16
XFILLER_77_898 VSS VDD FILLER2
X_18651_ _18841_/CK _18651_/D _18651_/Q VDD VSS DFFQX1
X_15863_ _16196_/A _16155_/A VDD VSS _15867_/A _16023_/A NAND3X1
XFILLER_36_228 VDD VSS FILLER4
XFILLER_45_740 VDD VSS FILLER4
XFILLER_91_334 VDD VSS FILLER1
X_18582_ _18994_/CK _18582_/D _18582_/Q VDD VSS DFFQX1
X_17602_ _19028_/CK _17602_/D _17602_/Q VDD VSS DFFQX1
X_15794_ _15995_/A VDD VSS _16926_/A BUFX3
X_14814_ _14812_/B _14814_/B VDD VSS _14815_/C NOR2BX1
XFILLER_17_464 VDD VSS FILLER1
XFILLER_33_902 VDD VSS FILLER4
XFILLER_45_762 VDD VSS FILLER4
X_11957_ _11957_/A _14081_/B _11957_/C _11957_/D VDD VSS _12052_/A AOAI211X1
X_17533_ _17533_/A _17533_/B _17533_/C VDD VSS _17730_/D NOR3X1
X_14745_ _14747_/C _14745_/B _14745_/C VDD VSS _18566_/D AOI21X1
XFILLER_18_998 VDD VSS FILLER1
XFILLER_32_401 VDD VSS FILLER1
XTAP_TAPCELL_ROW_34_429 VDD VSS WELLTAP
X_10908_ _10911_/A _10911_/B VDD VSS _11048_/B XNOR2X1
X_17464_ _17498_/A _17464_/B VDD VSS _17670_/D AND2X1
XFILLER_20_607 VSS VDD FILLER2
X_11888_ _18254_/Q _12122_/D _11888_/C VDD VSS _12013_/C XNOR3X1
X_16415_ _16604_/A _16415_/B _16415_/C VDD VSS _16415_/Y AOI21X1
X_14676_ _14678_/B _14676_/B VDD VSS _14684_/B NAND2BX1
X_10839_ _10844_/A _10976_/B VDD VSS _17954_/D NOR2X1
X_17395_ _17395_/A _17395_/B VDD VSS _17605_/D NOR2X1
X_13627_ _13628_/A _13628_/B _13628_/D _13628_/C VDD VSS _14247_/A OA211X2
XFILLER_34_1067 VSS VDD FILLER2
XFILLER_41_990 VDD VSS FILLER1
XFILLER_73_1094 VSS VDD FILLER2
XTAP_TAPCELL_ROW_14_186 VDD VSS WELLTAP
X_16346_ _16926_/A _16346_/B VDD VSS _16347_/D NOR2X1
X_13558_ _13558_/A _14306_/B _13558_/C _13558_/D VDD VSS _13705_/A OAOI211X2
X_12509_ _12509_/A _12509_/B _12509_/C _12509_/D VDD VSS _12844_/A AOAI211X1
X_16277_ _18845_/Q _18683_/Q VDD VSS _16284_/B XOR2X1
XFILLER_69_1119 VDD VSS DECAPHV16
X_18016_ _18016_/CK _18016_/D _18016_/Q VDD VSS DFFQX1
X_15228_ _15281_/A _18797_/Q VDD VSS _18770_/D AND2X1
X_13489_ _18217_/Q _13489_/B _13491_/B VDD VSS _14186_/B MIN3X1
XFILLER_126_550 VDD VSS FILLER1
XFILLER_99_434 VSS VDD FILLER2
X_15159_ _15272_/A _18729_/Q VDD VSS _18702_/D AND2X1
XFILLER_87_618 VDD VSS FILLER1
XTAP_TAPCELL_ROW_113_1369 VDD VSS WELLTAP
XFILLER_113_288 VDD VSS FILLER1
X_09720_ _17754_/Q _09720_/B _09720_/C VDD VSS _09743_/C MIN3X1
X_18918_ _18989_/CK _18918_/D _18918_/Q VDD VSS DFFQX1
XFILLER_41_1016 VSS VDD FILLER2
XFILLER_80_1054 VDD VSS DECAPHV8
XFILLER_27_217 VSS VDD FILLER2
XFILLER_67_375 VDD VSS DECAPHV8
XFILLER_83_824 VDD VSS DECAPHV8
XFILLER_94_150 VDD VSS FILLER4
X_09651_ _09652_/A _09652_/B _09653_/B VDD VSS _09681_/B AOI21BX1
X_18849_ _18850_/CK _18849_/D _18849_/Q VDD VSS DFFQX1
XFILLER_94_194 VDD VSS DECAPHV8
X_09582_ _09606_/A _09606_/B VDD VSS _17482_/B XNOR2X1
XFILLER_24_902 VDD VSS FILLER4
XFILLER_36_762 VDD VSS DECAPHV16
XFILLER_35_250 VDD VSS FILLER1
XFILLER_24_979 VDD VSS FILLER4
XFILLER_50_231 VDD VSS FILLER1
XFILLER_52_1134 VSS VDD FILLER2
XFILLER_136_358 VSS VDD FILLER2
X_09016_ _09037_/C _09037_/B VDD VSS _09017_/B NAND2BX1
XFILLER_117_561 VDD VSS DECAPHV8
XFILLER_117_583 VSS VDD FILLER2
XTAP_TAPCELL_ROW_92_1122 VDD VSS WELLTAP
XFILLER_120_704 VDD VSS FILLER1
XFILLER_78_607 VDD VSS FILLER4
X_09918_ _09915_/A _09926_/C VDD VSS _09919_/D NOR2BX1
XFILLER_86_651 VDD VSS FILLER1
XFILLER_19_729 VDD VSS FILLER4
XFILLER_37_32 VDD VSS DECAPHV32
XFILLER_46_504 VDD VSS FILLER1
X_09849_ _17779_/Q _09851_/B VDD VSS _10042_/B XOR2X1
XFILLER_46_526 VSS VDD FILLER2
X_12860_ _18236_/Q _14178_/B _14178_/C VDD VSS _12866_/D OR3BX1
XFILLER_27_751 VSS VDD FILLER2
XFILLER_27_762 VSS VDD FILLER2
XFILLER_2_1043 VDD VSS DECAPHV16
XFILLER_37_98 VDD VSS FILLER1
XFILLER_61_507 VSS VDD FILLER2
XFILLER_73_345 VSS VDD FILLER2
XFILLER_73_378 VDD VSS DECAPHV8
X_11811_ _18357_/Q _11811_/B _11906_/C VDD VSS _12102_/C XNOR3X1
XFILLER_14_401 VSS VDD FILLER2
XFILLER_26_261 VDD VSS FILLER4
X_12791_ _18289_/Q _12960_/B _12960_/C VDD VSS _13010_/B XNOR3X1
X_14530_ _18521_/Q _18553_/Q VDD VSS _14534_/C XNOR2X1
XFILLER_109_1135 VDD VSS FILLER1
XFILLER_15_957 VSS VDD FILLER2
X_11742_ _11742_/A _11755_/D VDD VSS _14194_/B XNOR2X1
XFILLER_30_916 VDD VSS FILLER4
XFILLER_42_776 VDD VSS FILLER4
XFILLER_53_64 VDD VSS DECAPHV16
X_11673_ _14136_/B _14136_/C _18198_/Q VDD VSS _11675_/C AOI21X1
X_14461_ _15310_/A _14461_/B VDD VSS _18483_/D AND2X1
XFILLER_30_949 VDD VSS FILLER4
X_10624_ _17885_/Q _10624_/B VDD VSS _10628_/A NOR2BX1
X_17180_ _18993_/Q _17287_/B VDD VSS _17183_/A NAND2X1
X_16200_ _16200_/A _16200_/B VDD VSS _16219_/B XNOR2X1
X_14392_ _14394_/A _14392_/B _14392_/C VDD VSS _18420_/D NOR3X1
X_13412_ _13556_/A _13556_/B VDD VSS _14276_/B XNOR2X1
XFILLER_127_314 VDD VSS DECAPHV8
XFILLER_128_837 VDD VSS DECAPHV16
XTAP_TAPCELL_ROW_11_145 VDD VSS WELLTAP
X_16131_ _16158_/A _16158_/B _16158_/C _16161_/C VDD VSS _16136_/D AOAI211X1
X_13343_ _13343_/A _13343_/B VDD VSS _13344_/C XNOR2X1
XFILLER_10_695 VSS VDD FILLER2
XTAP_TAPCELL_ROW_11_156 VDD VSS WELLTAP
X_10555_ _17875_/Q _10555_/B _10555_/C VDD VSS _10560_/D XNOR3X1
X_10486_ _17867_/Q VDD VSS _10487_/A INVX1
X_13274_ _18370_/Q _14332_/B _14332_/C VDD VSS _13276_/D OR3BX1
X_16062_ _16062_/A VDD VSS _16934_/A BUFX3
XFILLER_5_176 VDD VSS DECAPHV8
X_12225_ _18231_/Q _12430_/A _12430_/B VDD VSS _12227_/C XNOR3X1
X_15013_ _15016_/C _15014_/B _17554_/C VDD VSS _15014_/C OAI21X1
XFILLER_69_607 VDD VSS DECAPHV16
X_12156_ _12161_/A _12161_/B _12157_/D _12161_/C VDD VSS _14057_/A OA211X2
X_11107_ _17979_/Q VDD VSS _11108_/A INVX1
XFILLER_49_320 VDD VSS FILLER4
XFILLER_77_640 VDD VSS FILLER4
X_12087_ _18386_/Q _12201_/B _14353_/B VDD VSS _12106_/C XOR3X1
X_16964_ _16960_/A _16964_/B _16964_/C VDD VSS _16969_/C AOI2B1X1
XTAP_TAPCELL_ROW_67_819 VDD VSS WELLTAP
X_11038_ _11038_/A _11038_/B VDD VSS _11039_/C NAND2X1
X_18703_ _18840_/CK _18703_/D _18703_/Q VDD VSS DFFQX1
X_16895_ _16895_/A _16895_/B _16895_/C VDD VSS _16897_/C NOR3X1
X_15915_ _15972_/A _15972_/B _16316_/A VDD VSS _15916_/C AOI21X1
XFILLER_64_312 VDD VSS FILLER4
X_18634_ clkload1/A _18634_/D _18634_/Q VDD VSS DFFQX1
X_15846_ _16316_/A _15975_/B _15846_/C VDD VSS _15858_/B NOR3X1
XTAP_TAPCELL_ROW_19_245 VDD VSS WELLTAP
XFILLER_33_710 VDD VSS FILLER1
XTAP_TAPCELL_ROW_47_587 VDD VSS WELLTAP
X_12989_ _13191_/A _13191_/B _13191_/C VDD VSS _13122_/B AOI21X1
X_18565_ clkload2/A _18565_/D _18565_/Q VDD VSS DFFQX1
X_15777_ _18805_/Q _18697_/Q VDD VSS _15778_/C XOR2X1
XFILLER_32_231 VDD VSS FILLER1
X_18496_ _18496_/CK _18496_/D _18496_/Q VDD VSS DFFQX1
X_17516_ _17518_/A _17516_/B VDD VSS _17718_/D NOR2X1
X_14728_ _18594_/Q VDD VSS _14878_/A INVX1
X_17447_ _17501_/A VDD VSS _17463_/A BUFX3
X_14659_ _18548_/Q _18580_/Q _14659_/C VDD VSS _14663_/B AOI21X1
XFILLER_20_426 VDD VSS DECAPHV8
XFILLER_20_448 VDD VSS FILLER1
XFILLER_32_286 VDD VSS FILLER1
X_17378_ _17378_/A _17378_/B VDD VSS _17589_/D NOR2X1
XFILLER_119_848 VDD VSS FILLER4
XFILLER_64_0 VDD VSS DECAPHV32
X_16329_ _18818_/Q _18710_/Q VDD VSS _16333_/B NAND2X1
X_19048_ _19051_/CK _19048_/D _19048_/Q VDD VSS DFFQX1
XFILLER_99_220 VDD VSS FILLER1
XFILLER_114_564 VDD VSS FILLER1
XFILLER_82_1105 VDD VSS DECAPHV8
XFILLER_99_242 VDD VSS DECAPHV8
XFILLER_101_203 VDD VSS FILLER1
XFILLER_102_737 VDD VSS DECAPHV16
XFILLER_87_415 VDD VSS FILLER1
X_09703_ _17594_/Q _17384_/B VDD VSS _09712_/C XOR2X1
XFILLER_56_846 VDD VSS DECAPHV8
XTAP_TAPCELL_ROW_126_1527 VDD VSS WELLTAP
X_09634_ _17752_/Q _17720_/Q VDD VSS _09637_/A XNOR2X1
XFILLER_56_879 VDD VSS FILLER4
XFILLER_71_816 VDD VSS FILLER1
XFILLER_82_142 VDD VSS DECAPHV8
XFILLER_83_654 VDD VSS DECAPHV8
XFILLER_24_710 VDD VSS DECAPHV16
X_09565_ _17621_/Q _17413_/B VDD VSS _09577_/B XOR2X1
X_09496_ _17618_/Q _17409_/B VDD VSS _09514_/A NOR2X1
XFILLER_11_437 VDD VSS FILLER1
XFILLER_12_949 VSS VDD FILLER2
XFILLER_104_1010 VDD VSS FILLER1
XFILLER_23_78 VDD VSS FILLER1
XFILLER_136_133 VSS VDD FILLER2
XFILLER_17_1095 VDD VSS FILLER1
XFILLER_104_1076 VDD VSS DECAPHV8
XFILLER_125_818 VSS VDD FILLER2
X_10340_ _10541_/A _10524_/C VDD VSS _10532_/B XNOR2X1
XFILLER_2_113 VDD VSS DECAPHV16
XFILLER_3_625 VDD VSS DECAPHV16
X_10271_ _17837_/Q _10277_/B VDD VSS _10282_/C NOR2X1
XFILLER_117_391 VDD VSS DECAPHV8
XFILLER_133_840 VDD VSS FILLER1
X_12010_ _12010_/A _12080_/D VDD VSS _14258_/B XNOR2X1
XFILLER_132_372 VSS VDD FILLER2
XFILLER_24_1011 VDD VSS FILLER4
XFILLER_78_448 VSS VDD FILLER2
XFILLER_59_662 VSS VDD FILLER2
X_13961_ _13999_/A _13961_/B _14011_/A _17533_/A VDD VSS _18062_/D OAOI211X1
XFILLER_87_993 VSS VDD FILLER2
XFILLER_98_1134 VSS VDD FILLER2
X_12912_ _13137_/A _13137_/B VDD VSS _14420_/B XNOR2X1
X_16680_ _18856_/Q _18694_/Q VDD VSS _16682_/A XOR2X1
X_15700_ _18886_/Q VDD VSS _15707_/A INVX1
XFILLER_104_81 VDD VSS DECAPHV32
XFILLER_111_1069 VSS VDD FILLER2
XFILLER_24_1099 VDD VSS FILLER4
XFILLER_73_120 VDD VSS FILLER1
X_13892_ _13892_/A _13892_/B _13892_/C VDD VSS _14463_/C OAI21X1
XFILLER_34_518 VSS VDD FILLER2
XFILLER_62_838 VDD VSS FILLER4
XFILLER_73_175 VDD VSS FILLER4
X_12843_ _12843_/A _14328_/B _12843_/C _12843_/D VDD VSS _13056_/A OAOI211X1
X_15631_ _18929_/Q _15631_/B VDD VSS _15648_/B XOR2X1
XTAP_TAPCELL_ROW_16_215 VDD VSS WELLTAP
XTAP_TAPCELL_ROW_44_546 VDD VSS WELLTAP
X_12774_ _12781_/A _12781_/B VDD VSS _14093_/B _12781_/C NAND3X1
X_18350_ _18431_/CK _18350_/D _18350_/Q VDD VSS DFFQX1
X_15562_ _15567_/A _15566_/A VDD VSS _15564_/A XNOR2X1
XFILLER_15_765 VDD VSS FILLER1
XFILLER_30_702 VDD VSS FILLER1
XFILLER_42_573 VDD VSS FILLER1
XFILLER_70_882 VDD VSS FILLER1
XTAP_TAPCELL_ROW_72_877 VDD VSS WELLTAP
XTAP_TAPCELL_ROW_72_888 VDD VSS WELLTAP
X_11725_ _18381_/Q VDD VSS _11728_/A INVX1
X_18281_ _18358_/CK _18281_/D _18281_/Q VDD VSS DFFQX1
X_17301_ _19015_/Q _19016_/Q _17316_/B VDD VSS _17302_/C OAI21X1
X_15493_ _18869_/Q _15668_/B VDD VSS _15494_/C NAND2X1
X_14513_ _14511_/B _14513_/B VDD VSS _14514_/C NOR2BX1
XFILLER_15_798 VDD VSS DECAPHV8
XFILLER_70_1020 VDD VSS FILLER1
XFILLER_80_40 VDD VSS FILLER4
X_17232_ _19003_/Q _17232_/B VDD VSS _17238_/C NOR2BX1
X_14444_ _14451_/A _14444_/B VDD VSS _18467_/D NOR2X1
XFILLER_128_623 VDD VSS FILLER4
X_11656_ _11661_/A _11661_/B _11656_/C VDD VSS _14313_/B XNOR3X1
Xfanout90 hold95/Y VDD VSS hold96/A BUFX3
XFILLER_11_993 VDD VSS FILLER1
XFILLER_7_920 VDD VSS DECAPHV8
X_10607_ _10630_/A _10743_/B VDD VSS _17908_/D NOR2X1
X_11587_ _18353_/Q _14312_/B VDD VSS _11588_/B OR2X2
X_17163_ _18990_/Q _17226_/C _17163_/C VDD VSS _17168_/C AOI21X1
X_14375_ _17392_/A _14375_/B VDD VSS _18405_/D AND2X1
XFILLER_116_818 VDD VSS FILLER4
X_10538_ _10922_/A VDD VSS _10630_/A BUFX3
X_17094_ _17095_/A _17095_/B _17095_/C VDD VSS _17094_/Y NOR3X1
X_16114_ _18901_/Q _16114_/B VDD VSS _16119_/C NOR2X1
X_13326_ _18424_/Q _13457_/A _13532_/B VDD VSS _13444_/D XNOR3X1
XFILLER_6_485 VDD VSS DECAPHV16
XFILLER_7_997 VDD VSS DECAPHV16
X_13257_ _13257_/A _13257_/B _13257_/C VDD VSS _13261_/B OAI21X1
X_16045_ _16096_/A _16045_/B _16045_/C VDD VSS _16105_/C OAI21X1
X_10469_ _11062_/A _10651_/B VDD VSS _17890_/D AND2X1
X_12208_ _12375_/A _12375_/B _12375_/C VDD VSS _12374_/A OA21X2
XFILLER_111_501 VDD VSS FILLER1
XFILLER_97_724 VDD VSS FILLER4
XFILLER_97_735 VSS VDD FILLER2
X_13188_ _13294_/A _13294_/B VDD VSS _14241_/C _13294_/C NAND3X1
XFILLER_42_1100 VSS VDD FILLER2
XFILLER_69_459 VDD VSS FILLER4
XTAP_TAPCELL_ROW_110_1339 VDD VSS WELLTAP
X_12139_ _12139_/A _12139_/B _12139_/C _12139_/D VDD VSS _14143_/B OAOI211X2
X_17996_ _18016_/CK _17996_/D _17996_/Q VDD VSS DFFQX1
XFILLER_78_971 VDD VSS FILLER1
XFILLER_96_256 VDD VSS DECAPHV8
X_16947_ _16947_/A _16947_/B _16947_/C VDD VSS _16950_/B OAI21X1
XFILLER_49_183 VSS VDD FILLER2
XFILLER_65_621 VDD VSS FILLER1
XFILLER_49_194 VDD VSS DECAPHV8
XFILLER_64_142 VDD VSS FILLER4
X_16878_ _16868_/B _16878_/B VDD VSS _16889_/B NOR2BX1
X_18617_ clkload8/A _18617_/D _18617_/Q VDD VSS DFFQX1
X_15829_ _15829_/A _15829_/B VDD VSS _15834_/C NOR2X1
X_09350_ _09354_/A _09354_/B VDD VSS _17336_/B XNOR2X1
X_18548_ _18990_/CK _18548_/D _18548_/Q VDD VSS DFFQX1
X_09281_ _09281_/A _09281_/B _09281_/C _09281_/D VDD VSS _09288_/A AOAI211X1
XFILLER_20_201 VDD VSS FILLER4
XTAP_TAPCELL_ROW_121_1468 VDD VSS WELLTAP
X_18479_ _18480_/CK _18479_/D _18479_/Q VDD VSS DFFQX1
XFILLER_20_289 VSS VDD FILLER2
XFILLER_119_678 VDD VSS FILLER1
XFILLER_9_290 VDD VSS FILLER4
Xclkload71 _18417_/CK VDD VSS clkload71/Y INVX2
Xclkload60 _18478_/CK VDD VSS clkload60/Y INVX4
XFILLER_115_862 VDD VSS DECAPHV8
XFILLER_47_1000 VDD VSS DECAPHV8
XFILLER_47_1022 VDD VSS FILLER1
Xclkload93 _17706_/CK VDD VSS clkload93/Y INVX1
Xclkload82 _19045_/CK VDD VSS clkload82/Y INVX1
XFILLER_0_628 VSS VDD FILLER2
XFILLER_114_361 VDD VSS FILLER1
XFILLER_86_1082 VSS VDD FILLER2
XFILLER_87_212 VDD VSS FILLER1
XFILLER_47_1099 VSS VDD FILLER2
XFILLER_87_234 VDD VSS FILLER1
XTAP_TAPCELL_ROW_132_1597 VDD VSS WELLTAP
X_08996_ _08996_/A _09009_/B VDD VSS _17458_/B XOR2X1
XFILLER_102_567 VDD VSS DECAPHV8
XFILLER_87_278 VDD VSS FILLER1
XFILLER_28_312 VDD VSS FILLER1
XFILLER_29_835 VSS VDD FILLER2
XFILLER_87_289 VDD VSS DECAPHV16
XFILLER_84_963 VDD VSS FILLER4
XFILLER_28_389 VDD VSS DECAPHV16
XTAP_TAPCELL_ROW_87_1065 VDD VSS WELLTAP
X_09617_ _09631_/B _09617_/B VDD VSS _17380_/B XNOR2X1
XFILLER_93_1020 VSS VDD FILLER2
X_09548_ _09548_/A _09548_/B VDD VSS _09573_/A NAND2X1
XFILLER_19_1135 VDD VSS FILLER1
XFILLER_34_44 VSS VDD FILLER2
XFILLER_93_1064 VDD VSS DECAPHV8
XTAP_TAPCELL_ROW_41_505 VDD VSS WELLTAP
XTAP_TAPCELL_ROW_41_516 VDD VSS WELLTAP
X_09479_ _17745_/Q _09479_/B _09479_/C VDD VSS _09502_/B MIN3X1
X_11510_ _11544_/A _11544_/B _11544_/C VDD VSS _11752_/B OAI21X1
X_12490_ _12490_/A _12490_/B _14386_/B VDD VSS _12491_/B MIN3X1
XFILLER_11_278 VDD VSS FILLER1
XFILLER_50_32 VDD VSS DECAPHV8
X_11441_ _11488_/A _14075_/B _11478_/C VDD VSS _14076_/B AOI21BX1
XTAP_TAPCELL_ROW_21_273 VDD VSS WELLTAP
X_11372_ _18247_/Q VDD VSS _11473_/A INVX1
X_14160_ _14160_/A _14160_/B VDD VSS _18220_/D NOR2X1
XTAP_TAPCELL_ROW_98_1194 VDD VSS WELLTAP
X_10323_ _17844_/Q VDD VSS _10333_/A INVX1
X_13111_ _18136_/Q _14068_/B VDD VSS _13223_/A XNOR2X1
XFILLER_30_1092 VDD VSS DECAPHV8
X_14091_ _14129_/A _14091_/B VDD VSS _18156_/D NOR2X1
XFILLER_26_1106 VDD VSS FILLER1
XFILLER_3_455 VDD VSS DECAPHV8
X_10254_ _10254_/A _10257_/B VDD VSS _10444_/B XOR2X1
X_13042_ _18421_/Q _14393_/B VDD VSS _13258_/A NAND2X1
XFILLER_105_383 VSS VDD FILLER2
XFILLER_120_320 VDD VSS FILLER1
X_10185_ _17824_/Q _10185_/B _10185_/C VDD VSS _10376_/C XNOR3X1
X_17850_ _17932_/CK _17850_/D _17850_/Q VDD VSS DFFQX1
XFILLER_59_96 VDD VSS DECAPHV8
XTAP_TAPCELL_ROW_49_605 VDD VSS WELLTAP
X_16801_ _16819_/A _16957_/B VDD VSS _16819_/C NAND2X1
XFILLER_115_80 VDD VSS DECAPHV8
XFILLER_120_375 VSS VDD FILLER2
XFILLER_75_941 VSS VDD FILLER2
XTAP_TAPCELL_ROW_77_947 VDD VSS WELLTAP
X_17781_ _19051_/CK _17781_/D _17781_/Q VDD VSS DFFQX1
X_14993_ _18620_/Q _18998_/Q VDD VSS _14994_/B XNOR2X1
XFILLER_19_345 VDD VSS DECAPHV8
XFILLER_46_142 VDD VSS FILLER1
XFILLER_47_654 VDD VSS DECAPHV8
XFILLER_74_440 VDD VSS FILLER4
X_16732_ _16784_/A _18776_/Q _16732_/C _16732_/D VDD VSS _16732_/Y AO211X2
X_13944_ _18948_/Q _18949_/Q VDD VSS _13991_/B _13988_/B NAND3X1
XFILLER_19_367 VDD VSS FILLER4
XFILLER_34_315 VDD VSS FILLER4
XFILLER_75_985 VDD VSS FILLER1
XTAP_TAPCELL_ROW_29_362 VDD VSS WELLTAP
X_16663_ _16784_/A _18774_/Q _16757_/A _16663_/D VDD VSS _16664_/D AOI22X1
X_13875_ _13876_/A _13876_/C _13876_/B VDD VSS _14405_/A OA21X2
XFILLER_61_112 VSS VDD FILLER2
X_12826_ _18393_/Q _13021_/A _13021_/B VDD VSS _12926_/B XNOR3X1
X_18402_ _18431_/CK _18402_/D _18402_/Q VDD VSS DFFQX1
X_15614_ _15695_/A _15614_/B _15614_/C VDD VSS _15621_/B OAI21X1
X_18333_ _18358_/CK _18333_/D _18333_/Q VDD VSS DFFQX1
X_16594_ _16630_/A _16594_/B _16594_/C VDD VSS _16594_/Y AOI21X1
XFILLER_15_584 VDD VSS FILLER1
XFILLER_15_595 VSS VDD FILLER2
XFILLER_43_882 VSS VDD FILLER2
XFILLER_61_189 VDD VSS FILLER1
X_12757_ _18183_/Q _14119_/B _14119_/C VDD VSS _12763_/D OR3BX1
X_15545_ _15528_/Y _15543_/Y _15648_/A VDD VSS _15545_/Y MUX2X1
X_11708_ _18122_/Q _11954_/A _11787_/B VDD VSS _11847_/D XNOR3X1
X_12688_ _18314_/Q _12688_/B _12741_/C VDD VSS _13009_/B XNOR3X1
X_18264_ _18292_/CK _18264_/D _18264_/Q VDD VSS DFFQX1
X_15476_ _15483_/A VDD VSS _15686_/A BUFX3
X_11639_ _18121_/Q _11779_/B _11779_/C VDD VSS _11847_/B XNOR3X1
X_18195_ _18195_/CK _18195_/D _18195_/Q VDD VSS DFFQX1
X_17215_ _18999_/Q _19000_/Q _17226_/C VDD VSS _17216_/C OAI21X1
X_14427_ _14361_/Y _14427_/B _14427_/C VDD VSS _18453_/D AND3BX1
X_17146_ _17147_/B _18024_/Q VDD VSS _17152_/B NAND2BX1
X_14358_ _14378_/A _14358_/B VDD VSS _18391_/D NOR2X1
X_13309_ _18216_/Q VDD VSS _13407_/C INVX1
X_17077_ _18011_/Q _17082_/B VDD VSS _17078_/B XNOR2X1
X_14289_ _15300_/A _14289_/B VDD VSS _18332_/D AND2X1
X_16028_ _18899_/Q _16034_/B VDD VSS _16030_/C XNOR2X1
XFILLER_112_832 VDD VSS FILLER1
XFILLER_27_0 VDD VSS DECAPHV32
XFILLER_57_418 VDD VSS FILLER1
XFILLER_69_267 VDD VSS DECAPHV8
XFILLER_85_727 VSS VDD FILLER2
XFILLER_111_375 VDD VSS DECAPHV8
XFILLER_38_621 VDD VSS DECAPHV32
X_17979_ _17982_/CK _17979_/D _17979_/Q VDD VSS DFFQX1
XFILLER_1_92 VDD VSS FILLER1
XFILLER_81_933 VDD VSS DECAPHV8
XFILLER_93_771 VDD VSS FILLER1
XFILLER_26_849 VDD VSS DECAPHV8
XFILLER_80_421 VDD VSS DECAPHV8
X_09402_ _09402_/A _09416_/B VDD VSS _17372_/B XOR2X1
XFILLER_81_988 VDD VSS FILLER4
X_09333_ _17644_/Q _17437_/B VDD VSS _09345_/A NAND2BX1
XFILLER_33_381 VDD VSS FILLER1
XFILLER_34_893 VDD VSS DECAPHV8
XFILLER_40_318 VDD VSS FILLER1
XFILLER_21_565 VSS VDD FILLER2
X_09264_ _09264_/A _09264_/B _09264_/C VDD VSS _17367_/C NOR3X1
XFILLER_53_1070 VDD VSS DECAPHV8
X_09195_ _19031_/Q VDD VSS _09219_/A INVX1
XFILLER_119_442 VDD VSS FILLER4
XFILLER_135_902 VDD VSS DECAPHV16
XFILLER_14_1054 VDD VSS FILLER4
XFILLER_134_423 VDD VSS FILLER1
XFILLER_88_1133 VSS VDD FILLER2
XTAP_TAPCELL_ROW_134_1626 VDD VSS WELLTAP
XFILLER_0_403 VSS VDD FILLER2
XFILLER_122_607 VDD VSS DECAPHV32
XFILLER_1_904 VDD VSS DECAPHV16
XFILLER_20_79 VDD VSS FILLER1
XFILLER_88_510 VDD VSS FILLER1
XFILLER_121_128 VDD VSS DECAPHV32
X_08979_ _17521_/B _14645_/A _08979_/C VDD VSS _08982_/C MIN3X1
XFILLER_28_131 VDD VSS FILLER1
XFILLER_57_952 VDD VSS FILLER1
XTAP_TAPCELL_ROW_74_906 VDD VSS WELLTAP
X_11990_ _11991_/B _11990_/B _11990_/C VDD VSS _18033_/D AOI21X1
XFILLER_1_1119 VDD VSS DECAPHV16
XFILLER_28_142 VDD VSS DECAPHV16
XFILLER_57_985 VDD VSS DECAPHV8
XFILLER_90_229 VSS VDD FILLER2
X_10941_ _17043_/A _11077_/B VDD VSS _17973_/D AND2X1
XFILLER_45_32 VDD VSS DECAPHV32
XFILLER_72_955 VDD VSS FILLER4
X_13660_ _13660_/A _13660_/B _13660_/C _13660_/D VDD VSS _13774_/A OAOI211X1
XTAP_TAPCELL_ROW_26_332 VDD VSS WELLTAP
XTAP_TAPCELL_ROW_54_663 VDD VSS WELLTAP
X_10872_ _10874_/A _10872_/B VDD VSS _11008_/B XNOR2X1
X_12611_ _12611_/A _14325_/B _12611_/C _12611_/D VDD VSS _12796_/A OAOI211X1
XFILLER_24_370 VDD VSS DECAPHV8
XFILLER_40_830 VDD VSS FILLER4
XFILLER_43_189 VDD VSS FILLER1
X_13591_ _13591_/A _13591_/B _13591_/C _13591_/D VDD VSS _13738_/A AOAI211X1
XFILLER_24_392 VDD VSS FILLER4
X_12542_ _18155_/Q _12542_/B _12542_/C VDD VSS _12550_/A XNOR3X1
X_15330_ _15337_/B wire30/A _15760_/A VDD VSS _18860_/D MUX2X1
XFILLER_12_565 VDD VSS FILLER1
XFILLER_131_0 VDD VSS DECAPHV32
XFILLER_40_874 VDD VSS FILLER1
XFILLER_61_64 VDD VSS DECAPHV16
XFILLER_8_514 VDD VSS DECAPHV32
X_12473_ _18390_/Q _12601_/B _14357_/B VDD VSS _12491_/C XNOR3X1
X_15261_ _15318_/A _18829_/Q VDD VSS _18802_/D AND2X1
XFILLER_126_902 VDD VSS FILLER4
X_11424_ _18247_/Q _11424_/B _11424_/C VDD VSS _11530_/B MIN3X1
X_17000_ _17000_/A _17006_/B _17000_/C VDD VSS _18950_/D OAI21X1
X_14212_ _14217_/A _14212_/B VDD VSS _18268_/D NOR2X1
XANTENNA_8 _17533_/A VDD VSS ANTENNA2
X_15192_ _15250_/A _18761_/Q VDD VSS _18734_/D AND2X1
XFILLER_126_979 VDD VSS FILLER1
XFILLER_99_808 VSS VDD FILLER2
X_11355_ _11428_/A _11428_/B VDD VSS _11366_/B NOR2X1
X_14143_ _14143_/A _14143_/B _14143_/C VDD VSS _14144_/C NOR3X1
XFILLER_106_670 VDD VSS FILLER1
XFILLER_4_764 VDD VSS DECAPHV16
X_10306_ _10306_/A _10322_/B _10322_/C VDD VSS _10503_/B XNOR3X1
X_11286_ _11316_/A _11316_/B _11316_/C VDD VSS _11353_/B OAI21X1
X_18951_ _18951_/CK _18951_/D _18951_/Q VDD VSS DFFQX1
X_14074_ _14361_/A VDD VSS _14074_/Y BUFX3
X_10237_ _10237_/A _10237_/B VDD VSS _10423_/B XNOR2X1
X_13025_ _18420_/Q _14392_/B _14392_/C VDD VSS _13137_/C OR3BX1
X_17902_ _17932_/CK _17902_/D _17902_/Q VDD VSS DFFQX1
XFILLER_105_191 VDD VSS FILLER1
X_18882_ _18951_/CK _18882_/D _18882_/Q VDD VSS DFFQX1
XFILLER_48_930 VDD VSS DECAPHV32
XFILLER_66_204 VSS VDD FILLER2
X_10168_ _10356_/A _10356_/B VDD VSS _10359_/B XNOR2X1
X_17833_ _17854_/CK _17833_/D _17833_/Q VDD VSS DFFQX1
XFILLER_94_568 VDD VSS DECAPHV16
XTAP_TAPCELL_ROW_109_1330 VDD VSS WELLTAP
X_10099_ _10099_/A _10099_/B _10099_/C VDD VSS _10100_/B AOI21X1
X_17764_ _19033_/CK _17764_/D _17764_/Q VDD VSS DFFQX1
X_14976_ _17182_/D _14983_/B VDD VSS _14977_/C NAND2X1
XFILLER_19_153 VDD VSS FILLER4
XFILLER_47_451 VSS VDD FILLER2
XFILLER_47_462 VSS VDD FILLER2
XFILLER_48_974 VSS VDD FILLER2
XFILLER_48_985 VDD VSS FILLER1
XFILLER_63_922 VSS VDD FILLER2
X_16715_ _16715_/A _16715_/B _16715_/C _16715_/D VDD VSS _16726_/C OA211X2
X_13927_ _14500_/A _14500_/B _18513_/Q VDD VSS _13935_/B OAI21X1
XFILLER_19_197 VSS VDD FILLER2
XFILLER_34_112 VDD VSS DECAPHV8
X_17695_ _17698_/CK _17695_/D _17695_/Q VDD VSS DFFQX1
XFILLER_63_977 VDD VSS FILLER1
X_16646_ _18800_/Q _18746_/Q _16646_/C VDD VSS _16693_/C AO21X2
X_13858_ _13887_/A _14496_/B _13887_/C VDD VSS _14497_/C NOR3X1
XFILLER_15_370 VSS VDD FILLER2
XFILLER_16_882 VDD VSS FILLER1
XFILLER_37_1032 VDD VSS FILLER1
XFILLER_62_487 VSS VDD FILLER2
X_12809_ _18472_/Q VDD VSS _13037_/A INVX1
X_16577_ _18054_/Q _18664_/Q VDD VSS _16578_/B XOR2X1
X_13789_ _18482_/Q _14460_/B VDD VSS _13814_/C _14460_/C NAND3X1
XFILLER_124_1024 VSS VDD FILLER2
X_18316_ _18368_/CK _18316_/D _18316_/Q VDD VSS DFFQX1
X_15528_ _18922_/Q _15556_/C VDD VSS _15528_/Y XNOR2X1
XFILLER_31_874 VDD VSS FILLER1
XTAP_TAPCELL_ROW_6_91 VDD VSS WELLTAP
X_18247_ _18247_/CK _18247_/D _18247_/Q VDD VSS DFFQX1
XFILLER_129_762 VDD VSS DECAPHV8
X_15459_ _15430_/Y _15458_/Y _16657_/D VDD VSS _15460_/B MUX2X1
X_18178_ _18200_/CK _18178_/D _18178_/Q VDD VSS DFFQX1
XFILLER_116_445 VDD VSS FILLER4
XFILLER_116_456 VDD VSS FILLER1
XFILLER_117_979 VDD VSS FILLER4
X_17129_ _18020_/Q _17129_/B VDD VSS _17132_/A NOR2BX1
XFILLER_104_607 VDD VSS DECAPHV8
XFILLER_116_478 VDD VSS DECAPHV8
XFILLER_132_916 VSS VDD FILLER2
X_09951_ _10157_/A _10150_/C VDD VSS _10160_/B XOR2X1
XFILLER_103_128 VDD VSS DECAPHV8
XFILLER_131_437 VDD VSS FILLER4
XFILLER_131_448 VDD VSS DECAPHV8
X_08902_ _17732_/Q _18521_/Q _17537_/B VDD VSS _17540_/A AO21X2
XFILLER_106_49 VDD VSS DECAPHV32
XFILLER_83_1074 VDD VSS FILLER1
X_09882_ _17788_/Q _09896_/B VDD VSS _09888_/C XNOR2X1
XFILLER_85_513 VDD VSS FILLER4
XFILLER_85_524 VDD VSS DECAPHV16
XFILLER_100_857 VSS VDD FILLER2
XFILLER_26_602 VSS VDD FILLER2
XFILLER_54_911 VDD VSS FILLER1
XFILLER_81_730 VDD VSS FILLER1
XFILLER_93_590 VSS VDD FILLER2
XTAP_TAPCELL_ROW_84_1024 VDD VSS WELLTAP
Xclkbuf_2_3__f__002_ clkbuf_0__002_/Y VDD VSS clkload27/A BUFX12
XFILLER_13_307 VSS VDD FILLER2
XFILLER_40_104 VSS VDD FILLER2
XFILLER_41_649 VSS VDD FILLER2
XFILLER_80_273 VSS VDD FILLER2
XTAP_TAPCELL_ROW_51_633 VDD VSS WELLTAP
X_09316_ _09316_/A _09316_/B _09316_/C VDD VSS _09317_/B NOR3X1
X_09247_ _17609_/Q _17400_/B VDD VSS _09264_/A NOR2X1
XFILLER_135_710 VDD VSS FILLER1
XTAP_TAPCELL_ROW_31_390 VDD VSS WELLTAP
X_09178_ _09203_/A _09203_/B VDD VSS _09184_/A NAND2X1
XFILLER_108_979 VDD VSS DECAPHV8
XTAP_TAPCELL_ROW_2_38 VDD VSS WELLTAP
XTAP_TAPCELL_ROW_95_1153 VDD VSS WELLTAP
XTAP_TAPCELL_ROW_95_1164 VDD VSS WELLTAP
X_11140_ _11141_/A _11141_/B _11141_/D _11141_/C VDD VSS _11150_/B AOAI211X1
Xoutput12 _18080_/Q VDD VSS data_out[18] BUFX3
Xoutput23 _18070_/Q VDD VSS data_out[8] BUFX3
XFILLER_1_734 VDD VSS DECAPHV8
XFILLER_89_830 VDD VSS FILLER4
X_11071_ _11135_/A _11206_/B VDD VSS _17998_/D NOR2X1
XFILLER_48_204 VSS VDD FILLER2
XTAP_TAPCELL_ROW_59_722 VDD VSS WELLTAP
X_10022_ _10222_/A _10222_/B _10223_/C _10022_/D VDD VSS _10227_/B AOAI211X1
XFILLER_48_259 VSS VDD FILLER2
XFILLER_76_557 VDD VSS DECAPHV8
X_14830_ _18584_/Q _18616_/Q VDD VSS _14835_/A NAND2X1
XFILLER_91_505 VSS VDD FILLER2
XFILLER_44_421 VDD VSS FILLER4
XFILLER_45_933 VDD VSS FILLER1
XFILLER_56_97 VDD VSS DECAPHV8
XFILLER_57_793 VDD VSS FILLER1
X_11973_ _18177_/Q _11973_/B _12063_/C VDD VSS _12035_/B XNOR3X1
X_16500_ _16537_/A _18770_/Q VDD VSS _16501_/C NAND2X1
X_14761_ _18569_/Q _18601_/Q _14761_/C VDD VSS _14769_/A MIN3X1
XFILLER_16_134 VDD VSS FILLER4
XFILLER_45_966 VDD VSS FILLER4
XFILLER_72_752 VDD VSS FILLER1
XTAP_TAPCELL_ROW_39_490 VDD VSS WELLTAP
X_10924_ _10924_/A _10924_/B _10924_/C VDD VSS _10928_/C OAI21X1
X_17480_ _17501_/A VDD VSS _17499_/A BUFX3
X_14692_ _18555_/Q _18587_/Q VDD VSS _14693_/C NAND2X1
X_13712_ _18481_/Q _13718_/B _13784_/D VDD VSS _13777_/C XNOR3X1
XFILLER_112_81 VDD VSS DECAPHV32
X_10855_ _10855_/A _10858_/C VDD VSS _10990_/B XNOR2X1
X_16431_ _18822_/Q _18714_/Q VDD VSS _16463_/A XNOR2X1
X_13643_ _18401_/Q _13643_/B VDD VSS _13673_/C _13643_/C NAND3X1
XFILLER_13_830 VDD VSS FILLER1
XTAP_TAPCELL_ROW_104_1271 VDD VSS WELLTAP
X_16362_ _18792_/Q _18738_/Q VDD VSS _16396_/A NAND2X1
X_13574_ _18401_/Q _13574_/B _13675_/C VDD VSS _13603_/B XNOR3X1
XFILLER_9_812 VDD VSS FILLER4
X_10786_ _17917_/Q _10791_/A VDD VSS _10789_/A XNOR2X1
X_12525_ _12525_/A _12525_/B _12525_/C _12525_/D VDD VSS _12742_/A AOAI211X1
X_18101_ _18978_/CK _18101_/D _18101_/Q VDD VSS DFFQX1
X_15313_ _15313_/A _18053_/Q VDD VSS _18852_/D AND2X1
XFILLER_12_395 VDD VSS FILLER4
XFILLER_8_322 VSS VDD FILLER2
XFILLER_9_856 VDD VSS DECAPHV8
X_16293_ _16293_/A _16293_/B _16293_/C _16293_/D VDD VSS _16321_/A OAI31X1
X_12456_ _18130_/Q VDD VSS _12679_/C INVX1
X_18032_ _18547_/CK _18032_/D _18032_/Q VDD VSS DFFQX1
X_15244_ _15272_/A _18812_/Q VDD VSS _18785_/D AND2X1
X_11407_ _18169_/Q _11537_/A _11537_/B VDD VSS _11437_/D XNOR3X1
X_12387_ _18389_/Q _12489_/B _12489_/C VDD VSS _12404_/C XNOR3X1
X_15175_ _17079_/A _16570_/B VDD VSS _18717_/D NOR2X1
XFILLER_119_1115 VDD VSS FILLER1
XFILLER_125_253 VDD VSS DECAPHV16
XFILLER_99_605 VSS VDD FILLER2
X_11338_ _11420_/A _11420_/B _14131_/B VDD VSS _11378_/B MIN3X1
X_14126_ _14126_/A _14126_/B _15326_/C VDD VSS _18189_/D AOI21X1
XFILLER_113_437 VDD VSS FILLER4
XFILLER_4_594 VDD VSS DECAPHV8
XFILLER_79_351 VDD VSS DECAPHV8
X_11269_ _18191_/Q _14128_/B VDD VSS _11304_/B OR2X2
X_18934_ _18934_/CK _18934_/D _18934_/Q VDD VSS DFFQX1
X_14057_ _14057_/A _14057_/B _14107_/A VDD VSS _18126_/D OA21X2
XFILLER_122_993 VDD VSS FILLER4
XFILLER_95_822 VDD VSS FILLER1
X_13008_ _18317_/Q _13054_/B _13178_/C VDD VSS _13060_/A XNOR3X1
X_18865_ _18961_/CK _18865_/D _18865_/Q VDD VSS DFFQX1
XFILLER_39_248 VDD VSS FILLER1
XFILLER_67_546 VDD VSS DECAPHV8
XFILLER_95_844 VDD VSS DECAPHV16
XFILLER_95_866 VDD VSS FILLER1
X_17816_ _17871_/CK _17816_/D _17816_/Q VDD VSS DFFQX1
XFILLER_55_719 VSS VDD FILLER2
X_18796_ _18851_/CK _18796_/D _18796_/Q VDD VSS DFFQX1
XFILLER_130_1072 VDD VSS DECAPHV32
XFILLER_48_793 VDD VSS DECAPHV8
XFILLER_54_229 VSS VDD FILLER2
XFILLER_78_1121 VDD VSS DECAPHV8
X_17747_ clkload3/A _17747_/D _17747_/Q VDD VSS DFFQX1
X_14959_ _18613_/Q _18991_/Q VDD VSS _14960_/B XOR2X1
XFILLER_39_1105 VDD VSS DECAPHV8
X_17678_ _17680_/CK _17678_/D _17678_/Q VDD VSS DFFQX1
X_16629_ _16629_/A _16629_/B _16629_/C VDD VSS _16631_/B OAI21X1
XFILLER_94_0 VDD VSS DECAPHV32
X_09101_ _17667_/Q _09101_/B _17461_/B VDD VSS _09107_/A MIN3X1
XFILLER_136_518 VDD VSS DECAPHV16
XTAP_TAPCELL_ROW_118_1429 VDD VSS WELLTAP
X_09032_ _17730_/Q _17698_/Q VDD VSS _09064_/B XNOR2X1
XFILLER_116_231 VDD VSS FILLER1
XFILLER_117_743 VDD VSS FILLER1
XFILLER_7_80 VDD VSS DECAPHV8
XFILLER_116_264 VDD VSS FILLER4
XFILLER_2_509 VSS VDD FILLER2
XFILLER_116_275 VSS VDD FILLER2
XFILLER_89_137 VSS VDD FILLER2
XFILLER_120_919 VDD VSS DECAPHV8
XFILLER_86_800 VDD VSS DECAPHV8
X_09934_ _17565_/A _10147_/B _10147_/C VDD VSS _17818_/D AND3BX1
XFILLER_86_822 VSS VDD FILLER2
X_09865_ _09976_/A _10075_/B VDD VSS _17810_/D NOR2X1
XTAP_TAPCELL_ROW_90_1094 VDD VSS WELLTAP
XFILLER_27_900 VSS VDD FILLER2
XFILLER_73_505 VDD VSS FILLER1
XTAP_TAPCELL_ROW_129_1569 VDD VSS WELLTAP
X_09796_ _16977_/A VDD VSS _17501_/A BUFX3
XFILLER_27_933 VSS VDD FILLER2
XFILLER_38_281 VDD VSS DECAPHV16
XFILLER_39_782 VSS VDD FILLER2
XFILLER_27_977 VDD VSS DECAPHV16
XFILLER_53_240 VSS VDD FILLER2
XFILLER_41_424 VDD VSS FILLER1
XFILLER_13_137 VDD VSS FILLER4
XFILLER_42_958 VDD VSS FILLER1
XFILLER_53_295 VDD VSS DECAPHV16
XTAP_TAPCELL_ROW_64_791 VDD VSS WELLTAP
X_10640_ _10643_/A _10643_/B VDD VSS _10777_/B XNOR2X1
XFILLER_41_468 VDD VSS FILLER1
XFILLER_42_44 VSS VDD FILLER2
XFILLER_9_108 VDD VSS DECAPHV16
X_10571_ _10571_/A _10571_/B VDD VSS _10572_/B NOR2X1
X_12310_ _12310_/A _12310_/B _12310_/C _12310_/D VDD VSS _14261_/B OAOI211X1
X_13290_ _13395_/A _13416_/C VDD VSS _14242_/B XNOR2X1
XFILLER_108_743 VDD VSS FILLER1
XFILLER_5_314 VDD VSS DECAPHV32
X_12241_ _18153_/Q VDD VSS _12344_/A INVX1
X_12172_ _18306_/Q VDD VSS _12174_/A INVX1
XFILLER_123_757 VSS VDD FILLER2
X_11123_ _17983_/Q _11126_/B VDD VSS _11127_/B XNOR2X1
X_16980_ _16980_/A _17006_/B _16980_/C VDD VSS _18938_/D OAI21X1
XFILLER_107_92 VDD VSS FILLER1
XFILLER_122_267 VDD VSS DECAPHV16
XFILLER_7_1114 VSS VDD FILLER2
X_11054_ _17969_/Q _11059_/B VDD VSS _11056_/C XOR2X1
X_15931_ _15931_/A _15931_/B _15931_/C _15931_/D VDD VSS _15961_/A OAOI211X1
X_10005_ _10005_/A _10005_/B VDD VSS _10213_/C NOR2X1
X_18650_ _18840_/CK _18650_/D _18650_/Q VDD VSS DFFQX1
XFILLER_49_568 VDD VSS FILLER1
XFILLER_67_96 VDD VSS DECAPHV8
X_17601_ _19028_/CK _17601_/D _17601_/Q VDD VSS DFFQX1
X_15862_ _15939_/B _15937_/B _15771_/Y VDD VSS _16023_/A MUXI2X1
XFILLER_123_80 VDD VSS DECAPHV8
XFILLER_17_421 VDD VSS DECAPHV16
X_18581_ _18990_/CK _18581_/D _18581_/Q VDD VSS DFFQX1
X_15793_ _18859_/Q _15793_/B _15793_/C VDD VSS _15995_/A OR3BX1
X_14813_ _14903_/A _14813_/B VDD VSS _18581_/D NOR2X1
XFILLER_91_346 VDD VSS FILLER4
X_11956_ _18123_/Q _14054_/B VDD VSS _11957_/D _14054_/C NAND3X1
X_17532_ _08896_/B _17532_/B VDD VSS _17533_/C NOR2BX1
X_14744_ _14747_/C _14745_/B _17266_/C VDD VSS _14745_/C OAI21X1
XFILLER_45_796 VSS VDD FILLER2
XFILLER_60_722 VDD VSS FILLER1
X_10907_ _17941_/Q _10910_/B VDD VSS _10911_/B XNOR2X1
X_17463_ _17463_/A _17463_/B VDD VSS _17669_/D NOR2X1
X_11887_ _14196_/B _18253_/Q VDD VSS _12013_/A NAND2BX1
X_16414_ _16604_/A _16414_/B VDD VSS _16415_/C NOR2X1
X_14675_ _18551_/Q _18583_/Q _14675_/C VDD VSS _14678_/B AOI21X1
XFILLER_60_788 VSS VDD FILLER2
X_10838_ _10841_/A _10841_/B VDD VSS _10976_/B XNOR2X1
X_17394_ _17395_/A _17394_/B VDD VSS _17604_/D NOR2X1
X_13626_ _18298_/Q _14248_/B VDD VSS _13693_/B XOR2X1
XFILLER_12_181 VDD VSS FILLER1
XTAP_TAPCELL_ROW_14_187 VDD VSS WELLTAP
X_10769_ _10769_/A _10769_/B _10769_/C VDD VSS _10770_/B NOR3X1
X_16345_ _16345_/A _16345_/B _16345_/C VDD VSS _16346_/B NOR3X1
X_13557_ _18322_/Q _14277_/B VDD VSS _13558_/D _14277_/C AND3X2
XFILLER_118_529 VDD VSS FILLER4
XFILLER_9_686 VDD VSS DECAPHV32
X_12508_ _18285_/Q _14233_/B VDD VSS _12509_/D _14233_/C NAND3X1
X_16276_ _16276_/A _16276_/B _16276_/C _16276_/D VDD VSS _16327_/A OAI31X1
X_13488_ _13488_/A _13488_/B _13488_/C _13488_/D VDD VSS _13628_/A OAOI211X1
XFILLER_8_174 VDD VSS DECAPHV32
X_12439_ _18181_/Q VDD VSS _12538_/A INVX1
X_18015_ _18016_/CK _18015_/D _18015_/Q VDD VSS DFFQX1
X_15227_ _17388_/A _18796_/Q VDD VSS _18769_/D AND2X1
XFILLER_114_735 VDD VSS DECAPHV8
X_15158_ _15272_/A _18728_/Q VDD VSS _18701_/D AND2X1
X_15089_ _19018_/Q VDD VSS _17312_/A INVX1
X_14109_ _14108_/Y _14109_/B _14109_/C VDD VSS _18173_/D AND3BX1
XFILLER_101_418 VDD VSS DECAPHV16
XFILLER_86_129 VDD VSS DECAPHV8
X_18917_ _18959_/CK _18917_/D _18917_/Q VDD VSS DFFQX1
XFILLER_67_332 VDD VSS DECAPHV8
XFILLER_68_844 VDD VSS FILLER4
XFILLER_80_1066 VSS VDD FILLER2
X_09650_ _19047_/Q _17348_/B VDD VSS _09653_/B XOR2X1
X_18848_ _18848_/CK _18848_/D _18848_/Q VDD VSS DFFQX1
XFILLER_82_324 VDD VSS FILLER1
XFILLER_83_836 VDD VSS FILLER1
X_09581_ _17515_/B _17717_/Q _09581_/C VDD VSS _09606_/B MIN3X1
X_18779_ _18780_/CK _18779_/D _18779_/Q VDD VSS DFFQX1
XFILLER_36_752 VDD VSS FILLER4
XFILLER_24_936 VSS VDD FILLER2
XFILLER_35_262 VDD VSS DECAPHV8
XFILLER_51_722 VDD VSS FILLER1
XFILLER_91_891 VSS VDD FILLER2
XFILLER_23_457 VSS VDD FILLER2
XFILLER_23_479 VSS VDD FILLER2
XFILLER_51_788 VDD VSS DECAPHV8
XTAP_TAPCELL_ROW_61_750 VDD VSS WELLTAP
X_09015_ _17633_/Q _17426_/B VDD VSS _09037_/B NAND2X1
XFILLER_104_212 VDD VSS FILLER1
XFILLER_117_595 VSS VDD FILLER2
XFILLER_2_328 VDD VSS DECAPHV32
XTAP_TAPCELL_ROW_92_1123 VDD VSS WELLTAP
XFILLER_132_565 VDD VSS FILLER4
XFILLER_132_598 VDD VSS FILLER4
X_09917_ _17565_/A _10123_/B _10123_/C VDD VSS _17816_/D AND3BX1
XFILLER_101_941 VSS VDD FILLER2
XFILLER_86_663 VDD VSS DECAPHV8
XTAP_TAPCELL_ROW_69_850 VDD VSS WELLTAP
X_09848_ _17777_/Q _17778_/Q VDD VSS _09851_/B _09848_/C NAND3X1
XFILLER_100_473 VDD VSS FILLER1
XFILLER_2_1011 VDD VSS DECAPHV32
X_09779_ _17597_/Q _17387_/B VDD VSS _09780_/B XNOR2X1
XFILLER_74_869 VDD VSS DECAPHV8
X_11810_ _18331_/Q _14318_/A _14317_/B VDD VSS _11906_/C XNOR3X1
X_12790_ _18263_/Q _12790_/B _12962_/D VDD VSS _12960_/C XNOR3X1
XFILLER_42_700 VSS VDD FILLER2
X_11741_ _11750_/A wire28/Y _11801_/B VDD VSS _11755_/D XNOR3X1
XFILLER_14_446 VDD VSS FILLER1
XFILLER_15_947 VSS VDD FILLER2
XFILLER_18_1008 VDD VSS FILLER4
XFILLER_41_221 VDD VSS FILLER1
XFILLER_53_32 VDD VSS DECAPHV32
XFILLER_14_468 VSS VDD FILLER2
XFILLER_42_766 VDD VSS FILLER4
XTAP_TAPCELL_ROW_101_1230 VDD VSS WELLTAP
X_11672_ _11672_/A _11672_/B _11672_/C _11672_/D VDD VSS _14136_/B AOAI211X1
X_14460_ _14361_/Y _14460_/B _14460_/C VDD VSS _18482_/D AND3BX1
X_10623_ _10630_/A _10761_/B VDD VSS _17911_/D NOR2X1
X_14391_ _14414_/A _14391_/B VDD VSS _18419_/D NOR2X1
X_13411_ _18295_/Q _13411_/B _13488_/C VDD VSS _13556_/B XNOR3X1
XTAP_TAPCELL_ROW_11_146 VDD VSS WELLTAP
X_10554_ _10687_/A _10687_/B _10554_/C _10554_/D VDD VSS _10560_/B OAOI211X1
X_16130_ _16158_/A _16158_/B VDD VSS _16136_/C _16158_/C AND3X2
X_13342_ _13342_/A _14489_/B _13342_/C VDD VSS _13437_/B MIN3X1
XFILLER_127_348 VSS VDD FILLER2
XFILLER_33_1090 VDD VSS DECAPHV8
X_10485_ _14310_/C _10661_/B VDD VSS _17893_/D AND2X1
X_13273_ _13273_/A _13273_/B _13273_/C VDD VSS _13276_/B XNOR3X1
X_16061_ _16109_/A _16376_/B _16376_/C _16711_/A VDD VSS _16121_/B OAOI211X1
XFILLER_135_370 VSS VDD FILLER2
X_12224_ _12224_/A _14170_/B _12224_/C _12224_/D VDD VSS _12430_/A AOAI211X1
X_15012_ _18624_/Q _19002_/Q VDD VSS _15014_/B XOR2X1
XFILLER_78_40 VDD VSS FILLER4
X_12155_ _18978_/Q _18099_/Q VDD VSS _12161_/C NAND2X1
XFILLER_111_727 VSS VDD FILLER2
XFILLER_2_873 VDD VSS DECAPHV8
X_11106_ _17059_/C _17049_/B VDD VSS _18005_/D AND2X1
X_12086_ _12109_/A _12109_/B _14322_/B VDD VSS _14353_/B XNOR3X1
X_18702_ _18808_/CK _18702_/D _18702_/Q VDD VSS DFFQX1
X_16963_ _18935_/Q _16970_/B VDD VSS _16964_/C NOR2BX1
X_11037_ _17965_/Q VDD VSS _11039_/A INVX1
X_16894_ _16895_/A _16895_/B _16895_/C VDD VSS _16898_/C OA21X2
X_15914_ _15997_/B VDD VSS _15972_/B INVX1
XFILLER_37_527 VDD VSS FILLER1
XFILLER_64_335 VDD VSS DECAPHV8
X_18633_ _19011_/CK _18633_/D _18633_/Q VDD VSS DFFQX1
X_15845_ _15885_/A _15885_/B _15885_/D _15885_/C VDD VSS _15846_/C AOI211X1
XTAP_TAPCELL_ROW_19_246 VDD VSS WELLTAP
X_18564_ clkload4/A _18564_/D _18564_/Q VDD VSS DFFQX1
XFILLER_91_165 VDD VSS FILLER1
XTAP_TAPCELL_ROW_47_577 VDD VSS WELLTAP
XTAP_TAPCELL_ROW_47_588 VDD VSS WELLTAP
X_12988_ _13085_/A _14122_/B _14122_/C VDD VSS _13191_/C NOR3X1
X_17515_ _17518_/A _17515_/B VDD VSS _17717_/D NOR2X1
X_15776_ _18832_/Q _18670_/Q VDD VSS _15778_/B XOR2X1
X_11939_ _18228_/Q _14169_/B VDD VSS _12034_/A AND2X1
X_18495_ _18496_/CK _18495_/D _18495_/Q VDD VSS DFFQX1
X_14727_ _18563_/Q _18595_/Q VDD VSS _14731_/A XOR2X1
XFILLER_21_928 VSS VDD FILLER2
XFILLER_33_788 VSS VDD FILLER2
X_17446_ _17446_/A _17446_/B VDD VSS _17653_/D AND2X1
X_14658_ _14659_/C _17525_/B _14658_/C VDD VSS _18548_/D AND3BX1
XFILLER_60_596 VDD VSS FILLER1
X_17377_ _17446_/A _17377_/B VDD VSS _17588_/D AND2X1
X_13609_ _14307_/B _14307_/C _18348_/Q VDD VSS _13613_/B AOI21X1
XFILLER_118_315 VSS VDD FILLER2
XFILLER_9_450 VDD VSS FILLER1
X_16328_ _16320_/Y _16396_/B _16328_/C _16405_/B VDD VSS _16336_/B AOI2B2X1
X_14589_ _18533_/Q _18565_/Q VDD VSS _14591_/D XNOR2X1
X_19047_ _19051_/CK _19047_/D _19047_/Q VDD VSS DFFQX1
X_16259_ _16276_/B _16259_/B VDD VSS _16260_/D XNOR2X1
XFILLER_57_0 VDD VSS DECAPHV32
XFILLER_99_210 VDD VSS DECAPHV8
XFILLER_82_1117 VSS VDD FILLER2
XFILLER_99_254 VSS VDD FILLER2
XFILLER_4_81 VDD VSS DECAPHV32
XFILLER_99_298 VDD VSS FILLER4
XFILLER_114_49 VDD VSS DECAPHV32
X_09702_ _09702_/A _09714_/C VDD VSS _17384_/B XNOR2X1
XFILLER_110_793 VSS VDD FILLER2
XFILLER_55_302 VDD VSS FILLER4
XFILLER_56_858 VSS VDD FILLER2
XFILLER_67_173 VDD VSS FILLER4
XFILLER_68_696 VDD VSS FILLER1
XTAP_TAPCELL_ROW_126_1528 VDD VSS WELLTAP
X_09633_ _17687_/Q _17483_/B VDD VSS _09640_/A NOR2X1
XFILLER_83_666 VSS VDD FILLER2
X_09564_ _09578_/B _09564_/B VDD VSS _17413_/B XOR2X1
XFILLER_36_560 VDD VSS DECAPHV8
XFILLER_83_699 VDD VSS FILLER1
XFILLER_51_541 VDD VSS FILLER1
X_09495_ _09488_/B _09495_/B _09495_/C VDD VSS _09517_/A AOI2B1X1
XFILLER_17_1030 VSS VDD FILLER2
XFILLER_109_348 VSS VDD FILLER2
XFILLER_20_983 VSS VDD FILLER2
XFILLER_118_882 VDD VSS FILLER1
XFILLER_136_178 VSS VDD FILLER2
X_10270_ _10270_/A _10270_/B VDD VSS _10278_/B XNOR2X1
XFILLER_105_565 VDD VSS DECAPHV16
XFILLER_105_587 VDD VSS FILLER1
XFILLER_133_874 VSS VDD FILLER2
XFILLER_48_32 VDD VSS DECAPHV8
XFILLER_47_814 VDD VSS FILLER1
XFILLER_87_961 VDD VSS FILLER1
X_13960_ _14013_/C VDD VSS _14011_/A BUFX3
XFILLER_111_1026 VDD VSS DECAPHV16
XFILLER_46_324 VDD VSS FILLER1
XFILLER_47_836 VDD VSS FILLER1
XFILLER_58_162 VDD VSS FILLER4
XFILLER_58_173 VDD VSS FILLER4
X_12911_ _12939_/A _12911_/B _12949_/C VDD VSS _13137_/B XNOR3X1
XFILLER_19_549 VDD VSS DECAPHV8
XFILLER_58_195 VDD VSS FILLER4
X_15630_ _18928_/Q _15632_/C VDD VSS _15631_/B NAND2X1
X_13891_ _13901_/A _13892_/B _13892_/C VDD VSS _14463_/B OR3BX1
XFILLER_27_571 VSS VDD FILLER2
XTAP_TAPCELL_ROW_16_205 VDD VSS WELLTAP
X_12842_ _12842_/A _14300_/B _14300_/C VDD VSS _12843_/D NOR3X1
XFILLER_42_530 VDD VSS DECAPHV8
XFILLER_61_349 VDD VSS FILLER1
XTAP_TAPCELL_ROW_16_216 VDD VSS WELLTAP
XTAP_TAPCELL_ROW_44_547 VDD VSS WELLTAP
X_12773_ _12773_/A _12781_/B _12773_/C VDD VSS _12899_/B XNOR3X1
X_15561_ _15421_/B _15560_/Y _15651_/A VDD VSS _15566_/A MUXI2X1
XFILLER_42_563 VDD VSS DECAPHV8
XTAP_TAPCELL_ROW_72_878 VDD VSS WELLTAP
X_11724_ _18408_/Q _11724_/B _11724_/C VDD VSS _12103_/B MIN3X1
X_18280_ _18358_/CK _18280_/D _18280_/Q VDD VSS DFFQX1
X_17300_ _17294_/A _17300_/B VDD VSS _17302_/B NAND2BX1
X_15492_ _15504_/A _15492_/B VDD VSS _16980_/A XOR2X1
X_14512_ _14517_/A _14512_/B VDD VSS _18517_/D NOR2X1
XFILLER_120_81 VDD VSS DECAPHV32
X_11655_ _18328_/Q VDD VSS _11661_/A INVX1
X_17231_ _19004_/Q _17315_/B VDD VSS _17237_/B XNOR2X1
X_14443_ _14451_/A _14443_/B VDD VSS _18466_/D NOR2X1
Xfanout80 _16984_/A VDD VSS _15240_/A BUFX3
Xfanout91 _17260_/B VDD VSS _17315_/B BUFX3
XFILLER_11_983 VDD VSS FILLER1
X_10606_ _10611_/B _10606_/B VDD VSS _10743_/B NAND2BX1
X_11586_ _18380_/Q _14344_/B VDD VSS _11728_/B NOR2X1
X_17162_ _17232_/B VDD VSS _17226_/C INVX1
X_14374_ _14361_/Y _14374_/B _14374_/C VDD VSS _18404_/D AND3BX1
XFILLER_13_90 VSS VDD FILLER2
XFILLER_6_453 VDD VSS DECAPHV32
XFILLER_7_965 VDD VSS DECAPHV32
X_10537_ _10382_/Y _10692_/B _10692_/C VDD VSS _17899_/D AND3BX1
X_17093_ _18014_/Q _17100_/A VDD VSS _17095_/C XNOR2X1
X_16113_ _18901_/Q _16114_/B VDD VSS _16119_/D NAND2X1
X_13325_ _18398_/Q _13325_/B _14367_/C VDD VSS _13532_/B XNOR3X1
XFILLER_127_189 VDD VSS DECAPHV32
X_10468_ _10468_/A _10468_/B _10468_/C VDD VSS _10651_/B OAI21X1
X_13256_ _18449_/Q _14423_/B VDD VSS _13512_/A AND2X1
X_16044_ _16096_/A _16045_/B _16316_/A VDD VSS _16045_/C AOI21X1
XFILLER_124_863 VDD VSS FILLER1
X_12207_ _18335_/Q _12379_/B VDD VSS _12375_/C _12207_/C NAND3X1
XFILLER_69_405 VDD VSS DECAPHV8
XFILLER_97_714 VDD VSS FILLER4
X_10399_ _17851_/Q _10399_/B VDD VSS _10400_/D _10399_/C NAND3X1
X_13187_ _18266_/Q _13297_/D _13187_/C VDD VSS _13294_/C XNOR3X1
XFILLER_96_235 VSS VDD FILLER2
X_12138_ _18178_/Q _12335_/A _12335_/B VDD VSS _12139_/D XNOR3X1
X_17995_ _18016_/CK _17995_/D _17995_/Q VDD VSS DFFQX1
XFILLER_42_1134 VSS VDD FILLER2
XFILLER_96_268 VDD VSS DECAPHV8
X_12069_ _12139_/A _12139_/B _12139_/C VDD VSS _12070_/C OAI21X1
X_16946_ _16946_/A VDD VSS _16947_/C INVX1
XFILLER_37_302 VDD VSS FILLER1
XFILLER_49_162 VDD VSS FILLER4
XFILLER_65_633 VSS VDD FILLER2
X_18616_ _18994_/CK _18616_/D _18616_/Q VDD VSS DFFQX1
X_16877_ _16939_/A _16877_/B _16946_/A VDD VSS _16889_/A AOI21X1
X_15828_ _15828_/A _16120_/A _16147_/B _16196_/A VDD VSS _15829_/B OA211X2
X_18547_ _18547_/CK _18547_/D _18547_/Q VDD VSS DFFQX1
X_15759_ _15865_/C VDD VSS _16196_/A BUFX3
X_09280_ _17674_/Q _17469_/B VDD VSS _09281_/D OR2X2
X_18478_ _18478_/CK _18478_/D _18478_/Q VDD VSS DFFQX1
XFILLER_21_725 VDD VSS DECAPHV8
XFILLER_21_747 VDD VSS DECAPHV16
XFILLER_60_371 VSS VDD FILLER2
XFILLER_60_382 VDD VSS FILLER1
XTAP_TAPCELL_ROW_121_1469 VDD VSS WELLTAP
X_17429_ _17498_/A _17429_/B VDD VSS _17636_/D AND2X1
XFILLER_20_235 VDD VSS FILLER4
XFILLER_21_769 VDD VSS FILLER1
XFILLER_20_279 VSS VDD FILLER2
XFILLER_119_668 VDD VSS FILLER1
Xclkload61 _18292_/CK VDD VSS clkload61/Y INVX2
Xclkload50 _18249_/CK VDD VSS clkload50/Y INVX4
Xclkload94 _17710_/CK VDD VSS clkload94/Y BUFX12
Xclkload83 _17680_/CK VDD VSS clkload83/Y INVX2
Xclkload72 _18340_/CK VDD VSS clkload72/Y BUFX12
XFILLER_115_874 VDD VSS FILLER1
XFILLER_86_1072 VSS VDD FILLER2
XFILLER_88_714 VDD VSS FILLER1
XFILLER_114_395 VSS VDD FILLER2
XFILLER_76_909 VDD VSS FILLER1
XTAP_TAPCELL_ROW_132_1598 VDD VSS WELLTAP
X_08995_ _17728_/Q _17696_/Q VDD VSS _09009_/B XNOR2X1
XFILLER_102_579 VSS VDD FILLER2
XFILLER_134_1059 VDD VSS DECAPHV8
XFILLER_75_408 VDD VSS FILLER1
XFILLER_28_324 VDD VSS FILLER1
XFILLER_96_780 VSS VDD FILLER2
XFILLER_56_655 VDD VSS DECAPHV16
XFILLER_44_839 VDD VSS FILLER1
XFILLER_55_165 VSS VDD FILLER2
XFILLER_83_474 VDD VSS DECAPHV16
XTAP_TAPCELL_ROW_87_1066 VDD VSS WELLTAP
X_09616_ _17623_/Q _09630_/A VDD VSS _09617_/B XNOR2X1
XFILLER_70_113 VDD VSS FILLER4
XFILLER_70_135 VDD VSS FILLER4
X_09547_ _19043_/Q _17344_/B VDD VSS _09548_/A NAND2BX1
XFILLER_52_861 VSS VDD FILLER2
XTAP_TAPCELL_ROW_41_506 VDD VSS WELLTAP
XFILLER_11_213 VDD VSS FILLER1
XFILLER_24_585 VSS VDD FILLER2
XFILLER_51_371 VDD VSS FILLER1
XFILLER_93_1076 VDD VSS FILLER1
X_09478_ _17713_/Q VDD VSS _09479_/B INVX1
XFILLER_11_246 VDD VSS FILLER1
X_11440_ _11440_/A _14047_/B VDD VSS _11488_/A OR2X2
Xclkload0 _172_/CK VDD VSS clkload0/Y INVX1
XFILLER_50_44 VSS VDD FILLER2
XTAP_TAPCELL_ROW_21_274 VDD VSS WELLTAP
X_11371_ _18272_/Q _14216_/B VDD VSS _11470_/B NOR2X1
XFILLER_109_189 VSS VDD FILLER2
XFILLER_125_638 VDD VSS DECAPHV8
XTAP_TAPCELL_ROW_98_1195 VDD VSS WELLTAP
X_10322_ _17843_/Q _10322_/B _10322_/C VDD VSS _10329_/B XNOR3X1
X_13110_ _18988_/Q _18109_/Q _14067_/A VDD VSS _14068_/B AOI21X1
X_14090_ _14122_/A _14090_/B _14090_/C VDD VSS _18155_/D NOR3X1
XFILLER_124_137 VSS VDD FILLER2
XFILLER_65_1112 VDD VSS FILLER1
X_13041_ _13161_/A _13265_/B VDD VSS _14393_/B XNOR2X1
XFILLER_105_340 VDD VSS FILLER1
XFILLER_133_671 VDD VSS FILLER1
XFILLER_4_979 VDD VSS DECAPHV32
XFILLER_79_714 VSS VDD FILLER2
X_10253_ _17834_/Q _10256_/B VDD VSS _10257_/B XNOR2X1
XFILLER_59_64 VDD VSS DECAPHV16
XFILLER_78_235 VSS VDD FILLER2
XFILLER_79_747 VSS VDD FILLER2
X_10184_ _10184_/A _10184_/B _10184_/C VDD VSS _10185_/B AOI21X1
XFILLER_94_717 VDD VSS FILLER1
XTAP_TAPCELL_ROW_49_606 VDD VSS WELLTAP
X_17780_ _19051_/CK _17780_/D _17780_/Q VDD VSS DFFQX1
X_16800_ _16800_/A VDD VSS _16947_/A BUFX3
XFILLER_47_611 VDD VSS FILLER1
XFILLER_8_1072 VDD VSS DECAPHV32
XTAP_TAPCELL_ROW_77_937 VDD VSS WELLTAP
XTAP_TAPCELL_ROW_77_948 VDD VSS WELLTAP
X_16731_ _16731_/A _16731_/B VDD VSS _16732_/D NOR2X1
X_14992_ _14992_/A _14992_/B _14992_/C VDD VSS _14998_/C OA21X2
XFILLER_115_92 VDD VSS FILLER1
XFILLER_59_493 VDD VSS FILLER1
XFILLER_75_975 VDD VSS FILLER4
X_13943_ _18947_/Q _13984_/B VDD VSS _13988_/B NOR2BX1
XFILLER_62_603 VDD VSS FILLER1
XFILLER_75_96 VDD VSS DECAPHV16
XTAP_TAPCELL_ROW_29_363 VDD VSS WELLTAP
X_16662_ _16688_/A _16662_/B VDD VSS _16663_/D XNOR2X1
X_13874_ _18433_/Q _14406_/B VDD VSS _13898_/D XNOR2X1
XFILLER_90_945 VDD VSS FILLER1
X_12825_ _18367_/Q _12825_/B _12843_/C VDD VSS _13021_/A XNOR3X1
X_18401_ _18453_/CK _18401_/D _18401_/Q VDD VSS DFFQX1
X_16593_ _16630_/A _16593_/B VDD VSS _16594_/C NOR2X1
X_15613_ _15695_/A _15613_/B VDD VSS _15614_/C NAND2X1
XFILLER_131_80 VDD VSS DECAPHV8
X_18332_ _18358_/CK _18332_/D _18332_/Q VDD VSS DFFQX1
X_15544_ _16757_/D VDD VSS _15648_/A BUFX3
XFILLER_42_382 VDD VSS FILLER1
X_12756_ _12756_/A _12756_/B _12756_/C VDD VSS _12763_/B XNOR3X1
X_11707_ _18975_/Q _18096_/Q VDD VSS _11787_/B XOR2X1
X_12687_ _12740_/A _12687_/B _12845_/D VDD VSS _12741_/C XNOR3X1
X_18263_ _18313_/CK _18263_/D _18263_/Q VDD VSS DFFQX1
X_15475_ _15475_/A _15475_/B _15475_/C VDD VSS _15504_/A OAI21X1
XFILLER_128_410 VDD VSS FILLER4
XFILLER_30_566 VSS VDD FILLER2
X_11638_ _11706_/A _11706_/B VDD VSS _11779_/C NOR2X1
X_18194_ _18271_/CK _18194_/D _18194_/Q VDD VSS DFFQX1
X_17214_ _17208_/A _17214_/B VDD VSS _17216_/B NAND2BX1
X_14426_ _15309_/A _14426_/B VDD VSS _18452_/D AND2X1
X_17145_ _17145_/A _17145_/B _17145_/C VDD VSS _17149_/A AO21X2
X_14357_ _14378_/A _14357_/B VDD VSS _18390_/D NOR2X1
XFILLER_128_498 VSS VDD FILLER2
X_11569_ _18120_/Q _11569_/B _11633_/D VDD VSS _11686_/C XOR3X1
X_13308_ _13408_/A _13408_/B VDD VSS _13319_/B NOR2X1
X_17076_ _18010_/Q _17076_/B _17076_/C VDD VSS _17082_/C AOI21X1
X_14288_ _14313_/A _14288_/B VDD VSS _18331_/D NOR2X1
X_13239_ _18423_/Q _13239_/B _13278_/C VDD VSS _13444_/B XNOR3X1
X_16027_ _16064_/D _16027_/B VDD VSS _16034_/B XNOR2X1
XFILLER_130_129 VDD VSS DECAPHV8
XFILLER_69_213 VSS VDD FILLER2
XFILLER_69_235 VDD VSS DECAPHV16
XFILLER_38_611 VDD VSS FILLER4
XFILLER_97_588 VDD VSS FILLER1
X_17978_ _17982_/CK _17978_/D _17978_/Q VDD VSS DFFQX1
X_16929_ _16931_/B _16939_/A _16946_/A VDD VSS _16934_/B AOI2B1X1
XFILLER_65_474 VDD VSS FILLER1
XFILLER_66_975 VDD VSS FILLER1
XFILLER_129_1106 VDD VSS DECAPHV8
XFILLER_37_198 VDD VSS FILLER1
XFILLER_65_496 VSS VDD FILLER2
XFILLER_80_433 VSS VDD FILLER2
X_09401_ _17615_/Q _17406_/B VDD VSS _09416_/B XNOR2X1
XFILLER_34_850 VDD VSS FILLER4
XFILLER_80_444 VSS VDD FILLER2
XFILLER_80_466 VDD VSS DECAPHV16
X_09332_ _09332_/A _09332_/B _09332_/C VDD VSS _09348_/A AOI21X1
XFILLER_33_360 VDD VSS DECAPHV8
XFILLER_61_680 VDD VSS DECAPHV16
X_09263_ _09264_/A _09264_/B _09264_/C VDD VSS _17367_/B OA21X2
XFILLER_53_1082 VSS VDD FILLER2
X_09194_ _19030_/Q _09194_/B _17330_/B VDD VSS _09219_/B MIN3X1
XFILLER_101_1047 VDD VSS FILLER4
XFILLER_119_498 VDD VSS FILLER4
XTAP_TAPCELL_ROW_134_1627 VDD VSS WELLTAP
XFILLER_106_137 VSS VDD FILLER2
XFILLER_106_148 VDD VSS FILLER1
XFILLER_103_811 VDD VSS FILLER4
XFILLER_0_448 VSS VDD FILLER2
XFILLER_103_855 VDD VSS FILLER1
XFILLER_76_717 VDD VSS DECAPHV16
XFILLER_88_566 VDD VSS FILLER1
XFILLER_102_376 VSS VDD FILLER2
X_08978_ _18544_/Q VDD VSS _14645_/A INVX1
XFILLER_21_1026 VDD VSS DECAPHV8
XFILLER_28_110 VSS VDD FILLER2
XFILLER_29_644 VDD VSS FILLER4
XTAP_TAPCELL_ROW_74_907 VDD VSS WELLTAP
X_10940_ _10942_/A _10940_/B VDD VSS _11077_/B XNOR2X1
XFILLER_28_187 VSS VDD FILLER2
XFILLER_71_422 VDD VSS FILLER4
XFILLER_25_861 VDD VSS FILLER1
XFILLER_32_809 VDD VSS FILLER1
XFILLER_43_146 VDD VSS FILLER4
XFILLER_45_88 VDD VSS FILLER1
XFILLER_71_455 VSS VDD FILLER2
XTAP_TAPCELL_ROW_26_333 VDD VSS WELLTAP
XTAP_TAPCELL_ROW_54_664 VDD VSS WELLTAP
X_10871_ _10874_/C _10874_/B VDD VSS _10872_/B NOR2BX1
X_12610_ _12610_/A _14296_/B _14296_/C VDD VSS _12611_/D NOR3X1
XFILLER_25_883 VDD VSS DECAPHV16
X_13590_ _18400_/Q _14370_/B _14370_/C VDD VSS _13591_/D OR3BX1
XFILLER_61_32 VDD VSS DECAPHV32
X_12541_ _12743_/A _12743_/B _12743_/D VDD VSS _12571_/B OAI21X1
X_12472_ _18364_/Q _12614_/A _14326_/B VDD VSS _14357_/B XNOR3X1
X_15260_ _15318_/A _18828_/Q VDD VSS _18801_/D AND2X1
XFILLER_124_0 VDD VSS DECAPHV32
X_11423_ _11460_/B _11423_/B VDD VSS _11424_/C XNOR2X1
X_14211_ _14236_/A _14211_/B _14211_/C VDD VSS _18267_/D NOR3X1
XANTENNA_9 _17533_/A VDD VSS ANTENNA2
XFILLER_6_49 VDD VSS DECAPHV32
X_15191_ _15274_/A _18760_/Q VDD VSS _18733_/D AND2X1
XFILLER_4_732 VDD VSS DECAPHV32
X_11354_ _11354_/A _11354_/B _11354_/C _11354_/D VDD VSS _11428_/B OAOI211X1
X_14142_ _14174_/A _14143_/B _14142_/C VDD VSS _18204_/D NOR3X1
XFILLER_125_468 VSS VDD FILLER2
XFILLER_3_253 VDD VSS DECAPHV16
X_10305_ _10305_/A _10317_/B VDD VSS _10322_/B NAND2X1
X_11285_ _18114_/Q _11296_/B _11319_/D VDD VSS _11316_/C XNOR3X1
X_18950_ _18950_/CK _18950_/D _18950_/Q VDD VSS DFFQX1
X_14073_ _14083_/A _14073_/B VDD VSS _18141_/D NOR2X1
XFILLER_112_129 VDD VSS DECAPHV8
X_10236_ _10239_/D _10239_/C VDD VSS _10237_/B NOR2BX1
X_13024_ _18421_/Q _13265_/A _13265_/B VDD VSS _13137_/D XNOR3X1
X_18881_ _18950_/CK _18881_/D _18881_/Q VDD VSS DFFQX1
X_17901_ _17901_/CK _17901_/D _17901_/Q VDD VSS DFFQX1
XFILLER_79_577 VDD VSS DECAPHV8
XFILLER_86_40 VDD VSS FILLER4
X_17832_ _17854_/CK _17832_/D _17832_/Q VDD VSS DFFQX1
XFILLER_0_993 VDD VSS DECAPHV32
XFILLER_67_728 VDD VSS FILLER4
X_10167_ _17822_/Q _10176_/B _10176_/C VDD VSS _10356_/B XNOR3X1
X_10098_ _10270_/A _10098_/B _10098_/C _10276_/B VDD VSS _10311_/B OAOI211X1
X_17763_ _19033_/CK _17763_/D _17763_/Q VDD VSS DFFQX1
X_14975_ _14977_/B _14975_/B VDD VSS _14983_/B NAND2BX1
XFILLER_19_143 VSS VDD FILLER2
XFILLER_35_603 VDD VSS DECAPHV8
XFILLER_75_783 VSS VDD FILLER2
XFILLER_81_208 VSS VDD FILLER2
XTAP_TAPCELL_ROW_109_1331 VDD VSS WELLTAP
X_17694_ _17698_/CK _17694_/D _17694_/Q VDD VSS DFFQX1
X_16714_ _16715_/A _16715_/B _16715_/D _16715_/C VDD VSS _16748_/C OAOI211X1
X_13926_ _13929_/A _13929_/C _13929_/B VDD VSS _14500_/B NOR3X1
XFILLER_47_496 VDD VSS FILLER4
X_16645_ _16445_/Y _16593_/B _16819_/A VDD VSS _16668_/B MUXI2X1
X_13857_ _18483_/Q _14461_/B VDD VSS _13887_/A AND2X1
XFILLER_22_308 VDD VSS FILLER1
XFILLER_31_820 VSS VDD FILLER2
X_12808_ _18498_/Q VDD VSS _12920_/A INVX1
X_16576_ _18053_/Q _18663_/Q _16576_/C VDD VSS _16608_/C MIN3X1
X_13788_ _14460_/B _14460_/C _18482_/Q VDD VSS _13814_/B AOI21X1
X_12739_ _12845_/A _12845_/B _12845_/D _12845_/C VDD VSS _14236_/C AOI211X1
X_18315_ _18340_/CK _18315_/D _18315_/Q VDD VSS DFFQX1
X_15527_ _18921_/Q _15527_/B VDD VSS _15556_/C NOR2BX1
XTAP_TAPCELL_ROW_6_92 VDD VSS WELLTAP
X_18246_ _18271_/CK _18246_/D _18246_/Q VDD VSS DFFQX1
X_15458_ _18918_/Q _15477_/B VDD VSS _15458_/Y XOR2X1
X_14409_ _14414_/A _14409_/B VDD VSS _18436_/D NOR2X1
XFILLER_117_914 VDD VSS FILLER1
X_18177_ _18200_/CK _18177_/D _18177_/Q VDD VSS DFFQX1
X_15389_ _15374_/Y _15464_/B _15801_/B VDD VSS _15501_/B MUXI2X1
X_17128_ _17242_/A _17128_/B _17132_/B VDD VSS _18982_/D NOR3X1
X_09950_ _10157_/C _10157_/B VDD VSS _10150_/C NOR2BX1
X_17059_ _17057_/Y _17063_/B _17059_/C VDD VSS _18969_/D AND3BX1
XFILLER_125_991 VDD VSS FILLER1
X_08901_ _17536_/A _17536_/B _17536_/C VDD VSS _17537_/B AOI21X1
XFILLER_100_803 VDD VSS DECAPHV8
XFILLER_83_1064 VDD VSS FILLER4
XFILLER_97_330 VDD VSS FILLER1
X_09881_ _09881_/A _09881_/B _09881_/C _09881_/D VDD VSS _09897_/B AOAI211X1
XFILLER_57_205 VDD VSS DECAPHV8
XFILLER_98_886 VSS VDD FILLER2
XFILLER_57_238 VDD VSS DECAPHV8
Xclkbuf_2_3__f__001_ clkbuf_0__001_/Y VDD VSS clkload75/A BUFX12
XFILLER_122_49 VDD VSS DECAPHV32
XFILLER_65_282 VDD VSS FILLER4
XTAP_TAPCELL_ROW_84_1025 VDD VSS WELLTAP
XFILLER_14_809 VDD VSS FILLER4
XFILLER_80_241 VDD VSS FILLER1
XFILLER_40_116 VDD VSS FILLER1
XFILLER_53_477 VDD VSS FILLER1
XFILLER_40_138 VDD VSS FILLER1
XTAP_TAPCELL_ROW_51_634 VDD VSS WELLTAP
X_09315_ _09316_/A _09316_/B _09316_/C VDD VSS _09336_/B OAI21X1
XFILLER_22_886 VDD VSS DECAPHV8
X_09246_ _17577_/Q _17366_/B _09246_/C VDD VSS _09275_/B OAI21X1
XFILLER_108_903 VDD VSS FILLER4
XFILLER_108_936 VDD VSS FILLER4
XFILLER_135_700 VDD VSS FILLER1
XTAP_TAPCELL_ROW_31_391 VDD VSS WELLTAP
X_09177_ _17670_/Q _17464_/B VDD VSS _09203_/A NAND2BX1
XFILLER_107_424 VDD VSS FILLER1
XFILLER_119_284 VDD VSS FILLER1
XTAP_TAPCELL_ROW_2_39 VDD VSS WELLTAP
XTAP_TAPCELL_ROW_95_1154 VDD VSS WELLTAP
XFILLER_107_468 VDD VSS DECAPHV16
Xoutput13 _18081_/Q VDD VSS data_out[19] BUFX3
Xoutput24 _18071_/Q VDD VSS data_out[9] BUFX3
XFILLER_122_438 VDD VSS DECAPHV16
XFILLER_123_939 VDD VSS FILLER1
X_11070_ _11202_/B VDD VSS _11206_/B INVX1
XFILLER_0_223 VSS VDD FILLER2
XFILLER_88_341 VSS VDD FILLER2
X_10021_ _10019_/Y _10228_/B _17453_/A VDD VSS _17828_/D AND3BX1
XFILLER_103_674 VDD VSS FILLER1
XFILLER_1_779 VDD VSS DECAPHV32
XFILLER_76_514 VDD VSS FILLER4
XFILLER_76_525 VDD VSS FILLER1
XFILLER_48_227 VDD VSS FILLER1
XFILLER_56_32 VDD VSS DECAPHV8
XTAP_TAPCELL_ROW_59_723 VDD VSS WELLTAP
X_14760_ _14760_/A _14761_/C _14760_/C VDD VSS _18569_/D AOI21X1
XFILLER_45_923 VDD VSS FILLER4
X_11972_ _18151_/Q _12065_/B _12065_/C VDD VSS _12063_/C XNOR3X1
X_13711_ _18455_/Q _13792_/A _13734_/B VDD VSS _13784_/D XNOR3X1
XTAP_TAPCELL_ROW_39_491 VDD VSS WELLTAP
X_10923_ _17944_/Q _10928_/B VDD VSS _10925_/A XNOR2X1
X_14691_ _14693_/A _14693_/B _14691_/C VDD VSS _18555_/D AOI21X1
XFILLER_108_1009 VDD VSS FILLER1
X_10854_ _17931_/Q _10857_/B VDD VSS _10858_/C XNOR2X1
X_16430_ _16428_/Y _16731_/A _16474_/B VDD VSS _16444_/B OR3BX1
X_13642_ _13643_/B _13643_/C _18401_/Q VDD VSS _13673_/B AOI21X1
XTAP_TAPCELL_ROW_104_1261 VDD VSS WELLTAP
XTAP_TAPCELL_ROW_104_1272 VDD VSS WELLTAP
X_16361_ _16361_/A _16361_/B VDD VSS _16370_/B XNOR2X1
X_13573_ _18375_/Q _13640_/B _13686_/D VDD VSS _13675_/C XNOR3X1
XFILLER_12_363 VDD VSS DECAPHV8
X_10785_ _11062_/A _10915_/B VDD VSS _17942_/D AND2X1
X_12524_ _18207_/Q _14146_/B VDD VSS _12525_/D _14146_/C NAND3X1
X_18100_ _18978_/CK _18100_/D _18100_/Q VDD VSS DFFQX1
X_15312_ _17079_/A _16535_/A VDD VSS _18851_/D NOR2X1
XFILLER_13_897 VDD VSS DECAPHV8
XFILLER_40_694 VSS VDD FILLER2
X_18031_ _18863_/CK _18031_/D _18031_/Q VDD VSS DFFQX1
X_16292_ _18790_/Q _18736_/Q VDD VSS _16293_/D NAND2X1
XFILLER_126_700 VDD VSS FILLER4
X_12455_ _12455_/A _12455_/B _12542_/C _12455_/D VDD VSS _12680_/A OAOI211X1
X_15243_ _15299_/A _18811_/Q VDD VSS _18784_/D AND2X1
XFILLER_125_221 VDD VSS DECAPHV32
XFILLER_68_8 VDD VSS DECAPHV32
X_11406_ _18143_/Q _11478_/B _11478_/C VDD VSS _11537_/B XNOR3X1
X_12386_ _18363_/Q _12408_/B _12408_/C VDD VSS _12489_/C XOR3X1
X_15174_ _18744_/Q VDD VSS _16570_/B INVX1
XFILLER_113_405 VDD VSS FILLER1
XFILLER_114_906 VSS VDD FILLER2
XFILLER_67_1048 VDD VSS FILLER1
X_11337_ _11342_/A _11381_/B _11342_/C VDD VSS _14131_/B XNOR3X1
X_14125_ _14174_/A _14125_/B _14125_/C VDD VSS _18188_/D NOR3X1
XFILLER_107_980 VDD VSS DECAPHV16
XFILLER_125_298 VDD VSS DECAPHV8
XFILLER_99_639 VDD VSS FILLER4
X_11268_ _18165_/Q _11327_/B _11272_/C VDD VSS _14128_/B XNOR3X1
X_18933_ _18934_/CK _18933_/D _18933_/Q VDD VSS DFFQX1
X_14056_ _14107_/A _14056_/B VDD VSS _18125_/D AND2X1
XFILLER_39_216 VDD VSS FILLER4
XFILLER_95_812 VDD VSS DECAPHV8
XFILLER_95_834 VSS VDD FILLER2
X_10219_ _10222_/B _10220_/C _17827_/Q VDD VSS _10221_/C AOI21X1
X_11199_ _11203_/C _11199_/B VDD VSS _17144_/B XNOR2X1
X_13007_ _13177_/A _13053_/B _13186_/D VDD VSS _13178_/C XNOR3X1
X_18864_ _18961_/CK _18864_/D _18864_/Q VDD VSS DFFQX1
X_18795_ _18852_/CK _18795_/D _18795_/Q VDD VSS DFFQX1
X_17815_ _17871_/CK _17815_/D _17815_/Q VDD VSS DFFQX1
XFILLER_36_901 VDD VSS FILLER1
XFILLER_43_1070 VDD VSS FILLER4
XFILLER_48_761 VSS VDD FILLER2
XFILLER_67_569 VSS VDD FILLER2
X_17746_ clkload3/A _17746_/D _17746_/Q VDD VSS DFFQX1
XFILLER_35_400 VDD VSS FILLER1
XFILLER_47_282 VDD VSS FILLER4
XFILLER_78_1133 VSS VDD FILLER2
XFILLER_82_539 VDD VSS DECAPHV16
XFILLER_94_399 VDD VSS DECAPHV16
X_14958_ _18612_/Q _18990_/Q _14958_/C VDD VSS _14962_/B AOI21X1
XFILLER_74_1008 VSS VDD FILLER2
X_17677_ _17710_/CK _17677_/D _17677_/Q VDD VSS DFFQX1
X_14889_ _14889_/A _14889_/B _14889_/C _14889_/D VDD VSS _14890_/C AOAI211X1
X_13909_ _13913_/A _13913_/B _13909_/C _13909_/D VDD VSS _18056_/D OAOI211X1
XFILLER_23_639 VDD VSS FILLER4
XFILLER_63_786 VSS VDD FILLER2
X_16628_ _16629_/A _16628_/B VDD VSS _16629_/C NAND2X1
X_16559_ _16559_/A _16568_/B VDD VSS _16565_/B XNOR2X1
XFILLER_31_650 VDD VSS FILLER1
XFILLER_87_0 VDD VSS DECAPHV32
X_09100_ _09100_/A VDD VSS _17461_/B INVX1
X_09031_ _09011_/A _09031_/B _09031_/C VDD VSS _09033_/A AOI2B1X1
XFILLER_129_571 VDD VSS DECAPHV16
X_18229_ _18253_/CK _18229_/D _18229_/Q VDD VSS DFFQX1
XFILLER_117_755 VDD VSS FILLER1
XFILLER_116_254 VDD VSS FILLER4
XFILLER_117_788 VDD VSS FILLER4
XFILLER_7_92 VDD VSS FILLER1
XFILLER_85_1115 VDD VSS FILLER1
XFILLER_104_416 VSS VDD FILLER2
X_09933_ _10128_/A _10128_/B _10129_/C _10128_/C VDD VSS _10147_/C AO211X2
XFILLER_58_503 VDD VSS DECAPHV8
XFILLER_58_514 VDD VSS FILLER4
XFILLER_86_812 VDD VSS FILLER1
X_09864_ _17784_/Q _09864_/B VDD VSS _10075_/B XOR2X1
XFILLER_97_193 VSS VDD FILLER2
XTAP_TAPCELL_ROW_90_1095 VDD VSS WELLTAP
XFILLER_58_569 VDD VSS FILLER1
XFILLER_86_878 VDD VSS FILLER4
X_09795_ _09812_/A _09896_/B VDD VSS _17788_/D NOR2X1
XFILLER_14_639 VDD VSS DECAPHV32
XFILLER_42_926 VSS VDD FILLER2
XFILLER_81_561 VSS VDD FILLER2
XTAP_TAPCELL_ROW_36_450 VDD VSS WELLTAP
XFILLER_13_116 VDD VSS FILLER1
XTAP_TAPCELL_ROW_64_781 VDD VSS WELLTAP
XTAP_TAPCELL_ROW_64_792 VDD VSS WELLTAP
XFILLER_107_1042 VDD VSS FILLER4
XFILLER_10_812 VSS VDD FILLER2
XFILLER_22_650 VDD VSS DECAPHV8
XFILLER_107_1075 VDD VSS FILLER1
XFILLER_50_981 VDD VSS FILLER1
X_10570_ _10570_/A _10570_/B _10570_/C _10570_/D VDD VSS _10711_/B AOAI211X1
XFILLER_108_700 VDD VSS DECAPHV16
X_09229_ _17737_/Q _17705_/Q VDD VSS _09230_/B XNOR2X1
X_12240_ _18152_/Q _14086_/B _14086_/C VDD VSS _12244_/D OR3BX1
XFILLER_108_788 VSS VDD FILLER2
XFILLER_135_541 VDD VSS FILLER1
X_12171_ _12171_/A _12171_/B _12171_/C _12171_/D VDD VSS _12379_/B AOAI211X1
XFILLER_123_725 VDD VSS DECAPHV16
XFILLER_123_747 VSS VDD FILLER2
XTAP_TAPCELL_ROW_8_120 VDD VSS WELLTAP
XFILLER_122_235 VDD VSS DECAPHV32
XFILLER_1_532 VDD VSS DECAPHV16
X_11122_ _11122_/A _11122_/B _11122_/C VDD VSS _11127_/A AOI21X1
XFILLER_103_460 VDD VSS FILLER4
XFILLER_49_503 VDD VSS FILLER4
XFILLER_89_683 VDD VSS DECAPHV8
X_11053_ _11053_/A _11053_/B VDD VSS _11056_/B AND2X1
X_15930_ _18808_/Q _18700_/Q VDD VSS _15931_/D AND2X1
XFILLER_131_791 VSS VDD FILLER2
XFILLER_67_64 VDD VSS DECAPHV16
XFILLER_77_856 VDD VSS FILLER4
XFILLER_77_867 VDD VSS FILLER4
X_10004_ _10114_/A _10216_/B VDD VSS _17826_/D NOR2X1
X_15861_ _15898_/B _16180_/A _15861_/C VDD VSS _15937_/B AOI2B1X1
XFILLER_114_1068 VDD VSS FILLER1
X_17600_ _19024_/CK _17600_/D _17600_/Q VDD VSS DFFQX1
X_14812_ _14814_/B _14812_/B VDD VSS _14813_/B XOR2X1
X_18580_ _18990_/CK _18580_/D _18580_/Q VDD VSS DFFQX1
X_15792_ _16927_/B _15834_/B _15792_/C _15792_/D VDD VSS _18893_/D OA211X2
XFILLER_123_92 VDD VSS FILLER1
XFILLER_18_956 VSS VDD FILLER2
XFILLER_44_241 VDD VSS FILLER1
X_11955_ _14054_/B _14054_/C _18123_/Q VDD VSS _11957_/C AOI21X1
X_17531_ _17565_/A _17531_/B VDD VSS _17729_/D NOR2X1
X_14743_ _18566_/Q _18598_/Q VDD VSS _14745_/B XOR2X1
XFILLER_45_775 VDD VSS DECAPHV8
XFILLER_83_96 VDD VSS DECAPHV32
X_10906_ _17940_/Q _10906_/B _10906_/C VDD VSS _10911_/A AO21X2
X_17462_ _17463_/A _17462_/B VDD VSS _17668_/D NOR2X1
X_14674_ _18552_/Q _18584_/Q VDD VSS _14676_/B XOR2X1
XFILLER_33_948 VDD VSS FILLER4
XFILLER_33_959 VDD VSS FILLER1
X_11886_ _11937_/A _11937_/B _11937_/C VDD VSS _12079_/B OAI21X1
X_16413_ _16630_/A _16413_/B _16413_/C VDD VSS _16414_/B AOI21X1
X_13625_ _13625_/A _14215_/B _13625_/C VDD VSS _14248_/B MIN3X1
XFILLER_125_1131 VDD VSS FILLER1
XFILLER_13_650 VDD VSS FILLER1
X_10837_ _17927_/Q _10837_/B _10837_/C VDD VSS _10841_/B MIN3X1
X_17393_ _17395_/A _17393_/B VDD VSS _17603_/D NOR2X1
XTAP_TAPCELL_ROW_14_188 VDD VSS WELLTAP
X_10768_ _10769_/A _10769_/B _10769_/C VDD VSS _10768_/Y OAI21X1
X_16344_ _16345_/A _16345_/B _16345_/C VDD VSS _16381_/B OAI21X1
X_13556_ _13556_/A _13556_/B _13556_/C _13556_/D VDD VSS _14277_/C AO211X2
XFILLER_8_142 VDD VSS DECAPHV32
XFILLER_9_654 VDD VSS DECAPHV32
X_12507_ _14233_/B _14233_/C _18285_/Q VDD VSS _12509_/C AOI21X1
X_16275_ _18844_/Q _18682_/Q VDD VSS _16276_/D NAND2X1
X_13487_ _18269_/Q _14213_/B _14213_/C VDD VSS _13488_/D NOR3BX1
XFILLER_126_530 VDD VSS FILLER1
XTAP_TAPCELL_ROW_3_60 VDD VSS WELLTAP
X_10699_ _10705_/A _10705_/B VDD VSS _10702_/A NOR2X1
X_12438_ _12438_/A _14173_/B _12518_/C _12438_/D VDD VSS _12743_/A OAOI211X1
X_18014_ _18016_/CK _18014_/D _18014_/Q VDD VSS DFFQX1
X_15226_ _15281_/A _18795_/Q VDD VSS _18768_/D AND2X1
X_12369_ _18233_/Q _12518_/B _12518_/C VDD VSS _12626_/B XNOR3X1
X_15157_ _15240_/A _18727_/Q VDD VSS _18700_/D AND2X1
XFILLER_113_235 VSS VDD FILLER2
XFILLER_45_1110 VDD VSS FILLER1
XFILLER_4_392 VDD VSS DECAPHV16
X_15088_ _15093_/A _15088_/B VDD VSS _18640_/D NOR2X1
X_14108_ _14361_/A VDD VSS _14108_/Y BUFX3
XFILLER_101_408 VDD VSS FILLER1
XFILLER_68_823 VDD VSS FILLER4
X_18916_ _18989_/CK _18916_/D _18916_/Q VDD VSS DFFQX1
X_14039_ _14107_/A _18987_/Q VDD VSS _18108_/D AND2X1
XFILLER_68_856 VDD VSS DECAPHV16
XFILLER_80_1045 VDD VSS FILLER4
XFILLER_95_675 VDD VSS DECAPHV8
X_18847_ _18848_/CK _18847_/D _18847_/Q VDD VSS DFFQX1
XFILLER_27_219 VDD VSS FILLER1
X_09580_ _17749_/Q VDD VSS _17515_/B INVX1
X_18778_ _18805_/CK _18778_/D _18778_/Q VDD VSS DFFQX1
X_17729_ _18990_/CK _17729_/D _17729_/Q VDD VSS DFFQX1
XFILLER_35_241 VDD VSS FILLER4
XFILLER_63_561 VSS VDD FILLER2
XTAP_TAPCELL_ROW_33_420 VDD VSS WELLTAP
XTAP_TAPCELL_ROW_61_751 VDD VSS WELLTAP
XFILLER_136_305 VDD VSS DECAPHV8
X_09014_ _17633_/Q _17426_/B VDD VSS _09037_/C NOR2X1
XFILLER_104_202 VDD VSS DECAPHV8
XFILLER_117_585 VDD VSS FILLER1
XTAP_TAPCELL_ROW_92_1124 VDD VSS WELLTAP
XFILLER_104_235 VSS VDD FILLER2
X_09916_ _09927_/A _10109_/B VDD VSS _10123_/C _09927_/C NAND3X1
XFILLER_85_152 VDD VSS FILLER1
XFILLER_86_675 VDD VSS FILLER1
XTAP_TAPCELL_ROW_69_851 VDD VSS WELLTAP
X_09847_ _09976_/A _10030_/B VDD VSS _17804_/D NOR2X1
XFILLER_100_496 VDD VSS DECAPHV8
XFILLER_85_163 VDD VSS DECAPHV8
X_09778_ _09778_/A _09778_/B VDD VSS _17387_/B XNOR2X1
XFILLER_26_230 VSS VDD FILLER2
XFILLER_27_753 VDD VSS FILLER1
XFILLER_61_509 VDD VSS FILLER1
XFILLER_14_403 VDD VSS FILLER1
XFILLER_15_915 VDD VSS FILLER4
XFILLER_27_786 VDD VSS FILLER4
XFILLER_2_1067 VSS VDD FILLER2
XFILLER_96_1063 VSS VDD FILLER2
X_11740_ _18304_/Q _14286_/A _14285_/B VDD VSS _11916_/B MIN3X1
XFILLER_15_959 VDD VSS FILLER1
XFILLER_42_756 VDD VSS FILLER4
XFILLER_57_1069 VDD VSS DECAPHV16
XFILLER_81_380 VDD VSS DECAPHV8
XFILLER_96_1096 VDD VSS FILLER4
XFILLER_41_255 VDD VSS FILLER1
XFILLER_42_789 VDD VSS FILLER1
XFILLER_53_88 VDD VSS FILLER4
XTAP_TAPCELL_ROW_101_1231 VDD VSS WELLTAP
X_11671_ _18225_/Q VDD VSS _11750_/A INVX1
X_10622_ _10625_/A _10625_/B VDD VSS _10761_/B XNOR2X1
X_14390_ _14542_/A VDD VSS _14414_/A BUFX3
X_13410_ _18269_/Q _13410_/B _13482_/C VDD VSS _13488_/C XNOR3X1
XFILLER_6_602 VSS VDD FILLER2
X_10553_ _10553_/A _10553_/B _10553_/C VDD VSS _10554_/D NOR3X1
X_13341_ _18502_/Q VDD VSS _13342_/A INVX1
XTAP_TAPCELL_ROW_11_147 VDD VSS WELLTAP
X_16060_ _16064_/A VDD VSS _16711_/A BUFX3
XFILLER_136_850 VDD VSS FILLER4
X_10484_ _17867_/Q _10493_/B _10487_/C VDD VSS _10661_/B XNOR3X1
X_13272_ _13444_/A _13444_/B _13444_/C VDD VSS _13332_/B AOI21X1
X_15011_ _18623_/Q _19001_/Q _15011_/C VDD VSS _15016_/C AO21X2
XFILLER_108_563 VDD VSS FILLER4
XFILLER_120_1072 VSS VDD FILLER2
XFILLER_123_522 VSS VDD FILLER2
XFILLER_5_189 VDD VSS DECAPHV32
X_12223_ _18204_/Q _14143_/B _14142_/C VDD VSS _12224_/D OR3BX1
XFILLER_118_81 VDD VSS DECAPHV32
X_12154_ _12335_/A _12335_/B _12335_/C VDD VSS _12165_/B AOI21X1
XFILLER_1_362 VDD VSS DECAPHV8
XFILLER_96_417 VDD VSS FILLER1
XFILLER_97_929 VDD VSS FILLER1
XTAP_TAPCELL_ROW_112_1360 VDD VSS WELLTAP
X_11105_ _11108_/C _11105_/B VDD VSS _17049_/B XNOR2X1
X_12085_ _18334_/Q _12110_/B _14291_/B VDD VSS _14322_/B XNOR3X1
X_18701_ _18808_/CK _18701_/D _18701_/Q VDD VSS DFFQX1
X_16962_ _16973_/A _16962_/B _16962_/C VDD VSS _18935_/D OAI21X1
XFILLER_92_601 VSS VDD FILLER2
X_11036_ _11135_/A _11169_/B VDD VSS _17991_/D NOR2X1
X_16893_ _18928_/Q _16898_/B VDD VSS _16895_/C XOR2X1
X_15913_ _18037_/Q _18647_/Q VDD VSS _15997_/B XNOR2X1
XFILLER_94_40 VDD VSS FILLER4
X_18632_ clkload1/A _18632_/D _18632_/Q VDD VSS DFFQX1
X_15844_ _18034_/Q _18644_/Q VDD VSS _15885_/C AND2X1
XFILLER_64_347 VSS VDD FILLER2
XFILLER_65_859 VDD VSS DECAPHV8
XFILLER_80_818 VDD VSS DECAPHV32
XFILLER_92_645 VSS VDD FILLER2
XTAP_TAPCELL_ROW_19_247 VDD VSS WELLTAP
X_18563_ clkload4/A _18563_/D _18563_/Q VDD VSS DFFQX1
X_15775_ _18778_/Q _18724_/Q VDD VSS _15781_/B XNOR2X1
XFILLER_18_797 VDD VSS FILLER4
XFILLER_45_561 VDD VSS FILLER1
XTAP_TAPCELL_ROW_47_578 VDD VSS WELLTAP
X_12987_ _12993_/A _14121_/B _13085_/C VDD VSS _14122_/C NOR3X1
X_17514_ _17514_/A _17748_/Q VDD VSS _17716_/D AND2X1
X_14726_ _14903_/A _14726_/B VDD VSS _18562_/D NOR2X1
XFILLER_32_211 VDD VSS DECAPHV16
XFILLER_33_723 VDD VSS FILLER4
XFILLER_91_199 VSS VDD FILLER2
X_11938_ _12032_/A _12123_/B VDD VSS _14169_/B XNOR2X1
X_18494_ _18496_/CK _18494_/D _18494_/Q VDD VSS DFFQX1
XFILLER_33_778 VDD VSS FILLER1
XFILLER_60_564 VSS VDD FILLER2
X_11869_ _12039_/B _14054_/C _18123_/Q VDD VSS _11870_/D AND3BX1
X_17445_ _17445_/A _17445_/B VDD VSS _17652_/D NOR2X1
X_14657_ _14657_/A _14657_/B VDD VSS _14658_/C NAND2X1
X_17376_ _17446_/A _17376_/B VDD VSS _17587_/D AND2X1
X_14588_ _14591_/A _14588_/B _14588_/C VDD VSS _18532_/D AOI21X1
X_13608_ _18375_/Q VDD VSS _13640_/A INVX1
XFILLER_119_806 VSS VDD FILLER2
XFILLER_13_491 VDD VSS DECAPHV8
XFILLER_9_462 VSS VDD FILLER2
X_16327_ _16327_/A _16327_/B _16327_/C _16327_/D VDD VSS _16405_/B AOAI211X1
X_13539_ _14336_/B _14336_/C _18373_/Q VDD VSS _13544_/B AOI21X1
X_19046_ _19051_/CK _19046_/D _19046_/Q VDD VSS DFFQX1
XFILLER_127_850 VDD VSS DECAPHV8
X_16258_ _16276_/A _16276_/C VDD VSS _16259_/B NOR2X1
X_16189_ _16193_/A _16193_/B wire30/A VDD VSS _16191_/C OAI21X1
X_15209_ _16984_/A _18778_/Q VDD VSS _18751_/D AND2X1
XFILLER_114_522 VDD VSS FILLER4
XFILLER_114_533 VSS VDD FILLER2
XFILLER_114_588 VDD VSS FILLER1
XFILLER_96_940 VSS VDD FILLER2
X_09701_ _17626_/Q _17418_/B VDD VSS _09714_/C XNOR2X1
XFILLER_67_141 VDD VSS DECAPHV8
XFILLER_68_675 VDD VSS FILLER4
XFILLER_96_995 VSS VDD FILLER2
XTAP_TAPCELL_ROW_66_810 VDD VSS WELLTAP
X_09632_ _17655_/Q _09632_/B _17449_/B VDD VSS _09643_/A MIN3X1
XTAP_TAPCELL_ROW_126_1529 VDD VSS WELLTAP
X_09563_ _09578_/A _17446_/B VDD VSS _09564_/B XNOR2X1
XFILLER_82_166 VDD VSS FILLER1
XFILLER_130_49 VDD VSS DECAPHV32
XFILLER_23_211 VDD VSS FILLER4
XFILLER_23_222 VDD VSS DECAPHV32
X_09494_ _17586_/Q _17375_/B VDD VSS _09495_/C NOR2X1
XFILLER_12_907 VSS VDD FILLER2
XFILLER_24_767 VSS VDD FILLER2
XFILLER_24_789 VDD VSS FILLER1
XFILLER_17_1020 VSS VDD FILLER2
XFILLER_23_288 VSS VDD FILLER2
XFILLER_23_36 VSS VDD FILLER2
XFILLER_20_962 VSS VDD FILLER2
XFILLER_104_1045 VDD VSS FILLER1
XFILLER_109_316 VDD VSS DECAPHV16
XFILLER_117_360 VSS VDD FILLER2
XFILLER_117_371 VDD VSS FILLER1
XFILLER_118_894 VDD VSS FILLER4
XFILLER_124_319 VSS VDD FILLER2
XFILLER_2_137 VSS VDD FILLER2
XFILLER_3_649 VSS VDD FILLER2
XFILLER_120_514 VDD VSS DECAPHV8
XFILLER_105_599 VSS VDD FILLER2
XFILLER_48_44 VSS VDD FILLER2
XFILLER_19_517 VSS VDD FILLER2
XFILLER_47_848 VSS VDD FILLER2
XFILLER_59_697 VSS VDD FILLER2
XFILLER_74_601 VSS VDD FILLER2
XFILLER_74_623 VDD VSS FILLER4
XFILLER_86_461 VDD VSS FILLER1
X_12910_ _18394_/Q _12935_/B _13021_/D VDD VSS _12949_/C XNOR3X1
X_13890_ _14434_/B _18458_/Q VDD VSS _13901_/A NAND2BX1
XFILLER_46_347 VDD VSS FILLER1
XFILLER_46_358 VDD VSS FILLER4
X_12841_ _13009_/A _13009_/B _13009_/D _13009_/C VDD VSS _14300_/C AOI211X1
XFILLER_27_561 VDD VSS FILLER4
XFILLER_64_32 VDD VSS DECAPHV8
XFILLER_15_734 VDD VSS DECAPHV8
XFILLER_70_840 VSS VDD FILLER2
XTAP_TAPCELL_ROW_16_206 VDD VSS WELLTAP
X_12772_ _18158_/Q VDD VSS _12773_/A INVX1
X_15560_ _15498_/Y _15612_/B _15572_/A VDD VSS _15560_/Y MUXI2X1
XTAP_TAPCELL_ROW_44_548 VDD VSS WELLTAP
XTAP_TAPCELL_ROW_72_879 VDD VSS WELLTAP
X_11723_ _18407_/Q _14377_/B VDD VSS _11724_/B OR2X2
X_15491_ _15491_/A _15504_/B VDD VSS _15492_/B NAND2X1
X_14511_ _14513_/B _14511_/B VDD VSS _14512_/B XOR2X1
XFILLER_42_597 VDD VSS FILLER4
X_11654_ _18354_/Q VDD VSS _11657_/A INVX1
X_17230_ _17396_/A VDD VSS _17323_/A BUFX3
X_14442_ _14451_/A _14442_/B VDD VSS _18465_/D NOR2X1
X_10605_ _10605_/A _10605_/B VDD VSS _10606_/B _10605_/C NAND3X1
Xfanout70 hold96/A VDD VSS _15286_/A BUFX3
Xfanout81 _16984_/A VDD VSS _15295_/A BUFX3
Xfanout92 _17260_/B VDD VSS _17232_/B BUFX3
X_17161_ _17163_/C _17161_/B VDD VSS _18990_/D NOR2X1
XFILLER_7_933 VDD VSS DECAPHV32
X_11585_ _18354_/Q _11657_/B _11588_/C VDD VSS _14344_/B XNOR3X1
Xclkbuf_1_0__f__000_ clkbuf_0__000_/Y VDD VSS clkload110/A BUFX12
X_16112_ _16112_/A _16112_/B VDD VSS _16114_/B XOR2X1
X_14373_ _14394_/A _14373_/B _14373_/C VDD VSS _18403_/D NOR3X1
XFILLER_6_421 VDD VSS DECAPHV32
X_10536_ _10687_/A _10687_/B _10688_/C VDD VSS _10692_/C OAI21X1
X_17092_ _18013_/Q _17092_/B VDD VSS _17095_/A AND2X1
X_13324_ _18372_/Q _13363_/B _13466_/D VDD VSS _14367_/C XNOR3X1
XFILLER_108_371 VDD VSS DECAPHV8
XFILLER_124_820 VDD VSS FILLER4
XFILLER_129_80 VDD VSS DECAPHV8
X_10467_ _10467_/A _10467_/B VDD VSS _10468_/C NAND2X1
X_13255_ _13354_/A _13444_/B VDD VSS _14423_/B XNOR2X1
X_16043_ _18040_/Q _18650_/Q VDD VSS _16045_/B XOR2X1
X_12206_ _12379_/B _12207_/C _18335_/Q VDD VSS _12375_/B AOI21X1
XFILLER_123_341 VDD VSS FILLER1
XFILLER_123_363 VDD VSS FILLER4
X_10398_ _10707_/A _10587_/B VDD VSS _17878_/D AND2X1
X_13186_ _13186_/A _13186_/B _13186_/C _13186_/D VDD VSS _13294_/B AOAI211X1
XFILLER_111_547 VDD VSS FILLER1
XFILLER_124_897 VDD VSS FILLER4
XFILLER_2_671 VDD VSS DECAPHV16
XFILLER_96_214 VDD VSS DECAPHV8
XFILLER_97_737 VDD VSS FILLER1
X_12137_ _12137_/A _12137_/B _12137_/C _12137_/D VDD VSS _12335_/A AOAI211X1
X_17994_ _18016_/CK _17994_/D _17994_/Q VDD VSS DFFQX1
XFILLER_49_130 VDD VSS FILLER4
X_12068_ _18177_/Q _14113_/B VDD VSS _12139_/C _14113_/C NAND3X1
X_16945_ _16973_/A _16945_/B _16945_/C VDD VSS _18933_/D OAI21X1
X_11019_ _17963_/Q VDD VSS _11025_/A INVX1
XFILLER_49_185 VDD VSS FILLER1
XFILLER_93_954 VDD VSS FILLER4
X_18615_ _18994_/CK _18615_/D _18615_/Q VDD VSS DFFQX1
X_16876_ _16947_/A _16957_/B VDD VSS _16946_/A AND2X1
XFILLER_64_177 VDD VSS DECAPHV8
XFILLER_93_998 VSS VDD FILLER2
X_15827_ _15828_/A _16120_/A _16147_/B VDD VSS _15829_/A NOR3X1
XFILLER_18_583 VDD VSS FILLER4
XFILLER_33_531 VDD VSS FILLER4
XFILLER_61_840 VDD VSS FILLER1
X_18546_ _18641_/CK _18546_/D _18546_/Q VDD VSS DFFQX1
X_15758_ _15874_/A _15874_/B _15874_/C _15874_/D VDD VSS _15865_/C AOI31X1
XFILLER_61_862 VDD VSS DECAPHV16
X_18477_ _18505_/CK _18477_/D _18477_/Q VDD VSS DFFQX1
X_15689_ _18883_/Q _15689_/B _15689_/C VDD VSS _15693_/C MIN3X1
X_14709_ _14710_/A _14710_/B _14710_/D _14710_/C VDD VSS _14712_/C AOI211X1
XFILLER_20_214 VDD VSS FILLER4
XFILLER_21_737 VDD VSS FILLER1
X_17428_ _17498_/A _17428_/B VDD VSS _17635_/D AND2X1
XFILLER_119_603 VSS VDD FILLER2
XFILLER_118_113 VDD VSS DECAPHV16
X_17359_ _17378_/A _17359_/B VDD VSS _17570_/D NOR2X1
X_19029_ _19033_/CK _19029_/D _19029_/Q VDD VSS DFFQX1
Xclkload62 _18313_/CK VDD VSS clkload62/Y INVX2
Xclkload51 _18267_/CK VDD VSS clkload51/Y BUFX12
Xclkload40 _18966_/CK VDD VSS clkload40/Y INVX2
XFILLER_127_680 VDD VSS FILLER1
Xclkload95 _19034_/CK VDD VSS clkload95/Y INVX2
Xclkload84 _17656_/CK VDD VSS clkload84/Y INVX1
Xclkload73 clkload73/A VDD VSS clkload73/Y BUFX12
XFILLER_88_704 VSS VDD FILLER2
XFILLER_102_514 VDD VSS DECAPHV16
XFILLER_114_385 VDD VSS FILLER1
XFILLER_88_759 VSS VDD FILLER2
XTAP_TAPCELL_ROW_132_1599 VDD VSS WELLTAP
X_08994_ _17727_/Q _08994_/B _08994_/C VDD VSS _08996_/A MIN3X1
XFILLER_96_770 VDD VSS FILLER1
XFILLER_56_634 VDD VSS FILLER4
X_09615_ _09632_/B _09615_/B VDD VSS _09630_/A XNOR2X1
XFILLER_43_306 VDD VSS DECAPHV8
XFILLER_44_818 VSS VDD FILLER2
XTAP_TAPCELL_ROW_87_1067 VDD VSS WELLTAP
XFILLER_24_520 VDD VSS FILLER1
XFILLER_71_648 VSS VDD FILLER2
XFILLER_93_1000 VDD VSS FILLER1
XFILLER_93_1022 VDD VSS FILLER1
X_09546_ _09544_/B _09546_/B _09546_/C VDD VSS _17775_/D AOI2B1X1
XFILLER_70_147 VDD VSS FILLER4
XFILLER_93_1033 VDD VSS DECAPHV16
X_09477_ _17746_/Q _17714_/Q VDD VSS _09502_/A XOR2X1
XFILLER_51_383 VDD VSS DECAPHV8
XTAP_TAPCELL_ROW_41_507 VDD VSS WELLTAP
Xclkload1 clkload1/A VDD VSS clkload1/Y BUFX12
XTAP_TAPCELL_ROW_21_275 VDD VSS WELLTAP
X_11370_ _18246_/Q _11418_/B _11374_/C VDD VSS _14216_/B XNOR3X1
XFILLER_109_179 VSS VDD FILLER2
XFILLER_125_617 VDD VSS DECAPHV8
XTAP_TAPCELL_ROW_98_1196 VDD VSS WELLTAP
X_10321_ _10503_/A _10503_/B _10503_/C _10504_/C VDD VSS _10511_/B AOAI211X1
XFILLER_106_831 VDD VSS DECAPHV8
X_13040_ _18448_/Q VDD VSS _13153_/A INVX1
XFILLER_106_886 VDD VSS FILLER1
XFILLER_121_801 VDD VSS FILLER4
XFILLER_3_468 VDD VSS DECAPHV32
XFILLER_59_32 VDD VSS DECAPHV32
XFILLER_65_1135 VDD VSS FILLER1
X_10252_ _10252_/A _10252_/B _10252_/C VDD VSS _10254_/A AOI21X1
XFILLER_133_694 VSS VDD FILLER2
X_10183_ _10351_/B _10183_/B _10183_/C _10183_/D VDD VSS _10364_/B OAOI211X1
XFILLER_120_344 VDD VSS FILLER4
XFILLER_94_707 VDD VSS DECAPHV8
X_14991_ _18619_/Q _18997_/Q VDD VSS _14992_/C NAND2X1
XFILLER_120_377 VDD VSS FILLER1
XFILLER_59_472 VSS VDD FILLER2
XTAP_TAPCELL_ROW_49_607 VDD VSS WELLTAP
XTAP_TAPCELL_ROW_77_938 VDD VSS WELLTAP
X_16730_ _16758_/C _16730_/B VDD VSS _16731_/B XNOR2X1
X_13942_ _18945_/Q _18946_/Q VDD VSS _13984_/B _13981_/B NAND3X1
XFILLER_46_111 VSS VDD FILLER2
XFILLER_47_645 VDD VSS FILLER4
XFILLER_75_64 VDD VSS DECAPHV16
XFILLER_75_943 VDD VSS FILLER1
XFILLER_35_829 VDD VSS FILLER4
XFILLER_47_689 VDD VSS FILLER4
XFILLER_74_464 VDD VSS DECAPHV8
XFILLER_75_998 VDD VSS DECAPHV16
X_16661_ _16688_/C _16688_/B VDD VSS _16662_/B NOR2BX1
X_13873_ _13876_/A _13876_/C _13876_/B _13873_/D VDD VSS _14406_/B OAOI211X1
XFILLER_28_881 VSS VDD FILLER2
XFILLER_34_328 VDD VSS DECAPHV16
XFILLER_61_125 VDD VSS DECAPHV8
XFILLER_62_648 VDD VSS DECAPHV16
XFILLER_74_486 VDD VSS DECAPHV16
XTAP_TAPCELL_ROW_29_364 VDD VSS WELLTAP
X_12824_ _18392_/Q _12824_/B VDD VSS _12827_/C _12824_/C NAND3X1
X_18400_ _18453_/CK _18400_/D _18400_/Q VDD VSS DFFQX1
X_16592_ _16629_/A _16629_/B _16592_/C VDD VSS _16594_/B AOI21X1
X_15612_ _15674_/A _15612_/B _15612_/C VDD VSS _15614_/B OA21X2
XFILLER_131_92 VDD VSS FILLER1
XFILLER_90_979 VDD VSS DECAPHV8
X_12755_ _12962_/A _12962_/B _12962_/C VDD VSS _12790_/B AOI21X1
X_18331_ _18381_/CK _18331_/D _18331_/Q VDD VSS DFFQX1
X_15543_ _18923_/Q _15543_/B VDD VSS _15543_/Y XOR2X1
XFILLER_43_884 VDD VSS FILLER1
X_11706_ _11706_/A _11706_/B _11779_/B _11706_/D VDD VSS _11954_/A OAOI211X2
X_18262_ _18313_/CK _18262_/D _18262_/Q VDD VSS DFFQX1
XFILLER_30_534 VDD VSS FILLER1
XFILLER_42_394 VDD VSS FILLER4
XFILLER_91_96 VDD VSS DECAPHV32
X_12686_ _18262_/Q _12866_/A _12962_/B VDD VSS _12845_/D XNOR3X1
X_15474_ _18868_/Q _15474_/B VDD VSS _15475_/C NAND2X1
X_11637_ _11637_/A _11637_/B _11637_/C _11637_/D VDD VSS _11706_/B OAOI211X1
X_18193_ _18271_/CK _18193_/D _18193_/Q VDD VSS DFFQX1
X_17213_ _17224_/A _17213_/B VDD VSS _19000_/D NOR2X1
X_14425_ _14431_/A _14425_/B _14425_/C VDD VSS _18451_/D NOR3X1
XFILLER_10_280 VDD VSS FILLER4
X_11568_ _11637_/D _11706_/A VDD VSS _11633_/D NOR2X1
X_17144_ _18023_/Q _17144_/B VDD VSS _17145_/C NOR2BX1
X_14356_ _14378_/A _14356_/B VDD VSS _18389_/D NOR2X1
XFILLER_128_488 VSS VDD FILLER2
X_10519_ _17872_/Q _10541_/A _10524_/C VDD VSS _10681_/C XNOR3X1
X_17075_ _17242_/A _17075_/B _17076_/C VDD VSS _18972_/D NOR3X1
X_13307_ _18215_/Q _14155_/B VDD VSS _13408_/A NOR2BX1
X_11499_ _11499_/A _14048_/B _11499_/C _11499_/D VDD VSS _11500_/A AO31X2
X_16026_ _15988_/A _16064_/C _16120_/A VDD VSS _16027_/B AOI2B1X1
X_14287_ _14313_/A _14287_/B VDD VSS _18330_/D NOR2X1
XFILLER_112_801 VSS VDD FILLER2
X_13238_ _18397_/Q _13269_/B _13350_/D VDD VSS _13278_/C XNOR3X1
XFILLER_123_160 VDD VSS DECAPHV16
XFILLER_97_512 VDD VSS FILLER4
X_13169_ _18343_/Q _14302_/B VDD VSS _13267_/A NAND2X1
XFILLER_111_355 VDD VSS FILLER4
XFILLER_84_206 VSS VDD FILLER2
X_17977_ _17982_/CK _17977_/D _17977_/Q VDD VSS DFFQX1
XFILLER_65_442 VDD VSS DECAPHV8
X_16928_ _18931_/Q _16928_/B _16928_/C VDD VSS _16942_/A AO21X2
XFILLER_38_667 VDD VSS FILLER4
XFILLER_53_615 VDD VSS FILLER4
XFILLER_66_998 VDD VSS DECAPHV8
XFILLER_81_913 VDD VSS DECAPHV16
XFILLER_92_261 VSS VDD FILLER2
X_16859_ _16859_/A _16867_/B VDD VSS _16864_/B XNOR2X1
XFILLER_52_103 VDD VSS FILLER4
XFILLER_92_294 VSS VDD FILLER2
X_09400_ _09417_/C _09400_/B VDD VSS _17406_/B OR2X2
XFILLER_53_659 VDD VSS DECAPHV8
X_09331_ _17612_/Q _17403_/B VDD VSS _09332_/C NOR2X1
X_18529_ clkload4/A _18529_/D _18529_/Q VDD VSS DFFQX1
XFILLER_21_523 VDD VSS DECAPHV8
X_09262_ _17610_/Q _17401_/B VDD VSS _09264_/C XNOR2X1
XFILLER_21_567 VDD VSS FILLER1
X_09193_ _09218_/A _09193_/B VDD VSS _17762_/D NOR2X1
XFILLER_88_1102 VSS VDD FILLER2
XFILLER_101_1026 VDD VSS FILLER1
XFILLER_119_477 VDD VSS FILLER1
XFILLER_135_926 VDD VSS FILLER4
XFILLER_88_1135 VDD VSS FILLER1
XTAP_TAPCELL_ROW_134_1628 VDD VSS WELLTAP
XFILLER_136_48 VDD VSS DECAPHV32
XFILLER_115_683 VDD VSS DECAPHV16
XFILLER_1_928 VSS VDD FILLER2
XFILLER_103_878 VSS VDD FILLER2
XFILLER_130_642 VDD VSS FILLER4
XFILLER_88_545 VDD VSS FILLER1
XFILLER_57_921 VDD VSS FILLER4
X_08977_ _17755_/Q VDD VSS _17521_/B INVX1
XFILLER_68_280 VDD VSS FILLER1
XFILLER_75_228 VDD VSS DECAPHV8
XFILLER_21_1038 VSS VDD FILLER2
XFILLER_29_678 VDD VSS DECAPHV16
XFILLER_72_913 VSS VDD FILLER2
XFILLER_84_773 VSS VDD FILLER2
XTAP_TAPCELL_ROW_74_908 VDD VSS WELLTAP
X_10870_ _17934_/Q _10870_/B VDD VSS _10874_/B NOR2X1
XFILLER_72_979 VDD VSS FILLER1
XTAP_TAPCELL_ROW_26_334 VDD VSS WELLTAP
X_09529_ _17747_/Q VDD VSS _17513_/B INVX1
XFILLER_25_873 VDD VSS FILLER1
XFILLER_40_810 VDD VSS FILLER1
XFILLER_43_169 VSS VDD FILLER2
XTAP_TAPCELL_ROW_54_665 VDD VSS WELLTAP
XFILLER_12_534 VDD VSS FILLER4
X_12540_ _18208_/Q _14147_/B VDD VSS _12743_/D _14147_/C NAND3X1
XFILLER_32_1101 VDD VSS FILLER4
XFILLER_40_865 VSS VDD FILLER2
X_12471_ _12469_/Y _12577_/B VDD VSS _14326_/B NAND2BX1
XFILLER_32_1134 VSS VDD FILLER2
XFILLER_61_88 VDD VSS FILLER4
X_11422_ _18220_/Q _11422_/B _11422_/C VDD VSS _11460_/B MIN3X1
X_15190_ _15274_/A _18759_/Q VDD VSS _18732_/D AND2X1
X_14210_ _14236_/A _14210_/B _14210_/C VDD VSS _18266_/D NOR3X1
XFILLER_4_700 VDD VSS DECAPHV32
X_14141_ _14160_/A _14141_/B VDD VSS _18203_/D NOR2X1
X_11353_ _18140_/Q _11353_/B VDD VSS _11354_/C _11353_/C NAND3X1
XFILLER_3_221 VDD VSS DECAPHV32
X_10304_ _17843_/Q VDD VSS _10306_/A INVX1
X_11284_ _18967_/Q _18088_/Q VDD VSS _11319_/D XOR2X1
X_14072_ _14083_/A _14072_/B VDD VSS _18140_/D NOR2X1
XFILLER_4_788 VSS VDD FILLER2
X_10235_ _10235_/A _10235_/B _17830_/Q VDD VSS _10239_/C AOI21X1
X_13023_ _13023_/A _13023_/B _13023_/C _13023_/D VDD VSS _13265_/A AOAI211X1
X_18880_ _18950_/CK _18880_/D _18880_/Q VDD VSS DFFQX1
X_17900_ _17901_/CK _17900_/D _17900_/Q VDD VSS DFFQX1
XFILLER_126_81 VDD VSS DECAPHV32
X_17831_ _17854_/CK _17831_/D _17831_/Q VDD VSS DFFQX1
XFILLER_48_910 VDD VSS FILLER4
XFILLER_66_217 VDD VSS DECAPHV8
XFILLER_79_589 VSS VDD FILLER2
X_10166_ _10166_/A _10166_/B VDD VSS _10176_/B NOR2X1
XFILLER_120_174 VDD VSS DECAPHV32
XFILLER_19_100 VDD VSS FILLER4
XFILLER_47_431 VDD VSS DECAPHV8
XTAP_TAPCELL_ROW_109_1321 VDD VSS WELLTAP
X_10097_ _17814_/Q _10099_/A _10099_/B VDD VSS _10276_/B XNOR3X1
X_17762_ _17867_/CK _17762_/D _17762_/Q VDD VSS DFFQX1
X_14974_ _18615_/Q _18993_/Q _14974_/C VDD VSS _14977_/B AOI21X1
XFILLER_47_453 VDD VSS FILLER1
XFILLER_47_464 VDD VSS FILLER1
XFILLER_48_998 VDD VSS DECAPHV8
XFILLER_75_773 VDD VSS FILLER4
XTAP_TAPCELL_ROW_109_1332 VDD VSS WELLTAP
X_17693_ _17725_/CK _17693_/D _17693_/Q VDD VSS DFFQX1
X_16713_ _18803_/Q _18749_/Q VDD VSS _16715_/C XNOR2X1
X_13925_ _13929_/A _13929_/B _13929_/C VDD VSS _14500_/A OA21X2
XFILLER_19_177 VDD VSS FILLER4
XFILLER_34_103 VSS VDD FILLER2
XFILLER_35_626 VSS VDD FILLER2
XFILLER_35_648 VSS VDD FILLER2
XFILLER_63_924 VDD VSS FILLER1
XFILLER_63_946 VDD VSS FILLER4
X_16644_ _16678_/A _16678_/B _16934_/A VDD VSS _16671_/A OAI21X1
X_13856_ _13867_/A _13867_/B _13887_/C VDD VSS _14497_/B AOI21BX1
XFILLER_50_607 VSS VDD FILLER2
XFILLER_74_294 VDD VSS FILLER1
X_12807_ _12807_/A _12807_/B _12807_/C VDD VSS _18041_/D AOI21X1
XFILLER_50_629 VDD VSS FILLER1
X_10999_ _11002_/A _11002_/B VDD VSS _11138_/B XNOR2X1
X_16575_ _16778_/A _16575_/B VDD VSS _16575_/Y NOR2X1
X_13787_ _13794_/A _13794_/B VDD VSS _14460_/C _13794_/C NAND3X1
X_12738_ _12640_/A _14205_/B _14205_/C VDD VSS _12845_/C AND3BX1
X_18314_ _18340_/CK _18314_/D _18314_/Q VDD VSS DFFQX1
X_15526_ _15526_/A VDD VSS _15572_/A BUFX3
XFILLER_124_1026 VDD VSS FILLER1
XTAP_TAPCELL_ROW_6_93 VDD VSS WELLTAP
X_12669_ _12669_/A _12669_/B _12756_/C _12669_/D VDD VSS _12899_/A OAOI211X1
X_18245_ _18271_/CK _18245_/D _18245_/Q VDD VSS DFFQX1
X_15457_ _18917_/Q _18916_/Q VDD VSS _15477_/B _15457_/C NAND3X1
XFILLER_128_230 VSS VDD FILLER2
X_14408_ _14414_/A _14408_/B VDD VSS _18435_/D NOR2X1
X_18176_ _18200_/CK _18176_/D _18176_/Q VDD VSS DFFQX1
X_15388_ _15388_/A VDD VSS _15801_/B BUFX3
XFILLER_7_593 VDD VSS DECAPHV32
X_17127_ _17127_/A _17127_/B _17127_/C VDD VSS _17132_/B OA21X2
X_14339_ _14339_/A _14339_/B _14339_/C VDD VSS _14340_/C NOR3X1
XFILLER_89_309 VSS VDD FILLER2
X_17058_ _17058_/A _17058_/B _17058_/C VDD VSS _17063_/B OAI21X1
X_08900_ _17732_/Q _18521_/Q VDD VSS _17536_/C XNOR2X1
X_09880_ _09886_/C _09880_/B _09880_/C VDD VSS _09881_/B OAI21X1
X_16009_ _18783_/Q _18729_/Q VDD VSS _16038_/A NAND2X1
XFILLER_32_0 VDD VSS DECAPHV32
XFILLER_97_342 VDD VSS FILLER1
XFILLER_100_815 VSS VDD FILLER2
XFILLER_100_859 VDD VSS FILLER1
XFILLER_111_185 VDD VSS FILLER1
XFILLER_38_442 VDD VSS FILLER1
XFILLER_38_475 VDD VSS DECAPHV8
XFILLER_93_592 VDD VSS FILLER1
XFILLER_25_136 VDD VSS FILLER4
XFILLER_80_231 VDD VSS FILLER1
XTAP_TAPCELL_ROW_84_1026 VDD VSS WELLTAP
XFILLER_13_309 VDD VSS FILLER1
XFILLER_15_48 VDD VSS FILLER4
XFILLER_34_670 VDD VSS DECAPHV8
XFILLER_40_106 VDD VSS FILLER1
XFILLER_90_1003 VDD VSS FILLER4
XTAP_TAPCELL_ROW_51_635 VDD VSS WELLTAP
X_09314_ _17676_/Q _17471_/B VDD VSS _09316_/C XNOR2X1
XFILLER_21_342 VDD VSS DECAPHV8
X_09245_ _19032_/Q _17332_/B VDD VSS _09271_/A OR2X2
XFILLER_21_375 VDD VSS DECAPHV32
XTAP_TAPCELL_ROW_31_392 VDD VSS WELLTAP
X_09176_ _09176_/A _09176_/B _17431_/B VDD VSS _09201_/B MIN3X1
XFILLER_134_222 VDD VSS DECAPHV8
XFILLER_107_458 VDD VSS FILLER4
XFILLER_123_918 VDD VSS DECAPHV8
XTAP_TAPCELL_ROW_95_1155 VDD VSS WELLTAP
Xoutput14 _18063_/Q VDD VSS data_out[1] BUFX3
Xoutput25 _18060_/Q VDD VSS valid_strobe BUFX3
XFILLER_134_299 VDD VSS DECAPHV16
XFILLER_1_747 VDD VSS DECAPHV32
X_10020_ _10222_/A _10222_/B VDD VSS _10228_/B _10223_/C NAND3X1
XFILLER_0_268 VSS VDD FILLER2
XFILLER_48_239 VDD VSS FILLER1
XFILLER_5_1021 VSS VDD FILLER2
XTAP_TAPCELL_ROW_59_724 VDD VSS WELLTAP
XFILLER_56_44 VSS VDD FILLER2
XFILLER_63_209 VSS VDD FILLER2
XFILLER_91_507 VDD VSS FILLER1
X_11971_ _18125_/Q _12255_/A _12161_/B VDD VSS _12065_/C XNOR3X1
XFILLER_72_710 VDD VSS DECAPHV8
XFILLER_99_1083 VDD VSS FILLER4
X_10922_ _10922_/A VDD VSS _11024_/A BUFX3
X_13710_ _18429_/Q _13728_/B _13751_/C VDD VSS _13734_/B XNOR3X1
XFILLER_17_648 VSS VDD FILLER2
XTAP_TAPCELL_ROW_39_481 VDD VSS WELLTAP
XTAP_TAPCELL_ROW_39_492 VDD VSS WELLTAP
X_14690_ _14693_/A _14693_/B _17544_/C VDD VSS _14691_/C OAI21X1
XFILLER_32_607 VDD VSS DECAPHV8
XFILLER_60_938 VDD VSS DECAPHV8
XFILLER_71_264 VDD VSS DECAPHV8
XFILLER_72_32 VDD VSS DECAPHV8
X_10853_ _10858_/A _10858_/B VDD VSS _10855_/A NAND2X1
X_13641_ _13674_/A _13674_/B VDD VSS _13643_/C _13674_/C NAND3X1
XFILLER_12_320 VDD VSS FILLER1
XTAP_TAPCELL_ROW_104_1262 VDD VSS WELLTAP
X_10784_ _10787_/C _10784_/B VDD VSS _10915_/B XNOR2X1
X_16360_ _18048_/Q _18658_/Q VDD VSS _16361_/B XOR2X1
X_13572_ _18349_/Q _13705_/A _13617_/B VDD VSS _13686_/D XNOR3X1
XFILLER_13_887 VDD VSS FILLER1
X_12523_ _14146_/B _14146_/C _18207_/Q VDD VSS _12525_/C AOI21X1
X_16291_ _16582_/A _16291_/B VDD VSS _16297_/B NAND2X1
X_15311_ _18052_/Q VDD VSS _16535_/A INVX1
XFILLER_40_673 VDD VSS FILLER1
XFILLER_8_324 VDD VSS FILLER1
X_18030_ _18863_/CK _18030_/D _18030_/Q VDD VSS DFFQX1
X_15242_ _15299_/A _18810_/Q VDD VSS _18783_/D AND2X1
X_12454_ _18129_/Q _14060_/B VDD VSS _12455_/D _14060_/C AND3X2
XFILLER_67_1005 VDD VSS DECAPHV8
X_11405_ _18117_/Q _11446_/D _11405_/C VDD VSS _11478_/C XNOR3X1
X_12385_ _12385_/A _12385_/B _14324_/B VDD VSS _12408_/C MIN3X1
X_15173_ _15313_/A _18743_/Q VDD VSS _18716_/D AND2X1
XFILLER_114_929 VDD VSS DECAPHV16
XFILLER_99_607 VDD VSS FILLER1
X_11336_ _18167_/Q VDD VSS _11342_/A INVX1
X_14124_ _17065_/A VDD VSS _14174_/A BUFX3
XFILLER_125_277 VSS VDD FILLER2
X_18932_ _18940_/CK _18932_/D _18932_/Q VDD VSS DFFQX1
X_14055_ _14055_/A _14055_/B _14055_/C VDD VSS _18124_/D AOI21X1
XFILLER_106_491 VDD VSS FILLER4
XFILLER_79_320 VDD VSS FILLER1
X_11267_ _18139_/Q _11326_/B _11351_/C VDD VSS _11272_/C XNOR3X1
X_13006_ _18265_/Q _13195_/A _13081_/B VDD VSS _13186_/D XNOR3X1
X_10218_ _10154_/Y _10407_/B _10407_/C VDD VSS _17852_/D AND3BX1
X_11198_ _11203_/A _11203_/B VDD VSS _11199_/B XNOR2X1
X_18863_ _18863_/CK _18863_/D _18863_/Q VDD VSS DFFQX1
XFILLER_39_228 VDD VSS DECAPHV16
XFILLER_94_323 VSS VDD FILLER2
X_10149_ _10149_/A _10149_/B _10149_/C VDD VSS _10156_/B XNOR3X1
X_18794_ _18821_/CK _18794_/D _18794_/Q VDD VSS DFFQX1
X_17814_ _17867_/CK _17814_/D _17814_/Q VDD VSS DFFQX1
XFILLER_43_1093 VDD VSS FILLER1
XFILLER_94_356 VDD VSS FILLER4
X_17745_ clkload3/A _17745_/D _17745_/Q VDD VSS DFFQX1
X_14957_ _14958_/C _17525_/B _14957_/C VDD VSS _18612_/D AND3BX1
XFILLER_35_445 VSS VDD FILLER2
X_17676_ _17706_/CK _17676_/D _17676_/Q VDD VSS DFFQX1
X_14888_ _14889_/A _14889_/B _14889_/D _14889_/C VDD VSS _14891_/C AOI211X1
X_13908_ _13913_/A _13913_/B _13909_/C _17388_/A VDD VSS _13909_/D OAI31X1
XFILLER_51_938 VDD VSS FILLER1
X_16627_ _16731_/A _16627_/B _16627_/C _16627_/D VDD VSS _16628_/B OAI211X1
X_13839_ _18431_/Q _14404_/B _14404_/C VDD VSS _13840_/D NOR3BX1
XFILLER_62_286 VDD VSS FILLER1
XFILLER_90_595 VSS VDD FILLER2
X_16558_ _16265_/Y _16804_/B _16800_/A VDD VSS _16568_/B MUXI2X1
X_15509_ _172_/E _15509_/B VDD VSS _15752_/C NOR2X1
XFILLER_31_673 VSS VDD FILLER2
XFILLER_31_695 VDD VSS FILLER1
X_09030_ _17729_/Q _17697_/Q VDD VSS _09031_/C NOR2BX1
X_16489_ _16490_/A _16490_/B _16490_/D _16490_/C VDD VSS _16530_/B AOAI211X1
XFILLER_30_183 VDD VSS FILLER1
X_18228_ _18253_/CK _18228_/D _18228_/Q VDD VSS DFFQX1
XFILLER_11_1026 VSS VDD FILLER2
XFILLER_8_891 VDD VSS FILLER4
X_18159_ _18250_/CK _18159_/D _18159_/Q VDD VSS DFFQX1
XFILLER_116_288 VSS VDD FILLER2
XFILLER_89_128 VDD VSS FILLER4
X_09932_ _10128_/A _10128_/B _10128_/C _10129_/C VDD VSS _10147_/B AOAI211X2
XFILLER_89_139 VDD VSS FILLER1
XFILLER_98_640 VDD VSS DECAPHV8
XFILLER_113_995 VSS VDD FILLER2
XFILLER_131_269 VDD VSS DECAPHV8
X_09863_ _17783_/Q _09863_/B VDD VSS _09864_/B NAND2X1
XFILLER_97_172 VDD VSS DECAPHV8
XTAP_TAPCELL_ROW_90_1096 VDD VSS WELLTAP
X_09794_ _17762_/Q _09891_/B VDD VSS _09896_/B XNOR2X1
XFILLER_85_345 VDD VSS FILLER1
XFILLER_85_367 VDD VSS FILLER4
XFILLER_27_935 VDD VSS FILLER1
XFILLER_39_784 VDD VSS FILLER1
XFILLER_73_529 VSS VDD FILLER2
XFILLER_26_434 VSS VDD FILLER2
XFILLER_26_456 VDD VSS DECAPHV16
XFILLER_54_754 VDD VSS FILLER1
XFILLER_54_765 VDD VSS FILLER4
XFILLER_14_607 VDD VSS DECAPHV32
XFILLER_53_242 VDD VSS FILLER1
XFILLER_81_551 VSS VDD FILLER2
XFILLER_81_573 VDD VSS DECAPHV8
XTAP_TAPCELL_ROW_36_451 VDD VSS WELLTAP
XTAP_TAPCELL_ROW_64_782 VDD VSS WELLTAP
XFILLER_107_1021 VSS VDD FILLER2
X_09228_ _17736_/Q _09228_/B _09228_/C VDD VSS _09256_/C MIN3X1
X_09159_ _09159_/A _09159_/B _09159_/C VDD VSS _09160_/B NOR3X1
X_12170_ _18309_/Q _12310_/A _12503_/B VDD VSS _12171_/D XNOR3X1
XFILLER_1_500 VDD VSS DECAPHV32
XTAP_TAPCELL_ROW_8_110 VDD VSS WELLTAP
X_11121_ _17982_/Q _11121_/B VDD VSS _11122_/C NOR2BX1
XFILLER_123_759 VDD VSS FILLER1
XFILLER_131_770 VDD VSS FILLER1
XFILLER_27_1022 VDD VSS FILLER1
XFILLER_67_32 VDD VSS DECAPHV32
X_11052_ _17968_/Q _11052_/B VDD VSS _11056_/A NOR2BX1
XFILLER_77_835 VSS VDD FILLER2
X_10003_ _10213_/A _10213_/B VDD VSS _10216_/B XNOR2X1
X_15860_ _15860_/A _15860_/B _15860_/C _15860_/D VDD VSS _15861_/C AOI31X1
XFILLER_92_816 VDD VSS DECAPHV16
X_14811_ _18581_/Q _18613_/Q VDD VSS _14812_/B XOR2X1
XFILLER_18_913 VSS VDD FILLER2
XFILLER_18_946 VSS VDD FILLER2
XFILLER_92_849 VDD VSS FILLER4
X_15791_ _16905_/B _15828_/A _15791_/C VDD VSS _15792_/C OAI21X1
XFILLER_44_231 VDD VSS FILLER1
XFILLER_45_754 VDD VSS DECAPHV8
X_11954_ _11954_/A _11954_/B _11954_/C _11954_/D VDD VSS _14054_/B AO211X2
X_17530_ _17530_/A _17530_/B VDD VSS _17531_/B XOR2X1
X_14742_ _18565_/Q _18597_/Q _14742_/C VDD VSS _14747_/C AO21X2
XFILLER_45_787 VDD VSS FILLER1
XFILLER_45_798 VDD VSS FILLER1
XFILLER_83_64 VDD VSS DECAPHV16
X_10905_ _10903_/B _10905_/B VDD VSS _10906_/C NOR2BX1
X_11885_ _11936_/A _12122_/D _11888_/C VDD VSS _11937_/C XNOR3X1
X_17461_ _17463_/A _17461_/B VDD VSS _17667_/D NOR2X1
X_14673_ _14972_/A _14673_/B _14675_/C VDD VSS _18551_/D NOR3X1
X_10836_ _17928_/Q _10840_/B VDD VSS _10841_/A XNOR2X1
X_16412_ _16412_/A _16412_/B VDD VSS _16413_/C NOR2X1
X_13624_ _18271_/Q VDD VSS _13625_/A INVX1
X_17392_ _17392_/A _17392_/B VDD VSS _17602_/D AND2X1
X_10767_ _17913_/Q _10772_/B VDD VSS _10769_/C XOR2X1
X_16343_ _18907_/Q _16348_/B VDD VSS _16345_/C XOR2X1
X_13555_ _13556_/A _13556_/B _13556_/D _13556_/C VDD VSS _14277_/B AOAI211X1
XFILLER_121_1018 VDD VSS FILLER4
XFILLER_12_194 VDD VSS FILLER1
XFILLER_34_1059 VDD VSS DECAPHV8
XTAP_TAPCELL_ROW_14_189 VDD VSS WELLTAP
X_10698_ _17900_/Q _10698_/B VDD VSS _10705_/A NOR2BX1
X_12506_ _12506_/A _12506_/B _12506_/C _12506_/D VDD VSS _14233_/B AOAI211X1
X_16274_ _16349_/A _16349_/B _16567_/A VDD VSS _16304_/A AOI21X1
X_13486_ _13486_/A _13486_/B _13486_/C _13486_/D VDD VSS _14213_/C OAOI211X1
XTAP_TAPCELL_ROW_117_1420 VDD VSS WELLTAP
XTAP_TAPCELL_ROW_3_50 VDD VSS WELLTAP
X_12437_ _12552_/B _14146_/C _18207_/Q VDD VSS _12438_/D AND3BX1
X_18013_ _18016_/CK _18013_/D _18013_/Q VDD VSS DFFQX1
X_15225_ _15281_/A _18794_/Q VDD VSS _18767_/D AND2X1
X_15156_ _15240_/A _18726_/Q VDD VSS _18699_/D AND2X1
XFILLER_4_360 VDD VSS DECAPHV32
XFILLER_5_872 VDD VSS DECAPHV32
X_12368_ _18207_/Q _12368_/B _12436_/C VDD VSS _12518_/C XNOR3X1
X_14107_ _14107_/A _14107_/B VDD VSS _18172_/D AND2X1
X_11319_ _11319_/A _11319_/B _11319_/C _11319_/D VDD VSS _14045_/B AOAI211X1
X_12299_ _12379_/A _12379_/B VDD VSS _12380_/B _12379_/C NAND3X1
X_15087_ _15090_/C _15087_/B VDD VSS _15088_/B XNOR2X1
X_18915_ _18989_/CK _18915_/D _18915_/Q VDD VSS DFFQX1
X_14038_ _17154_/A _18986_/Q VDD VSS _18107_/D AND2X1
XFILLER_41_1008 VSS VDD FILLER2
XFILLER_67_312 VDD VSS FILLER4
XFILLER_95_610 VDD VSS FILLER1
X_18846_ _18846_/CK _18846_/D _18846_/Q VDD VSS DFFQX1
XFILLER_110_965 VSS VDD FILLER2
XFILLER_67_367 VDD VSS FILLER4
XFILLER_80_1068 VDD VSS FILLER1
XFILLER_94_142 VDD VSS DECAPHV8
XFILLER_55_529 VDD VSS FILLER1
XFILLER_82_304 VSS VDD FILLER2
XTAP_TAPCELL_ROW_128_1560 VDD VSS WELLTAP
X_18777_ _18858_/CK _18777_/D _18777_/Q VDD VSS DFFQX1
X_15989_ _18898_/Q _15990_/B VDD VSS _16030_/D NAND2X1
X_17728_ _18990_/CK _17728_/D _17728_/Q VDD VSS DFFQX1
XFILLER_24_938 VDD VSS FILLER1
XFILLER_36_798 VDD VSS DECAPHV16
X_17659_ _17725_/CK _17659_/D _17659_/Q VDD VSS DFFQX1
XFILLER_17_990 VSS VDD FILLER2
XTAP_TAPCELL_ROW_33_410 VDD VSS WELLTAP
XFILLER_23_459 VDD VSS FILLER1
XTAP_TAPCELL_ROW_61_752 VDD VSS WELLTAP
XFILLER_12_49 VDD VSS FILLER4
X_09013_ _09028_/A _09013_/B VDD VSS _17426_/B XNOR2X1
XFILLER_128_49 VDD VSS DECAPHV32
XFILLER_105_704 VDD VSS DECAPHV16
XFILLER_117_597 VDD VSS FILLER1
XFILLER_132_501 VDD VSS DECAPHV8
XTAP_TAPCELL_ROW_92_1125 VDD VSS WELLTAP
XFILLER_105_759 VDD VSS DECAPHV16
XFILLER_132_589 VSS VDD FILLER2
XFILLER_99_960 VDD VSS DECAPHV8
X_09915_ _09915_/A _09926_/C VDD VSS _09927_/C XOR2X1
XFILLER_101_943 VDD VSS FILLER1
XFILLER_113_770 VDD VSS DECAPHV16
XFILLER_98_481 VDD VSS FILLER1
X_09846_ _17778_/Q _09846_/B VDD VSS _10030_/B XOR2X1
XTAP_TAPCELL_ROW_69_841 VDD VSS WELLTAP
XTAP_TAPCELL_ROW_69_852 VDD VSS WELLTAP
XFILLER_85_175 VSS VDD FILLER2
X_09777_ _17629_/Q _17421_/B VDD VSS _09778_/B XOR2X1
XFILLER_26_220 VSS VDD FILLER2
XFILLER_42_702 VDD VSS FILLER1
XFILLER_42_713 VDD VSS FILLER4
XFILLER_57_1004 VDD VSS DECAPHV8
XFILLER_81_392 VSS VDD FILLER2
XTAP_TAPCELL_ROW_101_1232 VDD VSS WELLTAP
X_11670_ _18251_/Q _11670_/B _11670_/C VDD VSS _11843_/A MIN3X1
XFILLER_41_289 VSS VDD FILLER2
X_10621_ _17885_/Q _10624_/B VDD VSS _10625_/B XNOR2X1
XFILLER_128_818 VSS VDD FILLER2
XFILLER_22_492 VSS VDD FILLER2
X_10552_ _10553_/B _10553_/C _10553_/A VDD VSS _10554_/C OAI21X1
X_13340_ _15309_/A _13340_/B VDD VSS _18046_/D AND2X1
XFILLER_10_687 VDD VSS DECAPHV8
XTAP_TAPCELL_ROW_11_148 VDD VSS WELLTAP
X_13271_ _18423_/Q _14395_/B VDD VSS _13444_/C _14395_/C AND3X2
XFILLER_120_1051 VDD VSS FILLER4
X_10483_ _17866_/Q _10483_/B _10483_/C VDD VSS _10487_/C MIN3X1
X_12222_ _18230_/Q _14171_/B _14171_/C VDD VSS _12227_/D OR3BX1
X_15010_ _15011_/C _17554_/C _15010_/C VDD VSS _18623_/D AND3BX1
XFILLER_64_1008 VDD VSS FILLER4
X_12153_ _12153_/A _14086_/B _14086_/C VDD VSS _12335_/C NOR3X1
XTAP_TAPCELL_ROW_112_1361 VDD VSS WELLTAP
X_11104_ _17979_/Q _11108_/B VDD VSS _11105_/B XNOR2X1
X_12084_ _18308_/Q _12171_/A _14259_/B VDD VSS _14291_/B XNOR3X1
X_16961_ _18935_/Q _16972_/B VDD VSS _16962_/C NAND2X1
XFILLER_2_886 VDD VSS DECAPHV32
XFILLER_49_312 VDD VSS FILLER4
XFILLER_78_97 VDD VSS DECAPHV8
X_11035_ _11038_/A _11038_/B VDD VSS _11169_/B XNOR2X1
X_18700_ _18808_/CK _18700_/D _18700_/Q VDD VSS DFFQX1
X_15912_ _15912_/A _15912_/B _15912_/C _15912_/D VDD VSS _15972_/A AOAI211X1
XFILLER_65_816 VSS VDD FILLER2
XFILLER_77_654 VSS VDD FILLER2
X_16892_ _16892_/A _16892_/B VDD VSS _16898_/B XNOR2X1
XFILLER_134_81 VDD VSS DECAPHV32
XFILLER_40_1041 VDD VSS FILLER4
XFILLER_64_304 VDD VSS DECAPHV8
X_18631_ _19011_/CK _18631_/D _18631_/Q VDD VSS DFFQX1
X_15843_ _18035_/Q _18645_/Q VDD VSS _15885_/D XOR2X1
X_12986_ _13094_/A _13094_/B _13085_/C VDD VSS _14122_/B AOI21BX1
X_18562_ clkload7/A _18562_/D _18562_/Q VDD VSS DFFQX1
X_15774_ _18864_/Q _15800_/B VDD VSS _15917_/A NAND2X1
XFILLER_18_765 VDD VSS FILLER4
XFILLER_27_90 VSS VDD FILLER2
XFILLER_91_178 VSS VDD FILLER2
XTAP_TAPCELL_ROW_19_248 VDD VSS WELLTAP
XTAP_TAPCELL_ROW_47_579 VDD VSS WELLTAP
X_17513_ _17518_/A _17513_/B VDD VSS _17715_/D NOR2X1
X_14725_ _14729_/C _14725_/B VDD VSS _14726_/B XNOR2X1
XFILLER_75_1126 VDD VSS FILLER4
X_11937_ _11937_/A _11937_/B _11937_/C _11937_/D VDD VSS _12118_/A OAOI211X1
X_18493_ _18493_/CK _18493_/D _18493_/Q VDD VSS DFFQX1
XFILLER_21_919 VDD VSS FILLER4
XTAP_TAPCELL_ROW_123_1490 VDD VSS WELLTAP
X_11868_ _11954_/A _11954_/B _11954_/D _11954_/C VDD VSS _14054_/C AOAI211X1
X_17444_ _17514_/A _17444_/B VDD VSS _17651_/D AND2X1
X_14656_ _14657_/A _14657_/B VDD VSS _14659_/C NOR2X1
X_10819_ _10824_/A _10824_/B VDD VSS _10956_/B XNOR2X1
X_11799_ _18253_/Q _11929_/A _11841_/B VDD VSS _11800_/D XNOR3X1
X_17375_ _17378_/A _17375_/B VDD VSS _17586_/D NOR2X1
X_14587_ _14591_/A _14588_/B _17266_/C VDD VSS _14588_/C OAI21X1
X_13607_ _18428_/Q VDD VSS _13680_/A INVX1
XFILLER_119_818 VDD VSS FILLER4
X_16326_ _16326_/A _16326_/B VDD VSS _16328_/C NOR2X1
X_13538_ _13597_/A _13597_/B _13597_/C VDD VSS _13593_/B AOI21X1
XFILLER_118_317 VDD VSS FILLER1
XFILLER_118_328 VDD VSS DECAPHV8
X_19045_ _19045_/CK _19045_/D _19045_/Q VDD VSS DFFQX1
XFILLER_127_840 VDD VSS FILLER1
X_16257_ _18843_/Q _18681_/Q _16257_/C _16257_/D _16257_/E VDD VSS _16276_/C AOI221X1
X_13469_ _18373_/Q _14336_/B VDD VSS _13639_/C _14336_/C AND3X2
XFILLER_99_201 VSS VDD FILLER2
X_16188_ _18903_/Q _16192_/B VDD VSS _16193_/B XNOR2X1
X_15208_ _15286_/A _18777_/Q VDD VSS _18750_/D AND2X1
XFILLER_126_383 VSS VDD FILLER2
XFILLER_82_1119 VDD VSS FILLER1
X_15139_ _15304_/A _18709_/Q VDD VSS _18682_/D AND2X1
XFILLER_114_556 VDD VSS DECAPHV8
XFILLER_99_256 VDD VSS FILLER1
XFILLER_99_278 VDD VSS FILLER1
XFILLER_101_217 VSS VDD FILLER2
XFILLER_68_632 VSS VDD FILLER2
X_09700_ _09716_/A _09716_/B VDD VSS _17418_/B XNOR2X1
XFILLER_110_751 VSS VDD FILLER2
XFILLER_96_974 VSS VDD FILLER2
XTAP_TAPCELL_ROW_66_811 VDD VSS WELLTAP
X_09631_ _17623_/Q _09631_/B _17415_/B VDD VSS _09658_/A MIN3X1
X_18829_ _18856_/CK _18829_/D _18829_/Q VDD VSS DFFQX1
XFILLER_83_668 VDD VSS FILLER1
X_09562_ _09585_/B _09562_/B VDD VSS _17446_/B XNOR2X1
XFILLER_64_882 VDD VSS FILLER1
X_09493_ _09493_/A _09493_/B _09493_/C VDD VSS _09519_/A AOI21X1
XFILLER_1_1090 VDD VSS DECAPHV16
XFILLER_23_267 VDD VSS FILLER4
XFILLER_56_1081 VDD VSS DECAPHV8
XFILLER_23_59 VDD VSS DECAPHV8
XFILLER_17_1087 VDD VSS DECAPHV8
XFILLER_20_974 VSS VDD FILLER2
XFILLER_20_985 VDD VSS FILLER1
XFILLER_136_125 VDD VSS DECAPHV8
XFILLER_105_545 VSS VDD FILLER2
XFILLER_105_556 VSS VDD FILLER2
XFILLER_120_504 VDD VSS FILLER4
XFILLER_63_1052 VSS VDD FILLER2
XFILLER_78_429 VDD VSS FILLER4
XFILLER_99_790 VDD VSS FILLER1
XFILLER_120_559 VDD VSS FILLER4
XFILLER_24_1036 VSS VDD FILLER2
XFILLER_47_805 VDD VSS FILLER4
XFILLER_58_142 VDD VSS FILLER4
XFILLER_59_654 VDD VSS DECAPHV8
XFILLER_100_250 VSS VDD FILLER2
XFILLER_101_762 VDD VSS FILLER1
XFILLER_111_1006 VSS VDD FILLER2
XFILLER_46_304 VDD VSS FILLER1
XFILLER_48_89 VDD VSS FILLER4
XFILLER_59_676 VDD VSS FILLER1
XFILLER_86_473 VDD VSS FILLER4
XFILLER_87_985 VDD VSS DECAPHV8
X_09829_ _17771_/Q _17772_/Q VDD VSS _09832_/B _09829_/C NAND3X1
XFILLER_100_272 VDD VSS FILLER1
XFILLER_104_40 VDD VSS FILLER4
XFILLER_73_112 VDD VSS DECAPHV8
X_12840_ _12840_/A _12840_/B _12840_/C _12840_/D VDD VSS _14300_/B OAOI211X1
XFILLER_55_860 VDD VSS FILLER1
XFILLER_64_44 VSS VDD FILLER2
XFILLER_73_167 VDD VSS DECAPHV8
XFILLER_27_573 VDD VSS FILLER1
XFILLER_42_510 VDD VSS FILLER1
XFILLER_55_882 VDD VSS FILLER4
XFILLER_82_690 VSS VDD FILLER2
XTAP_TAPCELL_ROW_16_207 VDD VSS WELLTAP
X_12771_ _18185_/Q VDD VSS _13088_/A INVX1
XTAP_TAPCELL_ROW_44_549 VDD VSS WELLTAP
X_11722_ _18409_/Q VDD VSS _12103_/A INVX1
X_15490_ _15490_/A _15490_/B _15490_/C _18869_/Q VDD VSS _15504_/B AO31X2
X_14510_ _18517_/Q _18549_/Q VDD VSS _14511_/B XOR2X1
XFILLER_30_716 VDD VSS FILLER1
XFILLER_80_32 VDD VSS DECAPHV8
X_11653_ _18381_/Q _11653_/B _11653_/C VDD VSS _11825_/B MIN3X1
X_14441_ _14542_/A VDD VSS _14451_/A BUFX3
XFILLER_11_952 VSS VDD FILLER2
X_10604_ _10605_/A _10605_/B _10605_/C VDD VSS _10611_/B AOI21X1
Xfanout60 _17043_/A VDD VSS _17059_/C BUFX3
Xfanout71 _17388_/A VDD VSS _15313_/A BUFX3
Xfanout82 _15299_/A VDD VSS _15272_/A BUFX3
X_17160_ _18989_/Q _17160_/B _17525_/B VDD VSS _17161_/B OAI21X1
X_14372_ _14372_/A _14372_/B VDD VSS _18402_/D AND2X1
XFILLER_122_1135 VDD VSS FILLER1
X_11584_ _18328_/Q _11661_/B _11656_/C VDD VSS _11588_/C XNOR3X1
Xfanout93 input1/Y VDD VSS _17260_/B BUFX3
X_16111_ _15865_/A _16110_/Y _16196_/A VDD VSS _16112_/B MUXI2X1
X_13323_ _18346_/Q _13473_/A _13375_/B VDD VSS _13466_/D XNOR3X1
XFILLER_13_92 VDD VSS FILLER1
X_10535_ _10553_/A _10535_/B _10535_/C VDD VSS _10688_/C XNOR3X1
X_17091_ _17242_/A _17091_/B _17095_/B VDD VSS _18975_/D NOR3X1
XFILLER_129_92 VDD VSS FILLER1
X_10466_ _17863_/Q VDD VSS _10468_/A INVX1
X_13254_ _13254_/A _13337_/A _14453_/B VDD VSS _13515_/A MIN3X1
Xclkbuf_leaf_19_clk_fs_regs clkbuf_leaf_5_clk_fs_regs/A VDD VSS clkload6/A BUFX12
X_16042_ _16042_/A _16042_/B _16042_/C _16042_/D VDD VSS _16096_/A AOAI211X1
X_12205_ _18361_/Q _12205_/B _14323_/B VDD VSS _12385_/B MIN3X1
X_13185_ _14209_/B _18265_/Q VDD VSS _13294_/A NAND2BX1
XFILLER_89_96 VDD VSS DECAPHV32
X_10397_ _10582_/B _10582_/C VDD VSS _10587_/B XNOR2X1
X_12136_ _18151_/Q _14085_/B _14085_/C VDD VSS _12137_/D OR3BX1
XFILLER_1_160 VDD VSS DECAPHV16
XFILLER_96_237 VDD VSS FILLER1
X_17993_ _17993_/CK _17993_/D _17993_/Q VDD VSS DFFQX1
XFILLER_38_805 VDD VSS FILLER1
X_12067_ _14113_/B _14113_/C _18177_/Q VDD VSS _12139_/B AOI21X1
X_16944_ _18933_/Q _16972_/B VDD VSS _16945_/C NAND2X1
XFILLER_38_838 VSS VDD FILLER2
XFILLER_77_484 VDD VSS FILLER1
X_11018_ _11024_/A _11154_/B VDD VSS _17988_/D NOR2X1
X_16875_ _16875_/A _16875_/B _16875_/C VDD VSS _18926_/D OAI21X1
XFILLER_37_337 VDD VSS FILLER4
XFILLER_92_421 VSS VDD FILLER2
X_18614_ _18994_/CK _18614_/D _18614_/Q VDD VSS DFFQX1
X_15826_ _16155_/A _16076_/A _15984_/C _15984_/D VDD VSS _16147_/B AND4X2
XFILLER_52_307 VDD VSS DECAPHV8
XFILLER_92_476 VDD VSS FILLER4
XFILLER_33_510 VDD VSS DECAPHV8
XFILLER_46_882 VDD VSS FILLER1
XFILLER_79_1070 VDD VSS FILLER4
XFILLER_79_1092 VDD VSS DECAPHV16
X_12969_ _18291_/Q VDD VSS _13177_/A INVX1
X_18545_ _18641_/CK _18545_/D _18545_/Q VDD VSS DFFQX1
X_15757_ _18861_/Q _18862_/Q VDD VSS _15874_/D NOR2X1
X_18476_ _18505_/CK _18476_/D _18476_/Q VDD VSS DFFQX1
X_15688_ _15693_/A _15693_/B VDD VSS _15690_/A XNOR2X1
X_14708_ _18559_/Q _18591_/Q VDD VSS _14710_/D XNOR2X1
XFILLER_21_716 VDD VSS FILLER4
XFILLER_33_587 VDD VSS FILLER4
XFILLER_60_373 VDD VSS FILLER1
X_17427_ _17445_/A _17427_/B VDD VSS _17634_/D NOR2X1
X_14639_ _14639_/A _14639_/B _14639_/C VDD VSS _14645_/C OA21X2
XFILLER_20_259 VDD VSS DECAPHV16
X_17358_ _17378_/A _17358_/B VDD VSS _17569_/D NOR2X1
XFILLER_119_648 VSS VDD FILLER2
XFILLER_9_282 VDD VSS DECAPHV8
X_17289_ _17323_/A _17289_/B VDD VSS _19014_/D NOR2X1
X_16309_ _16973_/A _16345_/B _16309_/C _16309_/D VDD VSS _18906_/D OAI31X1
XFILLER_106_309 VSS VDD FILLER2
XFILLER_62_0 VDD VSS DECAPHV32
X_19028_ _19028_/CK _19028_/D _19028_/Q VDD VSS DFFQX1
Xclkload52 _18461_/CK VDD VSS clkload52/Y INVX1
Xclkload41 _18988_/CK VDD VSS clkload41/Y INVX2
Xclkload30 _18295_/CK VDD VSS clkload30/Y INVX1
XFILLER_133_128 VDD VSS DECAPHV32
Xclkload96 _19036_/CK VDD VSS clkload96/Y BUFX12
Xclkload85 _17722_/CK VDD VSS clkload85/Y INVX2
Xclkload74 clkload74/A VDD VSS clkload74/Y INVX14
Xclkload63 _18261_/CK VDD VSS clkload63/Y INVX1
Xclkbuf_leaf_19__002_ clkbuf_leaf_9__002_/A VDD VSS _18267_/CK BUFX12
XFILLER_86_1074 VDD VSS FILLER1
XFILLER_114_397 VDD VSS FILLER1
X_08993_ _17695_/Q VDD VSS _08994_/B INVX1
XFILLER_29_827 VSS VDD FILLER2
XFILLER_69_985 VDD VSS FILLER1
XFILLER_96_782 VDD VSS FILLER1
XFILLER_95_292 VSS VDD FILLER2
XFILLER_96_793 VSS VDD FILLER2
X_09614_ _17655_/Q _17449_/B VDD VSS _09615_/B XOR2X1
XFILLER_55_167 VDD VSS FILLER1
XTAP_TAPCELL_ROW_87_1057 VDD VSS WELLTAP
XTAP_TAPCELL_ROW_87_1068 VDD VSS WELLTAP
XFILLER_110_1072 VSS VDD FILLER2
XFILLER_58_1132 VDD VSS FILLER4
X_09545_ _17453_/A _09548_/B VDD VSS _09546_/C NAND2X1
XFILLER_51_340 VDD VSS DECAPHV8
XFILLER_52_863 VDD VSS FILLER1
X_09476_ _09476_/A _09476_/B _09476_/C VDD VSS _09482_/A AOI21X1
XFILLER_24_587 VDD VSS FILLER1
XTAP_TAPCELL_ROW_41_508 VDD VSS WELLTAP
Xclkload2 clkload2/A VDD VSS clkload2/Y INVX2
XFILLER_20_793 VDD VSS DECAPHV8
XTAP_TAPCELL_ROW_21_265 VDD VSS WELLTAP
XTAP_TAPCELL_ROW_21_276 VDD VSS WELLTAP
XFILLER_118_670 VSS VDD FILLER2
XFILLER_30_1051 VDD VSS DECAPHV16
XTAP_TAPCELL_ROW_98_1197 VDD VSS WELLTAP
X_10320_ _17844_/Q _10324_/B _10330_/B VDD VSS _10504_/C XNOR3X1
XFILLER_106_843 VDD VSS FILLER1
XFILLER_117_180 VDD VSS FILLER1
X_10251_ _17833_/Q _10251_/B VDD VSS _10252_/C NOR2BX1
XFILLER_79_716 VDD VSS FILLER1
XFILLER_105_375 VDD VSS DECAPHV8
X_10182_ _10187_/A _10187_/B VDD VSS _10364_/A NOR2X1
XFILLER_59_88 VDD VSS FILLER4
X_14990_ _14992_/A _14992_/B _14990_/C VDD VSS _18619_/D AOI21X1
XFILLER_87_760 VDD VSS FILLER4
XFILLER_8_1063 VDD VSS FILLER4
XTAP_TAPCELL_ROW_49_608 VDD VSS WELLTAP
XTAP_TAPCELL_ROW_77_939 VDD VSS WELLTAP
X_13941_ _18944_/Q _13975_/B VDD VSS _13981_/B NOR2BX1
XFILLER_74_421 VDD VSS FILLER4
XFILLER_75_32 VDD VSS DECAPHV32
XFILLER_75_933 VDD VSS DECAPHV8
XFILLER_34_307 VDD VSS DECAPHV8
XFILLER_74_476 VSS VDD FILLER2
XFILLER_90_903 VSS VDD FILLER2
XFILLER_90_925 VDD VSS FILLER1
X_16660_ _18828_/Q _18720_/Q VDD VSS _16688_/B NOR2X1
X_13872_ _18406_/Q _14376_/B VDD VSS _13873_/D AND2X1
XFILLER_43_830 VDD VSS FILLER1
XTAP_TAPCELL_ROW_29_365 VDD VSS WELLTAP
X_12823_ _12824_/B _12824_/C _18392_/Q VDD VSS _12827_/B AOI21X1
X_16591_ _16629_/A _16591_/B VDD VSS _16592_/C NOR2X1
X_15611_ _15685_/A _15662_/B _15662_/C _15674_/A VDD VSS _15612_/C OAI211X1
XFILLER_61_137 VSS VDD FILLER2
XFILLER_90_969 VDD VSS FILLER4
X_12754_ _12859_/A _14178_/B _14178_/C VDD VSS _12962_/C NOR3X1
X_18330_ _18381_/CK _18330_/D _18330_/Q VDD VSS DFFQX1
X_15542_ _18922_/Q _15556_/C VDD VSS _15543_/B NAND2X1
XFILLER_15_576 VDD VSS DECAPHV8
XFILLER_91_64 VDD VSS DECAPHV16
X_11705_ _18974_/Q _18095_/Q VDD VSS _11706_/D AND2X1
X_18261_ _18261_/CK _18261_/D _18261_/Q VDD VSS DFFQX1
XTAP_TAPCELL_ROW_120_1460 VDD VSS WELLTAP
X_12685_ _18236_/Q _12859_/B _12859_/C VDD VSS _12962_/B XNOR3X1
X_17212_ _17214_/B _17212_/B VDD VSS _17213_/B XOR2X1
X_15473_ _15669_/A _15473_/B _15473_/C VDD VSS _18868_/D OAI21X1
XFILLER_30_568 VDD VSS FILLER1
X_11636_ _18974_/Q _18095_/Q VDD VSS _11779_/B XOR2X1
X_18192_ _18271_/CK _18192_/D _18192_/Q VDD VSS DFFQX1
X_14424_ _14431_/A _14424_/B _14424_/C VDD VSS _18450_/D NOR3X1
XFILLER_128_456 VDD VSS DECAPHV16
XFILLER_7_742 VSS VDD FILLER2
X_11567_ _18973_/Q _18094_/Q VDD VSS _11706_/A AND2X1
X_17143_ _17224_/A _17143_/B VDD VSS _18985_/D NOR2X1
X_14355_ _14378_/A _14355_/B VDD VSS _18388_/D NOR2X1
XFILLER_116_607 VSS VDD FILLER2
XFILLER_116_629 VDD VSS FILLER1
XFILLER_6_230 VSS VDD FILLER2
X_10518_ _10523_/A _10525_/B _10525_/C VDD VSS _10680_/C AND3BX1
X_17074_ _17074_/A _17074_/B _17074_/C VDD VSS _17076_/C OA21X2
X_14286_ _14286_/A _14286_/B VDD VSS _14287_/B XNOR2X1
X_13306_ _13405_/A _13382_/C VDD VSS _14155_/B XNOR2X1
XFILLER_115_128 VDD VSS DECAPHV32
X_11498_ _18971_/Q _18092_/Q VDD VSS _11499_/D NOR2X1
X_13237_ _18371_/Q _13371_/A _13466_/B VDD VSS _13350_/D XNOR3X1
X_16025_ _16109_/A _16340_/B _16340_/C _16196_/A VDD VSS _16064_/D OAI211X1
X_10449_ _17860_/Q _10449_/B VDD VSS _10457_/A NAND2X1
XFILLER_69_215 VDD VSS FILLER1
X_13168_ _18370_/Q VDD VSS _13273_/A INVX1
XFILLER_111_334 VDD VSS FILLER4
XFILLER_112_879 VDD VSS FILLER4
X_12119_ _12216_/A _12216_/B _12216_/D _12216_/C VDD VSS _14229_/C AOI211X1
X_13099_ _13120_/A _13120_/B _13120_/C _13099_/D VDD VSS _13303_/A OAOI211X1
X_17976_ _18003_/CK _17976_/D _17976_/Q VDD VSS DFFQX1
XFILLER_38_602 VSS VDD FILLER2
X_16927_ _18931_/Q _16927_/B _16927_/C _16927_/D VDD VSS _18931_/D AO22X2
XFILLER_65_410 VDD VSS FILLER1
XFILLER_77_270 VSS VDD FILLER2
XFILLER_84_229 VSS VDD FILLER2
X_16858_ _16701_/Y _16939_/B _16947_/A VDD VSS _16867_/B MUXI2X1
XFILLER_129_1119 VDD VSS DECAPHV16
XFILLER_25_318 VDD VSS FILLER4
XFILLER_53_627 VSS VDD FILLER2
XFILLER_65_498 VDD VSS FILLER1
X_16789_ _16522_/Y _16900_/B _16800_/A VDD VSS _16790_/A MUXI2X1
X_15809_ _18778_/Q _18724_/Q VDD VSS _15850_/A AND2X1
XFILLER_52_137 VSS VDD FILLER2
XFILLER_80_435 VDD VSS FILLER1
XFILLER_80_446 VDD VSS FILLER1
X_09330_ _09323_/B _09330_/B _09330_/C VDD VSS _09354_/A AOI2B1X1
X_18528_ clkload7/A _18528_/D _18528_/Q VDD VSS DFFQX1
XFILLER_33_340 VDD VSS FILLER4
XFILLER_33_351 VSS VDD FILLER2
X_09261_ _09261_/A _09278_/B VDD VSS _17401_/B XNOR2X1
XFILLER_21_546 VSS VDD FILLER2
X_18459_ _18484_/CK _18459_/D _18459_/Q VDD VSS DFFQX1
X_09192_ _09194_/B _09192_/B VDD VSS _09193_/B XNOR2X1
XFILLER_119_423 VDD VSS FILLER1
XFILLER_119_434 VSS VDD FILLER2
XFILLER_14_1046 VDD VSS DECAPHV8
XFILLER_107_607 VDD VSS FILLER1
XTAP_TAPCELL_ROW_134_1629 VDD VSS WELLTAP
XFILLER_20_49 VDD VSS FILLER4
XFILLER_103_835 VSS VDD FILLER2
XFILLER_102_378 VDD VSS FILLER1
XFILLER_25_1131 VDD VSS FILLER1
XFILLER_60_1033 VDD VSS DECAPHV8
X_08976_ _17756_/Q _18545_/Q VDD VSS _08980_/A XOR2X1
XFILLER_28_123 VDD VSS DECAPHV8
XFILLER_56_421 VDD VSS FILLER4
XFILLER_84_730 VDD VSS FILLER1
XFILLER_84_763 VDD VSS FILLER4
XTAP_TAPCELL_ROW_74_909 VDD VSS WELLTAP
XFILLER_28_167 VDD VSS DECAPHV16
XFILLER_43_104 VSS VDD FILLER2
XFILLER_56_476 VSS VDD FILLER2
XFILLER_71_457 VDD VSS FILLER1
XFILLER_71_468 VDD VSS FILLER4
XTAP_TAPCELL_ROW_26_335 VDD VSS WELLTAP
X_09528_ _17748_/Q _17716_/Q VDD VSS _09531_/A XNOR2X1
XFILLER_12_502 VDD VSS FILLER4
XTAP_TAPCELL_ROW_54_666 VDD VSS WELLTAP
XTAP_TAPCELL_ROW_82_997 VDD VSS WELLTAP
XFILLER_40_822 VDD VSS DECAPHV8
X_09459_ _09459_/A _09459_/B VDD VSS _09460_/B _09459_/C NAND3X1
XFILLER_101_96 VDD VSS DECAPHV32
X_12470_ _12502_/A _12502_/B VDD VSS _12577_/B _12502_/C NAND3X1
X_11421_ _11421_/A _11421_/B _14159_/B VDD VSS _11422_/B MIN3X1
XFILLER_125_404 VDD VSS FILLER4
XFILLER_20_590 VDD VSS FILLER4
X_11352_ _11353_/B _11353_/C _18140_/Q VDD VSS _11354_/B AOI21X1
X_14140_ _14174_/A _14140_/B _14140_/C VDD VSS _18202_/D NOR3X1
XFILLER_125_448 VSS VDD FILLER2
X_10303_ _10488_/A _10488_/B _10489_/C _10303_/D VDD VSS _10498_/B OAOI211X1
X_11283_ _11319_/A _11319_/B _11319_/C VDD VSS _11296_/B AOI21X1
X_14071_ _14083_/A _14071_/B VDD VSS _18139_/D NOR2X1
XFILLER_106_662 VDD VSS DECAPHV8
XFILLER_10_71 VDD VSS FILLER1
XFILLER_3_277 VSS VDD FILLER2
X_10234_ _17830_/Q _10235_/A VDD VSS _10239_/D _10235_/B NAND3X1
X_13022_ _18394_/Q _14362_/B VDD VSS _13023_/D _14362_/C NAND3X1
XFILLER_121_654 VDD VSS FILLER4
X_10165_ _10165_/A _10349_/B _10165_/C _10165_/D VDD VSS _10356_/A AOAI211X1
X_17830_ _17851_/CK _17830_/D _17830_/Q VDD VSS DFFQX1
XFILLER_120_142 VDD VSS DECAPHV32
X_10096_ _17814_/Q _10102_/B VDD VSS _10311_/A AND2X1
X_17761_ _17867_/CK _17761_/D _17761_/Q VDD VSS DFFQX1
X_14973_ _18616_/Q _18994_/Q VDD VSS _14975_/B XOR2X1
XFILLER_19_145 VDD VSS FILLER1
XFILLER_63_914 VDD VSS DECAPHV8
XFILLER_90_700 VSS VDD FILLER2
XTAP_TAPCELL_ROW_109_1322 VDD VSS WELLTAP
X_17692_ _17725_/CK _17692_/D _17692_/Q VDD VSS DFFQX1
X_16712_ _18802_/Q _18748_/Q VDD VSS _16715_/D NAND2X1
X_13924_ _13935_/A _13924_/B _13924_/C VDD VSS _18057_/D AOI21X1
XFILLER_19_189 VDD VSS DECAPHV8
XFILLER_62_402 VDD VSS DECAPHV16
X_16643_ _16638_/A _16643_/B VDD VSS _16674_/B NOR2BX1
X_13855_ _13884_/A _13884_/B _13855_/C VDD VSS _18054_/D AOI21X1
XFILLER_16_841 VSS VDD FILLER2
XFILLER_16_852 VDD VSS DECAPHV16
XFILLER_63_969 VDD VSS DECAPHV8
X_12806_ _12807_/A _12807_/B _14423_/A VDD VSS _12807_/C OAI21X1
XFILLER_62_479 VDD VSS DECAPHV8
XFILLER_90_788 VSS VDD FILLER2
X_10998_ _10998_/A _10998_/B _10998_/C VDD VSS _11002_/B MIN3X1
X_18313_ _18313_/CK _18313_/D _18313_/Q VDD VSS DFFQX1
X_16574_ _16620_/A _16574_/B VDD VSS _16575_/B XNOR2X1
X_13786_ _13815_/A _13786_/B _13786_/C VDD VSS _13794_/C XNOR3X1
XFILLER_31_822 VDD VSS FILLER1
X_12737_ _12846_/A _12846_/B _12846_/D _12846_/C VDD VSS _14236_/B OAOI211X1
X_15525_ _16731_/A VDD VSS _15695_/A BUFX3
XTAP_TAPCELL_ROW_6_94 VDD VSS WELLTAP
X_12668_ _18157_/Q _14092_/B VDD VSS _12669_/D _14092_/C AND3X2
X_18244_ _18295_/CK _18244_/D _18244_/Q VDD VSS DFFQX1
X_15456_ _15374_/Y _15401_/B _15480_/A VDD VSS _15533_/B MUXI2X1
XFILLER_30_365 VDD VSS FILLER1
XFILLER_30_398 VDD VSS FILLER1
X_11619_ _18172_/Q _11766_/A _11766_/B VDD VSS _11621_/C XNOR3X1
X_18175_ _18200_/CK _18175_/D _18175_/Q VDD VSS DFFQX1
X_14407_ _15300_/A _14407_/B VDD VSS _18434_/D AND2X1
X_12599_ _12706_/A _12706_/B _14417_/B VDD VSS _12810_/B MIN3X1
X_17126_ _17127_/A _17127_/B _17127_/C VDD VSS _17128_/B NOR3X1
X_15387_ _18863_/Q _16784_/A VDD VSS _15388_/A OR2X2
XFILLER_116_437 VSS VDD FILLER2
XFILLER_117_949 VDD VSS FILLER4
XFILLER_129_798 VDD VSS DECAPHV8
XFILLER_7_561 VDD VSS DECAPHV32
X_14338_ _14394_/A _14339_/B _14338_/C VDD VSS _18375_/D NOR3X1
X_17057_ _17058_/A _17058_/B _17058_/C VDD VSS _17057_/Y NOR3X1
X_14269_ _14269_/A _14269_/B VDD VSS _18318_/D NOR2X1
XFILLER_125_971 VDD VSS FILLER1
XFILLER_131_429 VDD VSS DECAPHV8
XFILLER_48_1131 VDD VSS FILLER4
X_16008_ _16047_/A _16047_/B _16047_/C _16326_/A VDD VSS _16013_/B AOI31X1
XFILLER_44_1028 VDD VSS DECAPHV32
XFILLER_25_0 VDD VSS DECAPHV32
XFILLER_85_505 VDD VSS DECAPHV8
XFILLER_98_888 VDD VSS FILLER1
XFILLER_111_164 VSS VDD FILLER2
X_17959_ _17961_/CK _17959_/D _17959_/Q VDD VSS DFFQX1
XFILLER_65_240 VDD VSS DECAPHV8
XFILLER_38_487 VSS VDD FILLER2
XFILLER_53_402 VSS VDD FILLER2
XFILLER_54_936 VDD VSS FILLER4
XFILLER_20_1061 VDD VSS DECAPHV8
XFILLER_20_1072 VSS VDD FILLER2
XFILLER_26_649 VDD VSS FILLER4
XFILLER_80_221 VDD VSS DECAPHV8
XTAP_TAPCELL_ROW_84_1027 VDD VSS WELLTAP
XFILLER_25_159 VSS VDD FILLER2
XFILLER_34_660 VSS VDD FILLER2
XFILLER_41_619 VDD VSS FILLER1
X_09313_ _09313_/A _09338_/C VDD VSS _17471_/B XNOR2X1
XFILLER_22_822 VDD VSS DECAPHV16
XFILLER_34_682 VDD VSS FILLER1
XFILLER_55_1135 VDD VSS FILLER1
XTAP_TAPCELL_ROW_51_625 VDD VSS WELLTAP
XTAP_TAPCELL_ROW_51_636 VDD VSS WELLTAP
X_09244_ _09244_/A _09244_/B _09244_/C VDD VSS _17764_/D AOI21X1
XFILLER_21_365 VSS VDD FILLER2
X_09175_ _17638_/Q VDD VSS _09176_/A INVX1
XFILLER_31_48 VDD VSS FILLER4
XTAP_TAPCELL_ROW_31_393 VDD VSS WELLTAP
XFILLER_107_437 VDD VSS FILLER1
XTAP_TAPCELL_ROW_95_1156 VDD VSS WELLTAP
Xoutput15 _18082_/Q VDD VSS data_out[20] BUFX3
XFILLER_134_267 VDD VSS DECAPHV32
XFILLER_89_866 VDD VSS FILLER4
XFILLER_102_142 VDD VSS FILLER4
XFILLER_49_708 VDD VSS FILLER1
XFILLER_130_484 VDD VSS DECAPHV16
XFILLER_29_421 VDD VSS DECAPHV16
XTAP_TAPCELL_ROW_59_725 VDD VSS WELLTAP
X_08959_ _17751_/Q _18540_/Q _08959_/C VDD VSS _08963_/B MIN3X1
XFILLER_57_763 VDD VSS FILLER4
X_11970_ _12054_/A _14054_/B _12054_/C _12054_/D VDD VSS _12161_/B AO31X2
XFILLER_84_571 VDD VSS FILLER4
X_10921_ _11062_/A _11059_/B VDD VSS _17969_/D AND2X1
XFILLER_112_40 VDD VSS FILLER4
XFILLER_16_126 VDD VSS DECAPHV8
XFILLER_60_906 VDD VSS FILLER1
XTAP_TAPCELL_ROW_39_482 VDD VSS WELLTAP
XFILLER_25_671 VDD VSS DECAPHV16
XFILLER_60_928 VDD VSS FILLER4
XFILLER_71_276 VSS VDD FILLER2
XFILLER_72_44 VSS VDD FILLER2
X_10852_ _10849_/A _10852_/B VDD VSS _10858_/B NAND2BX1
X_13640_ _13640_/A _13640_/B _13686_/D VDD VSS _13674_/C XNOR3X1
XFILLER_24_170 VDD VSS DECAPHV8
XTAP_TAPCELL_ROW_104_1263 VDD VSS WELLTAP
X_10783_ _17916_/Q _10787_/B VDD VSS _10784_/B XNOR2X1
X_13571_ _18323_/Q _13611_/B _13621_/C VDD VSS _13617_/B XOR3X1
XFILLER_13_877 VDD VSS FILLER4
XFILLER_40_641 VDD VSS FILLER4
XFILLER_9_804 VDD VSS DECAPHV8
X_12522_ _12522_/A _12522_/B _12522_/C _12522_/D VDD VSS _14146_/B AOAI211X1
X_16290_ _16315_/A _16290_/B VDD VSS _16291_/B XNOR2X1
X_15310_ _15310_/A _18051_/Q VDD VSS _18850_/D AND2X1
XFILLER_40_696 VDD VSS FILLER1
XFILLER_8_314 VDD VSS DECAPHV8
X_15241_ _15272_/A _18809_/Q VDD VSS _18782_/D AND2X1
X_12453_ _12453_/A _12453_/B _12453_/C _12453_/D VDD VSS _14060_/C AOAI211X1
X_11404_ _11446_/A _11446_/B _11446_/C VDD VSS _11405_/C AOI21X1
X_12384_ _12411_/A _12411_/B VDD VSS _14324_/B XNOR2X1
X_15172_ _15313_/A _18742_/Q VDD VSS _18715_/D AND2X1
XFILLER_114_908 VDD VSS FILLER1
XFILLER_21_70 VSS VDD FILLER2
XFILLER_67_1017 VDD VSS FILLER1
X_11335_ _18193_/Q VDD VSS _11420_/A INVX1
X_14123_ _14396_/A _14123_/B VDD VSS _18187_/D AND2X1
XFILLER_113_429 VDD VSS DECAPHV8
XFILLER_98_129 VSS VDD FILLER2
X_11266_ _11275_/A _11281_/D VDD VSS _11351_/C XNOR2X1
X_18931_ _18940_/CK _18931_/D _18931_/Q VDD VSS DFFQX1
X_14054_ _10382_/Y _14054_/B _14054_/C VDD VSS _18123_/D AND3BX1
XFILLER_106_481 VDD VSS FILLER1
X_10217_ _10221_/A _10395_/B _10405_/C VDD VSS _10407_/C OR3BX1
X_13005_ _18239_/Q _13005_/B _13120_/C VDD VSS _13081_/B XNOR3X1
XFILLER_97_96 VDD VSS DECAPHV16
X_11197_ _17997_/Q VDD VSS _11203_/A INVX1
X_18862_ _18863_/CK _18862_/D _18862_/Q VDD VSS DFFQX1
XFILLER_95_836 VDD VSS FILLER1
X_10148_ _10148_/A _10148_/B _10322_/C _10148_/D VDD VSS _10324_/B OAOI211X1
X_18793_ _18821_/CK _18793_/D _18793_/Q VDD VSS DFFQX1
X_17813_ _17867_/CK _17813_/D _17813_/Q VDD VSS DFFQX1
XFILLER_48_763 VDD VSS FILLER1
X_10079_ _17811_/Q _10087_/B VDD VSS _10083_/C NOR2X1
X_17744_ clkload3/A _17744_/D _17744_/Q VDD VSS DFFQX1
X_14956_ _14956_/A _14956_/B VDD VSS _14957_/C NAND2X1
XFILLER_130_1053 VDD VSS DECAPHV16
XFILLER_47_251 VDD VSS DECAPHV8
X_13907_ _18512_/Q _14499_/B VDD VSS _13909_/C XNOR2X1
XFILLER_35_424 VDD VSS FILLER4
XFILLER_78_1135 VDD VSS FILLER1
X_17675_ _17706_/CK _17675_/D _17675_/Q VDD VSS DFFQX1
X_14887_ _18597_/Q _18629_/Q VDD VSS _14889_/D XNOR2X1
XFILLER_35_468 VSS VDD FILLER2
XFILLER_62_265 VDD VSS FILLER1
XFILLER_63_788 VDD VSS FILLER1
X_16626_ _16658_/C _16626_/B _16626_/C _16626_/D VDD VSS _16627_/D OA211X2
X_13838_ _13838_/A _13838_/B _13838_/C _13838_/D VDD VSS _14404_/C OAOI211X1
X_16557_ _16414_/B _16700_/B _16869_/A VDD VSS _16804_/B MUXI2X1
X_13769_ _13790_/A _14403_/B VDD VSS _13786_/C XNOR2X1
X_15508_ _15736_/B VDD VSS _15792_/D BUFX3
X_18227_ _18253_/CK _18227_/D _18227_/Q VDD VSS DFFQX1
X_16488_ _18911_/Q _16488_/B VDD VSS _16490_/C XNOR2X1
X_15439_ _16757_/A _16757_/D VDD VSS _15483_/A NOR2X1
XFILLER_117_713 VDD VSS FILLER4
X_18158_ _18171_/CK _18158_/D _18158_/Q VDD VSS DFFQX1
XFILLER_105_919 VSS VDD FILLER2
XFILLER_116_223 VDD VSS DECAPHV8
X_18089_ _18971_/CK _18089_/D _18089_/Q VDD VSS DFFQX1
X_17109_ _18016_/Q _17109_/B VDD VSS _17112_/A NOR2BX1
XFILLER_132_716 VDD VSS FILLER4
XFILLER_132_727 VDD VSS DECAPHV16
X_09931_ _09931_/A _09936_/C VDD VSS _10129_/C XNOR2X1
XFILLER_113_952 VDD VSS FILLER1
XFILLER_100_602 VSS VDD FILLER2
XFILLER_113_963 VDD VSS DECAPHV32
XFILLER_98_652 VSS VDD FILLER2
XFILLER_98_685 VSS VDD FILLER2
X_09862_ _09976_/A _10069_/A VDD VSS _17809_/D NOR2X1
XFILLER_97_184 VSS VDD FILLER2
XFILLER_98_696 VDD VSS FILLER1
XTAP_TAPCELL_ROW_90_1097 VDD VSS WELLTAP
X_09793_ _17759_/Q _17758_/Q _17760_/Q _17761_/Q VDD VSS _09891_/B AND4X2
XFILLER_22_1101 VDD VSS FILLER4
XFILLER_22_1134 VSS VDD FILLER2
XFILLER_39_774 VDD VSS DECAPHV8
XFILLER_39_796 VSS VDD FILLER2
XFILLER_66_560 VSS VDD FILLER2
XFILLER_27_958 VSS VDD FILLER2
XFILLER_53_232 VDD VSS DECAPHV8
XFILLER_42_928 VDD VSS FILLER1
XFILLER_54_788 VSS VDD FILLER2
XTAP_TAPCELL_ROW_36_452 VDD VSS WELLTAP
XFILLER_107_1000 VDD VSS FILLER1
XFILLER_13_129 VDD VSS DECAPHV8
XTAP_TAPCELL_ROW_64_783 VDD VSS WELLTAP
XFILLER_50_950 VDD VSS FILLER1
XFILLER_10_814 VDD VSS FILLER1
XFILLER_21_162 VDD VSS FILLER1
XFILLER_22_696 VDD VSS FILLER1
XFILLER_10_847 VDD VSS FILLER4
XFILLER_10_858 VDD VSS FILLER1
XFILLER_21_184 VSS VDD FILLER2
X_09227_ _17704_/Q VDD VSS _09228_/B INVX1
X_09158_ _09159_/A _09159_/B _09159_/C VDD VSS _09203_/B OAI21X1
X_09089_ _09089_/A _09089_/B _09089_/C _09089_/D VDD VSS _09090_/C AOAI211X1
XFILLER_107_278 VDD VSS FILLER1
XFILLER_135_576 VDD VSS DECAPHV8
XTAP_TAPCELL_ROW_8_111 VDD VSS WELLTAP
X_11120_ _11135_/A _17066_/B VDD VSS _18008_/D NOR2X1
XFILLER_123_749 VDD VSS FILLER1
XFILLER_104_974 VSS VDD FILLER2
XFILLER_1_556 VSS VDD FILLER2
XFILLER_7_1106 VDD VSS DECAPHV8
X_11051_ _11135_/A _11184_/A VDD VSS _17994_/D NOR2X1
XFILLER_27_1067 VDD VSS FILLER4
XFILLER_88_162 VDD VSS DECAPHV8
X_10002_ _10005_/A _10005_/B VDD VSS _10213_/B XOR2X1
XFILLER_64_508 VSS VDD FILLER2
XFILLER_67_88 VDD VSS FILLER4
X_14810_ _18580_/Q _18612_/Q _14810_/C VDD VSS _14814_/B AOI21X1
XFILLER_29_251 VSS VDD FILLER2
XFILLER_85_891 VSS VDD FILLER2
XFILLER_91_305 VDD VSS FILLER1
X_15790_ _18893_/Q VDD VSS _15791_/C INVX1
XFILLER_83_32 VDD VSS DECAPHV32
X_11953_ _11953_/A _11953_/B _12023_/C _11953_/D VDD VSS _12139_/A OAOI211X1
X_14741_ _14742_/C _17266_/C _14741_/C VDD VSS _18565_/D AND3BX1
XFILLER_17_479 VSS VDD FILLER2
XFILLER_33_906 VSS VDD FILLER2
XFILLER_44_254 VDD VSS FILLER1
XFILLER_45_766 VDD VSS FILLER1
X_10904_ _11062_/A _11045_/B VDD VSS _17966_/D AND2X1
X_11884_ _11929_/A _11929_/B _11929_/C VDD VSS _11888_/C OAI21X1
X_17460_ _17498_/A _17460_/B VDD VSS _17666_/D AND2X1
X_14672_ _14671_/B _14672_/B VDD VSS _14675_/C NOR2BX1
XFILLER_26_991 VSS VDD FILLER2
X_10835_ _10844_/A _10969_/A VDD VSS _17953_/D NOR2X1
X_17391_ _17395_/A _17391_/B VDD VSS _17601_/D NOR2X1
X_16411_ _16411_/A _16411_/B _16411_/C VDD VSS _16413_/B OAI21X1
X_13623_ _13705_/A _13705_/B _13705_/E VDD VSS _13688_/B OA21X2
X_16342_ _16342_/A _16349_/D VDD VSS _16348_/B XNOR2X1
XFILLER_34_1027 VDD VSS DECAPHV32
X_10766_ _10766_/A _10766_/B VDD VSS _10769_/B AND2X1
X_13554_ _13686_/A _13686_/B _13686_/C VDD VSS _13640_/B AOI21X1
X_10697_ _10731_/A _10832_/B VDD VSS _17926_/D NOR2X1
X_12505_ _18259_/Q _12528_/A _12626_/B VDD VSS _12506_/D XNOR3X1
X_16273_ _16273_/A _16273_/B _16273_/C VDD VSS _16307_/A MIN3X1
X_13485_ _18243_/Q _13491_/A _13491_/B VDD VSS _13486_/D XOR3X1
XTAP_TAPCELL_ROW_117_1421 VDD VSS WELLTAP
XTAP_TAPCELL_ROW_3_51 VDD VSS WELLTAP
X_12436_ _12436_/A _12436_/B _12436_/C _12436_/D VDD VSS _14146_/C OAI211X1
X_18012_ _18024_/CK _18012_/D _18012_/Q VDD VSS DFFQX1
X_15224_ _15307_/A _18793_/Q VDD VSS _18766_/D AND2X1
XFILLER_5_840 VDD VSS DECAPHV32
X_15155_ _15240_/A _18725_/Q VDD VSS _18698_/D AND2X1
XFILLER_114_705 VDD VSS DECAPHV8
XFILLER_126_565 VDD VSS FILLER4
XFILLER_99_405 VDD VSS FILLER4
XFILLER_99_427 VSS VDD FILLER2
X_12367_ _18181_/Q _12653_/A _12653_/B VDD VSS _12436_/C XNOR3X1
X_14106_ _14122_/A _14106_/B _14106_/C VDD VSS _18171_/D NOR3X1
XFILLER_113_215 VDD VSS DECAPHV16
X_11318_ _18967_/Q _18088_/Q VDD VSS _11356_/A NAND2X1
X_12298_ _12376_/A _12298_/B _12503_/D VDD VSS _12379_/C XNOR3X1
X_15086_ _18640_/Q _19018_/Q VDD VSS _15087_/B XNOR2X1
XFILLER_79_151 VDD VSS FILLER4
X_11249_ _11263_/A _11263_/B _11263_/C VDD VSS _14043_/C NOR3X1
X_18914_ _18989_/CK _18914_/D _18914_/Q VDD VSS DFFQX1
X_14037_ _17154_/A _18985_/Q VDD VSS _18106_/D AND2X1
XFILLER_122_782 VDD VSS FILLER1
XFILLER_122_793 VDD VSS DECAPHV8
XFILLER_132_1104 VDD VSS DECAPHV32
XFILLER_68_836 VSS VDD FILLER2
XFILLER_95_633 VSS VDD FILLER2
X_18845_ _18846_/CK _18845_/D _18845_/Q VDD VSS DFFQX1
XFILLER_79_195 VDD VSS DECAPHV8
XFILLER_94_121 VDD VSS FILLER4
XFILLER_36_700 VDD VSS FILLER1
XTAP_TAPCELL_ROW_128_1550 VDD VSS WELLTAP
X_18776_ _18857_/CK _18776_/D _18776_/Q VDD VSS DFFQX1
X_15988_ _15988_/A _15988_/B VDD VSS _15990_/B XOR2X1
XFILLER_82_349 VDD VSS FILLER1
X_17727_ _18547_/CK _17727_/D _17727_/Q VDD VSS DFFQX1
X_14939_ _18608_/Q _18640_/Q VDD VSS _14941_/B XNOR2X1
XFILLER_63_563 VDD VSS FILLER1
XFILLER_91_872 VDD VSS FILLER4
X_17658_ _17725_/CK _17658_/D _17658_/Q VDD VSS DFFQX1
XFILLER_63_585 VDD VSS FILLER4
XTAP_TAPCELL_ROW_33_411 VDD VSS WELLTAP
X_16609_ _16609_/A _16649_/C VDD VSS _16627_/B XNOR2X1
XFILLER_16_490 VDD VSS FILLER4
XFILLER_50_235 VSS VDD FILLER2
XFILLER_92_0 VDD VSS DECAPHV32
XTAP_TAPCELL_ROW_61_753 VDD VSS WELLTAP
X_17589_ _17656_/CK _17589_/D _17589_/Q VDD VSS DFFQX1
XFILLER_129_370 VSS VDD FILLER2
XFILLER_136_318 VDD VSS DECAPHV32
X_09012_ _17665_/Q _17459_/B VDD VSS _09013_/B XOR2X1
XFILLER_117_521 VSS VDD FILLER2
XFILLER_89_1050 VDD VSS FILLER1
XTAP_TAPCELL_ROW_92_1126 VDD VSS WELLTAP
XFILLER_104_226 VDD VSS FILLER4
XFILLER_104_237 VDD VSS FILLER1
XFILLER_101_900 VSS VDD FILLER2
XFILLER_132_557 VDD VSS DECAPHV8
X_09914_ _09914_/A _09914_/B VDD VSS _09927_/A OR2X2
XFILLER_101_933 VDD VSS DECAPHV8
XFILLER_86_633 VDD VSS FILLER1
X_09845_ _17777_/Q _09848_/C VDD VSS _09846_/B NAND2X1
XFILLER_100_432 VDD VSS FILLER1
XFILLER_58_346 VDD VSS DECAPHV16
XTAP_TAPCELL_ROW_69_842 VDD VSS WELLTAP
XFILLER_101_988 VSS VDD FILLER2
XFILLER_39_571 VDD VSS FILLER1
X_09776_ _09776_/A _09776_/B VDD VSS _17421_/B XNOR2X1
XFILLER_113_1092 VDD VSS FILLER4
XFILLER_15_939 VDD VSS DECAPHV8
XFILLER_81_371 VDD VSS FILLER1
XFILLER_22_460 VDD VSS DECAPHV32
XTAP_TAPCELL_ROW_101_1233 VDD VSS WELLTAP
X_10620_ _10620_/A _10620_/B _10620_/C VDD VSS _10625_/A OAI21X1
X_10551_ _10551_/A _10551_/B _10551_/C VDD VSS _10560_/A XNOR3X1
XTAP_TAPCELL_ROW_11_149 VDD VSS WELLTAP
X_10482_ _10482_/A _10482_/B _10482_/C VDD VSS _10483_/C MIN3X1
X_13270_ _13352_/A _13352_/B VDD VSS _14395_/C _13352_/C NAND3X1
X_12221_ _12221_/A _12221_/B _12221_/C VDD VSS _12227_/B XNOR3X1
Xclkbuf_leaf_18_clk_fs_regs clkbuf_leaf_9_clk_fs_regs/A VDD VSS _18990_/CK BUFX12
XFILLER_135_362 VDD VSS DECAPHV8
XFILLER_78_32 VDD VSS DECAPHV8
X_12152_ _12159_/A _14085_/B _12239_/C VDD VSS _14086_/C NOR3X1
XFILLER_111_719 VDD VSS DECAPHV8
XFILLER_123_579 VDD VSS FILLER1
X_11103_ _17978_/Q _11103_/B _11103_/C VDD VSS _11108_/C MIN3X1
X_12083_ _12179_/B _12179_/C VDD VSS _14259_/B OR2X2
X_16960_ _16960_/A _16964_/B VDD VSS _16962_/B XOR2X1
XFILLER_1_375 VDD VSS DECAPHV32
XFILLER_77_600 VDD VSS DECAPHV8
XTAP_TAPCELL_ROW_112_1362 VDD VSS WELLTAP
X_11034_ _17965_/Q _11039_/B VDD VSS _11038_/B XNOR2X1
X_15911_ _16411_/A _15911_/B _15911_/C _15911_/D VDD VSS _16021_/A AND4X2
XFILLER_131_590 VDD VSS DECAPHV8
XFILLER_77_644 VSS VDD FILLER2
X_18630_ _19011_/CK _18630_/D _18630_/Q VDD VSS DFFQX1
X_16891_ _16939_/A _16900_/B _16946_/A VDD VSS _16892_/B AOI21X1
XFILLER_58_880 VSS VDD FILLER2
XFILLER_64_316 VSS VDD FILLER2
XFILLER_77_699 VDD VSS DECAPHV32
XFILLER_92_603 VDD VSS FILLER1
X_15842_ _15842_/A _15842_/B _15842_/C _15842_/D VDD VSS _15975_/B OAOI211X1
X_12985_ _14094_/B _18159_/Q VDD VSS _13094_/A NAND2BX1
X_18561_ clkload7/A _18561_/D _18561_/Q VDD VSS DFFQX1
Xdelaybuf_3_clk_fs delaybuf_3_clk_fs/A VDD VSS delaybuf_3_clk_fs/Y BUFX12
X_15773_ _18863_/Q _15799_/B VDD VSS _15800_/B NOR2BX1
XTAP_TAPCELL_ROW_19_249 VDD VSS WELLTAP
X_11936_ _11936_/A _14197_/B _14197_/C VDD VSS _11937_/D NOR3X1
X_18492_ _18496_/CK _18492_/D _18492_/Q VDD VSS DFFQX1
X_17512_ _17518_/A _17512_/B VDD VSS _17714_/D NOR2X1
X_14724_ _18562_/Q _18594_/Q VDD VSS _14725_/B XNOR2X1
X_17443_ _17514_/A _17443_/B VDD VSS _17650_/D AND2X1
XFILLER_32_235 VSS VDD FILLER2
XFILLER_60_566 VDD VSS FILLER1
X_11867_ _11954_/A _11954_/B _11954_/C _11954_/D VDD VSS _12039_/B AOI211X1
X_14655_ _18548_/Q _18580_/Q VDD VSS _14657_/B XNOR2X1
XFILLER_14_994 VSS VDD FILLER2
XFILLER_60_588 VDD VSS DECAPHV8
XTAP_TAPCELL_ROW_123_1491 VDD VSS WELLTAP
X_10818_ _17924_/Q _10818_/B _10818_/C VDD VSS _10824_/B XNOR3X1
X_11798_ _18227_/Q _11798_/B _11931_/C VDD VSS _11841_/B XNOR3X1
X_17374_ _17446_/A _17374_/B VDD VSS _17585_/D AND2X1
X_14586_ _14591_/C _14591_/B VDD VSS _14588_/B NAND2BX1
X_13606_ _14428_/A _14428_/B VDD VSS _13646_/B NOR2X1
X_10749_ _10844_/A _10878_/A VDD VSS _17935_/D NOR2X1
X_16325_ _16327_/A _16327_/B _16327_/D _16327_/C VDD VSS _16326_/B AOI211X1
X_13537_ _13598_/A _14399_/B _14399_/C VDD VSS _13597_/C NOR3X1
XFILLER_9_464 VDD VSS FILLER1
X_19044_ _19045_/CK _19044_/D _19044_/Q VDD VSS DFFQX1
X_16256_ _18843_/Q _18681_/Q VDD VSS _16276_/A NOR2X1
X_15207_ _15286_/A _18776_/Q VDD VSS _18749_/D AND2X1
X_13468_ _13542_/A _13542_/B VDD VSS _14336_/C _13542_/C NAND3X1
X_12419_ _12419_/A _12419_/B _12419_/C _12419_/D VDD VSS _14233_/C OAI211X1
X_16187_ _16187_/A _16234_/B VDD VSS _16192_/B XOR2X1
X_13399_ _18242_/Q _14184_/B VDD VSS _13493_/E _14184_/C AND3X2
XFILLER_126_373 VDD VSS FILLER4
XFILLER_127_896 VDD VSS FILLER1
X_15138_ _15304_/A _18708_/Q VDD VSS _18681_/D AND2X1
XFILLER_4_40 VDD VSS FILLER4
X_15069_ _15072_/C _15070_/B _17455_/A VDD VSS _15070_/C OAI21X1
XFILLER_136_1070 VDD VSS DECAPHV8
XFILLER_56_806 VDD VSS FILLER4
XFILLER_110_785 VDD VSS FILLER4
XFILLER_56_817 VDD VSS DECAPHV8
XFILLER_67_165 VDD VSS DECAPHV8
XFILLER_95_463 VSS VDD FILLER2
XFILLER_96_997 VDD VSS FILLER1
XTAP_TAPCELL_ROW_66_812 VDD VSS WELLTAP
X_09630_ _09630_/A VDD VSS _17415_/B INVX1
X_18828_ _18856_/CK _18828_/D _18828_/Q VDD VSS DFFQX1
XFILLER_49_891 VDD VSS DECAPHV16
XFILLER_82_113 VDD VSS DECAPHV16
X_09561_ _17685_/Q _09584_/A VDD VSS _09562_/B XNOR2X1
X_18759_ _18787_/CK _18759_/D _18759_/Q VDD VSS DFFQX1
XFILLER_70_308 VDD VSS FILLER4
XFILLER_82_157 VSS VDD FILLER2
XFILLER_36_596 VSS VDD FILLER2
X_09492_ _19041_/Q _17342_/B VDD VSS _09493_/C NOR2X1
XFILLER_17_1022 VDD VSS FILLER1
XFILLER_51_588 VDD VSS DECAPHV8
XFILLER_23_38 VDD VSS FILLER1
XFILLER_20_964 VDD VSS FILLER1
XFILLER_105_502 VDD VSS FILLER1
XFILLER_118_874 VDD VSS DECAPHV8
XFILLER_59_600 VDD VSS FILLER1
XFILLER_24_1015 VDD VSS FILLER1
XFILLER_87_953 VDD VSS DECAPHV8
XFILLER_98_290 VDD VSS FILLER4
XFILLER_59_699 VDD VSS FILLER1
XFILLER_74_603 VDD VSS FILLER1
XFILLER_98_1105 VDD VSS FILLER4
X_09828_ _09843_/A _09989_/B VDD VSS _17798_/D NOR2X1
X_09759_ _09759_/A _09759_/B _09759_/C VDD VSS _09783_/B OA21X2
XFILLER_54_371 VSS VDD FILLER2
XFILLER_73_179 VSS VDD FILLER2
XTAP_TAPCELL_ROW_16_208 VDD VSS WELLTAP
X_12770_ _12902_/A _14150_/B VDD VSS _12872_/B NAND2X1
XFILLER_120_40 VDD VSS FILLER4
XFILLER_15_747 VDD VSS DECAPHV16
X_11721_ _18434_/Q _14407_/B VDD VSS _11816_/B NOR2X1
XFILLER_70_886 VDD VSS FILLER1
X_11652_ _18380_/Q _14344_/B VDD VSS _11653_/B OR2X2
X_14440_ _14440_/A _14440_/B VDD VSS _18464_/D NOR2X1
XFILLER_80_44 VSS VDD FILLER2
X_10603_ _17882_/Q _10608_/B VDD VSS _10605_/C XOR2X1
Xfanout50 _17554_/C VDD VSS _17561_/C BUFX3
Xfanout61 _14343_/A VDD VSS _17043_/A BUFX3
Xfanout72 _15310_/A VDD VSS _17388_/A BUFX3
Xfanout83 _16984_/A VDD VSS _15299_/A BUFX3
X_14371_ _14394_/A _14371_/B _14371_/C VDD VSS _18401_/D NOR3X1
XFILLER_10_441 VDD VSS FILLER1
XFILLER_128_627 VSS VDD FILLER2
X_11583_ _18302_/Q _11664_/B _11660_/C VDD VSS _11656_/C XNOR3X1
X_16110_ _16604_/A _16110_/B _16110_/C VDD VSS _16110_/Y OAI21X1
X_13322_ _18320_/Q _14272_/A _14272_/B VDD VSS _13375_/B XOR3X1
X_10534_ _17873_/Q VDD VSS _10553_/A INVX1
X_17090_ _17090_/A _17090_/B _17090_/C VDD VSS _17095_/B OA21X2
XFILLER_136_660 VDD VSS DECAPHV8
X_10465_ _11148_/A _10648_/B VDD VSS _17889_/D AND2X1
X_13253_ _13343_/A _13262_/D VDD VSS _14453_/B XNOR2X1
X_16041_ _16039_/Y _16041_/B _18758_/Q _16218_/A VDD VSS _16105_/B AOI2B2X1
XFILLER_108_395 VDD VSS DECAPHV8
XFILLER_124_833 VDD VSS FILLER1
XFILLER_89_64 VDD VSS DECAPHV16
X_10396_ _17852_/Q _10405_/B _10405_/C VDD VSS _10582_/C XNOR3X1
X_12204_ _12204_/A _12290_/B _14354_/B VDD VSS _12402_/B MIN3X1
X_13184_ _13200_/A _14240_/B _13200_/C VDD VSS _14241_/B OAI21X1
XFILLER_97_706 VDD VSS DECAPHV8
X_12135_ _12305_/A _12305_/B _12305_/C VDD VSS _12168_/B AOI21X1
XFILLER_96_205 VSS VDD FILLER2
X_17992_ _17993_/CK _17992_/D _17992_/Q VDD VSS DFFQX1
XFILLER_2_695 VSS VDD FILLER2
XFILLER_77_430 VDD VSS DECAPHV8
X_12066_ _12137_/A _12137_/B VDD VSS _14113_/C _12137_/C NAND3X1
X_16943_ _16953_/B _16943_/B VDD VSS _16945_/B XOR2X1
X_11017_ _11022_/C _11017_/B VDD VSS _11154_/B XNOR2X1
X_16874_ _18926_/Q _16972_/B VDD VSS _16875_/C NAND2X1
XFILLER_65_625 VDD VSS DECAPHV8
X_18613_ _18990_/CK _18613_/D _18613_/Q VDD VSS DFFQX1
X_15825_ _15897_/A _15860_/A VDD VSS _15984_/D _15860_/B _15860_/C NAND4X2
XFILLER_18_552 VDD VSS FILLER4
XFILLER_46_850 VDD VSS FILLER1
XFILLER_64_146 VDD VSS FILLER1
XTAP_TAPCELL_ROW_125_1520 VDD VSS WELLTAP
XFILLER_33_522 VSS VDD FILLER2
X_12968_ _13178_/A _13178_/B VDD VSS _13054_/B NOR2X1
X_18544_ _18641_/CK _18544_/D _18544_/Q VDD VSS DFFQX1
X_15756_ _18864_/Q _18860_/Q VDD VSS _15874_/C NAND2BX1
X_11919_ _11937_/A _11937_/B _11937_/C VDD VSS _11922_/C NOR3X1
X_12899_ _12899_/A _12899_/B _12899_/C _12899_/D VDD VSS _12901_/C OAI211X1
X_18475_ _18505_/CK _18475_/D _18475_/Q VDD VSS DFFQX1
X_15687_ _15584_/Y _15686_/Y _15651_/Y VDD VSS _15693_/B MUX2X1
X_14707_ _14710_/A _14707_/B _14707_/C VDD VSS _18558_/D AOI21X1
XFILLER_20_205 VSS VDD FILLER2
XFILLER_33_566 VDD VSS FILLER1
XFILLER_60_352 VDD VSS FILLER1
XFILLER_60_363 VDD VSS FILLER1
XTAP_TAPCELL_ROW_71_870 VDD VSS WELLTAP
X_17426_ _17445_/A _17426_/B VDD VSS _17633_/D NOR2X1
X_14638_ _18543_/Q _18575_/Q VDD VSS _14639_/C NAND2X1
X_17357_ _17378_/A _17357_/B VDD VSS _17568_/D NOR2X1
X_16308_ _18906_/Q _16905_/B VDD VSS _16309_/D NAND2X1
X_14569_ _18528_/Q _18560_/Q _14569_/C VDD VSS _14573_/B MIN3X1
XFILLER_118_137 VSS VDD FILLER2
Xclkload20 _18950_/CK VDD VSS clkload20/Y INVX2
X_17288_ _17291_/B _17288_/B VDD VSS _17289_/B XOR2X1
XTAP_TAPCELL_ROW_136_1660 VDD VSS WELLTAP
X_19027_ _19028_/CK _19027_/D _19027_/Q VDD VSS DFFQX1
Xclkload53 _18368_/CK VDD VSS clkload53/Y BUFX12
Xclkload42 _18171_/CK VDD VSS clkload42/Y INVX4
Xclkload31 _18453_/CK VDD VSS clkload31/Y BUFX12
X_16239_ _16239_/A _16239_/B _16239_/C _16239_/D VDD VSS _16286_/C AO211X2
XFILLER_55_0 VDD VSS DECAPHV32
Xclkload86 _17871_/CK VDD VSS clkload86/Y INVX4
Xclkload75 clkload75/A VDD VSS clkload75/Y INVX14
Xclkload64 _18253_/CK VDD VSS clkload64/Y INVX2
Xclkbuf_leaf_19__001_ clkload75/A VDD VSS _17972_/CK BUFX12
XFILLER_114_343 VDD VSS FILLER4
XFILLER_47_1026 VDD VSS FILLER4
XFILLER_88_706 VDD VSS FILLER1
Xclkload97 _17854_/CK VDD VSS clkload97/Y BUFX12
X_08992_ _08992_/A _17457_/B _09000_/A VDD VSS _09007_/B MIN3X1
XFILLER_102_538 VDD VSS FILLER4
XFILLER_102_549 VSS VDD FILLER2
XFILLER_56_603 VDD VSS FILLER1
XFILLER_84_912 VDD VSS DECAPHV16
XTAP_TAPCELL_ROW_79_970 VDD VSS WELLTAP
XFILLER_18_49 VDD VSS FILLER4
XFILLER_68_496 VDD VSS DECAPHV8
XFILLER_95_282 VDD VSS FILLER4
X_09613_ _09640_/B _09613_/B VDD VSS _17449_/B NAND2BX1
XFILLER_58_1100 VDD VSS FILLER1
XFILLER_84_967 VDD VSS FILLER1
XTAP_TAPCELL_ROW_87_1058 VDD VSS WELLTAP
XFILLER_110_1062 VDD VSS FILLER4
XFILLER_43_319 VDD VSS FILLER1
XFILLER_55_179 VSS VDD FILLER2
XFILLER_83_499 VSS VDD FILLER2
X_09544_ _09546_/B _09544_/B VDD VSS _09548_/B NAND2BX1
XFILLER_110_1084 VDD VSS DECAPHV16
XFILLER_19_1106 VDD VSS FILLER4
X_09475_ _17681_/Q _17476_/B VDD VSS _09476_/C NOR2X1
XFILLER_24_566 VDD VSS FILLER1
XTAP_TAPCELL_ROW_41_509 VDD VSS WELLTAP
Xclkload3 clkload3/A VDD VSS clkload3/Y INVX2
XTAP_TAPCELL_ROW_21_266 VDD VSS WELLTAP
XFILLER_118_660 VDD VSS FILLER1
XFILLER_124_129 VDD VSS DECAPHV8
XTAP_TAPCELL_ROW_98_1198 VDD VSS WELLTAP
X_10250_ _10268_/A _10438_/B VDD VSS _17858_/D NOR2X1
XFILLER_106_877 VDD VSS FILLER4
XFILLER_121_814 VSS VDD FILLER2
X_10181_ _10154_/Y _10370_/B _10370_/C VDD VSS _17848_/D AND3BX1
XFILLER_8_1031 VDD VSS FILLER1
XFILLER_59_441 VSS VDD FILLER2
XTAP_TAPCELL_ROW_49_609 VDD VSS WELLTAP
X_13940_ _18942_/Q _18943_/Q VDD VSS _13975_/B _13972_/B NAND3X1
XFILLER_46_102 VSS VDD FILLER2
XFILLER_46_113 VDD VSS FILLER1
XFILLER_47_636 VSS VDD FILLER2
XFILLER_74_411 VDD VSS FILLER4
XFILLER_75_88 VDD VSS FILLER4
X_15610_ _15685_/A _15610_/B VDD VSS _15662_/C NAND2X1
X_13871_ _13892_/A _13892_/B VDD VSS _13881_/B NOR2X1
XFILLER_34_319 VDD VSS FILLER1
XFILLER_43_820 VDD VSS DECAPHV8
XTAP_TAPCELL_ROW_29_366 VDD VSS WELLTAP
XTAP_TAPCELL_ROW_57_697 VDD VSS WELLTAP
X_12822_ _18393_/Q _14360_/B VDD VSS _12949_/A AND2X1
X_16590_ _16575_/Y _16590_/B _16590_/C VDD VSS _16629_/B AND3BX1
XFILLER_91_32 VDD VSS DECAPHV32
X_12753_ _12765_/A _14177_/B _12859_/C VDD VSS _14178_/C NOR3X1
X_15541_ _16782_/D VDD VSS _15651_/A BUFX3
XFILLER_42_341 VDD VSS FILLER1
XFILLER_42_352 VDD VSS DECAPHV16
X_11704_ _11847_/A _11847_/B _11847_/C VDD VSS _11709_/B AOI21X1
X_18260_ _18313_/CK _18260_/D _18260_/Q VDD VSS DFFQX1
X_15472_ _18868_/Q _15668_/B VDD VSS _15473_/C NAND2X1
XFILLER_30_514 VDD VSS FILLER4
XFILLER_30_547 VSS VDD FILLER2
XTAP_TAPCELL_ROW_120_1461 VDD VSS WELLTAP
X_12684_ _18210_/Q _12684_/B _12769_/D VDD VSS _12859_/C XNOR3X1
X_17211_ _18999_/Q _17287_/B _17211_/C VDD VSS _17212_/B MIN3X1
X_14423_ _14423_/A _14423_/B VDD VSS _18449_/D AND2X1
XFILLER_24_92 VSS VDD FILLER2
X_11635_ _11635_/A _11635_/B _11686_/C _11635_/D VDD VSS _11784_/A OAOI211X1
X_18191_ _18271_/CK _18191_/D _18191_/Q VDD VSS DFFQX1
XFILLER_129_958 VDD VSS FILLER4
X_11566_ _18973_/Q _18094_/Q VDD VSS _11637_/D NOR2X1
X_17142_ _17145_/A _17145_/B VDD VSS _17143_/B XNOR2X1
X_14354_ _14378_/A _14354_/B VDD VSS _18387_/D NOR2X1
X_10517_ _17871_/Q VDD VSS _10523_/A INVX1
X_17073_ _17074_/A _17074_/B _17074_/C VDD VSS _17075_/B NOR3X1
X_14285_ _14285_/A _14285_/B VDD VSS _14286_/B XNOR2X1
X_13305_ _13305_/A _14210_/B _13380_/C _13305_/D VDD VSS _13486_/A OAOI211X1
X_11497_ _18971_/Q _18092_/Q VDD VSS _11499_/C NAND2X1
X_13236_ _18345_/Q _13289_/B _13236_/C VDD VSS _13466_/B XNOR3X1
X_16024_ _16109_/A _16185_/C VDD VSS _16340_/C NAND2X1
XFILLER_108_181 VSS VDD FILLER2
XFILLER_136_490 VDD VSS FILLER4
X_10448_ _10707_/A _10631_/B VDD VSS _17886_/D AND2X1
XFILLER_124_663 VSS VDD FILLER2
XFILLER_69_205 VDD VSS DECAPHV8
X_10379_ _17849_/Q _10379_/B VDD VSS _10561_/C _10379_/C NAND3X1
X_13167_ _13278_/A _14394_/B VDD VSS _13239_/B NOR2X1
XFILLER_112_858 VSS VDD FILLER2
XFILLER_123_184 VSS VDD FILLER2
XFILLER_85_709 VSS VDD FILLER2
XTAP_TAPCELL_ROW_131_1590 VDD VSS WELLTAP
X_12118_ _12118_/A _12118_/B _12118_/C _12118_/D VDD VSS _14230_/B OAOI211X1
X_13098_ _13206_/B _14153_/C _18213_/Q VDD VSS _13099_/D AND3BX1
X_17975_ _18003_/CK _17975_/D _17975_/Q VDD VSS DFFQX1
XFILLER_78_772 VDD VSS FILLER4
XFILLER_84_208 VDD VSS FILLER1
X_12049_ _18152_/Q VDD VSS _12153_/A INVX1
X_16926_ _16926_/A _16928_/C VDD VSS _16927_/D NOR2X1
XFILLER_19_861 VDD VSS FILLER4
X_16857_ _16857_/A _16857_/B _16869_/C VDD VSS _16939_/B AOI21BX1
XFILLER_1_96 VDD VSS DECAPHV32
XFILLER_92_263 VDD VSS FILLER1
X_16788_ _16667_/B _16844_/B _16869_/A VDD VSS _16900_/B MUXI2X1
X_15808_ _16326_/A _15808_/B VDD VSS _15860_/A OR2X2
XFILLER_18_393 VDD VSS DECAPHV8
X_18527_ clkload7/A _18527_/D _18527_/Q VDD VSS DFFQX1
X_15739_ _15739_/A _15739_/B _15739_/C VDD VSS _15746_/B OAI21X1
XFILLER_61_650 VDD VSS FILLER1
X_09260_ _17642_/Q _17435_/B VDD VSS _09278_/B XNOR2X1
XFILLER_60_160 VDD VSS FILLER4
X_18458_ _18509_/CK _18458_/D _18458_/Q VDD VSS DFFQX1
X_09191_ _19030_/Q _17330_/B VDD VSS _09192_/B XNOR2X1
X_18389_ _18417_/CK _18389_/D _18389_/Q VDD VSS DFFQX1
X_17409_ _17410_/A _17409_/B VDD VSS _17618_/D NOR2X1
XFILLER_119_446 VSS VDD FILLER2
XFILLER_101_1017 VSS VDD FILLER2
XFILLER_119_468 VSS VDD FILLER2
XFILLER_14_1058 VSS VDD FILLER2
Xclkload120 _18850_/CK VDD VSS clkload120/Y INVX1
XFILLER_106_129 VDD VSS DECAPHV8
XFILLER_134_416 VSS VDD FILLER2
X_08975_ _08979_/C _08975_/B _08975_/C VDD VSS _17755_/D AOI21X1
XFILLER_130_688 VDD VSS FILLER4
XFILLER_29_48 VDD VSS FILLER1
XFILLER_111_891 VDD VSS DECAPHV8
XFILLER_29_636 VDD VSS DECAPHV8
XFILLER_68_260 VDD VSS FILLER4
XFILLER_112_1135 VDD VSS FILLER1
XFILLER_60_1089 VSS VDD FILLER2
XFILLER_72_915 VDD VSS FILLER1
XFILLER_84_775 VDD VSS FILLER1
XFILLER_16_319 VSS VDD FILLER2
XFILLER_71_414 VDD VSS DECAPHV8
XFILLER_72_959 VDD VSS FILLER1
XTAP_TAPCELL_ROW_26_325 VDD VSS WELLTAP
XTAP_TAPCELL_ROW_26_336 VDD VSS WELLTAP
X_09527_ _09553_/A _09553_/B VDD VSS _09536_/A NAND2X1
XTAP_TAPCELL_ROW_54_667 VDD VSS WELLTAP
XFILLER_101_64 VDD VSS DECAPHV16
XFILLER_24_396 VDD VSS FILLER1
XFILLER_40_834 VSS VDD FILLER2
XTAP_TAPCELL_ROW_82_998 VDD VSS WELLTAP
X_09458_ _09459_/A _09459_/B _09459_/C VDD VSS _09472_/C AO21X2
XFILLER_40_856 VSS VDD FILLER2
XFILLER_40_867 VDD VSS FILLER1
X_09389_ _17678_/Q _17473_/B VDD VSS _09390_/C NOR2X1
X_11420_ _11420_/A _11420_/B _11420_/C VDD VSS _14159_/B XNOR3X1
XFILLER_126_906 VDD VSS FILLER1
X_11351_ _18139_/Q _11351_/B _11351_/C VDD VSS _11354_/A MIN3X1
XFILLER_125_427 VDD VSS FILLER4
X_10302_ _10148_/B _10317_/C _17842_/Q VDD VSS _10303_/D AND3BX1
X_11282_ _18966_/Q _18087_/Q VDD VSS _11319_/C AND2X1
X_14070_ _14083_/A _14070_/B VDD VSS _18138_/D NOR2X1
XFILLER_69_1081 VSS VDD FILLER2
X_10233_ _10239_/A _10419_/C VDD VSS _10237_/A NAND2X1
X_13021_ _13021_/A _13021_/B _13021_/C _13021_/D VDD VSS _14362_/B AOAI211X1
XFILLER_79_547 VDD VSS FILLER4
X_10164_ _17821_/Q _10164_/B VDD VSS _10165_/D _10174_/B NAND3X1
XFILLER_117_1068 VDD VSS FILLER1
XFILLER_86_32 VDD VSS DECAPHV8
X_10095_ _10114_/A _10309_/B VDD VSS _17839_/D NOR2X1
X_17760_ _19028_/CK _17760_/D _17760_/Q VDD VSS DFFQX1
X_14972_ _14972_/A _14972_/B _14974_/C VDD VSS _18615_/D NOR3X1
XFILLER_74_230 VSS VDD FILLER2
XTAP_TAPCELL_ROW_109_1323 VDD VSS WELLTAP
X_17691_ _17725_/CK _17691_/D _17691_/Q VDD VSS DFFQX1
X_16711_ _16711_/A VDD VSS _16939_/A BUFX3
X_13923_ _13935_/A _13924_/B _17525_/B VDD VSS _13924_/C OAI21X1
XFILLER_47_488 VSS VDD FILLER2
X_16642_ _16642_/A VDD VSS _16674_/A INVX1
X_13854_ _13884_/A _13884_/B _15313_/A VDD VSS _13855_/C OAI21X1
XFILLER_62_447 VDD VSS FILLER4
X_12805_ _18497_/Q _14481_/B VDD VSS _12807_/B XNOR2X1
X_16573_ _16620_/C _16620_/B VDD VSS _16574_/B NOR2BX1
XFILLER_16_886 VDD VSS FILLER1
X_10997_ _17958_/Q VDD VSS _10998_/A INVX1
X_18312_ _18313_/CK _18312_/D _18312_/Q VDD VSS DFFQX1
Xclkbuf_leaf_18__002_ clkbuf_leaf_9__002_/A VDD VSS _18249_/CK BUFX12
X_15524_ _18872_/Q VDD VSS _15540_/A INVX1
X_13785_ _18456_/Q VDD VSS _13815_/A INVX1
XFILLER_15_396 VSS VDD FILLER2
XFILLER_70_491 VDD VSS DECAPHV16
X_12736_ _12854_/A _12866_/A _12962_/B VDD VSS _12846_/C XNOR3X1
XTAP_TAPCELL_ROW_6_95 VDD VSS WELLTAP
X_12667_ _12667_/A _12667_/B _12667_/C _12667_/D VDD VSS _14092_/C AOAI211X1
X_18243_ _18295_/CK _18243_/D _18243_/Q VDD VSS DFFQX1
X_15455_ _18867_/Q _15455_/B _15455_/C VDD VSS _15475_/A MIN3X1
X_11618_ _11618_/A _14105_/B _11618_/C _11618_/D VDD VSS _11766_/A AOAI211X1
X_18174_ _18200_/CK _18174_/D _18174_/Q VDD VSS DFFQX1
X_15386_ _16783_/A _15386_/B _15386_/C VDD VSS _15464_/B OAI21X1
X_14406_ _14414_/A _14406_/B VDD VSS _18433_/D NOR2X1
XFILLER_129_777 VSS VDD FILLER2
X_12598_ _12712_/A _12712_/B _12603_/C VDD VSS _14417_/B XNOR3X1
X_17125_ _18020_/Q _17129_/B VDD VSS _17127_/C XNOR2X1
X_14337_ _14372_/A _14337_/B VDD VSS _18374_/D AND2X1
X_11549_ _11614_/A _14106_/B _14106_/C VDD VSS _11672_/C NOR3X1
XFILLER_116_449 VDD VSS FILLER1
X_17056_ _18007_/Q _17060_/B VDD VSS _17058_/C XOR2X1
X_14268_ _14243_/Y _14268_/B _14268_/C VDD VSS _18317_/D AND3BX1
XFILLER_100_1072 VDD VSS FILLER4
XFILLER_98_801 VDD VSS DECAPHV8
X_13219_ _18189_/Q VDD VSS _13316_/C INVX1
X_16007_ _16047_/A _16047_/B _16047_/C VDD VSS _16007_/Y AOI21X1
X_14199_ _14198_/Y _14199_/B _14199_/C VDD VSS _18255_/D AND3BX1
XFILLER_124_482 VDD VSS FILLER1
XFILLER_135_1135 VDD VSS FILLER1
XFILLER_100_817 VDD VSS FILLER1
XFILLER_112_677 VDD VSS FILLER4
XFILLER_83_1089 VDD VSS DECAPHV8
XFILLER_85_517 VSS VDD FILLER2
XFILLER_97_388 VDD VSS DECAPHV16
X_17958_ _17961_/CK _17958_/D _17958_/Q VDD VSS DFFQX1
XFILLER_18_0 VDD VSS DECAPHV32
X_17889_ _17941_/CK _17889_/D _17889_/Q VDD VSS DFFQX1
X_16909_ _16946_/A _16911_/A VDD VSS _16914_/B OR2X2
XFILLER_54_948 VSS VDD FILLER2
XFILLER_65_274 VDD VSS FILLER4
XFILLER_80_200 VDD VSS DECAPHV8
XFILLER_93_561 VDD VSS FILLER4
XFILLER_0_1123 VSS VDD FILLER2
XTAP_TAPCELL_ROW_84_1028 VDD VSS WELLTAP
X_09312_ _17739_/Q _09312_/B _09312_/C VDD VSS _09338_/C MIN3X1
XTAP_TAPCELL_ROW_51_626 VDD VSS WELLTAP
X_09243_ _17434_/A _09271_/B VDD VSS _09244_/C NAND2X1
X_09174_ _09174_/A _09174_/B _09174_/C VDD VSS _09188_/A AOI21X1
XFILLER_108_928 VDD VSS DECAPHV8
XFILLER_119_232 VDD VSS FILLER1
XTAP_TAPCELL_ROW_31_394 VDD VSS WELLTAP
XFILLER_135_747 VSS VDD FILLER2
XFILLER_134_235 VDD VSS DECAPHV32
XFILLER_135_769 VSS VDD FILLER2
XTAP_TAPCELL_ROW_95_1157 VDD VSS WELLTAP
Xoutput16 _18061_/Q VDD VSS data_out[21] BUFX3
XFILLER_0_215 VDD VSS DECAPHV8
XFILLER_89_834 VSS VDD FILLER2
XFILLER_89_845 VDD VSS FILLER1
XFILLER_130_463 VDD VSS FILLER1
XFILLER_88_366 VDD VSS FILLER4
XFILLER_48_219 VDD VSS DECAPHV8
XTAP_TAPCELL_ROW_59_726 VDD VSS WELLTAP
X_08958_ _17752_/Q _18541_/Q VDD VSS _08963_/A XNOR2X1
X_08889_ _17727_/Q _18516_/Q VDD VSS _17526_/B XNOR2X1
XFILLER_17_628 VDD VSS DECAPHV16
XFILLER_44_403 VSS VDD FILLER2
XFILLER_45_915 VDD VSS DECAPHV8
XFILLER_56_241 VDD VSS FILLER1
X_10920_ _10924_/A _10920_/B VDD VSS _11059_/B XNOR2X1
XFILLER_16_138 VDD VSS FILLER1
XFILLER_44_425 VSS VDD FILLER2
XTAP_TAPCELL_ROW_39_483 VDD VSS WELLTAP
XFILLER_71_244 VDD VSS FILLER4
XFILLER_72_789 VDD VSS FILLER1
X_10851_ _17930_/Q _10851_/B VDD VSS _10858_/A NAND2X1
XTAP_TAPCELL_ROW_104_1264 VDD VSS WELLTAP
X_10782_ _10782_/A _10782_/B _10782_/C VDD VSS _10787_/C AOI21X1
X_13570_ _18297_/Q _13628_/D _13625_/C VDD VSS _13621_/C XNOR3X1
XFILLER_9_816 VDD VSS FILLER1
X_12521_ _12538_/A _12653_/A _12653_/B VDD VSS _12522_/D XNOR3X1
XFILLER_40_686 VDD VSS FILLER1
X_12452_ _12453_/A _12453_/B _12453_/D _12453_/C VDD VSS _14060_/B AO211X2
X_15240_ _15240_/A _18808_/Q VDD VSS _18781_/D AND2X1
XFILLER_122_0 VDD VSS DECAPHV32
XFILLER_12_399 VSS VDD FILLER2
X_11403_ _18969_/Q _18090_/Q VDD VSS _11446_/C NOR2X1
XFILLER_126_736 VDD VSS FILLER4
X_12383_ _18362_/Q VDD VSS _12385_/A INVX1
X_15171_ _15313_/A _18741_/Q VDD VSS _18714_/D AND2X1
X_11334_ _18219_/Q _11334_/B _11334_/C VDD VSS _11417_/B MIN3X1
X_14122_ _14122_/A _14122_/B _14122_/C VDD VSS _18186_/D NOR3X1
XFILLER_119_1119 VDD VSS DECAPHV16
X_11265_ _11287_/A _11314_/A _11319_/B VDD VSS _11281_/D XNOR3X1
X_18930_ _18940_/CK _18930_/D _18930_/Q VDD VSS DFFQX1
X_14053_ _14053_/A _14053_/B VDD VSS _18122_/D NOR2X1
XFILLER_106_471 VSS VDD FILLER2
XFILLER_97_64 VDD VSS DECAPHV16
XTAP_TAPCELL_ROW_115_1393 VDD VSS WELLTAP
X_10216_ _10216_/A _10216_/B VDD VSS _10221_/A OR2X2
X_13004_ _18213_/Q _13122_/B _13191_/D VDD VSS _13120_/C XNOR3X1
XFILLER_122_975 VDD VSS FILLER1
X_11196_ _11196_/A _11196_/B _11196_/C VDD VSS _11203_/C OA21X2
X_18861_ _18961_/CK _18861_/D _18861_/Q VDD VSS DFFQX1
XFILLER_121_463 VSS VDD FILLER2
XFILLER_122_997 VSS VDD FILLER2
XFILLER_48_720 VDD VSS FILLER1
X_10147_ _17818_/Q _10147_/B VDD VSS _10148_/D _10147_/C AND3X2
X_18792_ _18818_/CK _18792_/D _18792_/Q VDD VSS DFFQX1
X_17812_ _17867_/CK _17812_/D _17812_/Q VDD VSS DFFQX1
XFILLER_130_1021 VDD VSS DECAPHV32
X_10078_ _10078_/A _10078_/B VDD VSS _10088_/B XOR2X1
X_17743_ clkload5/A _17743_/D _17743_/Q VDD VSS DFFQX1
X_14955_ _14956_/A _14956_/B VDD VSS _14958_/C NOR2X1
XFILLER_36_926 VDD VSS FILLER4
XFILLER_63_723 VSS VDD FILLER2
X_13906_ _13912_/B _13912_/C VDD VSS _14499_/B OR2X2
XFILLER_35_447 VDD VSS FILLER1
X_17674_ _17706_/CK _17674_/D _17674_/Q VDD VSS DFFQX1
X_14886_ _14889_/A _14886_/B _14886_/C VDD VSS _18596_/D AOI21X1
XFILLER_51_907 VDD VSS FILLER4
XFILLER_62_244 VDD VSS FILLER4
XFILLER_63_778 VDD VSS DECAPHV8
XFILLER_90_564 VSS VDD FILLER2
X_16625_ _16657_/D _16625_/B VDD VSS _16626_/D _16625_/C NAND3X1
X_13837_ _18405_/Q _13845_/A _13845_/B VDD VSS _13838_/D XNOR3X1
XFILLER_43_480 VDD VSS FILLER1
X_16556_ _16481_/Y _16630_/B _16630_/A VDD VSS _16700_/B MUXI2X1
X_13768_ _13838_/A _13847_/B VDD VSS _14403_/B XNOR2X1
XFILLER_30_130 VSS VDD FILLER2
X_12719_ _12931_/A _12931_/B _12931_/C VDD VSS _12926_/A AOI21X1
X_16487_ _16487_/A _16531_/B VDD VSS _16488_/B XOR2X1
X_15507_ _15669_/A _16983_/A _15507_/C VDD VSS _18870_/D OAI21X1
X_18226_ _18252_/CK _18226_/D _18226_/Q VDD VSS DFFQX1
X_15438_ _16161_/C VDD VSS _16757_/A BUFX3
X_13699_ _18298_/Q _14248_/B VDD VSS _13701_/A NOR2X1
XFILLER_129_541 VDD VSS FILLER1
XFILLER_50_1055 VDD VSS FILLER4
XFILLER_8_882 VDD VSS FILLER1
X_18157_ _18250_/CK _18157_/D _18157_/Q VDD VSS DFFQX1
X_15369_ _16452_/A _16731_/A _15382_/A VDD VSS _15390_/C MIN3X1
XFILLER_116_235 VDD VSS DECAPHV16
XFILLER_117_747 VDD VSS DECAPHV8
XFILLER_7_370 VSS VDD FILLER2
X_18088_ _18971_/CK _18088_/D _18088_/Q VDD VSS DFFQX1
X_17108_ _17242_/A _17108_/B _17112_/B VDD VSS _18978_/D NOR3X1
X_09930_ _17793_/Q _09943_/B VDD VSS _09936_/C XOR2X1
X_17039_ _17037_/Y _17044_/B _17043_/A VDD VSS _18965_/D AND3BX1
XFILLER_125_791 VDD VSS FILLER1
X_09861_ _17783_/Q _09863_/B VDD VSS _10069_/A XNOR2X1
XFILLER_113_997 VDD VSS FILLER1
XFILLER_85_314 VDD VSS FILLER4
XTAP_TAPCELL_ROW_90_1098 VDD VSS WELLTAP
X_09792_ _17392_/A _09885_/B VDD VSS _17787_/D AND2X1
XFILLER_38_274 VDD VSS FILLER1
XFILLER_26_49 VDD VSS FILLER4
XTAP_TAPCELL_ROW_36_453 VDD VSS WELLTAP
XTAP_TAPCELL_ROW_64_784 VDD VSS WELLTAP
XFILLER_21_130 VDD VSS FILLER1
XFILLER_50_940 VDD VSS FILLER1
XFILLER_107_1056 VDD VSS FILLER4
X_09226_ _09226_/A _09226_/B _09226_/C VDD VSS _09232_/A AOI21X1
Xclkbuf_leaf_17_clk_fs_regs clkbuf_leaf_9_clk_fs_regs/A VDD VSS _18994_/CK BUFX12
X_09157_ _17670_/Q _17464_/B VDD VSS _09159_/C XNOR2X1
X_09088_ _19024_/Q _17323_/B VDD VSS _09089_/D NAND2X1
XTAP_TAPCELL_ROW_8_112 VDD VSS WELLTAP
XFILLER_77_804 VSS VDD FILLER2
X_11050_ _11053_/A _11053_/B VDD VSS _11184_/A XNOR2X1
XFILLER_107_96 VDD VSS DECAPHV32
XFILLER_114_1005 VSS VDD FILLER2
XFILLER_77_848 VSS VDD FILLER2
X_10001_ _17801_/Q _10006_/B VDD VSS _10005_/B XOR2X1
XFILLER_114_1038 VDD VSS FILLER4
XFILLER_114_1049 VDD VSS FILLER1
XFILLER_18_904 VDD VSS FILLER4
XFILLER_29_263 VSS VDD FILLER2
XFILLER_85_870 VDD VSS FILLER4
X_14740_ _14740_/A _14740_/B _14740_/C _14740_/D VDD VSS _14741_/C AOAI211X1
XFILLER_17_414 VSS VDD FILLER2
XFILLER_72_531 VDD VSS DECAPHV16
X_11952_ _11952_/A _14112_/B _14112_/C VDD VSS _11953_/D NOR3X1
X_10903_ _10905_/B _10903_/B VDD VSS _11045_/B XNOR2X1
X_11883_ _18227_/Q _11883_/B VDD VSS _11929_/C _11883_/C NAND3X1
X_14671_ _14672_/B _14671_/B VDD VSS _14673_/B NOR2BX1
XFILLER_32_417 VDD VSS FILLER1
XFILLER_44_277 VDD VSS DECAPHV16
XFILLER_73_1022 VDD VSS FILLER1
XFILLER_83_88 VDD VSS FILLER4
X_10834_ _10837_/C _10834_/B VDD VSS _10969_/A XNOR2X1
X_17390_ _17395_/A _17390_/B VDD VSS _17600_/D NOR2X1
X_16410_ _16411_/A _16410_/B VDD VSS _16411_/C NAND2X1
X_13622_ _18323_/Q _14278_/B _14278_/C VDD VSS _13705_/E OR3BX1
XFILLER_125_1101 VDD VSS DECAPHV8
X_16341_ _16459_/A _16341_/B _16341_/C VDD VSS _16349_/D AOI21X1
X_13553_ _18348_/Q _14307_/B VDD VSS _13686_/C _14307_/C AND3X2
XFILLER_12_130 VDD VSS FILLER4
XFILLER_13_686 VDD VSS DECAPHV32
XFILLER_41_984 VDD VSS FILLER4
X_10765_ _17912_/Q _10765_/B VDD VSS _10769_/A NOR2BX1
X_12504_ _12318_/A _14202_/B _14202_/C VDD VSS _12506_/C AND3BX1
X_10696_ _10705_/B _10696_/B VDD VSS _10832_/B NAND2BX1
X_16272_ _16456_/A _16272_/B _16272_/C VDD VSS _18905_/D OAI21X1
X_13484_ _18242_/Q _14184_/B VDD VSS _13486_/C _14184_/C NAND3X1
XFILLER_32_81 VSS VDD FILLER2
XTAP_TAPCELL_ROW_117_1422 VDD VSS WELLTAP
XTAP_TAPCELL_ROW_3_52 VDD VSS WELLTAP
X_12435_ _12436_/A _12436_/B _12436_/D _12436_/C VDD VSS _12552_/B OAOI211X1
X_18011_ _18011_/CK _18011_/D _18011_/Q VDD VSS DFFQX1
X_15223_ _15307_/A _18792_/Q VDD VSS _18765_/D AND2X1
X_12366_ _12366_/A _14115_/B _12366_/C _12366_/D VDD VSS _12653_/B AOAI211X1
X_15154_ _16984_/A _18724_/Q VDD VSS _18697_/D AND2X1
X_11317_ _18115_/Q VDD VSS _11359_/A INVX1
X_14105_ _14074_/Y _14105_/B _14105_/C VDD VSS _18170_/D AND3BX1
XFILLER_10_1072 VDD VSS DECAPHV16
X_12297_ _18310_/Q VDD VSS _12376_/A INVX1
X_15085_ _18639_/Q _19017_/Q _15085_/C VDD VSS _15090_/C MIN3X1
XFILLER_122_761 VDD VSS DECAPHV8
XFILLER_45_1135 VDD VSS FILLER1
XFILLER_68_815 VDD VSS DECAPHV8
X_11248_ _18965_/Q _18086_/Q VDD VSS _11263_/C XOR2X1
X_18913_ _18913_/CK _18913_/D _18913_/Q VDD VSS DFFQX1
X_14036_ _17154_/A _18984_/Q VDD VSS _18105_/D AND2X1
XFILLER_110_934 VDD VSS DECAPHV8
XFILLER_68_848 VDD VSS FILLER1
X_11179_ _17994_/Q _11184_/A VDD VSS _11182_/A XNOR2X1
X_18844_ _18844_/CK _18844_/D _18844_/Q VDD VSS DFFQX1
XFILLER_110_967 VDD VSS FILLER1
XFILLER_55_509 VDD VSS DECAPHV16
XTAP_TAPCELL_ROW_128_1551 VDD VSS WELLTAP
X_18775_ _18801_/CK _18775_/D _18775_/Q VDD VSS DFFQX1
X_15987_ _16120_/A _16064_/C VDD VSS _15988_/B NOR2X1
X_17726_ _18547_/CK _17726_/D _17726_/Q VDD VSS DFFQX1
X_14938_ _18607_/Q _18639_/Q _14938_/C VDD VSS _14944_/C MIN3X1
XFILLER_36_756 VSS VDD FILLER2
XFILLER_63_553 VDD VSS FILLER4
X_17657_ _17722_/CK _17657_/D _17657_/Q VDD VSS DFFQX1
X_14869_ _14872_/A _14872_/B _17229_/A VDD VSS _14870_/C OAI21X1
XFILLER_17_992 VDD VSS FILLER1
X_16608_ _16608_/A _16608_/B _16608_/C VDD VSS _16649_/C MIN3X1
XTAP_TAPCELL_ROW_33_412 VDD VSS WELLTAP
XTAP_TAPCELL_ROW_61_754 VDD VSS WELLTAP
X_17588_ _19045_/CK _17588_/D _17588_/Q VDD VSS DFFQX1
XFILLER_32_995 VDD VSS FILLER4
XFILLER_85_0 VDD VSS DECAPHV32
X_16539_ _18851_/Q _18689_/Q VDD VSS _16541_/B NOR2X1
XTAP_TAPCELL_ROW_13_180 VDD VSS WELLTAP
X_09011_ _09011_/A _09031_/B VDD VSS _17459_/B XOR2X1
X_18209_ _18261_/CK _18209_/D _18209_/Q VDD VSS DFFQX1
XFILLER_117_544 VSS VDD FILLER2
XTAP_TAPCELL_ROW_92_1127 VDD VSS WELLTAP
XFILLER_132_569 VSS VDD FILLER2
X_09913_ _10111_/A _10111_/B _10121_/C VDD VSS _10123_/B OAI21X1
XFILLER_86_623 VDD VSS FILLER4
X_09844_ _10922_/A VDD VSS _09976_/A BUFX3
XFILLER_101_967 VDD VSS DECAPHV16
XFILLER_58_336 VDD VSS FILLER4
XTAP_TAPCELL_ROW_69_843 VDD VSS WELLTAP
XFILLER_26_1090 VDD VSS DECAPHV16
XFILLER_39_561 VDD VSS DECAPHV8
XFILLER_74_818 VDD VSS FILLER4
XFILLER_85_144 VSS VDD FILLER2
X_09775_ _17661_/Q _17455_/B VDD VSS _09776_/B XNOR2X1
XFILLER_2_1059 VDD VSS DECAPHV8
XFILLER_23_951 VDD VSS FILLER1
XFILLER_42_748 VDD VSS DECAPHV8
XFILLER_10_601 VSS VDD FILLER2
XFILLER_23_962 VSS VDD FILLER2
XFILLER_23_973 VDD VSS FILLER4
XFILLER_50_770 VDD VSS FILLER1
XTAP_TAPCELL_ROW_101_1234 VDD VSS WELLTAP
X_10550_ _10700_/A _10700_/B _10700_/C _10701_/C VDD VSS _10570_/B AOAI211X1
XFILLER_33_1061 VDD VSS FILLER4
XFILLER_33_1072 VDD VSS FILLER1
X_09209_ _09226_/A _09226_/B VDD VSS _17433_/B XNOR2X1
X_10481_ _17865_/Q VDD VSS _10482_/A INVX1
X_12220_ _12503_/A _12503_/B _12503_/C VDD VSS _12298_/B AOI21X1
XFILLER_118_40 VDD VSS FILLER4
XFILLER_123_503 VSS VDD FILLER2
XFILLER_123_514 VDD VSS DECAPHV8
X_12151_ _18125_/Q _14056_/B VDD VSS _12159_/A AND2X1
XFILLER_104_750 VSS VDD FILLER2
XFILLER_78_44 VSS VDD FILLER2
XFILLER_96_409 VDD VSS DECAPHV8
X_11102_ _17059_/C _17045_/B VDD VSS _18004_/D AND2X1
X_12082_ _12121_/A _12121_/B _12121_/C VDD VSS _12179_/C NOR3X1
XFILLER_77_612 VSS VDD FILLER2
XTAP_TAPCELL_ROW_112_1363 VDD VSS WELLTAP
X_11033_ _11033_/A _11033_/B _11033_/C VDD VSS _11038_/A MIN3X1
X_15910_ _15939_/C VDD VSS _16109_/A BUFX3
XFILLER_103_282 VDD VSS DECAPHV16
XFILLER_49_336 VDD VSS DECAPHV16
X_16890_ _16957_/A _16890_/B VDD VSS _16892_/A NOR2X1
XFILLER_65_829 VDD VSS DECAPHV8
XFILLER_94_32 VDD VSS DECAPHV8
X_15841_ _18035_/Q _18645_/Q VDD VSS _15842_/D XNOR2X1
X_12984_ _18186_/Q VDD VSS _13085_/A INVX1
X_18560_ clkload7/A _18560_/D _18560_/Q VDD VSS DFFQX1
X_15772_ _16076_/A VDD VSS _15936_/A INVX1
X_11935_ _12122_/A _12122_/B _12122_/D _12122_/C VDD VSS _14197_/C AOI211X1
X_18491_ _18493_/CK _18491_/D _18491_/Q VDD VSS DFFQX1
X_17511_ _17746_/Q VDD VSS _17512_/B INVX1
X_14723_ _14723_/A _14723_/B _14723_/C VDD VSS _14729_/C OA21X2
XFILLER_27_92 VDD VSS FILLER1
XFILLER_72_350 VDD VSS FILLER4
XFILLER_72_372 VDD VSS FILLER1
XFILLER_73_895 VSS VDD FILLER2
X_17442_ _17445_/A _17442_/B VDD VSS _17649_/D NOR2X1
X_14654_ _14652_/Y _14657_/A _17525_/B VDD VSS _18547_/D AND3BX1
X_11866_ wire29/Y _12026_/B _12026_/D VDD VSS _11876_/B OAI21X1
X_13605_ _13605_/A _13605_/B _13605_/C _13605_/D VDD VSS _14428_/B OAOI211X1
XFILLER_14_973 VSS VDD FILLER2
XTAP_TAPCELL_ROW_123_1492 VDD VSS WELLTAP
X_10817_ _10817_/A _10817_/B VDD VSS _10818_/B NOR2X1
X_11797_ _18201_/Q _11797_/B _11924_/D VDD VSS _11931_/C XNOR3X1
X_17373_ _17446_/A _17373_/B VDD VSS _17584_/D AND2X1
X_14585_ _18532_/Q _18564_/Q VDD VSS _14591_/B NAND2X1
XFILLER_13_472 VSS VDD FILLER2
XFILLER_43_80 VDD VSS DECAPHV8
X_10748_ _10753_/B _10748_/B VDD VSS _10878_/A OR2X2
X_16324_ _18845_/Q _18683_/Q VDD VSS _16327_/C AND2X1
X_13536_ _13547_/A _14398_/B _13598_/C VDD VSS _14399_/C NOR3X1
X_19043_ _19043_/CK _19043_/D _19043_/Q VDD VSS DFFQX1
X_16255_ _18844_/Q _18682_/Q VDD VSS _16276_/B XNOR2X1
X_13467_ _18347_/Q _13467_/B _13467_/C VDD VSS _13542_/C XNOR3X1
X_10679_ _17897_/Q _10679_/B VDD VSS _10817_/A NOR2BX1
X_12418_ _12419_/A _12419_/B _12419_/D _12419_/C VDD VSS _12530_/B OAOI211X1
X_15206_ _15286_/A _18775_/Q VDD VSS _18748_/D AND2X1
X_16186_ _16196_/A _16485_/B _16485_/C _16186_/D VDD VSS _16234_/B AO31X2
X_13398_ _13408_/A _13408_/B _13398_/C VDD VSS _14184_/C OAI21X1
XFILLER_114_514 VDD VSS DECAPHV8
XFILLER_99_203 VDD VSS FILLER1
X_12349_ _18155_/Q VDD VSS _12448_/A INVX1
X_15137_ _15274_/A _18707_/Q VDD VSS _18680_/D AND2X1
X_15068_ _18636_/Q _19014_/Q VDD VSS _15070_/B XOR2X1
XFILLER_101_219 VDD VSS FILLER1
XFILLER_68_612 VDD VSS DECAPHV16
X_14019_ _17059_/C _18967_/Q VDD VSS _18088_/D AND2X1
XFILLER_110_753 VDD VSS FILLER1
XFILLER_55_306 VDD VSS FILLER1
X_18827_ _18853_/CK _18827_/D _18827_/Q VDD VSS DFFQX1
XFILLER_67_177 VSS VDD FILLER2
XFILLER_83_626 VDD VSS FILLER4
XFILLER_95_497 VSS VDD FILLER2
XTAP_TAPCELL_ROW_66_813 VDD VSS WELLTAP
X_09560_ _09581_/C _09560_/B VDD VSS _09584_/A XNOR2X1
X_18758_ _18787_/CK _18758_/D _18758_/Q VDD VSS DFFQX1
X_09491_ _09493_/A _09493_/B _09491_/C VDD VSS _17773_/D AOI21X1
X_17709_ _17710_/CK _17709_/D _17709_/Q VDD VSS DFFQX1
XFILLER_23_203 VDD VSS DECAPHV8
XFILLER_24_726 VSS VDD FILLER2
XFILLER_51_512 VDD VSS FILLER4
XTAP_TAPCELL_ROW_46_570 VDD VSS WELLTAP
X_18689_ _18851_/CK _18689_/D _18689_/Q VDD VSS DFFQX1
XFILLER_24_759 VDD VSS DECAPHV8
XFILLER_63_383 VSS VDD FILLER2
XFILLER_17_1045 VDD VSS FILLER1
XFILLER_136_138 VDD VSS DECAPHV32
XFILLER_118_886 VDD VSS DECAPHV8
XFILLER_2_129 VDD VSS DECAPHV8
XFILLER_133_889 VSS VDD FILLER2
XFILLER_63_1021 VSS VDD FILLER2
XFILLER_63_1043 VDD VSS FILLER4
XFILLER_58_133 VDD VSS FILLER1
XFILLER_59_634 VDD VSS FILLER1
XFILLER_86_442 VSS VDD FILLER2
XFILLER_101_775 VSS VDD FILLER2
XFILLER_111_1008 VDD VSS FILLER1
XFILLER_58_166 VSS VDD FILLER2
X_09827_ _17772_/Q _09827_/B VDD VSS _09989_/B XOR2X1
XFILLER_111_1019 VDD VSS FILLER4
XFILLER_46_328 VSS VDD FILLER2
XFILLER_58_177 VSS VDD FILLER2
X_09758_ _09759_/A _09759_/B _09759_/C VDD VSS _09760_/B NOR3X1
XFILLER_14_203 VSS VDD FILLER2
XTAP_TAPCELL_ROW_16_209 VDD VSS WELLTAP
X_09689_ _17657_/Q _17451_/B VDD VSS _09690_/A NAND2BX1
X_11720_ _18408_/Q _11821_/B _11724_/C VDD VSS _14407_/B XNOR3X1
XFILLER_42_545 VDD VSS FILLER4
X_11651_ _18407_/Q _14377_/B VDD VSS _11821_/B NOR2X1
Xfanout40 _18865_/Q VDD VSS _15799_/B BUFX3
X_10602_ _10599_/A _10602_/B VDD VSS _10605_/B NAND2BX1
X_11582_ _18276_/Q _11663_/B _14223_/B VDD VSS _11660_/C XOR3X1
Xfanout51 _17534_/A VDD VSS _17554_/C BUFX3
Xfanout62 _14343_/A VDD VSS _14310_/C BUFX3
Xfanout73 hold96/Y VDD VSS _15310_/A BUFX3
X_14370_ _14394_/A _14370_/B _14370_/C VDD VSS _18400_/D NOR3X1
XFILLER_10_431 VDD VSS DECAPHV8
XFILLER_11_954 VDD VSS FILLER1
XFILLER_13_50 VDD VSS FILLER1
X_10533_ _10533_/A _10533_/B _10533_/C _10533_/D VDD VSS _10687_/B OAOI211X1
Xfanout84 hold96/A VDD VSS _16984_/A BUFX3
X_13321_ _18294_/Q _13321_/B _13379_/D VDD VSS _14272_/B XNOR3X1
XFILLER_10_475 VSS VDD FILLER2
X_16040_ _16089_/A _16089_/B VDD VSS _16041_/B NAND2X1
XFILLER_109_875 VSS VDD FILLER2
XFILLER_89_32 VDD VSS DECAPHV32
X_10464_ _10467_/A _10467_/B VDD VSS _10648_/B XNOR2X1
X_13252_ _18449_/Q _13444_/A _13444_/B VDD VSS _13262_/D XNOR3X1
XFILLER_109_897 VDD VSS FILLER4
XFILLER_135_160 VDD VSS DECAPHV16
XFILLER_136_672 VSS VDD FILLER2
X_10395_ _10395_/A _10395_/B VDD VSS _10405_/B NOR2X1
X_12203_ _18413_/Q _12203_/B _12203_/C VDD VSS _12403_/B MIN3X1
X_13183_ _13183_/A _14331_/B _13273_/C _13183_/D VDD VSS _13371_/A OAOI211X1
XFILLER_123_333 VDD VSS DECAPHV8
XTAP_TAPCELL_ROW_0_20 VDD VSS WELLTAP
X_12134_ _12221_/A _14171_/B _14171_/C VDD VSS _12305_/C NOR3X1
X_17991_ _17993_/CK _17991_/D _17991_/Q VDD VSS DFFQX1
XFILLER_1_184 VSS VDD FILLER2
X_12065_ _12065_/A _12065_/B _12065_/C VDD VSS _12137_/C XNOR3X1
X_16942_ _16942_/A _16942_/B _16942_/C VDD VSS _16943_/B OAI21X1
XFILLER_49_166 VDD VSS FILLER1
XFILLER_77_442 VDD VSS FILLER1
XFILLER_77_453 VDD VSS FILLER4
X_11016_ _17962_/Q _11021_/A VDD VSS _11017_/B XNOR2X1
X_16873_ _16882_/B _16873_/B VDD VSS _16875_/B XNOR2X1
XFILLER_77_497 VDD VSS DECAPHV16
X_18612_ _18990_/CK _18612_/D _18612_/Q VDD VSS DFFQX1
X_15824_ _15822_/Y _15824_/B _16537_/A _18752_/Q VDD VSS _15860_/C AOI2B2X1
XFILLER_46_840 VDD VSS DECAPHV8
XFILLER_80_607 VDD VSS DECAPHV8
XTAP_TAPCELL_ROW_125_1521 VDD VSS WELLTAP
X_18543_ _18641_/CK _18543_/D _18543_/Q VDD VSS DFFQX1
XFILLER_73_670 VDD VSS FILLER1
X_12967_ _13011_/A _13011_/B _13011_/D _13011_/C VDD VSS _13178_/B OAOI211X1
X_15755_ _18862_/Q VDD VSS _15874_/A INVX1
XFILLER_72_191 VDD VSS FILLER1
X_11918_ _12013_/A _12013_/B _12013_/C VDD VSS _11922_/B AOI21X1
X_12898_ _13086_/A _13086_/B _13086_/D _13086_/C VDD VSS _13094_/B AOAI211X1
X_18474_ _18500_/CK _18474_/D _18474_/Q VDD VSS DFFQX1
X_15686_ _15686_/A _15686_/B _15686_/C VDD VSS _15686_/Y AOI21X1
X_14706_ _14710_/A _14707_/B _17229_/A VDD VSS _14707_/C OAI21X1
XFILLER_61_898 VDD VSS DECAPHV16
XTAP_TAPCELL_ROW_43_540 VDD VSS WELLTAP
X_11849_ _18148_/Q _14081_/B VDD VSS _11850_/D _14081_/C NAND3X1
X_17425_ _17445_/A _17425_/B VDD VSS _17632_/D NOR2X1
X_14637_ _14639_/A _14639_/B _14637_/C VDD VSS _18543_/D AOI21X1
XTAP_TAPCELL_ROW_71_871 VDD VSS WELLTAP
X_17356_ _17396_/A VDD VSS _17378_/A BUFX3
X_14568_ _18529_/Q _18561_/Q VDD VSS _14573_/A XNOR2X1
X_16307_ _16307_/A _16307_/B VDD VSS _16309_/C NOR2X1
Xclkload10 _19004_/CK VDD VSS clkload10/Y INVX2
X_17287_ _19013_/Q _17287_/B _17291_/A VDD VSS _17288_/B AOI21X1
X_14499_ _14517_/A _14499_/B VDD VSS _18512_/D NOR2X1
X_13519_ _13519_/A _13519_/B _13519_/C _13519_/D VDD VSS _13597_/A AOAI211X1
XTAP_TAPCELL_ROW_136_1650 VDD VSS WELLTAP
XTAP_TAPCELL_ROW_136_1661 VDD VSS WELLTAP
X_19026_ _19028_/CK _19026_/D _19026_/Q VDD VSS DFFQX1
Xclkload43 _18985_/CK VDD VSS clkload43/Y INVX1
Xclkload32 _18480_/CK VDD VSS clkload32/Y BUFX12
Xclkload21 _18940_/CK VDD VSS clkload21/Y BUFX12
X_16238_ _16238_/A VDD VSS _16239_/C INVX1
XFILLER_115_823 VDD VSS FILLER4
Xclkload87 _17867_/CK VDD VSS clkload87/Y BUFX12
Xclkload76 _19052_/CK VDD VSS clkload76/Y BUFX12
Xclkload65 _18309_/CK VDD VSS clkload65/Y INVX1
Xclkload54 _18397_/CK VDD VSS clkload54/Y INVX4
Xclkbuf_leaf_19__000_ clkbuf_leaf_9__000_/A VDD VSS _18835_/CK BUFX12
X_16169_ _16169_/A _16169_/B _16169_/C _16169_/D VDD VSS _16257_/C AOAI211X1
XFILLER_48_0 VDD VSS DECAPHV32
Xclkload98 _17901_/CK VDD VSS clkload98/Y INVX2
XFILLER_47_1049 VDD VSS FILLER1
X_08991_ _17662_/Q _17456_/B VDD VSS _09000_/A NAND2X1
XFILLER_87_239 VDD VSS FILLER1
XFILLER_110_550 VSS VDD FILLER2
XFILLER_96_762 VDD VSS DECAPHV8
XTAP_TAPCELL_ROW_79_971 VDD VSS WELLTAP
XFILLER_28_328 VSS VDD FILLER2
XFILLER_56_626 VDD VSS DECAPHV8
XFILLER_68_475 VDD VSS FILLER4
XFILLER_96_795 VDD VSS FILLER1
X_09612_ _09612_/A _09612_/B VDD VSS _09613_/B _09612_/C NAND3X1
XFILLER_83_456 VSS VDD FILLER2
XTAP_TAPCELL_ROW_87_1059 VDD VSS WELLTAP
X_09543_ _09519_/A _09543_/B _09543_/C VDD VSS _09546_/B AOI2B1X1
XFILLER_110_1074 VDD VSS FILLER1
XFILLER_37_895 VDD VSS DECAPHV16
XFILLER_64_681 VDD VSS FILLER4
XFILLER_70_117 VDD VSS FILLER1
XFILLER_63_180 VDD VSS FILLER4
X_09474_ _09474_/A _09474_/B _09474_/C _09474_/D VDD VSS _09484_/A AOAI211X1
XFILLER_34_49 VDD VSS DECAPHV16
XFILLER_51_375 VDD VSS FILLER1
XFILLER_52_898 VDD VSS DECAPHV8
Xclkbuf_1_0__f_clk_fs_regs clkbuf_0_clk_fs_regs/Y VDD VSS clkbuf_leaf_5_clk_fs_regs/A
+ BUFX12
Xclkload4 clkload4/A VDD VSS clkload4/Y BUFX12
XTAP_TAPCELL_ROW_21_267 VDD VSS WELLTAP
XFILLER_118_650 VDD VSS DECAPHV8
XFILLER_105_311 VDD VSS FILLER4
XFILLER_117_160 VDD VSS DECAPHV16
XTAP_TAPCELL_ROW_98_1199 VDD VSS WELLTAP
XFILLER_105_322 VDD VSS DECAPHV16
XFILLER_105_366 VDD VSS FILLER1
X_10180_ _10351_/B _10183_/B _10183_/D _10183_/C VDD VSS _10370_/C OAI211X1
XFILLER_132_174 VDD VSS DECAPHV32
XFILLER_86_250 VSS VDD FILLER2
XFILLER_101_561 VDD VSS DECAPHV16
XFILLER_115_96 VDD VSS DECAPHV32
X_13870_ _13870_/A _13870_/B _13870_/C _13870_/D VDD VSS _13892_/B OAOI211X1
XFILLER_75_979 VSS VDD FILLER2
XFILLER_90_905 VDD VSS FILLER1
X_12821_ _12947_/A _13021_/B VDD VSS _14360_/B XNOR2X1
XFILLER_62_629 VSS VDD FILLER2
XFILLER_74_478 VDD VSS FILLER1
XTAP_TAPCELL_ROW_29_367 VDD VSS WELLTAP
XFILLER_61_139 VDD VSS FILLER1
XTAP_TAPCELL_ROW_57_698 VDD VSS WELLTAP
X_12752_ _12863_/A _12863_/B _12859_/C VDD VSS _14178_/B AOI21BX1
X_15540_ _15540_/A _15540_/B _15540_/C VDD VSS _15563_/B MIN3X1
X_11703_ _11779_/A _14052_/B _14052_/C VDD VSS _11847_/C NOR3X1
X_12683_ _18184_/Q _12899_/A _13086_/B VDD VSS _12769_/D XNOR3X1
X_15471_ _15475_/A _15475_/B VDD VSS _15473_/B XNOR2X1
XFILLER_91_88 VDD VSS FILLER4
XTAP_TAPCELL_ROW_120_1462 VDD VSS WELLTAP
X_11634_ _14051_/A _14051_/B _18120_/Q VDD VSS _11635_/D OA21X2
X_17210_ _19000_/Q _17232_/B VDD VSS _17214_/B XNOR2X1
X_14422_ _14431_/A _14422_/B _14422_/C VDD VSS _18448_/D NOR3X1
XFILLER_129_904 VDD VSS DECAPHV16
X_18190_ _18295_/CK _18190_/D _18190_/Q VDD VSS DFFQX1
XFILLER_10_261 VSS VDD FILLER2
X_11565_ _11637_/A _11637_/B _11637_/C VDD VSS _11569_/B OAI21X1
X_17141_ _18023_/Q _17144_/B VDD VSS _17145_/B XNOR2X1
X_14353_ _14423_/A _14353_/B VDD VSS _18386_/D AND2X1
XFILLER_109_650 VDD VSS FILLER1
XFILLER_116_609 VDD VSS FILLER1
X_10516_ _10516_/A _10679_/B VDD VSS _17897_/D NOR2X1
X_11496_ _18972_/Q _18093_/Q VDD VSS _11560_/A XOR2X1
X_13304_ _13408_/B _14183_/C _18241_/Q VDD VSS _13305_/D AND3BX1
X_17072_ _18010_/Q _17076_/B VDD VSS _17074_/C XOR2X1
X_14284_ _14313_/A _14284_/B VDD VSS _18329_/D NOR2X1
XFILLER_109_683 VDD VSS FILLER4
X_10447_ _10447_/A _10450_/B VDD VSS _10631_/B XNOR2X1
X_13235_ _13289_/A _13289_/C VDD VSS _13236_/C NAND2X1
X_16023_ _16023_/A VDD VSS _16185_/C INVX1
XFILLER_112_826 VDD VSS FILLER4
X_10378_ _10388_/A _10378_/B _10385_/B VDD VSS _10562_/C XNOR3X1
X_13166_ _18396_/Q _14365_/B VDD VSS _13278_/A AND2X1
XFILLER_112_837 VSS VDD FILLER2
XTAP_TAPCELL_ROW_131_1591 VDD VSS WELLTAP
X_12117_ _12215_/A _12227_/A _12305_/B VDD VSS _12118_/D XNOR3X1
X_13097_ _13097_/A _13097_/B _13122_/C _13097_/D VDD VSS _14153_/C OAI211X1
X_17974_ _18000_/CK _17974_/D _17974_/Q VDD VSS DFFQX1
XFILLER_111_369 VSS VDD FILLER2
X_12048_ _12063_/A _14112_/B _12063_/C _12048_/D VDD VSS _12244_/A OAOI211X1
X_16925_ _16925_/A _16925_/B _16925_/C _16925_/D VDD VSS _16928_/C AOI211X1
XFILLER_120_881 VSS VDD FILLER2
XFILLER_38_615 VSS VDD FILLER2
XFILLER_66_924 VDD VSS FILLER1
XFILLER_66_946 VDD VSS FILLER4
XFILLER_19_840 VDD VSS FILLER1
XFILLER_1_64 VDD VSS DECAPHV16
XFILLER_37_147 VSS VDD FILLER2
XFILLER_38_659 VDD VSS DECAPHV8
XFILLER_66_979 VSS VDD FILLER2
XFILLER_93_754 VDD VSS FILLER1
XTAP_TAPCELL_ROW_76_930 VDD VSS WELLTAP
X_16856_ _16866_/A _16867_/A VDD VSS _16859_/A NOR2X1
XFILLER_53_607 VDD VSS FILLER1
XFILLER_81_949 VDD VSS DECAPHV8
XFILLER_93_798 VDD VSS FILLER4
X_16787_ _16819_/A _16819_/B _16787_/C VDD VSS _16844_/B AO21X2
X_15807_ _15838_/A _15838_/B VDD VSS _15808_/B XNOR2X1
X_13999_ _13999_/A _13999_/B _14008_/C _14013_/D VDD VSS _18076_/D OAOI211X1
XFILLER_19_895 VDD VSS FILLER4
XFILLER_46_681 VDD VSS DECAPHV16
XFILLER_52_117 VDD VSS DECAPHV16
X_18526_ clkload7/A _18526_/D _18526_/Q VDD VSS DFFQX1
X_15738_ _18890_/Q _15738_/B VDD VSS _15739_/C NAND2X1
X_18457_ _18509_/CK _18457_/D _18457_/Q VDD VSS DFFQX1
XFILLER_33_375 VDD VSS FILLER4
X_17408_ _17410_/A _17408_/B VDD VSS _17617_/D NOR2X1
X_15669_ _15669_/A _17002_/A _15669_/C VDD VSS _18882_/D OAI21X1
XFILLER_53_1053 VSS VDD FILLER2
X_09190_ _09197_/B _09190_/B VDD VSS _17330_/B XNOR2X1
X_18388_ _18417_/CK _18388_/D _18388_/Q VDD VSS DFFQX1
XFILLER_53_1097 VDD VSS DECAPHV8
X_17339_ _17396_/A VDD VSS _17355_/A BUFX3
XFILLER_135_918 VDD VSS DECAPHV8
Xclkload121 _18848_/CK VDD VSS clkload121/Y INVX2
Xclkload110 clkload110/A VDD VSS clkload110/Y INVX14
X_19009_ _19011_/CK _19009_/D _19009_/Q VDD VSS DFFQX1
XFILLER_0_408 VDD VSS DECAPHV32
XFILLER_114_174 VDD VSS DECAPHV16
X_08974_ _08979_/C _08975_/B _17455_/A VDD VSS _08975_/C OAI21X1
XFILLER_57_913 VSS VDD FILLER2
XFILLER_56_412 VDD VSS FILLER4
XFILLER_110_380 VSS VDD FILLER2
XFILLER_29_648 VSS VDD FILLER2
XFILLER_44_607 VSS VDD FILLER2
XFILLER_72_938 VDD VSS FILLER1
XFILLER_83_264 VSS VDD FILLER2
XFILLER_25_821 VSS VDD FILLER2
XFILLER_83_297 VDD VSS DECAPHV8
XTAP_TAPCELL_ROW_26_326 VDD VSS WELLTAP
X_09526_ _17651_/Q _17444_/B VDD VSS _09553_/A NAND2BX1
XFILLER_101_32 VDD VSS DECAPHV32
XFILLER_80_960 VDD VSS FILLER1
XTAP_TAPCELL_ROW_54_668 VDD VSS WELLTAP
X_09457_ _17617_/Q _17408_/B VDD VSS _09459_/C XNOR2X1
XFILLER_12_526 VDD VSS DECAPHV8
XTAP_TAPCELL_ROW_82_999 VDD VSS WELLTAP
XFILLER_12_559 VDD VSS FILLER4
XFILLER_40_879 VDD VSS FILLER4
X_09388_ _17646_/Q _17439_/B VDD VSS _09399_/A NOR2X1
XFILLER_32_1126 VDD VSS DECAPHV8
X_11350_ _11350_/A _11350_/B _14070_/B VDD VSS _11351_/B MIN3X1
XFILLER_119_992 VSS VDD FILLER2
X_10301_ _10154_/Y _10499_/B _10499_/C VDD VSS _17868_/D AND3BX1
X_11281_ _11349_/B _11281_/B _11281_/C _11281_/D VDD VSS _11316_/B OAOI211X1
X_13020_ _13020_/A _13020_/B _13020_/C _13020_/D VDD VSS _13258_/B AOAI211X1
XFILLER_106_686 VDD VSS FILLER4
XFILLER_10_40 VDD VSS FILLER4
XFILLER_126_40 VDD VSS FILLER4
X_10232_ _10232_/A _10232_/B VDD VSS _10239_/A OR2X2
XFILLER_105_174 VDD VSS FILLER1
X_10163_ _10164_/B _10174_/B _17821_/Q VDD VSS _10165_/C AOI21X1
XFILLER_86_44 VSS VDD FILLER2
XFILLER_121_689 VSS VDD FILLER2
XFILLER_59_261 VSS VDD FILLER2
X_10094_ _10276_/A _10107_/D VDD VSS _10309_/B XNOR2X1
X_16710_ _16746_/A _16746_/B _16866_/A VDD VSS _16738_/A AOI21X1
X_14971_ _14970_/B _14971_/B VDD VSS _14974_/C NOR2BX1
XFILLER_48_979 VDD VSS FILLER4
XFILLER_74_220 VDD VSS FILLER1
XFILLER_75_765 VDD VSS DECAPHV8
XTAP_TAPCELL_ROW_109_1324 VDD VSS WELLTAP
X_17690_ _17725_/CK _17690_/D _17690_/Q VDD VSS DFFQX1
X_13922_ _18513_/Q _13929_/C _13922_/C VDD VSS _13924_/B XNOR3X1
XFILLER_63_938 VDD VSS DECAPHV8
XTAP_TAPCELL_ROW_73_900 VDD VSS WELLTAP
X_16641_ _18915_/Q _16641_/B VDD VSS _16642_/A NAND2X1
X_13853_ _13853_/A _13853_/B _13853_/C _13853_/D VDD VSS _13884_/B OAOI211X1
XFILLER_16_843 VDD VSS FILLER1
XFILLER_28_692 VDD VSS FILLER4
XFILLER_90_735 VSS VDD FILLER2
X_12804_ _18471_/Q _12924_/B _12812_/C VDD VSS _14481_/B XNOR3X1
Xclkbuf_leaf_18__001_ clkload75/A VDD VSS _18024_/CK BUFX12
X_16572_ _18799_/Q _18745_/Q VDD VSS _16620_/B AND2X1
X_10996_ _17959_/Q _11001_/B VDD VSS _11002_/A XNOR2X1
X_18311_ _18337_/CK _18311_/D _18311_/Q VDD VSS DFFQX1
X_15523_ _18871_/Q _15523_/B _15523_/C VDD VSS _15540_/B MIN3X1
X_13784_ _13784_/A _13784_/B _13784_/C _13784_/D VDD VSS _13794_/B AOAI211X1
XFILLER_124_1007 VSS VDD FILLER2
XFILLER_31_835 VSS VDD FILLER2
X_12735_ _18262_/Q VDD VSS _12854_/A INVX1
XTAP_TAPCELL_ROW_6_85 VDD VSS WELLTAP
XTAP_TAPCELL_ROW_6_96 VDD VSS WELLTAP
X_12666_ _12667_/A _12667_/B _12667_/D _12667_/C VDD VSS _14092_/B AO211X2
X_18242_ _18267_/CK _18242_/D _18242_/Q VDD VSS DFFQX1
X_15454_ _15669_/A _15454_/B _15454_/C VDD VSS _18867_/D OAI21X1
XFILLER_128_222 VDD VSS DECAPHV8
X_11617_ _18145_/Q _14078_/B VDD VSS _11618_/D _14078_/C NAND3X1
X_12597_ _18417_/Q VDD VSS _12712_/A INVX1
X_18173_ _18199_/CK _18173_/D _18173_/Q VDD VSS DFFQX1
X_15385_ _16588_/A _15385_/B VDD VSS _15386_/C NAND2X1
X_14405_ _14405_/A _14405_/B _17534_/A VDD VSS _18432_/D OA21X2
XFILLER_51_80 VDD VSS DECAPHV8
X_11548_ _11558_/A _11558_/B _11614_/C VDD VSS _14106_/C NOR3X1
X_17124_ _18019_/Q _17124_/B VDD VSS _17127_/A AND2X1
X_14336_ _14243_/Y _14336_/B _14336_/C VDD VSS _18373_/D AND3BX1
XFILLER_116_417 VDD VSS FILLER1
XFILLER_128_299 VDD VSS DECAPHV16
XTAP_TAPCELL_ROW_133_1620 VDD VSS WELLTAP
X_11479_ _18143_/Q _14076_/B _14076_/C VDD VSS _11483_/D OR3BX1
X_17055_ _18006_/Q _17055_/B VDD VSS _17058_/A NOR2BX1
X_14267_ _14243_/Y _14267_/B _14267_/C VDD VSS _18316_/D AND3BX1
XFILLER_100_1095 VDD VSS FILLER1
XFILLER_98_813 VDD VSS FILLER1
X_13218_ _13218_/A _14153_/B _13218_/C _13218_/D VDD VSS _13405_/A AOAI211X1
X_16006_ _18838_/Q _18676_/Q VDD VSS _16047_/C XNOR2X1
X_14198_ _14361_/A VDD VSS _14198_/Y BUFX3
XFILLER_135_1114 VSS VDD FILLER2
XFILLER_83_1068 VSS VDD FILLER2
X_13149_ _13149_/A _13149_/B _14487_/B VDD VSS _13338_/B MIN3X1
XFILLER_39_902 VDD VSS FILLER4
XFILLER_66_710 VDD VSS DECAPHV16
X_17957_ _17961_/CK _17957_/D _17957_/Q VDD VSS DFFQX1
XFILLER_65_231 VSS VDD FILLER2
X_17888_ _17913_/CK _17888_/D _17888_/Q VDD VSS DFFQX1
X_16908_ _16939_/A _16908_/B VDD VSS _16911_/A AND2X1
XFILLER_26_607 VDD VSS DECAPHV8
XFILLER_38_489 VDD VSS FILLER1
XFILLER_53_404 VDD VSS FILLER1
XFILLER_81_724 VDD VSS FILLER4
X_16839_ _16850_/B _16839_/B _16839_/C VDD VSS _18923_/D OAI21X1
XFILLER_20_1074 VDD VSS FILLER1
XFILLER_65_286 VDD VSS FILLER1
XTAP_TAPCELL_ROW_84_1029 VDD VSS WELLTAP
XFILLER_20_1096 VDD VSS FILLER1
XFILLER_34_640 VDD VSS DECAPHV16
XFILLER_34_662 VDD VSS FILLER1
XFILLER_81_779 VDD VSS DECAPHV16
X_09311_ _17707_/Q VDD VSS _09312_/B INVX1
X_18509_ _18509_/CK _18509_/D _18509_/Q VDD VSS DFFQX1
XTAP_TAPCELL_ROW_51_627 VDD VSS WELLTAP
XFILLER_22_846 VDD VSS DECAPHV16
X_09242_ _09244_/A _09244_/B VDD VSS _09271_/B OR2X2
XFILLER_21_367 VDD VSS FILLER1
X_09173_ _17606_/Q _17397_/B VDD VSS _09174_/C NOR2X1
Xclkbuf_leaf_16_clk_fs_regs clkbuf_leaf_9_clk_fs_regs/A VDD VSS _18934_/CK BUFX12
XTAP_TAPCELL_ROW_31_395 VDD VSS WELLTAP
XFILLER_135_737 VDD VSS FILLER4
XFILLER_116_940 VDD VSS DECAPHV8
XTAP_TAPCELL_ROW_95_1158 VDD VSS WELLTAP
XFILLER_122_409 VSS VDD FILLER2
Xoutput17 _18064_/Q VDD VSS data_out[2] BUFX3
XFILLER_88_323 VSS VDD FILLER2
XFILLER_76_507 VDD VSS FILLER4
XFILLER_29_412 VDD VSS FILLER1
XFILLER_5_1013 VDD VSS DECAPHV8
XFILLER_76_518 VSS VDD FILLER2
XFILLER_76_529 VSS VDD FILLER2
XTAP_TAPCELL_ROW_59_727 VDD VSS WELLTAP
X_08957_ _09218_/A _08957_/B VDD VSS _17751_/D NOR2X1
XFILLER_56_231 VDD VSS FILLER1
X_08888_ _17726_/Q _18515_/Q VDD VSS _17526_/A NAND2X1
XFILLER_45_927 VSS VDD FILLER2
XFILLER_57_787 VDD VSS FILLER4
XTAP_TAPCELL_ROW_39_484 VDD VSS WELLTAP
X_10850_ _10914_/A _10985_/A VDD VSS _17956_/D NOR2X1
XFILLER_25_662 VDD VSS FILLER4
XFILLER_12_312 VDD VSS DECAPHV8
XFILLER_13_813 VDD VSS FILLER1
XFILLER_71_278 VDD VSS FILLER1
XTAP_TAPCELL_ROW_104_1265 VDD VSS WELLTAP
X_09509_ _09510_/A _09510_/B _09510_/C VDD VSS _09553_/B OAI21X1
X_10781_ _17915_/Q _10781_/B VDD VSS _10782_/C NOR2BX1
X_12520_ _12343_/A _14116_/B _14116_/C VDD VSS _12522_/C AND3BX1
X_12451_ _18981_/Q _18102_/Q VDD VSS _12453_/C NOR2X1
XFILLER_36_1092 VDD VSS FILLER4
X_11402_ _18969_/Q _18090_/Q VDD VSS _11446_/B NAND2X1
X_15170_ _15281_/A _18740_/Q VDD VSS _18713_/D AND2X1
X_12382_ _14325_/B _14325_/C VDD VSS _12408_/B NOR2X1
X_14121_ _14122_/A _14121_/B _14121_/C VDD VSS _18185_/D NOR3X1
XFILLER_115_0 VDD VSS DECAPHV32
XFILLER_21_72 VDD VSS FILLER1
X_11333_ _18218_/Q _14158_/B VDD VSS _11334_/B OR2X2
XFILLER_125_269 VDD VSS DECAPHV8
XFILLER_97_32 VDD VSS DECAPHV32
X_11264_ _18966_/Q _18087_/Q VDD VSS _11319_/B XOR2X1
X_14052_ _14079_/A _14052_/B _14052_/C VDD VSS _18121_/D NOR3X1
XTAP_TAPCELL_ROW_115_1394 VDD VSS WELLTAP
X_10215_ _10395_/A _10395_/B _10405_/C VDD VSS _10407_/B OAI21X1
X_13003_ _18187_/Q _13216_/A _13225_/B VDD VSS _13191_/D XNOR3X1
X_18860_ _18863_/CK _18860_/D _18860_/Q VDD VSS DFFQX1
X_11195_ _17154_/A _17139_/B VDD VSS _18022_/D AND2X1
X_17811_ _17865_/CK _17811_/D _17811_/Q VDD VSS DFFQX1
XFILLER_94_315 VDD VSS FILLER4
X_10146_ _10330_/A _10330_/B _10330_/C _10331_/C VDD VSS _10349_/B AOAI211X1
X_18791_ _18818_/CK _18791_/D _18791_/Q VDD VSS DFFQX1
X_10077_ _10707_/A _10267_/B VDD VSS _17836_/D AND2X1
X_17742_ clkload5/A _17742_/D _17742_/Q VDD VSS DFFQX1
X_14954_ _18612_/Q _18990_/Q VDD VSS _14956_/B XNOR2X1
XFILLER_43_1085 VDD VSS DECAPHV8
XFILLER_47_264 VSS VDD FILLER2
X_17673_ _17706_/CK _17673_/D _17673_/Q VDD VSS DFFQX1
X_13905_ _13905_/A _13905_/B _13905_/C _13905_/D VDD VSS _13912_/C OAOI211X1
XFILLER_47_286 VSS VDD FILLER2
XFILLER_62_212 VDD VSS FILLER1
X_16624_ _18853_/Q _18691_/Q _16624_/C _16624_/D VDD VSS _16625_/C AOAI211X1
X_14885_ _14889_/A _14886_/B _17266_/C VDD VSS _14886_/C OAI21X1
XFILLER_35_459 VDD VSS FILLER1
X_13836_ _18404_/Q _14374_/B VDD VSS _13838_/C _14374_/C NAND3X1
XFILLER_90_587 VDD VSS DECAPHV8
X_10979_ _11024_/A _11118_/B VDD VSS _17981_/D NOR2X1
X_16555_ _16518_/Y _16591_/B _16629_/A VDD VSS _16630_/B MUXI2X1
X_13767_ _18404_/Q _13767_/B _13800_/C VDD VSS _13847_/B XNOR3X1
XFILLER_71_790 VDD VSS FILLER1
X_12718_ _12718_/A _12718_/B _12718_/C VDD VSS _12931_/C NOR3X1
X_16486_ _16800_/A _16486_/B _16486_/C VDD VSS _16531_/B AOI21X1
X_15506_ _18870_/Q _15668_/B VDD VSS _15507_/C NAND2X1
XFILLER_15_1110 VDD VSS FILLER4
X_18225_ _18252_/CK _18225_/D _18225_/Q VDD VSS DFFQX1
X_15437_ _15549_/B _15436_/Y _15480_/A VDD VSS _15518_/B MUXI2X1
X_13698_ _18325_/Q VDD VSS _13702_/A INVX1
X_12649_ _12536_/A _14147_/B _14147_/C VDD VSS _12742_/C AND3BX1
XFILLER_102_1135 VDD VSS FILLER1
X_18156_ _18199_/CK _18156_/D _18156_/Q VDD VSS DFFQX1
X_15368_ _18909_/Q _18908_/Q VDD VSS _15382_/A _15410_/B NAND3X1
XFILLER_7_96 VDD VSS DECAPHV32
X_18087_ _18966_/CK _18087_/D _18087_/Q VDD VSS DFFQX1
X_17107_ _17107_/A _17107_/B _17107_/C VDD VSS _17112_/B OA21X2
X_15299_ _15299_/A _18040_/Q VDD VSS _18839_/D AND2X1
X_14319_ _14346_/A _14319_/B VDD VSS _18357_/D NOR2X1
XFILLER_116_258 VSS VDD FILLER2
X_17038_ _17038_/A _17038_/B VDD VSS _17044_/B NAND2X1
XFILLER_125_781 VDD VSS FILLER1
X_09860_ _17782_/Q _09860_/B VDD VSS _09863_/B NOR2BX1
XFILLER_30_0 VDD VSS DECAPHV32
XFILLER_97_120 VDD VSS FILLER1
XFILLER_98_654 VDD VSS FILLER1
XFILLER_100_615 VSS VDD FILLER2
XFILLER_97_153 VDD VSS FILLER4
XTAP_TAPCELL_ROW_90_1099 VDD VSS WELLTAP
X_09791_ _17761_/Q _09886_/C VDD VSS _09885_/B XOR2X1
X_18989_ _18989_/CK _18989_/D _18989_/Q VDD VSS DFFQX1
XFILLER_85_359 VDD VSS DECAPHV8
XFILLER_38_253 VDD VSS FILLER4
XFILLER_66_562 VDD VSS FILLER1
XFILLER_38_297 VDD VSS FILLER4
XFILLER_94_893 VDD VSS FILLER4
XTAP_TAPCELL_ROW_36_454 VDD VSS WELLTAP
XTAP_TAPCELL_ROW_64_785 VDD VSS WELLTAP
XFILLER_34_492 VDD VSS DECAPHV8
XFILLER_42_49 VDD VSS DECAPHV32
XFILLER_50_974 VSS VDD FILLER2
XFILLER_50_996 VSS VDD FILLER2
X_09225_ _17672_/Q _17467_/B VDD VSS _09226_/C NOR2X1
X_09156_ _09156_/A _09180_/C VDD VSS _17464_/B XNOR2X1
XFILLER_107_236 VDD VSS FILLER4
XFILLER_108_737 VDD VSS FILLER4
X_09087_ _19024_/Q _17323_/B _17322_/B _19023_/Q VDD VSS _09089_/C OAI22X1
XFILLER_122_206 VDD VSS DECAPHV16
XTAP_TAPCELL_ROW_8_113 VDD VSS WELLTAP
Xclkbuf_leaf_17__002_ clkbuf_leaf_9__002_/A VDD VSS _18250_/CK BUFX12
XFILLER_104_954 VDD VSS DECAPHV16
XFILLER_107_64 VDD VSS DECAPHV16
XFILLER_118_1131 VDD VSS FILLER1
XFILLER_27_1014 VDD VSS DECAPHV8
X_10000_ _17800_/Q _10000_/B VDD VSS _10005_/A NAND2X1
XFILLER_103_464 VDD VSS FILLER1
XFILLER_49_507 VDD VSS FILLER1
XFILLER_76_304 VDD VSS FILLER1
XFILLER_77_827 VDD VSS DECAPHV8
XFILLER_7_1119 VDD VSS DECAPHV16
X_09989_ _17798_/Q _09989_/B _09989_/C VDD VSS _10194_/A OR3BX1
XFILLER_17_437 VSS VDD FILLER2
XFILLER_18_938 VDD VSS FILLER4
XFILLER_29_286 VSS VDD FILLER2
XFILLER_72_510 VDD VSS FILLER1
X_11951_ _12025_/A _12025_/B _12025_/D _12025_/C VDD VSS _14112_/C AOI211X1
XFILLER_123_96 VDD VSS DECAPHV32
XFILLER_33_908 VDD VSS FILLER1
X_10902_ _17940_/Q _10906_/B VDD VSS _10903_/B XOR2X1
X_11882_ _11883_/B _11883_/C _18227_/Q VDD VSS _11929_/B AOI21X1
X_14670_ _18551_/Q _18583_/Q VDD VSS _14671_/B XOR2X1
XFILLER_38_1132 VDD VSS FILLER4
XFILLER_60_716 VDD VSS FILLER4
X_10833_ _17927_/Q _10837_/B VDD VSS _10834_/B XOR2X1
X_13621_ _13631_/A _14277_/B _13621_/C VDD VSS _14278_/C AOI21X1
XFILLER_125_1113 VSS VDD FILLER2
XFILLER_13_632 VDD VSS DECAPHV16
XFILLER_41_952 VSS VDD FILLER2
X_10764_ _10844_/A _10897_/B VDD VSS _17938_/D NOR2X1
X_16340_ _16604_/A _16340_/B _16340_/C _16711_/A VDD VSS _16341_/C OA211X2
X_13552_ _13558_/A _14306_/B _13558_/C VDD VSS _14307_/C OR3X2
XFILLER_12_142 VDD VSS DECAPHV16
XFILLER_13_654 VDD VSS DECAPHV32
XFILLER_40_462 VDD VSS FILLER1
XFILLER_73_1078 VDD VSS DECAPHV16
X_12503_ _12503_/A _12503_/B _12503_/C _12503_/D VDD VSS _12509_/B AOAI211X1
XFILLER_40_495 VSS VDD FILLER2
XFILLER_41_996 VSS VDD FILLER2
XFILLER_8_113 VDD VSS DECAPHV16
X_10695_ _10822_/B _10695_/B _10695_/C _10695_/D VDD VSS _10696_/B OAI211X1
X_18010_ _18025_/CK _18010_/D _18010_/Q VDD VSS DFFQX1
X_16271_ _18905_/Q _16527_/B VDD VSS _16272_/C NAND2X1
X_13483_ _14184_/B _14184_/C _18242_/Q VDD VSS _13486_/B AOI21X1
X_12434_ _12626_/A _12626_/B _12626_/C VDD VSS _12465_/B AOI21X1
X_15222_ _15250_/A _18791_/Q VDD VSS _18764_/D AND2X1
XTAP_TAPCELL_ROW_117_1423 VDD VSS WELLTAP
XTAP_TAPCELL_ROW_3_53 VDD VSS WELLTAP
X_12365_ _18154_/Q _14089_/B VDD VSS _12366_/D _14089_/C NAND3X1
X_15153_ _17182_/D _18723_/Q VDD VSS _18696_/D AND2X1
X_11316_ _11316_/A _11316_/B _11316_/C _11316_/D VDD VSS _11399_/A OAOI211X1
X_15084_ _15084_/A _15085_/C _15084_/C VDD VSS _18639_/D AOI21X1
X_14104_ _14107_/A _14104_/B VDD VSS _18169_/D AND2X1
XFILLER_10_1062 VDD VSS FILLER4
X_12296_ _12296_/A _14260_/B VDD VSS _12379_/A OR2X2
X_18912_ _18913_/CK _18912_/D _18912_/Q VDD VSS DFFQX1
X_14035_ _17122_/D _18983_/Q VDD VSS _18104_/D AND2X1
X_11247_ _11247_/A _11247_/B _11247_/C _11289_/B VDD VSS _11263_/B OAOI211X1
XFILLER_122_773 VSS VDD FILLER2
XFILLER_67_304 VDD VSS DECAPHV8
XFILLER_68_827 VSS VDD FILLER2
XFILLER_68_838 VDD VSS FILLER1
XFILLER_80_1049 VSS VDD FILLER2
XFILLER_95_624 VDD VSS FILLER1
X_11178_ _17154_/A _17124_/B VDD VSS _18019_/D AND2X1
X_18843_ _18844_/CK _18843_/D _18843_/Q VDD VSS DFFQX1
XFILLER_83_808 VDD VSS DECAPHV16
X_10129_ _17818_/Q _10129_/B _10129_/C VDD VSS _10322_/C XNOR3X1
X_18774_ _18801_/CK _18774_/D _18774_/Q VDD VSS DFFQX1
X_17725_ _17725_/CK _17725_/D _17725_/Q VDD VSS DFFQX1
X_15986_ _15986_/A _15986_/B VDD VSS _16064_/C NOR2X1
XFILLER_36_735 VDD VSS FILLER1
XFILLER_94_178 VDD VSS DECAPHV16
XTAP_TAPCELL_ROW_128_1552 VDD VSS WELLTAP
X_14937_ _14937_/A _14938_/C _14937_/C VDD VSS _18607_/D AOI21X1
XFILLER_35_223 VDD VSS DECAPHV8
XFILLER_35_245 VDD VSS FILLER1
X_17656_ _17656_/CK _17656_/D _17656_/Q VDD VSS DFFQX1
X_14868_ _18592_/Q _18624_/Q _14868_/C VDD VSS _14872_/B MIN3X1
XFILLER_23_429 VDD VSS DECAPHV16
XFILLER_50_215 VSS VDD FILLER2
XFILLER_51_716 VDD VSS FILLER4
X_17587_ _19045_/CK _17587_/D _17587_/Q VDD VSS DFFQX1
X_16607_ _18664_/Q VDD VSS _16608_/B INVX1
X_13819_ _13827_/A _13827_/B _13827_/D _13827_/C VDD VSS _14496_/C AOI211X1
XFILLER_91_1134 VSS VDD FILLER2
XTAP_TAPCELL_ROW_33_413 VDD VSS WELLTAP
X_16538_ _18852_/Q _18690_/Q VDD VSS _16587_/A XNOR2X1
X_14799_ _18577_/Q _18609_/Q _14799_/C VDD VSS _14801_/A MIN3X1
XTAP_TAPCELL_ROW_61_755 VDD VSS WELLTAP
X_09010_ _17729_/Q _17697_/Q VDD VSS _09031_/B XNOR2X1
X_16469_ _16467_/Y _16503_/B _16547_/D VDD VSS _16470_/E AND3BX1
XFILLER_106_1090 VDD VSS FILLER1
XFILLER_78_0 VDD VSS DECAPHV32
XTAP_TAPCELL_ROW_13_170 VDD VSS WELLTAP
X_18208_ _18261_/CK _18208_/D _18208_/Q VDD VSS DFFQX1
XFILLER_117_512 VSS VDD FILLER2
X_18139_ _18195_/CK _18139_/D _18139_/Q VDD VSS DFFQX1
XTAP_TAPCELL_ROW_92_1117 VDD VSS WELLTAP
XFILLER_104_217 VDD VSS FILLER4
XTAP_TAPCELL_ROW_92_1128 VDD VSS WELLTAP
XFILLER_99_941 VDD VSS FILLER4
X_09912_ _09915_/A _09926_/C VDD VSS _10121_/C XNOR2X1
XFILLER_98_451 VDD VSS DECAPHV16
X_09843_ _09843_/A _10023_/A VDD VSS _17803_/D NOR2X1
XTAP_TAPCELL_ROW_69_844 VDD VSS WELLTAP
XFILLER_26_1080 VSS VDD FILLER2
X_09774_ _09774_/A _09774_/B VDD VSS _17455_/B XNOR2X1
XFILLER_113_1061 VDD VSS DECAPHV8
XFILLER_26_212 VSS VDD FILLER2
XFILLER_54_521 VDD VSS DECAPHV16
XFILLER_85_189 VSS VDD FILLER2
XFILLER_96_1023 VDD VSS FILLER4
XFILLER_81_340 VDD VSS FILLER4
XFILLER_42_727 VDD VSS FILLER4
XFILLER_109_1119 VSS VDD FILLER2
XFILLER_23_941 VSS VDD FILLER2
XTAP_TAPCELL_ROW_101_1235 VDD VSS WELLTAP
XFILLER_50_793 VDD VSS DECAPHV8
X_09208_ _17672_/Q _17467_/B VDD VSS _09226_/B XOR2X1
X_10480_ _10480_/A _10480_/B VDD VSS _10493_/B XNOR2X1
XFILLER_120_1043 VDD VSS DECAPHV8
XFILLER_6_639 VDD VSS DECAPHV32
X_09139_ _09150_/B _09139_/B VDD VSS _17362_/B XNOR2X1
XFILLER_136_854 VDD VSS FILLER1
X_12150_ _12249_/A _12249_/B _12239_/C VDD VSS _14086_/B AOI21BX1
XFILLER_135_375 VDD VSS DECAPHV32
XFILLER_136_898 VSS VDD FILLER2
X_11101_ _11103_/C _11101_/B VDD VSS _17045_/B XNOR2X1
XFILLER_104_740 VSS VDD FILLER2
X_12081_ _18282_/Q _12081_/B _12216_/D VDD VSS _12121_/C XNOR3X1
XTAP_TAPCELL_ROW_112_1364 VDD VSS WELLTAP
X_11032_ _11032_/A VDD VSS _11033_/C INVX1
XFILLER_134_40 VDD VSS FILLER4
XFILLER_89_484 VSS VDD FILLER2
Xclkbuf_1_1__f_clk_fs clkbuf_0_clk_fs/Y VDD VSS _172_/CK BUFX12
X_15840_ _18034_/Q _18644_/Q VDD VSS _15842_/C NAND2X1
XFILLER_40_1011 VDD VSS FILLER4
XFILLER_65_808 VDD VSS DECAPHV8
XFILLER_77_679 VSS VDD FILLER2
XFILLER_94_44 VSS VDD FILLER2
XFILLER_58_882 VDD VSS FILLER1
XFILLER_76_178 VDD VSS FILLER4
X_12983_ _13120_/A _13120_/B VDD VSS _13005_/B NOR2X1
X_15771_ _15771_/A _15771_/B _15771_/C _15771_/D VDD VSS _15771_/Y NOR4X1
XFILLER_18_757 VDD VSS DECAPHV8
XFILLER_27_60 VSS VDD FILLER2
XFILLER_40_1077 VDD VSS FILLER1
XFILLER_40_1099 VDD VSS DECAPHV16
XFILLER_57_392 VSS VDD FILLER2
XFILLER_91_159 VDD VSS FILLER4
X_11934_ _11934_/A _14168_/B _14168_/C VDD VSS _12122_/C NOR3X1
X_18490_ _18496_/CK _18490_/D _18490_/Q VDD VSS DFFQX1
X_17510_ _17514_/A _17745_/Q VDD VSS _17713_/D AND2X1
X_14722_ _18561_/Q _18593_/Q VDD VSS _14723_/C NAND2X1
XFILLER_32_204 VDD VSS FILLER4
XFILLER_33_727 VDD VSS FILLER1
X_17441_ _17514_/A _17441_/B VDD VSS _17648_/D AND2X1
X_14653_ _18547_/Q _18579_/Q VDD VSS _14657_/A NAND2X1
XFILLER_32_237 VDD VSS FILLER1
X_11865_ _18149_/Q _14082_/B VDD VSS _12026_/D _14082_/C NAND3X1
X_13604_ _18427_/Q _14400_/B VDD VSS _14428_/A NOR2BX1
XFILLER_129_1090 VDD VSS DECAPHV16
XTAP_TAPCELL_ROW_123_1493 VDD VSS WELLTAP
X_10816_ _10816_/A _10816_/B _10816_/C VDD VSS _10824_/A MIN3X1
X_11796_ _18175_/Q wire29/Y _12025_/B VDD VSS _11924_/D XNOR3X1
X_17372_ _17378_/A _17372_/B VDD VSS _17583_/D NOR2X1
X_14584_ _18532_/Q _18564_/Q VDD VSS _14591_/C NOR2X1
XFILLER_14_996 VDD VSS FILLER1
XFILLER_41_793 VSS VDD FILLER2
XFILLER_43_92 VDD VSS FILLER1
X_10747_ _10747_/A _10747_/B _10747_/C VDD VSS _10748_/B NOR3X1
X_16323_ _18846_/Q _18684_/Q VDD VSS _16327_/D XOR2X1
X_13535_ _13591_/A _13591_/B _13591_/C VDD VSS _14399_/B AOI21X1
XFILLER_12_1102 VSS VDD FILLER2
X_10678_ _10731_/A _10816_/B VDD VSS _17923_/D NOR2X1
X_19042_ _19042_/CK _19042_/D _19042_/Q VDD VSS DFFQX1
X_16254_ _16246_/Y _16254_/B _16252_/Y _16254_/D VDD VSS _16261_/B AOI2B2BX1
X_13466_ _13466_/A _13466_/B _13466_/C _13466_/D VDD VSS _13542_/B AOAI211X1
XFILLER_127_821 VDD VSS DECAPHV16
XTAP_TAPCELL_ROW_10_140 VDD VSS WELLTAP
X_12417_ _12617_/A _12617_/B _12617_/C VDD VSS _12468_/B AOI21X1
X_15205_ _15286_/A _18774_/Q VDD VSS _18747_/D AND2X1
X_16185_ _16196_/A _16604_/A _16185_/C VDD VSS _16186_/D NOR3X1
X_13397_ _13408_/A _13408_/B _13398_/C VDD VSS _14184_/B OR3X2
XFILLER_114_526 VDD VSS FILLER1
XFILLER_126_364 VSS VDD FILLER2
XFILLER_127_887 VSS VDD FILLER2
X_12348_ _12436_/A _12436_/B _12436_/D VDD VSS _12368_/B OAI21X1
X_15136_ _15274_/A _18706_/Q VDD VSS _18679_/D AND2X1
X_12279_ _14053_/A _12279_/B VDD VSS _18036_/D NOR2X1
X_15067_ _18635_/Q _19013_/Q _15067_/C VDD VSS _15072_/C AO21X2
X_14018_ _17059_/C _18966_/Q VDD VSS _18087_/D AND2X1
XFILLER_110_743 VDD VSS DECAPHV8
XFILLER_136_1083 VDD VSS DECAPHV32
XFILLER_96_966 VDD VSS DECAPHV8
XFILLER_68_679 VSS VDD FILLER2
X_18826_ _18853_/CK _18826_/D _18826_/Q VDD VSS DFFQX1
XFILLER_64_830 VDD VSS DECAPHV16
XTAP_TAPCELL_ROW_66_814 VDD VSS WELLTAP
X_18757_ _18840_/CK _18757_/D _18757_/Q VDD VSS DFFQX1
X_15969_ _18037_/Q _18647_/Q VDD VSS _15972_/C AND2X1
XFILLER_82_137 VSS VDD FILLER2
XTAP_TAPCELL_ROW_89_1090 VDD VSS WELLTAP
X_09490_ _09493_/A _09493_/B _17446_/A VDD VSS _09491_/C OAI21X1
X_18688_ _18851_/CK _18688_/D _18688_/Q VDD VSS DFFQX1
X_17708_ _17710_/CK _17708_/D _17708_/Q VDD VSS DFFQX1
XFILLER_91_682 VSS VDD FILLER2
XTAP_TAPCELL_ROW_18_240 VDD VSS WELLTAP
X_17639_ _17669_/CK _17639_/D _17639_/Q VDD VSS DFFQX1
XFILLER_23_215 VSS VDD FILLER2
XTAP_TAPCELL_ROW_46_571 VDD VSS WELLTAP
XFILLER_23_259 VDD VSS DECAPHV8
XFILLER_20_911 VDD VSS FILLER4
XFILLER_56_1095 VDD VSS DECAPHV8
XFILLER_118_832 VDD VSS DECAPHV8
XFILLER_117_375 VDD VSS DECAPHV16
XFILLER_118_898 VDD VSS FILLER1
XFILLER_133_824 VSS VDD FILLER2
XFILLER_133_835 VSS VDD FILLER2
XFILLER_105_537 VDD VSS DECAPHV8
XFILLER_132_323 VSS VDD FILLER2
XFILLER_113_581 VSS VDD FILLER2
XFILLER_86_421 VDD VSS FILLER1
XFILLER_98_281 VSS VDD FILLER2
XFILLER_24_1028 VDD VSS DECAPHV8
XFILLER_47_819 VDD VSS FILLER4
X_09826_ _17771_/Q _09829_/C VDD VSS _09827_/B NAND2X1
XFILLER_104_32 VDD VSS DECAPHV8
XFILLER_27_510 VDD VSS FILLER1
XFILLER_74_627 VSS VDD FILLER2
X_09757_ _19051_/Q _17352_/B VDD VSS _09759_/C XOR2X1
XFILLER_27_565 VDD VSS FILLER1
XFILLER_54_373 VDD VSS FILLER1
X_09688_ _09714_/A _09714_/B VDD VSS _09702_/A NAND2X1
X_11650_ _18381_/Q _11728_/B _11653_/C VDD VSS _14377_/B XNOR3X1
XFILLER_11_922 VDD VSS FILLER1
XFILLER_11_933 VSS VDD FILLER2
XFILLER_35_1135 VDD VSS FILLER1
X_10601_ _17881_/Q _10601_/B VDD VSS _10605_/A NAND2X1
X_11581_ _18250_/Q _11669_/B _11601_/C VDD VSS _14223_/B XNOR3X1
Xfanout41 _17455_/A VDD VSS _17318_/C BUFX3
Xfanout52 _17498_/A VDD VSS _17544_/C BUFX3
Xfanout63 _14107_/A VDD VSS _17154_/A BUFX3
Xfanout74 _15307_/A VDD VSS _15281_/A BUFX3
XFILLER_10_421 VDD VSS FILLER1
XFILLER_128_607 VDD VSS DECAPHV16
XFILLER_7_904 VDD VSS DECAPHV16
X_10532_ _17872_/Q _10532_/B VDD VSS _10687_/A AND2X1
Xfanout85 _14396_/A VDD VSS _14372_/A BUFX3
X_13320_ _18268_/Q _13486_/A _13493_/B VDD VSS _13379_/D XNOR3X1
XFILLER_127_128 VDD VSS DECAPHV32
X_10463_ _17863_/Q _10468_/B VDD VSS _10467_/B XNOR2X1
X_13251_ _13258_/A _13258_/B _13258_/C _13251_/D VDD VSS _13444_/A AOAI211X1
XFILLER_124_813 VSS VDD FILLER2
X_10394_ _10571_/A _10571_/B _10572_/C _10394_/D VDD VSS _10582_/B OAOI211X1
X_12202_ _12202_/A _12202_/B _14383_/B VDD VSS _12203_/B MIN3X1
X_13182_ _13182_/A _14303_/B _14303_/C VDD VSS _13183_/D NOR3X1
XFILLER_124_857 VDD VSS FILLER4
XFILLER_89_88 VDD VSS FILLER4
XFILLER_8_0 VDD VSS DECAPHV32
XTAP_TAPCELL_ROW_0_10 VDD VSS WELLTAP
XTAP_TAPCELL_ROW_0_21 VDD VSS WELLTAP
X_12133_ _12146_/A _14170_/B _12224_/C VDD VSS _14171_/C AND3BX1
X_17990_ _18016_/CK _17990_/D _17990_/Q VDD VSS DFFQX1
XFILLER_78_922 VDD VSS FILLER4
X_12064_ _12064_/A _14083_/B VDD VSS _12137_/A OR2X2
X_16941_ _18933_/Q _16952_/B VDD VSS _16953_/B XOR2X1
XFILLER_104_581 VDD VSS FILLER1
X_11015_ _11015_/A _11015_/B _11015_/C _11015_/D VDD VSS _11022_/C AOAI211X1
X_16872_ _18926_/Q _16882_/C VDD VSS _16873_/B XOR2X1
XFILLER_93_958 VSS VDD FILLER2
X_18611_ _18989_/CK _18611_/D _18611_/Q VDD VSS DFFQX1
X_15823_ _15855_/A _15855_/B _16018_/C VDD VSS _15824_/B AOI21X1
XFILLER_46_830 VSS VDD FILLER2
XFILLER_92_468 VDD VSS DECAPHV8
XTAP_TAPCELL_ROW_125_1522 VDD VSS WELLTAP
X_18542_ _18641_/CK _18542_/D _18542_/Q VDD VSS DFFQX1
X_15754_ _16905_/B VDD VSS _16927_/B BUFX3
XFILLER_18_587 VDD VSS FILLER1
XFILLER_46_863 VSS VDD FILLER2
XFILLER_46_874 VDD VSS DECAPHV8
XFILLER_79_1062 VDD VSS DECAPHV8
X_12966_ _18290_/Q _13186_/A _13186_/B VDD VSS _13011_/C XNOR3X1
X_14705_ _14710_/C _14710_/B VDD VSS _14707_/B NAND2BX1
XFILLER_33_535 VDD VSS FILLER1
XFILLER_60_321 VDD VSS FILLER4
XFILLER_60_332 VSS VDD FILLER2
X_11917_ _18306_/Q _11917_/B _11917_/C VDD VSS _12011_/B MIN3X1
X_12897_ _12773_/A _14093_/B _14093_/C VDD VSS _13086_/D AND3BX1
X_18473_ _18500_/CK _18473_/D _18473_/Q VDD VSS DFFQX1
X_15685_ _15685_/A _15685_/B _15685_/C _15686_/A VDD VSS _15686_/C AOI211X1
XTAP_TAPCELL_ROW_43_530 VDD VSS WELLTAP
X_11848_ _14081_/B _14081_/C _18148_/Q VDD VSS _11850_/C AOI21X1
X_17424_ _17501_/A VDD VSS _17445_/A BUFX3
X_14636_ _14639_/A _14639_/B _17455_/A VDD VSS _14637_/C OAI21X1
XFILLER_13_270 VSS VDD FILLER2
XFILLER_14_793 VDD VSS DECAPHV16
XFILLER_60_398 VSS VDD FILLER2
XTAP_TAPCELL_ROW_71_872 VDD VSS WELLTAP
X_17355_ _17355_/A _17355_/B VDD VSS _17567_/D NOR2X1
X_14567_ _14696_/A _14567_/B VDD VSS _18528_/D NOR2X1
XFILLER_13_292 VSS VDD FILLER2
X_11779_ _11779_/A _11779_/B _11779_/C VDD VSS _11784_/B XNOR3X1
X_16306_ _16307_/A _16307_/B VDD VSS _16345_/B AND2X1
X_13518_ _18425_/Q _14398_/B _14398_/C VDD VSS _13519_/D OR3BX1
XFILLER_9_274 VDD VSS FILLER4
X_19025_ _19028_/CK _19025_/D _19025_/Q VDD VSS DFFQX1
X_17286_ _19014_/Q _17315_/B VDD VSS _17291_/B XNOR2X1
X_14498_ _17388_/A _14498_/B VDD VSS _18511_/D AND2X1
XTAP_TAPCELL_ROW_136_1651 VDD VSS WELLTAP
XTAP_TAPCELL_ROW_136_1662 VDD VSS WELLTAP
Xclkload44 _18978_/CK VDD VSS clkload44/Y INVX2
Xclkload33 _18509_/CK VDD VSS clkload33/Y INVX2
Xclkload22 _18934_/CK VDD VSS clkload22/Y INVX6
Xclkload11 _19011_/CK VDD VSS clkload11/Y INVX2
X_16237_ _16237_/A VDD VSS _16286_/B INVX1
X_13449_ _13517_/A _14425_/B _14425_/C VDD VSS _13516_/C NOR3X1
XFILLER_114_312 VSS VDD FILLER2
Xclkload77 _19051_/CK VDD VSS clkload77/Y INVX1
Xclkload66 _18337_/CK VDD VSS clkload66/Y INVX1
Xclkload55 _18448_/CK VDD VSS clkload55/Y BUFX12
X_16168_ _18841_/Q _18679_/Q VDD VSS _16169_/D NAND2X1
XFILLER_114_323 VSS VDD FILLER2
Xclkload99 _17908_/CK VDD VSS clkload99/Y INVX2
Xclkload88 _17865_/CK VDD VSS clkload88/Y INVX4
X_15119_ _15313_/A _18690_/Q VDD VSS _18663_/D AND2X1
XFILLER_102_507 VDD VSS FILLER4
XFILLER_130_816 VDD VSS FILLER1
X_08990_ _17726_/Q _17694_/Q VDD VSS _17456_/B XNOR2X1
X_16099_ _18813_/Q _18705_/Q VDD VSS _16102_/D XNOR2X1
XFILLER_68_421 VDD VSS FILLER4
XFILLER_69_933 VDD VSS DECAPHV8
XFILLER_96_741 VDD VSS FILLER1
XFILLER_68_454 VDD VSS FILLER4
XFILLER_69_977 VDD VSS DECAPHV8
XTAP_TAPCELL_ROW_79_961 VDD VSS WELLTAP
XFILLER_55_104 VDD VSS FILLER1
XFILLER_56_638 VSS VDD FILLER2
XTAP_TAPCELL_ROW_79_972 VDD VSS WELLTAP
X_09611_ _09612_/A _09612_/B _09612_/C VDD VSS _09640_/B AOI21X1
X_18809_ _18837_/CK _18809_/D _18809_/Q VDD VSS DFFQX1
X_09542_ _19042_/Q _17343_/B VDD VSS _09543_/C NOR2X1
XFILLER_58_1124 VDD VSS DECAPHV8
XFILLER_91_490 VDD VSS FILLER1
X_09473_ _17649_/Q _17442_/B VDD VSS _09474_/D OR2X2
XFILLER_51_398 VSS VDD FILLER2
Xclkload5 clkload5/A VDD VSS clkload5/Y INVX8
XFILLER_109_128 VDD VSS DECAPHV32
XFILLER_50_49 VDD VSS DECAPHV32
XTAP_TAPCELL_ROW_21_268 VDD VSS WELLTAP
XFILLER_30_1043 VDD VSS FILLER1
XFILLER_133_610 VSS VDD FILLER2
XFILLER_4_918 VDD VSS DECAPHV32
XTAP_TAPCELL_ROW_98_1189 VDD VSS WELLTAP
XFILLER_133_654 VSS VDD FILLER2
XFILLER_3_439 VDD VSS DECAPHV16
XFILLER_121_805 VSS VDD FILLER2
XFILLER_121_816 VDD VSS FILLER1
XFILLER_132_142 VDD VSS DECAPHV32
XFILLER_133_687 VDD VSS FILLER1
XFILLER_8_1011 VDD VSS DECAPHV16
XFILLER_101_551 VDD VSS FILLER4
XFILLER_115_64 VDD VSS DECAPHV16
XFILLER_47_605 VDD VSS FILLER4
XFILLER_59_443 VDD VSS FILLER1
XFILLER_87_752 VDD VSS DECAPHV8
XFILLER_8_1055 VDD VSS DECAPHV8
X_09809_ _17765_/Q _17766_/Q _17767_/Q _09810_/C VDD VSS _09821_/C AND4X2
XFILLER_47_649 VSS VDD FILLER2
X_12820_ _18420_/Q VDD VSS _12939_/A INVX1
XFILLER_43_800 VDD VSS FILLER4
XTAP_TAPCELL_ROW_29_368 VDD VSS WELLTAP
XFILLER_27_395 VSS VDD FILLER2
XTAP_TAPCELL_ROW_57_699 VDD VSS WELLTAP
X_12751_ _12751_/A _14148_/B VDD VSS _12863_/A OR2X2
XFILLER_131_96 VDD VSS DECAPHV32
XFILLER_15_557 VDD VSS FILLER1
XFILLER_70_641 VDD VSS FILLER1
X_11702_ _11706_/A _11779_/B _11706_/B VDD VSS _14052_/C NOR3X1
X_12682_ _18158_/Q _12781_/B _12773_/C VDD VSS _13086_/B XNOR3X1
X_15470_ _18868_/Q _15474_/B VDD VSS _15475_/B XNOR2X1
XFILLER_42_376 VDD VSS FILLER4
XFILLER_42_398 VSS VDD FILLER2
XFILLER_70_685 VDD VSS FILLER1
XTAP_TAPCELL_ROW_120_1463 VDD VSS WELLTAP
XTAP_TAPCELL_ROW_40_500 VDD VSS WELLTAP
X_11633_ _11637_/A _11637_/B _11637_/C _11633_/D VDD VSS _14051_/B OAOI211X1
X_14421_ _14440_/A _14421_/B VDD VSS _18447_/D NOR2X1
XFILLER_128_404 VDD VSS FILLER1
XFILLER_24_94 VDD VSS FILLER1
XFILLER_30_549 VDD VSS FILLER1
X_17140_ _17140_/A _17140_/B _17140_/C VDD VSS _17145_/A OAI21X1
XFILLER_11_763 VDD VSS FILLER4
XFILLER_7_734 VDD VSS DECAPHV8
X_11564_ _18972_/Q _18093_/Q VDD VSS _11637_/C NAND2X1
X_14352_ _14378_/A _14352_/B VDD VSS _18385_/D NOR2X1
XFILLER_10_284 VSS VDD FILLER2
XFILLER_6_222 VDD VSS DECAPHV8
X_10515_ _10680_/A _10680_/B VDD VSS _10679_/B XNOR2X1
X_11495_ _11562_/A _11562_/B _11562_/C VDD VSS _11502_/B AOI21X1
X_13303_ _13303_/A _13303_/B _13303_/C _13303_/D VDD VSS _14183_/C OAI211X1
X_17071_ _18009_/Q _17071_/B VDD VSS _17074_/A NOR2BX1
X_14283_ _14313_/A _14283_/B VDD VSS _18328_/D NOR2X1
XFILLER_109_662 VDD VSS FILLER4
X_10446_ _17860_/Q _10449_/B VDD VSS _10450_/B XOR2X1
X_13234_ _13234_/A _13234_/B _14269_/B _13234_/D _13234_/E VDD VSS _13289_/C OAI221X1
X_16022_ _16107_/B _16107_/C _16107_/A _16022_/D VDD VSS _16340_/B OAOI211X1
XFILLER_136_481 VSS VDD FILLER2
XFILLER_6_299 VDD VSS DECAPHV16
XFILLER_124_665 VDD VSS FILLER1
X_10377_ _17850_/Q VDD VSS _10388_/A INVX1
X_13165_ _13276_/A _13350_/B VDD VSS _14365_/B XNOR2X1
XTAP_TAPCELL_ROW_131_1592 VDD VSS WELLTAP
X_12116_ _18256_/Q VDD VSS _12215_/A INVX1
X_13096_ _13097_/A _13097_/B _13097_/D _13122_/C VDD VSS _13206_/B OAOI211X1
X_17973_ _18000_/CK _17973_/D _17973_/Q VDD VSS DFFQX1
XFILLER_111_359 VDD VSS FILLER1
XFILLER_46_1072 VDD VSS FILLER1
XFILLER_49_80 VDD VSS DECAPHV8
X_12047_ _12065_/A _14085_/B _14085_/C VDD VSS _12048_/D NOR3X1
X_16924_ _16925_/A _16925_/B _16925_/D _16925_/C VDD VSS _16927_/C AOAI211X1
XFILLER_1_32 VDD VSS DECAPHV32
XTAP_TAPCELL_ROW_48_600 VDD VSS WELLTAP
X_16855_ _16855_/A _16855_/B VDD VSS _16867_/A AND2X1
XFILLER_37_126 VDD VSS FILLER4
XTAP_TAPCELL_ROW_76_931 VDD VSS WELLTAP
X_15806_ _18833_/Q _18671_/Q VDD VSS _15838_/B XOR2X1
XFILLER_19_885 VDD VSS FILLER4
XFILLER_34_800 VDD VSS FILLER4
XFILLER_46_671 VDD VSS FILLER1
XFILLER_52_107 VSS VDD FILLER2
XFILLER_53_619 VDD VSS FILLER1
X_16786_ _16819_/A _16786_/B VDD VSS _16787_/C NOR2X1
X_13998_ _18953_/Q _13998_/B VDD VSS _13999_/B XOR2X1
XFILLER_18_373 VDD VSS DECAPHV8
X_12949_ _12949_/A _12949_/B _12949_/C _12949_/D VDD VSS _13161_/A OAOI211X1
X_18525_ clkload7/A _18525_/D _18525_/Q VDD VSS DFFQX1
X_15737_ _15737_/A _17017_/A _15737_/C VDD VSS _18890_/D OAI21X1
XFILLER_33_332 VDD VSS DECAPHV8
X_18456_ _18480_/CK _18456_/D _18456_/Q VDD VSS DFFQX1
X_15668_ _18882_/Q _15668_/B VDD VSS _15669_/C NAND2X1
XFILLER_21_538 VDD VSS DECAPHV8
XFILLER_53_1021 VSS VDD FILLER2
XFILLER_60_173 VDD VSS FILLER4
X_17407_ _17446_/A _17407_/B VDD VSS _17616_/D AND2X1
X_14619_ _14619_/A _14619_/B _14619_/C _14619_/D VDD VSS _14620_/C AOAI211X1
X_18387_ _18461_/CK _18387_/D _18387_/Q VDD VSS DFFQX1
Xclkbuf_leaf_15_clk_fs_regs clkbuf_leaf_9_clk_fs_regs/A VDD VSS _18940_/CK BUFX12
X_15599_ _15686_/A _15599_/B _15599_/C _15651_/A VDD VSS _15600_/C OAOI211X1
XFILLER_14_1016 VSS VDD FILLER2
X_17338_ _17338_/A _17338_/B VDD VSS _19038_/D NOR2X1
Xclkload122 _18815_/CK VDD VSS clkload122/Y INVX1
Xclkload111 _18857_/CK VDD VSS clkload111/Y INVX1
Xclkload100 _17861_/CK VDD VSS clkload100/Y INVX1
X_17269_ _17269_/A _17315_/B VDD VSS _17272_/D NAND2X1
XFILLER_60_0 VDD VSS DECAPHV32
X_19008_ _19011_/CK _19008_/D _19008_/Q VDD VSS DFFQX1
XFILLER_115_643 VDD VSS DECAPHV8
XFILLER_114_142 VDD VSS DECAPHV32
XFILLER_115_654 VDD VSS FILLER4
X_08973_ _17755_/Q _18544_/Q VDD VSS _08975_/B XNOR2X1
XFILLER_102_359 VSS VDD FILLER2
XFILLER_29_616 VDD VSS FILLER4
XFILLER_60_1058 VDD VSS FILLER4
XFILLER_84_700 VDD VSS DECAPHV16
XFILLER_84_755 VDD VSS DECAPHV8
XFILLER_56_468 VDD VSS DECAPHV8
XFILLER_65_980 VDD VSS FILLER4
XFILLER_71_438 VDD VSS DECAPHV8
XTAP_TAPCELL_ROW_26_327 VDD VSS WELLTAP
X_09525_ _17619_/Q _17410_/B _09525_/C VDD VSS _09551_/B OA21X2
XFILLER_24_354 VDD VSS FILLER4
XTAP_TAPCELL_ROW_54_669 VDD VSS WELLTAP
X_09456_ _09456_/A _09474_/C VDD VSS _17408_/B XOR2X1
XFILLER_25_899 VDD VSS FILLER1
XFILLER_40_836 VDD VSS FILLER1
XFILLER_80_983 VDD VSS FILLER4
XFILLER_101_88 VDD VSS FILLER4
XFILLER_12_538 VDD VSS FILLER1
XFILLER_51_195 VSS VDD FILLER2
XFILLER_8_509 VSS VDD FILLER2
X_09387_ _17614_/Q _17405_/B _09387_/C VDD VSS _09402_/A OAI21X1
XFILLER_32_1105 VSS VDD FILLER2
XFILLER_20_582 VDD VSS DECAPHV8
XFILLER_117_4 VDD VSS DECAPHV32
X_10300_ _10318_/A _10488_/B _10489_/C VDD VSS _10499_/C OR3BX1
X_11280_ _11287_/A _14044_/B VDD VSS _11316_/A NOR2X1
X_10231_ _10229_/Y _10707_/A _10419_/C VDD VSS _17854_/D AND3BX1
XFILLER_133_451 VDD VSS FILLER1
XFILLER_3_269 VDD VSS DECAPHV8
XFILLER_69_1072 VDD VSS FILLER4
XFILLER_121_624 VDD VSS FILLER4
X_10162_ _10154_/Y _10352_/B _10352_/C VDD VSS _17846_/D AND3BX1
XFILLER_0_943 VSS VDD FILLER2
XFILLER_121_668 VSS VDD FILLER2
X_10093_ _17814_/Q _10093_/B _10099_/B VDD VSS _10107_/D XNOR3X1
X_14970_ _14971_/B _14970_/B VDD VSS _14972_/B NOR2BX1
XFILLER_19_104 VDD VSS FILLER1
XFILLER_48_914 VSS VDD FILLER2
XFILLER_75_700 VSS VDD FILLER2
X_13921_ _13929_/A _13929_/B VDD VSS _13922_/C NOR2X1
XFILLER_101_381 VDD VSS DECAPHV8
XFILLER_87_593 VDD VSS DECAPHV8
XTAP_TAPCELL_ROW_109_1325 VDD VSS WELLTAP
XFILLER_35_619 VDD VSS FILLER1
XFILLER_47_468 VDD VSS FILLER4
XFILLER_75_777 VDD VSS FILLER1
X_16640_ _16875_/A _16640_/B _16640_/C VDD VSS _18915_/D OAI21X1
X_13852_ _18510_/Q _13852_/B _13887_/C VDD VSS _13884_/A XNOR3X1
XFILLER_28_671 VSS VDD FILLER2
X_12803_ _18445_/Q _12923_/B _12923_/C VDD VSS _12812_/C XNOR3X1
Xclkbuf_leaf_18__000_ clkbuf_leaf_9__000_/A VDD VSS _18808_/CK BUFX12
X_16571_ _18799_/Q _18745_/Q VDD VSS _16620_/C OR2X2
X_13783_ _18455_/Q _14430_/B VDD VSS _13794_/A NAND2X1
XFILLER_15_321 VSS VDD FILLER2
XFILLER_43_641 VDD VSS DECAPHV8
X_10995_ _11024_/A _11132_/B VDD VSS _17984_/D NOR2X1
X_12734_ _13009_/A _13009_/B _13009_/C VDD VSS _12831_/B AOI21X1
X_18310_ _18337_/CK _18310_/D _18310_/Q VDD VSS DFFQX1
X_15522_ _18871_/Q _15792_/D _15752_/C _16985_/A VDD VSS _18871_/D AO22X2
XFILLER_31_814 VSS VDD FILLER2
X_18241_ _18267_/CK _18241_/D _18241_/Q VDD VSS DFFQX1
XFILLER_30_346 VDD VSS FILLER1
XTAP_TAPCELL_ROW_6_86 VDD VSS WELLTAP
X_12665_ _12769_/A _12769_/B _12769_/C VDD VSS _12684_/B AOI21X1
X_15453_ _18867_/Q _15668_/B VDD VSS _15454_/C NAND2X1
XFILLER_129_724 VDD VSS FILLER4
XFILLER_30_357 VDD VSS DECAPHV8
X_11616_ _14078_/B _14078_/C _18145_/Q VDD VSS _11618_/C AOI21X1
X_12596_ _18443_/Q VDD VSS _12706_/A INVX1
X_18172_ _18199_/CK _18172_/D _18172_/Q VDD VSS DFFQX1
X_15384_ _18909_/Q _15384_/B VDD VSS _15385_/B XOR2X1
X_14404_ _14431_/A _14404_/B _14404_/C VDD VSS _18431_/D NOR3X1
XFILLER_129_779 VDD VSS FILLER1
X_11547_ _11618_/A _14105_/B _11614_/C VDD VSS _14106_/B AOI21BX1
X_17123_ _17127_/B _17123_/B VDD VSS _18981_/D NOR2X1
X_14335_ _14394_/A _14335_/B _14335_/C VDD VSS _18372_/D NOR3X1
XFILLER_116_407 VSS VDD FILLER2
XFILLER_128_267 VDD VSS DECAPHV32
X_17054_ _17054_/A _17054_/B _17054_/C VDD VSS _18968_/D OA21X2
XFILLER_13_1082 VDD VSS DECAPHV16
XFILLER_48_1101 VSS VDD FILLER2
XTAP_TAPCELL_ROW_133_1610 VDD VSS WELLTAP
X_11478_ _11478_/A _11478_/B _11478_/C VDD VSS _11483_/B XNOR3X1
X_16005_ _18837_/Q _18675_/Q VDD VSS _16047_/A NAND2X1
X_14266_ _14269_/A _14266_/B VDD VSS _18315_/D NOR2X1
X_10429_ _17857_/Q _10433_/B VDD VSS _10430_/B XOR2X1
X_13217_ _18188_/Q _14125_/B _14125_/C VDD VSS _13218_/D OR3BX1
X_14197_ _14236_/A _14197_/B _14197_/C VDD VSS _18254_/D NOR3X1
XFILLER_44_1009 VDD VSS FILLER4
X_13148_ _14053_/A _13148_/B VDD VSS _18044_/D NOR2X1
XFILLER_66_700 VDD VSS FILLER1
X_13079_ _18291_/Q _14240_/B _14240_/C VDD VSS _13080_/D OR3BX1
X_17956_ _17961_/CK _17956_/D _17956_/Q VDD VSS DFFQX1
XFILLER_111_189 VSS VDD FILLER2
XFILLER_120_690 VDD VSS FILLER4
XFILLER_78_593 VDD VSS DECAPHV8
X_17887_ _17913_/CK _17887_/D _17887_/Q VDD VSS DFFQX1
X_16907_ _18929_/Q _16907_/B _16907_/C VDD VSS _16925_/A MIN3X1
XFILLER_54_928 VDD VSS DECAPHV8
X_16838_ _18923_/Q _16862_/B VDD VSS _16839_/C NAND2X1
XFILLER_53_416 VDD VSS FILLER1
XFILLER_81_747 VDD VSS DECAPHV32
X_16769_ _16770_/A _16770_/B _16770_/C _16770_/D VDD VSS _16808_/B AO211X2
XFILLER_80_235 VDD VSS FILLER4
XFILLER_80_257 VDD VSS DECAPHV16
X_09310_ _17740_/Q _17708_/Q VDD VSS _09313_/A XNOR2X1
X_18508_ _18509_/CK _18508_/D _18508_/Q VDD VSS DFFQX1
XFILLER_34_696 VDD VSS FILLER1
XFILLER_62_972 VDD VSS FILLER4
XTAP_TAPCELL_ROW_51_628 VDD VSS WELLTAP
X_09241_ _19032_/Q _17332_/B VDD VSS _09244_/B XNOR2X1
X_18439_ _18461_/CK _18439_/D _18439_/Q VDD VSS DFFQX1
X_09172_ _17574_/Q _09172_/B _17363_/B VDD VSS _09197_/B MIN3X1
XFILLER_30_891 VDD VSS FILLER4
XTAP_TAPCELL_ROW_31_385 VDD VSS WELLTAP
XFILLER_119_278 VDD VSS FILLER1
XTAP_TAPCELL_ROW_31_396 VDD VSS WELLTAP
XTAP_TAPCELL_ROW_95_1159 VDD VSS WELLTAP
XFILLER_116_952 VSS VDD FILLER2
XFILLER_1_718 VDD VSS DECAPHV16
Xoutput18 _18065_/Q VDD VSS data_out[3] BUFX3
XFILLER_0_228 VDD VSS DECAPHV32
XFILLER_131_933 VDD VSS FILLER4
XFILLER_88_302 VSS VDD FILLER2
XFILLER_89_836 VDD VSS FILLER1
XFILLER_89_858 VDD VSS DECAPHV8
XFILLER_130_421 VDD VSS FILLER1
XFILLER_130_454 VSS VDD FILLER2
XFILLER_29_402 VDD VSS FILLER4
XTAP_TAPCELL_ROW_59_728 VDD VSS WELLTAP
X_08956_ _08959_/C _08956_/B VDD VSS _08957_/B XNOR2X1
XFILLER_99_1021 VSS VDD FILLER2
X_08887_ _17728_/Q _18517_/Q VDD VSS _17528_/B XOR2X1
XFILLER_29_457 VDD VSS FILLER1
XFILLER_29_468 VDD VSS FILLER1
XFILLER_56_265 VSS VDD FILLER2
XFILLER_5_1058 VDD VSS DECAPHV32
XFILLER_112_32 VDD VSS DECAPHV8
XFILLER_44_416 VSS VDD FILLER2
XFILLER_44_427 VDD VSS FILLER1
XFILLER_99_1087 VSS VDD FILLER2
XTAP_TAPCELL_ROW_39_485 VDD VSS WELLTAP
X_09508_ _17651_/Q _17444_/B VDD VSS _09510_/C XNOR2X1
XTAP_TAPCELL_ROW_104_1266 VDD VSS WELLTAP
X_10780_ _10844_/A _10910_/B VDD VSS _17941_/D NOR2X1
XFILLER_13_869 VDD VSS DECAPHV8
X_09439_ _19039_/Q _17340_/B VDD VSS _09465_/A NOR2X1
XFILLER_8_328 VDD VSS DECAPHV32
XFILLER_9_829 VDD VSS FILLER1
X_12450_ _18981_/Q _18102_/Q VDD VSS _12453_/B NAND2X1
X_11401_ _18970_/Q _18091_/Q VDD VSS _11446_/D XNOR2X1
XFILLER_123_1085 VDD VSS DECAPHV16
XFILLER_20_390 VDD VSS FILLER4
XFILLER_4_501 VDD VSS DECAPHV8
X_12381_ _12411_/A _12411_/B _12411_/D _12411_/C VDD VSS _14325_/C AOI211X1
X_14120_ _14396_/A _14120_/B VDD VSS _18184_/D AND2X1
XFILLER_107_941 VDD VSS FILLER4
X_11332_ _18245_/Q _14187_/B VDD VSS _11418_/B NOR2X1
XFILLER_108_0 VDD VSS DECAPHV32
XFILLER_122_900 VDD VSS FILLER1
X_11263_ _11263_/A _11263_/B _11263_/C _11263_/D VDD VSS _11314_/A OAOI211X1
X_14051_ _14051_/A _14051_/B _14107_/A VDD VSS _18120_/D OA21X2
XFILLER_106_473 VDD VSS FILLER1
XFILLER_107_996 VDD VSS FILLER4
XFILLER_134_793 VDD VSS FILLER4
XFILLER_4_578 VDD VSS DECAPHV16
XTAP_TAPCELL_ROW_115_1395 VDD VSS WELLTAP
X_10214_ _17827_/Q _10214_/B _10214_/C VDD VSS _10405_/C XNOR3X1
X_11194_ _11196_/A _11194_/B VDD VSS _17139_/B XNOR2X1
X_13002_ _18161_/Q _13002_/B _13105_/C VDD VSS _13225_/B XNOR3X1
XFILLER_106_495 VSS VDD FILLER2
XFILLER_79_335 VDD VSS DECAPHV16
XFILLER_97_88 VDD VSS FILLER4
X_10145_ _17820_/Q _10157_/A _10150_/C VDD VSS _10331_/C XOR3X1
X_17810_ _17854_/CK _17810_/D _17810_/Q VDD VSS DFFQX1
XFILLER_121_476 VSS VDD FILLER2
XFILLER_48_700 VDD VSS FILLER1
X_18790_ _18844_/CK _18790_/D _18790_/Q VDD VSS DFFQX1
X_10076_ _10076_/A _10076_/B _10076_/C VDD VSS _10267_/B OA21X2
X_17741_ clkload5/A _17741_/D _17741_/Q VDD VSS DFFQX1
X_14953_ _14951_/Y _14956_/A _17525_/B VDD VSS _18611_/D AND3BX1
XFILLER_35_405 VSS VDD FILLER2
XFILLER_47_243 VDD VSS FILLER1
XFILLER_75_552 VSS VDD FILLER2
X_17672_ _17706_/CK _17672_/D _17672_/Q VDD VSS DFFQX1
X_14884_ _14889_/C _14889_/B VDD VSS _14886_/B NAND2BX1
X_13904_ _13905_/A _13905_/B _13905_/D _13905_/C VDD VSS _13912_/B OA211X2
XFILLER_63_725 VDD VSS FILLER1
X_16623_ _18853_/Q _18691_/Q _16624_/C _16624_/D VDD VSS _16625_/B AO211X2
X_13835_ _14374_/B _14374_/C _18404_/Q VDD VSS _13838_/B AOI21X1
XFILLER_90_566 VDD VSS FILLER1
XFILLER_15_140 VDD VSS FILLER4
X_10978_ _10978_/A _10981_/C VDD VSS _11118_/B XOR2X1
X_16554_ _16554_/A VDD VSS _16629_/A BUFX3
X_13766_ _18378_/Q _13806_/D _13766_/C VDD VSS _13800_/C XNOR3X1
XFILLER_31_622 VSS VDD FILLER2
X_12717_ _12718_/B _12718_/C _12718_/A VDD VSS _12931_/B OAI21X1
X_16485_ _16800_/A _16485_/B _16485_/C VDD VSS _16486_/C AND3BX1
X_15505_ _15511_/A _15511_/B VDD VSS _16983_/A XNOR2X1
X_13697_ _14339_/A _14339_/B _14339_/C _13697_/D VDD VSS _13806_/A OAOI211X1
X_12648_ _12743_/A _12743_/B _12743_/D _12743_/C VDD VSS _14177_/B OAOI211X1
X_18224_ _18250_/CK _18224_/D _18224_/Q VDD VSS DFFQX1
X_15436_ _15373_/B _15393_/Y _16757_/D VDD VSS _15436_/Y MUX2X1
XFILLER_12_880 VSS VDD FILLER2
XFILLER_50_1013 VSS VDD FILLER2
X_18155_ _18199_/CK _18155_/D _18155_/Q VDD VSS DFFQX1
XFILLER_117_705 VDD VSS DECAPHV8
XFILLER_129_587 VSS VDD FILLER2
XFILLER_7_64 VDD VSS DECAPHV16
X_12579_ _12614_/A _12614_/B _12614_/D _12614_/C VDD VSS _12606_/C AOAI211X1
X_17106_ _17107_/A _17107_/B _17107_/C VDD VSS _17108_/B NOR3X1
X_15367_ _18907_/Q _15411_/B VDD VSS _15410_/B NOR2BX1
XFILLER_8_895 VSS VDD FILLER2
X_18086_ _18966_/CK _18086_/D _18086_/Q VDD VSS DFFQX1
X_15298_ _15300_/A _18039_/Q VDD VSS _18838_/D AND2X1
X_14318_ _14318_/A _14318_/B VDD VSS _14319_/B XNOR2X1
X_17037_ _17038_/A _17038_/B VDD VSS _17037_/Y NOR2X1
X_14249_ _15300_/A _14249_/B VDD VSS _18299_/D AND2X1
XFILLER_113_933 VDD VSS FILLER1
XFILLER_98_611 VDD VSS FILLER1
XFILLER_112_421 VSS VDD FILLER2
XFILLER_23_0 VDD VSS DECAPHV32
XFILLER_86_839 VSS VDD FILLER2
XFILLER_98_677 VDD VSS DECAPHV8
X_09790_ _09812_/A _09868_/B VDD VSS _17786_/D NOR2X1
X_18988_ _18988_/CK _18988_/D _18988_/Q VDD VSS DFFQX1
XFILLER_79_891 VDD VSS FILLER1
X_17939_ _17941_/CK _17939_/D _17939_/Q VDD VSS DFFQX1
XFILLER_22_1126 VDD VSS DECAPHV8
XFILLER_27_928 VSS VDD FILLER2
XFILLER_66_552 VDD VSS DECAPHV8
XFILLER_94_861 VSS VDD FILLER2
XFILLER_35_961 VDD VSS DECAPHV8
Xclkbuf_0__002_ _174_/ECK VDD VSS clkbuf_0__002_/Y BUFX12
XFILLER_34_460 VDD VSS FILLER4
XTAP_TAPCELL_ROW_36_455 VDD VSS WELLTAP
XTAP_TAPCELL_ROW_64_786 VDD VSS WELLTAP
XFILLER_34_471 VDD VSS DECAPHV8
XFILLER_62_780 VDD VSS DECAPHV8
X_09224_ _17640_/Q _09224_/B _17433_/B VDD VSS _09250_/B MIN3X1
X_09155_ _17497_/B _17701_/Q _09155_/C VDD VSS _09180_/C MIN3X1
X_09086_ _09086_/A _09086_/B VDD VSS _17323_/B XNOR2X1
XFILLER_107_32 VDD VSS DECAPHV32
XFILLER_116_793 VDD VSS FILLER4
XFILLER_66_1020 VDD VSS FILLER1
XTAP_TAPCELL_ROW_8_114 VDD VSS WELLTAP
Xclkbuf_leaf_17__001_ clkload75/A VDD VSS _18025_/CK BUFX12
XFILLER_115_270 VDD VSS FILLER1
XFILLER_1_548 VDD VSS DECAPHV8
XFILLER_27_1026 VSS VDD FILLER2
XFILLER_88_121 VSS VDD FILLER2
XFILLER_89_633 VSS VDD FILLER2
XFILLER_103_476 VDD VSS FILLER4
XFILLER_114_1007 VDD VSS FILLER1
X_09988_ _09935_/Y _10194_/B _10204_/B VDD VSS _17824_/D AND3BX1
X_08939_ _17748_/Q _18537_/Q VDD VSS _08944_/A XNOR2X1
X_11950_ _11861_/A _14082_/B _14082_/C VDD VSS _12025_/C AND3BX1
XFILLER_123_64 VDD VSS DECAPHV16
XFILLER_17_416 VDD VSS FILLER1
XFILLER_45_725 VDD VSS FILLER4
XFILLER_84_382 VSS VDD FILLER2
X_10901_ _17939_/Q _10901_/B _10901_/C VDD VSS _10905_/B MIN3X1
XFILLER_44_235 VDD VSS FILLER4
XFILLER_44_246 VDD VSS DECAPHV8
XFILLER_45_747 VSS VDD FILLER2
XFILLER_72_555 VSS VDD FILLER2
X_11881_ _11930_/A _11931_/B _11931_/C VDD VSS _11883_/C OR3BX1
XFILLER_13_600 VDD VSS DECAPHV32
XFILLER_16_40 VDD VSS FILLER4
XFILLER_72_577 VDD VSS FILLER4
XFILLER_73_1002 VSS VDD FILLER2
XFILLER_73_1013 VSS VDD FILLER2
X_10832_ _10832_/A _10832_/B _10832_/C VDD VSS _10837_/C MIN3X1
X_13620_ _13631_/A _14277_/B VDD VSS _14278_/B _13621_/C AND3X2
XFILLER_73_1046 VDD VSS DECAPHV32
X_10763_ _10766_/A _10766_/B VDD VSS _10897_/B XNOR2X1
X_13551_ _13558_/A _14306_/B _13558_/C VDD VSS _14307_/B OAI21X1
X_12502_ _12502_/A _12502_/B _12502_/C _12502_/D VDD VSS _12940_/A AOAI211X1
X_16270_ _16273_/B _16270_/B VDD VSS _16272_/B XNOR2X1
X_10694_ _10822_/B _10695_/B _10695_/D _10695_/C VDD VSS _10705_/B OAOI211X1
X_15221_ _15304_/A _18790_/Q VDD VSS _18763_/D AND2X1
X_13482_ _13493_/A _13493_/B _13482_/C _13493_/E VDD VSS _14213_/B AOI211X1
X_12433_ _12518_/A _14174_/B _14174_/C VDD VSS _12626_/C NOR3X1
XTAP_TAPCELL_ROW_117_1424 VDD VSS WELLTAP
XTAP_TAPCELL_ROW_3_54 VDD VSS WELLTAP
X_12364_ _14089_/B _14089_/C _18154_/Q VDD VSS _12366_/C AOI21X1
X_15152_ _17182_/D _18722_/Q VDD VSS _18695_/D AND2X1
XFILLER_126_557 VDD VSS DECAPHV8
X_11315_ _11362_/B _14045_/C _18114_/Q VDD VSS _11316_/D AND3BX1
X_15083_ _15084_/A _15085_/C _17318_/C VDD VSS _15084_/C OAI21X1
X_14103_ _14122_/A _14103_/B _14103_/C VDD VSS _18168_/D NOR3X1
XFILLER_99_419 VDD VSS DECAPHV8
X_12295_ _14293_/A _14293_/B _14293_/C VDD VSS _12301_/B OAI21X1
X_18911_ _18913_/CK _18911_/D _18911_/Q VDD VSS DFFQX1
X_14034_ _17122_/D _18982_/Q VDD VSS _18103_/D AND2X1
XFILLER_122_752 VSS VDD FILLER2
X_11246_ _18964_/Q _18085_/Q VDD VSS _11289_/B XNOR2X1
XFILLER_121_251 VDD VSS DECAPHV8
XFILLER_79_143 VDD VSS DECAPHV8
X_11177_ _11181_/C _11177_/B VDD VSS _17124_/B XNOR2X1
X_18842_ _18844_/CK _18842_/D _18842_/Q VDD VSS DFFQX1
XFILLER_110_947 VSS VDD FILLER2
XFILLER_94_113 VDD VSS DECAPHV8
X_10128_ _10128_/A _10128_/B _10128_/C VDD VSS _10129_/B AOI21X1
X_18773_ _18801_/CK _18773_/D _18773_/Q VDD VSS DFFQX1
X_15985_ _16109_/A _16063_/B _16063_/C _16064_/A VDD VSS _15988_/A OAOI211X1
XFILLER_57_80 VDD VSS DECAPHV8
X_10059_ _10114_/A _10251_/B VDD VSS _17833_/D NOR2X1
X_17724_ _17725_/CK _17724_/D _17724_/Q VDD VSS DFFQX1
X_14936_ _14937_/A _14938_/C _17318_/C VDD VSS _14937_/C OAI21X1
XFILLER_36_725 VDD VSS FILLER4
XFILLER_63_522 VDD VSS FILLER4
XTAP_TAPCELL_ROW_128_1553 VDD VSS WELLTAP
XFILLER_91_864 VDD VSS DECAPHV8
X_17655_ _17656_/CK _17655_/D _17655_/Q VDD VSS DFFQX1
X_14867_ _18593_/Q _18625_/Q VDD VSS _14872_/A XNOR2X1
XFILLER_90_374 VDD VSS DECAPHV8
X_17586_ _19045_/CK _17586_/D _17586_/Q VDD VSS DFFQX1
X_16606_ _18055_/Q _18665_/Q VDD VSS _16609_/A XOR2X1
X_14798_ _14903_/A _14798_/B VDD VSS _18577_/D NOR2X1
X_13818_ _18482_/Q _14460_/B VDD VSS _13827_/C _14460_/C AND3X2
XFILLER_44_780 VDD VSS FILLER1
XTAP_TAPCELL_ROW_33_414 VDD VSS WELLTAP
XTAP_TAPCELL_ROW_61_745 VDD VSS WELLTAP
X_16537_ _16537_/A _18771_/Q _16582_/A _16537_/D VDD VSS _16553_/A AOI22X1
X_13749_ _13754_/A _13754_/B _13754_/D _13754_/C VDD VSS _14373_/C AOI211X1
XFILLER_31_441 VDD VSS FILLER1
XTAP_TAPCELL_ROW_61_756 VDD VSS WELLTAP
X_16468_ _18795_/Q _18741_/Q _16468_/C _16468_/D VDD VSS _16503_/B AOAI211X1
XFILLER_106_1080 VSS VDD FILLER2
XFILLER_129_362 VDD VSS DECAPHV8
XTAP_TAPCELL_ROW_13_171 VDD VSS WELLTAP
X_18207_ _18261_/CK _18207_/D _18207_/Q VDD VSS DFFQX1
X_16399_ _18048_/Q _18658_/Q VDD VSS _16401_/C OR2X2
X_15419_ _15526_/A _15500_/B VDD VSS _15420_/C NAND2X1
X_18138_ _18963_/CK _18138_/D _18138_/Q VDD VSS DFFQX1
X_18069_ _18835_/CK _18069_/D _18069_/Q VDD VSS DFFQX1
XFILLER_132_527 VDD VSS FILLER1
XFILLER_132_538 VDD VSS FILLER4
XTAP_TAPCELL_ROW_92_1118 VDD VSS WELLTAP
X_09911_ _17791_/Q _09920_/A VDD VSS _09926_/C XOR2X1
XFILLER_101_925 VDD VSS FILLER4
XFILLER_112_251 VSS VDD FILLER2
XFILLER_113_763 VSS VDD FILLER2
XFILLER_99_997 VDD VSS DECAPHV16
X_09842_ _17777_/Q _09848_/C VDD VSS _10023_/A XNOR2X1
XFILLER_6_1120 VDD VSS DECAPHV8
XTAP_TAPCELL_ROW_69_845 VDD VSS WELLTAP
X_09773_ _17693_/Q _17489_/B VDD VSS _09774_/B XNOR2X1
XFILLER_73_308 VDD VSS FILLER1
XFILLER_85_146 VDD VSS FILLER1
XFILLER_94_680 VDD VSS DECAPHV16
XFILLER_96_1002 VDD VSS FILLER4
XFILLER_27_747 VDD VSS FILLER4
XFILLER_27_769 VDD VSS FILLER1
XFILLER_66_382 VDD VSS FILLER4
XFILLER_82_864 VDD VSS FILLER1
XFILLER_42_717 VDD VSS FILLER1
XFILLER_82_875 VDD VSS DECAPHV8
XFILLER_82_886 VDD VSS FILLER1
XFILLER_96_1068 VDD VSS FILLER1
XFILLER_96_1079 VSS VDD FILLER2
XFILLER_41_238 VSS VDD FILLER2
XFILLER_54_599 VDD VSS FILLER4
XFILLER_23_964 VDD VSS FILLER1
XTAP_TAPCELL_ROW_101_1225 VDD VSS WELLTAP
XTAP_TAPCELL_ROW_101_1236 VDD VSS WELLTAP
XFILLER_10_603 VDD VSS FILLER1
XFILLER_108_502 VSS VDD FILLER2
XFILLER_136_800 VDD VSS DECAPHV8
XFILLER_6_607 VDD VSS DECAPHV32
X_09207_ _09207_/A _09228_/C VDD VSS _17467_/B XNOR2X1
XFILLER_5_128 VDD VSS DECAPHV32
X_09138_ _17605_/Q _09149_/A VDD VSS _09139_/B XNOR2X1
XFILLER_120_1055 VDD VSS FILLER1
X_09069_ _17635_/Q _17428_/B VDD VSS _09099_/B XNOR2X1
X_11100_ _17978_/Q _11103_/B VDD VSS _11101_/B XNOR2X1
XFILLER_2_857 VDD VSS DECAPHV16
X_12080_ _12080_/A _12080_/B _12080_/C _12080_/D VDD VSS _12121_/B OAOI211X1
XFILLER_104_752 VDD VSS FILLER1
XFILLER_89_463 VSS VDD FILLER2
XTAP_TAPCELL_ROW_112_1365 VDD VSS WELLTAP
X_11031_ _14253_/A VDD VSS _11135_/A BUFX3
XFILLER_104_785 VSS VDD FILLER2
XFILLER_92_617 VDD VSS FILLER1
XFILLER_40_1045 VDD VSS FILLER1
XFILLER_57_371 VDD VSS FILLER1
XFILLER_58_872 VDD VSS DECAPHV8
X_12982_ _13121_/A _14152_/B VDD VSS _13120_/A NOR2X1
X_15770_ _18860_/Q _15801_/A _16018_/C VDD VSS _15771_/D NOR3X1
XFILLER_40_1067 VSS VDD FILLER2
XFILLER_73_831 VSS VDD FILLER2
X_11933_ _14168_/B _14168_/C _11934_/A VDD VSS _12122_/B OAI21X1
X_14721_ _17396_/A VDD VSS _14903_/A BUFX3
XFILLER_33_706 VDD VSS FILLER4
XFILLER_73_875 VSS VDD FILLER2
X_11864_ _11957_/A _11870_/B _11870_/C VDD VSS _14082_/C OR3BX1
X_17440_ _17561_/C _17440_/B VDD VSS _17647_/D AND2X1
X_14652_ _18547_/Q _18579_/Q VDD VSS _14652_/Y NOR2X1
XFILLER_26_780 VDD VSS FILLER4
XFILLER_32_227 VDD VSS FILLER4
X_10815_ _17923_/Q VDD VSS _10816_/A INVX1
X_17371_ _17434_/A _17371_/B VDD VSS _17582_/D AND2X1
X_13603_ _13738_/A _13603_/B VDD VSS _14400_/B XNOR2X1
XFILLER_14_975 VDD VSS FILLER1
XTAP_TAPCELL_ROW_123_1494 VDD VSS WELLTAP
X_11795_ _18149_/Q _11861_/B _11870_/C VDD VSS _12025_/B XNOR3X1
X_16322_ _18845_/Q _18683_/Q VDD VSS _16327_/B OR2X2
X_14583_ _18531_/Q _18563_/Q _14583_/C VDD VSS _14591_/A MIN3X1
XFILLER_13_463 VSS VDD FILLER2
X_10746_ _10747_/A _10747_/B _10747_/C VDD VSS _10753_/B OA21X2
X_13534_ _13546_/A _13534_/B _13639_/D VDD VSS _13591_/C XNOR3X1
X_10677_ _10817_/B _10677_/B VDD VSS _10816_/B NAND2BX1
X_19041_ _19042_/CK _19041_/D _19041_/Q VDD VSS DFFQX1
X_16253_ _16280_/A _16280_/B _16280_/C _16783_/D VDD VSS _16254_/D AOI31X1
X_13465_ _18346_/Q _14305_/B VDD VSS _13542_/A NAND2X1
XTAP_TAPCELL_ROW_10_141 VDD VSS WELLTAP
X_12416_ _18311_/Q _14262_/B VDD VSS _12617_/C _14262_/C AND3X2
X_16184_ _16521_/A _16340_/B VDD VSS _16485_/C OR2X2
X_15204_ _15286_/A _18773_/Q VDD VSS _18746_/D AND2X1
X_15135_ _15274_/A _18705_/Q VDD VSS _18678_/D AND2X1
X_13396_ _13488_/A _13488_/B VDD VSS _13411_/B NOR2X1
X_12347_ _18180_/Q _14116_/B VDD VSS _12436_/D _14116_/C NAND3X1
XFILLER_4_32 VDD VSS DECAPHV8
X_12278_ _18492_/Q _12281_/B _14474_/B VDD VSS _12279_/B XNOR3X1
X_15066_ _15067_/C _17455_/A _15066_/C VDD VSS _18635_/D AND3BX1
XFILLER_110_700 VSS VDD FILLER2
X_11229_ _18110_/Q _14041_/B VDD VSS _11290_/B NOR2X1
X_14017_ _17059_/C _18965_/Q VDD VSS _18086_/D AND2X1
X_18825_ _18852_/CK _18825_/D _18825_/Q VDD VSS DFFQX1
XFILLER_48_371 VDD VSS DECAPHV8
XTAP_TAPCELL_ROW_66_815 VDD VSS WELLTAP
X_18756_ _18787_/CK _18756_/D _18756_/Q VDD VSS DFFQX1
X_15968_ _16047_/B _16326_/A _15968_/C VDD VSS _15979_/C OR3BX1
XTAP_TAPCELL_ROW_89_1091 VDD VSS WELLTAP
X_18687_ _18850_/CK _18687_/D _18687_/Q VDD VSS DFFQX1
X_17707_ _17710_/CK _17707_/D _17707_/Q VDD VSS DFFQX1
X_15899_ _15984_/C _15984_/D _16107_/A VDD VSS _15900_/D AOI21X1
X_14919_ _18603_/Q _18635_/Q _14919_/C VDD VSS _14924_/C AO21X2
XFILLER_24_728 VDD VSS FILLER1
XFILLER_36_588 VSS VDD FILLER2
XFILLER_64_886 VSS VDD FILLER2
XFILLER_91_650 VDD VSS FILLER1
XTAP_TAPCELL_ROW_18_230 VDD VSS WELLTAP
X_17638_ _17669_/CK _17638_/D _17638_/Q VDD VSS DFFQX1
XTAP_TAPCELL_ROW_46_572 VDD VSS WELLTAP
XFILLER_56_1041 VDD VSS DECAPHV8
XFILLER_90_0 VDD VSS DECAPHV32
Xclkbuf_leaf_16__002_ clkbuf_leaf_9__002_/A VDD VSS _18252_/CK BUFX12
X_17569_ _19028_/CK _17569_/D _17569_/Q VDD VSS DFFQX1
XFILLER_32_783 VDD VSS FILLER4
XFILLER_120_508 VSS VDD FILLER2
XFILLER_132_368 VDD VSS FILLER4
XFILLER_59_614 VDD VSS FILLER4
XFILLER_63_1034 VDD VSS FILLER4
XFILLER_99_772 VDD VSS FILLER1
XFILLER_100_210 VDD VSS FILLER1
XFILLER_115_1113 VSS VDD FILLER2
XFILLER_115_1135 VDD VSS FILLER1
XFILLER_48_49 VDD VSS DECAPHV32
XFILLER_59_625 VSS VDD FILLER2
XFILLER_59_647 VDD VSS FILLER4
X_09825_ _09843_/A _09971_/A VDD VSS _17797_/D NOR2X1
XFILLER_86_444 VDD VSS FILLER1
XFILLER_101_777 VDD VSS FILLER1
XFILLER_104_44 VSS VDD FILLER2
XFILLER_86_477 VSS VDD FILLER2
X_09756_ _09763_/B _09756_/B VDD VSS _17352_/B XNOR2X1
X_09687_ _09674_/A _09687_/B VDD VSS _09714_/B NAND2BX1
XFILLER_55_886 VSS VDD FILLER2
XFILLER_82_661 VSS VDD FILLER2
XFILLER_120_32 VDD VSS DECAPHV8
XFILLER_14_205 VDD VSS FILLER1
XFILLER_14_216 VDD VSS FILLER4
XFILLER_42_514 VDD VSS DECAPHV16
XFILLER_11_901 VDD VSS FILLER1
XFILLER_70_878 VDD VSS FILLER4
XFILLER_70_1016 VDD VSS FILLER4
X_10600_ _10707_/A _10738_/B VDD VSS _17907_/D AND2X1
X_11580_ _18224_/Q _14165_/B _11678_/B VDD VSS _11601_/C XNOR3X1
Xfanout42 _17523_/A VDD VSS _17455_/A BUFX3
Xfanout53 _17534_/A VDD VSS _17498_/A BUFX3
Xfanout64 _14107_/A VDD VSS _17122_/D BUFX3
X_10531_ _10544_/A _10544_/B VDD VSS _10692_/B _10691_/C NAND3X1
Xfanout75 _15307_/A VDD VSS _15309_/A BUFX3
Xfanout86 _14377_/A VDD VSS _14396_/A BUFX3
XFILLER_10_477 VDD VSS FILLER1
X_13250_ _18422_/Q _14394_/B _14394_/C VDD VSS _13251_/D OR3BX1
XFILLER_108_321 VDD VSS FILLER4
XFILLER_136_641 VDD VSS FILLER4
XFILLER_13_96 VSS VDD FILLER2
X_10462_ _17862_/Q _10462_/B _10462_/C VDD VSS _10467_/A MIN3X1
X_12201_ _18386_/Q _12201_/B _14353_/B VDD VSS _14383_/B XNOR3X1
XFILLER_129_96 VDD VSS DECAPHV32
XFILLER_136_674 VDD VSS FILLER1
X_10393_ _10390_/A _10399_/B _10399_/C VDD VSS _10394_/D AND3BX1
X_13181_ _13234_/A _13234_/B _13181_/C _13234_/E VDD VSS _14303_/C OA211X2
XFILLER_123_324 VDD VSS FILLER4
XFILLER_135_184 VSS VDD FILLER2
XTAP_TAPCELL_ROW_0_11 VDD VSS WELLTAP
XTAP_TAPCELL_ROW_0_22 VDD VSS WELLTAP
X_12132_ _12224_/A _14170_/B _12224_/C VDD VSS _14171_/B AOI21X1
X_12063_ _12063_/A _14112_/B _12063_/C VDD VSS _14113_/B OAI21X1
X_16940_ _16948_/A _16948_/B VDD VSS _16952_/B XNOR2X1
XFILLER_104_560 VSS VDD FILLER2
XFILLER_2_687 VDD VSS DECAPHV8
X_11014_ _11014_/A _11014_/B VDD VSS _11015_/D OR2X2
XFILLER_78_967 VDD VSS FILLER4
XFILLER_78_989 VDD VSS DECAPHV16
X_16871_ _16871_/A _16878_/B VDD VSS _16882_/C XOR2X1
X_18610_ _18641_/CK _18610_/D _18610_/Q VDD VSS DFFQX1
X_15822_ _15855_/A _15855_/B VDD VSS _15822_/Y NOR2X1
XFILLER_18_544 VDD VSS DECAPHV8
XFILLER_79_1030 VDD VSS DECAPHV8
XTAP_TAPCELL_ROW_125_1523 VDD VSS WELLTAP
X_12965_ _12965_/A _12965_/B _12965_/C _12965_/D VDD VSS _13186_/A AOAI211X1
X_18541_ _18641_/CK _18541_/D _18541_/Q VDD VSS DFFQX1
X_15753_ _18859_/Q _172_/E VDD VSS _16905_/B NOR2X2
XFILLER_46_886 VSS VDD FILLER2
XFILLER_73_650 VDD VSS FILLER1
XFILLER_79_1074 VSS VDD FILLER2
X_11916_ _11916_/A _11916_/B _14256_/B VDD VSS _11917_/B MIN3X1
X_14704_ _18558_/Q _18590_/Q VDD VSS _14710_/B NAND2X1
XTAP_TAPCELL_ROW_15_200 VDD VSS WELLTAP
X_12896_ _18186_/Q _13085_/B _13085_/C VDD VSS _13191_/A XNOR3X1
X_18472_ _18500_/CK _18472_/D _18472_/Q VDD VSS DFFQX1
X_15684_ _15685_/A _15684_/B VDD VSS _15685_/C NOR2X1
XFILLER_21_709 VSS VDD FILLER2
XFILLER_54_81 VDD VSS DECAPHV16
XFILLER_61_878 VDD VSS DECAPHV8
XTAP_TAPCELL_ROW_43_531 VDD VSS WELLTAP
X_11847_ _11847_/A _11847_/B _11847_/C _11847_/D VDD VSS _14081_/B AOAI211X1
Xclkbuf_leaf_14_clk_fs_regs clkbuf_leaf_9_clk_fs_regs/A VDD VSS _18951_/CK BUFX12
X_17423_ _17423_/A _17423_/B VDD VSS _17631_/D NOR2X1
X_14635_ _18542_/Q _18574_/Q _14635_/C VDD VSS _14639_/B MIN3X1
XTAP_TAPCELL_ROW_71_873 VDD VSS WELLTAP
X_11778_ _11924_/A _11924_/B _11924_/C VDD VSS _11797_/B AOI21X1
X_17354_ _17388_/A _17354_/B VDD VSS _17566_/D AND2X1
X_14566_ _14569_/C _14566_/B VDD VSS _14567_/B XNOR2X1
XFILLER_13_282 VSS VDD FILLER2
X_10729_ _17906_/Q _10734_/B VDD VSS _10733_/B XNOR2X1
X_17285_ _17533_/A _17285_/B _17291_/A VDD VSS _19013_/D NOR3X1
X_16305_ _18906_/Q _16310_/B VDD VSS _16307_/B XNOR2X1
X_13517_ _13517_/A _13517_/B _13517_/C VDD VSS _13528_/B XNOR3X1
XFILLER_118_129 VDD VSS DECAPHV8
XFILLER_9_253 VSS VDD FILLER2
X_19024_ _19024_/CK _19024_/D _19024_/Q VDD VSS DFFQX1
X_16236_ _18045_/Q _18655_/Q VDD VSS _16237_/A XNOR2X1
X_14497_ _14972_/A _14497_/B _14497_/C VDD VSS _18510_/D NOR3X1
XFILLER_103_1061 VSS VDD FILLER2
XTAP_TAPCELL_ROW_136_1652 VDD VSS WELLTAP
Xclkload34 _18514_/CK VDD VSS clkload34/Y INVX2
Xclkload23 _18994_/CK VDD VSS clkload23/Y INVX2
Xclkload12 _19019_/CK VDD VSS clkload12/Y INVX2
X_13448_ _13460_/A _14424_/B _13517_/C VDD VSS _14425_/C NOR3X1
XFILLER_127_674 VDD VSS FILLER4
XFILLER_127_685 VDD VSS FILLER4
XTAP_TAPCELL_ROW_136_1663 VDD VSS WELLTAP
Xclkload78 _17851_/CK VDD VSS clkload78/Y INVX1
Xclkload67 _18358_/CK VDD VSS clkload67/Y INVX4
Xclkload56 _18500_/CK VDD VSS clkload56/Y INVX2
Xclkload45 _18152_/CK VDD VSS clkload45/Y INVX4
X_16167_ _16245_/C _16245_/D _16206_/A VDD VSS _16172_/B OAI21X1
X_13379_ _13416_/B _13416_/C _13379_/C _13379_/D VDD VSS _14244_/B AOAI211X1
Xclkload89 _19028_/CK VDD VSS clkload89/Y INVX2
X_16098_ _18812_/Q _18704_/Q VDD VSS _16102_/B NAND2X1
X_15118_ _15313_/A _18689_/Q VDD VSS _18662_/D AND2X1
XFILLER_69_901 VDD VSS DECAPHV16
X_15049_ _18632_/Q _19010_/Q VDD VSS _15050_/B XNOR2X1
XFILLER_96_720 VSS VDD FILLER2
XFILLER_110_530 VDD VSS DECAPHV16
XFILLER_110_552 VDD VSS FILLER1
XTAP_TAPCELL_ROW_79_962 VDD VSS WELLTAP
X_09610_ _17687_/Q _17483_/B VDD VSS _09612_/C XNOR2X1
X_18808_ _18808_/CK _18808_/D _18808_/Q VDD VSS DFFQX1
XFILLER_110_596 VSS VDD FILLER2
XFILLER_23_1073 VSS VDD FILLER2
XFILLER_55_149 VDD VSS FILLER1
X_09541_ _19043_/Q _17344_/B VDD VSS _09544_/B XNOR2X1
X_18739_ _18821_/CK _18739_/D _18739_/Q VDD VSS DFFQX1
XFILLER_24_514 VDD VSS FILLER4
XFILLER_52_823 VDD VSS FILLER4
XFILLER_52_845 VDD VSS FILLER4
XFILLER_93_1016 VDD VSS FILLER4
X_09472_ _17617_/Q _17408_/B _09472_/C VDD VSS _09497_/A OAI21X1
XFILLER_20_731 VDD VSS FILLER1
XTAP_TAPCELL_ROW_21_269 VDD VSS WELLTAP
Xclkload6 clkload6/A VDD VSS clkload6/Y INVX2
XFILLER_3_407 VDD VSS DECAPHV32
XFILLER_118_696 VDD VSS FILLER1
XFILLER_105_346 VDD VSS DECAPHV8
XFILLER_106_869 VDD VSS DECAPHV8
XFILLER_59_422 VSS VDD FILLER2
XFILLER_115_32 VDD VSS DECAPHV32
XFILLER_87_764 VSS VDD FILLER2
XFILLER_8_1067 VSS VDD FILLER2
XFILLER_47_628 VDD VSS DECAPHV8
XFILLER_86_252 VDD VSS FILLER1
XFILLER_86_263 VDD VSS FILLER4
XFILLER_87_797 VSS VDD FILLER2
X_09808_ _09812_/A _09936_/B VDD VSS _17792_/D NOR2X1
XFILLER_59_499 VDD VSS FILLER4
X_09739_ _09739_/A _09739_/B _09739_/C VDD VSS _09765_/B AOI21X1
XFILLER_28_886 VSS VDD FILLER2
XFILLER_55_650 VDD VSS FILLER1
XFILLER_55_661 VDD VSS DECAPHV8
XTAP_TAPCELL_ROW_29_369 VDD VSS WELLTAP
XFILLER_131_64 VDD VSS DECAPHV16
XFILLER_42_311 VDD VSS FILLER1
XFILLER_54_160 VSS VDD FILLER2
XFILLER_55_694 VDD VSS DECAPHV16
X_12750_ _18236_/Q VDD VSS _12859_/A INVX1
XFILLER_43_867 VDD VSS FILLER1
XTAP_TAPCELL_ROW_107_1297 VDD VSS WELLTAP
X_11701_ _11706_/A _11706_/B _11779_/B VDD VSS _14052_/B OA21X2
X_12681_ _12781_/A _12781_/C VDD VSS _12773_/C NAND2X1
XFILLER_24_51 VDD VSS FILLER1
XTAP_TAPCELL_ROW_120_1453 VDD VSS WELLTAP
XTAP_TAPCELL_ROW_40_501 VDD VSS WELLTAP
X_11632_ _11637_/A _11637_/B _11633_/D _11637_/C VDD VSS _14051_/A OA211X2
X_14420_ _14440_/A _14420_/B VDD VSS _18446_/D NOR2X1
XFILLER_11_742 VSS VDD FILLER2
XFILLER_126_1072 VDD VSS DECAPHV32
XFILLER_24_73 VSS VDD FILLER2
XTAP_TAPCELL_ROW_120_1464 VDD VSS WELLTAP
X_14351_ _14378_/A _14351_/B VDD VSS _18384_/D NOR2X1
XFILLER_128_438 VSS VDD FILLER2
X_11563_ _11696_/A _14078_/B VDD VSS _11686_/B NAND2X1
X_13302_ _13303_/A _13303_/B _13303_/D _13303_/C VDD VSS _13408_/B OAOI211X1
XFILLER_10_263 VDD VSS FILLER1
XFILLER_11_797 VSS VDD FILLER2
X_10514_ _17871_/Q _10523_/B _10523_/C VDD VSS _10680_/B XNOR3X1
X_11494_ _14049_/A _14049_/B _11552_/C VDD VSS _11562_/C AOI21X1
X_17070_ _17242_/A _17070_/B _17074_/B VDD VSS _18971_/D NOR3X1
X_14282_ _14313_/A _14282_/B VDD VSS _18327_/D NOR2X1
XFILLER_124_600 VDD VSS FILLER4
XFILLER_6_267 VDD VSS DECAPHV32
XFILLER_7_779 VDD VSS DECAPHV32
X_10445_ _10445_/A _10445_/B _10445_/C VDD VSS _10447_/A AOI21X1
X_13233_ _13234_/D _14269_/B VDD VSS _13289_/A NAND2X1
X_16021_ _16021_/A _16021_/B _16802_/A VDD VSS _16022_/D OA21X2
X_13164_ _13257_/A _13257_/B _13257_/C _13164_/D VDD VSS _13354_/A OAOI211X1
X_10376_ _10376_/A _10376_/B _10376_/C VDD VSS _10561_/B XNOR3X1
X_12115_ _18255_/Q _14199_/B VDD VSS _12118_/C _14199_/C NAND3X1
XFILLER_123_176 VDD VSS DECAPHV8
XFILLER_124_688 VDD VSS FILLER4
X_13095_ _18187_/Q _13225_/A _13225_/B VDD VSS _13122_/C XNOR3X1
X_17972_ _17972_/CK _17972_/D _17972_/Q VDD VSS DFFQX1
XFILLER_111_338 VSS VDD FILLER2
XFILLER_46_1062 VDD VSS FILLER4
XTAP_TAPCELL_ROW_131_1593 VDD VSS WELLTAP
X_12046_ _12052_/A _12052_/B _12065_/C _12052_/C VDD VSS _14085_/C AOI211X1
X_16923_ _18931_/Q _16928_/B VDD VSS _16925_/C XNOR2X1
XFILLER_49_92 VDD VSS FILLER1
XFILLER_93_701 VDD VSS DECAPHV8
X_16854_ _16854_/A _16854_/B VDD VSS _16865_/A NAND2X1
XFILLER_19_831 VDD VSS FILLER4
XFILLER_77_296 VSS VDD FILLER2
XTAP_TAPCELL_ROW_76_932 VDD VSS WELLTAP
X_15805_ _18832_/Q _18670_/Q VDD VSS _15838_/A AND2X1
XFILLER_19_853 VDD VSS DECAPHV8
XFILLER_1_88 VDD VSS FILLER4
XFILLER_37_149 VDD VSS FILLER1
XFILLER_81_907 VDD VSS FILLER1
XFILLER_81_929 VDD VSS FILLER1
X_16785_ _16762_/Y _16957_/B _16629_/A VDD VSS _16819_/B MUXI2X1
X_13997_ _14011_/A _13997_/B _14055_/C VDD VSS _18075_/D AOI21X1
XFILLER_34_823 VDD VSS DECAPHV16
XFILLER_61_620 VSS VDD FILLER2
XFILLER_65_80 VDD VSS DECAPHV8
XTAP_TAPCELL_ROW_86_1050 VDD VSS WELLTAP
X_12948_ _14363_/B _14362_/C _18394_/Q VDD VSS _12949_/D AND3BX1
X_18524_ clkload6/A _18524_/D _18524_/Q VDD VSS DFFQX1
X_15736_ _18890_/Q _15736_/B VDD VSS _15737_/C NAND2X1
XFILLER_60_130 VDD VSS DECAPHV8
XFILLER_61_642 VDD VSS DECAPHV8
X_12879_ _18159_/Q _14094_/B VDD VSS _12993_/A NOR2BX1
X_18455_ _18480_/CK _18455_/D _18455_/Q VDD VSS DFFQX1
X_15667_ _15671_/A _15671_/B VDD VSS _17002_/A XNOR2X1
XFILLER_18_1131 VDD VSS FILLER1
XFILLER_92_1060 VDD VSS FILLER4
X_17406_ _17410_/A _17406_/B VDD VSS _17615_/D NOR2X1
X_14618_ _14619_/A _14619_/B _14619_/D _14619_/C VDD VSS _14621_/C AOI211X1
X_18386_ _18436_/CK _18386_/D _18386_/Q VDD VSS DFFQX1
X_15598_ _15548_/B _15650_/B _15674_/A VDD VSS _15695_/B MUXI2X1
XFILLER_53_1055 VDD VSS FILLER1
X_17337_ _17434_/A _17337_/B VDD VSS _19037_/D AND2X1
X_14549_ _18524_/Q VDD VSS _14551_/A INVX1
Xclkload112 _18856_/CK VDD VSS clkload112/Y INVX1
Xclkload101 _17993_/CK VDD VSS clkload101/Y INVX1
X_17268_ _19009_/Q _17269_/A _17315_/B VDD VSS _17272_/B AOI2B1X1
XFILLER_134_408 VDD VSS DECAPHV8
X_19007_ _19011_/CK _19007_/D _19007_/Q VDD VSS DFFQX1
Xclkload123 _18841_/CK VDD VSS clkload123/Y INVX1
X_17199_ _17242_/A _17199_/B _17205_/A VDD VSS _18997_/D NOR3X1
X_16219_ _16783_/D _16219_/B _16219_/C _16219_/D VDD VSS _16263_/B OA211X2
XFILLER_53_0 VDD VSS DECAPHV32
XFILLER_115_699 VDD VSS DECAPHV8
X_08972_ _08972_/A _08972_/B _08972_/C VDD VSS _08979_/C OA21X2
XFILLER_114_198 VDD VSS FILLER4
XFILLER_112_1105 VSS VDD FILLER2
XFILLER_57_915 VDD VSS FILLER1
XFILLER_56_425 VSS VDD FILLER2
XFILLER_37_650 VDD VSS FILLER1
XFILLER_44_609 VDD VSS FILLER1
XFILLER_83_266 VDD VSS FILLER1
XFILLER_84_767 VSS VDD FILLER2
XTAP_TAPCELL_ROW_26_328 VDD VSS WELLTAP
X_09524_ _09524_/A VDD VSS _17410_/B INVX1
XFILLER_24_333 VDD VSS FILLER4
XFILLER_25_845 VDD VSS DECAPHV16
XFILLER_36_182 VSS VDD FILLER2
X_09455_ _17649_/Q _17442_/B VDD VSS _09474_/C XNOR2X1
XFILLER_12_506 VDD VSS FILLER1
XFILLER_51_152 VDD VSS FILLER1
XFILLER_52_675 VDD VSS FILLER1
XFILLER_71_1100 VSS VDD FILLER2
X_09386_ _09376_/A _09386_/B VDD VSS _09405_/B NAND2BX1
XFILLER_119_950 VDD VSS FILLER1
XFILLER_20_594 VDD VSS FILLER1
XFILLER_125_408 VSS VDD FILLER2
XFILLER_125_419 VDD VSS DECAPHV8
XFILLER_119_994 VDD VSS FILLER1
X_10230_ _10414_/A _10414_/B _10414_/C _10415_/C VDD VSS _10419_/C AOAI211X1
XFILLER_79_539 VDD VSS DECAPHV8
X_10161_ _10165_/A _10338_/B _10343_/C VDD VSS _10352_/C OR3BX1
XFILLER_120_113 VDD VSS DECAPHV16
X_10092_ _10270_/A _10098_/B _10098_/C VDD VSS _10276_/A OAI21X1
XFILLER_0_988 VSS VDD FILLER2
XFILLER_87_561 VDD VSS FILLER1
X_13920_ _13920_/A _13920_/B _14464_/B _18486_/Q _13920_/E VDD VSS _13929_/B AOI221X1
XFILLER_101_371 VDD VSS FILLER1
XFILLER_101_393 VSS VDD FILLER2
XFILLER_19_62 VSS VDD FILLER2
XFILLER_47_447 VDD VSS FILLER4
XFILLER_74_200 VDD VSS FILLER1
XTAP_TAPCELL_ROW_109_1326 VDD VSS WELLTAP
XFILLER_16_801 VDD VSS FILLER1
XFILLER_28_650 VDD VSS FILLER1
XFILLER_47_458 VDD VSS FILLER4
XFILLER_56_970 VDD VSS FILLER4
XFILLER_74_266 VDD VSS DECAPHV8
X_13851_ _18484_/Q _13851_/B _13860_/D VDD VSS _13887_/C XNOR3X1
XFILLER_15_300 VDD VSS DECAPHV8
XFILLER_27_171 VDD VSS DECAPHV8
XFILLER_90_737 VDD VSS FILLER1
X_10994_ _11129_/B VDD VSS _11132_/B INVX1
X_12802_ _18419_/Q _12927_/B _12819_/C VDD VSS _12923_/C XNOR3X1
X_16570_ _16570_/A _16570_/B _16570_/C VDD VSS _16620_/A MIN3X1
X_13782_ _13816_/A _14459_/B _13816_/C VDD VSS _14460_/B OAI21X1
X_12733_ _18314_/Q _14265_/B VDD VSS _13009_/C _14265_/C AND3X2
X_15521_ _15523_/B _15521_/B VDD VSS _16985_/A XNOR2X1
XFILLER_35_72 VSS VDD FILLER2
XFILLER_76_1066 VSS VDD FILLER2
X_18240_ _18267_/CK _18240_/D _18240_/Q VDD VSS DFFQX1
X_15452_ _15736_/B VDD VSS _15668_/B BUFX3
XFILLER_124_1009 VDD VSS FILLER1
XFILLER_15_388 VDD VSS DECAPHV8
XFILLER_31_848 VSS VDD FILLER2
XTAP_TAPCELL_ROW_6_87 VDD VSS WELLTAP
XTAP_TAPCELL_ROW_81_990 VDD VSS WELLTAP
X_12664_ _12756_/A _14119_/B _14119_/C VDD VSS _12769_/C NOR3X1
X_14403_ _15310_/A _14403_/B VDD VSS _18430_/D AND2X1
X_11615_ _18171_/Q _14106_/B _14106_/C VDD VSS _11621_/D OR3BX1
X_12595_ _18469_/Q _12595_/B _12595_/C VDD VSS _12811_/B MIN3X1
X_18171_ _18171_/CK _18171_/D _18171_/Q VDD VSS DFFQX1
X_15383_ _18908_/Q _15410_/B VDD VSS _15384_/B NAND2X1
XFILLER_11_561 VSS VDD FILLER2
XFILLER_128_235 VDD VSS DECAPHV32
XFILLER_7_532 VDD VSS DECAPHV16
X_11546_ _11546_/A _14077_/B VDD VSS _11618_/A OR2X2
X_17122_ _17122_/A _17122_/B _17122_/C _17122_/D VDD VSS _17123_/B OAI31X1
X_14334_ _17065_/A VDD VSS _14394_/A BUFX3
X_17053_ _17536_/D _17058_/B VDD VSS _17054_/C NOR2X1
X_14265_ _14243_/Y _14265_/B _14265_/C VDD VSS _18314_/D AND3BX1
XTAP_TAPCELL_ROW_133_1611 VDD VSS WELLTAP
X_11477_ _18222_/Q _11477_/B _11529_/C VDD VSS _11579_/B MIN3X1
X_13216_ _13216_/A _13216_/B _13216_/C _13216_/D VDD VSS _14125_/C OAOI211X1
X_16004_ _16582_/A _16004_/B _16004_/C _16004_/D VDD VSS _16056_/B AOI31X1
XFILLER_48_1135 VDD VSS FILLER1
XFILLER_83_1015 VDD VSS DECAPHV8
XFILLER_83_1026 VDD VSS DECAPHV8
X_10428_ _17856_/Q _10428_/B _10428_/C VDD VSS _10434_/A MIN3X1
X_14196_ _14217_/A _14196_/B VDD VSS _18253_/D NOR2X1
XFILLER_124_474 VDD VSS DECAPHV8
XFILLER_83_1048 VDD VSS FILLER1
X_10359_ _10359_/A _10359_/B VDD VSS _10371_/A OR2X2
X_13147_ _13149_/B _13147_/B VDD VSS _13148_/B XNOR2X1
XFILLER_112_669 VDD VSS DECAPHV8
X_13078_ _13186_/A _13186_/B _13186_/D _13186_/C VDD VSS _14240_/C AOI211X1
X_17955_ _17982_/CK _17955_/D _17955_/Q VDD VSS DFFQX1
X_12029_ _12029_/A _14139_/B _12029_/C _12029_/D VDD VSS _12234_/A AOAI211X1
X_16906_ _16907_/B _16906_/B _16906_/C _16906_/D VDD VSS _18929_/D AOAI211X1
XFILLER_66_734 VDD VSS FILLER4
X_17886_ _17913_/CK _17886_/D _17886_/Q VDD VSS DFFQX1
XFILLER_20_1010 VSS VDD FILLER2
XFILLER_65_233 VDD VSS FILLER1
X_16837_ _16837_/A _16837_/B _16837_/C wire30/Y VDD VSS _16839_/B OAI31X1
XFILLER_0_1115 VDD VSS DECAPHV8
XFILLER_81_737 VDD VSS FILLER1
X_16768_ _18919_/Q _16773_/B VDD VSS _16770_/D XNOR2X1
XFILLER_18_171 VDD VSS FILLER1
XFILLER_94_1133 VSS VDD FILLER2
X_18507_ _18509_/CK _18507_/D _18507_/Q VDD VSS DFFQX1
X_15719_ _18888_/Q _15719_/B _15719_/C VDD VSS _15734_/A MIN3X1
XTAP_TAPCELL_ROW_51_629 VDD VSS WELLTAP
X_09240_ _09246_/C _09240_/B VDD VSS _17332_/B NAND2X1
X_16699_ _16631_/B _16698_/Y _16819_/A VDD VSS _16701_/B MUXI2X1
XFILLER_61_483 VSS VDD FILLER2
X_18438_ _18461_/CK _18438_/D _18438_/Q VDD VSS DFFQX1
X_09171_ _09168_/A _09171_/B _09171_/C VDD VSS _09194_/B AOI2B1X1
X_18369_ _18448_/CK _18369_/D _18369_/Q VDD VSS DFFQX1
XTAP_TAPCELL_ROW_31_386 VDD VSS WELLTAP
XFILLER_135_706 VDD VSS FILLER4
XFILLER_128_780 VDD VSS DECAPHV8
Xoutput19 _18066_/Q VDD VSS data_out[4] BUFX3
XFILLER_103_614 VSS VDD FILLER2
XFILLER_115_463 VSS VDD FILLER2
XFILLER_130_400 VSS VDD FILLER2
XFILLER_102_113 VDD VSS DECAPHV16
XFILLER_88_336 VDD VSS FILLER1
X_08955_ _17751_/Q _18540_/Q VDD VSS _08956_/B XOR2X1
XFILLER_102_179 VDD VSS FILLER1
XFILLER_69_561 VDD VSS FILLER1
XTAP_TAPCELL_ROW_59_729 VDD VSS WELLTAP
XFILLER_56_200 VDD VSS DECAPHV8
XFILLER_57_734 VDD VSS FILLER1
XFILLER_5_1026 VDD VSS DECAPHV32
XFILLER_96_380 VDD VSS FILLER1
XFILLER_99_1033 VDD VSS FILLER4
X_08886_ _17729_/Q _18518_/Q VDD VSS _17530_/B XOR2X1
XFILLER_45_929 VDD VSS FILLER1
XFILLER_56_49 VDD VSS DECAPHV32
XFILLER_57_767 VDD VSS FILLER1
XFILLER_84_542 VDD VSS FILLER4
XFILLER_84_575 VDD VSS FILLER1
XTAP_TAPCELL_ROW_39_486 VDD VSS WELLTAP
XFILLER_112_44 VSS VDD FILLER2
XFILLER_71_236 VDD VSS DECAPHV8
X_09507_ _09533_/B _09507_/B VDD VSS _17444_/B XNOR2X1
XFILLER_24_130 VDD VSS DECAPHV8
XFILLER_40_601 VSS VDD FILLER2
XFILLER_40_623 VSS VDD FILLER2
XFILLER_40_645 VDD VSS FILLER1
XTAP_TAPCELL_ROW_104_1267 VDD VSS WELLTAP
X_09438_ _15326_/C _09438_/B _09465_/B VDD VSS _17771_/D NOR3X1
XFILLER_123_1020 VSS VDD FILLER2
XFILLER_36_1072 VDD VSS FILLER1
X_09369_ _09369_/A _09369_/B VDD VSS _09370_/B _09369_/C NAND3X1
X_11400_ _11448_/A _11448_/B VDD VSS _11478_/B NOR2X1
X_12380_ _14294_/B _12380_/B _18336_/Q VDD VSS _12411_/C AND3BX1
X_11331_ _18219_/Q _11421_/B _11334_/C VDD VSS _14187_/B XNOR3X1
XFILLER_106_441 VSS VDD FILLER2
XFILLER_4_546 VDD VSS DECAPHV32
X_11262_ _18965_/Q _18086_/Q VDD VSS _11263_/D AND2X1
X_14050_ _17154_/A _14050_/B VDD VSS _18119_/D AND2X1
XFILLER_106_463 VDD VSS DECAPHV8
XFILLER_122_923 VDD VSS FILLER4
X_10213_ _10213_/A _10213_/B _10213_/C VDD VSS _10214_/B AOI21X1
X_11193_ _11196_/C _11196_/B VDD VSS _11194_/B NOR2BX1
X_13001_ _18135_/Q _13001_/B _13112_/D VDD VSS _13105_/C XNOR3X1
XFILLER_122_956 VDD VSS DECAPHV8
XFILLER_133_282 VDD VSS DECAPHV32
XTAP_TAPCELL_ROW_115_1396 VDD VSS WELLTAP
X_10144_ _10149_/A _10151_/B _10151_/C VDD VSS _10330_/C AND3BX1
XFILLER_0_763 VSS VDD FILLER2
XFILLER_121_455 VDD VSS DECAPHV8
XFILLER_48_745 VDD VSS DECAPHV16
XFILLER_94_328 VDD VSS FILLER1
X_10075_ _17810_/Q _10075_/B _10075_/C _10075_/D VDD VSS _10076_/C AOI2B2X1
X_17740_ clkload4/A _17740_/D _17740_/Q VDD VSS DFFQX1
X_14952_ _18611_/Q _18989_/Q VDD VSS _14956_/A NAND2X1
XFILLER_36_918 VDD VSS DECAPHV8
XFILLER_78_1106 VSS VDD FILLER2
X_17671_ _17706_/CK _17671_/D _17671_/Q VDD VSS DFFQX1
X_14883_ _18596_/Q _18628_/Q VDD VSS _14889_/B NAND2X1
X_13903_ _18485_/Q _14463_/B VDD VSS _13905_/C _14463_/C NAND3X1
XFILLER_29_970 VDD VSS FILLER1
XFILLER_29_992 VSS VDD FILLER2
XFILLER_35_428 VDD VSS FILLER1
XFILLER_47_266 VDD VSS FILLER1
XFILLER_48_789 VDD VSS FILLER1
XFILLER_63_715 VDD VSS DECAPHV8
X_16622_ _18854_/Q _18692_/Q VDD VSS _16624_/D XOR2X1
X_13834_ _13847_/A _13847_/B _13834_/C _13847_/E VDD VSS _14404_/B AOI211X1
XTAP_TAPCELL_ROW_83_1020 VDD VSS WELLTAP
X_10977_ _10972_/A _10977_/B _10977_/C VDD VSS _10981_/C AOI2B1X1
X_16553_ _16553_/A _16553_/B VDD VSS _16591_/B _16553_/C NAND3X1
X_13765_ _13806_/A _13806_/B _13806_/C VDD VSS _13766_/C OAI21X1
XFILLER_31_634 VDD VSS DECAPHV16
X_12716_ _12799_/A _12799_/B _12715_/C VDD VSS _12718_/C AOI21BX1
X_16484_ _16604_/A _16484_/B _16484_/C VDD VSS _16486_/B AOI21X1
X_15504_ _15504_/A _15504_/B _15491_/A VDD VSS _15511_/B AOI21BX1
X_13696_ _13696_/A _14309_/B _14309_/C VDD VSS _13697_/D NOR3X1
XFILLER_129_500 VSS VDD FILLER2
XFILLER_30_122 VDD VSS DECAPHV8
XFILLER_62_81 VDD VSS DECAPHV16
X_12647_ _12751_/A _12763_/A _12769_/B VDD VSS _12743_/C XNOR3X1
X_18223_ _18247_/CK _18223_/D _18223_/Q VDD VSS DFFQX1
X_15435_ _16657_/D VDD VSS _16757_/D BUFX3
X_18154_ _18199_/CK _18154_/D _18154_/Q VDD VSS DFFQX1
X_15366_ _18906_/Q _16161_/C _15366_/C VDD VSS _15411_/B MIN3X1
XFILLER_117_717 VSS VDD FILLER2
XFILLER_129_555 VSS VDD FILLER2
XFILLER_50_1047 VDD VSS DECAPHV8
XFILLER_7_32 VDD VSS DECAPHV32
XFILLER_8_874 VDD VSS DECAPHV8
X_12578_ _12614_/A _12614_/B _12614_/C _12614_/D VDD VSS _12799_/B AO211X2
X_17105_ _18016_/Q _17109_/B VDD VSS _17107_/C XNOR2X1
XFILLER_7_362 VDD VSS DECAPHV8
X_11529_ _11533_/A _14163_/B _11529_/C VDD VSS _14190_/B XNOR3X1
X_18085_ _18966_/CK _18085_/D _18085_/Q VDD VSS DFFQX1
X_15297_ _16984_/A _18038_/Q VDD VSS _18837_/D AND2X1
X_14317_ _18331_/Q _14317_/B VDD VSS _14318_/B XNOR2X1
X_17036_ _17036_/A _17036_/B _17036_/C VDD VSS _17038_/B MIN3X1
X_14248_ _14310_/C _14248_/B VDD VSS _18298_/D AND2X1
XFILLER_112_400 VDD VSS FILLER1
X_14179_ _14396_/A _14179_/B VDD VSS _18237_/D AND2X1
XFILLER_112_477 VDD VSS FILLER4
XFILLER_85_306 VDD VSS DECAPHV8
XFILLER_86_818 VDD VSS FILLER4
X_18987_ _18988_/CK _18987_/D _18987_/Q VDD VSS DFFQX1
XFILLER_22_1105 VDD VSS FILLER1
XFILLER_39_734 VSS VDD FILLER2
X_17938_ _17941_/CK _17938_/D _17938_/Q VDD VSS DFFQX1
XFILLER_16_0 VDD VSS DECAPHV32
XFILLER_78_391 VSS VDD FILLER2
X_17869_ _17871_/CK _17869_/D _17869_/Q VDD VSS DFFQX1
XFILLER_38_266 VDD VSS DECAPHV8
Xclkbuf_0__001_ _173_/ECK VDD VSS clkbuf_0__001_/Y BUFX12
XFILLER_50_910 VDD VSS DECAPHV8
XFILLER_59_1050 VDD VSS FILLER4
XTAP_TAPCELL_ROW_36_445 VDD VSS WELLTAP
XTAP_TAPCELL_ROW_36_456 VDD VSS WELLTAP
XTAP_TAPCELL_ROW_64_787 VDD VSS WELLTAP
XFILLER_22_634 VDD VSS DECAPHV16
XFILLER_34_483 VDD VSS FILLER1
XFILLER_107_1026 VDD VSS DECAPHV16
X_09223_ _09223_/A VDD VSS _09224_/B INVX1
X_09154_ _17733_/Q VDD VSS _17497_/B INVX1
XFILLER_21_199 VSS VDD FILLER2
XFILLER_135_525 VDD VSS DECAPHV16
X_09085_ _17569_/Q _17358_/B VDD VSS _09086_/B XOR2X1
XTAP_TAPCELL_ROW_8_115 VDD VSS WELLTAP
Xclkbuf_leaf_17__000_ clkbuf_leaf_9__000_/A VDD VSS _18837_/CK BUFX12
XFILLER_107_88 VDD VSS FILLER4
XFILLER_130_230 VSS VDD FILLER2
X_09987_ _10203_/A _10203_/B _10203_/D _10203_/C VDD VSS _10204_/B OAI211X1
XFILLER_103_488 VDD VSS DECAPHV16
X_08938_ _09218_/A _08938_/B VDD VSS _17747_/D NOR2X1
XFILLER_123_32 VDD VSS DECAPHV32
XFILLER_69_391 VSS VDD FILLER2
XFILLER_85_840 VDD VSS DECAPHV8
XFILLER_85_862 VDD VSS DECAPHV8
X_08869_ _18027_/Q _18026_/Q _18029_/Q VDD VSS _08870_/C OR3X2
XFILLER_17_406 VDD VSS DECAPHV8
XFILLER_29_288 VDD VSS FILLER1
XFILLER_44_214 VDD VSS FILLER4
XFILLER_57_597 VDD VSS FILLER4
X_10900_ _10914_/A _11039_/B VDD VSS _17965_/D NOR2X1
XFILLER_17_439 VDD VSS FILLER1
XFILLER_84_394 VSS VDD FILLER2
X_11880_ _11880_/A _14138_/B VDD VSS _11930_/A OR2X2
XFILLER_25_450 VDD VSS FILLER1
XFILLER_38_1101 VDD VSS FILLER1
XFILLER_53_770 VDD VSS FILLER1
X_10831_ _10844_/A _10965_/B VDD VSS _17952_/D NOR2X1
XFILLER_52_280 VDD VSS FILLER4
X_10762_ _17912_/Q _10765_/B VDD VSS _10766_/B XNOR2X1
X_13550_ _13675_/A _14370_/B VDD VSS _13574_/B NOR2X1
XFILLER_125_1115 VDD VSS FILLER1
XFILLER_41_976 VDD VSS DECAPHV8
X_12501_ _18338_/Q _14296_/B _14296_/C VDD VSS _12502_/D OR3BX1
X_13481_ _13556_/A _13556_/B _13556_/D VDD VSS _13497_/B AOI21X1
XFILLER_32_40 VDD VSS FILLER4
XFILLER_41_998 VDD VSS FILLER1
X_10693_ _17900_/Q _10700_/A _10700_/B VDD VSS _10695_/C XNOR3X1
X_12432_ _12438_/A _14173_/B _12518_/C VDD VSS _14174_/C NOR3X1
X_15220_ _15250_/A _18789_/Q VDD VSS _18762_/D AND2X1
XFILLER_120_0 VDD VSS DECAPHV32
XFILLER_8_137 VSS VDD FILLER2
XFILLER_126_514 VDD VSS DECAPHV16
XFILLER_5_811 VDD VSS DECAPHV16
XTAP_TAPCELL_ROW_117_1425 VDD VSS WELLTAP
XTAP_TAPCELL_ROW_3_55 VDD VSS WELLTAP
X_12363_ _12446_/A _12446_/B _12446_/D _12446_/C VDD VSS _14089_/C OAI211X1
X_15151_ _15318_/A _18721_/Q VDD VSS _18694_/D AND2X1
XFILLER_99_409 VSS VDD FILLER2
X_11314_ _11314_/A _11314_/B _11314_/C _11314_/D VDD VSS _14045_/C OAI211X1
X_12294_ _18388_/Q _12402_/B _12402_/C VDD VSS _12489_/B MIN3X1
X_15082_ _15080_/B _15082_/B _15082_/C VDD VSS _15085_/C AOI2B1X1
X_14102_ _14129_/A _14102_/B VDD VSS _18167_/D NOR2X1
X_11245_ _18963_/Q _18084_/Q VDD VSS _11247_/C NAND2X1
X_18910_ _18913_/CK _18910_/D _18910_/Q VDD VSS DFFQX1
X_14033_ _14107_/A _18981_/Q VDD VSS _18102_/D AND2X1
XFILLER_122_775 VDD VSS FILLER1
XFILLER_79_155 VDD VSS FILLER1
XFILLER_80_1029 VDD VSS DECAPHV16
X_11176_ _17993_/Q _11181_/B VDD VSS _11177_/B XNOR2X1
X_18841_ _18841_/CK _18841_/D _18841_/Q VDD VSS DFFQX1
XFILLER_94_125 VSS VDD FILLER2
X_10127_ _10294_/B _10127_/B _10127_/C _10127_/D VDD VSS _10148_/B OAOI211X1
X_18772_ _18853_/CK _18772_/D _18772_/Q VDD VSS DFFQX1
X_15984_ _16109_/A _16076_/A VDD VSS _16063_/C _15984_/C _15984_/D NAND4X2
XFILLER_95_659 VSS VDD FILLER2
X_10058_ _10061_/A _10061_/B VDD VSS _10251_/B XNOR2X1
X_17723_ _17725_/CK _17723_/D _17723_/Q VDD VSS DFFQX1
X_14935_ _14935_/A _14935_/B _14935_/C VDD VSS _14938_/C MIN3X1
XFILLER_57_92 VDD VSS FILLER1
XTAP_TAPCELL_ROW_128_1554 VDD VSS WELLTAP
X_17654_ _17656_/CK _17654_/D _17654_/Q VDD VSS DFFQX1
X_14866_ _14868_/C _14866_/B _14866_/C VDD VSS _18592_/D AOI21X1
XFILLER_63_589 VSS VDD FILLER2
XFILLER_91_876 VSS VDD FILLER2
X_17585_ _19045_/CK _17585_/D _17585_/Q VDD VSS DFFQX1
X_16605_ _16630_/A VDD VSS _16819_/A BUFX3
X_14797_ _14797_/A _14799_/C VDD VSS _14798_/B XNOR2X1
X_13817_ _18483_/Q _13870_/A _13860_/B VDD VSS _13827_/D XNOR3X1
XFILLER_50_217 VDD VSS FILLER1
XFILLER_73_80 VDD VSS DECAPHV8
XTAP_TAPCELL_ROW_33_415 VDD VSS WELLTAP
X_16536_ _16536_/A _16576_/C VDD VSS _16537_/D XNOR2X1
X_13748_ _13748_/A _13748_/B _13748_/C _13748_/D VDD VSS _14373_/B OAOI211X1
XFILLER_31_431 VDD VSS DECAPHV8
XTAP_TAPCELL_ROW_61_746 VDD VSS WELLTAP
XFILLER_31_464 VDD VSS FILLER1
X_18206_ _18253_/CK _18206_/D _18206_/Q VDD VSS DFFQX1
X_16467_ _18795_/Q _18741_/Q _16468_/C _16468_/D VDD VSS _16467_/Y AOI211X1
X_13679_ _13738_/A _13738_/B _13738_/D _13738_/C VDD VSS _14401_/C AOI211X1
XTAP_TAPCELL_ROW_13_172 VDD VSS WELLTAP
X_16398_ _18049_/Q _18659_/Q VDD VSS _16429_/A XNOR2X1
X_15418_ _15480_/A _15465_/B _15418_/C VDD VSS _15500_/B AOI21X1
XFILLER_8_671 VDD VSS DECAPHV16
X_18137_ _18963_/CK _18137_/D _18137_/Q VDD VSS DFFQX1
X_15349_ _15349_/A VDD VSS _15737_/A BUFX3
XFILLER_117_569 VDD VSS FILLER4
X_18068_ _18082_/CK _18068_/D _18068_/Q VDD VSS DFFQX1
XFILLER_99_910 VDD VSS FILLER4
XFILLER_99_921 VDD VSS DECAPHV8
XTAP_TAPCELL_ROW_92_1119 VDD VSS WELLTAP
X_09910_ _17790_/Q _09926_/B VDD VSS _09915_/A NOR2BX1
X_17019_ _17019_/A _17019_/B _17019_/C _18961_/Q VDD VSS _18961_/D AO22X2
XFILLER_113_742 VSS VDD FILLER2
XFILLER_98_431 VDD VSS DECAPHV8
XFILLER_112_230 VSS VDD FILLER2
XFILLER_59_818 VSS VDD FILLER2
XFILLER_98_475 VDD VSS FILLER4
X_09841_ _17776_/Q _09841_/B VDD VSS _09848_/C NOR2BX1
XFILLER_100_414 VDD VSS FILLER4
XFILLER_113_786 VDD VSS DECAPHV8
XFILLER_58_328 VDD VSS DECAPHV8
X_09772_ _09772_/A _09772_/B VDD VSS _17489_/B XNOR2X1
XFILLER_67_840 VDD VSS FILLER4
XTAP_TAPCELL_ROW_69_846 VDD VSS WELLTAP
XFILLER_82_821 VDD VSS FILLER4
XFILLER_93_180 VDD VSS FILLER1
XFILLER_22_431 VDD VSS FILLER1
XFILLER_34_291 VDD VSS DECAPHV16
XFILLER_50_762 VDD VSS DECAPHV8
XTAP_TAPCELL_ROW_101_1226 VDD VSS WELLTAP
X_09206_ _17499_/B _17703_/Q _09206_/C VDD VSS _09228_/C MIN3X1
XFILLER_33_1053 VDD VSS DECAPHV8
X_09137_ _09151_/B _09137_/B VDD VSS _09149_/A XNOR2X1
XFILLER_118_32 VDD VSS DECAPHV8
XFILLER_120_1067 VSS VDD FILLER2
X_09068_ _09101_/B _09068_/B VDD VSS _17428_/B XNOR2X1
XFILLER_2_825 VDD VSS DECAPHV32
XFILLER_104_742 VDD VSS FILLER1
XFILLER_123_539 VSS VDD FILLER2
XFILLER_131_561 VSS VDD FILLER2
XFILLER_1_346 VDD VSS DECAPHV16
XTAP_TAPCELL_ROW_112_1366 VDD VSS WELLTAP
X_11030_ _16977_/A VDD VSS _14253_/A BUFX3
XFILLER_76_136 VSS VDD FILLER2
XFILLER_76_147 VDD VSS FILLER1
XFILLER_92_607 VDD VSS FILLER1
XFILLER_57_361 VDD VSS FILLER4
X_12981_ _13191_/A _13191_/B VDD VSS _14152_/B XNOR2X1
XFILLER_27_62 VDD VSS FILLER1
XFILLER_91_128 VDD VSS DECAPHV16
X_11932_ _18227_/Q VDD VSS _11934_/A INVX1
X_14720_ _16977_/A VDD VSS _17396_/A BUFX3
XFILLER_75_1109 VSS VDD FILLER2
X_11863_ _11863_/A _14053_/B VDD VSS _11957_/A OR2X2
X_14651_ _14696_/A _14651_/B VDD VSS _18546_/D NOR2X1
XFILLER_60_548 VDD VSS DECAPHV8
X_10814_ _17043_/A _10951_/B VDD VSS _17949_/D AND2X1
Xclkbuf_leaf_13_clk_fs_regs clkbuf_leaf_9_clk_fs_regs/A VDD VSS _18950_/CK BUFX12
X_17370_ _17434_/A _17370_/B VDD VSS _17581_/D AND2X1
X_13602_ _13602_/A _14456_/B _13602_/C _13602_/D VDD VSS _13784_/A AOAI211X1
XTAP_TAPCELL_ROW_123_1495 VDD VSS WELLTAP
X_11794_ _18123_/Q _11954_/C _11794_/C VDD VSS _11870_/C XNOR3X1
X_16321_ _16321_/A _16321_/B _16321_/C _16321_/D VDD VSS _16396_/B AOAI211X1
X_14582_ _14582_/A _14583_/C _14582_/C VDD VSS _18531_/D AOI21X1
XFILLER_14_987 VSS VDD FILLER2
XFILLER_9_402 VDD VSS FILLER4
X_10745_ _17909_/Q _10750_/B VDD VSS _10747_/C XNOR2X1
X_13533_ _18400_/Q VDD VSS _13546_/A INVX1
XFILLER_9_446 VDD VSS FILLER4
XFILLER_9_468 VDD VSS DECAPHV32
X_10676_ _10676_/A _10676_/B _10676_/C _10676_/D VDD VSS _10677_/B OAI211X1
X_19040_ _19042_/CK _19040_/D _19040_/Q VDD VSS DFFQX1
X_16252_ _16280_/A _16280_/C _16280_/B VDD VSS _16252_/Y AOI21X1
X_13464_ _13475_/A _14335_/B _13475_/C VDD VSS _14336_/B OAI21X1
XTAP_TAPCELL_ROW_10_142 VDD VSS WELLTAP
X_12415_ _12509_/A _14261_/B _12421_/C VDD VSS _14262_/C OR3BX1
X_16183_ _16521_/A _16183_/B VDD VSS _16485_/B NAND2X1
X_15203_ _15286_/A _18772_/Q VDD VSS _18745_/D AND2X1
X_13395_ _13395_/A _13395_/B _13395_/C _13395_/D VDD VSS _13488_/B OAOI211X1
XFILLER_5_641 VDD VSS DECAPHV8
X_12346_ _12545_/A _12545_/B _12346_/C VDD VSS _14116_/C OAI21X1
X_15134_ _15272_/A _18704_/Q VDD VSS _18677_/D AND2X1
XFILLER_107_580 VDD VSS FILLER4
X_12277_ _12398_/A _12398_/B _12285_/C VDD VSS _14474_/B XNOR3X1
X_15065_ _15065_/A _15065_/B _15065_/C _15065_/D VDD VSS _15066_/C AOAI211X1
XFILLER_4_44 VSS VDD FILLER2
XFILLER_96_902 VDD VSS FILLER4
X_11228_ _11247_/A _11240_/B VDD VSS _14041_/B XNOR2X1
X_14016_ _17059_/C _18964_/Q VDD VSS _18085_/D AND2X1
X_11159_ _17990_/Q _11164_/B VDD VSS _11165_/A XNOR2X1
X_18824_ _18851_/CK _18824_/D _18824_/Q VDD VSS DFFQX1
XFILLER_68_659 VDD VSS DECAPHV16
XFILLER_96_979 VDD VSS DECAPHV16
XFILLER_110_789 VDD VSS FILLER1
XFILLER_83_618 VDD VSS DECAPHV8
XTAP_TAPCELL_ROW_66_805 VDD VSS WELLTAP
XTAP_TAPCELL_ROW_66_816 VDD VSS WELLTAP
X_18755_ _18808_/CK _18755_/D _18755_/Q VDD VSS DFFQX1
X_15967_ _15967_/A _15967_/B _15967_/C _15967_/D VDD VSS _15968_/C AOI211X1
XTAP_TAPCELL_ROW_89_1081 VDD VSS WELLTAP
X_18686_ _18848_/CK _18686_/D _18686_/Q VDD VSS DFFQX1
X_17706_ _17706_/CK _17706_/D _17706_/Q VDD VSS DFFQX1
X_15898_ _16411_/A _15898_/B VDD VSS _15982_/B AND2X1
X_14918_ _14919_/C _17318_/C _14918_/C VDD VSS _18603_/D AND3BX1
XFILLER_51_504 VDD VSS DECAPHV8
XTAP_TAPCELL_ROW_18_231 VDD VSS WELLTAP
XTAP_TAPCELL_ROW_89_1092 VDD VSS WELLTAP
X_17637_ _17669_/CK _17637_/D _17637_/Q VDD VSS DFFQX1
X_14849_ _18620_/Q VDD VSS _14998_/A INVX1
XFILLER_56_1031 VSS VDD FILLER2
XFILLER_63_375 VDD VSS DECAPHV8
XTAP_TAPCELL_ROW_46_573 VDD VSS WELLTAP
XFILLER_56_1053 VSS VDD FILLER2
Xclkbuf_leaf_16__001_ clkload75/A VDD VSS _18003_/CK BUFX12
X_17568_ _19024_/CK _17568_/D _17568_/Q VDD VSS DFFQX1
XFILLER_17_1026 VDD VSS FILLER4
XFILLER_17_1037 VDD VSS DECAPHV8
X_17499_ _17499_/A _17499_/B VDD VSS _17703_/D NOR2X1
X_16519_ _16480_/Y _16518_/Y _16554_/A VDD VSS _16593_/B MUXI2X1
XFILLER_20_957 VDD VSS FILLER1
XFILLER_83_0 VDD VSS DECAPHV32
XFILLER_129_160 VDD VSS DECAPHV16
XFILLER_20_979 VDD VSS FILLER4
XFILLER_9_991 VDD VSS FILLER4
XFILLER_133_859 VDD VSS DECAPHV8
XFILLER_28_1133 VSS VDD FILLER2
XFILLER_63_1013 VSS VDD FILLER2
XFILLER_99_751 VDD VSS DECAPHV16
XFILLER_113_561 VDD VSS DECAPHV16
XFILLER_87_924 VDD VSS FILLER1
X_09824_ _17771_/Q _09829_/C VDD VSS _09971_/A XNOR2X1
XFILLER_74_607 VDD VSS DECAPHV16
XFILLER_67_670 VSS VDD FILLER2
X_09755_ _17596_/Q _09762_/A VDD VSS _09756_/B XOR2X1
XFILLER_27_545 VSS VDD FILLER2
XFILLER_39_383 VDD VSS FILLER1
X_09686_ _17625_/Q _17417_/B VDD VSS _09714_/A NAND2BX1
XFILLER_15_718 VDD VSS DECAPHV16
XFILLER_64_49 VDD VSS DECAPHV32
XFILLER_54_386 VDD VSS FILLER1
XFILLER_120_44 VSS VDD FILLER2
XFILLER_10_401 VSS VDD FILLER2
Xfanout43 _17514_/A VDD VSS _17266_/C BUFX3
Xfanout54 _17534_/A VDD VSS _17434_/A BUFX3
Xfanout65 _14343_/A VDD VSS _14107_/A BUFX3
XFILLER_23_795 VDD VSS DECAPHV8
X_10530_ _17873_/Q _10535_/B _10535_/C VDD VSS _10691_/C XNOR3X1
Xfanout76 hold96/A VDD VSS _15307_/A BUFX3
Xfanout87 _15300_/A VDD VSS _14423_/A BUFX3
XFILLER_11_979 VDD VSS FILLER4
XFILLER_6_416 VSS VDD FILLER2
XFILLER_7_928 VSS VDD FILLER2
X_10461_ _10468_/B VDD VSS _10462_/B INVX1
XFILLER_129_64 VDD VSS DECAPHV16
XFILLER_136_620 VDD VSS DECAPHV8
XFILLER_13_86 VDD VSS FILLER4
X_12200_ _18414_/Q VDD VSS _12403_/A INVX1
XFILLER_108_355 VDD VSS DECAPHV16
XFILLER_109_889 VDD VSS DECAPHV8
XFILLER_124_815 VDD VSS FILLER1
X_10392_ _10382_/Y _10583_/B _10583_/C VDD VSS _17877_/D AND3BX1
X_13180_ _13234_/A _13234_/B _13234_/E _13181_/C VDD VSS _14303_/B OAOI211X1
XTAP_TAPCELL_ROW_0_12 VDD VSS WELLTAP
X_12131_ _14141_/B _18203_/Q VDD VSS _12224_/A NAND2BX1
XFILLER_111_509 VSS VDD FILLER2
XFILLER_123_347 VDD VSS DECAPHV16
XTAP_TAPCELL_ROW_0_23 VDD VSS WELLTAP
X_12062_ _18178_/Q _12244_/A _12335_/B VDD VSS _12234_/D XNOR3X1
XFILLER_1_176 VDD VSS DECAPHV8
XFILLER_81_1135 VDD VSS FILLER1
XFILLER_89_261 VDD VSS FILLER4
X_11013_ _11062_/A _11149_/B VDD VSS _17987_/D AND2X1
XFILLER_78_979 VSS VDD FILLER2
X_16870_ _16736_/B _16947_/B _16947_/A VDD VSS _16878_/B MUXI2X1
XFILLER_46_810 VSS VDD FILLER2
XFILLER_92_404 VDD VSS FILLER1
XFILLER_92_415 VSS VDD FILLER2
XFILLER_93_938 VDD VSS DECAPHV16
X_15821_ _18806_/Q _18698_/Q VDD VSS _15855_/B XNOR2X1
XTAP_TAPCELL_ROW_125_1513 VDD VSS WELLTAP
X_12964_ _18263_/Q _14207_/B VDD VSS _12965_/D _14207_/C NAND3X1
X_18540_ clkload2/A _18540_/D _18540_/Q VDD VSS DFFQX1
X_15752_ _18892_/Q _15792_/D _15752_/C _17019_/A VDD VSS _18892_/D AO22X2
XFILLER_18_556 VDD VSS FILLER1
XFILLER_61_813 VSS VDD FILLER2
XFILLER_79_1042 VDD VSS FILLER1
XTAP_TAPCELL_ROW_125_1524 VDD VSS WELLTAP
X_11915_ _18279_/Q _12077_/A _14226_/B VDD VSS _14256_/B XNOR3X1
X_18471_ _18500_/CK _18471_/D _18471_/Q VDD VSS DFFQX1
X_14703_ _18558_/Q _18590_/Q VDD VSS _14710_/C NOR2X1
XTAP_TAPCELL_ROW_15_201 VDD VSS WELLTAP
X_12895_ _18160_/Q _13091_/C _12895_/C VDD VSS _13085_/C XNOR3X1
X_17422_ _17423_/A _17422_/B VDD VSS _17630_/D NOR2X1
X_15683_ _18933_/Q _15720_/B VDD VSS _15685_/B XOR2X1
XFILLER_72_183 VDD VSS FILLER4
XTAP_TAPCELL_ROW_43_532 VDD VSS WELLTAP
X_11846_ _18174_/Q _14110_/B _14110_/C VDD VSS _11853_/D OR3BX1
X_14634_ _18543_/Q _18575_/Q VDD VSS _14639_/A XNOR2X1
XFILLER_60_378 VDD VSS FILLER4
XTAP_TAPCELL_ROW_71_874 VDD VSS WELLTAP
X_11777_ _11845_/A _14110_/B _14110_/C VDD VSS _11924_/C NOR3X1
X_17353_ _17453_/A _17353_/B VDD VSS _19052_/D AND2X1
X_14565_ _18528_/Q _18560_/Q VDD VSS _14566_/B XOR2X1
XFILLER_13_272 VDD VSS FILLER1
XFILLER_9_221 VDD VSS DECAPHV32
X_10728_ _10728_/A _10728_/B _10728_/C VDD VSS _10733_/A MIN3X1
X_17284_ _17283_/B _17284_/B VDD VSS _17291_/A NOR2BX1
X_16304_ _16304_/A _16349_/C VDD VSS _16310_/B XOR2X1
X_13516_ _13516_/A _13516_/B _13516_/C _13516_/D VDD VSS _14456_/B AOAI211X1
X_19023_ _19024_/CK _19023_/D _19023_/Q VDD VSS DFFQX1
X_16235_ _16567_/A _16349_/A VDD VSS _16268_/A NOR2X1
X_14496_ _14972_/A _14496_/B _14496_/C VDD VSS _18509_/D NOR3X1
XFILLER_127_620 VSS VDD FILLER2
XFILLER_16_1081 VDD VSS FILLER4
XFILLER_70_81 VDD VSS DECAPHV32
XTAP_TAPCELL_ROW_136_1653 VDD VSS WELLTAP
X_10659_ _10731_/A _10798_/B VDD VSS _17919_/D NOR2X1
Xclkload35 _18484_/CK VDD VSS clkload35/Y INVX8
Xclkload24 _18990_/CK VDD VSS clkload24/Y INVX2
Xclkload13 _18547_/CK VDD VSS clkload13/Y INVX6
X_13447_ _13519_/A _13519_/B _13519_/C VDD VSS _14425_/B AOI21X1
XFILLER_115_815 VDD VSS DECAPHV8
XFILLER_6_950 VDD VSS DECAPHV16
XTAP_TAPCELL_ROW_136_1664 VDD VSS WELLTAP
Xclkload68 _18381_/CK VDD VSS clkload68/Y INVX1
Xclkload57 _18493_/CK VDD VSS clkload57/Y BUFX12
Xclkload46 _18199_/CK VDD VSS clkload46/Y INVX2
X_16166_ _16245_/C _16245_/D VDD VSS _16166_/Y NAND2X1
X_13378_ _18347_/Q VDD VSS _13474_/A INVX1
XFILLER_114_314 VDD VSS FILLER1
XFILLER_126_174 VDD VSS DECAPHV32
XFILLER_86_1068 VDD VSS FILLER1
X_12329_ _18206_/Q VDD VSS _12429_/A INVX1
Xclkload79 _19043_/CK VDD VSS clkload79/Y INVX4
X_16097_ _16176_/B _16097_/B _16316_/A VDD VSS _16104_/C OR3BX1
X_15117_ _15310_/A _18688_/Q VDD VSS _18661_/D AND2X1
XFILLER_114_347 VSS VDD FILLER2
XFILLER_114_369 VDD VSS DECAPHV16
X_15048_ _15048_/A _15048_/B _15048_/C VDD VSS _15054_/C OA21X2
XFILLER_68_401 VDD VSS DECAPHV16
XFILLER_110_520 VDD VSS FILLER1
XFILLER_95_220 VDD VSS FILLER4
XFILLER_110_575 VDD VSS DECAPHV8
XFILLER_56_607 VSS VDD FILLER2
XFILLER_83_415 VDD VSS FILLER4
XFILLER_96_787 VSS VDD FILLER2
XTAP_TAPCELL_ROW_79_963 VDD VSS WELLTAP
X_18807_ _18835_/CK _18807_/D _18807_/Q VDD VSS DFFQX1
X_16999_ _18950_/Q _17007_/B VDD VSS _17000_/C NAND2X1
XFILLER_3_1135 VDD VSS FILLER1
XFILLER_83_448 VDD VSS DECAPHV8
XFILLER_95_286 VSS VDD FILLER2
X_09540_ _09540_/A _09550_/C VDD VSS _17344_/B XNOR2X1
X_18738_ _18818_/CK _18738_/D _18738_/Q VDD VSS DFFQX1
X_09471_ _09471_/A _09471_/B VDD VSS _09495_/B NAND2X1
XFILLER_110_1066 VSS VDD FILLER2
XFILLER_36_386 VSS VDD FILLER2
XFILLER_63_172 VDD VSS DECAPHV8
XFILLER_64_673 VDD VSS DECAPHV8
X_18669_ _18858_/CK _18669_/D _18669_/Q VDD VSS DFFQX1
XFILLER_52_857 VDD VSS FILLER4
Xclkbuf_0_clk_fs clk_fs VDD VSS clkbuf_0_clk_fs/Y BUFX12
XFILLER_51_367 VDD VSS FILLER4
XFILLER_20_721 VDD VSS DECAPHV8
XFILLER_20_765 VDD VSS FILLER4
Xclkload7 clkload7/A VDD VSS clkload7/Y INVX1
XFILLER_30_1023 VDD VSS DECAPHV16
XFILLER_106_815 VDD VSS DECAPHV16
XFILLER_30_1067 VSS VDD FILLER2
XFILLER_101_520 VDD VSS FILLER1
XFILLER_115_88 VDD VSS FILLER4
XFILLER_59_478 VDD VSS FILLER1
XFILLER_59_489 VDD VSS FILLER4
XFILLER_74_415 VSS VDD FILLER2
X_09807_ _17766_/Q _09807_/B VDD VSS _09936_/B XOR2X1
XFILLER_101_597 VDD VSS FILLER1
X_09738_ _17627_/Q _17419_/B VDD VSS _09739_/C NOR2X1
XFILLER_131_32 VDD VSS DECAPHV32
XFILLER_39_191 VDD VSS FILLER1
X_09669_ _17657_/Q _17451_/B VDD VSS _09671_/C XNOR2X1
XFILLER_54_194 VDD VSS FILLER4
XTAP_TAPCELL_ROW_107_1298 VDD VSS WELLTAP
X_11700_ _18121_/Q VDD VSS _11779_/A INVX1
X_12680_ _12680_/A _12680_/B _14063_/B _12680_/D _12680_/E VDD VSS _12781_/C OAI221X1
XFILLER_30_507 VDD VSS FILLER4
XTAP_TAPCELL_ROW_120_1454 VDD VSS WELLTAP
XTAP_TAPCELL_ROW_40_502 VDD VSS WELLTAP
X_11631_ _11766_/A _11766_/B _11766_/C VDD VSS _11641_/B AOI21X1
X_11562_ _11562_/A _11562_/B _11562_/C _11562_/D VDD VSS _14078_/B AOAI211X1
X_14350_ _14350_/A _14350_/B VDD VSS _14351_/B XNOR2X1
XFILLER_10_231 VDD VSS FILLER1
X_10513_ _10513_/A _10513_/B VDD VSS _10523_/B NOR2X1
X_13301_ _13416_/B _13416_/C _13379_/C VDD VSS _13321_/B AOI21X1
XFILLER_10_286 VDD VSS FILLER1
XFILLER_6_235 VDD VSS DECAPHV32
XFILLER_7_747 VDD VSS DECAPHV32
X_11493_ _11499_/A _14048_/B _11551_/C VDD VSS _14049_/B AO21X2
X_14281_ _15300_/A _14281_/B VDD VSS _18326_/D AND2X1
XFILLER_40_40 VDD VSS FILLER4
X_10444_ _17859_/Q _10444_/B VDD VSS _10445_/C NOR2BX1
X_13232_ _18319_/Q _13232_/B _13287_/D VDD VSS _13289_/B XNOR3X1
X_16020_ _16180_/A _16020_/B VDD VSS _16107_/C NOR2X1
XFILLER_136_494 VDD VSS FILLER1
XFILLER_3_920 VDD VSS DECAPHV8
XFILLER_40_73 VDD VSS FILLER4
X_10375_ _10555_/B _10555_/C _10375_/C _10565_/C VDD VSS _10569_/B AOAI211X1
X_13163_ _13163_/A _14394_/B _14394_/C VDD VSS _13164_/D NOR3X1
XFILLER_112_818 VDD VSS DECAPHV8
X_12114_ _14199_/B _14199_/C _18255_/Q VDD VSS _12118_/B AOI21X1
XFILLER_105_881 VDD VSS FILLER4
XFILLER_3_997 VDD VSS DECAPHV16
X_13094_ _13094_/A _13094_/B _13094_/C _13094_/D VDD VSS _13225_/A AOAI211X1
X_17971_ _18016_/CK _17971_/D _17971_/Q VDD VSS DFFQX1
Xclkbuf_leaf_15__002_ clkbuf_leaf_9__002_/A VDD VSS _18200_/CK BUFX12
XFILLER_133_1022 VDD VSS FILLER1
XFILLER_2_485 VDD VSS DECAPHV16
XFILLER_46_1085 VDD VSS FILLER4
XTAP_TAPCELL_ROW_131_1594 VDD VSS WELLTAP
X_12045_ _12045_/A _12045_/B _12045_/C _12045_/D VDD VSS _14085_/B OAOI211X1
X_16922_ _16922_/A _16930_/B VDD VSS _16928_/B XNOR2X1
XFILLER_37_106 VSS VDD FILLER2
XFILLER_65_404 VDD VSS FILLER4
XFILLER_66_938 VDD VSS DECAPHV8
X_16853_ _18924_/Q _16853_/B VDD VSS _16854_/A NAND2X1
XTAP_TAPCELL_ROW_76_933 VDD VSS WELLTAP
X_15804_ _15804_/A _15897_/A VDD VSS _15984_/C OR2X2
XFILLER_93_779 VDD VSS FILLER4
X_18523_ clkload8/A _18523_/D _18523_/Q VDD VSS DFFQX1
X_16784_ _16784_/A _18777_/Q _16784_/C _16784_/D VDD VSS _16957_/B AO211X2
X_13996_ _13998_/B _14013_/A _13996_/C VDD VSS _13997_/B OR3BX1
XFILLER_45_161 VDD VSS FILLER4
XFILLER_65_92 VDD VSS FILLER1
XFILLER_73_470 VDD VSS FILLER1
XFILLER_80_429 VDD VSS FILLER4
XFILLER_92_278 VDD VSS DECAPHV8
XTAP_TAPCELL_ROW_86_1051 VDD VSS WELLTAP
X_12947_ _12947_/A _12947_/B _12947_/C _12947_/D VDD VSS _14362_/C OAI211X1
X_15735_ _15739_/A _15739_/B VDD VSS _17017_/A XNOR2X1
XFILLER_34_857 VDD VSS DECAPHV16
XFILLER_45_183 VSS VDD FILLER2
XFILLER_61_654 VDD VSS DECAPHV8
XTAP_TAPCELL_ROW_56_690 VDD VSS WELLTAP
X_12878_ wire27/Y _12880_/C VDD VSS _14094_/B XOR2X1
X_18454_ _18480_/CK _18454_/D _18454_/Q VDD VSS DFFQX1
X_15666_ _18881_/Q _15666_/B _15666_/C VDD VSS _15671_/B MIN3X1
XFILLER_21_507 VDD VSS DECAPHV16
XFILLER_60_164 VSS VDD FILLER2
X_11829_ _18357_/Q _11906_/B _11906_/C VDD VSS _14350_/A MIN3X1
X_18385_ _18408_/CK _18385_/D _18385_/Q VDD VSS DFFQX1
X_17405_ _17410_/A _17405_/B VDD VSS _17614_/D NOR2X1
X_14617_ _18539_/Q _18571_/Q VDD VSS _14619_/D XNOR2X1
XFILLER_42_890 VDD VSS FILLER4
XFILLER_53_1034 VDD VSS FILLER1
XFILLER_81_80 VDD VSS DECAPHV8
XFILLER_92_1083 VSS VDD FILLER2
X_17336_ _17338_/A _17336_/B VDD VSS _19036_/D NOR2X1
X_15597_ _15570_/Y _15595_/Y _15685_/A VDD VSS _15650_/B MUXI2X1
XFILLER_105_1135 VDD VSS FILLER1
XFILLER_53_1078 VDD VSS FILLER4
X_14548_ _18525_/Q _18557_/Q VDD VSS _14553_/A XOR2X1
XFILLER_128_951 VDD VSS DECAPHV8
Xclkload113 _18853_/CK VDD VSS clkload113/Y INVX1
Xclkload102 _17961_/CK VDD VSS clkload102/Y BUFX12
X_17267_ _17278_/A _17267_/B _17267_/C VDD VSS _19010_/D AOI21X1
X_14479_ _15300_/A _14479_/B VDD VSS _18495_/D AND2X1
X_19006_ _19011_/CK _19006_/D _19006_/Q VDD VSS DFFQX1
Xclkload124 _18787_/CK VDD VSS clkload124/Y INVX1
X_17198_ _17197_/B _17198_/B VDD VSS _17205_/A NOR2BX1
X_16218_ _16218_/A _18762_/Q _16547_/D _16218_/D _16218_/E VDD VSS _16219_/D AOI221X1
XFILLER_128_995 VSS VDD FILLER2
XFILLER_6_780 VDD VSS DECAPHV8
XTAP_TAPCELL_ROW_97_1180 VDD VSS WELLTAP
X_16149_ _16149_/A _16194_/B VDD VSS _16153_/C XNOR2X1
XFILLER_46_0 VDD VSS DECAPHV32
X_08971_ _17754_/Q _18543_/Q VDD VSS _08972_/C NAND2X1
XFILLER_102_328 VDD VSS FILLER4
XFILLER_56_404 VDD VSS DECAPHV8
XFILLER_57_905 VDD VSS DECAPHV8
XFILLER_68_264 VDD VSS FILLER1
XFILLER_84_724 VDD VSS FILLER4
XFILLER_7_1090 VDD VSS DECAPHV16
XFILLER_25_813 VSS VDD FILLER2
XFILLER_25_835 VSS VDD FILLER2
X_09523_ _09550_/A _09550_/B VDD VSS _09540_/A NAND2X1
XFILLER_80_930 VDD VSS FILLER4
XTAP_TAPCELL_ROW_26_329 VDD VSS WELLTAP
X_09454_ _09476_/A _09476_/B VDD VSS _17442_/B XNOR2X1
X_09385_ _17582_/Q _17371_/B VDD VSS _09405_/A NAND2BX1
XFILLER_32_1107 VDD VSS FILLER1
XFILLER_119_940 VDD VSS FILLER1
XFILLER_119_984 VDD VSS DECAPHV8
XFILLER_106_623 VDD VSS FILLER4
XFILLER_105_144 VSS VDD FILLER2
XFILLER_10_32 VDD VSS DECAPHV8
XFILLER_79_507 VDD VSS DECAPHV8
XFILLER_105_166 VDD VSS DECAPHV8
XFILLER_106_678 VDD VSS DECAPHV8
XFILLER_10_65 VDD VSS FILLER4
XFILLER_126_32 VDD VSS DECAPHV8
X_10160_ _17820_/Q _10160_/B VDD VSS _10165_/A NAND2X1
X_10091_ _10106_/A _10106_/B VDD VSS _10098_/C OR2X2
XFILLER_102_873 VSS VDD FILLER2
XFILLER_48_905 VDD VSS FILLER1
XFILLER_48_916 VDD VSS FILLER1
XFILLER_59_253 VDD VSS DECAPHV8
XFILLER_47_415 VDD VSS DECAPHV16
XTAP_TAPCELL_ROW_109_1327 VDD VSS WELLTAP
XFILLER_63_908 VSS VDD FILLER2
X_13850_ _18458_/Q wire26/Y _13868_/B VDD VSS _13860_/D XNOR3X1
XFILLER_28_673 VDD VSS FILLER1
XFILLER_90_727 VDD VSS DECAPHV8
X_10993_ _10998_/C _10993_/B VDD VSS _11129_/B XNOR2X1
X_12801_ _12926_/A _12931_/D VDD VSS _12819_/C XNOR2X1
X_13781_ _18509_/Q VDD VSS _13821_/C INVX1
XFILLER_16_868 VSS VDD FILLER2
XFILLER_43_654 VSS VDD FILLER2
XFILLER_71_952 VDD VSS FILLER1
X_12732_ _12849_/A _14264_/B _12741_/C VDD VSS _14265_/C OR3BX1
X_15520_ _18871_/Q _15523_/C VDD VSS _15521_/B XNOR2X1
XFILLER_31_816 VDD VSS FILLER1
XFILLER_71_985 VDD VSS FILLER1
XTAP_TAPCELL_ROW_53_660 VDD VSS WELLTAP
X_15451_ _15455_/B _15451_/B VDD VSS _15454_/B XNOR2X1
XTAP_TAPCELL_ROW_6_88 VDD VSS WELLTAP
XTAP_TAPCELL_ROW_81_991 VDD VSS WELLTAP
X_12663_ _12669_/A _12669_/B _12756_/C VDD VSS _14119_/C NOR3X1
X_14402_ _14431_/A _14402_/B _14402_/C VDD VSS _18429_/D NOR3X1
XFILLER_7_500 VDD VSS DECAPHV32
X_11614_ _11614_/A _11614_/B _11614_/C VDD VSS _11621_/B XNOR3X1
X_12594_ _12594_/A _12594_/B _14445_/B VDD VSS _12595_/B MIN3X1
X_18170_ _18171_/CK _18170_/D _18170_/Q VDD VSS DFFQX1
X_15382_ _15382_/A _15382_/B VDD VSS _15386_/B XNOR2X1
X_11545_ _18171_/Q VDD VSS _11614_/A INVX1
X_17121_ _17122_/A _17122_/B _17122_/C VDD VSS _17127_/B OA21X2
X_14333_ _14372_/A _14333_/B VDD VSS _18371_/D AND2X1
XFILLER_116_409 VDD VSS FILLER1
X_11476_ _11544_/A _11476_/B VDD VSS _11477_/B XNOR2X1
X_17052_ _17054_/A _17054_/B VDD VSS _17058_/B AND2X1
X_14264_ _14296_/A _14264_/B _14264_/C VDD VSS _18313_/D NOR3X1
XTAP_TAPCELL_ROW_133_1612 VDD VSS WELLTAP
X_10427_ _10427_/A VDD VSS _10428_/B INVX1
X_13215_ _18161_/Q _14096_/B VDD VSS _13216_/C _14096_/C NAND3X1
X_16003_ _16218_/A _18757_/Q VDD VSS _16004_/D AND2X1
XFILLER_100_1076 VSS VDD FILLER2
X_14195_ _14236_/A _14195_/B _14195_/C VDD VSS _18252_/D NOR3X1
XFILLER_125_987 VDD VSS FILLER4
XFILLER_135_1106 VDD VSS DECAPHV8
X_10358_ _10539_/A _10553_/B _10551_/C VDD VSS _10556_/B OAI21X1
X_13146_ _13149_/A _14487_/B VDD VSS _13147_/B XNOR2X1
XFILLER_112_648 VDD VSS FILLER4
XFILLER_97_326 VDD VSS FILLER4
X_10289_ _17841_/Q _10294_/B _10296_/B VDD VSS _10315_/D XNOR3X1
X_13077_ _18264_/Q _14208_/B VDD VSS _13186_/C _14208_/C AND3X2
X_17954_ _17982_/CK _17954_/D _17954_/Q VDD VSS DFFQX1
X_12028_ _18176_/Q _12137_/B VDD VSS _12029_/D _12028_/C NAND3X1
X_16905_ _18929_/Q _16905_/B VDD VSS _16906_/D NAND2X1
XFILLER_38_426 VDD VSS DECAPHV16
XFILLER_65_201 VDD VSS FILLER4
XFILLER_93_510 VSS VDD FILLER2
X_17885_ _17913_/CK _17885_/D _17885_/Q VDD VSS DFFQX1
XFILLER_38_459 VDD VSS DECAPHV16
XFILLER_81_705 VDD VSS FILLER4
XFILLER_93_565 VSS VDD FILLER2
X_16836_ _16837_/A _16837_/B _16837_/C VDD VSS _16850_/B OA21X2
XFILLER_47_971 VDD VSS FILLER1
XFILLER_65_278 VDD VSS FILLER1
X_16767_ _16767_/A _16775_/C VDD VSS _16773_/B XNOR2X1
X_13979_ _17065_/A VDD VSS _14013_/D BUFX3
X_18506_ _18509_/CK _18506_/D _18506_/Q VDD VSS DFFQX1
X_15718_ _15718_/A VDD VSS _15719_/C INVX1
XFILLER_62_996 VDD VSS FILLER1
X_18437_ _18461_/CK _18437_/D _18437_/Q VDD VSS DFFQX1
X_16698_ _16664_/Y _16697_/Y _16629_/A VDD VSS _16698_/Y MUX2X1
XFILLER_22_838 VDD VSS FILLER4
X_15649_ _15685_/A _15694_/B _15649_/C _15686_/A VDD VSS _15650_/C AO211X2
X_09170_ _17329_/B _19029_/Q VDD VSS _09171_/C NOR2BX1
X_18368_ _18368_/CK _18368_/D _18368_/Q VDD VSS DFFQX1
X_18299_ _18361_/CK _18299_/D _18299_/Q VDD VSS DFFQX1
X_17319_ _19020_/Q _17319_/B _17319_/C VDD VSS _19020_/D AOI21X1
XTAP_TAPCELL_ROW_31_387 VDD VSS WELLTAP
XFILLER_134_206 VDD VSS DECAPHV16
XFILLER_115_475 VDD VSS FILLER4
XFILLER_116_987 VSS VDD FILLER2
XFILLER_131_924 VDD VSS FILLER1
X_08954_ _17750_/Q _18539_/Q _08954_/C VDD VSS _08959_/C AO21X2
XFILLER_29_1091 VDD VSS FILLER4
XFILLER_97_871 VDD VSS FILLER4
XFILLER_116_1072 VDD VSS FILLER4
XFILLER_56_212 VSS VDD FILLER2
X_08885_ _17730_/Q _18519_/Q VDD VSS _17532_/B XOR2X1
XFILLER_96_392 VDD VSS FILLER1
XFILLER_25_610 VSS VDD FILLER2
XFILLER_56_267 VDD VSS FILLER1
XFILLER_71_248 VDD VSS FILLER1
XTAP_TAPCELL_ROW_39_487 VDD VSS WELLTAP
X_09506_ _17683_/Q _17478_/B VDD VSS _09507_/B XOR2X1
XFILLER_13_805 VDD VSS DECAPHV8
XFILLER_24_142 VDD VSS DECAPHV8
XFILLER_25_654 VDD VSS DECAPHV8
XFILLER_72_49 VDD VSS DECAPHV32
XFILLER_25_687 VDD VSS DECAPHV8
XFILLER_80_793 VSS VDD FILLER2
XTAP_TAPCELL_ROW_104_1268 VDD VSS WELLTAP
X_09437_ _09437_/A _09437_/B _09437_/C VDD VSS _09465_/B OA21X2
X_09368_ _09369_/A _09369_/B _09369_/C VDD VSS _09399_/B AOI21X1
XFILLER_21_871 VDD VSS DECAPHV16
X_09299_ _14361_/A VDD VSS _09812_/A BUFX3
X_11330_ _18193_/Q _11420_/B _11420_/C VDD VSS _11334_/C XNOR3X1
XFILLER_119_792 VDD VSS FILLER1
XFILLER_4_514 VDD VSS DECAPHV32
X_11261_ _18113_/Q VDD VSS _11287_/A INVX1
X_10212_ _10378_/B _10212_/B _10212_/C _10212_/D VDD VSS _10395_/B OAOI211X1
X_11192_ _17996_/Q _11192_/B VDD VSS _11196_/B NOR2X1
X_13000_ _18988_/Q _18109_/Q VDD VSS _13112_/D XOR2X1
XTAP_TAPCELL_ROW_115_1397 VDD VSS WELLTAP
X_10143_ _17819_/Q VDD VSS _10149_/A INVX1
XFILLER_121_478 VDD VSS FILLER1
XFILLER_79_359 VDD VSS FILLER1
XFILLER_47_201 VDD VSS DECAPHV8
X_10074_ _10114_/A _10262_/B VDD VSS _17835_/D NOR2X1
X_14951_ _18611_/Q _18989_/Q VDD VSS _14951_/Y NOR2X1
XFILLER_47_223 VDD VSS DECAPHV16
X_17670_ _17701_/CK _17670_/D _17670_/Q VDD VSS DFFQX1
X_14882_ _18596_/Q _18628_/Q VDD VSS _14889_/C NOR2X1
X_13902_ _18486_/Q _13917_/A _13917_/B VDD VSS _13905_/D XOR3X1
XFILLER_35_407 VDD VSS FILLER1
XFILLER_62_204 VDD VSS DECAPHV8
XFILLER_78_1129 VDD VSS FILLER4
X_16621_ _16547_/D _16646_/C _16621_/C VDD VSS _16626_/C OR3BX1
X_13833_ _13860_/A _13860_/B _13860_/C VDD VSS _13851_/B AOI21X1
XFILLER_62_248 VDD VSS FILLER1
XTAP_TAPCELL_ROW_83_1010 VDD VSS WELLTAP
X_16552_ _16550_/Y _16783_/D _16579_/C VDD VSS _16553_/C OR3BX1
XFILLER_43_462 VSS VDD FILLER2
XFILLER_44_963 VDD VSS DECAPHV8
X_10976_ _17954_/Q _10976_/B VDD VSS _10977_/C NOR2BX1
X_15503_ _18870_/Q _15510_/B VDD VSS _15511_/A XNOR2X1
X_13764_ _14310_/A _14310_/B _18351_/Q VDD VSS _13806_/C OAI21X1
X_12715_ _12944_/A _12944_/B _12715_/C VDD VSS _12718_/B NOR3X1
X_16483_ _16604_/A _16632_/B VDD VSS _16484_/C NOR2X1
X_13695_ _13705_/A _13705_/B _13705_/E _13695_/D VDD VSS _14309_/C OAOI211X1
X_12646_ _18209_/Q VDD VSS _12751_/A INVX1
X_18222_ _18247_/CK _18222_/D _18222_/Q VDD VSS DFFQX1
X_15434_ _15374_/B _15386_/B _16783_/A VDD VSS _15549_/B MUXI2X1
XFILLER_12_860 VDD VSS FILLER1
XFILLER_12_882 VDD VSS FILLER1
XFILLER_15_1135 VDD VSS FILLER1
X_18153_ _18199_/CK _18153_/D _18153_/Q VDD VSS DFFQX1
X_15365_ _15415_/A VDD VSS _15366_/C INVX1
XFILLER_102_1105 VSS VDD FILLER2
XFILLER_102_1127 VDD VSS DECAPHV8
XFILLER_50_1059 VSS VDD FILLER2
X_12577_ _12469_/Y _12577_/B _18364_/Q VDD VSS _12614_/D AOI2B1X1
X_17104_ _17242_/A _17104_/B _17107_/B VDD VSS _18977_/D NOR3X1
X_14316_ _14346_/A _14316_/B VDD VSS _18356_/D NOR2X1
XFILLER_7_88 VDD VSS FILLER4
XFILLER_8_897 VDD VSS FILLER1
X_11528_ _18222_/Q VDD VSS _11533_/A INVX1
X_18084_ _18963_/CK _18084_/D _18084_/Q VDD VSS DFFQX1
X_15296_ _16984_/A _18037_/Q VDD VSS _18836_/D AND2X1
X_11459_ _11531_/A _11531_/B VDD VSS _14162_/B XOR2X1
X_17035_ _18002_/Q VDD VSS _17036_/A INVX1
X_14247_ _14247_/A _14247_/B _14372_/A VDD VSS _18297_/D OA21X2
XFILLER_113_902 VDD VSS FILLER1
XFILLER_125_762 VSS VDD FILLER2
XFILLER_98_624 VDD VSS DECAPHV16
XTAP_TAPCELL_ROW_94_1150 VDD VSS WELLTAP
X_14178_ _14236_/A _14178_/B _14178_/C VDD VSS _18236_/D NOR3X1
XFILLER_112_423 VDD VSS FILLER1
XFILLER_97_112 VDD VSS DECAPHV8
X_13129_ _13287_/A _13287_/B VDD VSS _14269_/B XNOR2X1
XFILLER_100_607 VDD VSS DECAPHV8
XFILLER_86_808 VDD VSS FILLER4
X_18986_ _18988_/CK _18986_/D _18986_/Q VDD VSS DFFQX1
XFILLER_66_521 VDD VSS FILLER1
XFILLER_85_318 VDD VSS FILLER1
XFILLER_97_189 VDD VSS FILLER4
X_17937_ _17941_/CK _17937_/D _17937_/Q VDD VSS DFFQX1
XFILLER_94_863 VDD VSS FILLER1
X_17868_ _17871_/CK _17868_/D _17868_/Q VDD VSS DFFQX1
XFILLER_54_705 VSS VDD FILLER2
XFILLER_54_738 VDD VSS DECAPHV16
X_16819_ _16819_/A _16819_/B _16819_/C VDD VSS _16869_/B OAI21X1
Xclkbuf_0__000_ _172_/ECK VDD VSS clkbuf_0__000_/Y BUFX12
X_17799_ _19043_/CK _17799_/D _17799_/Q VDD VSS DFFQX1
XFILLER_22_602 VSS VDD FILLER2
XFILLER_35_985 VDD VSS FILLER1
XFILLER_53_259 VDD VSS DECAPHV16
XTAP_TAPCELL_ROW_36_446 VDD VSS WELLTAP
XFILLER_21_112 VSS VDD FILLER2
XFILLER_50_922 VSS VDD FILLER2
XFILLER_62_793 VSS VDD FILLER2
XTAP_TAPCELL_ROW_64_788 VDD VSS WELLTAP
X_09222_ _17608_/Q _09222_/B _17399_/B VDD VSS _09236_/A MIN3X1
X_09153_ _17734_/Q _17702_/Q VDD VSS _09156_/A XOR2X1
XFILLER_108_729 VDD VSS DECAPHV8
X_09084_ _19023_/Q _17322_/B _17321_/B _19022_/Q VDD VSS _09089_/B AOI22X1
XFILLER_116_773 VDD VSS FILLER1
XFILLER_118_1101 VDD VSS DECAPHV16
XFILLER_131_710 VDD VSS FILLER1
XFILLER_66_1033 VDD VSS DECAPHV16
XTAP_TAPCELL_ROW_8_116 VDD VSS WELLTAP
XFILLER_115_294 VDD VSS DECAPHV8
XFILLER_27_1028 VDD VSS FILLER1
XFILLER_66_1066 VSS VDD FILLER2
XFILLER_66_1077 VSS VDD FILLER2
XFILLER_104_979 VDD VSS FILLER4
XFILLER_131_754 VDD VSS DECAPHV16
X_09986_ _09986_/A _09986_/B VDD VSS _10203_/C OR2X2
X_08937_ _08940_/C _08937_/B VDD VSS _08938_/B XNOR2X1
XFILLER_85_874 VSS VDD FILLER2
XFILLER_123_88 VDD VSS FILLER4
XFILLER_26_974 VSS VDD FILLER2
XFILLER_41_900 VDD VSS FILLER1
X_10830_ _10832_/C _10830_/B VDD VSS _10965_/B XNOR2X1
Xclkbuf_leaf_12_clk_fs_regs clkbuf_leaf_9_clk_fs_regs/A VDD VSS _18958_/CK BUFX12
XFILLER_40_410 VDD VSS FILLER1
XFILLER_41_933 VSS VDD FILLER2
XFILLER_41_944 VDD VSS DECAPHV8
XFILLER_73_1026 VDD VSS DECAPHV8
X_10761_ _10761_/A _10761_/B _10761_/C VDD VSS _10766_/A MIN3X1
XFILLER_125_1127 VDD VSS FILLER4
XFILLER_12_123 VSS VDD FILLER2
XFILLER_40_421 VDD VSS FILLER4
X_10692_ _17899_/Q _10692_/B VDD VSS _10695_/D _10692_/C NAND3X1
X_12500_ _12617_/A _12617_/B _12617_/D _12617_/C VDD VSS _14296_/C AOI211X1
X_13480_ _18295_/Q _14245_/B _14245_/C VDD VSS _13556_/D NOR3BX1
XFILLER_41_988 VSS VDD FILLER2
X_12431_ _12525_/A _12525_/B _12518_/C VDD VSS _14174_/B AOI21BX1
XTAP_TAPCELL_ROW_117_1426 VDD VSS WELLTAP
XTAP_TAPCELL_ROW_3_56 VDD VSS WELLTAP
X_12362_ _18127_/Q _14058_/B _14058_/C VDD VSS _12446_/C OR3BX1
X_15150_ _15318_/A _18720_/Q VDD VSS _18693_/D AND2X1
XFILLER_113_0 VDD VSS DECAPHV32
X_11313_ _11314_/A _11314_/B _11314_/D _11314_/C VDD VSS _11362_/B OAOI211X1
X_12293_ _12385_/B _12293_/B VDD VSS _12402_/C XNOR2X1
X_15081_ _18639_/Q _19017_/Q VDD VSS _15084_/A XOR2X1
X_14101_ _14129_/A _14101_/B VDD VSS _18166_/D NOR2X1
X_11244_ _18963_/Q _18084_/Q VDD VSS _11247_/B NOR2X1
X_14032_ _14107_/A _18980_/Q VDD VSS _18101_/D AND2X1
XFILLER_106_261 VDD VSS DECAPHV16
XFILLER_79_112 VSS VDD FILLER2
XFILLER_110_905 VDD VSS FILLER1
XFILLER_122_754 VDD VSS FILLER1
XFILLER_95_616 VDD VSS DECAPHV8
X_11175_ _17992_/Q _11175_/B _11175_/C VDD VSS _11181_/C AOI21X1
X_18840_ _18840_/CK _18840_/D _18840_/Q VDD VSS DFFQX1
XFILLER_0_583 VSS VDD FILLER2
X_10126_ _17817_/Q _10131_/B VDD VSS _10148_/A AND2X1
X_18771_ _18852_/CK _18771_/D _18771_/Q VDD VSS DFFQX1
X_15983_ _16802_/A _15983_/B _15983_/C VDD VSS _16063_/B OAI21X1
XFILLER_94_159 VDD VSS FILLER1
X_10057_ _10057_/A _10060_/C VDD VSS _10061_/B XOR2X1
X_17722_ _17722_/CK _17722_/D _17722_/Q VDD VSS DFFQX1
X_14934_ _18638_/Q VDD VSS _14935_/B INVX1
XFILLER_48_565 VDD VSS FILLER4
XFILLER_75_340 VSS VDD FILLER2
XTAP_TAPCELL_ROW_128_1555 VDD VSS WELLTAP
X_17653_ _17656_/CK _17653_/D _17653_/Q VDD VSS DFFQX1
XFILLER_35_215 VDD VSS FILLER1
X_16604_ _16604_/A VDD VSS _16857_/A BUFX3
X_14865_ _14868_/C _14866_/B _17229_/A VDD VSS _14866_/C OAI21X1
XFILLER_16_440 VDD VSS FILLER1
XFILLER_17_974 VDD VSS DECAPHV16
XFILLER_51_708 VDD VSS DECAPHV8
XFILLER_63_557 VDD VSS FILLER1
XFILLER_90_354 VDD VSS FILLER1
X_17584_ _19045_/CK _17584_/D _17584_/Q VDD VSS DFFQX1
X_14796_ _14796_/A _14944_/A _14796_/C VDD VSS _14799_/C MIN3X1
X_13816_ _13816_/A _14459_/B _13816_/C _13816_/D VDD VSS _13870_/A OAOI211X1
XFILLER_16_462 VSS VDD FILLER2
XFILLER_32_933 VDD VSS FILLER1
XFILLER_44_793 VDD VSS FILLER1
XFILLER_73_92 VDD VSS FILLER1
XTAP_TAPCELL_ROW_33_416 VDD VSS WELLTAP
X_10959_ _11024_/A _11099_/B VDD VSS _17977_/D NOR2X1
X_16535_ _16535_/A _16535_/B _16535_/C VDD VSS _16576_/C MIN3X1
X_13747_ _18377_/Q _13806_/A _13752_/B VDD VSS _13748_/D XOR3X1
XTAP_TAPCELL_ROW_61_747 VDD VSS WELLTAP
X_16466_ _18796_/Q _18742_/Q VDD VSS _16468_/D XOR2X1
XFILLER_31_476 VDD VSS FILLER1
XFILLER_32_999 VSS VDD FILLER2
X_18205_ _18252_/CK _18205_/D _18205_/Q VDD VSS DFFQX1
X_15417_ _16783_/A _15417_/B _15417_/C _15874_/B VDD VSS _15418_/C AOI211X1
X_13678_ _13678_/A _14371_/B _14371_/C VDD VSS _13738_/C NOR3X1
XFILLER_12_690 VDD VSS FILLER4
XFILLER_89_1011 VSS VDD FILLER2
XTAP_TAPCELL_ROW_13_173 VDD VSS WELLTAP
X_12629_ _12629_/A _14233_/B _12629_/C _12629_/D VDD VSS _12845_/A AOAI211X1
X_16397_ _16397_/A _16440_/C VDD VSS _16408_/B XNOR2X1
XFILLER_129_375 VDD VSS DECAPHV32
XFILLER_89_1033 VDD VSS FILLER4
XFILLER_89_1044 VDD VSS FILLER4
X_18136_ _18247_/CK _18136_/D _18136_/Q VDD VSS DFFQX1
X_15348_ _172_/E _15509_/B VDD VSS _15349_/A OR2X2
XFILLER_7_160 VDD VSS DECAPHV16
XFILLER_89_1077 VDD VSS DECAPHV32
X_18067_ _18082_/CK _18067_/D _18067_/Q VDD VSS DFFQX1
X_15279_ _15307_/A _18847_/Q VDD VSS _18820_/D AND2X1
XFILLER_132_518 VSS VDD FILLER2
X_17018_ _17018_/A _17019_/B _17019_/C _18960_/Q VDD VSS _18960_/D AO22X2
XFILLER_125_581 VDD VSS FILLER1
XFILLER_99_933 VDD VSS DECAPHV8
X_09840_ _09843_/A _10017_/B VDD VSS _17802_/D NOR2X1
XFILLER_86_649 VSS VDD FILLER2
XFILLER_98_498 VSS VDD FILLER2
X_09771_ _17757_/Q _17725_/Q VDD VSS _09772_/B XOR2X1
X_18969_ _18971_/CK _18969_/D _18969_/Q VDD VSS DFFQX1
XFILLER_26_1072 VSS VDD FILLER2
XFILLER_67_830 VDD VSS FILLER4
XTAP_TAPCELL_ROW_69_847 VDD VSS WELLTAP
XFILLER_93_170 VDD VSS FILLER1
XFILLER_23_933 VDD VSS DECAPHV8
XTAP_TAPCELL_ROW_101_1227 VDD VSS WELLTAP
XFILLER_23_977 VSS VDD FILLER2
X_09205_ _17735_/Q VDD VSS _17499_/B INVX1
XFILLER_33_1021 VSS VDD FILLER2
XFILLER_108_504 VDD VSS FILLER1
XFILLER_136_813 VDD VSS DECAPHV32
XFILLER_33_1065 VSS VDD FILLER2
X_09136_ _17637_/Q _17430_/B VDD VSS _09137_/B XOR2X1
XFILLER_108_537 VDD VSS FILLER4
XFILLER_33_1098 VDD VSS FILLER1
X_09067_ _17667_/Q _09100_/A VDD VSS _09068_/B XNOR2X1
XFILLER_118_44 VSS VDD FILLER2
XFILLER_104_710 VDD VSS FILLER4
XFILLER_104_732 VDD VSS DECAPHV8
XFILLER_1_314 VDD VSS DECAPHV32
XFILLER_89_443 VSS VDD FILLER2
XTAP_TAPCELL_ROW_112_1367 VDD VSS WELLTAP
XFILLER_103_253 VDD VSS FILLER4
XFILLER_103_264 VSS VDD FILLER2
XFILLER_134_32 VDD VSS DECAPHV8
X_09969_ _17796_/Q _09969_/B _09982_/B VDD VSS _09970_/D OR3BX1
XFILLER_131_1131 VDD VSS FILLER1
XFILLER_40_1025 VDD VSS DECAPHV16
X_12980_ _18212_/Q VDD VSS _13121_/A INVX1
XFILLER_27_52 VDD VSS FILLER1
XFILLER_73_833 VDD VSS FILLER1
X_11931_ _11931_/A _11931_/B _11931_/C VDD VSS _14168_/C NOR3X1
XFILLER_72_354 VSS VDD FILLER2
XFILLER_73_877 VDD VSS FILLER1
X_11862_ _11870_/A _11870_/B _11870_/C VDD VSS _14082_/B OAI21X1
X_14650_ _14650_/A _14650_/B VDD VSS _14651_/B XNOR2X1
X_10813_ _10816_/C _10813_/B VDD VSS _10951_/B XNOR2X1
X_14581_ _14582_/A _14583_/C _17229_/A VDD VSS _14582_/C OAI21X1
X_13601_ _18453_/Q _14427_/B VDD VSS _13602_/D _14427_/C NAND3X1
XTAP_TAPCELL_ROW_123_1496 VDD VSS WELLTAP
X_11793_ _11954_/A _11954_/B _11954_/D VDD VSS _11794_/C AOI21X1
X_16320_ _16321_/C _16320_/B _16321_/D _16547_/D VDD VSS _16320_/Y OAI31X1
X_13532_ _13532_/A _13532_/B _13532_/C _13532_/D VDD VSS _13591_/B AOAI211X1
XFILLER_41_785 VDD VSS DECAPHV8
XFILLER_51_1110 VDD VSS FILLER4
XFILLER_9_414 VDD VSS DECAPHV32
X_10744_ _10740_/B _10744_/B VDD VSS _10747_/B NOR2BX1
X_10675_ _10676_/A _10676_/B _10676_/D _10676_/C VDD VSS _10817_/B OAOI211X1
X_16251_ _18817_/Q _18709_/Q VDD VSS _16280_/B XOR2X1
X_13463_ _13547_/A _14398_/B VDD VSS _13598_/B NOR2X1
X_12414_ _18284_/Q _14232_/B VDD VSS _12509_/A NAND2X1
X_16182_ _16108_/B _16181_/Y _16412_/A VDD VSS _16183_/B MUXI2X1
X_15202_ _15281_/A _18771_/Q VDD VSS _18744_/D AND2X1
X_13394_ _18268_/Q _14212_/B VDD VSS _13488_/A NOR2BX1
XTAP_TAPCELL_ROW_10_143 VDD VSS WELLTAP
X_12345_ _12366_/A _12545_/B _12346_/C VDD VSS _14116_/B OR3BX1
X_15133_ _15299_/A _18703_/Q VDD VSS _18676_/D AND2X1
XFILLER_99_218 VSS VDD FILLER2
XFILLER_4_174 VDD VSS DECAPHV32
XFILLER_5_686 VDD VSS DECAPHV32
X_12276_ _18440_/Q _12397_/B _14413_/B VDD VSS _12285_/C XNOR3X1
X_15064_ _15065_/A _15065_/B _15065_/D _15065_/C VDD VSS _15067_/C AOI211X1
XFILLER_49_1094 VDD VSS DECAPHV8
X_11227_ _18963_/Q _18084_/Q VDD VSS _11240_/B XOR2X1
X_14015_ _17043_/A _18963_/Q VDD VSS _18084_/D AND2X1
XFILLER_68_81 VDD VSS DECAPHV32
XFILLER_95_402 VSS VDD FILLER2
XFILLER_96_936 VDD VSS FILLER4
X_11158_ _11205_/A _17098_/A VDD VSS _18015_/D NOR2X1
X_18823_ _18851_/CK _18823_/D _18823_/Q VDD VSS DFFQX1
X_10109_ _17815_/Q _10109_/B VDD VSS _10110_/D _10119_/B NAND3X1
XFILLER_48_340 VSS VDD FILLER2
XFILLER_64_811 VSS VDD FILLER2
XTAP_TAPCELL_ROW_66_806 VDD VSS WELLTAP
X_11089_ _17976_/Q _11089_/B VDD VSS _11094_/B NOR2X1
X_18754_ _18805_/CK _18754_/D _18754_/Q VDD VSS DFFQX1
X_15966_ _15967_/A _15967_/B _15967_/D _15967_/C VDD VSS _16047_/B AOAI211X1
XFILLER_82_129 VDD VSS DECAPHV8
XTAP_TAPCELL_ROW_89_1082 VDD VSS WELLTAP
X_18685_ _18848_/CK _18685_/D _18685_/Q VDD VSS DFFQX1
X_17705_ _17706_/CK _17705_/D _17705_/Q VDD VSS DFFQX1
X_15897_ _15897_/A VDD VSS _16411_/A INVX2
X_14917_ _14917_/A _14917_/B _14917_/C _14917_/D VDD VSS _14918_/C AOAI211X1
XFILLER_36_568 VDD VSS FILLER1
XFILLER_64_866 VDD VSS DECAPHV16
XTAP_TAPCELL_ROW_18_232 VDD VSS WELLTAP
X_17636_ _17701_/CK _17636_/D _17636_/Q VDD VSS DFFQX1
X_14848_ _18589_/Q _18621_/Q VDD VSS _14852_/A XOR2X1
XFILLER_90_173 VDD VSS FILLER1
XTAP_TAPCELL_ROW_46_574 VDD VSS WELLTAP
Xclkbuf_leaf_16__000_ clkbuf_leaf_9__000_/A VDD VSS _18838_/CK BUFX12
X_17567_ _19024_/CK _17567_/D _17567_/Q VDD VSS DFFQX1
X_16518_ _16518_/A _16518_/B VDD VSS _16518_/Y _16518_/C _16518_/D OR4X1
X_14779_ _18573_/Q _18605_/Q VDD VSS _14780_/C NAND2X1
XFILLER_17_1016 VDD VSS FILLER4
XFILLER_20_925 VDD VSS DECAPHV8
XFILLER_31_262 VDD VSS FILLER1
X_17498_ _17498_/A _17734_/Q VDD VSS _17702_/D AND2X1
XFILLER_104_1008 VSS VDD FILLER2
XFILLER_31_295 VSS VDD FILLER2
X_16449_ _16459_/A _16737_/B _16449_/C VDD VSS _16457_/C AOI21X1
XFILLER_117_301 VDD VSS FILLER4
XFILLER_76_0 VDD VSS DECAPHV32
XFILLER_117_334 VDD VSS FILLER4
X_18119_ _18988_/CK _18119_/D _18119_/Q VDD VSS DFFQX1
XFILLER_133_816 VDD VSS FILLER1
XFILLER_132_315 VDD VSS DECAPHV8
XFILLER_113_551 VDD VSS FILLER4
XFILLER_115_1115 VDD VSS FILLER1
XFILLER_63_1047 VDD VSS FILLER1
XFILLER_99_796 VDD VSS DECAPHV8
X_09823_ _09843_/A _09969_/B VDD VSS _17796_/D NOR2X1
XFILLER_58_137 VSS VDD FILLER2
XFILLER_39_362 VDD VSS FILLER4
X_09754_ _09765_/B _09754_/B VDD VSS _09762_/A XNOR2X1
XFILLER_100_289 VSS VDD FILLER2
XFILLER_95_991 VDD VSS FILLER1
X_09685_ _09712_/A _09712_/B VDD VSS _09704_/A NAND2X1
XFILLER_82_663 VDD VSS FILLER1
XFILLER_27_579 VSS VDD FILLER2
XFILLER_55_888 VDD VSS FILLER1
XFILLER_42_549 VSS VDD FILLER2
XFILLER_74_1132 VDD VSS FILLER4
XFILLER_81_184 VSS VDD FILLER2
XFILLER_23_763 VDD VSS DECAPHV16
Xfanout44 _17514_/A VDD VSS _17255_/D BUFX3
Xfanout55 _17534_/A VDD VSS _17392_/A BUFX3
XFILLER_122_1119 VDD VSS DECAPHV16
XFILLER_13_32 VDD VSS DECAPHV16
XFILLER_80_49 VDD VSS DECAPHV32
Xfanout66 hold96/A VDD VSS _14343_/A BUFX3
Xfanout77 _15304_/A VDD VSS _15274_/A BUFX3
Xfanout88 _14377_/A VDD VSS _15300_/A BUFX3
XFILLER_109_813 VDD VSS FILLER4
XFILLER_10_446 VDD VSS FILLER1
XFILLER_129_32 VDD VSS DECAPHV32
X_10460_ _10516_/A _10642_/B VDD VSS _17888_/D NOR2X1
XFILLER_109_857 VSS VDD FILLER2
X_09119_ _09119_/A _09119_/B VDD VSS _09120_/C OR2X2
X_10391_ _10400_/A _10569_/B VDD VSS _10583_/C _10400_/C NAND3X1
XFILLER_124_849 VDD VSS DECAPHV8
XTAP_TAPCELL_ROW_0_13 VDD VSS WELLTAP
X_12130_ _18230_/Q VDD VSS _12221_/A INVX1
XTAP_TAPCELL_ROW_0_24 VDD VSS WELLTAP
X_12061_ _12153_/A _12239_/B _12239_/C VDD VSS _12335_/B XNOR3X1
XFILLER_104_573 VDD VSS DECAPHV8
XFILLER_132_882 VDD VSS FILLER1
XFILLER_78_914 VDD VSS DECAPHV8
X_11012_ _11012_/A _11015_/C VDD VSS _11149_/B XNOR2X1
XFILLER_131_370 VSS VDD FILLER2
XFILLER_77_457 VDD VSS FILLER1
X_15820_ _18805_/Q _18697_/Q VDD VSS _15855_/A NAND2X1
XFILLER_38_40 VDD VSS FILLER4
XFILLER_65_619 VSS VDD FILLER2
XFILLER_77_468 VDD VSS DECAPHV16
XFILLER_57_170 VDD VSS FILLER1
XFILLER_58_671 VDD VSS FILLER1
XFILLER_79_1021 VSS VDD FILLER2
XTAP_TAPCELL_ROW_125_1514 VDD VSS WELLTAP
X_12963_ _14207_/B _14207_/C _18263_/Q VDD VSS _12965_/C AOI21X1
X_15751_ _15751_/A _15751_/B VDD VSS _17019_/A XNOR2X1
X_11914_ _18307_/Q VDD VSS _12011_/A INVX1
X_18470_ _18470_/CK _18470_/D _18470_/Q VDD VSS DFFQX1
X_15682_ _18931_/Q _18932_/Q VDD VSS _15720_/B _15682_/C NAND3X1
X_14702_ _18557_/Q _18589_/Q _14702_/C VDD VSS _14710_/A MIN3X1
XFILLER_46_888 VDD VSS FILLER1
XFILLER_60_313 VDD VSS FILLER1
XFILLER_61_836 VDD VSS FILLER1
XFILLER_72_151 VDD VSS FILLER1
X_12894_ wire27/Y _13091_/B _13091_/D VDD VSS _12895_/C AOI21X1
X_17421_ _17423_/A _17421_/B VDD VSS _17629_/D NOR2X1
X_14633_ _14696_/A _14633_/B VDD VSS _18542_/D NOR2X1
XTAP_TAPCELL_ROW_15_202 VDD VSS WELLTAP
XTAP_TAPCELL_ROW_43_533 VDD VSS WELLTAP
X_11845_ _11845_/A _11845_/B _11845_/C VDD VSS _11853_/B XNOR3X1
XTAP_TAPCELL_ROW_71_875 VDD VSS WELLTAP
X_11776_ _11786_/A _11786_/B _11845_/C VDD VSS _14110_/C NOR3X1
X_17352_ _17355_/A _17352_/B VDD VSS _19051_/D NOR2X1
X_14564_ _18527_/Q _18559_/Q _14564_/C VDD VSS _14569_/C AO21X2
XFILLER_13_284 VDD VSS FILLER1
XFILLER_41_571 VDD VSS FILLER1
X_10727_ _17905_/Q VDD VSS _10728_/A INVX1
X_17283_ _17284_/B _17283_/B VDD VSS _17285_/B NOR2BX1
X_16303_ _16459_/A _16303_/B _16303_/C VDD VSS _16349_/C OA21X2
X_14495_ _15310_/A _14495_/B VDD VSS _18508_/D AND2X1
X_13515_ _13515_/A _13515_/B _13515_/C _13515_/D VDD VSS _13525_/B AOAI211X1
XFILLER_9_255 VDD VSS FILLER1
XTAP_TAPCELL_ROW_23_290 VDD VSS WELLTAP
X_19022_ _19024_/CK _19022_/D _19022_/Q VDD VSS DFFQX1
X_16234_ _16234_/A _16234_/B _16234_/C VDD VSS _16349_/A NOR3X1
X_13446_ _13459_/A _13446_/B _13532_/D VDD VSS _13519_/C XNOR3X1
XFILLER_127_643 VDD VSS DECAPHV8
X_10658_ _17893_/Q _10661_/B _10661_/C VDD VSS _10798_/B XNOR3X1
Xclkload25 clkload25/A VDD VSS clkload25/Y INVX14
Xclkload14 _18863_/CK VDD VSS clkload14/Y INVX8
XFILLER_126_142 VDD VSS DECAPHV32
XTAP_TAPCELL_ROW_136_1654 VDD VSS WELLTAP
XTAP_TAPCELL_ROW_136_1665 VDD VSS WELLTAP
X_10589_ _10594_/A _10594_/B VDD VSS _10590_/C NAND2X1
Xclkload69 _18361_/CK VDD VSS clkload69/Y INVX2
Xclkload58 _18496_/CK VDD VSS clkload58/Y INVX8
Xclkload47 _18200_/CK VDD VSS clkload47/Y INVX2
Xclkload36 _18963_/CK VDD VSS clkload36/Y INVX1
X_16165_ _16165_/A _16165_/B _16165_/C _16165_/D VDD VSS _16245_/D AOAI211X1
X_13377_ _13475_/A _14335_/B VDD VSS _13424_/B NOR2X1
XFILLER_103_1096 VSS VDD FILLER2
XFILLER_115_827 VSS VDD FILLER2
X_12328_ _18205_/Q _12328_/B VDD VSS _12331_/C _12328_/C NAND3X1
X_16096_ _16096_/A _16096_/B _16096_/C _16096_/D VDD VSS _16097_/B AOI211X1
X_15116_ _15309_/A _18687_/Q VDD VSS _18660_/D AND2X1
XFILLER_130_808 VDD VSS DECAPHV8
XFILLER_79_80 VDD VSS DECAPHV8
X_12259_ _12352_/A _12352_/B _12352_/C VDD VSS _12264_/B AOI21X1
X_15047_ _18631_/Q _19009_/Q VDD VSS _15048_/C NAND2X1
XFILLER_69_925 VDD VSS FILLER4
XFILLER_96_722 VDD VSS FILLER1
XFILLER_110_510 VDD VSS FILLER1
XFILLER_122_392 VDD VSS FILLER1
XFILLER_68_446 VDD VSS DECAPHV8
XFILLER_96_733 VDD VSS FILLER1
XFILLER_83_405 VDD VSS FILLER4
XFILLER_95_243 VDD VSS DECAPHV32
XTAP_TAPCELL_ROW_79_964 VDD VSS WELLTAP
X_18806_ _18835_/CK _18806_/D _18806_/Q VDD VSS DFFQX1
X_16998_ _16998_/A _17019_/B _17019_/C _18949_/Q VDD VSS _18949_/D AO22X2
XFILLER_110_598 VDD VSS FILLER1
XFILLER_3_1114 VSS VDD FILLER2
XFILLER_48_170 VSS VDD FILLER2
XFILLER_77_980 VSS VDD FILLER2
X_18737_ _18818_/CK _18737_/D _18737_/Q VDD VSS DFFQX1
X_15949_ _18897_/Q _15949_/B VDD VSS _15950_/C NOR2BX1
XFILLER_23_1075 VDD VSS FILLER1
XFILLER_23_1097 VDD VSS FILLER4
XFILLER_48_181 VSS VDD FILLER2
X_09470_ _09462_/A _09470_/B VDD VSS _09471_/B NAND2BX1
XFILLER_64_685 VSS VDD FILLER2
X_18668_ _18858_/CK _18668_/D _18668_/Q VDD VSS DFFQX1
XFILLER_36_398 VDD VSS DECAPHV8
XFILLER_63_184 VSS VDD FILLER2
X_18599_ _19011_/CK _18599_/D _18599_/Q VDD VSS DFFQX1
X_17619_ _19045_/CK _17619_/D _17619_/Q VDD VSS DFFQX1
XFILLER_20_700 VDD VSS FILLER4
Xclkload8 clkload8/A VDD VSS clkload8/Y BUFX12
XFILLER_133_635 VDD VSS FILLER4
XFILLER_105_359 VDD VSS FILLER1
XFILLER_114_871 VDD VSS DECAPHV8
XFILLER_120_318 VSS VDD FILLER2
XFILLER_113_381 VSS VDD FILLER2
XFILLER_87_733 VDD VSS FILLER4
XFILLER_59_468 VDD VSS FILLER4
XFILLER_87_766 VDD VSS FILLER1
X_09806_ _17765_/Q _09810_/C VDD VSS _09807_/B NAND2X1
XFILLER_87_799 VDD VSS FILLER1
X_09737_ _09737_/A _09737_/B _09737_/C VDD VSS _09763_/B AOI21X1
XFILLER_27_321 VDD VSS FILLER4
XFILLER_28_866 VSS VDD FILLER2
XFILLER_28_888 VDD VSS FILLER1
XFILLER_43_836 VDD VSS FILLER1
XFILLER_70_611 VDD VSS DECAPHV8
X_09668_ _09692_/B _09668_/B VDD VSS _17451_/B XNOR2X1
XFILLER_131_88 VDD VSS FILLER4
XFILLER_42_324 VDD VSS FILLER1
XFILLER_82_482 VSS VDD FILLER2
XTAP_TAPCELL_ROW_107_1299 VDD VSS WELLTAP
X_09599_ _09594_/A _09599_/B VDD VSS _09620_/B NAND2BX1
XFILLER_42_368 VDD VSS FILLER1
X_11630_ _11630_/A _14079_/B _14079_/C VDD VSS _11766_/C NOR3X1
XFILLER_24_75 VDD VSS FILLER1
XTAP_TAPCELL_ROW_120_1455 VDD VSS WELLTAP
XTAP_TAPCELL_ROW_40_503 VDD VSS WELLTAP
X_11561_ _18119_/Q _14050_/B VDD VSS _11696_/A NAND2X1
XFILLER_10_221 VDD VSS FILLER1
XFILLER_10_243 VSS VDD FILLER2
X_10512_ _10512_/A _10512_/B _10512_/C _10512_/D VDD VSS _10680_/A AOAI211X1
X_13300_ _13380_/A _14211_/B _14211_/C VDD VSS _13379_/C NOR3X1
XFILLER_109_632 VSS VDD FILLER2
XFILLER_11_799 VDD VSS FILLER1
X_11492_ _11499_/A _14048_/B VDD VSS _14049_/A _11551_/C NAND3X1
X_14280_ _14310_/C _14280_/B VDD VSS _18325_/D AND2X1
XFILLER_108_142 VDD VSS FILLER4
XTAP_TAPCELL_ROW_20_260 VDD VSS WELLTAP
X_10443_ _10516_/A _10624_/B VDD VSS _17885_/D NOR2X1
X_13231_ _18293_/Q _13395_/A _13416_/C VDD VSS _13287_/D XNOR3X1
XFILLER_109_687 VSS VDD FILLER2
X_10374_ _17850_/Q _10378_/B _10385_/B VDD VSS _10565_/C XNOR3X1
X_13162_ _13265_/A _13265_/B _13265_/D _13265_/C VDD VSS _14394_/C AOI211X1
XFILLER_3_965 VDD VSS DECAPHV32
XFILLER_6_0 VDD VSS DECAPHV32
X_12113_ _12176_/C _12179_/B _12179_/C VDD VSS _12171_/C NOR3X1
XFILLER_111_307 VDD VSS FILLER1
XFILLER_2_453 VDD VSS DECAPHV32
X_13093_ _18160_/Q _14095_/B VDD VSS _13094_/D _14095_/C NAND3X1
X_17970_ _18016_/CK _17970_/D _17970_/Q VDD VSS DFFQX1
Xclkbuf_leaf_15__001_ clkload75/A VDD VSS _17982_/CK BUFX12
XFILLER_123_189 VDD VSS DECAPHV32
XTAP_TAPCELL_ROW_131_1595 VDD VSS WELLTAP
X_12044_ _18125_/Q _12161_/A _12161_/B VDD VSS _12045_/D XNOR3X1
X_16921_ _16939_/A _16921_/B _16946_/A VDD VSS _16930_/B AOI21X1
XFILLER_77_243 VSS VDD FILLER2
X_16852_ _18924_/Q _16927_/B _16854_/B _16852_/D VDD VSS _18924_/D AO22X2
XFILLER_19_811 VSS VDD FILLER2
XFILLER_59_980 VDD VSS FILLER1
XFILLER_77_298 VDD VSS FILLER1
XFILLER_78_799 VDD VSS DECAPHV8
XFILLER_92_202 VDD VSS FILLER1
XTAP_TAPCELL_ROW_76_934 VDD VSS WELLTAP
X_16783_ _16783_/A _16783_/B _16783_/C _16783_/D _16783_/E VDD VSS _16784_/D OAI221X1
X_15803_ _18862_/Q _15803_/B _15803_/C VDD VSS _16155_/A OA21X2
XFILLER_74_950 VDD VSS FILLER1
XFILLER_92_235 VSS VDD FILLER2
X_18522_ clkload6/A _18522_/D _18522_/Q VDD VSS DFFQX1
X_15734_ _15734_/A _15734_/B _15734_/C VDD VSS _15739_/B AO21X2
X_13995_ _18951_/Q _13995_/B _18952_/Q VDD VSS _13996_/C AOI21X1
XFILLER_19_877 VDD VSS DECAPHV8
XFILLER_74_983 VDD VSS FILLER1
XTAP_TAPCELL_ROW_86_1052 VDD VSS WELLTAP
X_12946_ _12947_/A _12947_/B _12947_/D _12947_/C VDD VSS _14363_/B OAOI211X1
XFILLER_33_313 VDD VSS FILLER4
XTAP_TAPCELL_ROW_28_360 VDD VSS WELLTAP
XTAP_TAPCELL_ROW_56_691 VDD VSS WELLTAP
X_12877_ _12977_/A _12977_/B _12977_/D VDD VSS _12904_/B OAI21X1
X_18453_ _18453_/CK _18453_/D _18453_/Q VDD VSS DFFQX1
X_15665_ _18882_/Q _15670_/B VDD VSS _15671_/A XNOR2X1
XFILLER_33_368 VDD VSS FILLER4
XFILLER_33_379 VSS VDD FILLER2
X_11828_ _11828_/A _11828_/B _14316_/B VDD VSS _11906_/B MIN3X1
X_18384_ _18408_/CK _18384_/D _18384_/Q VDD VSS DFFQX1
X_17404_ _17434_/A _17404_/B VDD VSS _17613_/D AND2X1
X_15596_ _15596_/A VDD VSS _15685_/A BUFX3
X_14616_ _14619_/A _14616_/B _14616_/C VDD VSS _18538_/D AOI21X1
XFILLER_60_198 VSS VDD FILLER2
X_17335_ _17338_/A _17335_/B VDD VSS _19035_/D NOR2X1
X_14547_ _14696_/A _14547_/B VDD VSS _18524_/D NOR2X1
XFILLER_14_1008 VDD VSS DECAPHV8
XFILLER_81_92 VDD VSS FILLER1
X_11759_ _11759_/A _14195_/B _14195_/C VDD VSS _11800_/C NOR3X1
Xclkload103 _18016_/CK VDD VSS clkload103/Y INVX1
X_17266_ _17278_/A _17267_/B _17266_/C VDD VSS _17267_/C OAI21X1
X_14478_ _14480_/A _14478_/B VDD VSS _18494_/D NOR2X1
X_19005_ clkload9/A _19005_/D _19005_/Q VDD VSS DFFQX1
Xclkload125 _18840_/CK VDD VSS clkload125/Y INVX1
Xclkload114 _18801_/CK VDD VSS clkload114/Y BUFX12
X_17197_ _17198_/B _17197_/B VDD VSS _17199_/B NOR2BX1
X_16217_ _16215_/Y _16582_/A _16217_/C VDD VSS _16218_/E AND3BX1
X_13429_ _13436_/A _13515_/D VDD VSS _14490_/B XNOR2X1
XTAP_TAPCELL_ROW_97_1181 VDD VSS WELLTAP
X_16148_ _16711_/A _16448_/B _16148_/C VDD VSS _16194_/B OA21X2
X_08970_ _08972_/A _08972_/B _08970_/C VDD VSS _17754_/D AOI21X1
X_16079_ _16079_/A VDD VSS _16082_/D INVX1
XFILLER_123_690 VDD VSS DECAPHV8
XFILLER_39_0 VDD VSS DECAPHV32
XFILLER_29_608 VDD VSS DECAPHV8
XFILLER_60_1017 VDD VSS DECAPHV16
XFILLER_56_416 VSS VDD FILLER2
XFILLER_83_213 VDD VSS FILLER1
Xinput1 data_in VDD VSS input1/Y BUFX3
XFILLER_49_490 VDD VSS FILLER1
XFILLER_65_950 VSS VDD FILLER2
XFILLER_72_909 VDD VSS FILLER4
X_09522_ _09517_/A _09522_/B VDD VSS _09550_/B NAND2BX1
XFILLER_36_162 VDD VSS FILLER1
XFILLER_37_674 VSS VDD FILLER2
XFILLER_65_994 VDD VSS FILLER4
XFILLER_24_313 VDD VSS FILLER4
XFILLER_25_869 VDD VSS FILLER4
XFILLER_91_290 VDD VSS DECAPHV8
X_09453_ _17681_/Q _17476_/B VDD VSS _09476_/B XOR2X1
X_09384_ _09384_/A _09384_/B VDD VSS _09409_/A NAND2X1
XFILLER_71_1102 VDD VSS FILLER1
XFILLER_71_1135 VDD VSS FILLER1
XFILLER_20_563 VDD VSS FILLER4
XFILLER_106_646 VDD VSS DECAPHV16
XFILLER_10_44 VSS VDD FILLER2
XFILLER_133_421 VDD VSS FILLER1
XFILLER_134_944 VDD VSS DECAPHV32
XFILLER_126_44 VSS VDD FILLER2
XFILLER_79_519 VDD VSS FILLER1
XFILLER_0_935 VDD VSS DECAPHV8
XFILLER_105_189 VSS VDD FILLER2
XFILLER_120_137 VSS VDD FILLER2
X_10090_ _10106_/A _10106_/B VDD VSS _10098_/B XNOR2X1
XFILLER_59_232 VDD VSS FILLER4
XFILLER_19_129 VSS VDD FILLER2
XFILLER_19_64 VDD VSS FILLER1
XFILLER_59_298 VDD VSS DECAPHV8
XFILLER_74_235 VDD VSS FILLER1
XTAP_TAPCELL_ROW_109_1328 VDD VSS WELLTAP
X_12800_ _18393_/Q _12947_/A _13021_/B VDD VSS _12931_/D XNOR3X1
XFILLER_55_460 VDD VSS FILLER4
XFILLER_56_983 VDD VSS FILLER1
X_10992_ _17958_/Q _10998_/B VDD VSS _10993_/B XNOR2X1
X_13780_ _13853_/A _13853_/B VDD VSS _13823_/A NOR2X1
XFILLER_28_696 VDD VSS FILLER1
XFILLER_76_1024 VSS VDD FILLER2
X_12731_ _18287_/Q _14235_/B VDD VSS _12849_/A NAND2X1
XFILLER_31_806 VDD VSS DECAPHV8
XFILLER_76_1068 VDD VSS FILLER1
XFILLER_76_1079 VDD VSS FILLER1
XTAP_TAPCELL_ROW_53_650 VDD VSS WELLTAP
X_12662_ _12760_/A _14118_/B _12756_/C VDD VSS _14119_/B AOI21BX1
X_15450_ _18867_/Q _15455_/C VDD VSS _15451_/B XOR2X1
XFILLER_15_379 VSS VDD FILLER2
XFILLER_35_96 VDD VSS FILLER1
XFILLER_42_165 VDD VSS FILLER1
XFILLER_42_187 VSS VDD FILLER2
XTAP_TAPCELL_ROW_81_992 VDD VSS WELLTAP
X_11613_ _11678_/A _11678_/B _11678_/C VDD VSS _11742_/A AOI21X1
X_14401_ _14431_/A _14401_/B _14401_/C VDD VSS _18428_/D NOR3X1
XFILLER_129_716 VDD VSS DECAPHV8
XTAP_TAPCELL_ROW_6_89 VDD VSS WELLTAP
X_12593_ _18442_/Q _12593_/B _12593_/C VDD VSS _14445_/B XNOR3X1
X_17120_ _18019_/Q _17124_/B VDD VSS _17122_/C XOR2X1
X_15381_ _16452_/A _16582_/A VDD VSS _15382_/B XNOR2X1
X_11544_ _11544_/A _11544_/B _11544_/C _11752_/A VDD VSS _11623_/B OAOI211X1
X_14332_ _14332_/A _14332_/B _14332_/C VDD VSS _18370_/D NOR3X1
XFILLER_7_556 VSS VDD FILLER2
X_11475_ _11531_/A _11475_/B _11475_/C VDD VSS _11544_/A OA21X2
X_17051_ _18006_/Q _17055_/B VDD VSS _17054_/B XNOR2X1
X_14263_ _14269_/A _14263_/B VDD VSS _18312_/D NOR2X1
XTAP_TAPCELL_ROW_133_1613 VDD VSS WELLTAP
X_10426_ _10516_/A _10608_/B VDD VSS _17882_/D NOR2X1
X_13214_ _14096_/B _14096_/C _18161_/Q VDD VSS _13216_/B AOI21X1
X_16002_ _18038_/Q _18648_/Q _16002_/C _16002_/D VDD VSS _16004_/C AOAI211X1
XFILLER_100_1055 VDD VSS FILLER4
XFILLER_100_1066 VSS VDD FILLER2
XFILLER_124_421 VDD VSS FILLER1
X_14194_ _14217_/A _14194_/B VDD VSS _18251_/D NOR2X1
X_10357_ _17848_/Q _10357_/B _10357_/C VDD VSS _10551_/C XNOR3X1
X_13145_ _13151_/A _13151_/B _13249_/C VDD VSS _14487_/B XNOR3X1
XFILLER_97_338 VDD VSS FILLER4
X_10288_ _10475_/C _10295_/B _10295_/C VDD VSS _10480_/A OAI21X1
X_13076_ _13076_/A _13076_/B _13076_/C _13076_/D VDD VSS _14240_/B OAOI211X1
X_17953_ _17982_/CK _17953_/D _17953_/Q VDD VSS DFFQX1
X_12027_ _12137_/B _12028_/C _18176_/Q VDD VSS _12029_/C AOI21X1
X_16904_ _16907_/B _16906_/B wire30/Y VDD VSS _16906_/C OAI21X1
XFILLER_120_682 VDD VSS DECAPHV8
X_17884_ _17913_/CK _17884_/D _17884_/Q VDD VSS DFFQX1
XFILLER_19_641 VDD VSS DECAPHV8
XFILLER_54_909 VSS VDD FILLER2
XFILLER_76_81 VDD VSS DECAPHV32
X_16835_ _18923_/Q _16840_/B VDD VSS _16837_/C XOR2X1
XFILLER_20_1034 VDD VSS FILLER4
XFILLER_81_728 VSS VDD FILLER2
X_16766_ _16486_/B _16877_/B _16800_/A VDD VSS _16775_/C MUXI2X1
X_13978_ _18945_/Q _13981_/B VDD VSS _13980_/B XNOR2X1
XFILLER_0_1128 VDD VSS FILLER4
XFILLER_19_696 VSS VDD FILLER2
XFILLER_46_482 VDD VSS DECAPHV16
XFILLER_94_1135 VDD VSS FILLER1
X_12929_ _18446_/Q _13036_/B _13036_/C VDD VSS _13260_/A MIN3X1
X_18505_ _18505_/CK _18505_/D _18505_/Q VDD VSS DFFQX1
X_16697_ _16783_/A _16697_/B _16697_/C _16697_/D VDD VSS _16697_/Y OAI211X1
X_15717_ _18888_/Q _15792_/D _15752_/C _17013_/A VDD VSS _18888_/D AO22X2
X_18436_ _18436_/CK _18436_/D _18436_/Q VDD VSS DFFQX1
XFILLER_15_880 VDD VSS FILLER1
XFILLER_21_305 VSS VDD FILLER2
XFILLER_34_688 VDD VSS DECAPHV8
X_15648_ _15648_/A _15648_/B _15648_/C _15685_/A VDD VSS _15649_/C AOI211X1
XTAP_TAPCELL_ROW_99_1210 VDD VSS WELLTAP
X_18367_ _18368_/CK _18367_/D _18367_/Q VDD VSS DFFQX1
X_15579_ _15669_/A _16991_/A _15579_/C VDD VSS _18875_/D OAI21X1
X_18298_ _18431_/CK _18298_/D _18298_/Q VDD VSS DFFQX1
X_17318_ _19020_/Q _17319_/B _17318_/C VDD VSS _17319_/C OAI21X1
XFILLER_119_248 VSS VDD FILLER2
XFILLER_31_1130 VSS VDD FILLER2
XTAP_TAPCELL_ROW_31_388 VDD VSS WELLTAP
X_17249_ _19005_/Q _19006_/Q _17316_/B VDD VSS _17259_/D OA21X2
XFILLER_128_771 VDD VSS FILLER4
XFILLER_128_793 VSS VDD FILLER2
XFILLER_115_443 VDD VSS FILLER4
X_08953_ _08954_/C _17514_/A _08953_/C VDD VSS _17750_/D AND3BX1
XFILLER_102_137 VSS VDD FILLER2
XFILLER_99_1013 VDD VSS FILLER1
X_08884_ _17731_/Q _18520_/Q VDD VSS _17536_/A NAND2X1
XFILLER_56_235 VDD VSS FILLER4
XFILLER_57_747 VDD VSS DECAPHV16
XFILLER_38_983 VDD VSS DECAPHV8
Xclkbuf_leaf_11_clk_fs_regs clkbuf_leaf_9_clk_fs_regs/A VDD VSS _18959_/CK BUFX12
XTAP_TAPCELL_ROW_39_488 VDD VSS WELLTAP
X_09505_ _09530_/C _09505_/B VDD VSS _17478_/B XNOR2X1
XFILLER_40_603 VDD VSS FILLER1
XFILLER_80_750 VDD VSS FILLER1
X_09436_ _09437_/A _09437_/B _09437_/C VDD VSS _09438_/B NOR3X1
XFILLER_24_154 VDD VSS DECAPHV16
XFILLER_53_997 VDD VSS DECAPHV8
XTAP_TAPCELL_ROW_104_1269 VDD VSS WELLTAP
XFILLER_21_850 VDD VSS DECAPHV16
XTAP_TAPCELL_ROW_50_620 VDD VSS WELLTAP
X_09367_ _17646_/Q _17439_/B VDD VSS _09369_/C XNOR2X1
Xclkbuf_leaf_14__002_ clkbuf_leaf_9__002_/A VDD VSS _18199_/CK BUFX12
XFILLER_123_1022 VDD VSS FILLER1
XFILLER_36_1096 VDD VSS FILLER1
X_09298_ _09296_/Y _09301_/B _17434_/A VDD VSS _17766_/D AND3BX1
XFILLER_107_933 VDD VSS DECAPHV8
XFILLER_119_760 VSS VDD FILLER2
XFILLER_21_32 VSS VDD FILLER2
Xclkbuf_leaf_29__002_ clkload27/A VDD VSS _18408_/CK BUFX12
XFILLER_106_421 VDD VSS DECAPHV8
X_11260_ _11349_/B _11281_/B _11281_/C VDD VSS _11275_/A OAI21X1
XFILLER_106_443 VDD VSS FILLER1
XFILLER_79_305 VDD VSS FILLER4
X_10211_ _10216_/A _10216_/B VDD VSS _10395_/A NOR2X1
X_11191_ _17996_/Q _11192_/B VDD VSS _11196_/C NAND2X1
XFILLER_0_710 VDD VSS DECAPHV8
XFILLER_121_424 VDD VSS FILLER1
XTAP_TAPCELL_ROW_115_1398 VDD VSS WELLTAP
X_10142_ _10268_/A _10333_/B VDD VSS _17844_/D NOR2X1
XFILLER_121_446 VSS VDD FILLER2
XFILLER_121_468 VDD VSS DECAPHV8
X_10073_ _10075_/C _10075_/D VDD VSS _10262_/B XNOR2X1
X_14950_ _15093_/A _14950_/B VDD VSS _18610_/D NOR2X1
XFILLER_43_1034 VSS VDD FILLER2
XFILLER_102_693 VDD VSS FILLER4
XTAP_TAPCELL_ROW_58_720 VDD VSS WELLTAP
X_14881_ _18595_/Q _18627_/Q _14881_/C VDD VSS _14889_/A MIN3X1
X_13901_ _13901_/A _14462_/B _13901_/C _13901_/D VDD VSS _13917_/B AOAI211X1
XFILLER_28_460 VDD VSS FILLER1
XFILLER_29_961 VDD VSS FILLER1
XFILLER_46_40 VDD VSS FILLER4
XFILLER_78_1108 VDD VSS FILLER1
XFILLER_90_503 VDD VSS DECAPHV8
XFILLER_90_514 VDD VSS FILLER4
X_16620_ _16620_/A _16620_/B _16620_/C _16620_/D VDD VSS _16621_/C OAOI211X1
X_13832_ _13861_/A _14433_/B _14433_/C VDD VSS _13860_/C NOR3X1
XFILLER_28_493 VSS VDD FILLER2
XFILLER_29_994 VDD VSS FILLER1
XFILLER_46_73 VDD VSS FILLER4
XFILLER_56_780 VDD VSS DECAPHV8
XFILLER_90_525 VDD VSS FILLER1
XTAP_TAPCELL_ROW_83_1011 VDD VSS WELLTAP
X_16551_ _16551_/A _16551_/B VDD VSS _16579_/C NOR2X1
X_13763_ _18351_/Q _14310_/A _14310_/B VDD VSS _13806_/B NOR3X1
XFILLER_15_132 VDD VSS DECAPHV8
XFILLER_43_430 VSS VDD FILLER2
XFILLER_55_290 VDD VSS FILLER1
X_10975_ _17954_/Q _10976_/B VDD VSS _10977_/B NAND2BX1
X_12714_ _12714_/A _12714_/B _12714_/C VDD VSS _12931_/A OAI21X1
X_15502_ _16731_/A _15613_/B _15502_/C VDD VSS _15510_/B OAI21X1
XFILLER_15_176 VSS VDD FILLER2
XFILLER_16_688 VDD VSS FILLER4
X_16482_ _16413_/B _16481_/Y _16630_/A VDD VSS _16632_/B MUXI2X1
X_13694_ _13705_/A _13705_/B _13695_/D _13705_/E VDD VSS _14309_/B OA211X2
XFILLER_30_113 VSS VDD FILLER2
XFILLER_54_1130 VDD VSS FILLER4
X_12645_ _12846_/A _12846_/B _12846_/D VDD VSS _12687_/B OAI21X1
X_18221_ _18247_/CK _18221_/D _18221_/Q VDD VSS DFFQX1
X_15433_ _15431_/Y _15432_/Y _15801_/B VDD VSS _15433_/Y MUXI2X1
XFILLER_12_850 VDD VSS DECAPHV8
XFILLER_15_1114 VSS VDD FILLER2
XFILLER_50_1005 VDD VSS DECAPHV8
X_12576_ _18365_/Q _12940_/A _12940_/B VDD VSS _12614_/C XNOR3X1
X_18152_ _18152_/CK _18152_/D _18152_/Q VDD VSS DFFQX1
X_15364_ _18905_/Q wire35/Y _15364_/C VDD VSS _15415_/A AOI21X1
XFILLER_129_557 VDD VSS FILLER1
XFILLER_12_894 VDD VSS FILLER4
X_11527_ _18248_/Q VDD VSS _14219_/A INVX1
X_18083_ _18963_/CK _18083_/D _18083_/Q VDD VSS DFFQX1
X_17103_ _17103_/A _17103_/B _17107_/A _17103_/D VDD VSS _17107_/B AOI211X1
X_14315_ _14346_/A _14315_/B VDD VSS _18355_/D NOR2X1
XFILLER_116_207 VDD VSS FILLER4
XFILLER_116_218 VSS VDD FILLER2
XFILLER_117_719 VDD VSS FILLER1
XFILLER_7_375 VDD VSS DECAPHV32
X_17034_ _18003_/Q _17040_/B VDD VSS _17038_/A XOR2X1
X_15295_ _15295_/A _18036_/Q VDD VSS _18835_/D AND2X1
X_11458_ _18221_/Q VDD VSS _11460_/A INVX1
X_14246_ _14372_/A _14246_/B VDD VSS _18296_/D AND2X1
XTAP_TAPCELL_ROW_94_1151 VDD VSS WELLTAP
X_10409_ _10593_/B _10593_/C VDD VSS _10590_/B NAND2X1
X_11389_ _18115_/Q _11389_/B _11389_/C VDD VSS _11399_/B XNOR3X1
X_14177_ _14236_/A _14177_/B _14177_/C VDD VSS _18235_/D NOR3X1
XFILLER_113_958 VDD VSS FILLER1
X_13128_ _18292_/Q _13128_/B _13200_/C VDD VSS _13287_/B XNOR3X1
XFILLER_61_1101 VDD VSS FILLER1
XFILLER_97_157 VDD VSS FILLER1
X_18985_ _18985_/CK _18985_/D _18985_/Q VDD VSS DFFQX1
XFILLER_39_736 VDD VSS FILLER1
XFILLER_79_883 VSS VDD FILLER2
XFILLER_87_80 VDD VSS DECAPHV8
X_13059_ _14363_/A _14363_/B _14363_/C _13059_/D VDD VSS _13276_/A OAOI211X1
X_17936_ _17941_/CK _17936_/D _17936_/Q VDD VSS DFFQX1
XFILLER_27_909 VDD VSS FILLER1
XFILLER_39_758 VDD VSS DECAPHV16
XFILLER_78_393 VDD VSS FILLER1
X_17867_ _17867_/CK _17867_/D _17867_/Q VDD VSS DFFQX1
XFILLER_38_257 VSS VDD FILLER2
XFILLER_53_205 VSS VDD FILLER2
XFILLER_94_897 VSS VDD FILLER2
X_16818_ _16866_/A _16841_/A VDD VSS _16823_/A NOR2X1
XFILLER_4_1072 VDD VSS DECAPHV32
XFILLER_81_547 VDD VSS FILLER4
X_17798_ _19043_/CK _17798_/D _17798_/Q VDD VSS DFFQX1
XFILLER_62_750 VDD VSS DECAPHV8
XTAP_TAPCELL_ROW_36_447 VDD VSS WELLTAP
X_16749_ _18804_/Q _18750_/Q VDD VSS _16750_/B XNOR2X1
XFILLER_35_997 VDD VSS FILLER1
XTAP_TAPCELL_ROW_64_789 VDD VSS WELLTAP
XFILLER_107_1017 VDD VSS FILLER4
X_09221_ _09215_/A _09221_/B VDD VSS _09239_/B NAND2BX1
X_18419_ _18470_/CK _18419_/D _18419_/Q VDD VSS DFFQX1
X_09152_ _17669_/Q _17463_/B VDD VSS _09159_/A NOR2X1
X_09083_ _09083_/A _09083_/B VDD VSS _17321_/B XOR2X1
XFILLER_131_700 VSS VDD FILLER2
XTAP_TAPCELL_ROW_8_117 VDD VSS WELLTAP
XFILLER_131_733 VDD VSS FILLER4
XFILLER_88_113 VDD VSS DECAPHV8
XFILLER_89_625 VDD VSS DECAPHV8
XFILLER_103_468 VDD VSS DECAPHV8
XFILLER_89_669 VDD VSS FILLER1
X_09985_ _10185_/C VDD VSS _10203_/D INVX1
X_08936_ _17747_/Q _18536_/Q VDD VSS _08937_/B XOR2X1
XFILLER_57_533 VSS VDD FILLER2
XFILLER_72_514 VSS VDD FILLER2
XFILLER_72_547 VDD VSS DECAPHV8
XFILLER_16_32 VDD VSS DECAPHV8
XFILLER_26_953 VDD VSS FILLER1
XFILLER_38_1114 VSS VDD FILLER2
XFILLER_25_463 VSS VDD FILLER2
XFILLER_41_923 VSS VDD FILLER2
XFILLER_53_794 VDD VSS FILLER1
X_10760_ _17911_/Q VDD VSS _10761_/A INVX1
X_09419_ _09396_/A _09419_/B VDD VSS _09420_/B NAND2BX1
X_10691_ _17899_/Q _10691_/B _10691_/C VDD VSS _10695_/B XNOR3X1
XFILLER_9_618 VDD VSS DECAPHV32
X_12430_ _12430_/A _12430_/B _12430_/C _12430_/D VDD VSS _12525_/B AOAI211X1
XFILLER_12_179 VSS VDD FILLER2
XTAP_TAPCELL_ROW_117_1427 VDD VSS WELLTAP
XTAP_TAPCELL_ROW_3_57 VDD VSS WELLTAP
X_12361_ _18128_/Q _12361_/B _12361_/C VDD VSS _12446_/D XNOR3X1
X_14100_ _14129_/A _14100_/B VDD VSS _18165_/D NOR2X1
XFILLER_107_741 VSS VDD FILLER2
XFILLER_4_323 VSS VDD FILLER2
XFILLER_5_835 VSS VDD FILLER2
X_11312_ _18966_/Q _18087_/Q VDD VSS _11314_/D NAND2X1
X_12292_ _18414_/Q _12292_/B _12292_/C VDD VSS _12490_/B MIN3X1
X_15080_ _15082_/C _15080_/B _15082_/B _15080_/D VDD VSS _18638_/D OAOI211X1
XFILLER_106_0 VDD VSS DECAPHV32
XFILLER_106_251 VDD VSS FILLER4
XFILLER_10_1066 VSS VDD FILLER2
X_11243_ _11278_/A VDD VSS _11263_/A INVX1
X_14031_ _14107_/A _18979_/Q VDD VSS _18100_/D AND2X1
XFILLER_10_1088 VDD VSS FILLER1
XFILLER_134_571 VSS VDD FILLER2
XFILLER_84_1134 VSS VDD FILLER2
XFILLER_121_221 VDD VSS DECAPHV16
XFILLER_122_744 VDD VSS DECAPHV8
X_11174_ _11174_/A _11174_/B VDD VSS _11175_/C NOR2X1
X_10125_ _09935_/Y _10317_/B _10317_/C VDD VSS _17842_/D AND3BX1
X_18770_ _18852_/CK _18770_/D _18770_/Q VDD VSS DFFQX1
X_15982_ _15982_/A _15982_/B _16802_/A VDD VSS _15983_/C OAI21X1
XFILLER_94_138 VDD VSS FILLER1
X_10056_ _17808_/Q _10062_/B VDD VSS _10060_/C XOR2X1
X_17721_ _17722_/CK _17721_/D _17721_/Q VDD VSS DFFQX1
X_14933_ _18607_/Q _18639_/Q VDD VSS _14937_/A XOR2X1
XFILLER_36_717 VDD VSS DECAPHV8
XFILLER_76_886 VDD VSS FILLER4
XTAP_TAPCELL_ROW_128_1556 VDD VSS WELLTAP
X_17652_ _17716_/CK _17652_/D _17652_/Q VDD VSS DFFQX1
XFILLER_17_920 VDD VSS FILLER4
X_16603_ _16934_/A _16678_/A VDD VSS _16635_/A NAND2X1
X_14864_ _18592_/Q _18624_/Q VDD VSS _14866_/B XOR2X1
XFILLER_16_430 VDD VSS DECAPHV8
XFILLER_17_942 VDD VSS FILLER4
X_17583_ _17680_/CK _17583_/D _17583_/Q VDD VSS DFFQX1
X_14795_ _18608_/Q VDD VSS _14944_/A INVX1
X_13815_ _13815_/A _14431_/B _14431_/C VDD VSS _13816_/D NOR3X1
XTAP_TAPCELL_ROW_33_417 VDD VSS WELLTAP
X_10958_ _10960_/C _10958_/B VDD VSS _11099_/B XNOR2X1
X_16534_ _18662_/Q VDD VSS _16535_/B INVX1
X_13746_ _18376_/Q _13746_/B VDD VSS _13748_/C _13746_/C NAND3X1
XFILLER_43_282 VDD VSS DECAPHV16
XTAP_TAPCELL_ROW_61_748 VDD VSS WELLTAP
X_16465_ _16442_/B _16465_/B VDD VSS _16468_/C NOR2BX1
X_13677_ _14371_/B _14371_/C _13678_/A VDD VSS _13738_/B OAI21X1
X_10889_ _11020_/B VDD VSS _11025_/B INVX1
X_12628_ _18260_/Q _14204_/B VDD VSS _12629_/D _14204_/C NAND3X1
X_18204_ _18252_/CK _18204_/D _18204_/Q VDD VSS DFFQX1
X_15416_ _16588_/A _15444_/B VDD VSS _15417_/C NOR2X1
XFILLER_106_1072 VDD VSS DECAPHV8
XTAP_TAPCELL_ROW_13_174 VDD VSS WELLTAP
X_16396_ _16396_/A _16396_/B _16396_/C _16396_/D VDD VSS _16440_/C AOI31X1
X_12559_ _12566_/A _14060_/B _12678_/C VDD VSS _14061_/B AO21X2
X_18135_ _18249_/CK _18135_/D _18135_/Q VDD VSS DFFQX1
X_15347_ _18859_/Q _15793_/C _15793_/B VDD VSS _15509_/B AOI21X1
XFILLER_8_695 VSS VDD FILLER2
X_18066_ _18066_/CK _18066_/D _18066_/Q VDD VSS DFFQX1
X_15278_ _15307_/A _18846_/Q VDD VSS _18819_/D AND2X1
X_17017_ _17017_/A _17017_/B _17017_/C VDD VSS _18959_/D OAI21X1
X_14229_ _14236_/A _14230_/B _14229_/C VDD VSS _18282_/D NOR3X1
XFILLER_112_276 VDD VSS DECAPHV8
XFILLER_21_0 VDD VSS DECAPHV32
X_09770_ _17756_/Q _09770_/B _09770_/C VDD VSS _09772_/A MIN3X1
X_18968_ _18971_/CK _18968_/D _18968_/Q VDD VSS DFFQX1
XFILLER_113_1021 VSS VDD FILLER2
XTAP_TAPCELL_ROW_69_848 VDD VSS WELLTAP
X_17919_ _17972_/CK _17919_/D _17919_/Q VDD VSS DFFQX1
XFILLER_67_864 VSS VDD FILLER2
X_18899_ _18961_/CK _18899_/D _18899_/Q VDD VSS DFFQX1
XFILLER_54_514 VSS VDD FILLER2
XFILLER_66_374 VDD VSS DECAPHV8
XFILLER_96_1027 VSS VDD FILLER2
XFILLER_81_344 VSS VDD FILLER2
XFILLER_93_193 VSS VDD FILLER2
XFILLER_34_260 VSS VDD FILLER2
XFILLER_81_388 VDD VSS FILLER4
XFILLER_22_444 VDD VSS DECAPHV8
XFILLER_34_282 VDD VSS FILLER4
XFILLER_50_720 VDD VSS DECAPHV8
XTAP_TAPCELL_ROW_101_1228 VDD VSS WELLTAP
X_09204_ _17736_/Q _17704_/Q VDD VSS _09207_/A XNOR2X1
XFILLER_10_639 VDD VSS DECAPHV32
X_09135_ _09159_/B _09135_/B VDD VSS _17430_/B OR2X2
XFILLER_136_858 VDD VSS DECAPHV32
X_09066_ _09103_/C _09066_/B VDD VSS _09100_/A XNOR2X1
XFILLER_135_346 VDD VSS DECAPHV16
XFILLER_104_700 VDD VSS FILLER1
XFILLER_78_49 VDD VSS DECAPHV32
XFILLER_103_221 VSS VDD FILLER2
XTAP_TAPCELL_ROW_112_1357 VDD VSS WELLTAP
XTAP_TAPCELL_ROW_112_1368 VDD VSS WELLTAP
XFILLER_104_777 VDD VSS DECAPHV8
XFILLER_131_563 VDD VSS FILLER1
XFILLER_134_44 VSS VDD FILLER2
X_09968_ _09935_/Y _10179_/B _10179_/C VDD VSS _17822_/D AND3BX1
XFILLER_103_298 VDD VSS FILLER4
XFILLER_76_138 VDD VSS FILLER1
X_08919_ _17743_/Q _18532_/Q VDD VSS _08922_/C NOR2X1
XFILLER_100_972 VDD VSS FILLER4
XFILLER_40_1015 VSS VDD FILLER2
XFILLER_58_864 VSS VDD FILLER2
X_09899_ _17789_/Q _09899_/B VDD VSS _09914_/A _09899_/C NAND3X1
X_11930_ _11930_/A _14167_/B _11931_/C VDD VSS _14168_/B AOI21BX1
XFILLER_72_311 VDD VSS FILLER4
XFILLER_27_86 VDD VSS FILLER4
XFILLER_45_547 VDD VSS FILLER4
XFILLER_73_867 VDD VSS DECAPHV8
X_11861_ _11861_/A _11861_/B _11870_/C VDD VSS _12026_/B XNOR3X1
XFILLER_26_761 VDD VSS FILLER1
XFILLER_72_388 VDD VSS FILLER4
X_10812_ _17923_/Q _10816_/B VDD VSS _10813_/B XNOR2X1
X_11792_ _18975_/Q _18096_/Q VDD VSS _11954_/D NOR2X1
X_14580_ _14580_/A _14729_/A _14580_/C VDD VSS _14583_/C MIN3X1
X_13600_ _13605_/A _13605_/B _13605_/D _13605_/C VDD VSS _14427_/C OAI211X1
XFILLER_25_282 VDD VSS FILLER4
XFILLER_41_742 VSS VDD FILLER2
XTAP_TAPCELL_ROW_123_1497 VDD VSS WELLTAP
X_10743_ _17908_/Q _10743_/B VDD VSS _10747_/A NOR2BX1
X_13531_ _18399_/Q _14369_/B VDD VSS _13591_/A NAND2X1
XFILLER_14_989 VDD VSS FILLER1
X_16250_ _16250_/A _16250_/B _16250_/C _16250_/D VDD VSS _16280_/C AO211X2
XFILLER_13_499 VDD VSS FILLER4
XFILLER_40_274 VDD VSS FILLER1
XFILLER_40_285 VSS VDD FILLER2
X_10674_ _17897_/Q _10680_/A _10680_/B VDD VSS _10676_/C XNOR3X1
X_15201_ _15281_/A _18770_/Q VDD VSS _18743_/D AND2X1
X_13462_ _18399_/Q _14369_/B VDD VSS _13547_/A AND2X1
XTAP_TAPCELL_ROW_10_133 VDD VSS WELLTAP
X_12413_ _12421_/A _14261_/B _12421_/C VDD VSS _14262_/B OAI21X1
X_16181_ _16554_/A _16181_/B _16181_/C VDD VSS _16181_/Y AOI21X1
X_13393_ _13493_/A _13493_/B VDD VSS _14212_/B XNOR2X1
XFILLER_127_858 VDD VSS FILLER4
XTAP_TAPCELL_ROW_10_144 VDD VSS WELLTAP
X_12344_ _12344_/A _14088_/B VDD VSS _12366_/A OR2X2
X_15132_ _15299_/A _18702_/Q VDD VSS _18675_/D AND2X1
XFILLER_4_142 VDD VSS DECAPHV32
XFILLER_5_654 VDD VSS DECAPHV32
X_15063_ _18635_/Q _19013_/Q VDD VSS _15065_/D XNOR2X1
XFILLER_135_880 VDD VSS FILLER1
XTAP_TAPCELL_ROW_91_1110 VDD VSS WELLTAP
X_12275_ _12403_/A _12403_/B _12292_/C VDD VSS _14413_/B XNOR3X1
X_14014_ _14310_/C _18962_/Q VDD VSS _18083_/D AND2X1
XFILLER_49_1062 VDD VSS FILLER1
X_11226_ _18962_/Q _18083_/Q VDD VSS _11247_/A NOR2X1
XFILLER_68_628 VDD VSS FILLER4
X_11157_ _11161_/C _11157_/B VDD VSS _17098_/A XNOR2X1
X_18822_ _18850_/CK _18822_/D _18822_/Q VDD VSS DFFQX1
XFILLER_67_149 VSS VDD FILLER2
XFILLER_95_425 VSS VDD FILLER2
XFILLER_95_447 VDD VSS FILLER1
X_10108_ _10109_/B _10119_/B _17815_/Q VDD VSS _10110_/C AOI21X1
X_18753_ _18780_/CK _18753_/D _18753_/Q VDD VSS DFFQX1
XFILLER_49_864 VDD VSS FILLER4
XTAP_TAPCELL_ROW_66_807 VDD VSS WELLTAP
X_11088_ _17976_/Q _11089_/B VDD VSS _11094_/C NAND2X1
X_17704_ _17706_/CK _17704_/D _17704_/Q VDD VSS DFFQX1
X_15965_ _15965_/A VDD VSS _15967_/C INVX1
XFILLER_36_514 VDD VSS FILLER1
XFILLER_63_300 VSS VDD FILLER2
XFILLER_76_672 VDD VSS FILLER4
XFILLER_91_620 VSS VDD FILLER2
X_10039_ _10046_/A _10235_/A VDD VSS _10044_/A NAND2X1
X_18684_ _18846_/CK _18684_/D _18684_/Q VDD VSS DFFQX1
X_15896_ _15897_/A _15911_/B _15911_/C _15911_/D VDD VSS _15982_/A AND4X2
X_14916_ _14917_/A _14917_/B _14917_/D _14917_/C VDD VSS _14919_/C AOI211X1
XFILLER_63_355 VDD VSS FILLER1
XFILLER_84_81 VDD VSS DECAPHV32
XTAP_TAPCELL_ROW_18_233 VDD VSS WELLTAP
XTAP_TAPCELL_ROW_89_1083 VDD VSS WELLTAP
X_17635_ _17701_/CK _17635_/D _17635_/Q VDD VSS DFFQX1
X_14847_ _14903_/A _14847_/B VDD VSS _18588_/D NOR2X1
XFILLER_16_260 VDD VSS DECAPHV16
XFILLER_56_1011 VDD VSS FILLER4
XTAP_TAPCELL_ROW_46_575 VDD VSS WELLTAP
X_17566_ _19024_/CK _17566_/D _17566_/Q VDD VSS DFFQX1
XFILLER_51_539 VSS VDD FILLER2
XFILLER_56_1033 VDD VSS FILLER1
XFILLER_56_1055 VDD VSS FILLER1
X_16517_ _16535_/C _16517_/B _16517_/C _16731_/A VDD VSS _16518_/D AOI211X1
X_14778_ _14780_/A _14780_/B _14778_/C VDD VSS _18573_/D AOI21X1
XFILLER_20_915 VDD VSS FILLER1
XFILLER_32_753 VDD VSS FILLER1
XFILLER_32_775 VDD VSS DECAPHV8
X_17497_ _17499_/A _17497_/B VDD VSS _17701_/D NOR2X1
X_13729_ _18455_/Q _13792_/A _13792_/B VDD VSS _13730_/D XNOR3X1
X_16448_ _16459_/A _16448_/B VDD VSS _16449_/C NOR2X1
X_16379_ _18908_/Q _16383_/B VDD VSS _16381_/C XNOR2X1
XFILLER_129_184 VSS VDD FILLER2
XFILLER_69_0 VDD VSS DECAPHV32
X_18118_ _18988_/CK _18118_/D _18118_/Q VDD VSS DFFQX1
X_18049_ _18846_/CK _18049_/D _18049_/Q VDD VSS DFFQX1
XFILLER_113_530 VSS VDD FILLER2
XFILLER_28_1113 VDD VSS DECAPHV16
XFILLER_28_1135 VDD VSS FILLER1
XFILLER_63_1015 VDD VSS FILLER1
XFILLER_115_1105 VDD VSS DECAPHV8
XFILLER_59_606 VSS VDD FILLER2
XFILLER_63_1026 VDD VSS DECAPHV8
XFILLER_87_915 VSS VDD FILLER2
XFILLER_98_263 VDD VSS FILLER4
X_09822_ _09829_/C _09822_/B VDD VSS _09969_/B OR2X2
XFILLER_100_235 VSS VDD FILLER2
XFILLER_101_736 VDD VSS FILLER1
XFILLER_63_1059 VDD VSS FILLER1
X_09753_ _17628_/Q _09764_/A VDD VSS _09754_/B XNOR2X1
XFILLER_66_160 VSS VDD FILLER2
XFILLER_67_672 VDD VSS FILLER1
X_09684_ _17593_/Q _17383_/B VDD VSS _09712_/A NAND2BX1
XFILLER_27_547 VDD VSS FILLER1
XFILLER_54_344 VDD VSS FILLER1
XFILLER_66_182 VDD VSS FILLER4
XFILLER_82_642 VDD VSS FILLER4
XFILLER_82_686 VDD VSS FILLER4
XFILLER_81_196 VDD VSS DECAPHV8
XFILLER_22_230 VSS VDD FILLER2
XFILLER_70_1008 VDD VSS DECAPHV8
Xfanout45 _17523_/A VDD VSS _17514_/A BUFX3
Xfanout56 hold96/A VDD VSS _17534_/A BUFX3
XFILLER_10_403 VDD VSS FILLER1
XFILLER_50_572 VDD VSS FILLER1
Xfanout67 _17525_/B VDD VSS _15318_/A BUFX3
Xfanout78 _15250_/A VDD VSS _15304_/A BUFX3
Xfanout89 hold96/A VDD VSS _14377_/A BUFX3
XFILLER_136_633 VDD VSS DECAPHV8
X_09118_ _09115_/A _09118_/B _09118_/C VDD VSS _09143_/A AOI2B1X1
XFILLER_129_88 VDD VSS FILLER4
X_10390_ _10390_/A _10390_/B _10390_/C VDD VSS _10400_/C XNOR3X1
XFILLER_135_176 VDD VSS DECAPHV8
XFILLER_2_602 VSS VDD FILLER2
X_09049_ _17566_/Q _17354_/B VDD VSS _09083_/A NOR2BX1
XFILLER_81_1104 VSS VDD FILLER2
XTAP_TAPCELL_ROW_0_14 VDD VSS WELLTAP
X_12060_ _18126_/Q _12060_/B _12157_/D VDD VSS _12239_/C XNOR3X1
XFILLER_77_414 VDD VSS DECAPHV16
XFILLER_78_937 VDD VSS FILLER4
X_11011_ _11014_/A _11014_/B VDD VSS _11015_/C XNOR2X1
XFILLER_1_189 VDD VSS DECAPHV32
XFILLER_58_661 VDD VSS FILLER1
XFILLER_93_907 VDD VSS DECAPHV8
XFILLER_18_503 VDD VSS DECAPHV8
XFILLER_46_812 VDD VSS FILLER1
XFILLER_92_417 VDD VSS FILLER1
X_12962_ _12962_/A _12962_/B _12962_/C _12962_/D VDD VSS _14207_/B AOAI211X1
X_15750_ _18892_/Q _15750_/B VDD VSS _15751_/B XOR2X1
XTAP_TAPCELL_ROW_125_1515 VDD VSS WELLTAP
X_11913_ _18332_/Q _11913_/B _14289_/B VDD VSS _12007_/B MIN3X1
X_12893_ _14065_/B _14065_/C _18133_/Q VDD VSS _13091_/D AOI21X1
X_15681_ _18884_/Q VDD VSS _15693_/A INVX1
X_14701_ _14701_/A _14702_/C _14701_/C VDD VSS _18557_/D AOI21X1
XFILLER_54_40 VDD VSS FILLER4
X_11844_ _18254_/Q VDD VSS _11936_/A INVX1
X_17420_ _17423_/A _17420_/B VDD VSS _17628_/D NOR2X1
X_14632_ _14635_/C _14632_/B VDD VSS _14633_/B XNOR2X1
XFILLER_26_580 VDD VSS FILLER4
XTAP_TAPCELL_ROW_15_203 VDD VSS WELLTAP
XTAP_TAPCELL_ROW_43_534 VDD VSS WELLTAP
XFILLER_14_764 VSS VDD FILLER2
XTAP_TAPCELL_ROW_71_865 VDD VSS WELLTAP
XTAP_TAPCELL_ROW_71_876 VDD VSS WELLTAP
X_11775_ _11850_/A _14109_/B _11845_/C VDD VSS _14110_/B AOI21BX1
X_17351_ _17355_/A _17351_/B VDD VSS _19050_/D NOR2X1
X_14563_ _14564_/C _17229_/A _14563_/C VDD VSS _18527_/D AND3BX1
X_10726_ _11148_/A _10857_/B VDD VSS _17931_/D AND2X1
X_17282_ _19013_/Q _17315_/B VDD VSS _17283_/B XNOR2X1
X_16302_ _16459_/A _16302_/B VDD VSS _16303_/C NAND2X1
X_14494_ _14972_/A _14494_/B _14494_/C VDD VSS _18507_/D NOR3X1
X_13514_ _13514_/A _13514_/B _13514_/C VDD VSS _13515_/C NOR3X1
XTAP_TAPCELL_ROW_23_291 VDD VSS WELLTAP
X_10657_ _10657_/A _10657_/B _10657_/C VDD VSS _10661_/C MIN3X1
X_19021_ _19024_/CK _19021_/D _19021_/Q VDD VSS DFFQX1
X_16233_ _18905_/Q VDD VSS _16273_/A INVX1
X_13445_ _18425_/Q VDD VSS _13459_/A INVX1
XFILLER_9_278 VDD VSS FILLER1
Xclkload26 clkload26/A VDD VSS clkload26/Y INVX16
Xclkload15 _18961_/CK VDD VSS clkload15/Y INVX2
XTAP_TAPCELL_ROW_136_1655 VDD VSS WELLTAP
XTAP_TAPCELL_ROW_136_1666 VDD VSS WELLTAP
X_10588_ _10711_/B _10588_/B _10588_/C _10588_/D VDD VSS _10594_/B AOAI211X1
Xclkload59 _18505_/CK VDD VSS clkload59/Y INVX2
Xclkload48 _18252_/CK VDD VSS clkload48/Y INVX4
Xclkload37 _18406_/CK VDD VSS clkload37/Y INVX6
X_16164_ _18787_/Q _18733_/Q VDD VSS _16165_/D NAND2X1
X_13376_ _18346_/Q _14305_/B VDD VSS _13475_/A AND2X1
XFILLER_114_305 VSS VDD FILLER2
XFILLER_6_974 VSS VDD FILLER2
X_12327_ _12328_/B _12328_/C _18205_/Q VDD VSS _12331_/B AOI21X1
X_16095_ _16096_/A _16096_/B _16096_/D _16096_/C VDD VSS _16176_/B AOAI211X1
X_15115_ _15309_/A _18686_/Q VDD VSS _18659_/D AND2X1
X_12258_ _12360_/A _14058_/B _14058_/C VDD VSS _12352_/C NOR3X1
X_15046_ _15048_/A _15048_/B _15046_/C VDD VSS _18631_/D AOI21X1
XFILLER_79_92 VDD VSS FILLER1
X_11209_ _14053_/A _18026_/Q VDD VSS _18026_/D NOR2X1
XFILLER_68_425 VSS VDD FILLER2
X_12189_ _12191_/B _12190_/B _14423_/A VDD VSS _12190_/C OAI21X1
X_18805_ _18805_/CK _18805_/D _18805_/Q VDD VSS DFFQX1
XFILLER_49_650 VDD VSS FILLER1
XFILLER_56_609 VDD VSS FILLER1
XFILLER_68_458 VSS VDD FILLER2
XFILLER_96_789 VDD VSS FILLER1
XTAP_TAPCELL_ROW_79_965 VDD VSS WELLTAP
X_16997_ _16997_/A _17019_/B _17019_/C _18948_/Q VDD VSS _18948_/D AO22X2
XFILLER_110_588 VDD VSS DECAPHV8
XFILLER_95_288 VDD VSS FILLER1
XFILLER_95_80 VDD VSS DECAPHV8
X_18736_ _18844_/CK _18736_/D _18736_/Q VDD VSS DFFQX1
X_15948_ _16456_/A _15948_/B _15948_/C VDD VSS _18897_/D OAI21X1
XFILLER_110_1046 VDD VSS FILLER1
XFILLER_36_333 VDD VSS FILLER1
XFILLER_37_867 VDD VSS FILLER4
X_18667_ _18856_/CK _18667_/D _18667_/Q VDD VSS DFFQX1
XFILLER_110_1068 VDD VSS FILLER1
XFILLER_52_815 VDD VSS DECAPHV8
XFILLER_58_1117 VSS VDD FILLER2
X_17618_ _19045_/CK _17618_/D _17618_/Q VDD VSS DFFQX1
X_15879_ _15877_/Y _15879_/B _18754_/Q _16537_/A VDD VSS _15911_/B AOI2B2X1
X_18598_ _19011_/CK _18598_/D _18598_/Q VDD VSS DFFQX1
X_17549_ _17551_/B _17549_/B VDD VSS _17550_/B XNOR2X1
XFILLER_32_583 VDD VSS FILLER4
Xclkload9 clkload9/A VDD VSS clkload9/Y BUFX12
XFILLER_106_839 VDD VSS FILLER4
XFILLER_117_176 VDD VSS FILLER4
XFILLER_105_338 VSS VDD FILLER2
XFILLER_132_113 VDD VSS DECAPHV16
XFILLER_59_414 VDD VSS DECAPHV8
XFILLER_101_555 VSS VDD FILLER2
XFILLER_47_609 VSS VDD FILLER2
XFILLER_87_789 VDD VSS DECAPHV8
X_09805_ _09812_/A _09920_/A VDD VSS _17791_/D NOR2X1
XFILLER_101_577 VDD VSS DECAPHV8
XFILLER_28_823 VDD VSS FILLER4
XFILLER_74_417 VDD VSS FILLER1
X_09736_ _17595_/Q _17385_/B VDD VSS _09737_/C NOR2X1
XFILLER_67_491 VDD VSS FILLER4
X_09667_ _17689_/Q _17485_/B VDD VSS _09668_/B XNOR2X1
XFILLER_43_804 VSS VDD FILLER2
XFILLER_15_528 VDD VSS FILLER1
XFILLER_43_859 VDD VSS DECAPHV8
X_09598_ _17590_/Q _17379_/B VDD VSS _09620_/A NAND2BX1
XFILLER_23_550 VSS VDD FILLER2
XFILLER_24_32 VDD VSS FILLER4
XFILLER_10_200 VDD VSS FILLER4
XFILLER_11_734 VDD VSS DECAPHV8
XFILLER_23_561 VDD VSS FILLER4
XFILLER_24_65 VDD VSS FILLER1
XFILLER_51_881 VSS VDD FILLER2
XTAP_TAPCELL_ROW_120_1456 VDD VSS WELLTAP
XTAP_TAPCELL_ROW_40_504 VDD VSS WELLTAP
X_11560_ _11560_/A _11637_/B VDD VSS _14050_/B XNOR2X1
XFILLER_10_211 VDD VSS DECAPHV8
XFILLER_11_767 VDD VSS FILLER1
X_10511_ _17870_/Q _10511_/B VDD VSS _10512_/D _10521_/B NAND3X1
XFILLER_11_789 VDD VSS FILLER1
X_11491_ _11558_/A _11558_/B VDD VSS _11614_/B NOR2X1
X_13230_ _18267_/Q _13380_/B _13380_/C VDD VSS _13416_/C XNOR3X1
XFILLER_109_666 VSS VDD FILLER2
XTAP_TAPCELL_ROW_20_261 VDD VSS WELLTAP
X_10442_ _10445_/A _10445_/B VDD VSS _10624_/B XNOR2X1
X_10373_ _10376_/A _10379_/B _10379_/C VDD VSS _10375_/C AND3BX1
X_13161_ _13161_/A _13161_/B _13161_/C _13161_/D VDD VSS _14394_/B OAOI211X1
XFILLER_2_421 VDD VSS DECAPHV32
XFILLER_3_933 VDD VSS DECAPHV32
X_12112_ _12179_/B _12179_/C _12176_/C VDD VSS _12171_/B OAI21X1
X_13092_ _14095_/B _14095_/C _18160_/Q VDD VSS _13094_/C AOI21X1
X_12043_ _18978_/Q _18099_/Q VDD VSS _12161_/A XNOR2X1
Xclkbuf_leaf_15__000_ clkbuf_leaf_9__000_/A VDD VSS _18840_/CK BUFX12
X_16920_ _16973_/A _16920_/B _16920_/C VDD VSS _18930_/D OAI21X1
XTAP_TAPCELL_ROW_131_1585 VDD VSS WELLTAP
XTAP_TAPCELL_ROW_131_1596 VDD VSS WELLTAP
XFILLER_120_853 VDD VSS DECAPHV16
XFILLER_66_907 VSS VDD FILLER2
XFILLER_78_756 VDD VSS DECAPHV16
X_16851_ _16926_/A _16851_/B VDD VSS _16852_/D NOR2X1
XFILLER_120_886 VDD VSS FILLER4
XFILLER_37_108 VDD VSS FILLER1
XFILLER_59_970 VDD VSS DECAPHV8
XFILLER_77_266 VDD VSS FILLER4
XTAP_TAPCELL_ROW_76_935 VDD VSS WELLTAP
X_16782_ _16782_/A _16782_/B _16782_/C _16782_/D VDD VSS _16783_/E AOAI211X1
X_15802_ _15864_/B _15802_/B VDD VSS _16120_/A NOR2BX1
XFILLER_18_344 VSS VDD FILLER2
XFILLER_46_631 VDD VSS DECAPHV8
X_18521_ clkload6/A _18521_/D _18521_/Q VDD VSS DFFQX1
X_15733_ _18890_/Q _15738_/B VDD VSS _15739_/A XNOR2X1
X_13994_ _13999_/A _13994_/B _14008_/C _14013_/D VDD VSS _18074_/D OAOI211X1
XFILLER_19_889 VSS VDD FILLER2
XTAP_TAPCELL_ROW_28_350 VDD VSS WELLTAP
XTAP_TAPCELL_ROW_86_1053 VDD VSS WELLTAP
X_12945_ _18367_/Q _14329_/B _14329_/C VDD VSS _12947_/D OR3BX1
XFILLER_45_185 VDD VSS FILLER1
XTAP_TAPCELL_ROW_56_692 VDD VSS WELLTAP
X_12876_ _18211_/Q _14151_/B VDD VSS _12977_/D _14151_/C NAND3X1
X_18452_ _18478_/CK _18452_/D _18452_/Q VDD VSS DFFQX1
X_15664_ _15560_/Y _15663_/Y _15651_/Y VDD VSS _15670_/B MUXI2X1
X_11827_ _18330_/Q _11827_/B _11827_/C VDD VSS _14316_/B XNOR3X1
X_18383_ _18436_/CK _18383_/D _18383_/Q VDD VSS DFFQX1
X_17403_ _17410_/A _17403_/B VDD VSS _17612_/D NOR2X1
X_15595_ _15581_/Y _15594_/Y _15648_/A VDD VSS _15595_/Y MUX2X1
X_14615_ _14619_/A _14616_/B _17266_/C VDD VSS _14616_/C OAI21X1
XFILLER_14_561 VSS VDD FILLER2
XFILLER_42_881 VSS VDD FILLER2
XFILLER_60_177 VDD VSS FILLER1
X_11758_ _14195_/B _14195_/C _11759_/A VDD VSS _11800_/B OAI21X1
X_17334_ _17434_/A _17334_/B VDD VSS _19034_/D AND2X1
X_14546_ _14551_/C _14546_/B VDD VSS _14547_/B XNOR2X1
XFILLER_41_391 VSS VDD FILLER2
X_10709_ _17902_/Q _10709_/B VDD VSS _10715_/C _10709_/C NAND3X1
X_11689_ _11774_/A _11784_/A _11847_/B VDD VSS _11691_/C XNOR3X1
X_19004_ _19004_/CK _19004_/D _19004_/Q VDD VSS DFFQX1
Xclkload104 _18011_/CK VDD VSS clkload104/Y BUFX12
X_17265_ _19009_/Q _17287_/B _17281_/A VDD VSS _17267_/B AOI21X1
X_14477_ _14480_/A _14477_/B VDD VSS _18493_/D NOR2X1
XFILLER_127_430 VSS VDD FILLER2
Xclkload126 _18837_/CK VDD VSS clkload126/Y INVX1
Xclkload115 _18852_/CK VDD VSS clkload115/Y INVX1
X_17196_ _18997_/Q _17260_/B VDD VSS _17197_/B XNOR2X1
X_16216_ _16239_/A _16239_/B _16239_/D _16216_/D VDD VSS _16217_/C AOAI211X1
X_13428_ _18477_/Q _13528_/A _13516_/B VDD VSS _13515_/D XNOR3X1
XFILLER_115_603 VDD VSS DECAPHV16
XTAP_TAPCELL_ROW_97_1182 VDD VSS WELLTAP
X_16147_ _16711_/A _16147_/B VDD VSS _16148_/C NAND2X1
X_13359_ _18424_/Q _14396_/B VDD VSS _13460_/A AND2X1
XFILLER_114_113 VDD VSS DECAPHV16
XFILLER_6_793 VDD VSS DECAPHV32
XFILLER_69_712 VSS VDD FILLER2
X_16078_ _18840_/Q _18678_/Q VDD VSS _16079_/A XNOR2X1
X_15029_ _18627_/Q _19005_/Q _15029_/C VDD VSS _15037_/A MIN3X1
XFILLER_68_255 VDD VSS FILLER1
XFILLER_69_756 VDD VSS DECAPHV16
Xinput2 input2/A VDD VSS input2/Y BUFX3
XFILLER_83_236 VSS VDD FILLER2
X_09521_ _17587_/Q _17376_/B VDD VSS _09550_/A NAND2BX1
X_18719_ _18853_/CK _18719_/D _18719_/Q VDD VSS DFFQX1
Xclkbuf_leaf_10_clk_fs_regs clkbuf_leaf_9_clk_fs_regs/A VDD VSS _18989_/CK BUFX12
XFILLER_25_815 VDD VSS FILLER1
XFILLER_64_450 VDD VSS FILLER4
XFILLER_36_174 VDD VSS DECAPHV8
XFILLER_51_100 VDD VSS FILLER1
X_09452_ _09479_/C _09452_/B VDD VSS _17476_/B XNOR2X1
XFILLER_24_358 VDD VSS FILLER1
XFILLER_52_667 VDD VSS DECAPHV8
XFILLER_80_987 VDD VSS FILLER1
X_09383_ _19037_/Q _17337_/B VDD VSS _09384_/A NAND2BX1
XFILLER_69_1010 VSS VDD FILLER2
XFILLER_106_603 VDD VSS FILLER1
XFILLER_134_912 VDD VSS DECAPHV32
XFILLER_0_903 VDD VSS DECAPHV32
XFILLER_86_49 VDD VSS DECAPHV32
XFILLER_102_875 VDD VSS FILLER1
XFILLER_102_886 VSS VDD FILLER2
XFILLER_19_32 VDD VSS DECAPHV16
XFILLER_19_54 VDD VSS DECAPHV8
XFILLER_28_642 VDD VSS DECAPHV8
XFILLER_47_439 VDD VSS FILLER4
XFILLER_56_940 VDD VSS FILLER4
XTAP_TAPCELL_ROW_109_1329 VDD VSS WELLTAP
X_09719_ _17722_/Q VDD VSS _09720_/B INVX1
X_10991_ _10988_/A _10991_/B _10991_/C VDD VSS _10998_/C AOI2B1X1
XFILLER_128_1104 VDD VSS DECAPHV32
XFILLER_16_837 VDD VSS FILLER4
X_12730_ _12741_/A _14264_/B _12741_/C VDD VSS _14265_/B OAI21X1
XFILLER_35_64 VDD VSS DECAPHV8
XFILLER_37_1009 VSS VDD FILLER2
XFILLER_76_1058 VDD VSS FILLER1
XTAP_TAPCELL_ROW_25_320 VDD VSS WELLTAP
XTAP_TAPCELL_ROW_53_651 VDD VSS WELLTAP
X_12661_ _12661_/A _14091_/B VDD VSS _12760_/A OR2X2
XFILLER_30_328 VDD VSS DECAPHV8
XTAP_TAPCELL_ROW_81_993 VDD VSS WELLTAP
X_11612_ _11668_/A _11612_/B _11612_/C VDD VSS _11678_/C NOR3X1
X_14400_ _14414_/A _14400_/B VDD VSS _18427_/D NOR2X1
XFILLER_23_391 VDD VSS FILLER1
X_12592_ _18470_/Q VDD VSS _12811_/A INVX1
X_15380_ _15978_/A VDD VSS _16582_/A BUFX3
XFILLER_136_0 VDD VSS DECAPHV32
X_11543_ _11574_/A _11621_/A _11672_/B VDD VSS _11752_/A XNOR3X1
X_14331_ _14332_/A _14331_/B _14331_/C VDD VSS _18369_/D NOR3X1
XFILLER_109_430 VDD VSS DECAPHV8
XFILLER_13_1020 VSS VDD FILLER2
XFILLER_13_1042 VDD VSS DECAPHV16
XFILLER_51_96 VDD VSS FILLER4
X_11474_ _18248_/Q _14220_/A _14219_/B VDD VSS _11600_/B MIN3X1
X_17050_ _17050_/A _17050_/B _17050_/C _17050_/D VDD VSS _17054_/A AOAI211X1
X_14262_ _14243_/Y _14262_/B _14262_/C VDD VSS _18311_/D AND3BX1
XFILLER_136_260 VDD VSS DECAPHV8
XTAP_TAPCELL_ROW_133_1614 VDD VSS WELLTAP
X_10425_ _10428_/C _10425_/B VDD VSS _10608_/B XNOR2X1
X_13213_ _13225_/A _13225_/B _13213_/C _13225_/E VDD VSS _14125_/B AOI211X1
X_16001_ _16042_/A _16002_/C _16002_/D VDD VSS _16004_/B OR3BX1
X_14193_ _14217_/A _14193_/B VDD VSS _18250_/D NOR2X1
XFILLER_124_411 VSS VDD FILLER2
XFILLER_83_1007 VDD VSS FILLER4
X_13144_ _13153_/A _13150_/B _13330_/B VDD VSS _13249_/C XNOR3X1
XFILLER_100_1078 VDD VSS FILLER1
X_10356_ _10356_/A _10356_/B _10356_/C VDD VSS _10357_/B AOI21X1
XFILLER_135_1119 VDD VSS DECAPHV16
X_10287_ _17840_/Q _10287_/B VDD VSS _10295_/C _10287_/C NAND3X1
X_13075_ _18265_/Q _13297_/A _13081_/B VDD VSS _13076_/D XNOR3X1
X_17952_ _17982_/CK _17952_/D _17952_/Q VDD VSS DFFQX1
X_12026_ wire29/Y _12026_/B _12026_/C _12026_/D VDD VSS _12028_/C OAI211X1
X_17883_ _17908_/CK _17883_/D _17883_/Q VDD VSS DFFQX1
X_16903_ _18929_/Q _16907_/C VDD VSS _16906_/B XOR2X1
XFILLER_39_929 VDD VSS FILLER1
XFILLER_66_726 VDD VSS DECAPHV8
X_16834_ _16834_/A _16842_/B VDD VSS _16840_/B XOR2X1
XFILLER_120_694 VSS VDD FILLER2
XFILLER_93_567 VDD VSS FILLER1
X_16765_ _16633_/B _16832_/B _16869_/A VDD VSS _16877_/B MUXI2X1
X_13977_ _13999_/A _13977_/B _14008_/C _17533_/A VDD VSS _18067_/D OAOI211X1
XFILLER_34_623 VSS VDD FILLER2
XFILLER_74_781 VDD VSS DECAPHV8
XFILLER_80_239 VSS VDD FILLER2
X_12928_ _13020_/A _13137_/B VDD VSS _13036_/C XNOR2X1
X_18504_ _18505_/CK _18504_/D _18504_/Q VDD VSS DFFQX1
X_16696_ _16694_/Y _16696_/B _16784_/A _18775_/Q VDD VSS _16697_/D AOI2B2X1
X_15716_ _15716_/A _15718_/A VDD VSS _17013_/A XNOR2X1
XFILLER_34_656 VDD VSS FILLER4
XFILLER_34_678 VDD VSS FILLER4
XFILLER_62_987 VSS VDD FILLER2
XFILLER_92_81 VDD VSS DECAPHV32
X_18435_ _18436_/CK _18435_/D _18435_/Q VDD VSS DFFQX1
X_15647_ _15633_/Y _15646_/Y _15648_/A VDD VSS _15694_/B MUXI2X1
X_12859_ _12859_/A _12859_/B _12859_/C VDD VSS _12866_/B XNOR3X1
XFILLER_109_1081 VDD VSS FILLER4
X_18366_ _18368_/CK _18366_/D _18366_/Q VDD VSS DFFQX1
X_15578_ _18875_/Q _15668_/B VDD VSS _15579_/C NAND2X1
XFILLER_119_205 VDD VSS FILLER4
XTAP_TAPCELL_ROW_99_1211 VDD VSS WELLTAP
X_18297_ _18376_/CK _18297_/D _18297_/Q VDD VSS DFFQX1
X_17317_ _17317_/A _17317_/B _17317_/C VDD VSS _17319_/B AOI21X1
X_14529_ _18520_/Q _18552_/Q VDD VSS _14534_/A NAND2X1
XFILLER_30_895 VDD VSS FILLER1
XTAP_TAPCELL_ROW_31_389 VDD VSS WELLTAP
X_17248_ _17248_/A _17248_/B VDD VSS _17259_/A AND2X1
XFILLER_116_901 VDD VSS DECAPHV8
XFILLER_127_282 VDD VSS DECAPHV32
XFILLER_51_0 VDD VSS DECAPHV32
X_17179_ _17316_/B VDD VSS _17287_/B BUFX3
XFILLER_69_520 VDD VSS FILLER4
XFILLER_88_328 VDD VSS DECAPHV8
X_08952_ _08952_/A _08952_/B _08952_/C _08952_/D VDD VSS _08953_/C AOAI211X1
XFILLER_97_840 VDD VSS FILLER1
X_08883_ _17734_/Q _18523_/Q VDD VSS _17542_/A XNOR2X1
XFILLER_111_650 VDD VSS FILLER1
XFILLER_29_406 VSS VDD FILLER2
XFILLER_29_417 VDD VSS FILLER1
XFILLER_110_182 VSS VDD FILLER2
XFILLER_56_214 VDD VSS FILLER1
XFILLER_84_534 VDD VSS DECAPHV8
XFILLER_72_718 VDD VSS FILLER1
XFILLER_37_472 VDD VSS FILLER1
XFILLER_65_792 VDD VSS DECAPHV16
XTAP_TAPCELL_ROW_39_489 VDD VSS WELLTAP
X_09504_ _17747_/Q _17715_/Q VDD VSS _09505_/B XOR2X1
XFILLER_53_954 VDD VSS FILLER4
X_09435_ _19039_/Q _17340_/B VDD VSS _09437_/C XOR2X1
XFILLER_36_1020 VDD VSS DECAPHV16
XFILLER_53_987 VSS VDD FILLER2
XFILLER_21_840 VDD VSS FILLER1
XFILLER_24_199 VDD VSS FILLER1
XTAP_TAPCELL_ROW_50_621 VDD VSS WELLTAP
X_09366_ _09366_/A _09390_/B VDD VSS _17439_/B XOR2X1
Xclkbuf_leaf_14__001_ clkload74/A VDD VSS _17961_/CK BUFX12
X_09297_ _09297_/A _09297_/B _09297_/C VDD VSS _09301_/B OAI21X1
XFILLER_20_372 VDD VSS FILLER4
XFILLER_106_400 VDD VSS FILLER4
XFILLER_107_901 VDD VSS DECAPHV8
XFILLER_118_260 VSS VDD FILLER2
XFILLER_20_394 VSS VDD FILLER2
Xclkbuf_leaf_29__001_ clkbuf_2_1__f__001_/Y VDD VSS _17706_/CK BUFX12
X_10210_ _10154_/Y _10399_/B _10399_/C VDD VSS _17851_/D AND3BX1
XFILLER_21_99 VDD VSS FILLER4
X_11190_ _17995_/Q _11190_/B _11190_/C VDD VSS _11196_/A AOI21X1
XFILLER_134_797 VDD VSS FILLER1
XTAP_TAPCELL_ROW_115_1399 VDD VSS WELLTAP
X_10141_ _10330_/A _10330_/B VDD VSS _10333_/B XNOR2X1
XFILLER_0_755 VDD VSS DECAPHV8
X_10072_ _10076_/A _10076_/B VDD VSS _10075_/D XOR2X1
XFILLER_88_873 VDD VSS FILLER4
X_13900_ _14435_/A _14435_/B _18459_/Q VDD VSS _13901_/D OAI21X1
XTAP_TAPCELL_ROW_58_710 VDD VSS WELLTAP
X_14880_ _14880_/A _14881_/C _14880_/C VDD VSS _18595_/D AOI21X1
XFILLER_29_984 VDD VSS DECAPHV8
X_13831_ _13840_/A _14431_/B _13861_/C VDD VSS _14433_/C NOR3X1
X_10974_ _17955_/Q _10981_/B VDD VSS _10978_/A XNOR2X1
Xmax_cap31 _15860_/D VDD VSS _15897_/A BUFX4
X_16550_ _16551_/A _16551_/B VDD VSS _16550_/Y NAND2X1
X_13762_ _13762_/A _13762_/B _13762_/C _13762_/D VDD VSS _14310_/B OA211X2
XFILLER_15_111 VDD VSS DECAPHV8
XFILLER_15_144 VDD VSS FILLER1
XFILLER_16_656 VDD VSS DECAPHV32
XFILLER_71_762 VDD VSS DECAPHV16
XTAP_TAPCELL_ROW_83_1012 VDD VSS WELLTAP
X_12713_ _18418_/Q _12713_/B _12713_/C VDD VSS _12927_/B MIN3X1
X_15501_ _15686_/A _15501_/B _15501_/C _16731_/A VDD VSS _15502_/C OAI211X1
XFILLER_43_464 VDD VSS FILLER1
XFILLER_44_987 VSS VDD FILLER2
X_18220_ _18271_/CK _18220_/D _18220_/Q VDD VSS DFFQX1
X_16481_ _16444_/Y _16480_/Y _16554_/A VDD VSS _16481_/Y MUXI2X1
X_13693_ _18324_/Q _13693_/B _13701_/B VDD VSS _13695_/D XNOR3X1
XFILLER_62_40 VDD VSS FILLER4
X_12644_ _18261_/Q _14205_/B VDD VSS _12846_/D _14205_/C NAND3X1
X_15432_ _15398_/Y _15392_/Y _16783_/A VDD VSS _15432_/Y MUX2X1
XFILLER_30_158 VSS VDD FILLER2
X_12575_ _18339_/Q _12723_/B _12723_/C VDD VSS _12940_/B XNOR3X1
X_18151_ _18152_/CK _18151_/D _18151_/Q VDD VSS DFFQX1
X_15363_ _15413_/A _15413_/B VDD VSS _15364_/C NOR2X1
XFILLER_129_547 VDD VSS DECAPHV8
X_11526_ _11594_/A _11594_/B _14222_/B VDD VSS _11663_/B MIN3X1
X_18082_ _18082_/CK _18082_/D _18082_/Q VDD VSS DFFQX1
X_17102_ _17107_/A _17103_/D _17103_/A _17103_/B VDD VSS _17104_/B OA211X2
X_14314_ _14542_/A VDD VSS _14346_/A BUFX3
X_17033_ _17036_/C _17033_/B _17033_/C VDD VSS _18964_/D AOI21X1
X_15294_ _15295_/A _18035_/Q VDD VSS _18834_/D AND2X1
XFILLER_125_742 VSS VDD FILLER2
X_11457_ _11607_/A _11476_/B VDD VSS _14163_/B XNOR2X1
X_14245_ _14296_/A _14245_/B _14245_/C VDD VSS _18295_/D NOR3X1
XFILLER_124_230 VSS VDD FILLER2
XTAP_TAPCELL_ROW_94_1141 VDD VSS WELLTAP
XTAP_TAPCELL_ROW_94_1152 VDD VSS WELLTAP
X_10408_ _10582_/B _10412_/B _10412_/D _10412_/C VDD VSS _10593_/C OAI211X1
X_11388_ _11388_/A _11388_/B _11388_/C _11388_/D VDD VSS _14075_/B AOAI211X1
X_14176_ _17065_/A VDD VSS _14236_/A BUFX3
XFILLER_113_926 VDD VSS FILLER4
XFILLER_124_285 VSS VDD FILLER2
XFILLER_98_648 VDD VSS FILLER4
X_10339_ _17846_/Q _10343_/B _10343_/C VDD VSS _10524_/C XNOR3X1
X_13127_ _13199_/A _13297_/D _13187_/C VDD VSS _13200_/C XNOR3X1
X_18984_ _18985_/CK _18984_/D _18984_/Q VDD VSS DFFQX1
XFILLER_3_593 VDD VSS DECAPHV32
XFILLER_79_840 VSS VDD FILLER2
X_13058_ _13058_/A _14331_/B _14331_/C VDD VSS _13059_/D NOR3X1
X_17935_ _17961_/CK _17935_/D _17935_/Q VDD VSS DFFQX1
XFILLER_112_469 VDD VSS DECAPHV8
XFILLER_61_1135 VDD VSS FILLER1
XFILLER_87_92 VDD VSS FILLER1
X_12009_ _12076_/A _12118_/A _12216_/B VDD VSS _12080_/D XNOR3X1
XFILLER_120_480 VDD VSS DECAPHV16
XFILLER_38_214 VSS VDD FILLER2
XFILLER_93_320 VDD VSS DECAPHV8
X_17866_ _17867_/CK _17866_/D _17866_/Q VDD VSS DFFQX1
XFILLER_54_707 VDD VSS FILLER1
XFILLER_66_589 VDD VSS FILLER4
XFILLER_93_364 VDD VSS FILLER4
X_17797_ _19042_/CK _17797_/D _17797_/Q VDD VSS DFFQX1
X_16817_ _16817_/A _16817_/B VDD VSS _16841_/A AND2X1
XFILLER_19_483 VSS VDD FILLER2
X_16748_ _18803_/Q _18749_/Q _16748_/C VDD VSS _16777_/C AOI21X1
XTAP_TAPCELL_ROW_36_448 VDD VSS WELLTAP
XFILLER_21_103 VSS VDD FILLER2
XFILLER_22_615 VDD VSS FILLER1
XFILLER_62_762 VSS VDD FILLER2
XFILLER_62_795 VDD VSS FILLER1
X_09220_ _17576_/Q _17365_/B VDD VSS _09239_/A NAND2BX1
X_16679_ _16866_/A _16746_/A VDD VSS _16703_/A NOR2X1
XFILLER_21_114 VDD VSS FILLER1
XFILLER_99_0 VDD VSS DECAPHV32
X_18418_ _18470_/CK _18418_/D _18418_/Q VDD VSS DFFQX1
XFILLER_21_158 VDD VSS FILLER4
XFILLER_50_979 VSS VDD FILLER2
X_09151_ _17637_/Q _09151_/B _17430_/B VDD VSS _09176_/B MIN3X1
X_18349_ _18376_/CK _18349_/D _18349_/Q VDD VSS DFFQX1
XTAP_TAPCELL_ROW_0_0 VDD VSS WELLTAP
X_09082_ _09082_/A _09082_/B VDD VSS _17322_/B XNOR2X1
XFILLER_116_731 VDD VSS FILLER1
XFILLER_104_915 VSS VDD FILLER2
XTAP_TAPCELL_ROW_8_118 VDD VSS WELLTAP
XFILLER_116_797 VDD VSS FILLER1
XFILLER_118_1125 VDD VSS FILLER4
XFILLER_66_1068 VDD VSS FILLER1
XFILLER_130_222 VDD VSS DECAPHV8
X_09984_ _10184_/B VDD VSS _10203_/B INVX1
XFILLER_69_350 VDD VSS FILLER1
X_08935_ _08935_/A _08935_/B _08935_/C VDD VSS _08940_/C OAI21X1
XFILLER_130_299 VDD VSS DECAPHV16
XFILLER_29_214 VDD VSS FILLER1
XFILLER_16_44 VSS VDD FILLER2
XFILLER_44_239 VSS VDD FILLER2
XFILLER_77_1131 VDD VSS FILLER4
XFILLER_26_987 VDD VSS FILLER4
XFILLER_52_261 VDD VSS FILLER4
XFILLER_12_103 VDD VSS DECAPHV8
XFILLER_13_648 VSS VDD FILLER2
XFILLER_52_272 VDD VSS DECAPHV8
X_09418_ _17679_/Q _17474_/B VDD VSS _09420_/A NAND2BX1
X_10690_ _17043_/A _10827_/B VDD VSS _17925_/D AND2X1
XFILLER_12_158 VDD VSS DECAPHV8
X_09349_ _17581_/Q _17370_/B VDD VSS _09354_/B XOR2X1
XFILLER_21_670 VDD VSS DECAPHV8
XFILLER_32_32 VDD VSS DECAPHV8
XFILLER_8_129 VDD VSS DECAPHV8
X_12360_ _12360_/A _12360_/B _12360_/C VDD VSS _12446_/B XNOR3X1
XTAP_TAPCELL_ROW_117_1417 VDD VSS WELLTAP
XTAP_TAPCELL_ROW_117_1428 VDD VSS WELLTAP
XTAP_TAPCELL_ROW_3_58 VDD VSS WELLTAP
X_11311_ _18966_/Q _18087_/Q VDD VSS _11314_/B XNOR2X1
XFILLER_119_591 VSS VDD FILLER2
X_12291_ _12291_/A _12291_/B _14384_/B VDD VSS _12292_/B MIN3X1
X_11242_ _11278_/A _11278_/B _11278_/C VDD VSS _14043_/B AOI21X1
X_14030_ _14107_/A _18978_/Q VDD VSS _18099_/D AND2X1
X_11173_ _11205_/A _17119_/B VDD VSS _18018_/D NOR2X1
XFILLER_0_530 VDD VSS DECAPHV8
XFILLER_106_285 VDD VSS FILLER1
X_10124_ _10294_/B _10127_/B _10127_/D _10127_/C VDD VSS _10317_/C OAI211X1
XFILLER_76_810 VDD VSS FILLER1
XFILLER_95_629 VDD VSS FILLER4
X_15981_ _16180_/A _16020_/B _15981_/C VDD VSS _15983_/B AO21X2
XFILLER_76_832 VDD VSS FILLER4
X_10055_ _17807_/Q _10060_/B VDD VSS _10057_/A NOR2BX1
X_17720_ _17722_/CK _17720_/D _17720_/Q VDD VSS DFFQX1
X_14932_ _15093_/A _14932_/B VDD VSS _18606_/D NOR2X1
XFILLER_75_342 VDD VSS FILLER1
XTAP_TAPCELL_ROW_128_1557 VDD VSS WELLTAP
X_17651_ _17716_/CK _17651_/D _17651_/Q VDD VSS DFFQX1
X_14863_ _18591_/Q _18623_/Q _14863_/C VDD VSS _14868_/C AO21X2
XFILLER_29_781 VDD VSS FILLER4
XFILLER_29_792 VSS VDD FILLER2
XFILLER_63_526 VDD VSS FILLER1
XFILLER_63_537 VDD VSS DECAPHV16
XFILLER_75_375 VDD VSS FILLER4
X_16602_ _16602_/A _16602_/B VDD VSS _16678_/A NAND2X1
X_13814_ _13814_/A _13814_/B _13814_/C _13814_/D VDD VSS _14496_/B OAOI211X1
XFILLER_17_954 VDD VSS FILLER4
XFILLER_28_280 VDD VSS DECAPHV16
X_17582_ _17680_/CK _17582_/D _17582_/Q VDD VSS DFFQX1
X_14794_ _18577_/Q _18609_/Q VDD VSS _14797_/A XOR2X1
XFILLER_43_250 VSS VDD FILLER2
XFILLER_43_261 VDD VSS FILLER4
XTAP_TAPCELL_ROW_33_418 VDD VSS WELLTAP
X_10957_ _17951_/Q _10960_/B VDD VSS _10958_/B XOR2X1
X_16533_ _18053_/Q _18663_/Q VDD VSS _16536_/A XNOR2X1
X_13745_ _13746_/B _13746_/C _18376_/Q VDD VSS _13748_/B AOI21X1
XTAP_TAPCELL_ROW_61_749 VDD VSS WELLTAP
X_16464_ _16549_/B _16464_/B VDD VSS _16470_/D NOR2X1
X_13676_ _18401_/Q VDD VSS _13678_/A INVX1
XFILLER_32_979 VDD VSS DECAPHV16
X_10888_ _10891_/A _10888_/B VDD VSS _11020_/B XNOR2X1
X_12627_ _14204_/B _14204_/C _18260_/Q VDD VSS _12629_/C AOI21X1
X_18203_ _18253_/CK _18203_/D _18203_/Q VDD VSS DFFQX1
X_15415_ _15415_/A _15415_/B VDD VSS _15444_/B XNOR2X1
XTAP_TAPCELL_ROW_13_175 VDD VSS WELLTAP
X_18134_ _18249_/CK _18134_/D _18134_/Q VDD VSS DFFQX1
X_16395_ _18793_/Q _18739_/Q VDD VSS _16396_/D NOR2X1
XFILLER_106_1095 VSS VDD FILLER2
X_12558_ _12566_/A _14060_/B VDD VSS _14061_/A _12678_/C NAND3X1
X_15346_ _172_/E _15346_/B VDD VSS _18865_/D NOR2X1
XFILLER_117_528 VDD VSS DECAPHV16
XFILLER_7_184 VSS VDD FILLER2
X_11509_ _18196_/Q _11509_/B VDD VSS _11544_/C _11509_/C NAND3X1
X_12489_ _12489_/A _12489_/B _12489_/C VDD VSS _14386_/B XNOR3X1
X_18065_ _18066_/CK _18065_/D _18065_/Q VDD VSS DFFQX1
X_15277_ _15309_/A _18845_/Q VDD VSS _18818_/D AND2X1
XFILLER_132_509 VSS VDD FILLER2
X_17016_ _18959_/Q _17016_/B VDD VSS _17017_/C NAND2X1
X_14228_ _14252_/A _14228_/B VDD VSS _18281_/D NOR2X1
XFILLER_125_561 VDD VSS DECAPHV16
XFILLER_112_222 VDD VSS DECAPHV8
XFILLER_98_445 VSS VDD FILLER2
XFILLER_99_968 VDD VSS FILLER1
X_14159_ _14160_/A _14159_/B VDD VSS _18219_/D NOR2X1
XFILLER_101_929 VDD VSS FILLER1
XFILLER_79_670 VDD VSS FILLER4
XFILLER_86_607 VDD VSS DECAPHV16
XFILLER_98_467 VDD VSS DECAPHV8
X_18967_ _18971_/CK _18967_/D _18967_/Q VDD VSS DFFQX1
Xclkbuf_leaf_13__002_ clkbuf_leaf_9__002_/A VDD VSS _18152_/CK BUFX12
XFILLER_100_428 VDD VSS FILLER4
XFILLER_26_1074 VDD VSS FILLER1
XFILLER_39_512 VSS VDD FILLER2
XFILLER_85_128 VDD VSS DECAPHV16
XTAP_TAPCELL_ROW_69_849 VDD VSS WELLTAP
X_17918_ _17972_/CK _17918_/D _17918_/Q VDD VSS DFFQX1
X_18898_ _18961_/CK _18898_/D _18898_/Q VDD VSS DFFQX1
XFILLER_14_0 VDD VSS DECAPHV32
X_17849_ _17901_/CK _17849_/D _17849_/Q VDD VSS DFFQX1
XFILLER_66_386 VDD VSS FILLER1
XFILLER_93_150 VSS VDD FILLER2
XFILLER_96_1006 VSS VDD FILLER2
XFILLER_26_239 VDD VSS FILLER1
XFILLER_54_559 VDD VSS DECAPHV32
Xclkbuf_leaf_28__002_ clkload27/A VDD VSS _18361_/CK BUFX12
XFILLER_35_795 VDD VSS DECAPHV8
XFILLER_50_732 VSS VDD FILLER2
XTAP_TAPCELL_ROW_101_1229 VDD VSS WELLTAP
XFILLER_10_607 VDD VSS DECAPHV32
XFILLER_23_979 VDD VSS FILLER1
XFILLER_33_1001 VSS VDD FILLER2
X_09203_ _09203_/A _09203_/B _09203_/C _09203_/D VDD VSS _09226_/A AOAI211X1
XFILLER_31_990 VDD VSS DECAPHV8
XFILLER_33_1034 VSS VDD FILLER2
XFILLER_50_787 VSS VDD FILLER2
XFILLER_72_1072 VSS VDD FILLER2
X_09134_ _09134_/A _09134_/B _09134_/C VDD VSS _09135_/B NOR3X1
XFILLER_135_314 VDD VSS DECAPHV32
X_09065_ _17731_/Q _17699_/Q VDD VSS _09066_/B XNOR2X1
XFILLER_104_723 VSS VDD FILLER2
XTAP_TAPCELL_ROW_112_1358 VDD VSS WELLTAP
XFILLER_103_266 VDD VSS FILLER1
X_09967_ _09970_/A _10164_/B VDD VSS _10179_/C _09970_/C NAND3X1
X_08918_ _17562_/A _17562_/B _08918_/C VDD VSS _17564_/A OA21X2
XFILLER_18_707 VSS VDD FILLER2
XFILLER_57_353 VDD VSS DECAPHV8
XFILLER_85_662 VSS VDD FILLER2
XFILLER_94_49 VDD VSS DECAPHV32
X_09898_ _09904_/A _09904_/B VDD VSS _10099_/C NOR2X1
XFILLER_17_206 VDD VSS FILLER4
XFILLER_17_228 VDD VSS FILLER1
XFILLER_27_32 VDD VSS DECAPHV16
XFILLER_45_515 VDD VSS FILLER4
XFILLER_57_375 VDD VSS FILLER1
XFILLER_72_334 VDD VSS DECAPHV16
XFILLER_72_356 VDD VSS FILLER1
XFILLER_84_194 VDD VSS DECAPHV8
X_11860_ _18149_/Q VDD VSS _11861_/A INVX1
XFILLER_26_784 VSS VDD FILLER2
XFILLER_60_507 VDD VSS FILLER4
X_10811_ _17922_/Q _10811_/B _10811_/C VDD VSS _10816_/C MIN3X1
X_11791_ _18975_/Q _18096_/Q VDD VSS _11954_/B NAND2X1
XFILLER_13_412 VDD VSS FILLER1
X_10742_ _10922_/A VDD VSS _10844_/A BUFX3
X_13530_ _18426_/Q VDD VSS _13598_/A INVX1
XFILLER_14_979 VDD VSS DECAPHV8
XFILLER_40_231 VDD VSS FILLER1
XFILLER_43_64 VDD VSS DECAPHV16
XTAP_TAPCELL_ROW_123_1498 VDD VSS WELLTAP
XFILLER_51_1134 VSS VDD FILLER2
X_10673_ _17896_/Q _10673_/B VDD VSS _10676_/D _10673_/C NAND3X1
X_15200_ _15313_/A _18769_/Q VDD VSS _18742_/D AND2X1
X_13461_ _13544_/A _13639_/B VDD VSS _14369_/B XNOR2X1
X_12412_ _18338_/Q VDD VSS _12610_/A INVX1
X_16180_ _16180_/A _16180_/B _16180_/C VDD VSS _16181_/C NOR3X1
X_13392_ _13392_/A _13392_/B _13392_/C _13392_/D VDD VSS _13556_/A AOAI211X1
XTAP_TAPCELL_ROW_10_134 VDD VSS WELLTAP
X_12343_ _12343_/A _12343_/B _12346_/C VDD VSS _12436_/B XNOR3X1
X_15131_ _15299_/A _18701_/Q VDD VSS _18674_/D AND2X1
X_12274_ _18388_/Q _12402_/B _14355_/B VDD VSS _12292_/C XNOR3X1
X_15062_ _15065_/A _15062_/B _15062_/C VDD VSS _18634_/D AOI21X1
XTAP_TAPCELL_ROW_91_1111 VDD VSS WELLTAP
X_11225_ _18435_/Q VDD VSS _11816_/A INVX1
X_14013_ _14013_/A _14013_/B _14013_/C _14013_/D VDD VSS _18082_/D OAOI211X1
XFILLER_122_531 VDD VSS FILLER1
XFILLER_136_1033 VSS VDD FILLER2
XFILLER_122_575 VDD VSS FILLER1
XFILLER_1_872 VDD VSS DECAPHV32
X_11156_ _17989_/Q _11160_/A VDD VSS _11157_/B XNOR2X1
X_18821_ _18821_/CK _18821_/D _18821_/Q VDD VSS DFFQX1
XFILLER_49_832 VDD VSS FILLER4
X_10107_ _10107_/A _10270_/B _10107_/C _10107_/D VDD VSS _10310_/B AOAI211X1
X_11087_ _17975_/Q _11087_/B _11087_/C VDD VSS _11094_/A MIN3X1
X_18752_ _18780_/CK _18752_/D _18752_/Q VDD VSS DFFQX1
X_15964_ _18837_/Q _18675_/Q VDD VSS _15965_/A XNOR2X1
XFILLER_48_342 VDD VSS FILLER1
XTAP_TAPCELL_ROW_66_808 VDD VSS WELLTAP
X_10038_ _10038_/A VDD VSS _10046_/A INVX1
X_17703_ _17706_/CK _17703_/D _17703_/Q VDD VSS DFFQX1
X_14915_ _18603_/Q _18635_/Q VDD VSS _14917_/D XNOR2X1
XFILLER_64_813 VDD VSS FILLER1
XFILLER_75_150 VDD VSS FILLER1
XFILLER_76_695 VSS VDD FILLER2
X_18683_ _18846_/CK _18683_/D _18683_/Q VDD VSS DFFQX1
X_15895_ _15889_/Y _15895_/B _15893_/Y _15895_/D VDD VSS _15911_/D AOI2B2BX1
XFILLER_1_1021 VSS VDD FILLER2
XFILLER_64_846 VSS VDD FILLER2
XFILLER_91_654 VDD VSS FILLER4
XTAP_TAPCELL_ROW_18_234 VDD VSS WELLTAP
XTAP_TAPCELL_ROW_89_1084 VDD VSS WELLTAP
X_17634_ _17701_/CK _17634_/D _17634_/Q VDD VSS DFFQX1
X_14846_ _14850_/C _14846_/B VDD VSS _14847_/B XNOR2X1
XFILLER_16_250 VSS VDD FILLER2
XFILLER_91_665 VSS VDD FILLER2
XTAP_TAPCELL_ROW_46_565 VDD VSS WELLTAP
XTAP_TAPCELL_ROW_46_576 VDD VSS WELLTAP
X_17565_ _17565_/A _17565_/B VDD VSS _17743_/D NOR2X1
X_14777_ _14780_/A _14780_/B _17318_/C VDD VSS _14778_/C OAI21X1
XFILLER_108_1113 VSS VDD FILLER2
XFILLER_95_1094 VDD VSS FILLER4
X_11989_ _11991_/B _11990_/B _14423_/A VDD VSS _11990_/C OAI21X1
X_16516_ _16535_/C _16517_/B VDD VSS _16517_/C NOR2X1
X_13728_ _18429_/Q _13728_/B _13798_/C VDD VSS _13792_/B XNOR3X1
XFILLER_31_242 VDD VSS DECAPHV16
XFILLER_56_1067 VSS VDD FILLER2
XFILLER_56_1089 VSS VDD FILLER2
X_17496_ _17498_/A _17732_/Q VDD VSS _17700_/D AND2X1
XFILLER_20_949 VDD VSS DECAPHV8
XFILLER_32_787 VSS VDD FILLER2
X_16447_ _16300_/Y _16446_/Y _16521_/A VDD VSS _16737_/B MUXI2X1
X_13659_ _13659_/A _13659_/B _13659_/C VDD VSS _18050_/D AOI21X1
XFILLER_31_297 VDD VSS FILLER1
X_16378_ _16378_/A _16424_/B VDD VSS _16383_/B XOR2X1
XFILLER_117_314 VDD VSS FILLER1
XFILLER_9_983 VDD VSS DECAPHV8
X_18117_ _18971_/CK _18117_/D _18117_/Q VDD VSS DFFQX1
X_15329_ _18860_/Q VDD VSS _15760_/A INVX1
XFILLER_105_509 VDD VSS FILLER1
XFILLER_117_369 VSS VDD FILLER2
X_18048_ _18846_/CK _18048_/D _18048_/Q VDD VSS DFFQX1
XFILLER_126_870 VSS VDD FILLER2
XFILLER_132_328 VDD VSS DECAPHV32
XFILLER_98_231 VDD VSS FILLER1
XFILLER_101_704 VDD VSS FILLER4
XFILLER_59_618 VDD VSS FILLER1
X_09821_ _17768_/Q _17769_/Q _09821_/C _17770_/Q VDD VSS _09822_/B AOI31X1
XFILLER_113_586 VDD VSS FILLER1
X_09752_ _09752_/A _09767_/C VDD VSS _09764_/A XNOR2X1
XFILLER_55_802 VSS VDD FILLER2
XFILLER_95_971 VDD VSS DECAPHV8
XFILLER_39_375 VDD VSS DECAPHV8
XFILLER_66_150 VSS VDD FILLER2
XFILLER_67_695 VDD VSS FILLER4
X_09683_ _19048_/Q _17349_/B VDD VSS _09707_/A NOR2X1
XFILLER_27_537 VDD VSS DECAPHV8
XFILLER_81_120 VDD VSS FILLER4
XFILLER_94_492 VDD VSS DECAPHV8
XFILLER_54_367 VDD VSS FILLER4
XFILLER_70_816 VDD VSS FILLER1
XFILLER_70_849 VDD VSS FILLER1
Xfanout46 hold96/A VDD VSS _17523_/A BUFX3
XFILLER_50_595 VDD VSS DECAPHV8
Xfanout57 _11148_/A VDD VSS _10707_/A BUFX3
Xfanout68 _17182_/D VDD VSS _17525_/B BUFX3
Xfanout79 _16984_/A VDD VSS _15250_/A BUFX3
XFILLER_6_408 VDD VSS DECAPHV8
X_09117_ _19027_/Q _17327_/B VDD VSS _09118_/C NOR2X1
XFILLER_108_336 VSS VDD FILLER2
X_09048_ _17598_/Q _17388_/B VDD VSS _17354_/B XOR2X1
XFILLER_117_870 VSS VDD FILLER2
XFILLER_124_829 VDD VSS FILLER4
XFILLER_136_678 VDD VSS DECAPHV32
XFILLER_104_531 VDD VSS DECAPHV16
XTAP_TAPCELL_ROW_0_15 VDD VSS WELLTAP
XFILLER_89_253 VDD VSS DECAPHV8
X_11010_ _17961_/Q VDD VSS _11014_/A INVX1
XFILLER_131_383 VSS VDD FILLER2
XFILLER_46_802 VDD VSS DECAPHV8
XFILLER_58_651 VDD VSS DECAPHV8
XFILLER_100_781 VDD VSS DECAPHV8
XFILLER_58_695 VSS VDD FILLER2
XFILLER_79_1001 VDD VSS FILLER1
X_12961_ _18289_/Q _14238_/B _14238_/C VDD VSS _13011_/D OR3BX1
XFILLER_73_654 VDD VSS DECAPHV16
XFILLER_79_1056 VSS VDD FILLER2
XTAP_TAPCELL_ROW_125_1516 VDD VSS WELLTAP
X_11912_ _18333_/Q VDD VSS _12007_/A INVX1
X_12892_ _18133_/Q _14065_/B VDD VSS _13091_/B _14065_/C NAND3X1
X_15680_ _15737_/A _17004_/A _15680_/C VDD VSS _18883_/D OAI21X1
X_14700_ _14701_/A _14702_/C _17229_/A VDD VSS _14701_/C OAI21X1
XFILLER_33_518 VDD VSS FILLER4
X_11843_ _11843_/A _11843_/B _11843_/C _11843_/D VDD VSS _11937_/B OAOI211X1
X_14631_ _18542_/Q _18574_/Q VDD VSS _14632_/B XOR2X1
XFILLER_14_732 VDD VSS DECAPHV32
XFILLER_72_175 VDD VSS DECAPHV8
XTAP_TAPCELL_ROW_15_204 VDD VSS WELLTAP
X_17350_ _17453_/A _17350_/B VDD VSS _19049_/D AND2X1
XFILLER_60_348 VDD VSS FILLER4
XTAP_TAPCELL_ROW_43_535 VDD VSS WELLTAP
XTAP_TAPCELL_ROW_71_866 VDD VSS WELLTAP
X_11774_ _11774_/A _14080_/B VDD VSS _11850_/A OR2X2
X_16301_ _16145_/Y _16300_/Y _16521_/A VDD VSS _16302_/B MUXI2X1
X_14562_ _14562_/A _14562_/B _14562_/C _14562_/D VDD VSS _14563_/C AOAI211X1
XFILLER_13_253 VDD VSS FILLER1
XFILLER_14_787 VSS VDD FILLER2
X_10725_ _10728_/C _10725_/B VDD VSS _10857_/B XNOR2X1
X_17281_ _17281_/A _17281_/B _17281_/C _17281_/D VDD VSS _17284_/B AOI31X1
X_14493_ _14055_/C _14493_/B _14493_/C VDD VSS _18506_/D AND3BX1
X_13513_ _13514_/B _13514_/C _13514_/A VDD VSS _13515_/B OAI21X1
XFILLER_70_40 VDD VSS FILLER4
XTAP_TAPCELL_ROW_23_292 VDD VSS WELLTAP
X_10656_ _14310_/C _10795_/B VDD VSS _17918_/D AND2X1
X_19020_ clkload1/A _19020_/D _19020_/Q VDD VSS DFFQX1
X_16232_ _16227_/B _18904_/Q _16232_/C VDD VSS _16273_/B AOI2B1X1
X_13444_ _13444_/A _13444_/B _13444_/C _13444_/D VDD VSS _13519_/B AOAI211X1
Xclkload16 _18913_/CK VDD VSS clkload16/Y INVX2
X_16163_ _18787_/Q _18733_/Q VDD VSS _16165_/C NOR2X1
XFILLER_115_807 VSS VDD FILLER2
XTAP_TAPCELL_ROW_136_1645 VDD VSS WELLTAP
XTAP_TAPCELL_ROW_136_1656 VDD VSS WELLTAP
XTAP_TAPCELL_ROW_136_1667 VDD VSS WELLTAP
X_10587_ _17878_/Q _10587_/B VDD VSS _10594_/A NAND2X1
Xclkload49 _18250_/CK VDD VSS clkload49/Y INVX2
Xclkload38 _18247_/CK VDD VSS clkload38/Y INVX2
Xclkload27 clkload27/A VDD VSS clkload27/Y INVX8
X_15114_ _15309_/A _18685_/Q VDD VSS _18658_/D AND2X1
X_13375_ _13473_/A _13375_/B VDD VSS _14305_/B XNOR2X1
XFILLER_115_829 VDD VSS FILLER1
XFILLER_127_678 VSS VDD FILLER2
XFILLER_5_463 VSS VDD FILLER2
X_12326_ _14143_/A _14143_/B _14143_/C VDD VSS _12328_/B OAI21X1
X_16094_ _16094_/A VDD VSS _16096_/C INVX1
XFILLER_114_328 VDD VSS DECAPHV8
XFILLER_123_840 VDD VSS DECAPHV16
X_12257_ _12261_/A _12360_/B _12261_/B VDD VSS _14058_/C NOR3X1
X_15045_ _15048_/A _15048_/B _17266_/C VDD VSS _15046_/C OAI21X1
X_11208_ _14253_/A VDD VSS _14053_/A BUFX3
X_12188_ _18491_/Q _12191_/C VDD VSS _12190_/B XOR2X1
X_18804_ _18858_/CK _18804_/D _18804_/Q VDD VSS DFFQX1
XTAP_TAPCELL_ROW_79_966 VDD VSS WELLTAP
X_11139_ _17986_/Q _11144_/B VDD VSS _11141_/C XOR2X1
X_16996_ _16996_/A _17006_/B _16996_/C VDD VSS _18947_/D OAI21X1
XFILLER_37_824 VSS VDD FILLER2
XFILLER_62_1093 VDD VSS FILLER4
XFILLER_77_982 VDD VSS FILLER1
XFILLER_95_92 VDD VSS FILLER1
X_18735_ _18818_/CK _18735_/D _18735_/Q VDD VSS DFFQX1
X_15947_ _18897_/Q _16527_/B VDD VSS _15948_/C NAND2X1
XFILLER_48_172 VDD VSS FILLER1
XFILLER_48_183 VDD VSS FILLER1
XFILLER_97_1134 VSS VDD FILLER2
X_18666_ _18856_/CK _18666_/D _18666_/Q VDD VSS DFFQX1
X_15878_ _15931_/A _15931_/B _15931_/C VDD VSS _15879_/B OAI21X1
XFILLER_24_518 VSS VDD FILLER2
XFILLER_52_827 VSS VDD FILLER2
XFILLER_64_687 VDD VSS FILLER1
XFILLER_91_473 VDD VSS FILLER4
XFILLER_92_974 VSS VDD FILLER2
X_17617_ _19045_/CK _17617_/D _17617_/Q VDD VSS DFFQX1
X_14829_ _14827_/B _14829_/B _14829_/C VDD VSS _18584_/D AOI2B1X1
XFILLER_52_849 VSS VDD FILLER2
X_18597_ _19004_/CK _18597_/D _18597_/Q VDD VSS DFFQX1
XFILLER_51_359 VDD VSS FILLER1
X_17548_ _17737_/Q _18526_/Q VDD VSS _17549_/B XNOR2X1
XFILLER_60_882 VDD VSS FILLER1
X_17479_ _17479_/A _17479_/B VDD VSS _17684_/D NOR2X1
XFILLER_20_757 VDD VSS DECAPHV8
XFILLER_81_0 VDD VSS DECAPHV32
XFILLER_118_678 VSS VDD FILLER2
XFILLER_99_551 VSS VDD FILLER2
XFILLER_113_383 VDD VSS FILLER1
XFILLER_119_1061 VDD VSS FILLER4
XFILLER_59_437 VDD VSS FILLER4
XFILLER_87_724 VDD VSS FILLER4
XFILLER_8_1027 VDD VSS FILLER4
X_09804_ _17765_/Q _09810_/C VDD VSS _09920_/A XNOR2X1
XFILLER_101_589 VDD VSS FILLER1
XFILLER_39_161 VDD VSS FILLER4
XFILLER_67_470 VDD VSS FILLER1
XFILLER_68_971 VDD VSS FILLER4
XFILLER_86_267 VSS VDD FILLER2
X_09735_ _19050_/Q _17351_/B VDD VSS _09759_/A NOR2X1
XFILLER_28_846 VDD VSS DECAPHV8
XFILLER_28_868 VDD VSS FILLER1
XFILLER_55_632 VDD VSS DECAPHV16
X_09666_ _09694_/C _09666_/B VDD VSS _17485_/B XNOR2X1
XFILLER_54_131 VSS VDD FILLER2
XFILLER_54_142 VSS VDD FILLER2
XFILLER_55_654 VSS VDD FILLER2
X_09597_ _09812_/A _09597_/B VDD VSS _17777_/D NOR2X1
XFILLER_126_1043 VDD VSS DECAPHV16
XTAP_TAPCELL_ROW_120_1457 VDD VSS WELLTAP
XFILLER_23_595 VDD VSS DECAPHV16
XFILLER_50_381 VDD VSS FILLER4
X_10510_ _10511_/B _10521_/B _17870_/Q VDD VSS _10512_/C AOI21X1
X_11490_ _11546_/A _14077_/B VDD VSS _11558_/A NOR2X1
X_10441_ _17859_/Q _10444_/B VDD VSS _10445_/B XNOR2X1
XFILLER_109_634 VDD VSS FILLER1
XFILLER_40_32 VDD VSS DECAPHV8
XTAP_TAPCELL_ROW_20_262 VDD VSS WELLTAP
XFILLER_108_177 VDD VSS FILLER4
XFILLER_124_615 VSS VDD FILLER2
XFILLER_136_453 VDD VSS DECAPHV16
XFILLER_40_65 VDD VSS DECAPHV8
X_10372_ _17849_/Q VDD VSS _10376_/A INVX1
X_13160_ _18396_/Q _13350_/A _13350_/B VDD VSS _13161_/D XNOR3X1
XFILLER_105_840 VSS VDD FILLER2
X_12111_ _18308_/Q VDD VSS _12176_/C INVX1
X_13091_ wire27/Y _13091_/B _13091_/C _13091_/D VDD VSS _14095_/B AO211X2
XFILLER_105_873 VDD VSS DECAPHV8
XFILLER_85_1060 VDD VSS FILLER1
X_12042_ _12042_/A _12042_/B _18124_/Q VDD VSS _12045_/C OAI21X1
Xclkbuf_2_2__f__002_ clkbuf_0__002_/Y VDD VSS clkload26/A BUFX12
XFILLER_46_1066 VSS VDD FILLER2
XTAP_TAPCELL_ROW_131_1586 VDD VSS WELLTAP
XFILLER_104_394 VDD VSS DECAPHV16
XFILLER_120_843 VSS VDD FILLER2
XFILLER_133_1058 VDD VSS DECAPHV32
X_16850_ _16850_/A _16850_/B _16850_/C VDD VSS _16851_/B NOR3X1
XFILLER_19_824 VSS VDD FILLER2
XTAP_TAPCELL_ROW_76_925 VDD VSS WELLTAP
X_16781_ _18059_/Q _18669_/Q VDD VSS _16782_/C AND2X1
X_15801_ _15801_/A _15801_/B _15874_/C VDD VSS _15802_/B NOR3X1
X_13993_ _18951_/Q _13995_/B VDD VSS _13994_/B XNOR2X1
XFILLER_105_80 VDD VSS DECAPHV8
XFILLER_19_835 VSS VDD FILLER2
XFILLER_92_237 VDD VSS FILLER1
XTAP_TAPCELL_ROW_76_936 VDD VSS WELLTAP
X_12944_ _12944_/A _12944_/B _12944_/C _12944_/D VDD VSS _12947_/B OAOI211X1
X_18520_ clkload6/A _18520_/D _18520_/Q VDD VSS DFFQX1
X_15732_ _15663_/Y _15731_/Y _15651_/Y VDD VSS _15738_/B MUXI2X1
XFILLER_46_665 VDD VSS FILLER4
XFILLER_73_462 VSS VDD FILLER2
XFILLER_74_974 VSS VDD FILLER2
XTAP_TAPCELL_ROW_86_1054 VDD VSS WELLTAP
X_18451_ _18478_/CK _18451_/D _18451_/Q VDD VSS DFFQX1
XTAP_TAPCELL_ROW_28_351 VDD VSS WELLTAP
XTAP_TAPCELL_ROW_56_693 VDD VSS WELLTAP
X_12875_ _13089_/A _13089_/B _12875_/C VDD VSS _14151_/C OAI21X1
X_17402_ _17410_/A _17402_/B VDD VSS _17611_/D NOR2X1
X_15663_ _15685_/A _15684_/B _15663_/C _15663_/D VDD VSS _15663_/Y AOAI211X1
XFILLER_14_540 VDD VSS FILLER1
X_11826_ _18383_/Q _11826_/B _12102_/C VDD VSS _11895_/B MIN3X1
X_18382_ _18408_/CK _18382_/D _18382_/Q VDD VSS DFFQX1
X_15594_ _18927_/Q _15607_/B VDD VSS _15594_/Y XOR2X1
X_14614_ _14619_/C _14619_/B VDD VSS _14616_/B NAND2BX1
XFILLER_53_1026 VDD VSS DECAPHV8
XFILLER_60_189 VSS VDD FILLER2
XFILLER_92_1064 VDD VSS FILLER1
X_11757_ _18252_/Q VDD VSS _11759_/A INVX1
X_17333_ _17338_/A _17333_/B VDD VSS _19033_/D NOR2X1
X_14545_ _18524_/Q _18556_/Q VDD VSS _14546_/B XNOR2X1
X_10708_ _10709_/B _10709_/C _17902_/Q VDD VSS _10715_/B AOI21X1
X_17264_ _19010_/Q _17315_/B VDD VSS _17278_/A XOR2X1
X_11688_ _18147_/Q VDD VSS _11774_/A INVX1
X_19003_ _19004_/CK _19003_/D _19003_/Q VDD VSS DFFQX1
X_16215_ _16239_/A _16239_/B _16216_/D _16239_/D VDD VSS _16215_/Y AOI211X1
X_14476_ _14476_/A _14476_/B VDD VSS _14477_/B XNOR2X1
X_10639_ _17888_/Q _10642_/B VDD VSS _10643_/B XNOR2X1
Xclkload127 _18808_/CK VDD VSS clkload127/Y INVX1
Xclkload116 _18818_/CK VDD VSS clkload116/Y INVX1
Xclkload105 _18003_/CK VDD VSS clkload105/Y INVX2
X_17195_ _17195_/A _17195_/B VDD VSS _17198_/B _17195_/C AND3X2
X_13427_ _18451_/Q _13517_/B _13517_/C VDD VSS _13516_/B XNOR3X1
XFILLER_127_464 VDD VSS FILLER1
XTAP_TAPCELL_ROW_97_1183 VDD VSS WELLTAP
X_16146_ _16063_/B _16145_/Y _16155_/A VDD VSS _16448_/B MUX2X1
X_13358_ _13457_/A _13532_/B VDD VSS _14396_/B XNOR2X1
XFILLER_5_282 VDD VSS DECAPHV32
X_12309_ _18284_/Q _12506_/A _12506_/B VDD VSS _12310_/D XNOR3X1
X_16077_ _18839_/Q _18677_/Q VDD VSS _16082_/B OR2X2
XFILLER_130_607 VDD VSS FILLER4
X_13289_ _13289_/A _13289_/B _13289_/C _13289_/D VDD VSS _13473_/A AOI31X1
X_15028_ _15028_/A _15029_/C _15028_/C VDD VSS _18627_/D AOI21X1
XFILLER_64_1133 VSS VDD FILLER2
XFILLER_84_716 VDD VSS DECAPHV8
XFILLER_65_952 VDD VSS FILLER1
X_09520_ _09812_/A _09520_/B VDD VSS _17774_/D NOR2X1
X_18718_ _18853_/CK _18718_/D _18718_/Q VDD VSS DFFQX1
X_16979_ _18938_/Q _17019_/C VDD VSS _16980_/C NAND2X1
XFILLER_36_142 VDD VSS DECAPHV16
XFILLER_37_654 VDD VSS FILLER1
XFILLER_37_676 VDD VSS FILLER1
XFILLER_64_473 VDD VSS FILLER4
XFILLER_80_922 VDD VSS FILLER4
XFILLER_80_944 VDD VSS DECAPHV16
XFILLER_92_793 VDD VSS FILLER4
X_09451_ _17745_/Q _17713_/Q VDD VSS _09452_/B XNOR2X1
X_18649_ _18838_/CK _18649_/D _18649_/Q VDD VSS DFFQX1
XFILLER_24_337 VDD VSS FILLER1
XFILLER_40_808 VSS VDD FILLER2
XFILLER_51_134 VDD VSS FILLER4
X_09382_ _09380_/B _09382_/B _09382_/C VDD VSS _17769_/D AOI2B1X1
XFILLER_51_189 VDD VSS FILLER1
XFILLER_71_1115 VDD VSS FILLER1
XTAP_TAPCELL_ROW_106_1290 VDD VSS WELLTAP
XFILLER_20_510 VDD VSS FILLER1
XFILLER_32_370 VDD VSS FILLER1
XFILLER_118_453 VSS VDD FILLER2
XFILLER_119_998 VDD VSS DECAPHV16
XFILLER_134_979 VDD VSS DECAPHV32
XFILLER_69_1099 VSS VDD FILLER2
XFILLER_0_948 VDD VSS DECAPHV32
XFILLER_87_510 VDD VSS DECAPHV8
XFILLER_102_865 VDD VSS FILLER1
XFILLER_114_692 VSS VDD FILLER2
XFILLER_56_952 VSS VDD FILLER2
XFILLER_74_226 VDD VSS FILLER4
X_09718_ _09718_/A _09718_/B _09718_/C VDD VSS _09741_/A OA21X2
XFILLER_16_816 VDD VSS FILLER1
XFILLER_56_963 VSS VDD FILLER2
XFILLER_56_974 VSS VDD FILLER2
XFILLER_76_1004 VSS VDD FILLER2
X_10990_ _17957_/Q _10990_/B VDD VSS _10991_/C AND2X1
XFILLER_35_32 VDD VSS DECAPHV32
XFILLER_55_484 VDD VSS FILLER1
XFILLER_71_944 VDD VSS DECAPHV8
XFILLER_76_1026 VDD VSS FILLER1
XFILLER_76_1037 VDD VSS FILLER4
X_09649_ _09677_/B _09649_/B VDD VSS _17348_/B NAND2BX1
XFILLER_70_443 VDD VSS FILLER1
XFILLER_71_977 VDD VSS DECAPHV8
XFILLER_82_292 VDD VSS DECAPHV8
XTAP_TAPCELL_ROW_25_321 VDD VSS WELLTAP
X_12660_ _18183_/Q VDD VSS _12756_/A INVX1
XFILLER_30_307 VSS VDD FILLER2
XTAP_TAPCELL_ROW_53_652 VDD VSS WELLTAP
X_11611_ _11612_/B _11612_/C _11668_/A VDD VSS _11678_/A OAI21X1
XTAP_TAPCELL_ROW_81_994 VDD VSS WELLTAP
X_12591_ _18495_/Q _12591_/B _14479_/B VDD VSS _12916_/B MIN3X1
X_14330_ _14423_/A _14330_/B VDD VSS _18368_/D AND2X1
XFILLER_128_206 VDD VSS DECAPHV16
X_11542_ _11574_/A _14135_/B VDD VSS _11623_/A NOR2X1
XFILLER_129_0 VDD VSS DECAPHV32
XFILLER_51_64 VDD VSS DECAPHV16
XFILLER_52_1081 VSS VDD FILLER2
X_11473_ _11473_/A _11473_/B _14189_/B VDD VSS _14220_/A MIN3X1
X_14261_ _14296_/A _14261_/B _14261_/C VDD VSS _18310_/D NOR3X1
XTAP_TAPCELL_ROW_133_1615 VDD VSS WELLTAP
X_10424_ _17856_/Q _10427_/A VDD VSS _10425_/B XNOR2X1
X_13212_ _13303_/A _13303_/B _13303_/D VDD VSS _13229_/B OAI21X1
X_16000_ _16042_/D _16042_/C VDD VSS _16002_/D NOR2BX1
X_14192_ _14253_/A VDD VSS _14217_/A BUFX3
XFILLER_100_1068 VDD VSS FILLER1
XFILLER_13_1098 VDD VSS FILLER4
X_13143_ _13260_/A _13260_/B _13260_/C VDD VSS _13330_/B OAI21X1
XFILLER_112_607 VDD VSS DECAPHV16
XFILLER_124_456 VSS VDD FILLER2
XFILLER_2_230 VSS VDD FILLER2
XFILLER_3_742 VSS VDD FILLER2
XFILLER_98_819 VDD VSS FILLER1
X_10355_ _10359_/A _10359_/B VDD VSS _10539_/A NOR2X1
X_10286_ _10287_/B _10287_/C _17840_/Q VDD VSS _10295_/B AOI21X1
X_13074_ _13074_/A _14207_/B _13074_/C _13074_/D VDD VSS _13297_/A AOAI211X1
X_17951_ _17982_/CK _17951_/D _17951_/Q VDD VSS DFFQX1
XFILLER_104_180 VSS VDD FILLER2
XFILLER_111_128 VDD VSS DECAPHV32
XFILLER_120_640 VDD VSS FILLER1
X_12025_ _12025_/A _12025_/B _12025_/C _12025_/D VDD VSS _12137_/B AOAI211X1
X_17882_ _17908_/CK _17882_/D _17882_/Q VDD VSS DFFQX1
X_16902_ _16910_/A _16902_/B VDD VSS _16907_/C XNOR2X1
XFILLER_66_738 VDD VSS FILLER1
XFILLER_78_587 VDD VSS FILLER1
X_16833_ _16633_/Y _16921_/B _16947_/A VDD VSS _16842_/B MUX2X1
XFILLER_18_142 VSS VDD FILLER2
XFILLER_19_654 VSS VDD FILLER2
XFILLER_65_248 VDD VSS FILLER4
XFILLER_93_557 VDD VSS FILLER1
X_16764_ _16698_/Y _16802_/B _16819_/A VDD VSS _16832_/B MUXI2X1
X_13976_ _14013_/C VDD VSS _14008_/C BUFX3
XFILLER_46_462 VDD VSS FILLER4
XFILLER_74_793 VDD VSS FILLER4
XFILLER_80_229 VSS VDD FILLER2
X_12927_ _12927_/A _12927_/B _14391_/B VDD VSS _13020_/A MIN3X1
X_18503_ _18505_/CK _18503_/D _18503_/Q VDD VSS DFFQX1
X_16695_ _16715_/A _16715_/B _16778_/A VDD VSS _16696_/B AOI21X1
X_15715_ _18887_/Q _15715_/B _15715_/C VDD VSS _15718_/A MIN3X1
XFILLER_33_123 VSS VDD FILLER2
XFILLER_62_955 VDD VSS FILLER1
X_12858_ _13010_/A _13010_/B _13010_/C VDD VSS _12907_/B AOI21X1
X_18434_ _18436_/CK _18434_/D _18434_/Q VDD VSS DFFQX1
X_15646_ _18931_/Q _15682_/C VDD VSS _15646_/Y XNOR2X1
X_11809_ _18305_/Q _11916_/B _11837_/C VDD VSS _14317_/B XNOR3X1
X_18365_ _18417_/CK _18365_/D _18365_/Q VDD VSS DFFQX1
XFILLER_33_189 VDD VSS FILLER1
XTAP_TAPCELL_ROW_99_1201 VDD VSS WELLTAP
X_12789_ _18237_/Q _12977_/A _13071_/B VDD VSS _12962_/D XNOR3X1
X_17316_ _19019_/Q _17316_/B _17317_/B VDD VSS _17317_/C AOI2B1X1
X_15577_ _15587_/B _15577_/B VDD VSS _16991_/A XNOR2X1
XFILLER_30_874 VDD VSS FILLER1
XTAP_TAPCELL_ROW_99_1212 VDD VSS WELLTAP
X_18296_ _18376_/CK _18296_/D _18296_/Q VDD VSS DFFQX1
X_14528_ _14526_/B _14528_/B _14528_/C VDD VSS _18520_/D AOI2B1X1
X_17247_ _19007_/Q _17260_/B VDD VSS _17251_/C XNOR2X1
X_14459_ _14972_/A _14459_/B _14459_/C VDD VSS _18481_/D NOR3X1
XFILLER_128_762 VSS VDD FILLER2
X_17178_ _17226_/C VDD VSS _17316_/B BUFX3
X_16129_ _16129_/A VDD VSS _16158_/C INVX1
XFILLER_116_979 VDD VSS DECAPHV8
XFILLER_44_0 VDD VSS DECAPHV32
XFILLER_130_415 VSS VDD FILLER2
X_08951_ _08952_/A _08952_/B _08952_/D _08952_/C VDD VSS _08954_/C AOI211X1
XFILLER_111_640 VDD VSS DECAPHV8
XFILLER_97_863 VDD VSS DECAPHV8
X_08882_ _17736_/Q _18525_/Q VDD VSS _17547_/A XNOR2X1
XFILLER_97_896 VSS VDD FILLER2
XFILLER_84_546 VSS VDD FILLER2
XFILLER_37_451 VDD VSS DECAPHV8
XFILLER_53_900 VDD VSS DECAPHV8
XFILLER_37_484 VDD VSS FILLER4
XFILLER_53_933 VDD VSS DECAPHV16
XFILLER_65_771 VDD VSS FILLER1
X_09503_ _17714_/Q _17746_/Q _09503_/C VDD VSS _09530_/C AOI2B1X1
XFILLER_52_421 VDD VSS FILLER4
X_09434_ _09441_/B _09434_/B VDD VSS _17340_/B XNOR2X1
XFILLER_24_178 VSS VDD FILLER2
Xclkbuf_leaf_14__000_ clkbuf_leaf_9__000_/A VDD VSS _18787_/CK BUFX12
XFILLER_33_690 VDD VSS DECAPHV16
XTAP_TAPCELL_ROW_50_622 VDD VSS WELLTAP
X_09365_ _17678_/Q _17473_/B VDD VSS _09390_/B XOR2X1
XFILLER_36_1065 VDD VSS FILLER4
XFILLER_36_1076 VDD VSS DECAPHV16
X_09296_ _09297_/A _09297_/B _09297_/C VDD VSS _09296_/Y NOR3X1
XFILLER_123_1068 VSS VDD FILLER2
XFILLER_119_751 VSS VDD FILLER2
XFILLER_119_762 VDD VSS FILLER1
XFILLER_21_34 VDD VSS FILLER1
XFILLER_0_723 VDD VSS DECAPHV32
XFILLER_122_927 VDD VSS FILLER1
XFILLER_133_253 VDD VSS DECAPHV16
XFILLER_79_318 VSS VDD FILLER2
X_10140_ _17819_/Q _10149_/B _10149_/C VDD VSS _10330_/B XNOR3X1
XFILLER_88_841 VDD VSS FILLER1
X_10071_ _17810_/Q _10075_/B VDD VSS _10076_/B XOR2X1
XFILLER_43_1036 VDD VSS FILLER1
XFILLER_29_941 VDD VSS DECAPHV16
XTAP_TAPCELL_ROW_58_711 VDD VSS WELLTAP
XFILLER_28_440 VDD VSS FILLER1
XFILLER_47_259 VSS VDD FILLER2
X_13830_ _13840_/A _14431_/B _13861_/C VDD VSS _14433_/B OA21X2
XFILLER_16_624 VDD VSS DECAPHV32
XFILLER_44_933 VSS VDD FILLER2
XFILLER_56_793 VDD VSS FILLER4
X_10973_ _11148_/A _11112_/B VDD VSS _17980_/D AND2X1
Xmax_cap32 _15771_/Y VDD VSS _16076_/A BUFX3
X_13761_ _18325_/Q _14280_/B VDD VSS _13762_/B AND2X1
XFILLER_43_432 VDD VSS FILLER1
XFILLER_44_944 VDD VSS FILLER1
XTAP_TAPCELL_ROW_83_1013 VDD VSS WELLTAP
X_12712_ _12712_/A _12712_/B _14388_/B VDD VSS _12713_/B MIN3X1
X_16480_ _16470_/Y _16480_/B _16480_/C VDD VSS _16480_/Y OR3BX1
X_15500_ _15686_/A _15500_/B VDD VSS _15501_/C NAND2X1
XFILLER_102_81 VDD VSS DECAPHV32
XFILLER_15_178 VDD VSS FILLER1
XFILLER_43_476 VDD VSS FILLER4
XFILLER_70_240 VDD VSS DECAPHV8
XFILLER_70_262 VDD VSS FILLER1
X_15431_ _15397_/Y _15430_/Y _16657_/D VDD VSS _15431_/Y MUX2X1
X_13692_ _13754_/A _13754_/B _13754_/C VDD VSS _13727_/B AOI21X1
X_12643_ _12746_/A _12652_/B _12652_/C VDD VSS _14205_/C OR3BX1
X_12574_ _18313_/Q _12619_/B _12844_/D VDD VSS _12723_/C XNOR3X1
X_18150_ _18200_/CK _18150_/D _18150_/Q VDD VSS DFFQX1
X_15362_ _18905_/Q wire35/Y VDD VSS _15413_/B XNOR2X1
XFILLER_129_537 VDD VSS FILLER4
X_11525_ _18249_/Q _11600_/B _14191_/B VDD VSS _14222_/B XNOR3X1
X_18081_ _18805_/CK _18081_/D _18081_/Q VDD VSS DFFQX1
X_17101_ _18014_/Q _17101_/B VDD VSS _17103_/A NAND2X1
X_15293_ _15295_/A _18034_/Q VDD VSS _18833_/D AND2X1
X_14313_ _14313_/A _14313_/B VDD VSS _18354_/D NOR2X1
X_17032_ _17036_/C _17033_/B _17043_/A VDD VSS _17033_/C OAI21X1
X_14244_ _14243_/Y _14244_/B _14244_/C VDD VSS _18294_/D AND3BX1
X_11456_ _18196_/Q _11456_/B _11603_/C VDD VSS _11476_/B XNOR3X1
XTAP_TAPCELL_ROW_94_1142 VDD VSS WELLTAP
X_10407_ _17852_/Q _10407_/B VDD VSS _10412_/C _10407_/C NAND3X1
X_11387_ _11437_/A _11437_/B _11437_/C VDD VSS _11408_/B OAI21X1
X_14175_ _14396_/A _14175_/B VDD VSS _18234_/D AND2X1
XFILLER_125_787 VDD VSS FILLER4
XFILLER_125_798 VDD VSS DECAPHV16
XFILLER_3_561 VDD VSS DECAPHV32
XFILLER_98_616 VDD VSS FILLER1
X_10338_ _10338_/A _10338_/B VDD VSS _10343_/B NOR2X1
X_13126_ _13195_/A _13195_/B _13195_/C VDD VSS _13187_/C OAI21X1
X_18983_ _18985_/CK _18983_/D _18983_/Q VDD VSS DFFQX1
X_13057_ _13170_/A _13170_/B _13170_/D _13170_/C VDD VSS _14331_/C AOI211X1
X_17934_ _17961_/CK _17934_/D _17934_/Q VDD VSS DFFQX1
XFILLER_79_885 VDD VSS FILLER1
X_10269_ _17565_/A _10468_/B VDD VSS _17863_/D NOR2X1
X_12008_ _18281_/Q VDD VSS _12076_/A INVX1
X_17865_ _17865_/CK _17865_/D _17865_/Q VDD VSS DFFQX1
X_17796_ _19038_/CK _17796_/D _17796_/Q VDD VSS DFFQX1
X_16816_ _16829_/A _16829_/B VDD VSS _16825_/A NAND2X1
XFILLER_35_933 VDD VSS FILLER4
XFILLER_53_207 VDD VSS FILLER1
XFILLER_93_398 VDD VSS DECAPHV8
XFILLER_94_899 VDD VSS FILLER1
X_16747_ _16746_/Y _16775_/B _16866_/A VDD VSS _16767_/A AOI2B1X1
X_13959_ _13959_/A _13959_/B VDD VSS _14013_/C NAND2X1
XFILLER_59_1054 VSS VDD FILLER2
XTAP_TAPCELL_ROW_36_449 VDD VSS WELLTAP
XFILLER_35_977 VDD VSS DECAPHV8
X_16678_ _16678_/A _16678_/B _16678_/C VDD VSS _16746_/A NOR3X1
XFILLER_21_126 VDD VSS FILLER4
XFILLER_50_958 VDD VSS FILLER4
XTAP_TAPCELL_ROW_103_1260 VDD VSS WELLTAP
X_18417_ _18417_/CK _18417_/D _18417_/Q VDD VSS DFFQX1
X_15629_ _18879_/Q _15792_/D _15752_/C _16997_/A VDD VSS _18879_/D AO22X2
X_09150_ _17605_/Q _09150_/B _17395_/B VDD VSS _09174_/A MIN3X1
X_18348_ _18376_/CK _18348_/D _18348_/Q VDD VSS DFFQX1
X_09081_ _17568_/Q _17357_/B VDD VSS _09082_/B XOR2X1
X_18279_ _18358_/CK _18279_/D _18279_/Q VDD VSS DFFQX1
XTAP_TAPCELL_ROW_0_1 VDD VSS WELLTAP
XFILLER_128_570 VDD VSS FILLER1
XFILLER_116_765 VDD VSS DECAPHV8
XFILLER_66_1025 VSS VDD FILLER2
XTAP_TAPCELL_ROW_8_119 VDD VSS WELLTAP
X_09983_ _10166_/A _10166_/B _10176_/C _09983_/D VDD VSS _10203_/A OAOI211X1
X_08934_ _17746_/Q _18535_/Q VDD VSS _08935_/C NAND2X1
XFILLER_130_267 VDD VSS DECAPHV32
XFILLER_69_340 VDD VSS DECAPHV8
XFILLER_57_535 VDD VSS FILLER1
XFILLER_84_310 VDD VSS FILLER1
XFILLER_42_1080 VSS VDD FILLER2
XFILLER_38_793 VDD VSS DECAPHV8
XFILLER_44_218 VSS VDD FILLER2
XFILLER_26_966 VSS VDD FILLER2
XFILLER_53_741 VSS VDD FILLER2
XFILLER_41_925 VDD VSS FILLER1
XFILLER_125_1119 VDD VSS DECAPHV8
XFILLER_12_115 VDD VSS DECAPHV8
XFILLER_52_284 VDD VSS FILLER1
XTAP_TAPCELL_ROW_63_780 VDD VSS WELLTAP
X_09417_ _17647_/Q _17440_/B _09417_/C VDD VSS _09428_/A AOI2B1X1
X_09348_ _09348_/A _09357_/B VDD VSS _17370_/B XNOR2X1
XFILLER_32_44 VSS VDD FILLER2
XFILLER_32_77 VDD VSS FILLER4
XTAP_TAPCELL_ROW_117_1418 VDD VSS WELLTAP
X_09279_ _09279_/A _09279_/B VDD VSS _09307_/B NAND2X1
X_11310_ _11383_/A _11383_/B _11383_/C VDD VSS _11341_/A AOI21X1
XFILLER_101_1130 VSS VDD FILLER2
XFILLER_107_710 VDD VSS FILLER4
XTAP_TAPCELL_ROW_3_59 VDD VSS WELLTAP
X_12290_ _18387_/Q _12290_/B _14354_/B VDD VSS _14384_/B XNOR3X1
XFILLER_107_743 VDD VSS FILLER1
X_11241_ _18965_/Q _18086_/Q VDD VSS _11278_/C XNOR2X1
XFILLER_107_798 VDD VSS DECAPHV16
XFILLER_10_1068 VDD VSS FILLER1
XFILLER_134_562 VSS VDD FILLER2
X_11172_ _11174_/A _11174_/B VDD VSS _17119_/B XNOR2X1
X_10123_ _17816_/Q _10123_/B VDD VSS _10127_/C _10123_/C NAND3X1
XFILLER_121_245 VSS VDD FILLER2
X_15980_ _15980_/A _15980_/B _15980_/C _16180_/A VDD VSS _15981_/C AOI31X1
XFILLER_0_575 VDD VSS DECAPHV8
XFILLER_88_693 VDD VSS FILLER4
X_10054_ _10054_/A _10054_/B _10054_/C VDD VSS _10061_/A AOI21X1
X_14931_ _14935_/C _14931_/B VDD VSS _14932_/B XNOR2X1
XFILLER_36_708 VDD VSS FILLER1
XFILLER_57_96 VDD VSS DECAPHV32
XFILLER_75_354 VSS VDD FILLER2
XTAP_TAPCELL_ROW_128_1558 VDD VSS WELLTAP
X_17650_ _19045_/CK _17650_/D _17650_/Q VDD VSS DFFQX1
X_14862_ _14863_/C _17554_/C _14862_/C VDD VSS _18591_/D AND3BX1
X_17581_ _19034_/CK _17581_/D _17581_/Q VDD VSS DFFQX1
X_16601_ _16875_/A _16601_/B _16601_/C VDD VSS _18914_/D OAI21X1
X_13813_ _18483_/Q _13860_/A _13860_/B VDD VSS _13814_/D XNOR3X1
XFILLER_113_80 VDD VSS DECAPHV8
XFILLER_17_933 VSS VDD FILLER2
Xclkbuf_leaf_9__002_ clkbuf_leaf_9__002_/A VDD VSS _18171_/CK BUFX12
X_16532_ _16934_/A _16568_/A VDD VSS _16559_/A NAND2X1
X_14793_ _14796_/C _14793_/B _14793_/C VDD VSS _18576_/D AOI21X1
X_10956_ _10956_/A _10956_/B _10956_/C VDD VSS _10960_/C MIN3X1
X_13744_ _14339_/A _14339_/B _14339_/C VDD VSS _13746_/B OAI21X1
XFILLER_71_571 VSS VDD FILLER2
XTAP_TAPCELL_ROW_33_419 VDD VSS WELLTAP
X_10887_ _10891_/C _10891_/B VDD VSS _10888_/B NOR2BX1
X_16463_ _16463_/A _16463_/B _16463_/C _16463_/D VDD VSS _16464_/B OA211X2
X_13675_ _13675_/A _14370_/B _13675_/C VDD VSS _14371_/C NOR3X1
XFILLER_31_468 VDD VSS DECAPHV8
X_12626_ _12626_/A _12626_/B _12626_/C _12626_/D VDD VSS _14204_/B AOAI211X1
X_18202_ _18252_/CK _18202_/D _18202_/Q VDD VSS DFFQX1
X_16394_ _18793_/Q _18739_/Q VDD VSS _16396_/C NAND2X1
X_15414_ _18906_/Q _16783_/D VDD VSS _15415_/B XNOR2X1
XFILLER_12_682 VDD VSS DECAPHV8
X_18133_ _18985_/CK _18133_/D _18133_/Q VDD VSS DFFQX1
X_15345_ _16784_/A _15345_/B VDD VSS _15346_/B XNOR2X1
XTAP_TAPCELL_ROW_13_176 VDD VSS WELLTAP
X_12557_ _12669_/A _12669_/B VDD VSS _12756_/B NOR2X1
X_11508_ _11509_/B _11509_/C _18196_/Q VDD VSS _11544_/B AOI21X1
X_12488_ _18442_/Q _12593_/B _12593_/C VDD VSS _12706_/B MIN3X1
X_18064_ _18066_/CK _18064_/D _18064_/Q VDD VSS DFFQX1
X_15276_ _15304_/A _18844_/Q VDD VSS _18817_/D AND2X1
X_11439_ _18143_/Q VDD VSS _11478_/A INVX1
X_17015_ _17015_/A _17017_/B _17015_/C VDD VSS _18958_/D OAI21X1
X_14227_ _14252_/A _14227_/B VDD VSS _18280_/D NOR2X1
XFILLER_99_914 VSS VDD FILLER2
X_14158_ _14372_/A _14158_/B VDD VSS _18218_/D AND2X1
XFILLER_4_881 VSS VDD FILLER2
XFILLER_98_81 VDD VSS DECAPHV32
X_13109_ _13112_/A _13112_/B _13112_/D _13112_/C VDD VSS _14067_/A OA211X2
XFILLER_67_800 VDD VSS DECAPHV16
XFILLER_98_479 VSS VDD FILLER2
X_18966_ _18966_/CK _18966_/D _18966_/Q VDD VSS DFFQX1
Xclkbuf_leaf_13__001_ clkload75/A VDD VSS _18011_/CK BUFX12
X_14089_ _14074_/Y _14089_/B _14089_/C VDD VSS _18154_/D AND3BX1
X_17917_ _17941_/CK _17917_/D _17917_/Q VDD VSS DFFQX1
X_18897_ _18913_/CK _18897_/D _18897_/Q VDD VSS DFFQX1
XFILLER_113_1056 VDD VSS FILLER1
XFILLER_66_343 VDD VSS FILLER4
XFILLER_94_641 VDD VSS DECAPHV8
X_17848_ _17901_/CK _17848_/D _17848_/Q VDD VSS DFFQX1
XFILLER_94_696 VDD VSS FILLER1
XFILLER_96_1029 VDD VSS FILLER1
XFILLER_81_346 VDD VSS FILLER1
XFILLER_93_195 VDD VSS FILLER1
Xclkbuf_leaf_28__001_ clkbuf_2_1__f__001_/Y VDD VSS _17669_/CK BUFX12
X_17779_ _17851_/CK _17779_/D _17779_/Q VDD VSS DFFQX1
XFILLER_50_700 VDD VSS DECAPHV8
XFILLER_62_593 VSS VDD FILLER2
XFILLER_90_891 VSS VDD FILLER2
X_09202_ _17671_/Q _17466_/B VDD VSS _09203_/D OR2X2
X_09133_ _09134_/A _09134_/B _09134_/C VDD VSS _09159_/B OA21X2
XFILLER_120_1005 VDD VSS FILLER4
XFILLER_129_890 VSS VDD FILLER2
X_09064_ _09033_/A _09064_/B _09064_/C VDD VSS _09103_/C AOI2B1X1
XFILLER_116_595 VDD VSS DECAPHV8
XTAP_TAPCELL_ROW_112_1359 VDD VSS WELLTAP
XFILLER_44_1131 VDD VSS FILLER1
XFILLER_77_608 VDD VSS FILLER4
XFILLER_89_468 VDD VSS DECAPHV16
X_09966_ _10166_/A _10166_/B _10176_/C VDD VSS _10179_/B OAI21X1
XFILLER_131_598 VSS VDD FILLER2
XFILLER_69_170 VSS VDD FILLER2
X_08917_ _17742_/Q _18531_/Q VDD VSS _08918_/C NAND2X1
X_09897_ _09897_/A _09897_/B _09897_/C VDD VSS _10099_/A MIN3X1
XFILLER_40_1017 VDD VSS FILLER1
XFILLER_57_321 VDD VSS FILLER1
XFILLER_58_866 VDD VSS FILLER1
XFILLER_72_368 VDD VSS FILLER4
X_10810_ _10844_/A _10947_/B VDD VSS _17948_/D NOR2X1
X_11790_ _18976_/Q _18097_/Q VDD VSS _11954_/C XNOR2X1
XFILLER_14_936 VSS VDD FILLER2
XFILLER_43_32 VDD VSS DECAPHV32
X_10741_ _11148_/A _10870_/B VDD VSS _17934_/D AND2X1
XFILLER_13_468 VDD VSS FILLER4
XFILLER_41_766 VSS VDD FILLER2
XFILLER_9_406 VSS VDD FILLER2
XTAP_TAPCELL_ROW_123_1499 VDD VSS WELLTAP
X_13460_ _13460_/A _14424_/B _13517_/C _13460_/D VDD VSS _13605_/A OAOI211X1
XFILLER_40_287 VDD VSS FILLER1
XFILLER_41_799 VDD VSS FILLER1
XFILLER_51_1102 VDD VSS DECAPHV8
X_10672_ _17043_/A _10811_/B VDD VSS _17922_/D AND2X1
X_12411_ _12411_/A _12411_/B _12411_/C _12411_/D VDD VSS _12502_/B AOAI211X1
X_13391_ _18294_/Q _14244_/B VDD VSS _13392_/D _14244_/C NAND3X1
XTAP_TAPCELL_ROW_10_135 VDD VSS WELLTAP
X_12342_ _18180_/Q VDD VSS _12343_/A INVX1
X_15130_ _15295_/A _18700_/Q VDD VSS _18673_/D AND2X1
XFILLER_111_0 VDD VSS DECAPHV32
X_12273_ _12385_/B _12293_/B VDD VSS _14355_/B XOR2X1
X_15061_ _15065_/A _15062_/B _17455_/A VDD VSS _15062_/C OAI21X1
XFILLER_107_573 VSS VDD FILLER2
XFILLER_49_1042 VSS VDD FILLER2
XTAP_TAPCELL_ROW_91_1112 VDD VSS WELLTAP
X_11224_ _18032_/Q _11224_/B _11224_/C VDD VSS _18032_/D AOI21X1
X_14012_ _18959_/Q _14012_/B VDD VSS _14013_/B XOR2X1
XFILLER_107_584 VDD VSS FILLER1
XFILLER_122_510 VDD VSS FILLER1
XFILLER_122_521 VDD VSS DECAPHV8
XFILLER_134_392 VDD VSS DECAPHV16
XFILLER_1_840 VDD VSS DECAPHV32
XFILLER_68_40 VDD VSS FILLER4
XFILLER_96_906 VDD VSS FILLER1
XFILLER_96_928 VDD VSS DECAPHV8
X_11155_ _11155_/A _11155_/B _11155_/C VDD VSS _11161_/C AO21X2
X_18820_ _18848_/CK _18820_/D _18820_/Q VDD VSS DFFQX1
XFILLER_0_350 VDD VSS DECAPHV8
XFILLER_136_1078 VSS VDD FILLER2
X_10106_ _10106_/A _10106_/B VDD VSS _10107_/C NOR2X1
X_11086_ _11086_/A VDD VSS _11087_/C INVX1
X_18751_ _18805_/CK _18751_/D _18751_/Q VDD VSS DFFQX1
X_15963_ _18836_/Q _18674_/Q VDD VSS _15967_/D AND2X1
XTAP_TAPCELL_ROW_66_809 VDD VSS WELLTAP
X_10037_ _10033_/A _10037_/B VDD VSS _10038_/A NOR2BX1
X_17702_ _17706_/CK _17702_/D _17702_/Q VDD VSS DFFQX1
X_14914_ _14917_/A _14914_/B _14914_/C VDD VSS _18602_/D AOI21X1
X_18682_ _18846_/CK _18682_/D _18682_/Q VDD VSS DFFQX1
X_15894_ _15919_/A _15919_/B _15919_/C _15917_/A VDD VSS _15895_/D AOI31X1
XFILLER_17_741 VSS VDD FILLER2
XFILLER_63_324 VDD VSS FILLER1
XFILLER_64_858 VDD VSS FILLER4
XFILLER_75_195 VDD VSS FILLER4
XFILLER_90_121 VSS VDD FILLER2
XTAP_TAPCELL_ROW_89_1085 VDD VSS WELLTAP
X_17633_ _17701_/CK _17633_/D _17633_/Q VDD VSS DFFQX1
X_14845_ _18588_/Q _18620_/Q VDD VSS _14846_/B XNOR2X1
XFILLER_17_752 VDD VSS DECAPHV16
XFILLER_32_700 VSS VDD FILLER2
XFILLER_63_368 VDD VSS FILLER4
XFILLER_90_154 VSS VDD FILLER2
XTAP_TAPCELL_ROW_18_235 VDD VSS WELLTAP
XTAP_TAPCELL_ROW_46_566 VDD VSS WELLTAP
X_11988_ _18489_/Q _11991_/C VDD VSS _11990_/B XOR2X1
X_17564_ _17564_/A _17564_/B VDD VSS _17565_/B XNOR2X1
X_14776_ _18572_/Q _18604_/Q _14776_/C VDD VSS _14780_/B MIN3X1
XFILLER_17_796 VDD VSS FILLER4
XFILLER_90_198 VDD VSS DECAPHV8
XFILLER_95_1062 VSS VDD FILLER2
X_10939_ _10942_/C _10942_/B VDD VSS _10940_/B NOR2BX1
X_16515_ _18052_/Q _18662_/Q VDD VSS _16517_/B XNOR2X1
X_13727_ _13750_/A _13727_/B _13754_/D VDD VSS _13798_/C XNOR3X1
XFILLER_16_295 VDD VSS DECAPHV16
X_17495_ _17499_/A _17495_/B VDD VSS _17699_/D NOR2X1
X_16446_ _16373_/B _16445_/Y _16630_/A VDD VSS _16446_/Y MUX2X1
X_13658_ _13659_/A _13659_/B _15309_/A VDD VSS _13659_/C OAI21X1
XFILLER_31_287 VDD VSS DECAPHV8
XFILLER_9_951 VDD VSS FILLER1
X_12609_ _14296_/B _14296_/C _12610_/A VDD VSS _12611_/C OAI21X1
X_16377_ _16711_/A _16669_/B _16377_/C VDD VSS _16424_/B OAI21X1
X_13589_ _18452_/Q _14426_/B VDD VSS _13602_/A NAND2X1
XFILLER_117_326 VDD VSS DECAPHV8
XFILLER_9_995 VSS VDD FILLER2
X_18116_ _18971_/CK _18116_/D _18116_/Q VDD VSS DFFQX1
X_15328_ _18859_/Q _172_/E _15793_/C VDD VSS wire30/A NOR3BX1
X_18047_ _18848_/CK _18047_/D _18047_/Q VDD VSS DFFQX1
X_15259_ _15286_/A _18827_/Q VDD VSS _18800_/D AND2X1
XFILLER_126_882 VDD VSS FILLER1
XFILLER_113_543 VDD VSS DECAPHV8
XFILLER_87_917 VDD VSS FILLER1
XFILLER_99_788 VSS VDD FILLER2
X_09820_ _17768_/Q _17769_/Q _17770_/Q _09821_/C VDD VSS _09829_/C AND4X2
XFILLER_58_129 VDD VSS FILLER4
XFILLER_86_438 VDD VSS FILLER4
X_09751_ _09751_/A _09751_/B _17453_/B VDD VSS _09767_/C MIN3X1
X_18949_ _18950_/CK _18949_/D _18949_/Q VDD VSS DFFQX1
XFILLER_67_641 VDD VSS FILLER1
XFILLER_104_49 VDD VSS DECAPHV32
XFILLER_55_825 VDD VSS FILLER1
XFILLER_66_162 VDD VSS FILLER1
XFILLER_94_460 VDD VSS FILLER1
X_09682_ _15326_/C _09682_/B _09707_/B VDD VSS _17780_/D NOR3X1
XFILLER_54_324 VDD VSS FILLER1
XFILLER_55_858 VSS VDD FILLER2
XFILLER_74_1124 VDD VSS DECAPHV8
XFILLER_81_176 VDD VSS DECAPHV8
Xfanout47 _17453_/A VDD VSS _17446_/A BUFX3
Xfanout58 _11148_/A VDD VSS _11062_/A BUFX3
Xfanout69 _15286_/A VDD VSS _17182_/D BUFX3
XFILLER_109_805 VDD VSS DECAPHV8
XFILLER_109_849 VDD VSS DECAPHV8
X_09116_ _09218_/A _09116_/B VDD VSS _17759_/D NOR2X1
XFILLER_136_668 VDD VSS FILLER4
X_09047_ _09047_/A _09047_/B VDD VSS _17355_/B XNOR2X1
XFILLER_135_189 VDD VSS DECAPHV32
XTAP_TAPCELL_ROW_0_16 VDD VSS WELLTAP
XFILLER_81_1106 VDD VSS FILLER1
XFILLER_89_265 VSS VDD FILLER2
XFILLER_131_362 VDD VSS DECAPHV8
XFILLER_77_438 VDD VSS FILLER4
X_09949_ _09949_/A _09949_/B VDD VSS _10157_/B NOR2X1
XFILLER_38_32 VDD VSS DECAPHV8
XFILLER_38_65 VDD VSS FILLER4
XFILLER_86_994 VSS VDD FILLER2
X_12960_ _12960_/A _12960_/B _12960_/C VDD VSS _13011_/B XNOR3X1
XFILLER_72_121 VDD VSS FILLER1
XFILLER_73_622 VDD VSS FILLER4
XTAP_TAPCELL_ROW_125_1517 VDD VSS WELLTAP
X_11911_ _11911_/A _14350_/A _14320_/B VDD VSS _12006_/B MIN3X1
X_12891_ _12891_/A _12891_/B _12891_/C _12891_/D VDD VSS _14065_/C AOAI211X1
X_11842_ _18253_/Q _14196_/B VDD VSS _11937_/A NOR2BX1
X_14630_ _14630_/A _14630_/B _14630_/C VDD VSS _14635_/C OAI21X1
XFILLER_14_700 VDD VSS DECAPHV32
XFILLER_73_699 VDD VSS DECAPHV16
X_14561_ _14562_/A _14562_/B _14562_/D _14562_/C VDD VSS _14564_/C AOI211X1
XFILLER_14_766 VDD VSS FILLER1
XFILLER_54_97 VSS VDD FILLER2
XTAP_TAPCELL_ROW_43_536 VDD VSS WELLTAP
XTAP_TAPCELL_ROW_71_867 VDD VSS WELLTAP
X_11773_ _18174_/Q VDD VSS _11845_/A INVX1
X_16300_ _16222_/B _16374_/B _16412_/A VDD VSS _16300_/Y MUXI2X1
X_13512_ _13512_/A _13512_/B _13512_/C VDD VSS _13514_/C NOR3X1
X_10724_ _17905_/Q _10728_/B VDD VSS _10725_/B XNOR2X1
X_17280_ _17272_/B _17280_/B VDD VSS _17281_/D NAND2BX1
X_14492_ _15309_/A _14492_/B VDD VSS _18505_/D AND2X1
XFILLER_110_81 VDD VSS DECAPHV32
X_10655_ _10657_/A _10657_/B _10657_/C VDD VSS _10795_/B XNOR3X1
Xclkbuf_leaf_12__002_ clkbuf_leaf_9__002_/A VDD VSS _18978_/CK BUFX12
X_16231_ _16232_/C _16231_/B _16231_/C VDD VSS _18904_/D OAI21X1
X_13443_ _18424_/Q _14396_/B VDD VSS _13519_/A NAND2X1
XFILLER_103_1033 VDD VSS DECAPHV16
XTAP_TAPCELL_ROW_23_293 VDD VSS WELLTAP
Xclkload17 _18989_/CK VDD VSS clkload17/Y INVX6
X_16162_ _18788_/Q _18734_/Q VDD VSS _16245_/C XOR2X1
X_13374_ _14367_/A _14367_/B _14367_/C _13374_/D VDD VSS _13544_/A OAOI211X1
XTAP_TAPCELL_ROW_136_1646 VDD VSS WELLTAP
XTAP_TAPCELL_ROW_136_1657 VDD VSS WELLTAP
XTAP_TAPCELL_ROW_136_1668 VDD VSS WELLTAP
X_10586_ _10630_/A _10717_/B VDD VSS _17904_/D NOR2X1
X_12325_ _18232_/Q VDD VSS _12422_/C INVX1
Xclkload39 _18195_/CK VDD VSS clkload39/Y BUFX12
Xclkload28 _18431_/CK VDD VSS clkload28/Y INVX2
X_15113_ _15309_/A _18684_/Q VDD VSS _18657_/D AND2X1
XFILLER_103_1088 VDD VSS DECAPHV8
X_16093_ _18041_/Q _18651_/Q VDD VSS _16094_/A XNOR2X1
X_12256_ _12356_/A _12356_/B _12356_/C VDD VSS _14058_/B NOR3X1
Xclkbuf_leaf_27__002_ clkload27/A VDD VSS _18381_/CK BUFX12
X_15044_ _18630_/Q _19008_/Q _15044_/C VDD VSS _15048_/B MIN3X1
XFILLER_69_917 VDD VSS DECAPHV8
X_11207_ _17154_/A _17155_/B VDD VSS _18025_/D AND2X1
X_12187_ _18465_/Q _12284_/B _14471_/B VDD VSS _12191_/C XNOR3X1
XFILLER_95_224 VSS VDD FILLER2
X_11138_ _17985_/Q _11138_/B VDD VSS _11141_/D NOR2BX1
X_18803_ _18857_/CK _18803_/D _18803_/Q VDD VSS DFFQX1
XFILLER_110_546 VDD VSS FILLER4
XTAP_TAPCELL_ROW_79_967 VDD VSS WELLTAP
X_16995_ _18947_/Q _17007_/B VDD VSS _16996_/C NAND2X1
XFILLER_3_1106 VDD VSS DECAPHV8
XFILLER_64_611 VDD VSS FILLER1
XFILLER_76_471 VSS VDD FILLER2
XFILLER_83_419 VSS VDD FILLER2
X_11069_ _11069_/A _11069_/B _11069_/C VDD VSS _11202_/B MIN3X1
X_18734_ _18815_/CK _18734_/D _18734_/Q VDD VSS DFFQX1
X_15946_ _15950_/A _15950_/B VDD VSS _15948_/B XNOR2X1
XFILLER_110_1015 VDD VSS FILLER1
XFILLER_37_847 VDD VSS FILLER1
XFILLER_64_633 VDD VSS FILLER4
X_18665_ _18856_/CK _18665_/D _18665_/Q VDD VSS DFFQX1
X_15877_ _15931_/A _15931_/B _15931_/C _16161_/C VDD VSS _15877_/Y OAI31X1
XFILLER_64_655 VDD VSS FILLER1
X_17616_ _19045_/CK _17616_/D _17616_/Q VDD VSS DFFQX1
X_14828_ _17544_/C _14835_/B VDD VSS _14829_/C NAND2X1
X_18596_ _19004_/CK _18596_/D _18596_/Q VDD VSS DFFQX1
XFILLER_32_530 VDD VSS FILLER1
XFILLER_44_390 VDD VSS FILLER1
X_17547_ _17547_/A _17547_/B _17547_/C VDD VSS _17736_/D AOI21X1
X_14759_ _14760_/A _14761_/C _17266_/C VDD VSS _14760_/C OAI21X1
X_17478_ _17479_/A _17478_/B VDD VSS _17683_/D NOR2X1
X_16429_ _16429_/A _16429_/B _16429_/C _16429_/D VDD VSS _16474_/B OAOI211X1
XFILLER_121_1111 VDD VSS FILLER4
XFILLER_20_769 VSS VDD FILLER2
XFILLER_74_0 VDD VSS DECAPHV32
XFILLER_126_690 VDD VSS FILLER4
XFILLER_132_137 VSS VDD FILLER2
XFILLER_5_80 VDD VSS DECAPHV8
XFILLER_101_513 VSS VDD FILLER2
XFILLER_8_1039 VDD VSS DECAPHV16
X_09803_ _17762_/Q _17763_/Q _17764_/Q _09891_/B VDD VSS _09810_/C AND4X2
XFILLER_101_557 VDD VSS FILLER1
XFILLER_41_1101 VDD VSS DECAPHV8
XFILLER_59_449 VDD VSS DECAPHV16
XFILLER_75_909 VSS VDD FILLER2
XFILLER_86_224 VDD VSS FILLER1
XFILLER_55_611 VDD VSS FILLER1
X_09734_ _09759_/B _09734_/B VDD VSS _17782_/D NOR2X1
XFILLER_27_313 VDD VSS DECAPHV8
XFILLER_39_184 VSS VDD FILLER2
X_09665_ _17753_/Q _17721_/Q VDD VSS _09666_/B XNOR2X1
XFILLER_43_806 VDD VSS FILLER1
XFILLER_94_290 VDD VSS FILLER4
XFILLER_43_828 VSS VDD FILLER2
X_09596_ _09596_/A _09624_/B VDD VSS _09597_/B XOR2X1
XFILLER_54_198 VSS VDD FILLER2
XFILLER_70_669 VDD VSS DECAPHV16
XFILLER_23_552 VDD VSS FILLER1
XFILLER_51_883 VDD VSS FILLER1
XTAP_TAPCELL_ROW_120_1458 VDD VSS WELLTAP
XFILLER_11_747 VDD VSS DECAPHV16
XFILLER_109_624 VDD VSS DECAPHV8
XFILLER_10_235 VDD VSS DECAPHV8
XFILLER_6_206 VDD VSS DECAPHV16
XFILLER_7_718 VDD VSS DECAPHV16
X_10440_ _10440_/A _10440_/B VDD VSS _10445_/A OR2X2
XFILLER_40_44 VSS VDD FILLER2
XTAP_TAPCELL_ROW_20_263 VDD VSS WELLTAP
XFILLER_109_668 VDD VSS FILLER1
XFILLER_40_77 VSS VDD FILLER2
X_10371_ _10371_/A _10543_/B _10371_/C _10371_/D VDD VSS _10555_/B AOAI211X1
XFILLER_124_649 VDD VSS DECAPHV8
XFILLER_136_498 VDD VSS DECAPHV8
X_12110_ _18334_/Q _12110_/B _14291_/B VDD VSS _12375_/A MIN3X1
X_13090_ _18186_/Q _14122_/B _14122_/C VDD VSS _13097_/D OR3BX1
XFILLER_46_1023 VSS VDD FILLER2
X_12041_ _18124_/Q _12042_/A _12042_/B VDD VSS _12045_/B NOR3X1
Xclkbuf_2_2__f__001_ clkbuf_0__001_/Y VDD VSS clkload74/A BUFX12
XFILLER_104_373 VDD VSS FILLER4
XFILLER_105_885 VSS VDD FILLER2
XFILLER_46_1056 VSS VDD FILLER2
XFILLER_49_64 VDD VSS DECAPHV16
XTAP_TAPCELL_ROW_131_1587 VDD VSS WELLTAP
XFILLER_133_1026 VDD VSS DECAPHV32
XFILLER_120_877 VDD VSS FILLER4
XFILLER_65_408 VSS VDD FILLER2
XTAP_TAPCELL_ROW_76_926 VDD VSS WELLTAP
X_16780_ _18831_/Q _18723_/Q _16780_/C VDD VSS _16783_/C MIN3X1
X_15800_ _15800_/A _15800_/B _16161_/C _15800_/D _15800_/E VDD VSS _15864_/B AOI221X1
X_13992_ _13999_/A _13992_/B _14008_/C _14013_/D VDD VSS _18073_/D OAOI211X1
XFILLER_105_92 VDD VSS FILLER1
XFILLER_18_324 VDD VSS FILLER1
X_12943_ _12943_/A _14328_/B _14328_/C VDD VSS _12944_/D NOR3X1
X_15731_ _15729_/Y _15747_/B VDD VSS _15731_/Y NAND2BX1
XFILLER_45_132 VDD VSS FILLER1
XFILLER_73_430 VDD VSS DECAPHV8
X_18450_ _18505_/CK _18450_/D _18450_/Q VDD VSS DFFQX1
XFILLER_34_839 VDD VSS FILLER1
XFILLER_45_165 VSS VDD FILLER2
XFILLER_65_96 VDD VSS DECAPHV16
XTAP_TAPCELL_ROW_28_352 VDD VSS WELLTAP
XTAP_TAPCELL_ROW_86_1055 VDD VSS WELLTAP
X_12874_ _18184_/Q _14120_/B VDD VSS _13089_/A AND2X1
X_17401_ _17434_/A _17401_/B VDD VSS _17610_/D AND2X1
X_15662_ _15685_/A _15662_/B _15662_/C _15686_/A VDD VSS _15663_/D OAI211X1
XFILLER_121_80 VDD VSS DECAPHV8
XTAP_TAPCELL_ROW_56_694 VDD VSS WELLTAP
X_11825_ _11825_/A _11825_/B _14346_/B VDD VSS _11826_/B MIN3X1
X_18381_ _18381_/CK _18381_/D _18381_/Q VDD VSS DFFQX1
X_15593_ _18925_/Q _18926_/Q VDD VSS _15607_/B _15593_/C NAND3X1
X_14613_ _18538_/Q _18570_/Q VDD VSS _14619_/B NAND2X1
XFILLER_53_1005 VSS VDD FILLER2
X_11756_ _11765_/A _11765_/B _11765_/C VDD VSS _14195_/C NOR3X1
X_17332_ _17338_/A _17332_/B VDD VSS _19032_/D NOR2X1
X_14544_ _14544_/A _14544_/B _14544_/C VDD VSS _14551_/C OA21X2
XFILLER_41_393 VDD VSS FILLER1
XFILLER_53_1049 VDD VSS FILLER4
X_10707_ _10707_/A _10840_/B VDD VSS _17928_/D AND2X1
X_17263_ _17533_/A _17263_/B _17281_/A VDD VSS _19009_/D NOR3X1
X_14475_ _14475_/A _14475_/B VDD VSS _14476_/B XNOR2X1
X_11687_ _18146_/Q _14079_/B _14079_/C VDD VSS _11691_/D OR3BX1
X_19002_ clkload9/A _19002_/D _19002_/Q VDD VSS DFFQX1
X_16214_ _18043_/Q _18653_/Q VDD VSS _16239_/D AND2X1
X_13426_ _18425_/Q _13446_/B _13532_/D VDD VSS _13517_/C XNOR3X1
XFILLER_127_432 VDD VSS FILLER1
X_10638_ _10638_/A _10638_/B _10638_/C _10638_/D VDD VSS _10643_/A AOAI211X1
Xclkload128 _18780_/CK VDD VSS clkload128/Y INVX2
Xclkload117 _18082_/CK VDD VSS clkload117/Y INVX4
Xclkload106 _18025_/CK VDD VSS clkload106/Y BUFX12
X_17194_ _18995_/Q _18996_/Q _17226_/C VDD VSS _17195_/C OAI21X1
XTAP_TAPCELL_ROW_97_1184 VDD VSS WELLTAP
X_10569_ _17876_/Q _10569_/B VDD VSS _10570_/D _10575_/B NAND3X1
X_16145_ _16412_/A _16221_/B _16145_/C VDD VSS _16145_/Y AO21X2
X_13357_ _13512_/A _13512_/B _13512_/C _13357_/D VDD VSS _13528_/A OAOI211X1
XFILLER_115_627 VDD VSS DECAPHV16
X_12308_ _12308_/A _12308_/B _12308_/C _12308_/D VDD VSS _12506_/A AOAI211X1
X_13288_ _14270_/C _18319_/Q _13392_/B VDD VSS _13289_/D AND3BX1
X_16076_ _16076_/A VDD VSS _16412_/A BUFX3
XFILLER_114_137 VSS VDD FILLER2
X_12239_ _18152_/Q _12239_/B _12239_/C VDD VSS _12244_/B XNOR3X1
X_15027_ _15028_/A _15029_/C _17255_/D VDD VSS _15028_/C OAI21X1
XFILLER_111_811 VDD VSS FILLER1
XFILLER_110_332 VDD VSS FILLER1
XFILLER_111_855 VSS VDD FILLER2
XFILLER_111_899 VDD VSS FILLER1
XFILLER_84_728 VSS VDD FILLER2
XFILLER_96_577 VSS VDD FILLER2
X_16978_ _17016_/B VDD VSS _17019_/C BUFX3
XFILLER_110_398 VSS VDD FILLER2
X_18717_ _18852_/CK _18717_/D _18717_/Q VDD VSS DFFQX1
X_15929_ _15967_/A _15929_/B _16326_/A VDD VSS _15934_/B AOI2B1X1
XFILLER_65_964 VDD VSS DECAPHV16
X_09450_ _17509_/B _17712_/Q _09450_/C VDD VSS _09479_/C OAI21X1
XFILLER_37_699 VSS VDD FILLER2
XFILLER_52_625 VDD VSS FILLER4
XFILLER_80_934 VDD VSS FILLER1
X_18648_ _18837_/CK _18648_/D _18648_/Q VDD VSS DFFQX1
XFILLER_17_390 VDD VSS DECAPHV16
XFILLER_91_282 VDD VSS FILLER1
X_09381_ _17434_/A _09384_/B VDD VSS _09382_/C NAND2X1
X_18579_ _18989_/CK _18579_/D _18579_/Q VDD VSS DFFQX1
XFILLER_51_168 VDD VSS DECAPHV8
XTAP_TAPCELL_ROW_106_1291 VDD VSS WELLTAP
XFILLER_20_522 VDD VSS FILLER4
XFILLER_32_393 VDD VSS DECAPHV8
XFILLER_33_894 VDD VSS DECAPHV8
XFILLER_106_627 VDD VSS FILLER1
XFILLER_10_69 VSS VDD FILLER2
XFILLER_133_457 VSS VDD FILLER2
XFILLER_101_321 VDD VSS DECAPHV16
XFILLER_120_129 VDD VSS DECAPHV8
X_09717_ _17690_/Q _17486_/B VDD VSS _09718_/C OR2X2
XFILLER_55_441 VSS VDD FILLER2
XFILLER_43_603 VDD VSS FILLER4
X_09648_ _09648_/A _09648_/B VDD VSS _09649_/B _09648_/C NAND3X1
XTAP_TAPCELL_ROW_25_322 VDD VSS WELLTAP
X_09579_ _17750_/Q _17718_/Q VDD VSS _09606_/A XNOR2X1
XTAP_TAPCELL_ROW_53_653 VDD VSS WELLTAP
X_11610_ _18224_/Q VDD VSS _11668_/A INVX1
X_12590_ _14079_/A _12590_/B _12700_/B VDD VSS _18039_/D NOR3X1
XFILLER_51_691 VDD VSS FILLER1
XTAP_TAPCELL_ROW_81_995 VDD VSS WELLTAP
X_11541_ _11672_/A _11672_/B VDD VSS _14135_/B XNOR2X1
XFILLER_11_555 VSS VDD FILLER2
XFILLER_51_32 VDD VSS DECAPHV32
XFILLER_13_1022 VDD VSS FILLER1
XFILLER_7_548 VDD VSS DECAPHV8
X_11472_ _18249_/Q VDD VSS _11600_/A INVX1
X_14260_ _14269_/A _14260_/B VDD VSS _18309_/D NOR2X1
XFILLER_87_1134 VSS VDD FILLER2
XTAP_TAPCELL_ROW_133_1616 VDD VSS WELLTAP
X_10423_ _10423_/A _10423_/B _10423_/C VDD VSS _10428_/C MIN3X1
X_13211_ _18214_/Q _14154_/B VDD VSS _13303_/D _14154_/C NAND3X1
X_14191_ _14191_/A _14191_/B VDD VSS _18249_/D NOR2X1
XFILLER_136_273 VDD VSS DECAPHV32
X_10354_ _15326_/C _10553_/B _10553_/C VDD VSS _17873_/D NOR3X1
X_13142_ _18447_/Q _13258_/B VDD VSS _13260_/C _13142_/C NAND3X1
XFILLER_4_0 VDD VSS DECAPHV32
XFILLER_98_809 VDD VSS FILLER4
XFILLER_105_671 VDD VSS FILLER1
XFILLER_105_682 VDD VSS FILLER1
X_10285_ _10516_/A _10492_/B VDD VSS _17866_/D NOR2X1
X_13073_ _18238_/Q _14180_/B VDD VSS _13074_/D _14180_/C NAND3X1
X_17950_ _18003_/CK _17950_/D _17950_/Q VDD VSS DFFQX1
X_12024_ _18202_/Q _14140_/B _14140_/C VDD VSS _12032_/D OR3BX1
X_17881_ _17908_/CK _17881_/D _17881_/Q VDD VSS DFFQX1
X_16901_ _16957_/A _16910_/B VDD VSS _16902_/B NOR2X1
XFILLER_65_205 VDD VSS FILLER1
XFILLER_76_40 VDD VSS FILLER4
X_16832_ _16857_/A _16832_/B _16869_/C VDD VSS _16921_/B AOI21BX1
XFILLER_120_696 VDD VSS FILLER1
XFILLER_59_791 VDD VSS FILLER1
XFILLER_65_227 VDD VSS FILLER4
XFILLER_93_536 VSS VDD FILLER2
XFILLER_20_1026 VDD VSS DECAPHV8
XFILLER_58_290 VSS VDD FILLER2
X_18502_ _18505_/CK _18502_/D _18502_/Q VDD VSS DFFQX1
X_16763_ _16732_/Y _16762_/Y _16629_/A VDD VSS _16802_/B MUX2X1
X_13975_ _18944_/Q _13975_/B VDD VSS _13977_/B XOR2X1
XFILLER_34_625 VDD VSS FILLER1
XFILLER_62_912 VDD VSS FILLER4
XFILLER_80_208 VDD VSS FILLER4
XFILLER_94_1105 VDD VSS FILLER4
X_12926_ _12926_/A _12926_/B VDD VSS _14391_/B XNOR2X1
X_16694_ _16715_/A _16715_/B VDD VSS _16694_/Y NOR2X1
X_15714_ _18888_/Q _15719_/B VDD VSS _15716_/A XOR2X1
X_12857_ _12960_/A _14238_/B _14238_/C VDD VSS _13010_/C NOR3X1
X_18433_ _18484_/CK _18433_/D _18433_/Q VDD VSS DFFQX1
X_15645_ _18930_/Q _15645_/B VDD VSS _15682_/C NOR2BX1
XFILLER_15_872 VSS VDD FILLER2
X_11808_ _18279_/Q _12077_/A _14226_/B VDD VSS _11837_/C XOR3X1
X_18364_ _18417_/CK _18364_/D _18364_/Q VDD VSS DFFQX1
XFILLER_30_820 VSS VDD FILLER2
X_12788_ _12788_/A _12872_/B _12875_/C VDD VSS _13071_/B XNOR3X1
X_17315_ _19019_/Q _17315_/B VDD VSS _17317_/A NAND2X1
X_15576_ _18875_/Q _15587_/C VDD VSS _15577_/B XOR2X1
XTAP_TAPCELL_ROW_99_1202 VDD VSS WELLTAP
X_11739_ _11739_/A _11739_/B _14254_/B VDD VSS _14286_/A MIN3X1
X_18295_ _18295_/CK _18295_/D _18295_/Q VDD VSS DFFQX1
X_14527_ _17544_/C _14534_/B VDD VSS _14528_/C NAND2X1
X_17246_ _17323_/A _17246_/B VDD VSS _19006_/D NOR2X1
X_14458_ _15310_/A _14458_/B VDD VSS _18480_/D AND2X1
X_17177_ _17175_/Y _17193_/A _17182_/D VDD VSS _18993_/D AND3BX1
X_14389_ _14389_/A _14389_/B VDD VSS _18418_/D NOR2X1
X_13409_ _18243_/Q _13491_/A _13491_/B VDD VSS _13482_/C XNOR3X1
X_16128_ _18814_/Q _18706_/Q VDD VSS _16129_/A XOR2X1
XFILLER_115_479 VDD VSS FILLER1
XFILLER_29_1040 VDD VSS FILLER1
XFILLER_97_820 VSS VDD FILLER2
X_08950_ _17750_/Q _18539_/Q VDD VSS _08952_/D XNOR2X1
X_16059_ _16109_/A _16224_/C VDD VSS _16376_/C NAND2X1
XFILLER_102_129 VDD VSS DECAPHV8
XFILLER_111_630 VDD VSS FILLER4
XFILLER_124_991 VDD VSS FILLER1
XFILLER_29_1073 VSS VDD FILLER2
XFILLER_37_0 VDD VSS DECAPHV32
X_08881_ _17737_/Q _18526_/Q VDD VSS _17551_/A NAND2X1
XFILLER_29_1095 VSS VDD FILLER2
XFILLER_29_408 VDD VSS FILLER1
XFILLER_97_875 VSS VDD FILLER2
XFILLER_111_685 VDD VSS FILLER4
XFILLER_116_1076 VDD VSS FILLER1
XFILLER_84_514 VSS VDD FILLER2
XFILLER_2_81 VDD VSS DECAPHV32
XFILLER_37_441 VDD VSS FILLER4
XTAP_TAPCELL_ROW_108_1320 VDD VSS WELLTAP
X_09502_ _09502_/A _09502_/B VDD VSS _09503_/C NOR2X1
XFILLER_112_49 VDD VSS DECAPHV32
XFILLER_37_463 VSS VDD FILLER2
XFILLER_64_282 VSS VDD FILLER2
X_09433_ _17584_/Q _17373_/B VDD VSS _09434_/B XNOR2X1
XFILLER_53_989 VDD VSS FILLER1
XFILLER_75_1060 VDD VSS FILLER1
X_09364_ _09364_/A _09392_/C VDD VSS _17473_/B XNOR2X1
XTAP_TAPCELL_ROW_50_623 VDD VSS WELLTAP
X_09295_ _19034_/Q _17334_/B VDD VSS _09297_/C XNOR2X1
XFILLER_20_396 VDD VSS FILLER1
XTAP_TAPCELL_ROW_30_380 VDD VSS WELLTAP
XFILLER_133_221 VDD VSS DECAPHV32
XFILLER_106_479 VSS VDD FILLER2
XFILLER_121_416 VDD VSS DECAPHV8
XFILLER_43_1004 VDD VSS FILLER4
XFILLER_88_831 VDD VSS DECAPHV8
X_10070_ _17809_/Q _10070_/B VDD VSS _10076_/A NAND2X1
XFILLER_0_768 VDD VSS DECAPHV32
XFILLER_102_641 VDD VSS FILLER1
XFILLER_130_950 VDD VSS FILLER4
XFILLER_43_1026 VDD VSS DECAPHV8
XFILLER_87_341 VDD VSS FILLER4
XFILLER_102_685 VDD VSS DECAPHV8
XTAP_TAPCELL_ROW_58_712 VDD VSS WELLTAP
XFILLER_101_184 VSS VDD FILLER2
XFILLER_46_32 VDD VSS DECAPHV8
XFILLER_75_569 VDD VSS DECAPHV16
XFILLER_28_485 VDD VSS DECAPHV8
XFILLER_46_65 VDD VSS DECAPHV8
X_10972_ _10972_/A _10972_/B VDD VSS _11112_/B XNOR2X1
Xmax_cap33 _15771_/Y VDD VSS _16107_/A BUFX3
X_13760_ _13762_/D _13762_/C _13707_/B VDD VSS _14310_/A AOI21BX1
XFILLER_15_102 VDD VSS FILLER4
XFILLER_43_422 VDD VSS DECAPHV8
XTAP_TAPCELL_ROW_38_480 VDD VSS WELLTAP
XTAP_TAPCELL_ROW_83_1014 VDD VSS WELLTAP
X_12711_ _18391_/Q _12714_/A _14358_/B VDD VSS _14388_/B XNOR3X1
X_13691_ _14340_/B _13746_/C _18376_/Q VDD VSS _13754_/C AND3BX1
XFILLER_15_168 VDD VSS DECAPHV8
XFILLER_44_989 VDD VSS FILLER1
XFILLER_71_786 VDD VSS FILLER4
X_12642_ _18234_/Q _14175_/B VDD VSS _12746_/A NAND2X1
X_15430_ _18917_/Q _15430_/B VDD VSS _15430_/Y XOR2X1
XFILLER_12_820 VSS VDD FILLER2
XFILLER_30_105 VDD VSS DECAPHV8
XFILLER_62_97 VDD VSS DECAPHV8
X_12573_ _18287_/Q _12846_/A _12845_/B VDD VSS _12844_/D XNOR3X1
X_15361_ _18904_/Q _15485_/B VDD VSS _15413_/A NAND2X1
XFILLER_12_886 VDD VSS DECAPHV8
X_11524_ _18275_/Q VDD VSS _11594_/A INVX1
X_18080_ _18082_/CK _18080_/D _18080_/Q VDD VSS DFFQX1
X_17100_ _17100_/A VDD VSS _17101_/B INVX1
X_15292_ _15295_/A _18033_/Q VDD VSS _18832_/D AND2X1
X_14312_ _14377_/A _14312_/B VDD VSS _18353_/D AND2X1
X_11455_ _18170_/Q _11455_/B _11537_/D VDD VSS _11603_/C XNOR3X1
X_17031_ _18002_/Q _17031_/B VDD VSS _17033_/B XNOR2X1
X_14243_ _14361_/A VDD VSS _14243_/Y BUFX3
X_10406_ _17853_/Q _10414_/A _10414_/B VDD VSS _10412_/D XNOR3X1
XTAP_TAPCELL_ROW_94_1143 VDD VSS WELLTAP
X_11386_ _18168_/Q _14103_/B _14103_/C VDD VSS _11437_/C OR3BX1
X_14174_ _14174_/A _14174_/B _14174_/C VDD VSS _18233_/D NOR3X1
X_10337_ _10513_/A _10513_/B _10523_/C _10337_/D VDD VSS _10541_/A OAOI211X1
X_13125_ _18239_/Q _14181_/B VDD VSS _13195_/C _14181_/C NAND3X1
X_18982_ _18982_/CK _18982_/D _18982_/Q VDD VSS DFFQX1
XFILLER_124_287 VDD VSS FILLER1
X_10268_ _10268_/A _10468_/B VDD VSS _17862_/D NOR2X1
X_13056_ _13056_/A _13056_/B _13056_/C _13056_/D VDD VSS _14331_/B OAOI211X1
X_17933_ _17961_/CK _17933_/D _17933_/Q VDD VSS DFFQX1
XFILLER_61_1115 VDD VSS FILLER1
XFILLER_66_503 VDD VSS FILLER1
X_12007_ _12007_/A _12007_/B _14290_/B VDD VSS _12110_/B MIN3X1
X_10199_ _10196_/A _10208_/B _10208_/C VDD VSS _10385_/C AND3BX1
X_17864_ _17865_/CK _17864_/D _17864_/Q VDD VSS DFFQX1
X_17795_ _19038_/CK _17795_/D _17795_/Q VDD VSS DFFQX1
X_16815_ _16815_/A _16815_/B VDD VSS _16829_/B _16815_/C NAND3X1
XFILLER_59_1011 VDD VSS DECAPHV8
XFILLER_81_539 VDD VSS DECAPHV8
X_16746_ _16746_/A _16746_/B VDD VSS _16746_/Y NAND2X1
X_13958_ _18939_/Q _18938_/Q VDD VSS _13961_/B XNOR2X1
XFILLER_19_485 VDD VSS FILLER1
X_12909_ _18368_/Q _13056_/A _13170_/B VDD VSS _13021_/D XNOR3X1
X_18416_ _18461_/CK _18416_/D _18416_/Q VDD VSS DFFQX1
X_16677_ _18916_/Q _16677_/B VDD VSS _16706_/A AND2X1
X_13889_ _18511_/Q _14498_/B VDD VSS _13913_/A AND2X1
XTAP_TAPCELL_ROW_103_1250 VDD VSS WELLTAP
X_15628_ _15640_/B _15628_/B VDD VSS _16997_/A XNOR2X1
X_18347_ _18376_/CK _18347_/D _18347_/Q VDD VSS DFFQX1
X_15559_ _15529_/Y _15558_/Y _15596_/A VDD VSS _15612_/B MUXI2X1
X_09080_ _19022_/Q _09083_/B _17320_/B _19021_/Q VDD VSS _09089_/A OAI211X1
X_18278_ _18337_/CK _18278_/D _18278_/Q VDD VSS DFFQX1
XTAP_TAPCELL_ROW_0_2 VDD VSS WELLTAP
X_17229_ _17229_/A _17229_/B VDD VSS _19003_/D AND2X1
XFILLER_116_700 VDD VSS DECAPHV16
XFILLER_115_232 VDD VSS FILLER4
XTAP_TAPCELL_ROW_8_109 VDD VSS WELLTAP
XFILLER_104_917 VDD VSS FILLER1
XFILLER_115_276 VSS VDD FILLER2
X_09982_ _09964_/A _09982_/B VDD VSS _09983_/D NOR2BX1
XFILLER_130_235 VDD VSS DECAPHV32
XFILLER_131_747 VSS VDD FILLER2
XFILLER_88_149 VDD VSS FILLER1
XTAP_TAPCELL_ROW_114_1390 VDD VSS WELLTAP
X_08933_ _08935_/A _08935_/B _08933_/C VDD VSS _17746_/D AOI21X1
XFILLER_57_514 VDD VSS FILLER1
XFILLER_45_709 VDD VSS DECAPHV16
XFILLER_84_366 VDD VSS DECAPHV16
XFILLER_37_271 VDD VSS FILLER1
XFILLER_16_57 VDD VSS FILLER1
XFILLER_38_1106 VDD VSS DECAPHV8
XFILLER_41_915 VDD VSS DECAPHV8
XFILLER_52_252 VSS VDD FILLER2
X_09416_ _09402_/A _09416_/B VDD VSS _09431_/B NOR2BX1
XFILLER_125_1109 VDD VSS FILLER4
XFILLER_16_79 VDD VSS FILLER1
XFILLER_40_425 VSS VDD FILLER2
XFILLER_41_959 VDD VSS DECAPHV8
XTAP_TAPCELL_ROW_63_770 VDD VSS WELLTAP
X_09347_ _17613_/Q _17404_/B VDD VSS _09357_/B XNOR2X1
X_09278_ _09261_/A _09278_/B VDD VSS _09279_/B NAND2BX1
XTAP_TAPCELL_ROW_117_1419 VDD VSS WELLTAP
XTAP_TAPCELL_ROW_3_49 VDD VSS WELLTAP
XFILLER_4_315 VDD VSS DECAPHV8
XFILLER_5_827 VDD VSS DECAPHV8
XFILLER_119_593 VDD VSS FILLER1
X_11240_ _11240_/A _11240_/B _11240_/C _11240_/D VDD VSS _11278_/B AOAI211X1
X_11171_ _17992_/Q _11175_/B VDD VSS _11174_/B XNOR2X1
XFILLER_122_736 VDD VSS FILLER1
X_10122_ _17817_/Q _10128_/A _10128_/B VDD VSS _10127_/D XNOR3X1
XFILLER_0_543 VDD VSS DECAPHV32
XFILLER_122_769 VDD VSS FILLER4
XFILLER_87_171 VDD VSS DECAPHV8
X_10053_ _10053_/A _10053_/B VDD VSS _10054_/C NOR2X1
X_14930_ _18606_/Q _18638_/Q VDD VSS _14931_/B XNOR2X1
XFILLER_57_64 VDD VSS DECAPHV16
XFILLER_76_867 VDD VSS FILLER1
X_14861_ _14861_/A _14861_/B _14861_/C _14861_/D VDD VSS _14862_/C AOAI211X1
XFILLER_21_1132 VDD VSS FILLER4
XFILLER_63_506 VDD VSS DECAPHV16
XFILLER_91_815 VDD VSS FILLER4
XTAP_TAPCELL_ROW_128_1559 VDD VSS WELLTAP
X_17580_ _19034_/CK _17580_/D _17580_/Q VDD VSS DFFQX1
X_16600_ _18914_/Q _16862_/B VDD VSS _16601_/C NAND2X1
X_13812_ _18457_/Q _13861_/B _13861_/C VDD VSS _13860_/B XNOR3X1
XFILLER_28_271 VSS VDD FILLER2
XFILLER_29_794 VDD VSS FILLER1
Xclkbuf_leaf_9__001_ clkload74/A VDD VSS _17913_/CK BUFX12
X_16531_ _16531_/A _16531_/B VDD VSS _16568_/A _16531_/C NAND3X1
X_14792_ _14796_/C _14793_/B _17318_/C VDD VSS _14793_/C OAI21X1
XFILLER_113_92 VDD VSS FILLER1
XFILLER_71_561 VDD VSS FILLER4
XTAP_TAPCELL_ROW_33_409 VDD VSS WELLTAP
X_10955_ _17950_/Q VDD VSS _10956_/A INVX1
X_13743_ _18430_/Q VDD VSS _13790_/A INVX1
XFILLER_43_274 VDD VSS FILLER4
XFILLER_73_96 VDD VSS DECAPHV16
X_10886_ _17937_/Q _10886_/B VDD VSS _10891_/B NOR2X1
X_16462_ _16463_/A _16463_/B _16463_/D _16463_/C VDD VSS _16549_/B OAOI211X1
X_13674_ _13674_/A _13674_/B _13674_/C VDD VSS _14371_/B AOI21X1
X_12625_ _18286_/Q _14234_/B VDD VSS _12631_/C _14234_/C NAND3X1
X_18201_ _18252_/CK _18201_/D _18201_/Q VDD VSS DFFQX1
X_16393_ _18794_/Q _18740_/Q VDD VSS _16397_/A XNOR2X1
X_15413_ _15413_/A _15413_/B VDD VSS _15417_/B XNOR2X1
XFILLER_106_1042 VDD VSS FILLER4
XFILLER_12_650 VDD VSS DECAPHV32
X_12556_ _12661_/A _14091_/B VDD VSS _12669_/A NOR2X1
X_18132_ _18985_/CK _18132_/D _18132_/Q VDD VSS DFFQX1
X_15344_ _18864_/Q _15344_/B VDD VSS _15345_/B NOR2BX1
XFILLER_106_1064 VDD VSS FILLER4
XFILLER_106_1086 VDD VSS FILLER4
XFILLER_129_346 VDD VSS DECAPHV16
XFILLER_12_694 VSS VDD FILLER2
XTAP_TAPCELL_ROW_13_177 VDD VSS WELLTAP
X_11507_ _11602_/A _11603_/B _11603_/C VDD VSS _11509_/C OR3BX1
XFILLER_89_1037 VSS VDD FILLER2
XFILLER_89_1048 VSS VDD FILLER2
XFILLER_8_687 VDD VSS DECAPHV8
X_12487_ _18416_/Q _12602_/B _12491_/C VDD VSS _12593_/C XNOR3X1
X_18063_ _18066_/CK _18063_/D _18063_/Q VDD VSS DFFQX1
X_15275_ _15304_/A _18843_/Q VDD VSS _18816_/D AND2X1
X_11438_ _11603_/A _11603_/B VDD VSS _11456_/B NOR2X1
X_17014_ _18958_/Q _17016_/B VDD VSS _17015_/C NAND2X1
X_14226_ _14252_/A _14226_/B VDD VSS _18279_/D NOR2X1
XFILLER_125_552 VDD VSS FILLER1
X_11369_ _18220_/Q _11417_/B _11422_/C VDD VSS _11374_/C XNOR3X1
X_14157_ _14157_/A _14157_/B _15326_/C VDD VSS _18217_/D AOI21X1
XFILLER_113_747 VDD VSS DECAPHV16
XFILLER_3_370 VSS VDD FILLER2
XFILLER_98_447 VDD VSS FILLER1
X_13108_ _13108_/A VDD VSS _13112_/B INVX1
XFILLER_6_1104 VDD VSS DECAPHV16
X_18965_ _18966_/CK _18965_/D _18965_/Q VDD VSS DFFQX1
Xclkbuf_leaf_13__000_ clkbuf_leaf_9__000_/A VDD VSS _18841_/CK BUFX12
X_14088_ _14129_/A _14088_/B VDD VSS _18153_/D NOR2X1
XFILLER_39_514 VDD VSS FILLER1
XFILLER_66_300 VDD VSS DECAPHV8
XFILLER_67_834 VSS VDD FILLER2
X_13039_ _18473_/Q _14485_/A _13039_/C VDD VSS _13151_/B MIN3X1
X_17916_ _17941_/CK _17916_/D _17916_/Q VDD VSS DFFQX1
X_18896_ _18913_/CK _18896_/D _18896_/Q VDD VSS DFFQX1
XFILLER_39_569 VSS VDD FILLER2
X_17847_ _17901_/CK _17847_/D _17847_/Q VDD VSS DFFQX1
XFILLER_26_208 VDD VSS FILLER4
XFILLER_81_303 VDD VSS FILLER4
XFILLER_94_664 VDD VSS FILLER4
XFILLER_19_271 VSS VDD FILLER2
XFILLER_19_282 VDD VSS FILLER1
X_17778_ _17851_/CK _17778_/D _17778_/Q VDD VSS DFFQX1
XFILLER_34_252 VDD VSS DECAPHV8
XFILLER_35_775 VSS VDD FILLER2
XFILLER_81_369 VSS VDD FILLER2
X_16729_ _18058_/Q _18668_/Q VDD VSS _16730_/B XOR2X1
XFILLER_22_425 VDD VSS FILLER4
XFILLER_34_274 VDD VSS DECAPHV8
XFILLER_50_734 VDD VSS FILLER1
XTAP_TAPCELL_ROW_60_740 VDD VSS WELLTAP
X_09201_ _17639_/Q _09201_/B _17432_/B VDD VSS _09223_/A MIN3X1
XFILLER_50_789 VDD VSS FILLER1
XFILLER_72_1063 VDD VSS FILLER4
XFILLER_72_1074 VDD VSS FILLER1
X_09132_ _17669_/Q _17463_/B VDD VSS _09134_/C XOR2X1
XFILLER_33_1036 VDD VSS FILLER1
XFILLER_72_1096 VDD VSS FILLER4
X_09063_ _17730_/Q _17698_/Q VDD VSS _09064_/C NOR2BX1
XFILLER_104_714 VDD VSS FILLER1
XFILLER_104_725 VDD VSS FILLER1
XFILLER_103_257 VSS VDD FILLER2
XFILLER_131_555 VSS VDD FILLER2
X_09965_ _09970_/C VDD VSS _10176_/C INVX1
XFILLER_97_480 VDD VSS DECAPHV8
X_08916_ _17741_/Q _18530_/Q _17560_/A VDD VSS _17562_/B MIN3X1
X_09896_ _09896_/A _09896_/B VDD VSS _09897_/C XNOR2X1
XFILLER_58_845 VDD VSS FILLER1
XFILLER_58_856 VDD VSS FILLER1
XTAP_TAPCELL_ROW_68_840 VDD VSS WELLTAP
XFILLER_27_78 VDD VSS DECAPHV8
XFILLER_84_174 VDD VSS FILLER4
XFILLER_14_904 VDD VSS FILLER4
XFILLER_26_786 VDD VSS FILLER1
XFILLER_26_797 VSS VDD FILLER2
XFILLER_41_734 VSS VDD FILLER2
XFILLER_53_561 VDD VSS DECAPHV8
X_10740_ _10744_/B _10740_/B VDD VSS _10870_/B XNOR2X1
XTAP_TAPCELL_ROW_123_1489 VDD VSS WELLTAP
X_10671_ _10676_/A _10676_/B VDD VSS _10811_/B XOR2X1
XFILLER_43_88 VDD VSS FILLER4
XFILLER_51_1114 VSS VDD FILLER2
X_12410_ _18337_/Q _14295_/B VDD VSS _12502_/A NAND2X1
XFILLER_21_491 VSS VDD FILLER2
X_13390_ _14244_/B _14244_/C _18294_/Q VDD VSS _13392_/C AOI21X1
XTAP_TAPCELL_ROW_10_136 VDD VSS WELLTAP
X_12341_ _12438_/A _14173_/B VDD VSS _12518_/B NOR2X1
XFILLER_107_530 VDD VSS FILLER4
X_12272_ _18362_/Q _12374_/A _12411_/B VDD VSS _12293_/B XNOR3X1
X_15060_ _15065_/C _15065_/B VDD VSS _15062_/B NAND2BX1
XFILLER_104_0 VDD VSS DECAPHV32
XFILLER_135_872 VDD VSS DECAPHV8
XFILLER_88_1092 VDD VSS FILLER4
XTAP_TAPCELL_ROW_91_1113 VDD VSS WELLTAP
X_11223_ _18032_/Q _11224_/B _17388_/A VDD VSS _11224_/C OAI21X1
X_14011_ _14011_/A _14011_/B _14055_/C VDD VSS _18081_/D AOI21X1
XFILLER_134_360 VDD VSS DECAPHV32
XFILLER_49_1054 VDD VSS DECAPHV8
XFILLER_4_49 VDD VSS DECAPHV32
XFILLER_108_81 VDD VSS DECAPHV32
XFILLER_122_555 VSS VDD FILLER2
X_11154_ _17988_/Q _11154_/B VDD VSS _11155_/C NOR2BX1
XFILLER_110_717 VDD VSS DECAPHV8
XFILLER_89_981 VSS VDD FILLER2
X_10105_ _10114_/A _10475_/B VDD VSS _17840_/D NOR2X1
X_11085_ _17059_/C _17030_/B VDD VSS _18001_/D AND2X1
X_18750_ _18858_/CK _18750_/D _18750_/Q VDD VSS DFFQX1
X_15962_ _15960_/Y _16018_/C _16051_/B VDD VSS _15979_/B OR3BX1
XFILLER_0_395 VDD VSS DECAPHV8
XFILLER_49_856 VDD VSS DECAPHV8
XFILLER_76_653 VDD VSS FILLER4
X_10036_ _09935_/Y _10235_/A _10235_/B VDD VSS _17830_/D AND3BX1
X_18681_ _18844_/CK _18681_/D _18681_/Q VDD VSS DFFQX1
X_17701_ _17701_/CK _17701_/D _17701_/Q VDD VSS DFFQX1
X_14913_ _14917_/A _14914_/B _17318_/C VDD VSS _14914_/C OAI21X1
XFILLER_84_40 VDD VSS FILLER4
X_17632_ _17698_/CK _17632_/D _17632_/Q VDD VSS DFFQX1
X_15893_ _15919_/A _15919_/B _15919_/C VDD VSS _15893_/Y AOI21X1
XFILLER_17_720 VSS VDD FILLER2
XFILLER_64_848 VDD VSS FILLER1
XFILLER_75_185 VDD VSS FILLER1
XTAP_TAPCELL_ROW_89_1086 VDD VSS WELLTAP
X_14844_ _14844_/A _14844_/B _14844_/C VDD VSS _14850_/C OA21X2
XTAP_TAPCELL_ROW_18_236 VDD VSS WELLTAP
XTAP_TAPCELL_ROW_46_567 VDD VSS WELLTAP
X_11987_ _12096_/A _12096_/B _14467_/B VDD VSS _11991_/C XNOR3X1
X_17563_ _17743_/Q _18532_/Q VDD VSS _17564_/B XNOR2X1
X_14775_ _18573_/Q _18605_/Q VDD VSS _14780_/A XNOR2X1
XFILLER_16_252 VDD VSS FILLER1
XFILLER_32_723 VSS VDD FILLER2
X_10938_ _17947_/Q _10938_/B VDD VSS _10942_/B NOR2X1
X_17494_ _17498_/A _17730_/Q VDD VSS _17698_/D AND2X1
X_16514_ _18051_/Q _18661_/Q _16514_/C VDD VSS _16535_/C AOI21X1
X_13726_ _18403_/Q VDD VSS _13750_/A INVX1
XFILLER_108_1115 VDD VSS FILLER1
XFILLER_31_222 VSS VDD FILLER2
XFILLER_32_767 VDD VSS FILLER4
X_16445_ _16411_/B _16444_/Y _16554_/A VDD VSS _16445_/Y MUXI2X1
XFILLER_13_970 VDD VSS DECAPHV8
XFILLER_32_789 VDD VSS FILLER1
XTAP_TAPCELL_ROW_100_1220 VDD VSS WELLTAP
X_10869_ _17934_/Q _10870_/B VDD VSS _10874_/C NAND2X1
X_13657_ _13660_/D _13660_/C VDD VSS _13659_/B NAND2BX1
X_12608_ _18337_/Q _14295_/B VDD VSS _12611_/A AND2X1
X_16376_ _16604_/A _16376_/B _16376_/C _16711_/A VDD VSS _16377_/C OAI211X1
X_13588_ _13651_/A _13588_/B _13653_/C VDD VSS _13649_/B XNOR3X1
XFILLER_117_305 VSS VDD FILLER2
XFILLER_129_176 VDD VSS DECAPHV8
XTAP_TAPCELL_ROW_4_70 VDD VSS WELLTAP
X_12539_ _12656_/A _12552_/B _12552_/C VDD VSS _14147_/C OR3BX1
X_18115_ _18971_/CK _18115_/D _18115_/Q VDD VSS DFFQX1
X_15327_ _15338_/B _172_/E VDD VSS _15337_/B NOR2BX1
XFILLER_117_338 VSS VDD FILLER2
X_18046_ _18846_/CK _18046_/D _18046_/Q VDD VSS DFFQX1
X_15258_ _15318_/A _18826_/Q VDD VSS _18799_/D AND2X1
XFILLER_126_850 VDD VSS DECAPHV16
X_14209_ _14217_/A _14209_/B VDD VSS _18265_/D NOR2X1
X_15189_ _15272_/A _18758_/Q VDD VSS _18731_/D AND2X1
XFILLER_113_555 VSS VDD FILLER2
XFILLER_87_907 VDD VSS DECAPHV8
XFILLER_113_577 VDD VSS FILLER4
XFILLER_115_1119 VDD VSS DECAPHV16
X_09750_ _17659_/Q VDD VSS _09751_/A INVX1
X_18948_ _18958_/CK _18948_/D _18948_/Q VDD VSS DFFQX1
XFILLER_39_333 VDD VSS FILLER4
XFILLER_95_951 VSS VDD FILLER2
X_09681_ _09681_/A _09681_/B _09681_/C VDD VSS _09707_/B OA21X2
XFILLER_39_366 VDD VSS FILLER1
XFILLER_55_804 VDD VSS FILLER1
XFILLER_66_152 VDD VSS FILLER1
X_18879_ _18950_/CK _18879_/D _18879_/Q VDD VSS DFFQX1
XFILLER_39_388 VDD VSS DECAPHV8
XFILLER_66_174 VDD VSS DECAPHV8
XFILLER_81_133 VDD VSS DECAPHV16
XFILLER_35_561 VDD VSS DECAPHV8
XFILLER_63_870 VSS VDD FILLER2
XFILLER_11_907 VDD VSS FILLER1
XFILLER_120_49 VDD VSS DECAPHV32
XFILLER_22_222 VDD VSS FILLER1
Xfanout37 _15799_/B VDD VSS _16784_/A BUFX3
XFILLER_22_266 VDD VSS FILLER1
Xfanout48 hold96/A VDD VSS _17453_/A BUFX3
Xfanout59 hold96/A VDD VSS _11148_/A BUFX3
XFILLER_10_439 VSS VDD FILLER2
X_09115_ _09115_/A _09118_/B VDD VSS _09116_/B XOR2X1
XFILLER_124_809 VDD VSS FILLER4
X_09046_ _17599_/Q _17389_/B VDD VSS _09047_/B XNOR2X1
XFILLER_123_308 VDD VSS DECAPHV16
Xclkbuf_leaf_8__002_ clkbuf_leaf_9__002_/A VDD VSS _18988_/CK BUFX12
XFILLER_117_894 VDD VSS DECAPHV16
XFILLER_132_820 VDD VSS DECAPHV16
XTAP_TAPCELL_ROW_0_17 VDD VSS WELLTAP
XFILLER_131_385 VDD VSS FILLER1
XFILLER_132_886 VDD VSS DECAPHV8
X_09948_ _09949_/A _09949_/B VDD VSS _10157_/C NAND2X1
XFILLER_135_1090 VDD VSS DECAPHV16
XFILLER_38_44 VSS VDD FILLER2
XFILLER_46_826 VDD VSS FILLER4
XFILLER_57_152 VDD VSS FILLER1
XFILLER_86_962 VDD VSS FILLER4
X_09879_ _17785_/Q _09879_/B VDD VSS _09881_/A OR2X2
XFILLER_46_848 VSS VDD FILLER2
XFILLER_46_859 VDD VSS FILLER4
XFILLER_57_185 VDD VSS FILLER1
XTAP_TAPCELL_ROW_125_1518 VDD VSS WELLTAP
X_11910_ _18332_/Q _11913_/B _14289_/B VDD VSS _14320_/B XNOR3X1
X_12890_ _18985_/Q _18106_/Q VDD VSS _12891_/C NOR2X1
XFILLER_54_32 VDD VSS DECAPHV8
X_11841_ _12122_/A _11841_/B VDD VSS _14196_/B XNOR2X1
XFILLER_26_561 VSS VDD FILLER2
XFILLER_60_328 VDD VSS FILLER4
X_11772_ _11931_/A _11931_/B VDD VSS _11798_/B NOR2X1
X_14560_ _18527_/Q _18559_/Q VDD VSS _14562_/D XNOR2X1
XFILLER_41_531 VSS VDD FILLER2
XFILLER_53_380 VDD VSS FILLER4
XTAP_TAPCELL_ROW_43_537 VDD VSS WELLTAP
XTAP_TAPCELL_ROW_71_868 VDD VSS WELLTAP
X_10723_ _10723_/A _10723_/B _10723_/C _10723_/D VDD VSS _10728_/C OAOI211X1
X_13511_ _13511_/A _13511_/B _13511_/C VDD VSS _13514_/B AOI21X1
XFILLER_13_266 VDD VSS FILLER4
XFILLER_14_789 VDD VSS FILLER1
X_14491_ _14361_/Y _14491_/B _14491_/C VDD VSS _18504_/D AND3BX1
X_10654_ _17891_/Q _10654_/B VDD VSS _10657_/C NOR2X1
Xclkbuf_leaf_12__001_ clkload75/A VDD VSS _18016_/CK BUFX12
X_16230_ _18904_/Q _16527_/B VDD VSS _16231_/C NAND2X1
X_13442_ _18451_/Q VDD VSS _13517_/A INVX1
XTAP_TAPCELL_ROW_23_294 VDD VSS WELLTAP
X_10585_ _10722_/B _10722_/C VDD VSS _10717_/B OR2X2
X_16161_ _16218_/A _18761_/Q _16161_/C _16161_/D VDD VSS _16161_/Y AOI22X1
X_13373_ _13373_/A _14335_/B _14335_/C VDD VSS _13374_/D NOR3X1
XFILLER_126_113 VDD VSS DECAPHV16
XFILLER_127_658 VDD VSS DECAPHV16
XTAP_TAPCELL_ROW_136_1647 VDD VSS WELLTAP
XTAP_TAPCELL_ROW_136_1658 VDD VSS WELLTAP
X_12324_ _18259_/Q VDD VSS _12514_/A INVX1
Xclkload29 _18376_/CK VDD VSS clkload29/Y INVX1
Xclkload18 _18959_/CK VDD VSS clkload18/Y INVX2
X_15112_ _15309_/A _18683_/Q VDD VSS _18656_/D AND2X1
XFILLER_108_861 VDD VSS FILLER4
XFILLER_115_809 VDD VSS FILLER1
XFILLER_119_80 VDD VSS DECAPHV8
XFILLER_6_966 VDD VSS DECAPHV8
XTAP_TAPCELL_ROW_136_1669 VDD VSS WELLTAP
Xclkbuf_leaf_27__001_ clkbuf_2_1__f__001_/Y VDD VSS _17701_/CK BUFX12
X_16092_ _18040_/Q _18650_/Q VDD VSS _16096_/D AND2X1
X_12255_ _12255_/A _12255_/B _12261_/A _12255_/D VDD VSS _12356_/C AOI211X1
X_15043_ _18631_/Q _19009_/Q VDD VSS _15048_/A XNOR2X1
XFILLER_123_864 VDD VSS FILLER4
X_11206_ _11206_/A _11206_/B _11206_/C VDD VSS _17155_/B MIN3X1
X_12186_ _18439_/Q _12283_/B _12283_/C VDD VSS _14471_/B XNOR3X1
XFILLER_110_514 VDD VSS FILLER4
XFILLER_123_875 VSS VDD FILLER2
XFILLER_68_417 VDD VSS FILLER1
XFILLER_69_929 VDD VSS FILLER1
X_11137_ _17985_/Q _11138_/B VDD VSS _11141_/B NAND2BX1
X_18802_ _18857_/CK _18802_/D _18802_/Q VDD VSS DFFQX1
XFILLER_0_170 VDD VSS DECAPHV8
XFILLER_62_1062 VDD VSS FILLER1
XTAP_TAPCELL_ROW_79_968 VDD VSS WELLTAP
X_18733_ _18815_/CK _18733_/D _18733_/Q VDD VSS DFFQX1
X_16994_ _16994_/A _17019_/B _17019_/C _18946_/Q VDD VSS _18946_/D AO22X2
XFILLER_110_569 VSS VDD FILLER2
XFILLER_83_409 VDD VSS FILLER1
X_11068_ _11135_/A _11203_/B VDD VSS _17997_/D NOR2X1
X_15945_ _15945_/A _15945_/B _15945_/C VDD VSS _15950_/B MIN3X1
XFILLER_63_100 VSS VDD FILLER2
XFILLER_77_995 VDD VSS DECAPHV8
X_10019_ _10222_/A _10222_/B _10223_/C VDD VSS _10019_/Y AOI21X1
X_18664_ _18853_/CK _18664_/D _18664_/Q VDD VSS DFFQX1
X_15876_ _18808_/Q _18700_/Q VDD VSS _15931_/C XOR2X1
XFILLER_24_509 VSS VDD FILLER2
XFILLER_91_431 VDD VSS FILLER1
X_18595_ _19004_/CK _18595_/D _18595_/Q VDD VSS DFFQX1
X_17615_ _17680_/CK _17615_/D _17615_/Q VDD VSS DFFQX1
X_14827_ _14829_/B _14827_/B VDD VSS _14835_/B NAND2BX1
X_17546_ _17547_/A _17547_/B _17554_/C VDD VSS _17547_/C OAI21X1
X_14758_ _14758_/A _14906_/A _14758_/C VDD VSS _14761_/C MIN3X1
XFILLER_20_704 VSS VDD FILLER2
XFILLER_32_575 VDD VSS DECAPHV8
X_17477_ _17514_/A _17477_/B VDD VSS _17682_/D AND2X1
X_14689_ _18554_/Q _18586_/Q _14689_/C VDD VSS _14693_/B MIN3X1
X_13709_ _18403_/Q _13727_/B _13754_/D VDD VSS _13751_/C XNOR3X1
X_16428_ _16429_/A _16429_/B _16429_/D _16429_/C VDD VSS _16428_/Y OAI211X1
X_16359_ _16401_/A _16401_/B VDD VSS _16361_/A NOR2X1
XFILLER_118_658 VSS VDD FILLER2
XFILLER_30_1039 VDD VSS FILLER4
XFILLER_67_0 VDD VSS DECAPHV32
X_18029_ _18547_/CK _18029_/D _18029_/Q VDD VSS DFFQX1
XFILLER_59_428 VDD VSS FILLER4
XFILLER_5_92 VDD VSS FILLER1
XFILLER_86_214 VDD VSS FILLER4
X_09802_ _09812_/A _09926_/B VDD VSS _17790_/D NOR2X1
XFILLER_39_130 VDD VSS FILLER1
XFILLER_41_1113 VSS VDD FILLER2
XFILLER_41_1135 VDD VSS FILLER1
X_09733_ _09733_/A _09733_/B _17453_/A VDD VSS _09734_/B OAI21X1
XFILLER_27_303 VSS VDD FILLER2
XFILLER_27_325 VSS VDD FILLER2
X_09664_ _17518_/B _17720_/Q _09664_/C VDD VSS _09694_/C MIN3X1
XFILLER_27_347 VDD VSS FILLER1
XFILLER_54_133 VDD VSS FILLER1
XFILLER_55_656 VDD VSS FILLER1
XFILLER_83_976 VDD VSS FILLER1
X_09595_ _19045_/Q _17346_/B VDD VSS _09624_/B XOR2X1
XFILLER_42_328 VSS VDD FILLER2
XFILLER_23_542 VDD VSS DECAPHV8
XFILLER_39_1042 VDD VSS FILLER4
XTAP_TAPCELL_ROW_120_1459 VDD VSS WELLTAP
XFILLER_126_1067 VSS VDD FILLER2
XFILLER_108_113 VDD VSS DECAPHV16
XTAP_TAPCELL_ROW_20_253 VDD VSS WELLTAP
XTAP_TAPCELL_ROW_20_264 VDD VSS WELLTAP
XFILLER_108_146 VSS VDD FILLER2
XFILLER_124_617 VDD VSS FILLER1
XFILLER_136_444 VDD VSS FILLER4
XFILLER_136_477 VDD VSS FILLER4
X_10370_ _17848_/Q _10370_/B VDD VSS _10371_/D _10370_/C NAND3X1
X_09029_ _17665_/Q _09029_/B _17459_/B VDD VSS _09062_/B MIN3X1
XFILLER_105_842 VDD VSS FILLER1
XFILLER_46_1002 VDD VSS DECAPHV16
X_12040_ _12054_/A _14054_/B _12040_/C VDD VSS _12042_/B AOI21X1
XFILLER_131_160 VDD VSS DECAPHV16
XFILLER_49_32 VDD VSS DECAPHV32
XFILLER_77_203 VDD VSS FILLER4
XFILLER_78_715 VDD VSS FILLER1
XTAP_TAPCELL_ROW_131_1588 VDD VSS WELLTAP
XFILLER_120_834 VSS VDD FILLER2
XFILLER_120_845 VDD VSS FILLER1
XFILLER_132_694 VSS VDD FILLER2
XFILLER_46_1068 VDD VSS FILLER1
XFILLER_74_910 VDD VSS DECAPHV8
XFILLER_77_258 VDD VSS DECAPHV8
X_13991_ _18950_/Q _13991_/B VDD VSS _13992_/B XOR2X1
XTAP_TAPCELL_ROW_76_927 VDD VSS WELLTAP
X_12942_ _14328_/B _14328_/C _12943_/A VDD VSS _12944_/C OAI21X1
X_15730_ _18934_/Q _18935_/Q VDD VSS _15747_/B _15730_/C NAND3X1
XFILLER_65_64 VDD VSS DECAPHV16
XTAP_TAPCELL_ROW_86_1045 VDD VSS WELLTAP
X_15661_ _15673_/A _15661_/B _15686_/A VDD VSS _15663_/C AO21X2
XFILLER_33_317 VDD VSS FILLER1
XFILLER_73_464 VDD VSS FILLER1
XTAP_TAPCELL_ROW_28_353 VDD VSS WELLTAP
XTAP_TAPCELL_ROW_86_1056 VDD VSS WELLTAP
X_12873_ _12902_/A _13089_/B _12875_/C VDD VSS _14151_/B OR3BX1
X_17400_ _17410_/A _17400_/B VDD VSS _17609_/D NOR2X1
X_14612_ _18538_/Q _18570_/Q VDD VSS _14619_/C NOR2X1
XTAP_TAPCELL_ROW_56_695 VDD VSS WELLTAP
X_11824_ _11828_/A _11828_/B _11824_/C VDD VSS _14346_/B XNOR3X1
X_18380_ _18408_/CK _18380_/D _18380_/Q VDD VSS DFFQX1
X_15592_ _18876_/Q _15592_/B _15592_/C VDD VSS _15617_/A AOI21X1
XFILLER_121_92 VDD VSS FILLER1
XFILLER_14_553 VDD VSS DECAPHV8
X_11755_ _11755_/A _11755_/B _11755_/C _11755_/D VDD VSS _11765_/B OAOI211X1
X_17331_ _17434_/A _17331_/B VDD VSS _19031_/D AND2X1
X_14543_ _18523_/Q _18555_/Q VDD VSS _14544_/C NAND2X1
XFILLER_81_96 VDD VSS DECAPHV16
X_10706_ _17902_/Q _10706_/B _10715_/A VDD VSS _10840_/B XOR3X1
X_17262_ _17261_/B _17262_/B VDD VSS _17281_/A NOR2BX1
X_14474_ _14480_/A _14474_/B VDD VSS _18492_/D NOR2X1
X_11686_ _18146_/Q _11686_/B _11686_/C VDD VSS _11691_/B XNOR3X1
X_19001_ clkload9/A _19001_/D _19001_/Q VDD VSS DFFQX1
X_16213_ _16286_/A _16238_/A VDD VSS _16216_/D AND2X1
X_13425_ _18399_/Q _13544_/A _13639_/B VDD VSS _13532_/D XNOR3X1
X_10637_ _17887_/Q _10637_/B VDD VSS _10638_/D NAND2X1
Xclkload118 _18066_/CK VDD VSS clkload118/Y INVX8
Xclkload107 _18024_/CK VDD VSS clkload107/Y BUFX12
X_17193_ _17193_/A _17193_/B VDD VSS _17195_/B _17193_/C _17193_/D OR4X1
X_10568_ _10630_/A _10706_/B VDD VSS _17902_/D NOR2X1
Xclkload129 _18805_/CK VDD VSS clkload129/Y INVX2
X_16144_ _16144_/A _16144_/B _16412_/A VDD VSS _16145_/C AOI21X1
X_13356_ _13356_/A _14424_/B _14424_/C VDD VSS _13357_/D NOR3X1
XFILLER_127_477 VDD VSS FILLER4
XFILLER_127_499 VDD VSS FILLER4
XTAP_TAPCELL_ROW_97_1185 VDD VSS WELLTAP
X_10499_ _17868_/Q _10499_/B VDD VSS _10509_/C _10499_/C AND3X2
X_12307_ _18257_/Q _14201_/B VDD VSS _12308_/D _14201_/C NAND3X1
X_13287_ _13287_/A _13287_/B _13287_/C _13287_/D VDD VSS _13392_/B AOAI211X1
X_16075_ _16109_/A VDD VSS _16604_/A BUFX3
X_12238_ _12430_/A _12430_/B _12430_/C VDD VSS _12267_/B AOI21X1
X_15026_ _15026_/A _15026_/B _15026_/C VDD VSS _15029_/C MIN3X1
XFILLER_123_650 VDD VSS FILLER1
XFILLER_64_1135 VDD VSS FILLER1
XFILLER_68_214 VDD VSS FILLER4
XFILLER_96_534 VDD VSS FILLER4
X_12169_ _18283_/Q _12169_/B _14230_/C VDD VSS _12503_/B XNOR3X1
X_16977_ _16977_/A _16984_/B VDD VSS _17016_/B NOR2X1
XFILLER_37_634 VDD VSS DECAPHV16
XFILLER_49_472 VDD VSS FILLER1
X_18716_ _18852_/CK _18716_/D _18716_/Q VDD VSS DFFQX1
X_15928_ _15967_/A _15967_/B VDD VSS _15934_/A NAND2X1
XFILLER_64_442 VDD VSS DECAPHV8
X_18647_ _18837_/CK _18647_/D _18647_/Q VDD VSS DFFQX1
XFILLER_18_881 VSS VDD FILLER2
XFILLER_24_317 VDD VSS FILLER1
XFILLER_65_998 VDD VSS FILLER1
X_15859_ _15897_/A VDD VSS _16180_/A BUFX3
XFILLER_33_840 VDD VSS DECAPHV8
XFILLER_36_188 VDD VSS DECAPHV32
XFILLER_80_979 VDD VSS FILLER1
X_09380_ _09382_/B _09380_/B VDD VSS _09384_/B NAND2BX1
X_18578_ _18641_/CK _18578_/D _18578_/Q VDD VSS DFFQX1
XFILLER_33_873 VDD VSS FILLER1
XTAP_TAPCELL_ROW_106_1292 VDD VSS WELLTAP
X_17529_ _17565_/A _17529_/B VDD VSS _17728_/D NOR2X1
XFILLER_118_400 VDD VSS FILLER1
XFILLER_119_923 VDD VSS FILLER4
XFILLER_20_567 VSS VDD FILLER2
XFILLER_121_609 VSS VDD FILLER2
XFILLER_113_160 VDD VSS DECAPHV16
XFILLER_59_236 VDD VSS FILLER1
XFILLER_113_193 VSS VDD FILLER2
XFILLER_87_556 VSS VDD FILLER2
XFILLER_56_921 VDD VSS DECAPHV8
X_09716_ _09716_/A _09716_/B _09716_/C VDD VSS _09751_/B AO21X2
Xclkbuf_leaf_11__002_ clkbuf_leaf_9__002_/A VDD VSS _18982_/CK BUFX12
XFILLER_55_431 VSS VDD FILLER2
XFILLER_56_954 VDD VSS FILLER1
XFILLER_55_464 VDD VSS FILLER1
XFILLER_70_412 VDD VSS FILLER4
XFILLER_76_1006 VDD VSS FILLER1
X_09647_ _09648_/A _09648_/B _09648_/C VDD VSS _09677_/B AOI21X1
XTAP_TAPCELL_ROW_25_323 VDD VSS WELLTAP
X_09578_ _09578_/A _09578_/B _17446_/B VDD VSS _09588_/A MIN3X1
Xclkbuf_leaf_26__002_ clkload27/A VDD VSS _18358_/CK BUFX12
XFILLER_23_350 VDD VSS FILLER1
XTAP_TAPCELL_ROW_53_654 VDD VSS WELLTAP
XFILLER_11_523 VDD VSS DECAPHV32
XFILLER_51_681 VDD VSS FILLER1
XTAP_TAPCELL_ROW_81_985 VDD VSS WELLTAP
XTAP_TAPCELL_ROW_81_996 VDD VSS WELLTAP
X_11540_ _11602_/A _14133_/B _11540_/C _11540_/D VDD VSS _11672_/A AOAI211X1
XFILLER_13_1012 VDD VSS DECAPHV8
X_11471_ _18274_/Q _11521_/B _11521_/C VDD VSS _11594_/B MIN3X1
XFILLER_109_455 VSS VDD FILLER2
XFILLER_52_1094 VDD VSS DECAPHV8
X_10422_ _10707_/A _10601_/B VDD VSS _17881_/D AND2X1
X_13210_ _13218_/A _14153_/B VDD VSS _14154_/C _13218_/C NAND3X1
X_14190_ _14191_/A _14190_/B VDD VSS _18248_/D NOR2X1
XTAP_TAPCELL_ROW_133_1617 VDD VSS WELLTAP
X_10353_ _10524_/B _10524_/C _10535_/C _10368_/C VDD VSS _10553_/C AOI211X1
X_13141_ _13258_/B _13142_/C _18447_/Q VDD VSS _13260_/B AOI21X1
X_13072_ _14180_/B _14180_/C _18238_/Q VDD VSS _13074_/C AOI21X1
XFILLER_105_650 VDD VSS FILLER1
X_10284_ _17840_/Q _10475_/B _10475_/C VDD VSS _10492_/B XNOR3X1
X_12023_ _12023_/A _12023_/B _12023_/C VDD VSS _12032_/B XNOR3X1
X_16900_ _16939_/A _16900_/B _16890_/B VDD VSS _16910_/B AOI21BX1
XFILLER_120_631 VSS VDD FILLER2
X_17880_ _17908_/CK _17880_/D _17880_/Q VDD VSS DFFQX1
XFILLER_116_81 VDD VSS DECAPHV32
X_16831_ _16857_/A _16957_/B VDD VSS _16869_/C OR2X2
X_16762_ _16778_/A _16762_/B _16762_/C _16762_/D VDD VSS _16762_/Y OAI211X1
XFILLER_18_133 VDD VSS FILLER1
XFILLER_19_656 VDD VSS FILLER1
XFILLER_47_943 VSS VDD FILLER2
XFILLER_58_280 VSS VDD FILLER2
X_18501_ _18505_/CK _18501_/D _18501_/Q VDD VSS DFFQX1
X_15713_ _15637_/B _15685_/B _15651_/Y VDD VSS _15719_/B MUXI2X1
X_13974_ _14011_/A _13974_/B _14055_/C VDD VSS _18066_/D AOI21X1
XFILLER_18_144 VDD VSS FILLER1
XFILLER_34_615 VDD VSS DECAPHV8
XFILLER_62_902 VSS VDD FILLER2
XFILLER_73_261 VSS VDD FILLER2
X_12925_ _18472_/Q _12925_/B _12925_/C VDD VSS _13248_/B MIN3X1
X_16693_ _18801_/Q _18747_/Q _16693_/C VDD VSS _16715_/B MIN3X1
XFILLER_33_125 VDD VSS FILLER1
XFILLER_92_40 VDD VSS FILLER4
X_12856_ _12868_/A _14236_/B _12960_/C VDD VSS _14238_/C NOR3X1
X_18432_ _18484_/CK _18432_/D _18432_/Q VDD VSS DFFQX1
X_15644_ _15644_/A _15644_/B _15644_/C VDD VSS _15666_/B MIN3X1
XFILLER_61_456 VSS VDD FILLER2
XFILLER_62_979 VDD VSS DECAPHV8
X_11807_ _12013_/B _11839_/C VDD VSS _14226_/B NAND2X1
X_18363_ _18417_/CK _18363_/D _18363_/Q VDD VSS DFFQX1
X_15575_ _15651_/A _15575_/B _15575_/C VDD VSS _15587_/C OAI21X1
X_12787_ _13088_/A _12787_/B _13086_/C VDD VSS _12875_/C XNOR3X1
X_17314_ _17323_/A _17314_/B VDD VSS _19019_/D NOR2X1
X_14526_ _14528_/B _14526_/B VDD VSS _14534_/B NAND2BX1
XFILLER_41_180 VDD VSS FILLER4
XTAP_TAPCELL_ROW_99_1203 VDD VSS WELLTAP
X_11738_ _18277_/Q _11738_/B _14224_/B VDD VSS _14254_/B XNOR3X1
X_18294_ _18295_/CK _18294_/D _18294_/Q VDD VSS DFFQX1
XFILLER_31_1112 VDD VSS FILLER4
X_11669_ _11669_/A _11669_/B _14193_/B VDD VSS _11670_/B MIN3X1
X_17245_ _17248_/B _17245_/B VDD VSS _17246_/B XOR2X1
X_14457_ _14972_/A _14457_/B _14457_/C VDD VSS _18479_/D NOR3X1
XFILLER_128_775 VDD VSS FILLER1
X_17176_ _17176_/A _17176_/B _17176_/C _17176_/D VDD VSS _17193_/A OAI211X1
X_14388_ _14389_/A _14388_/B VDD VSS _18417_/D NOR2X1
X_13408_ _13408_/A _13408_/B _13408_/C _13408_/D VDD VSS _13491_/B OAOI211X1
XFILLER_116_948 VDD VSS FILLER4
X_16127_ _18813_/Q _18705_/Q VDD VSS _16158_/A NAND2X1
X_13339_ _13339_/A _13342_/C VDD VSS _13340_/B XNOR2X1
XFILLER_130_417 VDD VSS FILLER1
XFILLER_29_1030 VSS VDD FILLER2
X_16058_ _16144_/A _16144_/B _16802_/A _16058_/D VDD VSS _16376_/B AOAI211X1
XFILLER_69_512 VDD VSS FILLER1
XFILLER_9_1135 VDD VSS FILLER1
X_08880_ _17740_/Q _18529_/Q VDD VSS _17557_/A XNOR2X1
X_15009_ _15009_/A _15009_/B _15009_/C _15009_/D VDD VSS _15010_/C AOAI211X1
XFILLER_69_578 VDD VSS FILLER4
XFILLER_97_898 VDD VSS FILLER1
XFILLER_99_1017 VDD VSS FILLER4
XFILLER_56_239 VSS VDD FILLER2
XFILLER_65_751 VDD VSS FILLER1
XTAP_TAPCELL_ROW_108_1310 VDD VSS WELLTAP
X_09501_ _09482_/A _09501_/B _09501_/C VDD VSS _09533_/B AOI2B1X1
XFILLER_52_412 VDD VSS FILLER4
X_09432_ _09459_/B _09432_/B VDD VSS _17373_/B NOR2BX1
XFILLER_40_607 VDD VSS DECAPHV16
XFILLER_52_456 VSS VDD FILLER2
XFILLER_53_979 VDD VSS DECAPHV8
XFILLER_75_1050 VDD VSS FILLER4
XFILLER_80_787 VSS VDD FILLER2
X_09363_ _17741_/Q _17709_/Q _09363_/C VDD VSS _09392_/C AOI2B1X1
XTAP_TAPCELL_ROW_50_613 VDD VSS WELLTAP
XTAP_TAPCELL_ROW_50_624 VDD VSS WELLTAP
XANTENNA_10 _17536_/D VDD VSS ANTENNA2
XFILLER_123_1026 VDD VSS FILLER1
XFILLER_32_180 VDD VSS DECAPHV16
X_09294_ _09294_/A _09303_/B VDD VSS _17334_/B XNOR2X1
XFILLER_21_887 VDD VSS DECAPHV8
XFILLER_119_753 VDD VSS FILLER1
XTAP_TAPCELL_ROW_119_1450 VDD VSS WELLTAP
XTAP_TAPCELL_ROW_30_381 VDD VSS WELLTAP
XFILLER_106_447 VDD VSS DECAPHV16
XFILLER_134_767 VDD VSS FILLER1
XFILLER_133_277 VSS VDD FILLER2
XFILLER_79_309 VSS VDD FILLER2
XFILLER_102_631 VDD VSS DECAPHV8
XFILLER_102_653 VDD VSS DECAPHV32
XFILLER_48_718 VSS VDD FILLER2
XFILLER_88_865 VDD VSS DECAPHV8
XTAP_TAPCELL_ROW_58_713 VDD VSS WELLTAP
XFILLER_47_239 VDD VSS FILLER4
XFILLER_75_548 VDD VSS FILLER4
XFILLER_46_44 VSS VDD FILLER2
XFILLER_46_77 VSS VDD FILLER2
XFILLER_55_261 VSS VDD FILLER2
X_10971_ _17954_/Q _10976_/B VDD VSS _10972_/B XNOR2X1
XFILLER_44_935 VDD VSS FILLER1
XTAP_TAPCELL_ROW_38_470 VDD VSS WELLTAP
XTAP_TAPCELL_ROW_83_1015 VDD VSS WELLTAP
X_12710_ _18444_/Q _12810_/B _12810_/C VDD VSS _12923_/B MIN3X1
X_13690_ _13690_/A _13690_/B VDD VSS _13746_/C _13690_/C NAND3X1
XFILLER_31_618 VDD VSS FILLER4
XFILLER_44_979 VDD VSS DECAPHV8
X_12641_ _12652_/A _12652_/B _12652_/C VDD VSS _14205_/B OAI21X1
XFILLER_54_1134 VSS VDD FILLER2
XFILLER_62_32 VDD VSS DECAPHV8
XFILLER_23_180 VSS VDD FILLER2
X_12572_ _18261_/Q _12640_/B _12652_/C VDD VSS _12845_/B XNOR3X1
X_15360_ _18903_/Q _18902_/Q VDD VSS _15485_/B _15466_/B AND3X2
XFILLER_12_876 VDD VSS FILLER4
XFILLER_12_898 VSS VDD FILLER2
XFILLER_134_0 VDD VSS DECAPHV32
XFILLER_8_825 VDD VSS FILLER1
XFILLER_8_836 VDD VSS FILLER1
X_11523_ _18301_/Q _11523_/B _11591_/C VDD VSS _11664_/B MIN3X1
X_15291_ _17182_/D _18858_/Q VDD VSS _18831_/D AND2X1
X_14311_ _14343_/A _14311_/B VDD VSS _18352_/D AND2X1
XFILLER_7_346 VDD VSS DECAPHV16
XFILLER_8_858 VDD VSS DECAPHV16
X_11454_ _18144_/Q _11556_/A _11562_/B VDD VSS _11537_/D XNOR3X1
X_17030_ _18001_/Q _17030_/B _17030_/C VDD VSS _17036_/C MIN3X1
X_14242_ _14372_/A _14242_/B VDD VSS _18293_/D AND2X1
XFILLER_125_701 VDD VSS FILLER1
X_10405_ _10405_/A _10405_/B _10405_/C VDD VSS _10412_/B XNOR3X1
XFILLER_124_222 VDD VSS DECAPHV8
XTAP_TAPCELL_ROW_94_1144 VDD VSS WELLTAP
X_11385_ _11428_/A _11428_/B _11428_/C VDD VSS _14103_/C NOR3X1
X_14173_ _14174_/A _14173_/B _14173_/C VDD VSS _18232_/D NOR3X1
XFILLER_112_406 VDD VSS DECAPHV8
XFILLER_79_810 VDD VSS DECAPHV8
XFILLER_98_607 VDD VSS FILLER4
X_10336_ _10338_/B _10349_/C _17845_/Q VDD VSS _10337_/D AND3BX1
X_13124_ _14181_/B _14181_/C _18239_/Q VDD VSS _13195_/B AOI21X1
X_18981_ _18982_/CK _18981_/D _18981_/Q VDD VSS DFFQX1
XFILLER_127_80 VDD VSS DECAPHV8
X_10267_ _17836_/Q _10267_/B _10267_/C VDD VSS _10468_/B MIN3X1
X_13055_ _18343_/Q _13234_/A _13234_/B VDD VSS _13056_/D XNOR3X1
X_17932_ _17932_/CK _17932_/D _17932_/Q VDD VSS DFFQX1
Xclkbuf_leaf_25_clk_fs_regs clkbuf_leaf_5_clk_fs_regs/A VDD VSS _19019_/CK BUFX12
X_12006_ _18359_/Q _12006_/B _14321_/B VDD VSS _12109_/B MIN3X1
X_17863_ _17913_/CK _17863_/D _17863_/Q VDD VSS DFFQX1
XFILLER_120_461 VDD VSS DECAPHV8
XFILLER_78_375 VDD VSS DECAPHV16
XFILLER_93_312 VDD VSS FILLER1
XFILLER_94_813 VSS VDD FILLER2
X_10198_ _10268_/A _10388_/B VDD VSS _17850_/D NOR2X1
XFILLER_4_1043 VDD VSS DECAPHV16
XFILLER_94_857 VDD VSS FILLER4
X_17794_ _19038_/CK _17794_/D _17794_/Q VDD VSS DFFQX1
X_16814_ _16814_/A VDD VSS _16829_/A INVX1
XFILLER_19_475 VDD VSS DECAPHV8
X_16745_ _18919_/Q _16927_/B VDD VSS _16772_/A NAND2X1
X_13957_ _13971_/A VDD VSS _13999_/A BUFX3
XFILLER_19_497 VDD VSS DECAPHV16
XFILLER_46_272 VSS VDD FILLER2
XFILLER_62_732 VSS VDD FILLER2
X_12908_ _18342_/Q _12908_/B _12955_/C VDD VSS _13170_/B XNOR3X1
X_16676_ _16706_/B _16676_/B _16676_/C VDD VSS _18916_/D OAI21X1
XFILLER_22_607 VDD VSS DECAPHV8
XFILLER_61_242 VDD VSS FILLER4
X_18415_ _18461_/CK _18415_/D _18415_/Q VDD VSS DFFQX1
X_15627_ _18879_/Q _15640_/C VDD VSS _15628_/B XNOR2X1
X_13888_ _13905_/A _13920_/B VDD VSS _14498_/B XNOR2X1
XFILLER_61_264 VDD VSS FILLER4
XTAP_TAPCELL_ROW_103_1251 VDD VSS WELLTAP
X_12839_ _12953_/A _13011_/A _13010_/B VDD VSS _12840_/D XNOR3X1
XFILLER_30_640 VDD VSS FILLER4
XFILLER_61_297 VDD VSS FILLER4
X_18346_ _18453_/CK _18346_/D _18346_/Q VDD VSS DFFQX1
X_15558_ _15543_/Y _15557_/Y _15648_/A VDD VSS _15558_/Y MUX2X1
XFILLER_30_662 VSS VDD FILLER2
X_18277_ _18361_/CK _18277_/D _18277_/Q VDD VSS DFFQX1
X_15489_ _18869_/Q _15490_/A VDD VSS _15491_/A _15490_/B _15490_/C NAND4X2
X_14509_ _18516_/Q _18548_/Q _14509_/C VDD VSS _14513_/B AOI21X1
XFILLER_30_695 VSS VDD FILLER2
XTAP_TAPCELL_ROW_0_3 VDD VSS WELLTAP
X_17228_ _17237_/A _17228_/B VDD VSS _17229_/B XNOR2X1
X_17159_ _18989_/Q _17160_/B VDD VSS _17163_/C AND2X1
XFILLER_104_907 VDD VSS DECAPHV8
XFILLER_116_789 VDD VSS FILLER1
XFILLER_118_1117 VDD VSS DECAPHV8
XFILLER_66_1027 VDD VSS FILLER1
XFILLER_66_1049 VDD VSS DECAPHV8
X_09981_ _10184_/A _10184_/B _10184_/C _10185_/C VDD VSS _10194_/B AOAI211X1
XFILLER_131_737 VSS VDD FILLER2
XTAP_TAPCELL_ROW_114_1391 VDD VSS WELLTAP
X_08932_ _08935_/A _08935_/B _17514_/A VDD VSS _08933_/C OAI21X1
XFILLER_111_472 VSS VDD FILLER2
XFILLER_69_375 VDD VSS DECAPHV16
XFILLER_97_684 VDD VSS FILLER4
XFILLER_29_228 VSS VDD FILLER2
XFILLER_26_902 VDD VSS FILLER4
XFILLER_42_1082 VDD VSS FILLER1
XFILLER_25_401 VDD VSS FILLER1
XFILLER_53_743 VDD VSS FILLER1
XFILLER_26_968 VDD VSS FILLER1
XFILLER_26_979 VDD VSS DECAPHV8
XTAP_TAPCELL_ROW_35_440 VDD VSS WELLTAP
X_09415_ _17615_/Q _17406_/B VDD VSS _09431_/A NOR2X1
XFILLER_25_478 VDD VSS FILLER4
XTAP_TAPCELL_ROW_63_771 VDD VSS WELLTAP
X_09346_ _09369_/B _09346_/B VDD VSS _17404_/B AND2X1
X_09277_ _17642_/Q _17435_/B VDD VSS _09279_/A NAND2BX1
XFILLER_21_684 VSS VDD FILLER2
XFILLER_119_550 VSS VDD FILLER2
XFILLER_134_542 VDD VSS FILLER1
XFILLER_106_255 VDD VSS FILLER1
XFILLER_107_767 VSS VDD FILLER2
X_11170_ _11170_/A _11170_/B _11170_/C VDD VSS _11174_/A AOI21X1
XFILLER_106_277 VSS VDD FILLER2
X_10121_ _10121_/A _10121_/B _10121_/C VDD VSS _10127_/B XNOR3X1
XFILLER_88_662 VSS VDD FILLER2
X_10052_ _10114_/A _10247_/B VDD VSS _17832_/D NOR2X1
XFILLER_0_588 VDD VSS DECAPHV32
XFILLER_57_32 VDD VSS DECAPHV32
XFILLER_29_740 VDD VSS FILLER4
XFILLER_87_183 VSS VDD FILLER2
XTAP_TAPCELL_ROW_128_1549 VDD VSS WELLTAP
X_14860_ _14861_/A _14861_/B _14861_/D _14861_/C VDD VSS _14863_/C AOI211X1
XFILLER_29_751 VDD VSS FILLER1
XFILLER_29_773 VDD VSS DECAPHV8
XFILLER_75_356 VDD VSS FILLER1
X_14791_ _18576_/Q _18608_/Q VDD VSS _14793_/B XNOR2X1
X_13811_ _18431_/Q _13811_/B _13834_/C VDD VSS _13861_/C XNOR3X1
XFILLER_16_401 VDD VSS FILLER1
XFILLER_17_924 VDD VSS FILLER1
XFILLER_17_935 VDD VSS FILLER1
XFILLER_17_946 VSS VDD FILLER2
Xclkbuf_leaf_9__000_ clkbuf_leaf_9__000_/A VDD VSS _18848_/CK BUFX12
X_16530_ _16530_/A _16530_/B _16530_/C _16530_/D VDD VSS _16566_/A AOAI211X1
X_13742_ _13792_/A _13792_/B _13792_/D VDD VSS _13786_/B OA21X2
XFILLER_43_220 VDD VSS FILLER4
XFILLER_73_64 VDD VSS DECAPHV16
X_10954_ _17059_/C _11089_/B VDD VSS _17976_/D AND2X1
X_10885_ _17937_/Q _10886_/B VDD VSS _10891_/C NAND2X1
X_18200_ _18200_/CK _18200_/D _18200_/Q VDD VSS DFFQX1
X_16461_ _18823_/Q _18715_/Q VDD VSS _16463_/C XNOR2X1
X_13673_ _13673_/A _13673_/B _13673_/C _13673_/D VDD VSS _14401_/B OAOI211X1
X_12624_ _14234_/B _14234_/C _18286_/Q VDD VSS _12631_/B AOI21X1
X_16392_ _16537_/A _18767_/Q VDD VSS _16409_/C NAND2X1
X_15412_ _15410_/Y _15445_/B _16588_/A VDD VSS _15465_/B MUXI2X1
XFILLER_129_314 VDD VSS DECAPHV32
X_12555_ _12667_/A _12667_/B VDD VSS _14091_/B XNOR2X1
X_18131_ _18199_/CK _18131_/D _18131_/Q VDD VSS DFFQX1
X_15343_ _172_/E _15343_/B VDD VSS _18864_/D NOR2X1
XTAP_TAPCELL_ROW_13_178 VDD VSS WELLTAP
X_11506_ _18169_/Q _14104_/B VDD VSS _11602_/A NAND2X1
X_18062_ _18066_/CK _18062_/D output3/A VDD VSS DFFQX1
X_12486_ _18468_/Q _12486_/B _12486_/C VDD VSS _12707_/B MIN3X1
X_17013_ _17013_/A _17019_/B _17019_/C _18957_/Q VDD VSS _18957_/D AO22X2
X_15274_ _15274_/A _18842_/Q VDD VSS _18815_/D AND2X1
XFILLER_7_176 VDD VSS DECAPHV8
X_11437_ _11437_/A _11437_/B _11437_/C _11437_/D VDD VSS _11603_/B OAOI211X1
X_14225_ _14252_/A _14225_/B VDD VSS _18278_/D NOR2X1
XFILLER_99_905 VSS VDD FILLER2
X_11368_ _18194_/Q _11378_/B _14132_/B VDD VSS _11422_/C XOR3X1
X_14156_ _14157_/B _14156_/B _15326_/C VDD VSS _18216_/D AOI21X1
XFILLER_112_214 VDD VSS FILLER1
XFILLER_98_426 VDD VSS FILLER1
X_10319_ _10306_/A _10325_/B _10325_/C VDD VSS _10503_/C AND3BX1
X_13107_ _13225_/A _13225_/B _13225_/E VDD VSS _13209_/B AOI21X1
XFILLER_65_1060 VDD VSS DECAPHV8
X_11299_ _18140_/Q _11383_/A _14072_/B VDD VSS _11328_/C XNOR3X1
X_18964_ _18966_/CK _18964_/D _18964_/Q VDD VSS DFFQX1
X_14087_ _14253_/A VDD VSS _14129_/A BUFX3
XFILLER_26_1055 VSS VDD FILLER2
XFILLER_65_1082 VDD VSS FILLER4
XFILLER_79_662 VDD VSS DECAPHV8
XFILLER_79_684 VSS VDD FILLER2
X_13038_ _18447_/Q _13260_/A _14421_/B VDD VSS _13039_/C XOR3X1
X_17915_ _17941_/CK _17915_/D _17915_/Q VDD VSS DFFQX1
X_18895_ _18913_/CK _18895_/D _18895_/Q VDD VSS DFFQX1
XFILLER_93_120 VDD VSS FILLER4
X_17846_ _17901_/CK _17846_/D _17846_/Q VDD VSS DFFQX1
XFILLER_113_1069 VDD VSS FILLER4
XFILLER_54_507 VDD VSS FILLER4
X_17777_ _19043_/CK _17777_/D _17777_/Q VDD VSS DFFQX1
X_14989_ _14992_/A _14992_/B _17498_/A VDD VSS _14990_/C OAI21X1
XFILLER_19_294 VDD VSS DECAPHV16
X_16728_ _16728_/A _16728_/B VDD VSS _16758_/C NAND2X1
X_16659_ _18828_/Q _18720_/Q VDD VSS _16688_/C NAND2X1
XFILLER_34_286 VDD VSS FILLER1
XFILLER_62_595 VDD VSS FILLER1
XFILLER_97_0 VDD VSS DECAPHV32
XTAP_TAPCELL_ROW_60_741 VDD VSS WELLTAP
X_09200_ _09200_/A VDD VSS _17432_/B INVX1
XFILLER_33_1026 VDD VSS DECAPHV8
X_09131_ _09155_/C _09131_/B VDD VSS _17463_/B XNOR2X1
X_18329_ _18381_/CK _18329_/D _18329_/Q VDD VSS DFFQX1
X_09062_ _09062_/A _09062_/B _17460_/B VDD VSS _09101_/B MIN3X1
XFILLER_129_881 VSS VDD FILLER2
XFILLER_8_81 VDD VSS DECAPHV32
XFILLER_118_49 VDD VSS DECAPHV32
XFILLER_131_512 VSS VDD FILLER2
XFILLER_89_459 VDD VSS FILLER4
X_09964_ _09964_/A _09982_/B VDD VSS _09970_/C XOR2X1
X_08915_ _17557_/A _17557_/B _08915_/C VDD VSS _17560_/A OAI21X1
X_09895_ _17392_/A _10102_/B VDD VSS _17814_/D AND2X1
XFILLER_131_1114 VSS VDD FILLER2
XFILLER_85_654 VDD VSS DECAPHV8
XFILLER_97_492 VDD VSS FILLER4
XTAP_TAPCELL_ROW_68_830 VDD VSS WELLTAP
XFILLER_73_827 VDD VSS FILLER4
XFILLER_84_142 VSS VDD FILLER2
XFILLER_100_998 VDD VSS DECAPHV8
XFILLER_72_315 VDD VSS FILLER1
XFILLER_81_860 VDD VSS FILLER4
XFILLER_14_916 VDD VSS FILLER4
XFILLER_14_949 VDD VSS DECAPHV8
XFILLER_53_573 VSS VDD FILLER2
XFILLER_25_286 VDD VSS FILLER1
XFILLER_53_595 VDD VSS FILLER4
X_10670_ _17896_/Q _10670_/B _10670_/C VDD VSS _10676_/B XOR3X1
X_09329_ _17580_/Q _17369_/B VDD VSS _09330_/C NOR2X1
XFILLER_51_1126 VDD VSS DECAPHV8
XTAP_TAPCELL_ROW_10_137 VDD VSS WELLTAP
X_12340_ _12429_/A _14145_/B VDD VSS _12438_/A NOR2X1
XFILLER_4_113 VDD VSS DECAPHV16
XFILLER_5_625 VDD VSS DECAPHV16
X_12271_ _18336_/Q _12271_/B _14293_/C VDD VSS _12411_/B XNOR3X1
X_11222_ _14079_/A _11222_/B _11224_/B VDD VSS _18031_/D NOR3X1
X_14010_ _14012_/B _14013_/A _14010_/C VDD VSS _14011_/B OR3BX1
XFILLER_136_1025 VDD VSS DECAPHV8
XTAP_TAPCELL_ROW_91_1114 VDD VSS WELLTAP
XFILLER_96_919 VSS VDD FILLER2
X_11153_ _11205_/A _17100_/A VDD VSS _18014_/D NOR2X1
XFILLER_0_363 VDD VSS DECAPHV32
XFILLER_49_824 VDD VSS DECAPHV8
X_10104_ _10287_/B _10287_/C VDD VSS _10475_/B NAND2X1
X_11084_ _11086_/A _11084_/B VDD VSS _17030_/B XNOR2X1
X_15961_ _15961_/A _15961_/B _15961_/C _15961_/D VDD VSS _16051_/B OAOI211X1
XFILLER_75_120 VSS VDD FILLER2
X_10035_ _10227_/B _10227_/C _10035_/C _10035_/D VDD VSS _10235_/B AO211X2
X_18680_ _18815_/CK _18680_/D _18680_/Q VDD VSS DFFQX1
X_17700_ _17701_/CK _17700_/D _17700_/Q VDD VSS DFFQX1
X_15892_ _18781_/Q _18727_/Q VDD VSS _15919_/C XNOR2X1
X_14912_ _14917_/C _14917_/B VDD VSS _14914_/B NAND2BX1
XFILLER_124_81 VDD VSS DECAPHV32
X_17631_ _19024_/CK _17631_/D _17631_/Q VDD VSS DFFQX1
X_14843_ _18587_/Q _18619_/Q VDD VSS _14844_/C NAND2X1
XFILLER_1_1013 VDD VSS DECAPHV8
XFILLER_91_646 VDD VSS FILLER4
XTAP_TAPCELL_ROW_89_1087 VDD VSS WELLTAP
XFILLER_16_231 VDD VSS FILLER1
XFILLER_17_743 VDD VSS FILLER1
XFILLER_90_156 VDD VSS FILLER1
XTAP_TAPCELL_ROW_18_237 VDD VSS WELLTAP
X_11986_ _18437_/Q _12089_/B _14410_/B VDD VSS _14467_/B XNOR3X1
X_17562_ _17562_/A _17562_/B _17562_/C VDD VSS _17742_/D AOI21X1
X_14774_ _14776_/C _14774_/B _14774_/C VDD VSS _18572_/D AOI21X1
XFILLER_32_702 VDD VSS FILLER1
XTAP_TAPCELL_ROW_46_568 VDD VSS WELLTAP
X_10937_ _17947_/Q _10938_/B VDD VSS _10942_/C NAND2X1
X_17493_ _17498_/A _17729_/Q VDD VSS _17697_/D AND2X1
X_16513_ _16513_/A _16513_/B _16513_/C VDD VSS _16518_/C AOI21X1
X_13725_ _18454_/Q _13725_/B VDD VSS _13730_/C _13725_/C NAND3X1
X_16444_ _16444_/A _16444_/B VDD VSS _16444_/Y _16444_/C _16444_/D NAND4X2
X_13656_ _14493_/B _14493_/C _18506_/Q VDD VSS _13660_/C AO21X2
XTAP_TAPCELL_ROW_100_1221 VDD VSS WELLTAP
X_10868_ _17933_/Q _10868_/B _10868_/C VDD VSS _10874_/A MIN3X1
X_12607_ _12714_/A _12714_/B _12714_/C VDD VSS _12827_/A OA21X2
XFILLER_13_982 VSS VDD FILLER2
X_10799_ _17920_/Q _10802_/B VDD VSS _10800_/B XNOR2X1
X_18114_ _18966_/CK _18114_/D _18114_/Q VDD VSS DFFQX1
X_16375_ _16222_/Y _16374_/Y _16521_/A VDD VSS _16669_/B MUXI2X1
X_13587_ _18479_/Q VDD VSS _13651_/A INVX1
XFILLER_118_818 VSS VDD FILLER2
XTAP_TAPCELL_ROW_4_71 VDD VSS WELLTAP
X_12538_ _12538_/A _14117_/B VDD VSS _12656_/A OR2X2
X_15326_ wire34/Y _15338_/B _15326_/C VDD VSS _18859_/D AOI21X1
XFILLER_8_485 VDD VSS DECAPHV16
X_12469_ _12502_/A _12502_/B _12502_/C VDD VSS _12469_/Y AOI21X1
X_18045_ _18841_/CK _18045_/D _18045_/Q VDD VSS DFFQX1
X_15257_ _15313_/A _18825_/Q VDD VSS _18798_/D AND2X1
X_14208_ _14198_/Y _14208_/B _14208_/C VDD VSS _18264_/D AND3BX1
X_15188_ _15299_/A _18757_/Q VDD VSS _18730_/D AND2X1
X_14139_ _14108_/Y _14139_/B _14139_/C VDD VSS _18201_/D AND3BX1
XTAP_TAPCELL_ROW_111_1350 VDD VSS WELLTAP
X_18947_ _18950_/CK _18947_/D _18947_/Q VDD VSS DFFQX1
XFILLER_95_941 VDD VSS FILLER4
X_09680_ _09681_/A _09681_/B _09681_/C VDD VSS _09682_/B NOR3X1
XFILLER_12_0 VDD VSS DECAPHV32
XFILLER_66_142 VDD VSS DECAPHV8
X_18878_ _18950_/CK _18878_/D _18878_/Q VDD VSS DFFQX1
XFILLER_66_186 VSS VDD FILLER2
XFILLER_81_112 VDD VSS DECAPHV8
XTAP_TAPCELL_ROW_65_800 VDD VSS WELLTAP
X_17829_ _17854_/CK _17829_/D _17829_/Q VDD VSS DFFQX1
XFILLER_70_808 VDD VSS FILLER1
XFILLER_50_532 VDD VSS FILLER4
Xfanout38 _15799_/B VDD VSS _16537_/A BUFX3
Xfanout49 _17554_/C VDD VSS _17229_/A BUFX3
XFILLER_13_48 VSS VDD FILLER2
X_09114_ _19027_/Q _17327_/B VDD VSS _09118_/B XOR2X1
XFILLER_108_328 VDD VSS DECAPHV8
X_09045_ _09045_/A _09045_/B VDD VSS _17357_/B XNOR2X1
XFILLER_117_840 VDD VSS DECAPHV8
Xclkbuf_leaf_8__001_ clkload74/A VDD VSS _17861_/CK BUFX12
XFILLER_2_639 VDD VSS DECAPHV32
XTAP_TAPCELL_ROW_0_18 VDD VSS WELLTAP
XFILLER_104_589 VDD VSS FILLER1
XFILLER_131_375 VDD VSS DECAPHV8
X_09947_ _17795_/Q _09959_/B VDD VSS _09949_/B XOR2X1
X_09878_ _17787_/Q _09885_/B VDD VSS _09897_/A NAND2X1
XFILLER_57_175 VDD VSS FILLER4
XFILLER_79_1048 VDD VSS DECAPHV8
XTAP_TAPCELL_ROW_125_1519 VDD VSS WELLTAP
X_11840_ _12077_/A _12077_/B _12077_/C VDD VSS _12173_/B OAI21X1
XFILLER_54_44 VSS VDD FILLER2
XFILLER_54_871 VDD VSS DECAPHV8
X_11771_ _11880_/A _14138_/B VDD VSS _11931_/A NOR2X1
XFILLER_13_201 VDD VSS FILLER1
XFILLER_26_584 VSS VDD FILLER2
XFILLER_26_595 VSS VDD FILLER2
XFILLER_54_99 VDD VSS FILLER1
XTAP_TAPCELL_ROW_43_538 VDD VSS WELLTAP
X_10722_ _10722_/A _10722_/B _10722_/C VDD VSS _10723_/D NOR3X1
X_13510_ _18504_/Q _14491_/B VDD VSS _13580_/D _14491_/C NAND3X1
XFILLER_41_565 VDD VSS FILLER4
XTAP_TAPCELL_ROW_71_869 VDD VSS WELLTAP
X_14490_ _14517_/A _14490_/B VDD VSS _18503_/D NOR2X1
XFILLER_70_32 VDD VSS DECAPHV8
X_10653_ _17892_/Q VDD VSS _10657_/A INVX1
Xclkbuf_leaf_12__000_ clkbuf_leaf_9__000_/A VDD VSS _18844_/CK BUFX12
X_13441_ _13583_/A _13583_/B VDD VSS _13504_/B NOR2X1
XTAP_TAPCELL_ROW_23_295 VDD VSS WELLTAP
X_10584_ _10711_/B _10588_/B _10588_/D _10588_/C VDD VSS _10722_/C AOI211X1
X_16160_ _16250_/A _16250_/B VDD VSS _16161_/D XOR2X1
X_13372_ _13466_/A _13466_/B _13466_/D _13466_/C VDD VSS _14335_/C AOI211X1
XFILLER_103_1057 VDD VSS FILLER4
XFILLER_10_974 VSS VDD FILLER2
XTAP_TAPCELL_ROW_136_1648 VDD VSS WELLTAP
XTAP_TAPCELL_ROW_136_1659 VDD VSS WELLTAP
X_12323_ _12419_/A _12419_/B _12419_/D VDD VSS _12371_/B OAI21X1
Xclkload19 _18958_/CK VDD VSS clkload19/Y INVX1
X_16091_ _18040_/Q _18650_/Q VDD VSS _16096_/B OR2X2
X_15111_ _15304_/A _18682_/Q VDD VSS _18655_/D AND2X1
XFILLER_5_455 VDD VSS DECAPHV8
X_15042_ _15044_/C _15042_/B _15042_/C VDD VSS _18630_/D AOI21X1
XFILLER_107_350 VSS VDD FILLER2
XFILLER_108_895 VDD VSS DECAPHV8
XFILLER_119_92 VDD VSS FILLER1
XFILLER_135_670 VSS VDD FILLER2
X_12254_ _18980_/Q _18101_/Q VDD VSS _12356_/B XNOR2X1
XFILLER_79_96 VDD VSS DECAPHV16
X_11205_ _11205_/A _17147_/B VDD VSS _18024_/D NOR2X1
X_12185_ _18413_/Q _12291_/B _12203_/C VDD VSS _12283_/C XNOR3X1
XFILLER_96_716 VDD VSS FILLER4
X_11136_ _14253_/A VDD VSS _11205_/A BUFX3
X_18801_ _18801_/CK _18801_/D _18801_/Q VDD VSS DFFQX1
XFILLER_122_386 VSS VDD FILLER2
XFILLER_135_80 VDD VSS DECAPHV8
XFILLER_89_790 VDD VSS FILLER1
XFILLER_95_226 VDD VSS FILLER1
X_18732_ _18787_/CK _18732_/D _18732_/Q VDD VSS DFFQX1
X_16993_ _16993_/A _17006_/B _16993_/C VDD VSS _18945_/D OAI21X1
XFILLER_3_1119 VDD VSS DECAPHV16
XFILLER_48_142 VDD VSS DECAPHV16
XFILLER_49_654 VDD VSS FILLER1
XFILLER_49_676 VSS VDD FILLER2
XTAP_TAPCELL_ROW_79_969 VDD VSS WELLTAP
X_11067_ _11067_/A _11069_/C VDD VSS _11203_/B XNOR2X1
X_15944_ _18897_/Q _15949_/B VDD VSS _15950_/A XNOR2X1
XFILLER_23_1069 VDD VSS FILLER4
XFILLER_76_473 VDD VSS FILLER1
X_10018_ _10022_/D _10018_/B VDD VSS _10223_/C NAND2X1
X_18663_ _18852_/CK _18663_/D _18663_/Q VDD VSS DFFQX1
X_15875_ _18807_/Q _18699_/Q VDD VSS _15931_/A AND2X1
XFILLER_63_145 VDD VSS DECAPHV8
X_18594_ _19004_/CK _18594_/D _18594_/Q VDD VSS DFFQX1
X_17614_ _17680_/CK _17614_/D _17614_/Q VDD VSS DFFQX1
X_14826_ _18583_/Q _18615_/Q _14826_/C VDD VSS _14829_/B AOI21X1
XFILLER_17_551 VDD VSS FILLER1
XFILLER_45_882 VSS VDD FILLER2
XFILLER_92_999 VDD VSS DECAPHV8
X_17545_ _17545_/A _17545_/B _17545_/C VDD VSS _17735_/D AOI21X1
X_14757_ _18600_/Q VDD VSS _14906_/A INVX1
XFILLER_17_584 VDD VSS DECAPHV16
XFILLER_32_510 VDD VSS FILLER1
XFILLER_60_841 VDD VSS DECAPHV8
X_11969_ _18978_/Q _18099_/Q VDD VSS _12255_/A XOR2X1
X_13708_ _18377_/Q _13806_/A _13752_/B VDD VSS _13754_/D XNOR3X1
X_17476_ _17479_/A _17476_/B VDD VSS _17681_/D NOR2X1
X_14688_ _18555_/Q _18587_/Q VDD VSS _14693_/A XNOR2X1
XFILLER_32_587 VDD VSS FILLER1
X_16427_ _18049_/Q _18659_/Q VDD VSS _16429_/C NAND2X1
X_13639_ _13639_/A _13639_/B _13639_/C _13639_/D VDD VSS _13674_/B AOAI211X1
X_16358_ _18047_/Q _18657_/Q VDD VSS _16401_/A AND2X1
XFILLER_121_1135 VDD VSS FILLER1
XFILLER_9_783 VDD VSS FILLER1
X_15309_ _15309_/A _18050_/Q VDD VSS _18849_/D AND2X1
X_16289_ _16315_/D _16315_/B VDD VSS _16290_/B NOR2BX1
X_18028_ _18547_/CK _18028_/D _18028_/Q VDD VSS DFFQX1
XFILLER_101_515 VDD VSS FILLER1
XFILLER_114_898 VDD VSS DECAPHV8
XFILLER_119_1053 VDD VSS DECAPHV8
X_09801_ _17764_/Q _09899_/C VDD VSS _09926_/B XOR2X1
XFILLER_68_941 VDD VSS DECAPHV8
X_09732_ _09733_/A _09733_/B VDD VSS _09759_/B AND2X1
XFILLER_67_451 VDD VSS DECAPHV8
XFILLER_28_827 VSS VDD FILLER2
XFILLER_67_495 VSS VDD FILLER2
XFILLER_95_782 VDD VSS FILLER4
X_09663_ _17752_/Q VDD VSS _17518_/B INVX1
XFILLER_82_421 VSS VDD FILLER2
XFILLER_83_955 VDD VSS FILLER4
X_09594_ _09594_/A _09599_/B VDD VSS _17346_/B XOR2X1
XFILLER_83_999 VDD VSS DECAPHV8
XFILLER_51_830 VSS VDD FILLER2
XFILLER_23_565 VSS VDD FILLER2
XFILLER_10_204 VSS VDD FILLER2
XFILLER_24_69 VDD VSS FILLER4
XTAP_TAPCELL_ROW_20_254 VDD VSS WELLTAP
XFILLER_124_607 VDD VSS DECAPHV8
XFILLER_3_904 VDD VSS DECAPHV16
XFILLER_40_79 VDD VSS FILLER1
X_09028_ _09028_/A VDD VSS _09029_/B INVX1
XFILLER_123_128 VDD VSS DECAPHV32
XFILLER_132_640 VSS VDD FILLER2
XTAP_TAPCELL_ROW_131_1589 VDD VSS WELLTAP
XFILLER_49_88 VDD VSS FILLER4
X_13990_ _14011_/A _13990_/B _14055_/C VDD VSS _18072_/D AOI21X1
XFILLER_46_602 VSS VDD FILLER2
XFILLER_65_32 VDD VSS DECAPHV32
XFILLER_74_944 VDD VSS FILLER4
XTAP_TAPCELL_ROW_76_928 VDD VSS WELLTAP
X_12941_ _18366_/Q VDD VSS _12943_/A INVX1
XFILLER_46_657 VDD VSS DECAPHV8
X_12872_ _18211_/Q _12872_/B _12875_/C VDD VSS _12977_/B XNOR3X1
X_15660_ _15646_/Y _15673_/B _15648_/A VDD VSS _15684_/B MUXI2X1
XFILLER_22_1080 VDD VSS FILLER1
XFILLER_45_167 VDD VSS FILLER1
XFILLER_61_616 VDD VSS FILLER4
XTAP_TAPCELL_ROW_28_354 VDD VSS WELLTAP
XTAP_TAPCELL_ROW_86_1046 VDD VSS WELLTAP
X_11823_ _18356_/Q VDD VSS _11828_/A INVX1
X_14611_ _14611_/A _14611_/B _14611_/C VDD VSS _14619_/A OA21X2
XFILLER_42_830 VDD VSS FILLER1
XFILLER_45_189 VDD VSS FILLER1
XFILLER_92_1012 VDD VSS FILLER1
XTAP_TAPCELL_ROW_56_685 VDD VSS WELLTAP
XTAP_TAPCELL_ROW_56_696 VDD VSS WELLTAP
X_17330_ _17338_/A _17330_/B VDD VSS _19030_/D NOR2X1
X_15591_ _15591_/A _15591_/B VDD VSS _15592_/C NOR2X1
XFILLER_53_1007 VDD VSS FILLER1
X_11754_ _18224_/Q _11754_/B VDD VSS _11755_/C _11754_/C NAND3X1
X_14542_ _14542_/A VDD VSS _14696_/A BUFX3
XFILLER_105_1119 VDD VSS DECAPHV16
XFILLER_81_64 VDD VSS DECAPHV16
X_10705_ _10705_/A _10705_/B _10705_/C _10705_/D VDD VSS _10715_/A OAOI211X1
X_11685_ _11801_/A _11801_/B _11801_/C VDD VSS _11748_/B AOI21X1
X_17261_ _17262_/B _17261_/B VDD VSS _17263_/B NOR2BX1
X_14473_ _14480_/A _14473_/B VDD VSS _18491_/D NOR2X1
X_10636_ _10922_/A VDD VSS _10731_/A BUFX3
X_19000_ clkload9/A _19000_/D _19000_/Q VDD VSS DFFQX1
X_17192_ _17224_/A _17192_/B VDD VSS _18996_/D NOR2X1
X_16212_ _18044_/Q _18654_/Q VDD VSS _16238_/A NAND2X1
X_13424_ _18373_/Q _13424_/B _13475_/C VDD VSS _13639_/B XNOR3X1
Xclkload119 _18858_/CK VDD VSS clkload119/Y BUFX12
Xclkload108 _17972_/CK VDD VSS clkload108/Y INVX2
X_16143_ _16411_/A _16180_/B _16180_/C _16143_/D VDD VSS _16221_/B OAI31X1
XFILLER_10_793 VDD VSS FILLER1
XFILLER_128_968 VDD VSS DECAPHV8
XFILLER_128_979 VDD VSS DECAPHV16
XFILLER_6_764 VDD VSS DECAPHV16
X_10567_ _10709_/B _10709_/C VDD VSS _10706_/B NAND2X1
X_13355_ _13444_/A _13444_/B _13444_/D _13444_/C VDD VSS _14424_/C AOI211X1
XTAP_TAPCELL_ROW_97_1186 VDD VSS WELLTAP
X_10498_ _17869_/Q _10498_/B _10503_/B VDD VSS _10509_/D XNOR3X1
X_12306_ _14201_/B _14201_/C _18257_/Q VDD VSS _12308_/C AOI21X1
X_13286_ _13287_/A _13287_/B _13287_/D _13287_/C VDD VSS _14270_/C AOI211X1
X_16074_ _16121_/B _16121_/C _16934_/A VDD VSS _16112_/A OAI21X1
XFILLER_64_1103 VDD VSS FILLER1
X_12237_ _14144_/B _12328_/C _18205_/Q VDD VSS _12430_/C AND3BX1
X_15025_ _19004_/Q VDD VSS _15026_/B INVX1
XFILLER_111_857 VDD VSS FILLER1
X_12168_ _18257_/Q _12168_/B _12305_/D VDD VSS _14230_/C XNOR3X1
X_11119_ _11122_/A _11122_/B VDD VSS _17066_/B XNOR2X1
X_12099_ _18438_/Q _12193_/B _12193_/C VDD VSS _12283_/B MIN3X1
X_16976_ _17017_/B VDD VSS _17006_/B BUFX3
X_18715_ _18851_/CK _18715_/D _18715_/Q VDD VSS DFFQX1
X_15927_ _15929_/B VDD VSS _15967_/B INVX1
XFILLER_25_808 VDD VSS FILLER1
XFILLER_64_421 VDD VSS FILLER4
X_18646_ _18808_/CK _18646_/D _18646_/Q VDD VSS DFFQX1
XFILLER_64_454 VSS VDD FILLER2
X_15858_ _15839_/Y _15858_/B _15858_/C _15858_/D VDD VSS _15898_/B NOR4BX1
XFILLER_51_115 VDD VSS FILLER4
XFILLER_51_126 VDD VSS DECAPHV8
X_18577_ _18641_/CK _18577_/D _18577_/Q VDD VSS DFFQX1
Xclkbuf_leaf_7__002_ clkbuf_leaf_9__002_/A VDD VSS _18971_/CK BUFX12
X_15789_ _15865_/C _15865_/A VDD VSS _15828_/A NAND2X1
X_14809_ _14810_/C _17525_/B _14809_/C VDD VSS _18580_/D AND3BX1
XTAP_TAPCELL_ROW_106_1293 VDD VSS WELLTAP
X_17528_ _17528_/A _17528_/B VDD VSS _17529_/B XOR2X1
XFILLER_20_502 VDD VSS DECAPHV8
XFILLER_32_384 VSS VDD FILLER2
X_17459_ _17463_/A _17459_/B VDD VSS _17665_/D NOR2X1
XFILLER_119_946 VDD VSS FILLER4
XFILLER_9_580 VDD VSS FILLER1
XFILLER_106_607 VDD VSS FILLER1
XFILLER_118_467 VSS VDD FILLER2
XFILLER_119_968 VDD VSS DECAPHV16
XFILLER_69_1047 VDD VSS FILLER4
XFILLER_105_128 VDD VSS DECAPHV16
XFILLER_10_49 VDD VSS DECAPHV16
XFILLER_133_459 VDD VSS FILLER1
XFILLER_102_813 VDD VSS FILLER1
XFILLER_126_49 VDD VSS DECAPHV32
XFILLER_99_395 VDD VSS FILLER4
XFILLER_101_345 VSS VDD FILLER2
XFILLER_68_760 VDD VSS DECAPHV16
Xclkbuf_leaf_11__001_ clkload74/A VDD VSS _17993_/CK BUFX12
XFILLER_101_367 VDD VSS FILLER4
XFILLER_101_389 VDD VSS FILLER4
XFILLER_19_69 VDD VSS FILLER1
XFILLER_28_602 VSS VDD FILLER2
XFILLER_56_933 VSS VDD FILLER2
XFILLER_68_782 VDD VSS FILLER1
XFILLER_68_793 VDD VSS DECAPHV8
X_09715_ _17658_/Q _17452_/B VDD VSS _09716_/C NOR2X1
XFILLER_132_1072 VDD VSS DECAPHV32
XFILLER_56_944 VDD VSS FILLER1
XFILLER_95_590 VDD VSS FILLER1
X_09646_ _17592_/Q _17382_/B VDD VSS _09648_/C XNOR2X1
XFILLER_27_189 VDD VSS DECAPHV16
XFILLER_36_690 VDD VSS FILLER4
XFILLER_43_649 VSS VDD FILLER2
XTAP_TAPCELL_ROW_25_313 VDD VSS WELLTAP
XTAP_TAPCELL_ROW_25_324 VDD VSS WELLTAP
X_09577_ _09577_/A _09577_/B VDD VSS _09591_/B AND2X1
Xclkbuf_leaf_26__001_ clkbuf_2_1__f__001_/Y VDD VSS _17698_/CK BUFX12
XFILLER_70_479 VSS VDD FILLER2
XTAP_TAPCELL_ROW_53_655 VDD VSS WELLTAP
XFILLER_11_502 VDD VSS FILLER4
XTAP_TAPCELL_ROW_81_986 VDD VSS WELLTAP
XFILLER_11_557 VDD VSS FILLER1
X_11470_ _11470_/A _11470_/B _14217_/B VDD VSS _11521_/B MIN3X1
X_10421_ _10423_/A _10423_/B _10423_/C VDD VSS _10601_/B XNOR3X1
XTAP_TAPCELL_ROW_133_1618 VDD VSS WELLTAP
X_10352_ _10343_/A _10352_/B _10352_/C VDD VSS _10368_/C AND3BX1
X_13140_ _14422_/B _14422_/C VDD VSS _13150_/B NOR2X1
XFILLER_2_222 VDD VSS DECAPHV8
XFILLER_3_734 VDD VSS DECAPHV8
X_13071_ _13071_/A _13071_/B _13071_/C _13071_/D VDD VSS _14180_/B AOAI211X1
X_10283_ _17839_/Q _10470_/B _10283_/C VDD VSS _10475_/C MIN3X1
X_12022_ _12216_/A _12216_/B _12216_/C VDD VSS _12081_/B AOI21X1
Xclkbuf_leaf_24_clk_fs_regs clkbuf_leaf_5_clk_fs_regs/A VDD VSS _19011_/CK BUFX12
XFILLER_104_172 VDD VSS DECAPHV8
XFILLER_2_299 VDD VSS DECAPHV16
XFILLER_104_194 VDD VSS FILLER1
XFILLER_120_665 VDD VSS FILLER4
X_16830_ _16841_/A _16841_/B _16866_/A VDD VSS _16834_/A AOI21X1
XFILLER_47_933 VDD VSS FILLER1
XFILLER_93_516 VDD VSS FILLER1
X_16761_ _16784_/A _18777_/Q _16782_/D _16761_/D VDD VSS _16762_/D AOI22X1
X_13973_ _13975_/B _14013_/A _13973_/C VDD VSS _13974_/B OR3BX1
XFILLER_111_1134 VSS VDD FILLER2
XFILLER_20_1006 VDD VSS FILLER4
XFILLER_46_421 VDD VSS FILLER4
XFILLER_58_292 VDD VSS FILLER1
X_12924_ _12924_/A _12924_/B _14448_/B VDD VSS _12925_/B MIN3X1
X_18500_ _18500_/CK _18500_/D _18500_/Q VDD VSS DFFQX1
X_15712_ _15737_/A _17012_/A _15712_/C VDD VSS _18887_/D OAI21X1
XFILLER_132_81 VDD VSS DECAPHV32
XFILLER_46_454 VDD VSS FILLER1
X_16692_ _18802_/Q _18748_/Q VDD VSS _16715_/A XNOR2X1
XFILLER_46_498 VDD VSS FILLER4
XFILLER_62_947 VDD VSS DECAPHV8
XFILLER_94_1129 VDD VSS FILLER4
X_12855_ _12965_/A _12965_/B _12960_/C VDD VSS _14238_/B AOI21BX1
X_18431_ _18431_/CK _18431_/D _18431_/Q VDD VSS DFFQX1
X_15643_ _18880_/Q VDD VSS _15644_/A INVX1
XFILLER_14_340 VDD VSS FILLER1
XFILLER_15_852 VDD VSS FILLER4
XFILLER_33_159 VSS VDD FILLER2
XFILLER_61_479 VDD VSS FILLER4
X_11806_ _11843_/A _11843_/B _11843_/D _11843_/C VDD VSS _11839_/C OAI211X1
X_12786_ _18159_/Q wire27/Y _12880_/C VDD VSS _13086_/C XNOR3X1
X_18362_ _18417_/CK _18362_/D _18362_/Q VDD VSS DFFQX1
X_15574_ _15651_/A _15675_/B VDD VSS _15575_/C NAND2X1
XFILLER_42_660 VDD VSS FILLER1
X_11737_ _18330_/Q _11827_/B _11827_/C VDD VSS _14318_/A MIN3X1
X_17313_ _17313_/A _17317_/B VDD VSS _17314_/B XNOR2X1
X_14525_ _18519_/Q _18551_/Q _14525_/C VDD VSS _14528_/B AOI21X1
XFILLER_119_209 VSS VDD FILLER2
XTAP_TAPCELL_ROW_99_1204 VDD VSS WELLTAP
X_18293_ _18397_/CK _18293_/D _18293_/Q VDD VSS DFFQX1
X_11668_ _11668_/A _14165_/B _11678_/B VDD VSS _14193_/B XNOR3X1
X_17244_ _19005_/Q _17287_/B _17248_/A VDD VSS _17245_/B AOI21X1
X_14456_ _14361_/Y _14456_/B _14456_/C VDD VSS _18478_/D AND3BX1
X_10619_ _10707_/A _10756_/B VDD VSS _17910_/D AND2X1
X_11599_ _18251_/Q VDD VSS _11743_/A INVX1
X_17175_ _17176_/A _17176_/B _17176_/D _17176_/C VDD VSS _17175_/Y OAOI211X1
X_14387_ _14389_/A _14387_/B VDD VSS _18416_/D NOR2X1
X_13407_ _14157_/B _14156_/B _13407_/C VDD VSS _13408_/D AOI21X1
XFILLER_127_253 VDD VSS DECAPHV16
X_16126_ _16126_/A _16126_/B VDD VSS _16136_/B XNOR2X1
X_13338_ _18501_/Q _13338_/B _13338_/C VDD VSS _13342_/C MIN3X1
XFILLER_6_594 VDD VSS DECAPHV8
X_16057_ _15983_/B _16802_/A VDD VSS _16058_/D NAND2BX1
XFILLER_130_407 VDD VSS DECAPHV8
X_13269_ _18397_/Q _13269_/B _13276_/C VDD VSS _13352_/C XNOR3X1
X_15008_ _15009_/A _15009_/B _15009_/D _15009_/C VDD VSS _15011_/C AOI211X1
XFILLER_111_654 VDD VSS FILLER4
XFILLER_29_1097 VDD VSS FILLER1
XFILLER_110_142 VDD VSS DECAPHV16
XFILLER_38_900 VSS VDD FILLER2
XFILLER_38_944 VDD VSS FILLER4
XTAP_TAPCELL_ROW_108_1311 VDD VSS WELLTAP
X_09500_ _17477_/B _17682_/Q VDD VSS _09501_/C NOR2BX1
X_16959_ _16959_/A _16959_/B _16959_/C VDD VSS _16964_/B OAI21X1
XFILLER_64_251 VDD VSS FILLER4
XFILLER_65_785 VDD VSS FILLER1
XFILLER_80_700 VDD VSS DECAPHV8
XFILLER_64_273 VDD VSS FILLER1
XFILLER_64_284 VDD VSS FILLER1
XFILLER_92_593 VDD VSS DECAPHV8
X_09431_ _09431_/A _09431_/B _09431_/C VDD VSS _09432_/B NOR3X1
X_18629_ _19011_/CK _18629_/D _18629_/Q VDD VSS DFFQX1
XFILLER_52_446 VSS VDD FILLER2
X_09362_ _17709_/Q _17741_/Q _09362_/C VDD VSS _09363_/C AOI2B1X1
XFILLER_33_671 VDD VSS FILLER4
XFILLER_61_980 VDD VSS DECAPHV8
XTAP_TAPCELL_ROW_50_614 VDD VSS WELLTAP
XANTENNA_11 _14053_/A VDD VSS ANTENNA2
XFILLER_20_332 VDD VSS FILLER1
XFILLER_32_170 VDD VSS FILLER4
XFILLER_60_490 VDD VSS FILLER1
X_09293_ _17579_/Q _17368_/B VDD VSS _09303_/B XNOR2X1
XFILLER_119_721 VDD VSS DECAPHV16
XFILLER_118_220 VDD VSS FILLER4
XFILLER_119_743 VDD VSS FILLER1
XFILLER_20_376 VSS VDD FILLER2
XTAP_TAPCELL_ROW_119_1451 VDD VSS WELLTAP
XTAP_TAPCELL_ROW_30_382 VDD VSS WELLTAP
XFILLER_106_404 VSS VDD FILLER2
XFILLER_4_509 VSS VDD FILLER2
XFILLER_106_437 VDD VSS FILLER4
XFILLER_82_1022 VSS VDD FILLER2
XTAP_TAPCELL_ROW_58_714 VDD VSS WELLTAP
XFILLER_101_197 VDD VSS FILLER1
XFILLER_29_933 VDD VSS FILLER1
XFILLER_29_977 VSS VDD FILLER2
XFILLER_44_903 VSS VDD FILLER2
XFILLER_55_240 VSS VDD FILLER2
X_10970_ _17953_/Q _10970_/B _10970_/C VDD VSS _10972_/A MIN3X1
XFILLER_70_210 VDD VSS FILLER1
XFILLER_83_593 VDD VSS FILLER1
XTAP_TAPCELL_ROW_38_471 VDD VSS WELLTAP
XTAP_TAPCELL_ROW_83_1016 VDD VSS WELLTAP
X_09629_ _17591_/Q _17380_/B VDD VSS _09648_/A NAND2BX1
XFILLER_102_40 VDD VSS FILLER4
XFILLER_43_468 VDD VSS DECAPHV8
X_12640_ _12640_/A _12640_/B _12652_/C VDD VSS _12846_/B XNOR3X1
XFILLER_12_822 VDD VSS FILLER1
XFILLER_52_991 VDD VSS FILLER4
XFILLER_62_44 VSS VDD FILLER2
XFILLER_129_507 VSS VDD FILLER2
XFILLER_23_170 VDD VSS FILLER4
X_12571_ _12651_/A _12571_/B _12742_/D VDD VSS _12652_/C XNOR3X1
X_14310_ _14310_/A _14310_/B _14310_/C VDD VSS _18351_/D OA21X2
XFILLER_129_529 VDD VSS DECAPHV8
XFILLER_7_314 VDD VSS DECAPHV32
X_11522_ _11522_/A _11522_/B _14250_/B VDD VSS _11523_/B MIN3X1
X_15290_ _17182_/D _18857_/Q VDD VSS _18830_/D AND2X1
XFILLER_11_398 VSS VDD FILLER2
XFILLER_127_0 VDD VSS DECAPHV32
X_11453_ _11552_/C _11551_/B _11551_/C VDD VSS _11562_/B XNOR3X1
X_14241_ _14198_/Y _14241_/B _14241_/C VDD VSS _18292_/D AND3BX1
X_10404_ _10579_/B _10582_/C _10404_/C _10404_/D VDD VSS _10593_/B AOAI211X1
X_14172_ _14396_/A _14172_/B VDD VSS _18231_/D AND2X1
XTAP_TAPCELL_ROW_94_1145 VDD VSS WELLTAP
X_11384_ _11396_/A _11396_/B _11428_/C VDD VSS _14103_/B AOI21BX1
X_13123_ _13193_/A _14180_/B VDD VSS _14181_/C _13193_/C NAND3X1
XFILLER_124_267 VSS VDD FILLER2
XFILLER_125_779 VSS VDD FILLER2
X_10335_ _10154_/Y _10525_/B _10525_/C VDD VSS _17871_/D AND3BX1
X_18980_ _18982_/CK _18980_/D _18980_/Q VDD VSS DFFQX1
XFILLER_105_470 VDD VSS FILLER1
XFILLER_127_92 VDD VSS FILLER1
X_10266_ _10266_/A VDD VSS _10267_/C INVX1
X_13054_ _18317_/Q _13054_/B _13080_/C VDD VSS _13234_/A XNOR3X1
X_17931_ _17932_/CK _17931_/D _17931_/Q VDD VSS DFFQX1
X_12005_ _18360_/Q VDD VSS _12109_/A INVX1
X_17862_ _17913_/CK _17862_/D _17862_/Q VDD VSS DFFQX1
XFILLER_87_96 VDD VSS DECAPHV16
X_10197_ _10385_/A _10385_/B VDD VSS _10388_/B XNOR2X1
X_16813_ _18921_/Q _16813_/B VDD VSS _16814_/A AND2X1
XFILLER_4_1011 VDD VSS DECAPHV32
X_17793_ _19036_/CK _17793_/D _17793_/Q VDD VSS DFFQX1
XFILLER_47_763 VDD VSS FILLER4
XFILLER_98_1040 VDD VSS DECAPHV8
Xclkbuf_1_0__f_clk_fs clkbuf_0_clk_fs/Y VDD VSS _174_/CK BUFX12
X_16744_ _16875_/A _16744_/B _16744_/C VDD VSS _18918_/D OAI21X1
X_13956_ _18961_/Q _13959_/B _13959_/A VDD VSS _13971_/A AOI21X1
XFILLER_35_925 VDD VSS FILLER4
X_12907_ _18316_/Q _12907_/B _13010_/D VDD VSS _12955_/C XNOR3X1
X_16675_ _18916_/Q _16862_/B VDD VSS _16676_/C NAND2X1
X_13887_ _13887_/A _14496_/B _13887_/C _13887_/D VDD VSS _13905_/A OAOI211X1
XFILLER_61_221 VDD VSS FILLER1
X_12838_ _18315_/Q VDD VSS _12953_/A INVX1
X_18414_ _18461_/CK _18414_/D _18414_/Q VDD VSS DFFQX1
X_15626_ _15519_/B _15625_/Y _15651_/A VDD VSS _15640_/C MUXI2X1
XFILLER_34_479 VDD VSS FILLER4
XFILLER_62_788 VSS VDD FILLER2
XTAP_TAPCELL_ROW_103_1252 VDD VSS WELLTAP
XFILLER_14_181 VSS VDD FILLER2
X_12769_ _12769_/A _12769_/B _12769_/C _12769_/D VDD VSS _14150_/B AOAI211X1
X_18345_ _18397_/CK _18345_/D _18345_/Q VDD VSS DFFQX1
X_15557_ _18924_/Q _15568_/B VDD VSS _15557_/Y XOR2X1
X_18276_ _18361_/CK _18276_/D _18276_/Q VDD VSS DFFQX1
X_15488_ _15673_/A _15549_/B _15549_/C _15526_/A VDD VSS _15490_/C OAI211X1
X_14508_ _14509_/C _17525_/B _14508_/C VDD VSS _18516_/D AND3BX1
XTAP_TAPCELL_ROW_0_4 VDD VSS WELLTAP
Xclkbuf_leaf_10__002_ clkbuf_leaf_9__002_/A VDD VSS _18985_/CK BUFX12
X_17227_ _17236_/A _17236_/B _17238_/D VDD VSS _17228_/B AOI21X1
X_14439_ _14440_/A _14467_/B VDD VSS _18463_/D NOR2X1
XFILLER_115_212 VDD VSS FILLER1
XFILLER_66_1006 VDD VSS FILLER1
X_17158_ _18990_/Q _17232_/B VDD VSS _17160_/B XNOR2X1
XFILLER_103_407 VDD VSS FILLER1
XFILLER_42_0 VDD VSS DECAPHV32
X_09980_ _09980_/A _09989_/C VDD VSS _10185_/C XNOR2X1
X_17089_ _17090_/A _17090_/B _17090_/C VDD VSS _17091_/B NOR3X1
X_16109_ _16109_/A _16266_/B VDD VSS _16110_/C NAND2X1
XFILLER_112_930 VSS VDD FILLER2
XFILLER_115_278 VDD VSS FILLER1
XFILLER_118_1129 VSS VDD FILLER2
XTAP_TAPCELL_ROW_114_1381 VDD VSS WELLTAP
X_08931_ _17745_/Q _18534_/Q _08931_/C VDD VSS _08935_/B MIN3X1
Xclkbuf_leaf_25__002_ clkload27/A VDD VSS _18337_/CK BUFX12
XTAP_TAPCELL_ROW_114_1392 VDD VSS WELLTAP
XFILLER_112_985 VDD VSS DECAPHV16
XFILLER_85_836 VDD VSS FILLER1
XFILLER_84_324 VDD VSS FILLER1
XFILLER_96_184 VDD VSS FILLER1
XFILLER_38_763 VDD VSS FILLER4
XFILLER_42_1072 VDD VSS DECAPHV8
XFILLER_26_925 VDD VSS FILLER4
XFILLER_65_593 VDD VSS FILLER4
XFILLER_77_1135 VDD VSS FILLER1
XFILLER_52_243 VDD VSS FILLER4
XFILLER_53_755 VDD VSS FILLER4
X_09414_ _17583_/Q _17372_/B _09414_/C VDD VSS _09441_/B OAI21X1
XFILLER_40_427 VDD VSS FILLER1
XTAP_TAPCELL_ROW_35_441 VDD VSS WELLTAP
XTAP_TAPCELL_ROW_63_772 VDD VSS WELLTAP
X_09345_ _09345_/A _09345_/B VDD VSS _09346_/B _09345_/C NAND3X1
X_09276_ _17610_/Q _17401_/B _17367_/B VDD VSS _09305_/B AOI2B1X1
XFILLER_20_184 VDD VSS FILLER1
XFILLER_106_212 VDD VSS FILLER4
XFILLER_119_584 VSS VDD FILLER2
XFILLER_4_328 VDD VSS DECAPHV32
XFILLER_84_1106 VDD VSS FILLER1
XFILLER_134_554 VSS VDD FILLER2
XTAP_TAPCELL_ROW_7_100 VDD VSS WELLTAP
X_10120_ _10311_/A _10311_/B _10311_/C _10120_/D VDD VSS _10294_/B OAOI211X1
XFILLER_121_237 VDD VSS DECAPHV8
XFILLER_121_259 VDD VSS FILLER4
X_10051_ _10054_/A _10054_/B VDD VSS _10247_/B XNOR2X1
XFILLER_103_985 VSS VDD FILLER2
XFILLER_130_771 VSS VDD FILLER2
XFILLER_76_836 VDD VSS FILLER1
XFILLER_57_88 VDD VSS FILLER4
XFILLER_75_379 VSS VDD FILLER2
X_14790_ _18575_/Q _18607_/Q _14790_/C VDD VSS _14796_/C MIN3X1
X_13810_ _18405_/Q _13845_/A _13845_/B VDD VSS _13834_/C XOR3X1
XFILLER_29_785 VSS VDD FILLER2
X_10953_ _10956_/C _10953_/B VDD VSS _11089_/B XNOR2X1
X_13741_ _18429_/Q _14402_/B _14402_/C VDD VSS _13792_/D OR3BX1
XFILLER_32_906 VDD VSS DECAPHV8
XFILLER_71_541 VDD VSS DECAPHV16
XFILLER_73_32 VDD VSS DECAPHV32
XFILLER_32_939 VDD VSS DECAPHV16
XFILLER_43_265 VDD VSS FILLER1
XFILLER_71_585 VSS VDD FILLER2
X_10884_ _10881_/A _10884_/B _10884_/C VDD VSS _10891_/A AOI2B1X1
X_16460_ _18822_/Q _18714_/Q VDD VSS _16463_/D NAND2X1
X_13672_ _18402_/Q _13754_/A _13754_/B VDD VSS _13673_/D XNOR3X1
XFILLER_43_298 VDD VSS FILLER4
X_12623_ _12940_/A _12940_/B _12940_/D VDD VSS _12690_/B AOI21X1
X_16391_ _16391_/A _16432_/C VDD VSS _16409_/B XNOR2X1
X_15411_ _18907_/Q _15411_/B VDD VSS _15445_/B XOR2X1
XFILLER_40_972 VDD VSS FILLER4
XFILLER_8_601 VSS VDD FILLER2
X_12554_ _12554_/A _14089_/B _12554_/C _12554_/D VDD VSS _12667_/A AOAI211X1
X_18130_ _18171_/CK _18130_/D _18130_/Q VDD VSS DFFQX1
X_15342_ _18864_/Q _15344_/B VDD VSS _15343_/B XOR2X1
XFILLER_12_696 VDD VSS FILLER1
XTAP_TAPCELL_ROW_13_179 VDD VSS WELLTAP
X_11505_ _11603_/A _11603_/B _11603_/C VDD VSS _11509_/B OAI21X1
X_18061_ _18805_/CK _18061_/D _18061_/Q VDD VSS DFFQX1
X_15273_ _15274_/A _18841_/Q VDD VSS _18814_/D AND2X1
XFILLER_89_1039 VDD VSS FILLER1
X_12485_ _14475_/A _12485_/B _14444_/B VDD VSS _12486_/B MIN3X1
X_17012_ _17012_/A _17017_/B _17012_/C VDD VSS _18956_/D OAI21X1
X_14224_ _14252_/A _14224_/B VDD VSS _18277_/D NOR2X1
XFILLER_22_91 VSS VDD FILLER2
X_11436_ _18169_/Q _14104_/B VDD VSS _11603_/A AND2X1
XFILLER_98_40 VDD VSS FILLER4
X_11367_ _11430_/A _11437_/B VDD VSS _14132_/B XNOR2X1
X_14155_ _14160_/A _14155_/B VDD VSS _18215_/D NOR2X1
XFILLER_113_738 VDD VSS FILLER4
XFILLER_4_873 VDD VSS DECAPHV8
X_10318_ _10318_/A _10318_/B _10318_/C _10318_/D VDD VSS _10503_/A AOAI211X1
X_13106_ _18161_/Q _14096_/B VDD VSS _13225_/E _14096_/C AND3X2
X_18963_ _18963_/CK _18963_/D _18963_/Q VDD VSS DFFQX1
X_14086_ _14122_/A _14086_/B _14086_/C VDD VSS _18152_/D NOR3X1
XFILLER_79_641 VDD VSS FILLER4
X_11298_ _11353_/B _11353_/C VDD VSS _14072_/B NAND2X1
X_13037_ _13037_/A _13037_/B _14449_/B VDD VSS _14485_/A MIN3X1
X_17914_ _17941_/CK _17914_/D _17914_/Q VDD VSS DFFQX1
XFILLER_6_1128 VDD VSS FILLER4
XFILLER_79_674 VSS VDD FILLER2
X_10249_ _10252_/A _10252_/B VDD VSS _10438_/B XNOR2X1
X_18894_ _18961_/CK _18894_/D _18894_/Q VDD VSS DFFQX1
XFILLER_113_1026 VDD VSS FILLER4
XFILLER_121_793 VDD VSS DECAPHV8
XFILLER_66_335 VDD VSS DECAPHV8
XFILLER_67_836 VDD VSS FILLER1
X_17845_ _19036_/CK _17845_/D _17845_/Q VDD VSS DFFQX1
X_17776_ _17851_/CK _17776_/D _17776_/Q VDD VSS DFFQX1
XFILLER_19_251 VDD VSS DECAPHV16
X_16727_ _18057_/Q _18667_/Q VDD VSS _16728_/A NAND2X1
X_14988_ _18618_/Q _18996_/Q _14988_/C VDD VSS _14992_/B MIN3X1
XFILLER_90_861 VDD VSS DECAPHV8
X_13939_ _18939_/Q _18938_/Q _18940_/Q _18941_/Q VDD VSS _13972_/B AND4X2
XFILLER_22_416 VSS VDD FILLER2
X_16658_ _18827_/Q _18719_/Q _16658_/C VDD VSS _16688_/A AOI21X1
XTAP_TAPCELL_ROW_32_400 VDD VSS WELLTAP
X_16589_ _16784_/A _18772_/Q _16589_/C _16589_/D VDD VSS _16590_/C AOI22X1
X_15609_ _15594_/Y _15622_/B _15648_/A VDD VSS _15610_/B MUXI2X1
XFILLER_124_1133 VSS VDD FILLER2
XTAP_TAPCELL_ROW_60_742 VDD VSS WELLTAP
X_09130_ _17733_/Q _17701_/Q VDD VSS _09131_/B XOR2X1
X_18328_ _18381_/CK _18328_/D _18328_/Q VDD VSS DFFQX1
XFILLER_136_808 VSS VDD FILLER2
X_09061_ _17666_/Q VDD VSS _09062_/A INVX1
X_18259_ _18261_/CK _18259_/D _18259_/Q VDD VSS DFFQX1
XTAP_TAPCELL_ROW_116_1410 VDD VSS WELLTAP
XFILLER_89_405 VDD VSS FILLER4
XFILLER_116_587 VDD VSS FILLER4
X_09963_ _17797_/Q _09971_/A VDD VSS _09982_/B XOR2X1
XFILLER_131_557 VDD VSS FILLER1
XFILLER_44_1101 VSS VDD FILLER2
X_08914_ _17740_/Q _18529_/Q VDD VSS _08915_/C NAND2X1
XFILLER_103_259 VDD VSS FILLER1
XFILLER_134_49 VDD VSS DECAPHV32
X_09894_ _10093_/B _10099_/B VDD VSS _10102_/B XNOR2X1
XFILLER_112_793 VDD VSS DECAPHV8
XFILLER_85_633 VDD VSS FILLER1
XTAP_TAPCELL_ROW_68_831 VDD VSS WELLTAP
XFILLER_26_755 VDD VSS FILLER4
XFILLER_53_530 VDD VSS DECAPHV8
XFILLER_40_202 VSS VDD FILLER2
XFILLER_40_224 VSS VDD FILLER2
XFILLER_40_235 VSS VDD FILLER2
XFILLER_41_736 VDD VSS FILLER1
XFILLER_41_758 VDD VSS DECAPHV8
XFILLER_22_972 VDD VSS FILLER4
XFILLER_90_1132 VDD VSS FILLER4
X_09328_ _09325_/B _09328_/B _09328_/C VDD VSS _09352_/A AOI2B1X1
XFILLER_22_994 VSS VDD FILLER2
XFILLER_126_307 VSS VDD FILLER2
XTAP_TAPCELL_ROW_10_138 VDD VSS WELLTAP
X_09259_ _09259_/A _09281_/C VDD VSS _17435_/B XNOR2X1
XFILLER_107_510 VDD VSS FILLER4
XFILLER_119_381 VSS VDD FILLER2
X_12270_ _18310_/Q _12298_/B _12503_/D VDD VSS _14293_/C XNOR3X1
XFILLER_49_1012 VDD VSS FILLER4
X_11221_ _18030_/Q _18031_/Q VDD VSS _11224_/B _11221_/C AND3X2
XTAP_TAPCELL_ROW_91_1115 VDD VSS WELLTAP
X_11152_ _11155_/A _11155_/B VDD VSS _17100_/A XNOR2X1
XFILLER_49_1078 VDD VSS DECAPHV16
X_10103_ _10310_/A _10311_/B _10311_/C VDD VSS _10287_/C OR3BX1
XFILLER_76_611 VSS VDD FILLER2
XFILLER_89_983 VDD VSS FILLER1
X_11083_ _17975_/Q _11087_/B VDD VSS _11084_/B XOR2X1
X_15960_ _15961_/A _15961_/B _15961_/D _15961_/C VDD VSS _15960_/Y OAI211X1
XFILLER_48_324 VDD VSS FILLER1
XFILLER_49_836 VDD VSS FILLER1
X_10034_ _10227_/B _10227_/C _10035_/D _10035_/C VDD VSS _10235_/A AOAI211X1
X_15891_ _18780_/Q _18726_/Q VDD VSS _15919_/A NAND2X1
X_14911_ _18602_/Q _18634_/Q VDD VSS _14917_/B NAND2X1
X_17630_ _19024_/CK _17630_/D _17630_/Q VDD VSS DFFQX1
X_14842_ _14844_/A _14844_/B _14842_/C VDD VSS _18587_/D AOI21X1
XFILLER_48_379 VSS VDD FILLER2
XFILLER_90_113 VDD VSS DECAPHV8
XTAP_TAPCELL_ROW_89_1088 VDD VSS WELLTAP
XFILLER_1_1058 VDD VSS DECAPHV32
XFILLER_91_658 VSS VDD FILLER2
XTAP_TAPCELL_ROW_18_238 VDD VSS WELLTAP
X_11985_ _18411_/Q _12001_/B _12001_/C VDD VSS _14410_/B XNOR3X1
X_17561_ _17562_/A _17562_/B _17561_/C VDD VSS _17562_/C OAI21X1
X_14773_ _14776_/C _14774_/B _17318_/C VDD VSS _14774_/C OAI21X1
XFILLER_32_725 VDD VSS FILLER1
XTAP_TAPCELL_ROW_46_569 VDD VSS WELLTAP
X_10936_ _17946_/Q _10936_/B _10936_/C VDD VSS _10942_/A MIN3X1
X_17492_ _17498_/A _17728_/Q VDD VSS _17696_/D AND2X1
X_16512_ _16513_/A _16513_/B _16757_/A VDD VSS _16513_/C OAI21X1
X_13724_ _13725_/B _13725_/C _18454_/Q VDD VSS _13730_/B AOI21X1
XFILLER_16_276 VDD VSS FILLER4
XFILLER_16_287 VDD VSS FILLER4
XFILLER_44_596 VDD VSS DECAPHV8
XFILLER_56_1049 VDD VSS FILLER4
XFILLER_95_1098 VSS VDD FILLER2
X_10867_ _10914_/A _11001_/B VDD VSS _17959_/D NOR2X1
X_16443_ _16657_/D _16443_/B _16443_/C _16547_/D VDD VSS _16444_/D AOI22X1
X_13655_ _13655_/A _13655_/B _13655_/C _13655_/D VDD VSS _14493_/B AOAI211X1
XTAP_TAPCELL_ROW_100_1222 VDD VSS WELLTAP
X_12606_ _18391_/Q _12799_/B VDD VSS _12714_/C _12606_/C NAND3X1
XFILLER_12_460 VSS VDD FILLER2
XFILLER_40_780 VDD VSS FILLER1
X_10798_ _10798_/A _10798_/B _10798_/C VDD VSS _10802_/C MIN3X1
X_18113_ _18966_/CK _18113_/D _18113_/Q VDD VSS DFFQX1
X_16374_ _16630_/A _16374_/B _16374_/C VDD VSS _16374_/Y OAI21X1
X_13586_ _13660_/A _13660_/B VDD VSS _13659_/A NOR2X1
XFILLER_8_453 VDD VSS DECAPHV32
XTAP_TAPCELL_ROW_4_61 VDD VSS WELLTAP
XTAP_TAPCELL_ROW_4_72 VDD VSS WELLTAP
X_12537_ _12552_/A _12552_/B _12552_/C VDD VSS _14147_/B OAI21X1
X_15325_ _18859_/Q _16974_/B VDD VSS _15338_/B NAND2X1
XFILLER_129_189 VDD VSS DECAPHV32
X_12468_ _12610_/A _12468_/B _12617_/D VDD VSS _12502_/C XNOR3X1
X_18044_ _18841_/CK _18044_/D _18044_/Q VDD VSS DFFQX1
X_15256_ _15313_/A _18824_/Q VDD VSS _18797_/D AND2X1
XFILLER_125_340 VDD VSS FILLER1
XFILLER_32_1093 VDD VSS DECAPHV8
X_11419_ _18219_/Q VDD VSS _11421_/A INVX1
X_15187_ _15272_/A _18756_/Q VDD VSS _18729_/D AND2X1
X_14207_ _14198_/Y _14207_/B _14207_/C VDD VSS _18263_/D AND3BX1
XFILLER_125_351 VDD VSS FILLER4
XFILLER_99_736 VSS VDD FILLER2
X_12399_ _18467_/Q _14476_/A _14475_/B VDD VSS _12594_/B MIN3X1
X_14138_ _14160_/A _14138_/B VDD VSS _18200_/D NOR2X1
XFILLER_113_557 VDD VSS FILLER1
XFILLER_28_1129 VDD VSS FILLER4
XFILLER_63_1009 VDD VSS FILLER4
XFILLER_101_708 VSS VDD FILLER2
XFILLER_98_257 VDD VSS FILLER1
XTAP_TAPCELL_ROW_111_1351 VDD VSS WELLTAP
X_18946_ _18951_/CK _18946_/D _18946_/Q VDD VSS DFFQX1
X_14069_ _14310_/C _14069_/B VDD VSS _18137_/D AND2X1
XFILLER_39_313 VDD VSS DECAPHV8
XFILLER_67_622 VDD VSS FILLER1
XFILLER_95_953 VDD VSS FILLER1
X_18877_ _18951_/CK _18877_/D _18877_/Q VDD VSS DFFQX1
XFILLER_55_817 VDD VSS DECAPHV8
XFILLER_66_132 VDD VSS FILLER4
XFILLER_67_666 VDD VSS FILLER4
XFILLER_82_603 VDD VSS FILLER1
X_17828_ _17854_/CK _17828_/D _17828_/Q VDD VSS DFFQX1
XFILLER_54_305 VSS VDD FILLER2
XFILLER_67_699 VDD VSS FILLER1
XTAP_TAPCELL_ROW_65_801 VDD VSS WELLTAP
XFILLER_54_349 VSS VDD FILLER2
XFILLER_81_124 VSS VDD FILLER2
X_17759_ _19028_/CK _17759_/D _17759_/Q VDD VSS DFFQX1
XFILLER_63_872 VDD VSS FILLER1
XFILLER_90_691 VDD VSS FILLER4
XFILLER_22_235 VDD VSS DECAPHV8
XTAP_TAPCELL_ROW_122_1480 VDD VSS WELLTAP
Xfanout39 _15799_/B VDD VSS _16218_/A BUFX3
X_09113_ _09119_/A _09119_/B VDD VSS _17327_/B XNOR2X1
X_09044_ _17600_/Q _17390_/B VDD VSS _09045_/B XOR2X1
XFILLER_117_852 VSS VDD FILLER2
Xclkbuf_leaf_8__000_ clkbuf_leaf_9__000_/A VDD VSS _18846_/CK BUFX12
XFILLER_2_607 VDD VSS DECAPHV32
XTAP_TAPCELL_ROW_0_19 VDD VSS WELLTAP
XFILLER_1_128 VDD VSS DECAPHV32
X_09946_ _17794_/Q _09946_/B VDD VSS _09949_/A NAND2X1
XFILLER_58_611 VDD VSS FILLER1
XFILLER_58_633 VSS VDD FILLER2
X_09877_ _09976_/A _10083_/B VDD VSS _17812_/D NOR2X1
XFILLER_72_113 VDD VSS DECAPHV8
XFILLER_79_1038 VDD VSS FILLER4
XFILLER_26_530 VDD VSS DECAPHV8
XFILLER_38_390 VDD VSS FILLER4
XFILLER_26_563 VDD VSS FILLER1
XFILLER_54_861 VDD VSS FILLER1
X_11770_ _11924_/A _11924_/B VDD VSS _14138_/B XNOR2X1
XFILLER_53_371 VDD VSS FILLER1
XTAP_TAPCELL_ROW_43_539 VDD VSS WELLTAP
X_10721_ _10722_/B _10722_/C _10722_/A VDD VSS _10723_/C OAI21X1
XFILLER_110_40 VDD VSS FILLER4
X_13440_ _13440_/A _13440_/B _13440_/C _13440_/D VDD VSS _13583_/B OAOI211X1
XFILLER_41_599 VDD VSS DECAPHV16
XFILLER_70_44 VSS VDD FILLER2
X_10652_ _10731_/A _10791_/A VDD VSS _17917_/D NOR2X1
XFILLER_103_1003 VDD VSS FILLER4
XFILLER_127_616 VDD VSS FILLER4
XTAP_TAPCELL_ROW_23_296 VDD VSS WELLTAP
X_10583_ _17877_/Q _10583_/B VDD VSS _10588_/C _10583_/C AND3X2
X_13371_ _13371_/A _13371_/B _13371_/C _13371_/D VDD VSS _14335_/B OAOI211X1
XTAP_TAPCELL_ROW_136_1649 VDD VSS WELLTAP
X_12322_ _18258_/Q _14202_/B VDD VSS _12419_/D _14202_/C NAND3X1
X_16090_ _16165_/B _16778_/A _16090_/C VDD VSS _16104_/B OR3BX1
X_15110_ _15304_/A _18681_/Q VDD VSS _18654_/D AND2X1
XFILLER_126_137 VSS VDD FILLER2
XFILLER_6_979 VDD VSS DECAPHV32
X_12253_ _18127_/Q VDD VSS _12360_/A INVX1
X_15041_ _15044_/C _15042_/B _17255_/D VDD VSS _15042_/C OAI21X1
X_11204_ _11204_/A _11206_/C VDD VSS _17147_/B XNOR2X1
XFILLER_79_64 VDD VSS DECAPHV16
X_12184_ _12204_/A _12290_/B _14354_/B VDD VSS _12203_/C XNOR3X1
XFILLER_123_899 VSS VDD FILLER2
X_11135_ _11135_/A _17082_/B VDD VSS _18011_/D NOR2X1
X_18800_ _18801_/CK _18800_/D _18800_/Q VDD VSS DFFQX1
X_16992_ _18945_/Q _17007_/B VDD VSS _16993_/C NAND2X1
XFILLER_135_92 VDD VSS FILLER1
XFILLER_49_611 VDD VSS DECAPHV8
X_11066_ _11066_/A _11066_/B _11066_/C VDD VSS _11069_/C MIN3X1
X_18731_ _18815_/CK _18731_/D _18731_/Q VDD VSS DFFQX1
X_15943_ _15986_/A _15943_/B VDD VSS _15949_/B XOR2X1
XFILLER_0_183 VDD VSS DECAPHV32
XFILLER_76_441 VDD VSS FILLER4
X_10017_ _10017_/A _10017_/B _10017_/C VDD VSS _10018_/B OAI21X1
XFILLER_36_316 VSS VDD FILLER2
XFILLER_62_1097 VDD VSS FILLER1
XFILLER_63_102 VDD VSS FILLER1
XFILLER_64_625 VDD VSS DECAPHV8
XFILLER_95_96 VDD VSS DECAPHV16
XFILLER_97_1105 VSS VDD FILLER2
X_18662_ _18851_/CK _18662_/D _18662_/Q VDD VSS DFFQX1
X_15874_ _15874_/A _15874_/B _15874_/C _15874_/D VDD VSS _16064_/A AO31X2
XFILLER_76_496 VDD VSS FILLER4
X_18593_ _19004_/CK _18593_/D _18593_/Q VDD VSS DFFQX1
X_17613_ _17710_/CK _17613_/D _17613_/Q VDD VSS DFFQX1
X_14825_ _18584_/Q _18616_/Q VDD VSS _14827_/B XOR2X1
XFILLER_91_477 VSS VDD FILLER2
X_17544_ _17545_/A _17545_/B _17544_/C VDD VSS _17545_/C OAI21X1
X_14756_ _18568_/Q VDD VSS _14758_/A INVX1
X_11968_ _12052_/A _12052_/B _12052_/C VDD VSS _12065_/B AOI21X1
X_13707_ _18351_/Q _13707_/B _13707_/C VDD VSS _13752_/B XNOR3X1
XFILLER_60_853 VSS VDD FILLER2
X_10919_ _10924_/C _10924_/B VDD VSS _10920_/B NOR2BX1
X_11899_ _18488_/Q _14466_/B VDD VSS _11991_/B OR2X2
X_17475_ _17479_/A _17475_/B VDD VSS _17680_/D NOR2X1
X_14687_ _14689_/C _14687_/B _14687_/C VDD VSS _18554_/D AOI21X1
X_16426_ _18050_/Q _18660_/Q VDD VSS _16429_/D XNOR2X1
X_13638_ _18374_/Q _14337_/B VDD VSS _13674_/A NAND2X1
XFILLER_12_290 VDD VSS FILLER1
X_16357_ _16405_/A _16405_/B _16357_/C _16357_/D VDD VSS _16371_/C AOI31X1
X_13569_ _13628_/A _13628_/B _13628_/C VDD VSS _13625_/C OAI21X1
X_15308_ _15309_/A _18049_/Q VDD VSS _18848_/D AND2X1
X_18027_ _18547_/CK _18027_/D _18027_/Q VDD VSS DFFQX1
Xclkbuf_regs_0_clk_fs delaybuf_3_clk_fs/Y VDD VSS clkbuf_regs_0_clk_fs/Y BUFX12
X_16288_ _18046_/Q _18656_/Q VDD VSS _16315_/B NOR2X1
X_15239_ _15240_/A _18807_/Q VDD VSS _18780_/D AND2X1
XFILLER_114_833 VDD VSS FILLER4
XFILLER_132_129 VDD VSS DECAPHV8
XFILLER_87_728 VSS VDD FILLER2
XFILLER_99_577 VSS VDD FILLER2
X_09800_ _17565_/A _09899_/B _09899_/C VDD VSS _17789_/D AND3BX1
XFILLER_101_538 VSS VDD FILLER2
X_09731_ _19050_/Q _17351_/B VDD VSS _09733_/B XOR2X1
X_18929_ _18934_/CK _18929_/D _18929_/Q VDD VSS DFFQX1
XFILLER_28_806 VSS VDD FILLER2
XFILLER_39_143 VDD VSS FILLER1
XFILLER_41_1115 VDD VSS FILLER1
XFILLER_68_975 VDD VSS FILLER1
XFILLER_67_463 VSS VDD FILLER2
XFILLER_67_485 VSS VDD FILLER2
X_09662_ _09662_/A _09662_/B VDD VSS _09692_/B NAND2X1
XFILLER_27_327 VDD VSS FILLER1
XFILLER_55_669 VDD VSS FILLER4
X_09593_ _17590_/Q _17379_/B VDD VSS _09599_/B XNOR2X1
XFILLER_50_352 VDD VSS FILLER1
XFILLER_24_59 VDD VSS FILLER1
XFILLER_50_385 VDD VSS FILLER1
XTAP_TAPCELL_ROW_20_255 VDD VSS WELLTAP
XFILLER_108_137 VSS VDD FILLER2
XFILLER_108_148 VDD VSS FILLER1
X_09027_ _17601_/Q _17391_/B _09043_/A VDD VSS _09058_/B MIN3X1
XFILLER_85_1020 VSS VDD FILLER2
Xclkbuf_leaf_23_clk_fs_regs clkbuf_leaf_5_clk_fs_regs/A VDD VSS _19004_/CK BUFX12
XFILLER_104_332 VSS VDD FILLER2
XFILLER_105_833 VDD VSS FILLER4
XFILLER_120_836 VDD VSS FILLER1
XFILLER_131_184 VSS VDD FILLER2
XFILLER_132_696 VDD VSS FILLER1
XFILLER_133_1018 VDD VSS FILLER4
XFILLER_120_869 VDD VSS DECAPHV8
XFILLER_59_953 VDD VSS FILLER1
X_09929_ _17792_/Q _09936_/B VDD VSS _09931_/A NOR2BX1
XFILLER_100_560 VSS VDD FILLER2
XFILLER_58_463 VDD VSS FILLER1
XFILLER_85_271 VDD VSS FILLER1
XTAP_TAPCELL_ROW_76_929 VDD VSS WELLTAP
X_12940_ _12940_/A _12940_/B _12940_/C _12940_/D VDD VSS _14328_/C AOI211X1
X_12871_ _12979_/A _12979_/B VDD VSS _12905_/B NOR2X1
XFILLER_46_669 VSS VDD FILLER2
XFILLER_65_88 VDD VSS FILLER4
XTAP_TAPCELL_ROW_28_355 VDD VSS WELLTAP
XTAP_TAPCELL_ROW_86_1047 VDD VSS WELLTAP
X_11822_ _18409_/Q _11822_/B _11822_/C VDD VSS _11984_/B MIN3X1
X_14610_ _18537_/Q _18569_/Q VDD VSS _14611_/C NAND2X1
XFILLER_60_105 VSS VDD FILLER2
XTAP_TAPCELL_ROW_56_686 VDD VSS WELLTAP
X_15590_ _15669_/A _16993_/A _15590_/C VDD VSS _18876_/D OAI21X1
XFILLER_42_864 VSS VDD FILLER2
XFILLER_60_138 VDD VSS FILLER1
XFILLER_60_149 VDD VSS FILLER1
XFILLER_81_32 VDD VSS DECAPHV32
X_11753_ _18223_/Q _11753_/B _11753_/C VDD VSS _11755_/B MIN3X1
X_14541_ _14544_/A _14544_/B _14541_/C VDD VSS _18523_/D AOI21X1
XFILLER_92_1079 VDD VSS FILLER4
X_10704_ _10576_/B _10704_/B _17901_/Q VDD VSS _10705_/D AND3BX1
X_11684_ _11760_/A _14137_/B _14137_/C VDD VSS _11801_/C NOR3X1
X_17260_ _19009_/Q _17260_/B VDD VSS _17261_/B XNOR2X1
X_14472_ _14472_/A _14472_/B VDD VSS _14473_/B XNOR2X1
XFILLER_128_903 VDD VSS FILLER1
X_10635_ _11148_/A _10772_/B VDD VSS _17913_/D AND2X1
X_17191_ _17193_/D _17191_/B VDD VSS _17192_/B XNOR2X1
X_16211_ _18044_/Q _18654_/Q VDD VSS _16286_/A OR2X2
X_13423_ _13474_/A _13467_/B _13467_/C VDD VSS _13475_/C XNOR3X1
XFILLER_10_772 VDD VSS FILLER4
Xclkload109 _18000_/CK VDD VSS clkload109/Y BUFX12
X_16142_ _16411_/A _16142_/B VDD VSS _16143_/D NAND2X1
X_13354_ _13354_/A _13354_/B _13354_/C _13354_/D VDD VSS _14424_/B OAOI211X1
XFILLER_6_732 VDD VSS DECAPHV32
X_10566_ _10570_/A _10570_/B VDD VSS _10709_/C _10570_/C NAND3X1
X_12305_ _12305_/A _12305_/B _12305_/C _12305_/D VDD VSS _14201_/B AOAI211X1
XFILLER_115_619 VSS VDD FILLER2
XFILLER_127_468 VDD VSS FILLER4
XFILLER_136_980 VDD VSS DECAPHV8
XFILLER_5_253 VDD VSS DECAPHV16
XTAP_TAPCELL_ROW_97_1187 VDD VSS WELLTAP
X_10497_ _10497_/A _10497_/B _10497_/C _10497_/D VDD VSS _10669_/B OAOI211X1
X_13285_ _13466_/A _13466_/B _13466_/C VDD VSS _13363_/B AOI21X1
X_16073_ _16119_/A _16119_/B VDD VSS _16116_/A NAND2X1
XFILLER_107_170 VDD VSS FILLER1
XFILLER_114_129 VDD VSS DECAPHV8
XFILLER_30_91 VDD VSS FILLER4
X_12236_ _12338_/A _14143_/B _14143_/C VDD VSS _12328_/C OR3BX1
X_15024_ _18627_/Q _19005_/Q VDD VSS _15028_/A XOR2X1
XFILLER_123_674 VDD VSS DECAPHV16
X_12167_ _18231_/Q _12331_/A _12430_/B VDD VSS _12305_/D XNOR3X1
X_11118_ _11118_/A _11118_/B _11118_/C VDD VSS _11122_/B MIN3X1
XFILLER_65_901 VDD VSS FILLER4
X_12098_ _18412_/Q _12202_/B _12106_/C VDD VSS _12193_/B XNOR3X1
X_16975_ _16984_/A _16984_/B VDD VSS _17017_/B NAND2X1
X_11049_ _17968_/Q _11052_/B VDD VSS _11053_/B XNOR2X1
X_18714_ _18850_/CK _18714_/D _18714_/Q VDD VSS DFFQX1
X_15926_ _18836_/Q _18674_/Q VDD VSS _15929_/B XNOR2X1
XFILLER_92_753 VDD VSS FILLER1
X_18645_ _18835_/CK _18645_/D _18645_/Q VDD VSS DFFQX1
X_15857_ _16018_/C _15931_/B _15857_/C _15857_/D VDD VSS _15858_/D OAI31X1
XFILLER_18_861 VDD VSS DECAPHV8
XFILLER_64_477 VDD VSS FILLER1
X_14808_ _14808_/A _14808_/B VDD VSS _14809_/C NAND2X1
XFILLER_17_371 VDD VSS FILLER1
XFILLER_91_274 VDD VSS FILLER1
XFILLER_92_797 VDD VSS FILLER1
X_18576_ _18641_/CK _18576_/D _18576_/Q VDD VSS DFFQX1
Xclkbuf_leaf_7__001_ clkload74/A VDD VSS _17908_/CK BUFX12
X_15788_ _18893_/Q _16196_/A VDD VSS _15834_/B _15865_/A NAND3X1
XFILLER_33_853 VDD VSS DECAPHV16
XTAP_TAPCELL_ROW_106_1294 VDD VSS WELLTAP
X_17527_ _08891_/C _17527_/B _17534_/A VDD VSS _17727_/D AND3BX1
X_14739_ _14740_/A _14740_/B _14740_/D _14740_/C VDD VSS _14742_/C AOI211X1
XFILLER_20_514 VDD VSS DECAPHV8
X_17458_ _17463_/A _17458_/B VDD VSS _17664_/D NOR2X1
XFILLER_119_914 VDD VSS FILLER4
XFILLER_20_547 VDD VSS DECAPHV16
XFILLER_60_694 VSS VDD FILLER2
X_16409_ _16783_/D _16409_/B _16409_/C _16409_/D VDD VSS _16411_/B OAI211X1
XFILLER_20_569 VDD VSS FILLER1
XFILLER_72_0 VDD VSS DECAPHV32
X_17389_ _17395_/A _17389_/B VDD VSS _17599_/D NOR2X1
XFILLER_69_1015 VDD VSS FILLER1
XFILLER_69_1026 VDD VSS FILLER1
Xclkbuf_leaf_11__000_ clkbuf_leaf_9__000_/A VDD VSS _18815_/CK BUFX12
XFILLER_132_1062 VDD VSS FILLER4
XFILLER_19_48 VDD VSS FILLER1
X_09714_ _09714_/A _09714_/B _09714_/C _09714_/D VDD VSS _09739_/A AOAI211X1
XFILLER_55_422 VDD VSS FILLER1
XFILLER_67_282 VSS VDD FILLER2
X_09645_ _09658_/A _09658_/B VDD VSS _17382_/B XNOR2X1
XFILLER_15_308 VDD VSS FILLER1
XFILLER_83_786 VSS VDD FILLER2
XFILLER_27_179 VDD VSS FILLER1
XTAP_TAPCELL_ROW_25_314 VDD VSS WELLTAP
X_09576_ _17621_/Q _17413_/B VDD VSS _09591_/A NOR2X1
XFILLER_51_650 VDD VSS FILLER1
XTAP_TAPCELL_ROW_53_656 VDD VSS WELLTAP
XFILLER_24_886 VDD VSS DECAPHV16
XTAP_TAPCELL_ROW_81_987 VDD VSS WELLTAP
X_10420_ _10420_/A _10420_/B _10420_/C _10420_/D VDD VSS _10423_/C OAOI211X1
XFILLER_100_1006 VSS VDD FILLER2
XFILLER_109_457 VDD VSS FILLER1
XFILLER_13_1058 VDD VSS FILLER4
XFILLER_87_1115 VDD VSS FILLER1
XFILLER_109_468 VSS VDD FILLER2
XTAP_TAPCELL_ROW_133_1619 VDD VSS WELLTAP
X_10351_ _17847_/Q _10351_/B _10356_/B VDD VSS _10535_/C XNOR3X1
X_10282_ _10282_/A _10282_/B _10282_/C VDD VSS _10283_/C MIN3X1
X_13070_ _13121_/A _13191_/A _13191_/B VDD VSS _13071_/D XNOR3X1
XFILLER_3_779 VDD VSS DECAPHV32
XFILLER_78_503 VDD VSS DECAPHV8
X_12021_ _18255_/Q _14199_/B VDD VSS _12216_/C _14199_/C AND3X2
XFILLER_132_471 VSS VDD FILLER2
XFILLER_2_267 VDD VSS DECAPHV32
XFILLER_76_32 VDD VSS DECAPHV8
XFILLER_111_1102 VDD VSS FILLER4
XFILLER_24_1132 VDD VSS FILLER4
XFILLER_47_923 VDD VSS FILLER4
XFILLER_58_260 VDD VSS DECAPHV8
XFILLER_93_506 VDD VSS FILLER4
X_16760_ _16782_/A _16782_/B VDD VSS _16761_/D XNOR2X1
X_13972_ _18942_/Q _13972_/B _18943_/Q VDD VSS _13973_/C AOI21X1
XFILLER_47_945 VDD VSS FILLER1
XFILLER_47_967 VDD VSS FILLER4
XFILLER_86_591 VDD VSS FILLER4
X_12923_ _12923_/A _12923_/B _12923_/C VDD VSS _14448_/B XNOR3X1
X_15711_ _18887_/Q _15736_/B VDD VSS _15712_/C NAND2X1
XFILLER_46_466 VSS VDD FILLER2
X_18430_ _18480_/CK _18430_/D _18430_/Q VDD VSS DFFQX1
X_16691_ _16782_/D _16691_/B _16728_/B _16691_/D VDD VSS _16697_/C AOI31X1
X_12854_ _12854_/A _14206_/B VDD VSS _12965_/A OR2X2
X_15642_ _18880_/Q _15792_/D _15752_/C _16998_/A VDD VSS _18880_/D AO22X2
X_11805_ _18252_/Q _14195_/B _14195_/C VDD VSS _11843_/C OR3BX1
X_12785_ _18133_/Q _12891_/D _12785_/C VDD VSS _12880_/C XOR3X1
X_18361_ _18361_/CK _18361_/D _18361_/Q VDD VSS DFFQX1
X_15573_ _15515_/Y _15571_/Y _15674_/A VDD VSS _15675_/B MUX2X1
XFILLER_30_812 VDD VSS DECAPHV8
X_11736_ _11736_/A _11736_/B _14284_/B VDD VSS _11827_/B MIN3X1
X_18292_ _18292_/CK _18292_/D _18292_/Q VDD VSS DFFQX1
X_17312_ _17312_/A _17315_/B _17312_/C VDD VSS _17317_/B MIN3X1
X_14524_ _18520_/Q _18552_/Q VDD VSS _14526_/B XOR2X1
XTAP_TAPCELL_ROW_99_1205 VDD VSS WELLTAP
X_17243_ _19006_/Q _17260_/B VDD VSS _17248_/B XNOR2X1
XFILLER_128_700 VDD VSS FILLER1
X_11667_ _18250_/Q VDD VSS _11669_/A INVX1
X_14455_ _15309_/A _14455_/B VDD VSS _18477_/D AND2X1
XFILLER_127_221 VDD VSS DECAPHV32
X_10618_ _10620_/A _10618_/B VDD VSS _10756_/B XNOR2X1
X_11598_ _18276_/Q _11663_/B _14223_/B VDD VSS _11738_/B MIN3X1
X_17174_ _18993_/Q _17232_/B VDD VSS _17176_/C XNOR2X1
X_14386_ _14389_/A _14386_/B VDD VSS _18415_/D NOR2X1
X_13406_ _13407_/C _14157_/B VDD VSS _13408_/C _14156_/B NAND3X1
XFILLER_128_788 VSS VDD FILLER2
X_10549_ _17875_/Q _10561_/A _10555_/C VDD VSS _10701_/C XNOR3X1
X_16125_ _18042_/Q _18652_/Q VDD VSS _16126_/B XOR2X1
X_13337_ _13337_/A _13337_/B VDD VSS _13338_/C XNOR2X1
XFILLER_109_991 VSS VDD FILLER2
XFILLER_115_427 VDD VSS DECAPHV16
X_16056_ _16411_/A _16056_/B VDD VSS _16144_/B _16056_/C _16056_/D NAND4X2
XFILLER_124_972 VDD VSS FILLER4
XFILLER_29_1032 VDD VSS FILLER1
X_13268_ _18371_/Q _13466_/A _13466_/B VDD VSS _13276_/C XNOR3X1
X_15007_ _18623_/Q _19001_/Q VDD VSS _15009_/D XNOR2X1
XFILLER_111_622 VDD VSS DECAPHV8
XFILLER_96_300 VDD VSS DECAPHV16
X_12219_ _14231_/B _12304_/C _18283_/Q VDD VSS _12503_/C AND3BX1
X_13199_ _13199_/A _14210_/B _14210_/C VDD VSS _13200_/D NOR3X1
XFILLER_111_677 VDD VSS DECAPHV8
XFILLER_2_40 VDD VSS FILLER4
XFILLER_56_208 VDD VSS FILLER4
X_16958_ _18935_/Q _16970_/B VDD VSS _16960_/A XOR2X1
XFILLER_49_282 VDD VSS FILLER4
XFILLER_65_742 VSS VDD FILLER2
XTAP_TAPCELL_ROW_108_1312 VDD VSS WELLTAP
X_15909_ _16456_/A _15909_/B _15909_/C VDD VSS _18896_/D OAI21X1
XFILLER_25_606 VDD VSS FILLER4
X_09430_ _09431_/A _09431_/B _09431_/C VDD VSS _09459_/B OAI21X1
X_16889_ _16889_/A _16889_/B VDD VSS _16890_/B AND2X1
XFILLER_18_680 VDD VSS FILLER1
XFILLER_52_425 VDD VSS FILLER1
XFILLER_80_712 VSS VDD FILLER2
XFILLER_92_583 VDD VSS FILLER4
X_18628_ _19011_/CK _18628_/D _18628_/Q VDD VSS DFFQX1
XFILLER_24_138 VDD VSS FILLER1
XFILLER_52_458 VDD VSS FILLER1
X_09361_ _17742_/Q _17710_/Q VDD VSS _09364_/A XNOR2X1
X_18559_ clkload7/A _18559_/D _18559_/Q VDD VSS DFFQX1
XFILLER_36_1036 VDD VSS FILLER4
XFILLER_80_789 VDD VSS FILLER1
XTAP_TAPCELL_ROW_50_615 VDD VSS WELLTAP
X_09292_ _09305_/B _09292_/B VDD VSS _17368_/B XNOR2X1
XANTENNA_12 output9/A VDD VSS ANTENNA2
XFILLER_20_311 VDD VSS DECAPHV8
XFILLER_119_700 VDD VSS FILLER1
XTAP_TAPCELL_ROW_119_1441 VDD VSS WELLTAP
XTAP_TAPCELL_ROW_119_1452 VDD VSS WELLTAP
XTAP_TAPCELL_ROW_30_383 VDD VSS WELLTAP
XFILLER_118_276 VDD VSS DECAPHV16
XFILLER_102_622 VSS VDD FILLER2
XFILLER_101_132 VSS VDD FILLER2
XFILLER_82_1067 VSS VDD FILLER2
XFILLER_99_193 VSS VDD FILLER2
XFILLER_82_1089 VDD VSS DECAPHV8
XTAP_TAPCELL_ROW_58_715 VDD VSS WELLTAP
XFILLER_101_176 VDD VSS DECAPHV8
XFILLER_83_550 VDD VSS FILLER1
Xmax_cap36 wire35/A VDD VSS _16084_/A BUFX4
XFILLER_28_477 VDD VSS FILLER4
XFILLER_55_263 VDD VSS FILLER1
XFILLER_70_200 VDD VSS DECAPHV8
XTAP_TAPCELL_ROW_38_472 VDD VSS WELLTAP
XTAP_TAPCELL_ROW_83_1017 VDD VSS WELLTAP
X_09628_ _19046_/Q _17347_/B VDD VSS _09652_/A NAND2BX1
XFILLER_43_458 VDD VSS FILLER4
X_09559_ _17749_/Q _17717_/Q VDD VSS _09560_/B XNOR2X1
XFILLER_71_778 VDD VSS DECAPHV8
X_12570_ _18209_/Q _12763_/A _12769_/B VDD VSS _12742_/D XNOR3X1
XFILLER_23_182 VDD VSS FILLER1
XFILLER_24_694 VSS VDD FILLER2
XFILLER_51_480 VDD VSS FILLER1
X_11521_ _18274_/Q _11521_/B _11521_/C VDD VSS _14250_/B XNOR3X1
X_11452_ _18971_/Q _18092_/Q VDD VSS _11551_/C XOR2X1
X_14240_ _14296_/A _14240_/B _14240_/C VDD VSS _18291_/D NOR3X1
XFILLER_109_243 VSS VDD FILLER2
X_10403_ _17853_/Q _10414_/A _10414_/B VDD VSS _10404_/D XOR3X1
X_11383_ _11383_/A _11383_/B _11383_/C _11383_/D VDD VSS _11396_/B AOAI211X1
X_14171_ _14174_/A _14171_/B _14171_/C VDD VSS _18230_/D NOR3X1
XFILLER_125_725 VSS VDD FILLER2
XTAP_TAPCELL_ROW_94_1146 VDD VSS WELLTAP
X_10334_ _10350_/A _10513_/B _10523_/C VDD VSS _10525_/C OR3BX1
X_13122_ _18213_/Q _13122_/B _13122_/C VDD VSS _13193_/C XNOR3X1
XFILLER_124_235 VDD VSS DECAPHV32
XFILLER_2_0 VDD VSS DECAPHV32
XFILLER_3_532 VDD VSS DECAPHV16
XFILLER_78_300 VDD VSS FILLER1
X_10265_ _10268_/A _10456_/B VDD VSS _17861_/D NOR2X1
X_13053_ _18291_/Q _13053_/B _13186_/D VDD VSS _13080_/C XNOR3X1
X_17930_ _17932_/CK _17930_/D _17930_/Q VDD VSS DFFQX1
Xclkbuf_leaf_6__002_ clkbuf_leaf_9__002_/A VDD VSS _18966_/CK BUFX12
XFILLER_121_964 VSS VDD FILLER2
XFILLER_61_1107 VDD VSS DECAPHV8
XFILLER_87_64 VDD VSS DECAPHV16
X_10196_ _10196_/A _10206_/B _10206_/C VDD VSS _10385_/B XNOR3X1
X_12004_ _12101_/A _12101_/B _14352_/B VDD VSS _12201_/B MIN3X1
X_17861_ _17861_/CK _17861_/D _17861_/Q VDD VSS DFFQX1
XFILLER_78_355 VSS VDD FILLER2
X_16812_ _16875_/A _16812_/B _16812_/C VDD VSS _18921_/D OAI21X1
XFILLER_120_496 VDD VSS DECAPHV8
X_17792_ _19036_/CK _17792_/D _17792_/Q VDD VSS DFFQX1
XFILLER_4_1067 VSS VDD FILLER2
X_16743_ _18918_/Q _16862_/B VDD VSS _16744_/C NAND2X1
X_13955_ _18960_/Q _13955_/B VDD VSS _13959_/B OR2X2
XFILLER_35_937 VSS VDD FILLER2
XFILLER_98_1096 VDD VSS FILLER4
X_12906_ _18290_/Q _13076_/A _13186_/B VDD VSS _13010_/D XNOR3X1
X_16674_ _16674_/A _16674_/B _16674_/C wire30/Y VDD VSS _16676_/B OAI31X1
X_13886_ _13892_/B _14462_/C _18484_/Q VDD VSS _13887_/D AND3BX1
X_12837_ _18314_/Q _14265_/B VDD VSS _12840_/C _14265_/C NAND3X1
X_18413_ _18461_/CK _18413_/D _18413_/Q VDD VSS DFFQX1
X_15625_ _15571_/Y _15674_/B _15674_/A VDD VSS _15625_/Y MUXI2X1
XFILLER_43_981 VDD VSS FILLER1
XFILLER_50_918 VDD VSS FILLER4
XTAP_TAPCELL_ROW_103_1253 VDD VSS WELLTAP
X_18344_ _18397_/CK _18344_/D _18344_/Q VDD VSS DFFQX1
X_12768_ _18184_/Q _14120_/B VDD VSS _12902_/A NAND2X1
X_15556_ _18922_/Q _18923_/Q VDD VSS _15568_/B _15556_/C NAND3X1
XFILLER_30_653 VDD VSS FILLER1
X_11719_ _18382_/Q _11825_/B _11820_/C VDD VSS _11724_/C XNOR3X1
X_12699_ _18496_/Q _14480_/B VDD VSS _12704_/B XNOR2X1
X_18275_ _18361_/CK _18275_/D _18275_/Q VDD VSS DFFQX1
X_15487_ _15673_/A _15517_/B VDD VSS _15549_/C NAND2X1
X_14507_ _14507_/A _14507_/B VDD VSS _14508_/C NAND2X1
XTAP_TAPCELL_ROW_0_5 VDD VSS WELLTAP
Xclkbuf_leaf_10__001_ clkload74/A VDD VSS _17941_/CK BUFX12
X_17226_ _19001_/Q _19002_/Q _17226_/C VDD VSS _17238_/D OA21X2
X_14438_ _14440_/A _14438_/B VDD VSS _18462_/D NOR2X1
X_17157_ _17224_/A _18989_/Q VDD VSS _18989_/D NOR2X1
X_16108_ _16412_/A _16108_/B _16108_/C VDD VSS _16110_/B AOI21X1
X_14369_ _14372_/A _14369_/B VDD VSS _18399_/D AND2X1
XFILLER_66_1018 VSS VDD FILLER2
XFILLER_6_392 VDD VSS DECAPHV16
X_17088_ _18013_/Q _17092_/B VDD VSS _17090_/C XOR2X1
XFILLER_131_717 VDD VSS DECAPHV16
XFILLER_131_739 VDD VSS FILLER1
XTAP_TAPCELL_ROW_114_1382 VDD VSS WELLTAP
X_08930_ _17746_/Q _18535_/Q VDD VSS _08935_/A XNOR2X1
Xclkbuf_leaf_25__001_ clkbuf_2_1__f__001_/Y VDD VSS _19024_/CK BUFX12
X_16039_ _16089_/A _16089_/B _16206_/A VDD VSS _16039_/Y OAI21X1
XFILLER_112_942 VDD VSS FILLER1
XFILLER_35_0 VDD VSS DECAPHV32
XFILLER_97_642 VSS VDD FILLER2
XFILLER_57_506 VDD VSS FILLER1
XFILLER_85_804 VDD VSS FILLER1
XFILLER_111_474 VDD VSS FILLER1
XFILLER_85_848 VDD VSS FILLER1
XFILLER_97_697 VSS VDD FILLER2
XFILLER_38_775 VSS VDD FILLER2
XFILLER_65_561 VSS VDD FILLER2
XFILLER_77_1114 VSS VDD FILLER2
XFILLER_16_49 VDD VSS DECAPHV8
X_09413_ _19038_/Q _17338_/B VDD VSS _09437_/A NOR2X1
XTAP_TAPCELL_ROW_35_442 VDD VSS WELLTAP
XTAP_TAPCELL_ROW_63_773 VDD VSS WELLTAP
X_09344_ _09345_/A _09345_/B _09345_/C VDD VSS _09369_/B AO21X2
X_09275_ _09275_/A _09275_/B _09275_/C VDD VSS _09294_/A MIN3X1
XFILLER_20_174 VDD VSS FILLER4
XFILLER_107_747 VSS VDD FILLER2
XFILLER_106_235 VDD VSS DECAPHV16
XFILLER_107_769 VDD VSS FILLER1
XFILLER_106_279 VDD VSS FILLER1
XFILLER_122_728 VDD VSS FILLER4
XTAP_TAPCELL_ROW_7_101 VDD VSS WELLTAP
X_10050_ _10053_/A _10053_/B VDD VSS _10054_/B XOR2X1
XFILLER_88_664 VDD VSS FILLER1
XFILLER_76_848 VDD VSS DECAPHV8
XFILLER_87_185 VDD VSS FILLER1
XFILLER_87_196 VDD VSS DECAPHV16
XFILLER_21_1124 VDD VSS DECAPHV8
XFILLER_17_948 VDD VSS FILLER1
XFILLER_84_881 VSS VDD FILLER2
X_10952_ _17950_/Q _10956_/B VDD VSS _10953_/B XNOR2X1
X_13740_ _13751_/A _14401_/B _13751_/C VDD VSS _14402_/C NOR3X1
XFILLER_25_981 VDD VSS FILLER4
XFILLER_44_778 VSS VDD FILLER2
XFILLER_73_88 VDD VSS FILLER4
X_10883_ _17936_/Q _10883_/B VDD VSS _10884_/C AND2X1
X_15410_ _18908_/Q _15410_/B VDD VSS _15410_/Y XNOR2X1
X_13671_ _13674_/A _13674_/B _13674_/C _13671_/D VDD VSS _13754_/A AOAI211X1
XFILLER_24_480 VDD VSS FILLER1
XFILLER_31_439 VSS VDD FILLER2
XFILLER_58_1091 VSS VDD FILLER2
X_12622_ _12723_/A _14298_/B _14298_/C VDD VSS _12940_/D NOR3X1
X_16390_ _16390_/A _16390_/B _16390_/C _16390_/D VDD VSS _16432_/C AOAI211X1
XFILLER_19_1064 VDD VSS FILLER4
XFILLER_40_962 VSS VDD FILLER2
X_12553_ _18129_/Q _14060_/B VDD VSS _12554_/D _14060_/C NAND3X1
X_15341_ _15344_/B _15341_/B _172_/E VDD VSS _18863_/D NOR3BX1
XFILLER_89_1007 VDD VSS FILLER4
XTAP_TAPCELL_ROW_13_169 VDD VSS WELLTAP
X_11504_ _18197_/Q _11621_/A _11672_/B VDD VSS _11607_/D XNOR3X1
X_18060_ _18863_/CK _18060_/D _18060_/Q VDD VSS DFFQX1
X_15272_ _15272_/A _18840_/Q VDD VSS _18813_/D AND2X1
X_12484_ _18441_/Q _12484_/B _14414_/B VDD VSS _14444_/B XNOR3X1
X_17011_ _18956_/Q _17016_/B VDD VSS _17012_/C NAND2X1
X_14223_ _15300_/A _14223_/B VDD VSS _18276_/D AND2X1
XFILLER_125_511 VDD VSS FILLER4
XFILLER_22_81 VSS VDD FILLER2
XFILLER_7_189 VDD VSS DECAPHV32
X_11435_ _11483_/A _11537_/B VDD VSS _14104_/B XNOR2X1
XFILLER_99_929 VDD VSS FILLER1
X_11366_ _11426_/A _11366_/B _11428_/C VDD VSS _11437_/B XNOR3X1
X_14154_ _14149_/Y _14154_/B _14154_/C VDD VSS _18214_/D AND3BX1
XFILLER_3_362 VDD VSS DECAPHV8
XFILLER_98_439 VSS VDD FILLER2
X_10317_ _17842_/Q _10317_/B VDD VSS _10318_/D _10317_/C NAND3X1
X_11297_ _11345_/A _11345_/B VDD VSS _11353_/C _11345_/C NAND3X1
X_13105_ _13105_/A _13105_/B _13105_/C VDD VSS _14096_/C OAI21X1
X_18962_ _18963_/CK _18962_/D _18962_/Q VDD VSS DFFQX1
X_14085_ _14122_/A _14085_/B _14085_/C VDD VSS _18151_/D NOR3X1
X_10248_ _17833_/Q _10251_/B VDD VSS _10252_/B XNOR2X1
X_13036_ _18446_/Q _13036_/B _13036_/C VDD VSS _14449_/B XNOR3X1
X_17913_ _17913_/CK _17913_/D _17913_/Q VDD VSS DFFQX1
XFILLER_105_290 VDD VSS FILLER1
XFILLER_26_1024 VDD VSS FILLER4
XFILLER_94_601 VSS VDD FILLER2
XFILLER_94_612 VDD VSS FILLER4
X_18893_ _18961_/CK _18893_/D _18893_/Q VDD VSS DFFQX1
XFILLER_120_271 VDD VSS DECAPHV8
XFILLER_26_1068 VDD VSS FILLER1
XFILLER_78_163 VDD VSS FILLER4
X_10179_ _17822_/Q _10179_/B VDD VSS _10183_/C _10179_/C NAND3X1
X_17844_ _19038_/CK _17844_/D _17844_/Q VDD VSS DFFQX1
XFILLER_19_230 VDD VSS DECAPHV16
XFILLER_66_347 VSS VDD FILLER2
X_17775_ _19043_/CK _17775_/D _17775_/Q VDD VSS DFFQX1
X_14987_ _18619_/Q _18997_/Q VDD VSS _14992_/A XNOR2X1
XFILLER_47_561 VDD VSS FILLER4
X_16726_ _16778_/A _16748_/C _16726_/C _16726_/D VDD VSS _16732_/C OAI31X1
X_13938_ _14053_/A wire34/Y VDD VSS _18060_/D NOR2X1
XFILLER_34_244 VDD VSS FILLER1
XFILLER_90_873 VSS VDD FILLER2
X_16657_ _16782_/D _16657_/B _16657_/C _16657_/D VDD VSS _16664_/C AOI22X1
X_13869_ _18458_/Q _14434_/B VDD VSS _13892_/A NOR2BX1
XFILLER_72_1022 VDD VSS FILLER1
XTAP_TAPCELL_ROW_32_401 VDD VSS WELLTAP
X_16588_ _16588_/A _16624_/C VDD VSS _16589_/D NOR2X1
X_15608_ _18928_/Q _15632_/C VDD VSS _15622_/B XNOR2X1
XFILLER_31_973 VDD VSS FILLER1
XFILLER_33_1017 VDD VSS FILLER4
XFILLER_72_1055 VDD VSS DECAPHV8
XTAP_TAPCELL_ROW_60_743 VDD VSS WELLTAP
X_18327_ _18408_/CK _18327_/D _18327_/Q VDD VSS DFFQX1
X_15539_ _15669_/A _16987_/A _15539_/C VDD VSS _18872_/D OAI21X1
X_09060_ _17634_/Q _17427_/B _09060_/C VDD VSS _09099_/A MIN3X1
X_18258_ _18309_/CK _18258_/D _18258_/Q VDD VSS DFFQX1
X_17209_ _17224_/A _17209_/B VDD VSS _18999_/D NOR2X1
XTAP_TAPCELL_ROW_116_1411 VDD VSS WELLTAP
X_18189_ _18295_/CK _18189_/D _18189_/Q VDD VSS DFFQX1
XFILLER_131_514 VDD VSS FILLER1
XFILLER_89_417 VSS VDD FILLER2
X_09962_ _17796_/Q _09969_/B VDD VSS _09964_/A NOR2BX1
XFILLER_89_439 VDD VSS FILLER4
X_08913_ _17739_/Q _18528_/Q _17555_/A VDD VSS _17557_/B MIN3X1
XFILLER_112_772 VDD VSS DECAPHV16
XFILLER_97_461 VDD VSS FILLER4
X_09893_ _09904_/A _09904_/B VDD VSS _10099_/B XOR2X1
XFILLER_111_260 VSS VDD FILLER2
XFILLER_131_1127 VDD VSS FILLER4
XFILLER_57_303 VSS VDD FILLER2
XFILLER_58_837 VDD VSS DECAPHV8
XTAP_TAPCELL_ROW_68_832 VDD VSS WELLTAP
XFILLER_57_369 VSS VDD FILLER2
XFILLER_100_989 VDD VSS FILLER1
XFILLER_27_48 VDD VSS FILLER4
XFILLER_38_561 VDD VSS DECAPHV16
XFILLER_72_328 VSS VDD FILLER2
XTAP_TAPCELL_ROW_127_1540 VDD VSS WELLTAP
XFILLER_81_840 VDD VSS FILLER4
XFILLER_25_255 VSS VDD FILLER2
XFILLER_53_575 VDD VSS FILLER1
XFILLER_81_884 VDD VSS FILLER4
XFILLER_25_277 VSS VDD FILLER2
X_09327_ _19035_/Q _17335_/B VDD VSS _09328_/C NOR2X1
XFILLER_21_461 VDD VSS FILLER4
XTAP_TAPCELL_ROW_10_139 VDD VSS WELLTAP
X_09258_ _17674_/Q _17469_/B VDD VSS _09281_/C XNOR2X1
XFILLER_119_360 VSS VDD FILLER2
X_09189_ _17575_/Q _17364_/B VDD VSS _09190_/B XNOR2X1
XFILLER_4_137 VSS VDD FILLER2
XFILLER_5_649 VSS VDD FILLER2
X_11220_ _18030_/Q _11221_/C _18031_/Q VDD VSS _11222_/B AOI21X1
XFILLER_108_40 VDD VSS FILLER4
XFILLER_1_811 VDD VSS DECAPHV16
XTAP_TAPCELL_ROW_91_1105 VDD VSS WELLTAP
XTAP_TAPCELL_ROW_91_1116 VDD VSS WELLTAP
X_11151_ _17988_/Q _11154_/B VDD VSS _11155_/B XNOR2X1
XFILLER_136_1038 VDD VSS DECAPHV32
XFILLER_68_44 VSS VDD FILLER2
X_10102_ _17814_/Q _10102_/B VDD VSS _10310_/A NAND2X1
X_11082_ _11079_/A _11082_/B _11082_/C VDD VSS _11086_/A AOI2B1X1
XFILLER_103_772 VDD VSS DECAPHV16
XFILLER_88_494 VDD VSS FILLER1
X_10033_ _10033_/A _10037_/B VDD VSS _10035_/C XNOR2X1
X_15890_ _15912_/A _15912_/B _15912_/C _16316_/A VDD VSS _15895_/B AOI31X1
X_14910_ _18602_/Q _18634_/Q VDD VSS _14917_/C NOR2X1
XFILLER_48_336 VDD VSS FILLER4
XFILLER_64_807 VDD VSS FILLER4
XFILLER_75_144 VDD VSS FILLER4
XFILLER_84_32 VDD VSS DECAPHV8
X_14841_ _14844_/A _14844_/B _17544_/C VDD VSS _14842_/C OAI21X1
XFILLER_75_177 VDD VSS DECAPHV8
XTAP_TAPCELL_ROW_89_1089 VDD VSS WELLTAP
X_17560_ _17560_/A _17560_/B _17560_/C VDD VSS _17741_/D AOI21X1
XFILLER_1_1026 VDD VSS DECAPHV32
XFILLER_63_339 VDD VSS DECAPHV16
XFILLER_75_199 VSS VDD FILLER2
XTAP_TAPCELL_ROW_18_239 VDD VSS WELLTAP
X_11984_ _11984_/A _11984_/B _14381_/B VDD VSS _12001_/C MIN3X1
X_16511_ _16549_/C _16549_/D VDD VSS _16513_/B NAND2BX1
X_14772_ _18572_/Q _18604_/Q VDD VSS _14774_/B XOR2X1
XFILLER_32_715 VDD VSS DECAPHV8
X_10935_ _10935_/A VDD VSS _10936_/C INVX1
X_17491_ _17498_/A _17727_/Q VDD VSS _17695_/D AND2X1
X_13723_ _14428_/A _14428_/B _14428_/C VDD VSS _13725_/B OAI21X1
XFILLER_31_214 VDD VSS DECAPHV8
X_10866_ _10868_/C _10866_/B VDD VSS _11001_/B XNOR2X1
Xclkbuf_leaf_24__002_ clkload27/A VDD VSS _18309_/CK BUFX12
X_16442_ _16465_/B _16442_/B VDD VSS _16443_/C XNOR2X1
X_13654_ _18480_/Q _13730_/A _13784_/B VDD VSS _13655_/D XNOR3X1
XFILLER_31_258 VDD VSS FILLER4
XTAP_TAPCELL_ROW_100_1223 VDD VSS WELLTAP
X_12605_ _12799_/B _12606_/C _18391_/Q VDD VSS _12714_/B AOI21X1
X_16373_ _16412_/A _16373_/B VDD VSS _16374_/C NAND2X1
XFILLER_13_984 VDD VSS FILLER1
XFILLER_8_421 VDD VSS DECAPHV32
X_10797_ _14310_/C _10931_/B VDD VSS _17945_/D AND2X1
X_18112_ _18966_/CK _18112_/D _18112_/Q VDD VSS DFFQX1
X_15324_ _16784_/A _15793_/C VDD VSS _16974_/B _15324_/C NAND3X1
X_13585_ _18505_/Q _14492_/B VDD VSS _13660_/A AND2X1
XFILLER_12_494 VDD VSS DECAPHV8
XTAP_TAPCELL_ROW_4_62 VDD VSS WELLTAP
X_12536_ _12536_/A _12536_/B _12552_/C VDD VSS _12743_/B XNOR3X1
X_12467_ _18312_/Q _12631_/A _12844_/B VDD VSS _12617_/D XNOR3X1
X_18043_ _18841_/CK _18043_/D _18043_/Q VDD VSS DFFQX1
Xclkbuf_leaf_39__002_ clkload26/A VDD VSS _18493_/CK BUFX12
X_15255_ _17388_/A _18823_/Q VDD VSS _18796_/D AND2X1
X_11418_ _11418_/A _11418_/B _14188_/B VDD VSS _11424_/B MIN3X1
X_15186_ _15272_/A _18755_/Q VDD VSS _18728_/D AND2X1
X_14206_ _14217_/A _14206_/B VDD VSS _18262_/D NOR2X1
XFILLER_126_886 VDD VSS DECAPHV16
XFILLER_4_671 VDD VSS DECAPHV16
XFILLER_67_1135 VDD VSS FILLER1
X_12398_ _12398_/A _12398_/B _14443_/B VDD VSS _14476_/A MIN3X1
X_14137_ _14174_/A _14137_/B _14137_/C VDD VSS _18199_/D NOR3X1
XFILLER_98_225 VDD VSS FILLER4
X_11349_ _11349_/A _11349_/B _11349_/C VDD VSS _14070_/B XNOR3X1
XFILLER_95_910 VSS VDD FILLER2
XTAP_TAPCELL_ROW_111_1352 VDD VSS WELLTAP
X_18945_ _18951_/CK _18945_/D _18945_/Q VDD VSS DFFQX1
X_14068_ _14083_/A _14068_/B VDD VSS _18136_/D NOR2X1
XFILLER_39_325 VDD VSS DECAPHV8
X_13019_ _18421_/Q _13161_/A _13265_/B VDD VSS _13020_/D XNOR3X1
X_18876_ _18951_/CK _18876_/D _18876_/Q VDD VSS DFFQX1
X_17827_ _17851_/CK _17827_/D _17827_/Q VDD VSS DFFQX1
XFILLER_54_328 VDD VSS DECAPHV16
XFILLER_67_678 VSS VDD FILLER2
XTAP_TAPCELL_ROW_65_802 VDD VSS WELLTAP
XFILLER_63_840 VDD VSS FILLER1
XFILLER_66_188 VDD VSS FILLER1
X_17758_ _17865_/CK _17758_/D _17758_/Q VDD VSS DFFQX1
X_17689_ _17722_/CK _17689_/D _17689_/Q VDD VSS DFFQX1
X_16709_ _16704_/B _18917_/Q _16709_/C VDD VSS _16770_/B AOI2B1X1
XFILLER_22_203 VSS VDD FILLER2
XFILLER_23_726 VSS VDD FILLER2
XTAP_TAPCELL_ROW_73_890 VDD VSS WELLTAP
XTAP_TAPCELL_ROW_122_1481 VDD VSS WELLTAP
X_09112_ _17572_/Q _17361_/B VDD VSS _09119_/B XNOR2X1
XFILLER_11_1112 VDD VSS FILLER4
XFILLER_136_628 VSS VDD FILLER2
X_09043_ _09043_/A _09043_/B VDD VSS _17358_/B XNOR2X1
Xclkbuf_leaf_22_clk_fs_regs clkbuf_leaf_5_clk_fs_regs/A VDD VSS clkload9/A BUFX12
XFILLER_104_503 VSS VDD FILLER2
XFILLER_104_514 VDD VSS FILLER1
XFILLER_104_547 VSS VDD FILLER2
X_09945_ _09945_/A VDD VSS _09946_/B INVX1
X_09876_ _10078_/A _10078_/B VDD VSS _10083_/B XNOR2X1
XFILLER_38_69 VDD VSS FILLER1
XFILLER_58_667 VDD VSS FILLER4
XFILLER_86_954 VDD VSS DECAPHV8
XFILLER_46_818 VDD VSS DECAPHV8
XFILLER_57_166 VDD VSS FILLER4
XFILLER_73_626 VSS VDD FILLER2
XFILLER_79_1017 VDD VSS FILLER4
XFILLER_26_542 VSS VDD FILLER2
XFILLER_0_1070 VDD VSS DECAPHV8
XFILLER_13_225 VSS VDD FILLER2
XFILLER_41_512 VDD VSS FILLER4
XFILLER_53_361 VDD VSS DECAPHV8
XFILLER_81_692 VDD VSS FILLER4
XTAP_TAPCELL_ROW_43_529 VDD VSS WELLTAP
X_10720_ _17904_/Q VDD VSS _10722_/A INVX1
XFILLER_41_556 VSS VDD FILLER2
X_10651_ _17890_/Q _10651_/B _10651_/C VDD VSS _10791_/A MIN3X1
XFILLER_10_943 VDD VSS FILLER4
XFILLER_16_1045 VDD VSS FILLER1
XTAP_TAPCELL_ROW_23_297 VDD VSS WELLTAP
X_10582_ _17878_/Q _10582_/B _10582_/C VDD VSS _10588_/D XNOR3X1
X_13370_ _18346_/Q _13473_/A _13375_/B VDD VSS _13371_/D XOR3X1
XFILLER_10_987 VSS VDD FILLER2
X_12321_ _12424_/A _12334_/B _12334_/C VDD VSS _14202_/C OR3BX1
XFILLER_108_831 VSS VDD FILLER2
X_12252_ _12545_/A _12545_/B VDD VSS _12343_/B NOR2X1
X_15040_ _18630_/Q _19008_/Q VDD VSS _15042_/B XOR2X1
XFILLER_102_0 VDD VSS DECAPHV32
XFILLER_135_650 VDD VSS FILLER1
XFILLER_135_672 VDD VSS FILLER1
XFILLER_5_468 VDD VSS DECAPHV32
XFILLER_79_32 VDD VSS DECAPHV32
X_11203_ _11203_/A _11203_/B _11203_/C VDD VSS _11206_/C MIN3X1
XFILLER_123_856 VDD VSS DECAPHV8
X_12183_ _18361_/Q _12205_/B _14323_/B VDD VSS _14354_/B XNOR3X1
XFILLER_110_506 VDD VSS FILLER4
XFILLER_1_641 VDD VSS DECAPHV8
XFILLER_96_729 VDD VSS FILLER4
X_11134_ _11141_/A _11134_/B VDD VSS _17082_/B XNOR2X1
X_16991_ _16991_/A _17006_/B _16991_/C VDD VSS _18944_/D OAI21X1
XFILLER_49_623 VDD VSS FILLER1
XFILLER_62_1054 VDD VSS DECAPHV8
X_11065_ _17970_/Q VDD VSS _11066_/A INVX1
X_18730_ _18840_/CK _18730_/D _18730_/Q VDD VSS DFFQX1
X_15942_ _16062_/A _15986_/B VDD VSS _15943_/B NAND2X1
XFILLER_48_133 VDD VSS FILLER4
XFILLER_77_976 VDD VSS FILLER4
XFILLER_95_64 VDD VSS DECAPHV16
X_10016_ _17802_/Q _10017_/B _10017_/C VDD VSS _10022_/D OR3BX1
X_18661_ _18850_/CK _18661_/D _18661_/Q VDD VSS DFFQX1
XFILLER_48_166 VDD VSS FILLER4
XFILLER_48_177 VDD VSS FILLER4
XFILLER_49_678 VDD VSS FILLER1
XFILLER_49_689 VDD VSS DECAPHV8
XFILLER_77_987 VDD VSS FILLER1
X_15873_ _18896_/Q VDD VSS _15945_/A INVX1
XFILLER_64_637 VSS VDD FILLER2
XFILLER_91_445 VSS VDD FILLER2
X_18592_ _19004_/CK _18592_/D _18592_/Q VDD VSS DFFQX1
X_17612_ _17710_/CK _17612_/D _17612_/Q VDD VSS DFFQX1
X_14824_ _14972_/A _14824_/B _14826_/C VDD VSS _18583_/D NOR3X1
X_11967_ _14055_/A _14055_/B _18124_/Q VDD VSS _12052_/C AOI21BX1
X_17543_ _17735_/Q _18524_/Q VDD VSS _17545_/B XOR2X1
X_14755_ _18569_/Q _18601_/Q VDD VSS _14760_/A XOR2X1
XFILLER_72_681 VDD VSS FILLER1
X_10918_ _17943_/Q _10918_/B VDD VSS _10924_/B NOR2X1
X_17474_ _17561_/C _17474_/B VDD VSS _17679_/D AND2X1
X_13706_ _13762_/D _13762_/C VDD VSS _13707_/C NAND2X1
X_11898_ _18462_/Q _11996_/B _11902_/C VDD VSS _14466_/B XNOR3X1
X_16425_ _16537_/A _18768_/Q VDD VSS _16444_/A NAND2X1
X_14686_ _14689_/C _14687_/B _17544_/C VDD VSS _14687_/C OAI21X1
XFILLER_20_729 VSS VDD FILLER2
XFILLER_34_1101 VDD VSS FILLER1
XTAP_TAPCELL_ROW_70_860 VDD VSS WELLTAP
X_10849_ _10849_/A _10852_/B VDD VSS _10985_/A XOR2X1
X_13637_ _13675_/A _14370_/B _13675_/C VDD VSS _13643_/B OAI21X1
XFILLER_121_1115 VDD VSS FILLER1
X_16356_ _16405_/A _16405_/B _16357_/C _16657_/D VDD VSS _16357_/D AOAI211X1
X_13568_ _14214_/A _14214_/B _18270_/Q VDD VSS _13628_/C OAI21X1
XFILLER_8_251 VDD VSS DECAPHV8
X_12519_ _18233_/Q _14174_/B _14174_/C VDD VSS _12528_/D OR3BX1
X_16287_ _18046_/Q _18656_/Q VDD VSS _16315_/D NAND2X1
X_15307_ _15307_/A _18048_/Q VDD VSS _18847_/D AND2X1
X_18026_ _18547_/CK _18026_/D _18026_/Q VDD VSS DFFQX1
X_15238_ _15295_/A _18806_/Q VDD VSS _18779_/D AND2X1
X_13499_ _18374_/Q _13613_/A _13686_/B VDD VSS _13639_/D XNOR3X1
XFILLER_113_300 VDD VSS FILLER1
XFILLER_119_1022 VDD VSS FILLER1
XFILLER_125_160 VDD VSS DECAPHV16
XFILLER_126_694 VSS VDD FILLER2
X_15169_ _15281_/A _18739_/Q VDD VSS _18712_/D AND2X1
XFILLER_113_355 VDD VSS FILLER4
XFILLER_86_206 VDD VSS DECAPHV8
X_09730_ _09737_/A _09737_/B VDD VSS _17351_/B XNOR2X1
X_18928_ _18934_/CK _18928_/D _18928_/Q VDD VSS DFFQX1
XFILLER_28_829 VDD VSS FILLER1
XTAP_TAPCELL_ROW_78_960 VDD VSS WELLTAP
X_09661_ _17688_/Q _17484_/B VDD VSS _09662_/A NAND2BX1
X_18859_ _18961_/CK _18859_/D _18859_/Q VDD VSS DFFQX1
XFILLER_55_648 VSS VDD FILLER2
XFILLER_67_497 VDD VSS FILLER1
XFILLER_83_968 VDD VSS DECAPHV8
XFILLER_94_294 VSS VDD FILLER2
XTAP_TAPCELL_ROW_124_1510 VDD VSS WELLTAP
X_09592_ _09600_/C _09592_/B VDD VSS _17379_/B NOR2X1
XFILLER_23_512 VDD VSS FILLER1
XFILLER_36_895 VDD VSS FILLER4
XFILLER_51_832 VDD VSS FILLER1
XFILLER_78_1072 VSS VDD FILLER2
XFILLER_78_1083 VDD VSS FILLER1
XFILLER_24_49 VSS VDD FILLER2
XFILLER_51_865 VDD VSS FILLER1
XFILLER_11_718 VDD VSS DECAPHV16
XFILLER_126_1059 VDD VSS DECAPHV8
XFILLER_23_567 VDD VSS FILLER1
XFILLER_50_364 VSS VDD FILLER2
XFILLER_136_403 VSS VDD FILLER2
XTAP_TAPCELL_ROW_20_256 VDD VSS WELLTAP
X_09026_ _09026_/A VDD VSS _09043_/A INVX1
XFILLER_117_661 VSS VDD FILLER2
XFILLER_136_469 VDD VSS DECAPHV8
XFILLER_3_928 VSS VDD FILLER2
XFILLER_104_311 VDD VSS FILLER1
XFILLER_117_694 VDD VSS DECAPHV8
XFILLER_2_416 VSS VDD FILLER2
XFILLER_132_642 VDD VSS FILLER1
XFILLER_104_377 VDD VSS FILLER1
XFILLER_132_686 VDD VSS DECAPHV8
X_09928_ _09928_/A _09928_/B VDD VSS _10128_/C NOR2X1
XFILLER_19_807 VDD VSS FILLER4
XFILLER_86_751 VSS VDD FILLER2
XFILLER_46_615 VDD VSS FILLER4
X_09859_ _09976_/A _10062_/B VDD VSS _17808_/D NOR2X1
XFILLER_105_96 VDD VSS DECAPHV32
X_12870_ _18237_/Q _14179_/B VDD VSS _12979_/A AND2X1
XFILLER_22_1093 VDD VSS DECAPHV8
XFILLER_57_1101 VDD VSS FILLER4
XFILLER_74_979 VDD VSS FILLER4
XTAP_TAPCELL_ROW_28_356 VDD VSS WELLTAP
XTAP_TAPCELL_ROW_86_1048 VDD VSS WELLTAP
X_11821_ _11821_/A _11821_/B _14378_/B VDD VSS _11822_/B MIN3X1
XFILLER_14_501 VDD VSS FILLER1
XFILLER_73_489 VDD VSS DECAPHV16
XTAP_TAPCELL_ROW_56_687 VDD VSS WELLTAP
X_14540_ _14544_/A _14544_/B _17544_/C VDD VSS _14541_/C OAI21X1
XFILLER_14_534 VDD VSS FILLER4
XFILLER_18_1107 VDD VSS FILLER1
XFILLER_18_1129 VSS VDD FILLER2
XFILLER_53_180 VDD VSS FILLER1
X_11752_ _11752_/A _11752_/B VDD VSS _11753_/C XNOR2X1
XFILLER_41_375 VSS VDD FILLER2
X_10703_ _10707_/A _10837_/B VDD VSS _17927_/D AND2X1
X_11683_ _11693_/A _11693_/B _11760_/C VDD VSS _14137_/C NOR3X1
X_14471_ _14471_/A _14471_/B VDD VSS _14472_/B XNOR2X1
XFILLER_81_88 VDD VSS FILLER4
X_10634_ _10634_/A _10638_/C VDD VSS _10772_/B XNOR2X1
X_17190_ _18995_/Q _17287_/B _17190_/C VDD VSS _17191_/B MIN3X1
X_16210_ _16210_/A _16210_/B VDD VSS _16218_/D XNOR2X1
X_13422_ _13473_/A _13473_/B _13473_/D VDD VSS _13467_/C OAI21X1
XFILLER_6_700 VDD VSS DECAPHV32
X_16141_ _16218_/A _18760_/Q _16206_/A _16141_/D VDD VSS _16180_/C AO22X2
X_13353_ _18424_/Q _13532_/A _13532_/B VDD VSS _13354_/D XNOR3X1
XFILLER_128_959 VDD VSS FILLER4
XFILLER_5_221 VDD VSS DECAPHV32
X_10565_ _17876_/Q _10565_/B _10565_/C VDD VSS _10570_/C XNOR3X1
X_12304_ _18283_/Q _12304_/B VDD VSS _12310_/C _12304_/C NAND3X1
XFILLER_6_788 VSS VDD FILLER2
XTAP_TAPCELL_ROW_97_1177 VDD VSS WELLTAP
XTAP_TAPCELL_ROW_97_1188 VDD VSS WELLTAP
X_10496_ _17869_/Q _10503_/A _10503_/B VDD VSS _10497_/D XNOR3X1
X_13284_ _18345_/Q _14304_/B VDD VSS _13466_/C _14304_/C AND3X2
X_16072_ _16067_/B _18900_/Q VDD VSS _16119_/A NAND2BX1
XFILLER_107_160 VDD VSS FILLER1
XTAP_TAPCELL_ROW_1_30 VDD VSS WELLTAP
X_12235_ _12338_/A _12338_/B _14143_/C VDD VSS _14144_/B AOI21BX1
X_15023_ _15093_/A _15023_/B VDD VSS _18626_/D NOR2X1
XFILLER_2_950 VDD VSS DECAPHV16
X_12166_ _18205_/Q _12166_/B _14143_/C VDD VSS _12430_/B XNOR3X1
XFILLER_122_174 VDD VSS DECAPHV32
XFILLER_68_206 VDD VSS DECAPHV8
XFILLER_69_729 VDD VSS FILLER4
XFILLER_96_526 VDD VSS DECAPHV8
X_11117_ _17981_/Q VDD VSS _11118_/A INVX1
XFILLER_68_239 VDD VSS DECAPHV16
XFILLER_7_1021 VSS VDD FILLER2
X_12097_ _18464_/Q _12097_/B _12097_/C VDD VSS _12284_/B MIN3X1
X_16974_ _18859_/Q _16974_/B VDD VSS _16984_/B NOR2BX1
XFILLER_65_913 VDD VSS FILLER1
XFILLER_83_209 VDD VSS FILLER4
X_11048_ _11048_/A _11048_/B _11048_/C VDD VSS _11053_/A MIN3X1
X_18713_ _18821_/CK _18713_/D _18713_/Q VDD VSS DFFQX1
X_15925_ _15925_/A _15925_/B _15925_/C _15925_/D VDD VSS _15967_/A AOAI211X1
XFILLER_65_946 VDD VSS FILLER4
X_18644_ _18835_/CK _18644_/D _18644_/Q VDD VSS DFFQX1
X_15856_ _16537_/A _18753_/Q VDD VSS _15857_/D NAND2X1
XFILLER_36_158 VDD VSS FILLER4
XFILLER_52_607 VSS VDD FILLER2
XFILLER_64_456 VDD VSS FILLER1
XFILLER_92_787 VSS VDD FILLER2
X_14807_ _14808_/A _14808_/B VDD VSS _14810_/C NOR2X1
XFILLER_18_895 VDD VSS FILLER1
XFILLER_52_629 VSS VDD FILLER2
X_12999_ _12999_/A _13108_/A _13112_/C VDD VSS _13001_/B AOI21BX1
X_18575_ _18641_/CK _18575_/D _18575_/Q VDD VSS DFFQX1
Xclkbuf_leaf_7__000_ clkbuf_leaf_9__000_/A VDD VSS _18850_/CK BUFX12
X_15787_ _15939_/C _15936_/A _15939_/B VDD VSS _15865_/A NOR3X1
XTAP_TAPCELL_ROW_106_1295 VDD VSS WELLTAP
X_17526_ _17526_/A _17526_/B VDD VSS _17527_/B NAND2X1
X_14738_ _18565_/Q _18597_/Q VDD VSS _14740_/D XNOR2X1
XFILLER_32_353 VDD VSS FILLER4
XFILLER_32_375 VSS VDD FILLER2
X_17457_ _17498_/A _17457_/B VDD VSS _17663_/D AND2X1
X_14669_ _18550_/Q _18582_/Q _14669_/C VDD VSS _14672_/B AOI21X1
X_17388_ _17388_/A _17388_/B VDD VSS _17598_/D AND2X1
X_16408_ _16547_/D _16408_/B _16408_/C _16408_/D VDD VSS _16409_/D AOI211X1
X_16339_ _16183_/B _16484_/B _16521_/A VDD VSS _16341_/B MUXI2X1
XFILLER_118_425 VDD VSS FILLER1
XFILLER_65_0 VDD VSS DECAPHV32
XFILLER_118_469 VDD VSS FILLER1
XFILLER_127_992 VDD VSS DECAPHV16
X_18009_ _18025_/CK _18009_/D _18009_/Q VDD VSS DFFQX1
XFILLER_102_826 VDD VSS FILLER1
XFILLER_99_364 VSS VDD FILLER2
XFILLER_101_347 VDD VSS FILLER1
XTAP_TAPCELL_ROW_130_1580 VDD VSS WELLTAP
XFILLER_132_1030 VDD VSS DECAPHV32
XFILLER_28_615 VDD VSS FILLER1
XFILLER_56_913 VSS VDD FILLER2
X_09713_ _17626_/Q _17418_/B VDD VSS _09714_/D OR2X2
X_09644_ _17624_/Q _17416_/B VDD VSS _09658_/B XOR2X1
XFILLER_43_607 VDD VSS FILLER1
XFILLER_56_979 VDD VSS FILLER4
XFILLER_82_231 VDD VSS FILLER1
XTAP_TAPCELL_ROW_25_315 VDD VSS WELLTAP
X_09575_ _09568_/B _09575_/B _09575_/C VDD VSS _09594_/A AOI2B1X1
XFILLER_23_331 VDD VSS FILLER1
XTAP_TAPCELL_ROW_53_657 VDD VSS WELLTAP
XFILLER_51_662 VSS VDD FILLER2
XTAP_TAPCELL_ROW_81_988 VDD VSS WELLTAP
XFILLER_50_183 VDD VSS FILLER1
XFILLER_52_1031 VSS VDD FILLER2
XFILLER_104_1132 VDD VSS FILLER4
XFILLER_13_1026 VSS VDD FILLER2
XFILLER_125_907 VDD VSS DECAPHV8
XTAP_TAPCELL_ROW_133_1609 VDD VSS WELLTAP
X_10350_ _10350_/A _10511_/B _10350_/C _10350_/D VDD VSS _10524_/B AOAI211X1
XFILLER_117_480 VDD VSS FILLER1
X_09009_ _08996_/A _09009_/B _09009_/C VDD VSS _09011_/A AOI2B1X1
X_10281_ _17838_/Q VDD VSS _10282_/A INVX1
XFILLER_105_631 VSS VDD FILLER2
XFILLER_117_491 VDD VSS DECAPHV8
XFILLER_2_235 VDD VSS DECAPHV32
XFILLER_3_747 VDD VSS DECAPHV32
X_12020_ _12126_/A _14197_/B _12034_/C VDD VSS _14199_/C OR3BX1
XFILLER_116_40 VDD VSS FILLER4
XFILLER_120_623 VDD VSS DECAPHV8
XFILLER_120_656 VSS VDD FILLER2
XFILLER_76_44 VSS VDD FILLER2
X_13971_ _13971_/A VDD VSS _14013_/A BUFX3
XFILLER_100_380 VSS VDD FILLER2
XFILLER_101_892 VDD VSS DECAPHV8
XFILLER_18_103 VDD VSS FILLER4
X_12922_ _18471_/Q VDD VSS _12924_/A INVX1
X_16690_ _16723_/A _16723_/B _16690_/C VDD VSS _16691_/D OA21X2
X_15710_ _15715_/B _15710_/B VDD VSS _17012_/A XNOR2X1
XFILLER_62_916 VSS VDD FILLER2
XFILLER_74_765 VDD VSS DECAPHV16
XFILLER_94_1109 VDD VSS FILLER1
X_15641_ _15641_/A _15644_/C VDD VSS _16998_/A XNOR2X1
XFILLER_15_810 VSS VDD FILLER2
XFILLER_18_169 VSS VDD FILLER2
XFILLER_61_415 VDD VSS FILLER4
XFILLER_92_32 VDD VSS DECAPHV8
X_12853_ _18289_/Q VDD VSS _12960_/A INVX1
X_11804_ _18253_/Q _12122_/A _11841_/B VDD VSS _11843_/D XNOR3X1
X_12784_ _12994_/A _12994_/C VDD VSS _12785_/C NAND2X1
X_18360_ _18361_/CK _18360_/D _18360_/Q VDD VSS DFFQX1
X_15572_ _15572_/A VDD VSS _15674_/A BUFX3
X_11735_ _11739_/A _11739_/B _11735_/C VDD VSS _14284_/B XNOR3X1
X_18291_ _18292_/CK _18291_/D _18291_/Q VDD VSS DFFQX1
X_17311_ _19019_/Q _17315_/B VDD VSS _17313_/A XNOR2X1
X_14523_ _14972_/A _14523_/B _14525_/C VDD VSS _18519_/D NOR3X1
XFILLER_14_397 VDD VSS FILLER4
XTAP_TAPCELL_ROW_99_1206 VDD VSS WELLTAP
X_17242_ _17242_/A _17242_/B _17248_/A VDD VSS _19005_/D NOR3X1
X_14454_ _14480_/A _14454_/B VDD VSS _18476_/D NOR2X1
XFILLER_30_879 VDD VSS FILLER4
X_11666_ _11666_/A _11738_/B _14224_/B VDD VSS _11835_/B MIN3X1
X_13405_ _13405_/A _13405_/B _13405_/C _13405_/D VDD VSS _14156_/B AOAI211X1
XFILLER_128_745 VSS VDD FILLER2
XFILLER_31_1126 VDD VSS FILLER4
X_10617_ _10620_/C _10620_/B VDD VSS _10618_/B NOR2BX1
X_11597_ _18277_/Q VDD VSS _11666_/A INVX1
X_17173_ _17176_/A _17173_/B _17173_/C VDD VSS _18992_/D AOI21X1
X_14385_ _14389_/A _14385_/B VDD VSS _18414_/D NOR2X1
X_10548_ _10551_/A _10556_/B _10556_/C VDD VSS _10700_/C AND3BX1
X_16124_ _16176_/A _16176_/B VDD VSS _16126_/A NAND2X1
X_13336_ _18502_/Q _14489_/B VDD VSS _13339_/A XNOR2X1
XFILLER_127_277 VSS VDD FILLER2
X_13267_ _13267_/A _13267_/B _13267_/C _13267_/D VDD VSS _13466_/A AOAI211X1
X_16055_ _16180_/A _16105_/B VDD VSS _16144_/A _16105_/C _16105_/D NAND4X2
XFILLER_124_962 VDD VSS FILLER1
XFILLER_29_1022 VDD VSS FILLER1
X_10479_ _10516_/A _10657_/B VDD VSS _17892_/D NOR2X1
X_12218_ _12308_/A _14230_/B _14230_/C VDD VSS _12304_/C OR3BX1
X_15006_ _15009_/A _15006_/B _15006_/C VDD VSS _18622_/D AOI21X1
XFILLER_123_472 VSS VDD FILLER2
XFILLER_68_1093 VDD VSS FILLER4
XFILLER_69_504 VDD VSS DECAPHV8
X_13198_ _13297_/A _13297_/B _13297_/D _13297_/C VDD VSS _14210_/C AOI211X1
XFILLER_2_780 VDD VSS DECAPHV8
X_12149_ _14143_/A _14143_/B VDD VSS _12166_/B NOR2X1
XFILLER_111_689 VSS VDD FILLER2
XFILLER_38_902 VDD VSS FILLER1
XFILLER_84_507 VDD VSS FILLER4
XFILLER_96_378 VSS VDD FILLER2
X_16957_ _16957_/A _16957_/B _16957_/C VDD VSS _16970_/B AOI21X1
XTAP_TAPCELL_ROW_108_1313 VDD VSS WELLTAP
X_15908_ _18896_/Q _16527_/B VDD VSS _15909_/C NAND2X1
XFILLER_37_445 VDD VSS FILLER1
XFILLER_65_765 VDD VSS FILLER4
XFILLER_92_551 VDD VSS FILLER1
X_16888_ _16883_/A _16888_/B VDD VSS _16895_/B NOR2BX1
XFILLER_24_106 VDD VSS FILLER1
X_18627_ _19004_/CK _18627_/D _18627_/Q VDD VSS DFFQX1
X_15839_ _15925_/B _16326_/A _15839_/C VDD VSS _15839_/Y OR3BX1
XFILLER_52_448 VDD VSS FILLER1
XFILLER_75_1042 VDD VSS DECAPHV8
X_09360_ _09342_/B _09360_/B _09360_/C VDD VSS _09366_/A AOI2B1X1
X_18558_ clkload7/A _18558_/D _18558_/Q VDD VSS DFFQX1
XFILLER_36_1015 VDD VSS FILLER1
XTAP_TAPCELL_ROW_50_616 VDD VSS WELLTAP
X_09291_ _17611_/Q _17402_/B VDD VSS _09292_/B XOR2X1
X_17509_ _17518_/A _17509_/B VDD VSS _17712_/D NOR2X1
XANTENNA_13 _17536_/D VDD VSS ANTENNA2
XFILLER_20_323 VSS VDD FILLER2
XFILLER_75_1086 VDD VSS FILLER4
X_18489_ _18493_/CK _18489_/D _18489_/Q VDD VSS DFFQX1
XTAP_TAPCELL_ROW_119_1442 VDD VSS WELLTAP
XTAP_TAPCELL_ROW_30_373 VDD VSS WELLTAP
XFILLER_107_918 VDD VSS FILLER4
XFILLER_107_929 VDD VSS FILLER1
XTAP_TAPCELL_ROW_30_384 VDD VSS WELLTAP
XFILLER_106_417 VDD VSS FILLER1
XFILLER_82_1002 VDD VSS FILLER4
XFILLER_133_269 VDD VSS DECAPHV8
XFILLER_82_1024 VDD VSS FILLER1
XFILLER_114_494 VSS VDD FILLER2
XFILLER_130_954 VSS VDD FILLER2
XFILLER_87_345 VSS VDD FILLER2
XFILLER_99_183 VSS VDD FILLER2
XFILLER_101_155 VDD VSS FILLER1
XFILLER_47_209 VSS VDD FILLER2
XTAP_TAPCELL_ROW_58_716 VDD VSS WELLTAP
XFILLER_29_924 VDD VSS FILLER1
XFILLER_29_957 VDD VSS FILLER4
XFILLER_68_581 VDD VSS FILLER4
XFILLER_68_592 VDD VSS FILLER4
XFILLER_16_607 VDD VSS FILLER1
XFILLER_55_242 VDD VSS FILLER1
XFILLER_44_949 VDD VSS DECAPHV8
XTAP_TAPCELL_ROW_38_473 VDD VSS WELLTAP
XTAP_TAPCELL_ROW_83_1018 VDD VSS WELLTAP
X_09627_ _09625_/B _09627_/B _09627_/C VDD VSS _17778_/D AOI2B1X1
XFILLER_93_1131 VDD VSS FILLER1
X_09558_ _17748_/Q _09558_/B _09558_/C VDD VSS _09581_/C MIN3X1
XFILLER_24_651 VDD VSS FILLER4
XFILLER_70_278 VSS VDD FILLER2
XFILLER_12_835 VDD VSS DECAPHV8
X_09489_ _19041_/Q _17342_/B VDD VSS _09493_/B XOR2X1
X_11520_ _18300_/Q VDD VSS _11522_/A INVX1
Xclkbuf_leaf_9_clk_fs_regs clkbuf_leaf_9_clk_fs_regs/A VDD VSS _18913_/CK BUFX12
XFILLER_12_868 VDD VSS FILLER4
X_11451_ _11499_/A _14048_/B VDD VSS _11551_/B NAND2X1
X_10402_ _10405_/A _10407_/B _10407_/C VDD VSS _10404_/C AND3BX1
X_11382_ _11382_/A _14073_/B VDD VSS _11396_/A OR2X2
X_14170_ _14149_/Y _14170_/B _14170_/C VDD VSS _18229_/D AND3BX1
XFILLER_109_277 VSS VDD FILLER2
XFILLER_3_500 VDD VSS DECAPHV32
XTAP_TAPCELL_ROW_94_1147 VDD VSS WELLTAP
X_10333_ _10333_/A _10333_/B VDD VSS _10350_/A OR2X2
X_13121_ _13121_/A _14152_/B VDD VSS _13193_/A OR2X2
Xclkbuf_leaf_6__001_ clkload74/A VDD VSS _17932_/CK BUFX12
XFILLER_105_450 VDD VSS FILLER1
XFILLER_133_770 VDD VSS FILLER1
XFILLER_87_32 VDD VSS DECAPHV32
X_10264_ _10266_/A _10264_/B VDD VSS _10456_/B XNOR2X1
X_13052_ _18342_/Q _14301_/B VDD VSS _13056_/C _14301_/C NAND3X1
XFILLER_120_431 VDD VSS FILLER1
X_10195_ _10195_/A VDD VSS _10206_/C INVX1
X_12003_ _18359_/Q _12006_/B _14321_/B VDD VSS _14352_/B XNOR3X1
X_17860_ _17861_/CK _17860_/D _17860_/Q VDD VSS DFFQX1
XFILLER_79_879 VDD VSS FILLER4
X_16811_ _18921_/Q _16862_/B VDD VSS _16812_/C NAND2X1
XFILLER_115_1080 VSS VDD FILLER2
XFILLER_94_849 VDD VSS DECAPHV8
X_17791_ _19033_/CK _17791_/D _17791_/Q VDD VSS DFFQX1
XFILLER_19_445 VDD VSS DECAPHV8
X_16742_ _16770_/B _16742_/B VDD VSS _16744_/B XOR2X1
X_13954_ _13952_/Y _13959_/A VDD VSS _18061_/D NOR2BX1
XFILLER_46_253 VSS VDD FILLER2
XFILLER_59_1026 VDD VSS FILLER1
XFILLER_98_1064 VDD VSS FILLER4
X_12905_ _18264_/Q _12905_/B _12979_/C VDD VSS _13186_/B XNOR3X1
X_16673_ _16674_/A _16674_/B _16674_/C VDD VSS _16706_/B OA21X2
X_13885_ _13913_/B _17388_/A _13885_/C VDD VSS _18055_/D AND3BX1
XFILLER_46_286 VSS VDD FILLER2
X_12836_ _14265_/B _14265_/C _18314_/Q VDD VSS _12840_/B AOI21X1
X_18412_ _18436_/CK _18412_/D _18412_/Q VDD VSS DFFQX1
X_15624_ _18863_/Q _15799_/B _15648_/C _15624_/D VDD VSS _15674_/B OAI31X1
XFILLER_61_278 VDD VSS FILLER1
X_18343_ _18368_/CK _18343_/D _18343_/Q VDD VSS DFFQX1
X_15555_ _18874_/Q VDD VSS _15567_/A INVX1
XFILLER_43_993 VSS VDD FILLER2
XFILLER_61_289 VDD VSS FILLER4
XTAP_TAPCELL_ROW_103_1254 VDD VSS WELLTAP
X_12767_ _12899_/A _13086_/B VDD VSS _14120_/B XNOR2X1
X_14506_ _14507_/A _14507_/B VDD VSS _14509_/C NOR2X1
X_11718_ _18356_/Q _11828_/B _11824_/C VDD VSS _11820_/C XNOR3X1
X_12698_ _12811_/A _12811_/B _12708_/C VDD VSS _14480_/B XNOR3X1
X_18274_ _18340_/CK _18274_/D _18274_/Q VDD VSS DFFQX1
X_15486_ _15760_/B _15596_/A _15486_/C VDD VSS _15490_/B OR3X2
XFILLER_30_676 VSS VDD FILLER2
XTAP_TAPCELL_ROW_0_6 VDD VSS WELLTAP
X_11649_ _18355_/Q _11732_/B _11727_/C VDD VSS _11653_/C XNOR3X1
Xclkbuf_leaf_10__000_ clkload110/A VDD VSS _18818_/CK BUFX12
X_17225_ _19003_/Q _17232_/B VDD VSS _17237_/A XNOR2X1
X_14437_ _15300_/A _14437_/B VDD VSS _18461_/D AND2X1
XFILLER_128_564 VDD VSS FILLER1
X_17156_ _17156_/A _17156_/B _17156_/C _17536_/D VDD VSS _18988_/D OAOI211X1
X_14368_ _14394_/A _14368_/B _14368_/C VDD VSS _18398_/D NOR3X1
XFILLER_6_360 VDD VSS DECAPHV32
XFILLER_7_872 VDD VSS DECAPHV32
X_16107_ _16107_/A _16107_/B _16107_/C VDD VSS _16108_/C NOR3X1
X_13319_ _18242_/Q _13319_/B _13398_/C VDD VSS _13493_/B XNOR3X1
XFILLER_115_236 VSS VDD FILLER2
X_17087_ _17084_/A _17087_/B VDD VSS _17090_/B NOR2BX1
X_14299_ _14423_/A _14299_/B VDD VSS _18340_/D AND2X1
XFILLER_130_206 VDD VSS DECAPHV16
X_16038_ _16038_/A _16038_/B _16038_/C _16038_/D VDD VSS _16089_/B AOAI211X1
XFILLER_112_932 VDD VSS FILLER1
XTAP_TAPCELL_ROW_114_1383 VDD VSS WELLTAP
XFILLER_111_442 VDD VSS FILLER1
XFILLER_28_0 VDD VSS DECAPHV32
XFILLER_96_142 VSS VDD FILLER2
XFILLER_97_654 VDD VSS DECAPHV8
X_17989_ _18016_/CK _17989_/D _17989_/Q VDD VSS DFFQX1
XFILLER_25_415 VSS VDD FILLER2
XFILLER_52_201 VSS VDD FILLER2
XFILLER_77_1104 VSS VDD FILLER2
XFILLER_25_448 VSS VDD FILLER2
XFILLER_26_949 VDD VSS FILLER4
XFILLER_92_381 VDD VSS FILLER4
X_09412_ _17065_/A VDD VSS _15326_/C BUFX3
XFILLER_34_971 VDD VSS FILLER4
XFILLER_53_768 VSS VDD FILLER2
XFILLER_80_576 VDD VSS DECAPHV8
XTAP_TAPCELL_ROW_35_443 VDD VSS WELLTAP
XTAP_TAPCELL_ROW_63_774 VDD VSS WELLTAP
X_09343_ _17645_/Q _17438_/B VDD VSS _09345_/C XOR2X1
XFILLER_20_120 VDD VSS DECAPHV16
XFILLER_21_632 VSS VDD FILLER2
XFILLER_21_654 VDD VSS DECAPHV16
X_09274_ _17578_/Q VDD VSS _09275_/A INVX1
XFILLER_20_142 VDD VSS DECAPHV32
XFILLER_32_49 VSS VDD FILLER2
XFILLER_107_759 VDD VSS DECAPHV8
XFILLER_134_534 VDD VSS DECAPHV8
XFILLER_103_910 VDD VSS FILLER1
XTAP_TAPCELL_ROW_7_102 VDD VSS WELLTAP
XFILLER_87_120 VDD VSS FILLER4
XFILLER_102_442 VDD VSS DECAPHV8
XFILLER_103_987 VDD VSS FILLER1
XFILLER_130_773 VDD VSS FILLER1
XFILLER_76_816 VDD VSS DECAPHV16
XFILLER_88_654 VDD VSS DECAPHV8
X_08989_ _08994_/C _08989_/B VDD VSS _17457_/B XNOR2X1
XFILLER_28_231 VDD VSS FILLER1
XFILLER_91_819 VSS VDD FILLER2
XFILLER_16_415 VSS VDD FILLER2
XFILLER_29_787 VDD VSS FILLER1
XFILLER_44_724 VSS VDD FILLER2
X_10951_ _17949_/Q _10951_/B _10951_/C VDD VSS _10956_/C MIN3X1
XFILLER_113_96 VDD VSS DECAPHV32
XFILLER_3_1090 VDD VSS DECAPHV16
XFILLER_43_234 VDD VSS DECAPHV16
XFILLER_83_370 VSS VDD FILLER2
X_13670_ _18375_/Q _14339_/B _14338_/C VDD VSS _13671_/D OR3BX1
XFILLER_43_256 VDD VSS FILLER1
XFILLER_71_565 VDD VSS FILLER1
X_10882_ _10914_/A _11021_/A VDD VSS _17962_/D NOR2X1
X_12621_ _12634_/A _14296_/B _12723_/C VDD VSS _14298_/C NOR3X1
XFILLER_43_278 VDD VSS FILLER1
XFILLER_71_587 VDD VSS FILLER1
XFILLER_8_603 VDD VSS FILLER1
X_12552_ _12552_/A _12552_/B _12552_/C _12552_/D VDD VSS _12763_/A OAOI211X1
X_15340_ _18863_/Q _15340_/B VDD VSS _15341_/B NOR2X1
XFILLER_106_1046 VSS VDD FILLER2
XFILLER_106_1068 VDD VSS FILLER1
XFILLER_11_153 VDD VSS FILLER1
XFILLER_132_0 VDD VSS DECAPHV32
X_11503_ _18171_/Q _11614_/B _11614_/C VDD VSS _11672_/B XNOR3X1
X_12483_ _18467_/Q VDD VSS _14475_/A INVX1
X_15271_ _15272_/A _18839_/Q VDD VSS _18812_/D AND2X1
X_11434_ _11531_/A _11475_/B _11475_/C VDD VSS _11607_/A OAI21X1
X_17010_ _17010_/A _17017_/B _17010_/C VDD VSS _18955_/D OAI21X1
X_14222_ _14252_/A _14222_/B VDD VSS _18275_/D NOR2X1
XFILLER_22_93 VDD VSS FILLER1
X_11365_ _18142_/Q _11365_/B _11388_/D VDD VSS _11428_/C XNOR3X1
X_14153_ _14149_/Y _14153_/B _14153_/C VDD VSS _18213_/D AND3BX1
XFILLER_112_206 VDD VSS DECAPHV8
XFILLER_4_886 VDD VSS DECAPHV32
X_10316_ _10317_/B _10317_/C _17842_/Q VDD VSS _10318_/C AOI21X1
X_11296_ _18114_/Q _11296_/B _11314_/C VDD VSS _11345_/C XNOR3X1
X_13104_ _13115_/A _13105_/B _13105_/C VDD VSS _14096_/B OR3BX1
X_18961_ _18961_/CK _18961_/D _18961_/Q VDD VSS DFFQX1
X_14084_ _17501_/A VDD VSS _14122_/A BUFX3
XFILLER_65_1041 VDD VSS DECAPHV8
X_10247_ _10247_/A _10247_/B _10247_/C VDD VSS _10252_/A MIN3X1
X_13035_ _18474_/Q VDD VSS _13151_/A INVX1
X_17912_ _17913_/CK _17912_/D _17912_/Q VDD VSS DFFQX1
XFILLER_67_816 VSS VDD FILLER2
XFILLER_79_676 VDD VSS FILLER1
X_18892_ _18959_/CK _18892_/D _18892_/Q VDD VSS DFFQX1
XFILLER_39_529 VSS VDD FILLER2
XFILLER_93_112 VDD VSS DECAPHV8
X_10178_ _10187_/A _10203_/A _10184_/B VDD VSS _10183_/D XNOR3X1
X_17843_ _17871_/CK _17843_/D _17843_/Q VDD VSS DFFQX1
XFILLER_120_283 VDD VSS FILLER1
XFILLER_94_668 VDD VSS FILLER1
X_17774_ _19042_/CK _17774_/D _17774_/Q VDD VSS DFFQX1
X_14986_ _14988_/C _14986_/B _14986_/C VDD VSS _18618_/D AOI21X1
XFILLER_93_178 VSS VDD FILLER2
XFILLER_93_189 VDD VSS FILLER4
X_16725_ _16757_/D _16725_/B _16725_/C _16725_/D VDD VSS _16726_/D AOI31X1
X_13937_ _13937_/A _13937_/B _13937_/C _17533_/A VDD VSS _18059_/D OAOI211X1
XFILLER_90_830 VDD VSS FILLER1
X_16656_ _16681_/C _16656_/B VDD VSS _16657_/C XNOR2X1
X_13868_ wire26/Y _13868_/B VDD VSS _14434_/B XOR2X1
XFILLER_22_429 VSS VDD FILLER2
XTAP_TAPCELL_ROW_32_402 VDD VSS WELLTAP
X_12819_ _18419_/Q _12819_/B _12819_/C VDD VSS _13137_/A MIN3X1
X_16587_ _16587_/A _16587_/B _16587_/C _16587_/D VDD VSS _16624_/C OAOI211X1
X_15607_ _18927_/Q _15607_/B VDD VSS _15632_/C NOR2BX1
X_13799_ _13809_/A _13809_/B VDD VSS _14374_/B _13800_/C NAND3X1
XTAP_TAPCELL_ROW_60_733 VDD VSS WELLTAP
XTAP_TAPCELL_ROW_60_744 VDD VSS WELLTAP
X_18326_ _18408_/CK _18326_/D _18326_/Q VDD VSS DFFQX1
X_15538_ _18872_/Q _15668_/B VDD VSS _15539_/C NAND2X1
XFILLER_124_1135 VDD VSS FILLER1
XFILLER_72_1067 VSS VDD FILLER2
XFILLER_8_40 VDD VSS FILLER4
X_18257_ _18309_/CK _18257_/D _18257_/Q VDD VSS DFFQX1
X_15469_ _16782_/D _15469_/B _15534_/B _15526_/A _15469_/E VDD VSS _15474_/B AOI221X1
X_17208_ _17208_/A _17211_/C VDD VSS _17209_/B XOR2X1
XTAP_TAPCELL_ROW_116_1412 VDD VSS WELLTAP
X_18188_ _18249_/CK _18188_/D _18188_/Q VDD VSS DFFQX1
Xclkbuf_leaf_21_clk_fs_regs clkbuf_leaf_5_clk_fs_regs/A VDD VSS clkload8/A BUFX12
XFILLER_116_556 VDD VSS FILLER4
X_17139_ _18022_/Q _17139_/B VDD VSS _17140_/C NAND2X1
X_09961_ _10157_/A _10157_/B _10158_/B _10157_/C VDD VSS _10166_/B OA211X2
XFILLER_103_217 VDD VSS FILLER4
X_08912_ _17738_/Q _18527_/Q _08912_/C VDD VSS _17555_/A AO21X2
X_09892_ _17763_/Q _17789_/Q _09892_/C VDD VSS _09904_/B XOR3X1
XFILLER_111_272 VDD VSS FILLER4
XFILLER_131_1106 VDD VSS DECAPHV8
XFILLER_57_337 VSS VDD FILLER2
XFILLER_73_819 VDD VSS DECAPHV8
XTAP_TAPCELL_ROW_68_833 VDD VSS WELLTAP
XTAP_TAPCELL_ROW_127_1541 VDD VSS WELLTAP
XFILLER_65_370 VSS VDD FILLER2
XFILLER_81_852 VDD VSS DECAPHV8
XTAP_TAPCELL_ROW_48_590 VDD VSS WELLTAP
XFILLER_40_204 VDD VSS FILLER1
Xclkbuf_leaf_5__002_ clkbuf_leaf_9__002_/A VDD VSS _18195_/CK BUFX12
X_09326_ _09812_/A _09326_/B VDD VSS _17767_/D NOR2X1
X_09257_ _09283_/A _09283_/B VDD VSS _17469_/B XNOR2X1
XFILLER_21_484 VDD VSS FILLER1
XFILLER_88_1030 VDD VSS FILLER1
X_09188_ _09188_/A _09199_/B VDD VSS _17364_/B XNOR2X1
XFILLER_107_534 VSS VDD FILLER2
XFILLER_119_383 VDD VSS FILLER1
XFILLER_88_1096 VSS VDD FILLER2
XTAP_TAPCELL_ROW_91_1106 VDD VSS WELLTAP
X_11150_ _11150_/A _11150_/B _11150_/C _11150_/D VDD VSS _11155_/A AOAI211X1
XFILLER_122_537 VSS VDD FILLER2
X_10101_ _10311_/A _10311_/B _10311_/C VDD VSS _10287_/B OAI21X1
X_11081_ _17974_/Q _11081_/B VDD VSS _11082_/C AND2X1
XFILLER_124_40 VDD VSS FILLER4
XFILLER_75_112 VDD VSS DECAPHV8
XFILLER_76_613 VDD VSS FILLER1
X_10032_ _10042_/A _10042_/B VDD VSS _10037_/B XNOR2X1
XFILLER_48_348 VSS VDD FILLER2
X_14840_ _18586_/Q _18618_/Q _14840_/C VDD VSS _14844_/B MIN3X1
XFILLER_84_44 VSS VDD FILLER2
X_14771_ _18571_/Q _18603_/Q _14771_/C VDD VSS _14776_/C AO21X2
XFILLER_16_201 VDD VSS FILLER4
XFILLER_17_735 VDD VSS FILLER1
XFILLER_72_830 VDD VSS DECAPHV8
XFILLER_84_690 VDD VSS FILLER4
XFILLER_91_638 VDD VSS DECAPHV8
XTAP_TAPCELL_ROW_18_229 VDD VSS WELLTAP
X_11983_ _18384_/Q _11983_/B _11983_/C VDD VSS _14381_/B XNOR3X1
X_16510_ _18824_/Q _18716_/Q VDD VSS _16549_/D OR2X2
X_13722_ _18507_/Q _14494_/B _14494_/C VDD VSS _13774_/C OR3BX1
XFILLER_17_768 VDD VSS FILLER1
X_10934_ _14310_/C _11072_/B VDD VSS _17972_/D AND2X1
X_17490_ _17525_/B _17726_/Q VDD VSS _17694_/D AND2X1
XFILLER_32_749 VDD VSS FILLER4
X_10865_ _17933_/Q _10868_/B VDD VSS _10866_/B XOR2X1
Xclkbuf_leaf_24__001_ clkbuf_2_1__f__001_/Y VDD VSS _19028_/CK BUFX12
X_16441_ _18795_/Q _18741_/Q VDD VSS _16442_/B XOR2X1
X_13653_ _13653_/A _13653_/B _13653_/C _13653_/D VDD VSS _13730_/A OAOI211X1
XFILLER_25_790 VDD VSS FILLER4
XFILLER_31_237 VDD VSS FILLER1
XTAP_TAPCELL_ROW_100_1213 VDD VSS WELLTAP
XTAP_TAPCELL_ROW_100_1224 VDD VSS WELLTAP
X_12604_ _18392_/Q VDD VSS _12718_/A INVX1
X_16372_ _16336_/Y _16410_/B _16554_/A VDD VSS _16373_/B MUX2X1
X_13584_ _13649_/A _13655_/B VDD VSS _14492_/B XNOR2X1
XFILLER_12_462 VDD VSS FILLER1
XFILLER_9_923 VSS VDD FILLER2
X_10796_ _10798_/A _10798_/B _10798_/C VDD VSS _10931_/B XNOR3X1
X_12535_ _18208_/Q VDD VSS _12536_/A INVX1
X_18111_ _18963_/CK _18111_/D _18111_/Q VDD VSS DFFQX1
X_15323_ _18864_/Q _18863_/Q VDD VSS _15324_/C NOR2X1
XFILLER_33_81 VDD VSS FILLER1
XTAP_TAPCELL_ROW_4_63 VDD VSS WELLTAP
X_12466_ _18286_/Q _12466_/B _12530_/C VDD VSS _12844_/B XNOR3X1
X_18042_ _18841_/CK _18042_/D _18042_/Q VDD VSS DFFQX1
Xclkbuf_leaf_39__001_ clkload73/A VDD VSS _17656_/CK BUFX12
X_15254_ _15281_/A _18822_/Q VDD VSS _18795_/D AND2X1
X_11417_ _11417_/A _11417_/B _11422_/C VDD VSS _14188_/B XNOR3X1
X_12397_ _18440_/Q _12397_/B _12397_/C VDD VSS _14443_/B XNOR3X1
X_15185_ _15240_/A _18754_/Q VDD VSS _18727_/D AND2X1
X_14205_ _14198_/Y _14205_/B _14205_/C VDD VSS _18261_/D AND3BX1
XFILLER_99_705 VDD VSS DECAPHV8
X_11348_ _18138_/Q VDD VSS _11350_/A INVX1
X_14136_ _14108_/Y _14136_/B _14136_/C VDD VSS _18198_/D AND3BX1
XFILLER_125_375 VSS VDD FILLER2
XFILLER_3_160 VDD VSS DECAPHV16
XFILLER_99_738 VDD VSS FILLER1
XTAP_TAPCELL_ROW_111_1353 VDD VSS WELLTAP
X_11279_ _11319_/A _11319_/B VDD VSS _14044_/B XNOR2X1
X_18944_ _18951_/CK _18944_/D _18944_/Q VDD VSS DFFQX1
X_14067_ _14067_/A _14067_/B _14396_/A VDD VSS _18135_/D OA21X2
XFILLER_67_635 VDD VSS FILLER4
XFILLER_95_933 VDD VSS DECAPHV8
X_13018_ _18395_/Q _13018_/B _14363_/C VDD VSS _13265_/B XNOR3X1
X_18875_ _18951_/CK _18875_/D _18875_/Q VDD VSS DFFQX1
XFILLER_94_421 VSS VDD FILLER2
X_17826_ _17851_/CK _17826_/D _17826_/Q VDD VSS DFFQX1
XFILLER_54_307 VDD VSS FILLER1
XTAP_TAPCELL_ROW_65_803 VDD VSS WELLTAP
XFILLER_47_381 VDD VSS FILLER1
X_17757_ clkload3/A _17757_/D _17757_/Q VDD VSS DFFQX1
X_14969_ _18615_/Q _18993_/Q VDD VSS _14970_/B XOR2X1
X_17688_ _17722_/CK _17688_/D _17688_/Q VDD VSS DFFQX1
X_16708_ _16926_/A _16708_/B _16709_/C _16708_/D VDD VSS _18917_/D OAI31X1
XFILLER_35_587 VDD VSS DECAPHV16
XTAP_TAPCELL_ROW_45_560 VDD VSS WELLTAP
X_16639_ _18915_/Q _16862_/B VDD VSS _16640_/C NAND2X1
XFILLER_50_568 VDD VSS FILLER4
XFILLER_95_0 VDD VSS DECAPHV32
XTAP_TAPCELL_ROW_122_1482 VDD VSS WELLTAP
XTAP_TAPCELL_ROW_73_891 VDD VSS WELLTAP
X_09111_ _09123_/A _09123_/B VDD VSS _17361_/B XNOR2X1
X_18309_ _18309_/CK _18309_/D _18309_/Q VDD VSS DFFQX1
XFILLER_31_782 VDD VSS DECAPHV16
XFILLER_108_309 VDD VSS FILLER1
XFILLER_129_681 VDD VSS DECAPHV8
X_09042_ _17601_/Q _17391_/B VDD VSS _09043_/B XNOR2X1
XFILLER_117_854 VDD VSS FILLER1
XFILLER_11_1135 VDD VSS FILLER1
XFILLER_135_128 VDD VSS DECAPHV32
XFILLER_116_364 VDD VSS FILLER4
XFILLER_89_204 VDD VSS FILLER4
XFILLER_89_237 VDD VSS DECAPHV16
X_09944_ _10138_/A _10147_/B _10139_/A _09944_/D VDD VSS _10157_/A AOAI211X2
XFILLER_58_602 VSS VDD FILLER2
XFILLER_98_782 VDD VSS FILLER1
XFILLER_98_793 VSS VDD FILLER2
X_09875_ _09887_/C _09881_/D VDD VSS _10078_/B XNOR2X1
XFILLER_58_679 VDD VSS DECAPHV16
XFILLER_85_476 VDD VSS FILLER4
XFILLER_26_510 VDD VSS FILLER1
XFILLER_57_189 VDD VSS DECAPHV16
XFILLER_72_159 VDD VSS FILLER1
XFILLER_53_384 VSS VDD FILLER2
X_10650_ _10731_/A _10787_/B VDD VSS _17916_/D NOR2X1
X_09309_ _09288_/A _09309_/B VDD VSS _09316_/B NOR2BX1
XFILLER_22_793 VDD VSS FILLER4
XTAP_TAPCELL_ROW_23_298 VDD VSS WELLTAP
X_10581_ _10583_/B _10583_/C _17877_/Q VDD VSS _10588_/B AO21X2
XFILLER_103_1049 VDD VSS DECAPHV8
X_12320_ _18231_/Q _14172_/B VDD VSS _12424_/A NAND2X1
X_12251_ _12344_/A _14088_/B VDD VSS _12545_/A NOR2X1
XFILLER_107_364 VDD VSS FILLER4
XFILLER_108_865 VSS VDD FILLER2
X_11202_ _11206_/A _11202_/B VDD VSS _11204_/A XNOR2X1
XFILLER_107_375 VSS VDD FILLER2
XFILLER_79_88 VDD VSS FILLER4
X_12182_ _18335_/Q _12375_/A _14292_/B VDD VSS _14323_/B XOR3X1
XFILLER_123_868 VDD VSS FILLER1
XFILLER_77_900 VDD VSS FILLER1
X_11133_ _17985_/Q _11138_/B VDD VSS _11134_/B XNOR2X1
X_16990_ _18944_/Q _17007_/B VDD VSS _16991_/C NAND2X1
XFILLER_110_518 VSS VDD FILLER2
XFILLER_122_378 VDD VSS DECAPHV8
XFILLER_1_686 VDD VSS DECAPHV32
XFILLER_77_911 VDD VSS DECAPHV16
XFILLER_77_933 VDD VSS DECAPHV8
XFILLER_88_270 VDD VSS FILLER4
XFILLER_95_32 VDD VSS DECAPHV32
X_11064_ _11069_/A _11064_/B VDD VSS _11067_/A XNOR2X1
X_15941_ _15904_/A _15941_/B VDD VSS _15986_/B NAND2BX1
XFILLER_37_808 VSS VDD FILLER2
XFILLER_62_1077 VDD VSS DECAPHV16
XFILLER_88_281 VDD VSS FILLER4
X_10015_ _17803_/Q _10023_/A VDD VSS _10017_/C XOR2X1
X_18660_ _18850_/CK _18660_/D _18660_/Q VDD VSS DFFQX1
XFILLER_92_903 VDD VSS DECAPHV16
XFILLER_97_1107 VDD VSS FILLER1
X_17611_ _19034_/CK _17611_/D _17611_/Q VDD VSS DFFQX1
X_15872_ _18895_/Q _15872_/B _15872_/C VDD VSS _15945_/B MIN3X1
XFILLER_28_92 VSS VDD FILLER2
XFILLER_92_947 VDD VSS DECAPHV8
X_18591_ _19004_/CK _18591_/D _18591_/Q VDD VSS DFFQX1
X_14823_ _14822_/B _14823_/B VDD VSS _14826_/C NOR2BX1
XFILLER_91_479 VDD VSS FILLER1
X_11966_ _12039_/A _12039_/B _12039_/C VDD VSS _14055_/B OAI21X1
X_17542_ _17542_/A _17542_/B _17542_/C VDD VSS _17734_/D AOI21X1
X_14754_ _14903_/A _14754_/B VDD VSS _18568_/D NOR2X1
XFILLER_44_384 VDD VSS FILLER4
XFILLER_72_671 VDD VSS DECAPHV8
X_10917_ _17943_/Q _10918_/B VDD VSS _10924_/C NAND2X1
X_17473_ _17479_/A _17473_/B VDD VSS _17678_/D NOR2X1
X_14685_ _18554_/Q _18586_/Q VDD VSS _14687_/B XOR2X1
X_13705_ _13705_/A _13705_/B _14279_/B _13705_/D _13705_/E VDD VSS _13762_/C OAI221X1
XFILLER_60_855 VDD VSS FILLER1
XFILLER_60_866 VDD VSS DECAPHV16
X_11897_ _18436_/Q _11995_/B _14409_/B VDD VSS _11902_/C XNOR3X1
X_16424_ _16424_/A _16424_/B _16457_/B _16567_/A VDD VSS _16450_/A AOI31X1
X_13636_ _18402_/Q _13748_/A _13754_/B VDD VSS _13738_/D XNOR3X1
XFILLER_13_771 VSS VDD FILLER2
XTAP_TAPCELL_ROW_70_861 VDD VSS WELLTAP
X_10848_ _17930_/Q _10851_/B VDD VSS _10852_/B XOR2X1
XFILLER_8_230 VSS VDD FILLER2
XFILLER_9_742 VSS VDD FILLER2
X_10779_ _10782_/A _10782_/B VDD VSS _10910_/B XNOR2X1
X_16355_ _16405_/D _16405_/C VDD VSS _16357_/C NAND2BX1
X_13567_ _18270_/Q _14214_/A _14214_/B VDD VSS _13628_/B NOR3X1
X_12518_ _12518_/A _12518_/B _12518_/C VDD VSS _12528_/B XNOR3X1
X_16286_ _16286_/A _16286_/B _16286_/C _16286_/D VDD VSS _16315_/A AOI31X1
X_15306_ _15307_/A _18047_/Q VDD VSS _18846_/D AND2X1
X_13498_ _18348_/Q _13498_/B _13558_/C VDD VSS _13686_/B XNOR3X1
XFILLER_117_128 VDD VSS DECAPHV32
X_12449_ _12653_/A _12653_/B _12653_/C VDD VSS _12462_/B AOI21X1
X_18025_ _18025_/CK _18025_/D _18025_/Q VDD VSS DFFQX1
X_15237_ _16984_/A _18805_/Q VDD VSS _18778_/D AND2X1
XFILLER_113_312 VSS VDD FILLER2
XFILLER_99_513 VSS VDD FILLER2
X_15168_ _15281_/A _18738_/Q VDD VSS _18711_/D AND2X1
XFILLER_113_345 VDD VSS FILLER4
XFILLER_114_879 VDD VSS FILLER4
XFILLER_5_96 VDD VSS DECAPHV32
X_15099_ _15240_/A _18670_/Q VDD VSS _18643_/D AND2X1
X_14119_ _14122_/A _14119_/B _14119_/C VDD VSS _18183_/D NOR3X1
XFILLER_68_933 VSS VDD FILLER2
XFILLER_86_218 VSS VDD FILLER2
X_18927_ _18934_/CK _18927_/D _18927_/Q VDD VSS DFFQX1
X_09660_ _09643_/A _09660_/B VDD VSS _09671_/B NOR2BX1
XFILLER_10_0 VDD VSS DECAPHV32
XFILLER_55_605 VDD VSS FILLER4
XFILLER_83_903 VDD VSS DECAPHV8
XTAP_TAPCELL_ROW_78_950 VDD VSS WELLTAP
X_18858_ _18858_/CK _18858_/D _18858_/Q VDD VSS DFFQX1
XFILLER_39_189 VSS VDD FILLER2
XFILLER_48_690 VSS VDD FILLER2
X_09591_ _09591_/A _09591_/B _09591_/C VDD VSS _09592_/B NOR3X1
X_18789_ _18815_/CK _18789_/D _18789_/Q VDD VSS DFFQX1
X_17809_ _17854_/CK _17809_/D _17809_/Q VDD VSS DFFQX1
XFILLER_70_619 VDD VSS FILLER1
XFILLER_82_446 VDD VSS FILLER4
XTAP_TAPCELL_ROW_124_1511 VDD VSS WELLTAP
XFILLER_39_1046 VSS VDD FILLER2
XFILLER_51_800 VSS VDD FILLER2
XFILLER_51_811 VDD VSS FILLER1
XFILLER_10_229 VSS VDD FILLER2
XFILLER_31_590 VDD VSS FILLER4
XFILLER_136_448 VSS VDD FILLER2
XFILLER_40_49 VDD VSS DECAPHV16
XTAP_TAPCELL_ROW_20_257 VDD VSS WELLTAP
X_09025_ _17600_/Q _17390_/B _09025_/C VDD VSS _09026_/A MIN3X1
XFILLER_85_1022 VDD VSS FILLER1
XTAP_TAPCELL_ROW_135_1640 VDD VSS WELLTAP
XFILLER_104_301 VDD VSS DECAPHV8
XFILLER_104_323 VSS VDD FILLER2
XFILLER_132_621 VDD VSS FILLER1
XFILLER_132_632 VDD VSS DECAPHV8
XFILLER_85_1044 VDD VSS DECAPHV16
XFILLER_104_334 VDD VSS FILLER1
XFILLER_77_207 VSS VDD FILLER2
X_09927_ _09927_/A _10109_/B _09927_/C _09927_/D VDD VSS _10128_/A AOAI211X1
Xclkbuf_leaf_23__002_ clkload27/A VDD VSS _18253_/CK BUFX12
XFILLER_58_421 VDD VSS DECAPHV8
XFILLER_100_562 VDD VSS FILLER1
XFILLER_105_64 VDD VSS DECAPHV16
XFILLER_85_251 VSS VDD FILLER2
X_09858_ _17782_/Q _09860_/B VDD VSS _10062_/B XOR2X1
XFILLER_45_115 VDD VSS FILLER1
XFILLER_58_487 VDD VSS DECAPHV16
X_09789_ _09886_/C _09880_/B VDD VSS _09868_/B OR2X2
Xclkbuf_leaf_38__002_ clkload26/A VDD VSS _18470_/CK BUFX12
XFILLER_22_1072 VDD VSS DECAPHV8
XFILLER_27_852 VDD VSS FILLER1
XFILLER_61_608 VDD VSS DECAPHV8
XFILLER_73_468 VSS VDD FILLER2
XTAP_TAPCELL_ROW_86_1049 VDD VSS WELLTAP
X_11820_ _11825_/A _11825_/B _11820_/C VDD VSS _14378_/B XNOR3X1
XFILLER_27_896 VDD VSS FILLER4
XFILLER_57_1135 VDD VSS FILLER1
XTAP_TAPCELL_ROW_28_357 VDD VSS WELLTAP
XTAP_TAPCELL_ROW_56_688 VDD VSS WELLTAP
X_11751_ _11754_/B _11754_/C _18224_/Q VDD VSS _11755_/A AOI21X1
XFILLER_121_96 VDD VSS DECAPHV32
XFILLER_41_310 VDD VSS FILLER1
XFILLER_42_866 VDD VSS FILLER1
XFILLER_92_1048 VDD VSS DECAPHV8
X_10702_ _10702_/A _10705_/C VDD VSS _10837_/B XNOR2X1
XFILLER_41_365 VSS VDD FILLER2
X_11682_ _11769_/A _14136_/B _11760_/C VDD VSS _14137_/B AOI21BX1
X_14470_ _14480_/A _14470_/B VDD VSS _18490_/D NOR2X1
XFILLER_14_72 VDD VSS FILLER4
X_10633_ _17887_/Q _10637_/B VDD VSS _10638_/C XNOR2X1
X_13421_ _18320_/Q _13421_/B VDD VSS _13473_/D _13421_/C NAND3X1
XFILLER_14_83 VDD VSS FILLER4
X_10564_ _17875_/Q _10564_/B VDD VSS _10570_/A NAND2X1
X_16140_ _16140_/A _16140_/B VDD VSS _16141_/D XNOR2X1
X_13352_ _13352_/A _13352_/B _13352_/C _13352_/D VDD VSS _13532_/A AOAI211X1
XFILLER_127_426 VDD VSS FILLER4
X_12303_ _12304_/B _12304_/C _18283_/Q VDD VSS _12310_/B AOI21X1
X_16071_ _18900_/Q _16927_/B _16119_/B _16071_/D VDD VSS _18900_/D AO22X2
XTAP_TAPCELL_ROW_97_1178 VDD VSS WELLTAP
X_10495_ _17868_/Q _10499_/B VDD VSS _10497_/C _10499_/C NAND3X1
X_13283_ _13289_/A _13289_/C _13289_/B VDD VSS _14304_/C AO21X2
X_15022_ _15026_/C _15022_/B VDD VSS _15023_/B XNOR2X1
XFILLER_108_695 VSS VDD FILLER2
XFILLER_136_993 VDD VSS DECAPHV32
XFILLER_5_277 VSS VDD FILLER2
XTAP_TAPCELL_ROW_1_31 VDD VSS WELLTAP
X_12234_ _12234_/A _12234_/B _12234_/C _12234_/D VDD VSS _12338_/B AOAI211X1
XFILLER_123_654 VDD VSS FILLER4
X_12165_ _18179_/Q _12165_/B _12335_/D VDD VSS _14143_/C XNOR3X1
XFILLER_122_142 VDD VSS DECAPHV32
XFILLER_123_698 VDD VSS FILLER4
XFILLER_68_218 VDD VSS FILLER1
XFILLER_96_538 VDD VSS FILLER1
X_11116_ _17982_/Q _11121_/B VDD VSS _11122_/A XNOR2X1
XFILLER_77_741 VSS VDD FILLER2
X_12096_ _12096_/A _12096_/B _14467_/B VDD VSS _12097_/B MIN3X1
X_18712_ _18848_/CK _18712_/D _18712_/Q VDD VSS DFFQX1
X_16973_ _16973_/A _16973_/B _16973_/C VDD VSS _18937_/D OAI21X1
XFILLER_39_80 VDD VSS FILLER4
X_11047_ _11135_/A _11181_/B VDD VSS _17993_/D NOR2X1
X_15924_ _18835_/Q _18673_/Q VDD VSS _15925_/D NAND2X1
XFILLER_64_402 VDD VSS DECAPHV16
XTAP_TAPCELL_ROW_75_920 VDD VSS WELLTAP
X_18643_ _18835_/CK _18643_/D _18643_/Q VDD VSS DFFQX1
X_15855_ _15855_/A _15855_/B _15855_/C _15855_/D VDD VSS _15857_/C OA211X2
XFILLER_36_137 VSS VDD FILLER2
X_18574_ clkload2/A _18574_/D _18574_/Q VDD VSS DFFQX1
X_14806_ _18580_/Q _18612_/Q VDD VSS _14808_/B XNOR2X1
XFILLER_45_682 VDD VSS DECAPHV16
X_12998_ _18987_/Q _18108_/Q VDD VSS _13112_/C NAND2X1
X_17525_ _17524_/Y _17525_/B _17526_/A VDD VSS _17726_/D AND3BX1
X_15786_ _15804_/A _15897_/A VDD VSS _15939_/B NAND2X1
XFILLER_91_298 VSS VDD FILLER2
XTAP_TAPCELL_ROW_106_1285 VDD VSS WELLTAP
XTAP_TAPCELL_ROW_106_1296 VDD VSS WELLTAP
X_11949_ wire29/Y _12026_/B _12026_/D _12026_/C VDD VSS _14112_/B OAOI211X1
X_14737_ _14740_/A _14737_/B _14737_/C VDD VSS _18564_/D AOI21X1
X_17456_ _17463_/A _17456_/B VDD VSS _17662_/D NOR2X1
X_14668_ _14666_/B _14668_/B VDD VSS _14669_/C NOR2BX1
XFILLER_60_696 VDD VSS FILLER1
X_17387_ _17395_/A _17387_/B VDD VSS _17597_/D NOR2X1
X_16407_ _16407_/A _16435_/C _16407_/C VDD VSS _16408_/D AOI21X1
X_13619_ _14339_/A _14339_/B VDD VSS _13635_/B NOR2X1
XFILLER_119_927 VSS VDD FILLER2
XFILLER_119_938 VSS VDD FILLER2
XFILLER_125_1060 VSS VDD FILLER2
XFILLER_9_561 VSS VDD FILLER2
X_16338_ _16263_/Y _16412_/B _16412_/A VDD VSS _16484_/B MUXI2X1
X_14599_ _14602_/A _14602_/B _17514_/A VDD VSS _14600_/C OAI21X1
XFILLER_69_1006 VDD VSS FILLER4
XFILLER_118_459 VDD VSS DECAPHV8
XFILLER_69_1039 VDD VSS DECAPHV8
X_16269_ _16273_/A _16273_/C VDD VSS _16270_/B XNOR2X1
XFILLER_114_610 VDD VSS FILLER4
XFILLER_58_0 VDD VSS DECAPHV32
X_18008_ _18025_/CK _18008_/D _18008_/Q VDD VSS DFFQX1
XFILLER_101_337 VDD VSS DECAPHV8
XFILLER_45_1050 VDD VSS FILLER1
XTAP_TAPCELL_ROW_130_1581 VDD VSS WELLTAP
X_09712_ _09712_/A _09712_/B _09712_/C _09712_/D VDD VSS _09737_/A AOAI211X1
XFILLER_82_210 VDD VSS FILLER1
X_09643_ _09643_/A _09660_/B VDD VSS _17416_/B XOR2X1
XFILLER_55_468 VDD VSS DECAPHV16
XFILLER_83_766 VDD VSS FILLER4
X_09574_ _17589_/Q _17378_/B VDD VSS _09575_/C NOR2X1
XFILLER_70_416 VSS VDD FILLER2
XFILLER_82_276 VDD VSS FILLER4
XFILLER_23_321 VDD VSS DECAPHV8
XFILLER_24_833 VDD VSS DECAPHV8
XTAP_TAPCELL_ROW_25_316 VDD VSS WELLTAP
XFILLER_24_866 VDD VSS DECAPHV8
XTAP_TAPCELL_ROW_53_658 VDD VSS WELLTAP
XTAP_TAPCELL_ROW_81_989 VDD VSS WELLTAP
Xclkbuf_leaf_8_clk_fs_regs clkbuf_leaf_9_clk_fs_regs/A VDD VSS _18961_/CK BUFX12
XFILLER_52_1054 VDD VSS FILLER4
XFILLER_52_1065 VDD VSS FILLER4
XFILLER_136_223 VSS VDD FILLER2
X_09008_ _17728_/Q _17696_/Q VDD VSS _09009_/C NOR2BX1
X_10280_ _10516_/A _10482_/B VDD VSS _17865_/D NOR2X1
XFILLER_105_654 VDD VSS FILLER4
XFILLER_120_602 VSS VDD FILLER2
XFILLER_74_700 VDD VSS FILLER4
X_13970_ _13999_/A _13970_/B _14011_/A _17533_/A VDD VSS _18065_/D OAOI211X1
XFILLER_19_627 VSS VDD FILLER2
XFILLER_19_649 VSS VDD FILLER2
XFILLER_59_785 VDD VSS FILLER4
X_12921_ _18473_/Q VDD VSS _13248_/A INVX1
XFILLER_132_40 VDD VSS FILLER4
X_15640_ _18879_/Q _15640_/B _15640_/C VDD VSS _15644_/C MIN3X1
XFILLER_92_44 VSS VDD FILLER2
X_12852_ _12955_/A _14300_/B VDD VSS _12908_/B NOR2X1
XFILLER_15_844 VDD VSS FILLER4
XFILLER_42_630 VDD VSS FILLER1
XFILLER_55_991 VDD VSS FILLER4
X_11803_ _11803_/A _11803_/B _11803_/C _11803_/D VDD VSS _12122_/A AOAI211X1
X_12783_ _12783_/A _12783_/B _12891_/B _12783_/D VDD VSS _12994_/C OAI211X1
X_15571_ _15545_/Y _15570_/Y _15596_/A VDD VSS _15571_/Y MUXI2X1
XFILLER_14_332 VDD VSS FILLER1
XFILLER_15_888 VDD VSS DECAPHV8
XFILLER_42_652 VDD VSS DECAPHV8
X_11734_ _18303_/Q VDD VSS _11739_/A INVX1
X_18290_ _18292_/CK _18290_/D _18290_/Q VDD VSS DFFQX1
X_17310_ _17312_/C _17310_/B _17310_/C VDD VSS _19018_/D AOI21X1
X_14522_ _14521_/B _14522_/B VDD VSS _14525_/C NOR2BX1
XFILLER_30_847 VSS VDD FILLER2
XFILLER_41_151 VDD VSS FILLER1
XFILLER_41_184 VSS VDD FILLER2
XTAP_TAPCELL_ROW_99_1207 VDD VSS WELLTAP
X_11665_ _18303_/Q _11665_/B _11735_/C VDD VSS _11836_/B MIN3X1
X_17241_ _17241_/A _17241_/B _17241_/C _17241_/D VDD VSS _17248_/A OAOI211X1
X_14453_ _14480_/A _14453_/B VDD VSS _18475_/D NOR2X1
XFILLER_70_1132 VDD VSS FILLER4
X_10616_ _17884_/Q _10616_/B VDD VSS _10620_/B NOR2X1
X_13404_ _18217_/Q _13489_/B VDD VSS _13491_/A XOR2X1
XFILLER_128_724 VDD VSS DECAPHV8
X_11596_ _18302_/Q _11596_/B _11660_/C VDD VSS _11739_/B MIN3X1
X_17172_ _17176_/A _17173_/B _17182_/D VDD VSS _17173_/C OAI21X1
X_14384_ _14389_/A _14384_/B VDD VSS _18413_/D NOR2X1
X_10547_ _17874_/Q VDD VSS _10551_/A INVX1
X_16123_ _18041_/Q _18651_/Q VDD VSS _16176_/A NAND2X1
X_13335_ _13514_/A _13515_/A _14454_/B VDD VSS _14489_/B XNOR3X1
XFILLER_109_993 VDD VSS FILLER1
X_10478_ _10492_/A _10483_/B _10492_/C VDD VSS _10657_/B XNOR3X1
X_13266_ _18344_/Q _14303_/B _14303_/C VDD VSS _13267_/D OR3BX1
X_16054_ _16049_/Y _16084_/A _16161_/C _16054_/D VDD VSS _16105_/D AOI2B2X1
XFILLER_108_481 VDD VSS FILLER4
X_12217_ _12308_/A _12308_/B _14230_/C VDD VSS _14231_/B AOI21BX1
X_15005_ _15009_/A _15006_/B _17554_/C VDD VSS _15006_/C OAI21X1
XFILLER_116_1015 VSS VDD FILLER2
XFILLER_123_462 VSS VDD FILLER2
X_13197_ _18239_/Q _14181_/B VDD VSS _13297_/C _14181_/C AND3X2
XFILLER_96_346 VDD VSS FILLER4
X_12148_ _18178_/Q _14114_/B VDD VSS _14143_/A AND2X1
X_12079_ _18280_/Q _12079_/B VDD VSS _12080_/C _12079_/C NAND3X1
X_16956_ _16973_/A _16956_/B _16956_/C VDD VSS _18934_/D OAI21X1
XFILLER_65_733 VSS VDD FILLER2
XTAP_TAPCELL_ROW_108_1314 VDD VSS WELLTAP
X_15907_ _16905_/B VDD VSS _16527_/B BUFX3
XFILLER_37_435 VSS VDD FILLER2
XFILLER_64_221 VDD VSS FILLER1
X_18626_ _19004_/CK _18626_/D _18626_/Q VDD VSS DFFQX1
X_16887_ _16887_/A VDD VSS _16895_/A INVX1
XFILLER_52_416 VSS VDD FILLER2
XFILLER_80_714 VDD VSS FILLER1
X_15838_ _15838_/A _15838_/B _15838_/C _15838_/D VDD VSS _15839_/C AOI211X1
XFILLER_17_181 VDD VSS FILLER4
XFILLER_52_438 VDD VSS DECAPHV8
X_18557_ clkload7/A _18557_/D _18557_/Q VDD VSS DFFQX1
X_15769_ _15800_/A _15769_/B VDD VSS _15771_/C AND2X1
X_09290_ _09307_/B _09290_/B VDD VSS _17402_/B XOR2X1
X_18488_ _18493_/CK _18488_/D _18488_/Q VDD VSS DFFQX1
X_17508_ _17518_/A _17508_/B VDD VSS _17711_/D NOR2X1
XANTENNA_14 _17536_/D VDD VSS ANTENNA2
XFILLER_21_836 VDD VSS FILLER1
XFILLER_60_460 VDD VSS FILLER4
XFILLER_60_471 VSS VDD FILLER2
XTAP_TAPCELL_ROW_50_617 VDD VSS WELLTAP
X_17439_ _17445_/A _17439_/B VDD VSS _17646_/D NOR2X1
XFILLER_118_212 VDD VSS FILLER1
XTAP_TAPCELL_ROW_119_1443 VDD VSS WELLTAP
XFILLER_118_256 VDD VSS FILLER4
XTAP_TAPCELL_ROW_30_374 VDD VSS WELLTAP
XFILLER_106_429 VDD VSS FILLER4
XFILLER_12_1093 VDD VSS FILLER1
XFILLER_0_718 VSS VDD FILLER2
XFILLER_134_1104 VDD VSS DECAPHV32
XFILLER_99_140 VDD VSS FILLER1
XFILLER_102_624 VDD VSS FILLER1
XFILLER_114_484 VDD VSS FILLER1
XFILLER_99_195 VDD VSS FILLER1
XFILLER_130_966 VSS VDD FILLER2
XFILLER_101_189 VDD VSS DECAPHV8
XFILLER_28_413 VDD VSS FILLER1
XFILLER_56_700 VDD VSS FILLER4
XTAP_TAPCELL_ROW_58_717 VDD VSS WELLTAP
XFILLER_28_446 VSS VDD FILLER2
XFILLER_55_232 VDD VSS DECAPHV8
XFILLER_56_788 VSS VDD FILLER2
X_09626_ _17446_/A _09652_/B VDD VSS _09627_/C NAND2X1
XFILLER_102_32 VDD VSS DECAPHV8
XTAP_TAPCELL_ROW_38_474 VDD VSS WELLTAP
XTAP_TAPCELL_ROW_83_1019 VDD VSS WELLTAP
X_09557_ _17716_/Q VDD VSS _09558_/B INVX1
XFILLER_52_972 VDD VSS FILLER4
XFILLER_54_1105 VDD VSS FILLER4
X_09488_ _09495_/B _09488_/B VDD VSS _17342_/B XOR2X1
XFILLER_23_162 VDD VSS DECAPHV8
XFILLER_24_674 VDD VSS DECAPHV8
XFILLER_24_696 VDD VSS FILLER1
XFILLER_52_983 VDD VSS FILLER4
XFILLER_12_858 VSS VDD FILLER2
XFILLER_51_493 VSS VDD FILLER2
XFILLER_109_212 VDD VSS FILLER4
XFILLER_109_223 VSS VDD FILLER2
X_11450_ _18970_/Q _18091_/Q VDD VSS _11499_/A NAND2X1
XFILLER_109_245 VDD VSS FILLER1
X_10401_ _17852_/Q VDD VSS _10405_/A INVX1
X_11381_ _18167_/Q _11381_/B _11381_/C VDD VSS _11437_/A MIN3X1
XFILLER_125_727 VDD VSS FILLER1
X_10332_ _10513_/A _10513_/B _10523_/C VDD VSS _10525_/B OAI21X1
X_13120_ _13120_/A _13120_/B _13120_/C VDD VSS _14181_/B OAI21X1
XFILLER_106_930 VDD VSS FILLER1
XTAP_TAPCELL_ROW_94_1148 VDD VSS WELLTAP
X_13051_ _14301_/B _14301_/C _18342_/Q VDD VSS _13056_/B AOI21X1
Xclkbuf_leaf_6__000_ clkbuf_leaf_9__000_/A VDD VSS _18851_/CK BUFX12
XFILLER_3_556 VSS VDD FILLER2
X_10263_ _17836_/Q _10267_/B VDD VSS _10264_/B XOR2X1
X_12002_ _18385_/Q VDD VSS _12101_/A INVX1
XFILLER_120_421 VDD VSS DECAPHV8
XFILLER_78_324 VDD VSS FILLER1
XFILLER_78_335 VDD VSS FILLER4
X_10194_ _10194_/A _10194_/B VDD VSS _10206_/B NAND2X1
XFILLER_78_357 VDD VSS FILLER1
XFILLER_87_88 VDD VSS FILLER4
X_17790_ _19033_/CK _17790_/D _17790_/Q VDD VSS DFFQX1
X_16810_ _16815_/B _16810_/B VDD VSS _16812_/B XNOR2X1
X_16741_ _16770_/A _16770_/C VDD VSS _16742_/B NOR2BX1
X_13953_ _18960_/Q _13955_/B _18961_/Q VDD VSS _13959_/A AOI21X1
XFILLER_35_939 VDD VSS FILLER1
XFILLER_98_1076 VSS VDD FILLER2
X_12904_ _18238_/Q _12904_/B _12977_/C VDD VSS _12979_/C XNOR3X1
X_16672_ _18916_/Q _16677_/B VDD VSS _16674_/C XOR2X1
X_13884_ _13884_/A _13884_/B _13884_/C _13884_/D VDD VSS _13885_/C OAI211X1
XFILLER_61_213 VDD VSS FILLER4
XFILLER_62_758 VDD VSS FILLER4
X_12835_ _13021_/A _13021_/B _13021_/C VDD VSS _12935_/B AOI21X1
X_18411_ _18436_/CK _18411_/D _18411_/Q VDD VSS DFFQX1
X_15623_ _15595_/Y _15673_/A VDD VSS _15624_/D NAND2BX1
XFILLER_43_961 VSS VDD FILLER2
XFILLER_61_246 VDD VSS FILLER1
XFILLER_61_257 VSS VDD FILLER2
XFILLER_61_268 VSS VDD FILLER2
X_18342_ _18368_/CK _18342_/D _18342_/Q VDD VSS DFFQX1
X_15554_ _18873_/Q _15792_/D _15752_/C _16988_/A VDD VSS _18873_/D AO22X2
XFILLER_42_471 VDD VSS FILLER1
XTAP_TAPCELL_ROW_103_1255 VDD VSS WELLTAP
X_12766_ _18211_/Q VDD VSS _12788_/A INVX1
X_14505_ _18516_/Q _18548_/Q VDD VSS _14507_/B XNOR2X1
XFILLER_14_195 VDD VSS DECAPHV8
XFILLER_30_644 VDD VSS FILLER1
X_11717_ _18330_/Q _11717_/B _11827_/C VDD VSS _11824_/C XNOR3X1
X_12697_ _18444_/Q _12810_/B _14418_/B VDD VSS _12708_/C XNOR3X1
X_18273_ _18340_/CK _18273_/D _18273_/Q VDD VSS DFFQX1
X_15485_ _18904_/Q _15485_/B VDD VSS _15486_/C XOR2X1
XFILLER_30_688 VSS VDD FILLER2
XTAP_TAPCELL_ROW_0_7 VDD VSS WELLTAP
X_11648_ _18329_/Q _11736_/B _11731_/C VDD VSS _11727_/C XNOR3X1
Xclkbuf_leaf_20_clk_fs_regs clkbuf_leaf_5_clk_fs_regs/A VDD VSS clkload7/A BUFX12
X_17224_ _17224_/A _17224_/B VDD VSS _19002_/D NOR2X1
X_14436_ _17388_/A _14436_/B VDD VSS _18460_/D AND2X1
XFILLER_128_532 VSS VDD FILLER2
XFILLER_7_840 VDD VSS DECAPHV32
X_11579_ _11579_/A _11579_/B _14164_/B VDD VSS _11678_/B MIN3X1
X_17155_ _18025_/Q _17155_/B VDD VSS _17156_/C NAND2X1
X_14367_ _14367_/A _14367_/B _14367_/C VDD VSS _14368_/C NOR3X1
X_16106_ _16180_/A _16142_/B _16106_/C VDD VSS _16108_/B AOI21X1
X_13318_ _13407_/C _13405_/D _13318_/C VDD VSS _13398_/C XNOR3X1
X_17086_ _18012_/Q _17086_/B VDD VSS _17090_/A NOR2BX1
X_14298_ _14332_/A _14298_/B _14298_/C VDD VSS _18339_/D NOR3X1
XFILLER_131_708 VSS VDD FILLER2
X_13249_ _18474_/Q _13249_/B _13249_/C VDD VSS _13337_/A MIN3X1
X_16037_ _18784_/Q _18730_/Q VDD VSS _16038_/D NAND2X1
XFILLER_124_793 VDD VSS DECAPHV16
XFILLER_96_121 VDD VSS FILLER4
XTAP_TAPCELL_ROW_114_1384 VDD VSS WELLTAP
XFILLER_112_966 VSS VDD FILLER2
XFILLER_38_700 VSS VDD FILLER2
XFILLER_42_1053 VSS VDD FILLER2
XFILLER_85_828 VDD VSS DECAPHV8
XFILLER_96_176 VDD VSS DECAPHV8
XFILLER_97_699 VDD VSS FILLER1
X_17988_ _18011_/CK _17988_/D _17988_/Q VDD VSS DFFQX1
XFILLER_26_906 VSS VDD FILLER2
XFILLER_38_755 VDD VSS DECAPHV8
X_16939_ _16939_/A _16939_/B _16946_/A VDD VSS _16948_/B AOI21X1
XFILLER_38_777 VDD VSS FILLER1
XFILLER_65_563 VDD VSS FILLER1
XFILLER_25_427 VSS VDD FILLER2
XFILLER_52_224 VDD VSS DECAPHV8
XFILLER_52_235 VDD VSS DECAPHV8
XFILLER_53_747 VDD VSS DECAPHV8
XFILLER_65_585 VDD VSS DECAPHV8
XFILLER_80_522 VDD VSS FILLER4
X_09411_ _16977_/A VDD VSS _17065_/A BUFX3
X_18609_ _18641_/CK _18609_/D _18609_/Q VDD VSS DFFQX1
XTAP_TAPCELL_ROW_35_433 VDD VSS WELLTAP
XTAP_TAPCELL_ROW_35_444 VDD VSS WELLTAP
X_09342_ _09360_/B _09342_/B VDD VSS _17438_/B XNOR2X1
XFILLER_61_780 VDD VSS FILLER4
XTAP_TAPCELL_ROW_63_775 VDD VSS WELLTAP
X_09273_ _19033_/Q _17333_/B VDD VSS _09297_/A NOR2X1
XFILLER_106_204 VDD VSS DECAPHV8
XFILLER_10_1019 VDD VSS FILLER4
XFILLER_122_719 VSS VDD FILLER2
XTAP_TAPCELL_ROW_7_103 VDD VSS WELLTAP
XFILLER_115_793 VDD VSS FILLER4
XFILLER_88_622 VDD VSS FILLER4
XFILLER_75_305 VDD VSS FILLER4
X_08988_ _17727_/Q _17695_/Q VDD VSS _08989_/B XOR2X1
XFILLER_56_530 VDD VSS DECAPHV8
XFILLER_68_390 VSS VDD FILLER2
XFILLER_113_64 VDD VSS DECAPHV16
XFILLER_28_243 VDD VSS FILLER4
X_10950_ _17059_/C _11087_/B VDD VSS _17975_/D AND2X1
XFILLER_16_438 VSS VDD FILLER2
XFILLER_43_224 VSS VDD FILLER2
X_09609_ _09636_/C _09609_/B VDD VSS _17483_/B XNOR2X1
X_10881_ _10881_/A _10884_/B VDD VSS _11021_/A XOR2X1
XFILLER_71_577 VDD VSS DECAPHV8
X_12620_ _12726_/A _12726_/B _12726_/C VDD VSS _14298_/B AOI21X1
XFILLER_19_1033 VDD VSS FILLER1
XFILLER_24_460 VSS VDD FILLER2
XFILLER_52_780 VDD VSS DECAPHV8
XFILLER_106_1025 VDD VSS FILLER4
XFILLER_40_964 VDD VSS FILLER1
X_12551_ _12669_/B _14118_/C _18182_/Q VDD VSS _12552_/D AND3BX1
X_11502_ _18145_/Q _11502_/B _11562_/D VDD VSS _11614_/C XNOR3X1
X_12482_ _12480_/Y _12587_/D _14423_/A VDD VSS _18038_/D AND3BX1
X_15270_ _15299_/A _18838_/Q VDD VSS _18811_/D AND2X1
XFILLER_125_0 VDD VSS DECAPHV32
X_11433_ _18195_/Q _14133_/B VDD VSS _11475_/C _14133_/C NAND3X1
X_14221_ _14252_/A _14221_/B VDD VSS _18274_/D NOR2X1
XFILLER_22_83 VDD VSS FILLER1
X_14152_ _14160_/A _14152_/B VDD VSS _18212_/D NOR2X1
XFILLER_98_32 VDD VSS DECAPHV8
X_11364_ _18116_/Q _11446_/A _11397_/B VDD VSS _11388_/D XNOR3X1
XFILLER_113_708 VSS VDD FILLER2
X_10315_ _10315_/A _10315_/B _10315_/C _10315_/D VDD VSS _10318_/B AOAI211X1
X_11295_ _18967_/Q _18088_/Q VDD VSS _11314_/C XNOR2X1
X_13103_ _13103_/A _14066_/B VDD VSS _13115_/A OR2X2
X_18960_ _18961_/CK _18960_/D _18960_/Q VDD VSS DFFQX1
X_14083_ _14083_/A _14083_/B VDD VSS _18150_/D NOR2X1
XFILLER_106_771 VSS VDD FILLER2
XFILLER_3_375 VDD VSS DECAPHV32
XFILLER_79_633 VDD VSS DECAPHV8
X_10246_ _17832_/Q VDD VSS _10247_/A INVX1
X_13034_ _18500_/Q VDD VSS _13149_/A INVX1
X_17911_ _17913_/CK _17911_/D _17911_/Q VDD VSS DFFQX1
X_18891_ _18959_/CK _18891_/D _18891_/Q VDD VSS DFFQX1
XFILLER_121_763 VSS VDD FILLER2
XFILLER_65_1086 VSS VDD FILLER2
XFILLER_94_603 VDD VSS FILLER1
X_17842_ _17871_/CK _17842_/D _17842_/Q VDD VSS DFFQX1
XFILLER_121_774 VDD VSS FILLER4
X_10177_ _17823_/Q VDD VSS _10187_/A INVX1
XFILLER_47_530 VDD VSS DECAPHV8
XFILLER_66_349 VDD VSS FILLER1
X_17773_ _19042_/CK _17773_/D _17773_/Q VDD VSS DFFQX1
X_14985_ _14988_/C _14986_/B _17498_/A VDD VSS _14986_/C OAI21X1
XFILLER_47_80 VDD VSS DECAPHV8
XFILLER_93_168 VSS VDD FILLER2
X_16724_ _16751_/C _16724_/B _16757_/A VDD VSS _16725_/D AND3BX1
X_13936_ _14501_/B _18514_/Q VDD VSS _13937_/C NAND2BX1
X_16655_ _18855_/Q _18693_/Q VDD VSS _16656_/B XOR2X1
XFILLER_23_909 VDD VSS FILLER4
XFILLER_34_235 VSS VDD FILLER2
XFILLER_62_555 VDD VSS FILLER1
X_15606_ _18878_/Q VDD VSS _15621_/A INVX1
X_13867_ _13867_/A _13867_/B _13867_/C _13867_/D VDD VSS _13920_/A AOAI211X1
XFILLER_34_268 VSS VDD FILLER2
XFILLER_50_728 VDD VSS FILLER4
XTAP_TAPCELL_ROW_32_403 VDD VSS WELLTAP
X_12818_ _12818_/A _12818_/B _14389_/B VDD VSS _12819_/B MIN3X1
X_16586_ _16587_/A _16587_/B _16587_/D _16587_/C VDD VSS _16589_/C OAI211X1
X_13798_ _13798_/A _13798_/B _13798_/C _13798_/D VDD VSS _13847_/A AOAI211X1
XFILLER_124_1125 VDD VSS DECAPHV8
XTAP_TAPCELL_ROW_60_734 VDD VSS WELLTAP
X_12749_ _12868_/A _14236_/B VDD VSS _12960_/B NOR2X1
X_18325_ _18963_/CK _18325_/D _18325_/Q VDD VSS DFFQX1
X_15537_ _15540_/B _15537_/B VDD VSS _16987_/A XNOR2X1
XFILLER_30_474 VDD VSS FILLER1
X_18256_ _18309_/CK _18256_/D _18256_/Q VDD VSS DFFQX1
X_15468_ _15760_/B _15480_/A _15468_/C VDD VSS _15469_/E NOR3X1
XTAP_TAPCELL_ROW_12_160 VDD VSS WELLTAP
X_17207_ _17216_/A _17216_/D VDD VSS _17211_/C NAND2X1
X_14419_ _14440_/A _14419_/B VDD VSS _18445_/D NOR2X1
XFILLER_129_896 VDD VSS FILLER4
XTAP_TAPCELL_ROW_116_1413 VDD VSS WELLTAP
X_18187_ _18249_/CK _18187_/D _18187_/Q VDD VSS DFFQX1
X_15399_ _15397_/Y _15398_/Y _16588_/A VDD VSS _15461_/B MUXI2X1
X_17138_ _17224_/A _17138_/B VDD VSS _18984_/D NOR2X1
XFILLER_104_719 VDD VSS FILLER4
X_09960_ _09970_/A VDD VSS _10166_/A INVX1
X_17069_ _17069_/A _17069_/B _17069_/C VDD VSS _17074_/B OA21X2
XFILLER_131_527 VSS VDD FILLER2
XFILLER_40_0 VDD VSS DECAPHV32
X_08911_ _17551_/A _17551_/B _17551_/C _17551_/D VDD VSS _08912_/C AOI211X1
XFILLER_100_903 VSS VDD FILLER2
XFILLER_112_741 VDD VSS DECAPHV8
XFILLER_44_1115 VDD VSS DECAPHV16
XFILLER_98_953 VDD VSS DECAPHV16
X_09891_ _17762_/Q _09891_/B VDD VSS _09892_/C NAND2X1
XFILLER_98_986 VSS VDD FILLER2
XFILLER_84_113 VDD VSS DECAPHV16
XFILLER_97_496 VDD VSS FILLER1
XTAP_TAPCELL_ROW_68_834 VDD VSS WELLTAP
XFILLER_26_714 VDD VSS FILLER4
XTAP_TAPCELL_ROW_127_1542 VDD VSS WELLTAP
XFILLER_26_747 VDD VSS DECAPHV8
XFILLER_25_257 VDD VSS FILLER1
XFILLER_53_555 VSS VDD FILLER2
XTAP_TAPCELL_ROW_48_591 VDD VSS WELLTAP
XFILLER_129_1058 VDD VSS DECAPHV32
XFILLER_13_408 VDD VSS FILLER4
XFILLER_13_419 VDD VSS DECAPHV16
XFILLER_40_216 VDD VSS DECAPHV8
XFILLER_53_588 VSS VDD FILLER2
XFILLER_53_599 VDD VSS FILLER1
Xclkbuf_leaf_5__001_ clkload74/A VDD VSS _17901_/CK BUFX12
X_09325_ _09328_/B _09325_/B VDD VSS _09326_/B XOR2X1
X_09256_ _17502_/B _17705_/Q _09256_/C VDD VSS _09283_/B MIN3X1
XFILLER_107_502 VDD VSS DECAPHV8
X_09187_ _17607_/Q _17398_/B VDD VSS _09199_/B XNOR2X1
XFILLER_49_1004 VDD VSS DECAPHV8
XFILLER_88_1053 VDD VSS FILLER1
XTAP_TAPCELL_ROW_91_1107 VDD VSS WELLTAP
XFILLER_1_835 VSS VDD FILLER2
X_10100_ _17815_/Q _10100_/B _10100_/C VDD VSS _10311_/C XNOR3X1
X_11080_ _17043_/A _17022_/B VDD VSS _18000_/D AND2X1
XFILLER_89_953 VDD VSS DECAPHV16
X_10031_ _17805_/Q VDD VSS _10042_/A INVX1
XFILLER_76_603 VDD VSS FILLER1
XFILLER_25_1070 VSS VDD FILLER2
XFILLER_57_872 VDD VSS DECAPHV16
X_14770_ _14771_/C _17318_/C _14770_/C VDD VSS _18571_/D AND3BX1
XFILLER_29_585 VSS VDD FILLER2
X_11982_ _18385_/Q _12101_/B _12101_/C VDD VSS _12001_/B XNOR3X1
X_13721_ _13777_/A _13777_/B _13777_/C VDD VSS _14494_/C NOR3X1
XFILLER_16_235 VSS VDD FILLER2
X_10933_ _10935_/A _10933_/B VDD VSS _11072_/B XNOR2X1
XFILLER_72_886 VDD VSS FILLER1
X_10864_ _10864_/A _10864_/B _10864_/C VDD VSS _10868_/C OAI21X1
Xclkbuf_leaf_24__000_ clkload110/A VDD VSS _18858_/CK BUFX12
X_16440_ _18794_/Q _18740_/Q _16440_/C VDD VSS _16465_/B MIN3X1
X_13652_ _14428_/B _14427_/C _18453_/Q VDD VSS _13653_/D AND3BX1
XFILLER_12_430 VDD VSS FILLER1
XFILLER_13_942 VDD VSS DECAPHV16
XTAP_TAPCELL_ROW_100_1214 VDD VSS WELLTAP
X_10795_ _17918_/Q _10795_/B VDD VSS _10798_/C NOR2X1
X_12603_ _18417_/Q _12603_/B _12603_/C VDD VSS _12818_/B MIN3X1
X_16371_ _16537_/A _18766_/Q _16371_/C _16371_/D VDD VSS _16410_/B AOI211X1
X_13583_ _13583_/A _13583_/B _13583_/C _13583_/D VDD VSS _13649_/A OAOI211X1
X_12534_ _18235_/Q VDD VSS _12651_/A INVX1
X_18110_ _18963_/CK _18110_/D _18110_/Q VDD VSS DFFQX1
X_15322_ _18860_/Q _15338_/A VDD VSS _15793_/C NOR2X1
XTAP_TAPCELL_ROW_4_64 VDD VSS WELLTAP
X_18041_ _18840_/CK _18041_/D _18041_/Q VDD VSS DFFQX1
X_12465_ _18260_/Q _12465_/B _12626_/D VDD VSS _12530_/C XNOR3X1
X_15253_ _15281_/A _18821_/Q VDD VSS _18794_/D AND2X1
X_11416_ _18246_/Q VDD VSS _11418_/A INVX1
X_12396_ _18468_/Q VDD VSS _12594_/A INVX1
X_15184_ _15240_/A _18753_/Q VDD VSS _18726_/D AND2X1
X_14204_ _14198_/Y _14204_/B _14204_/C VDD VSS _18260_/D AND3BX1
XFILLER_126_866 VDD VSS FILLER4
X_11347_ _11382_/A _14073_/B VDD VSS _11428_/A NOR2X1
X_14135_ _14160_/A _14135_/B VDD VSS _18197_/D NOR2X1
XFILLER_4_695 VSS VDD FILLER2
XFILLER_98_249 VDD VSS DECAPHV8
XTAP_TAPCELL_ROW_111_1354 VDD VSS WELLTAP
X_11278_ _11278_/A _11278_/B _11278_/C _11278_/D VDD VSS _11319_/A AOAI211X1
X_18943_ _18951_/CK _18943_/D _18943_/Q VDD VSS DFFQX1
X_14066_ _14083_/A _14066_/B VDD VSS _18134_/D NOR2X1
XFILLER_79_463 VSS VDD FILLER2
XFILLER_95_912 VDD VSS FILLER1
X_10229_ _10414_/A _10414_/B _10415_/C _10414_/C VDD VSS _10229_/Y AOI211X1
X_13017_ _18369_/Q _13046_/B _13170_/D VDD VSS _14363_/C XNOR3X1
X_18874_ _18951_/CK _18874_/D _18874_/Q VDD VSS DFFQX1
XFILLER_0_890 VDD VSS DECAPHV8
XFILLER_55_809 VDD VSS FILLER1
XFILLER_67_658 VDD VSS DECAPHV8
XFILLER_95_945 VDD VSS FILLER1
X_17825_ _19043_/CK _17825_/D _17825_/Q VDD VSS DFFQX1
XFILLER_82_617 VDD VSS FILLER4
XTAP_TAPCELL_ROW_65_804 VDD VSS WELLTAP
X_17756_ clkload5/A _17756_/D _17756_/Q VDD VSS DFFQX1
XFILLER_47_371 VDD VSS FILLER1
X_16707_ _18917_/Q _16905_/B VDD VSS _16708_/D NAND2X1
X_14968_ _18614_/Q _18992_/Q _14968_/C VDD VSS _14971_/B AOI21X1
XFILLER_35_544 VDD VSS FILLER1
XFILLER_74_1108 VDD VSS DECAPHV16
XFILLER_81_149 VDD VSS FILLER4
X_17687_ _17722_/CK _17687_/D _17687_/Q VDD VSS DFFQX1
X_14899_ _18599_/Q _18631_/Q VDD VSS _14900_/C NAND2X1
X_13919_ _18485_/Q _14463_/B VDD VSS _13920_/E _14463_/C AND3X2
XFILLER_90_683 VDD VSS DECAPHV8
XTAP_TAPCELL_ROW_45_561 VDD VSS WELLTAP
X_16638_ _16638_/A _16643_/B VDD VSS _16640_/B XOR2X1
XFILLER_22_249 VDD VSS FILLER1
XFILLER_50_536 VDD VSS FILLER1
XTAP_TAPCELL_ROW_122_1483 VDD VSS WELLTAP
XTAP_TAPCELL_ROW_73_892 VDD VSS WELLTAP
X_16569_ _16866_/A _16602_/A VDD VSS _16597_/A NOR2X1
XFILLER_88_0 VDD VSS DECAPHV32
X_09110_ _17604_/Q _17394_/B VDD VSS _09123_/B XOR2X1
X_18308_ _18337_/CK _18308_/D _18308_/Q VDD VSS DFFQX1
X_09041_ _17570_/Q _17359_/B VDD VSS _09076_/A XOR2X1
XFILLER_30_293 VDD VSS FILLER4
X_18239_ _18292_/CK _18239_/D _18239_/Q VDD VSS DFFQX1
XFILLER_129_693 VSS VDD FILLER2
XFILLER_104_505 VDD VSS FILLER1
XFILLER_117_866 VDD VSS FILLER4
XFILLER_132_814 VDD VSS FILLER1
XFILLER_132_836 VDD VSS DECAPHV8
XFILLER_131_346 VDD VSS DECAPHV16
XFILLER_48_1081 VDD VSS FILLER1
X_09943_ _17793_/Q _09943_/B _09943_/C VDD VSS _09944_/D OR3BX1
XFILLER_100_700 VDD VSS DECAPHV16
XFILLER_85_400 VDD VSS FILLER4
XFILLER_85_411 VSS VDD FILLER2
X_09874_ _17761_/Q _17787_/Q _09886_/C VDD VSS _09881_/D XOR3X1
XFILLER_38_49 VDD VSS DECAPHV16
XFILLER_73_606 VDD VSS DECAPHV16
XFILLER_26_522 VDD VSS FILLER1
XFILLER_38_382 VDD VSS DECAPHV8
XFILLER_39_883 VSS VDD FILLER2
XFILLER_57_179 VSS VDD FILLER2
XFILLER_26_544 VDD VSS FILLER1
XFILLER_72_138 VDD VSS FILLER1
XFILLER_72_149 VSS VDD FILLER2
XFILLER_81_650 VDD VSS FILLER1
XTAP_TAPCELL_ROW_88_1080 VDD VSS WELLTAP
XFILLER_54_886 VDD VSS FILLER4
XFILLER_0_1083 VDD VSS DECAPHV32
XFILLER_110_32 VDD VSS DECAPHV8
XFILLER_13_227 VDD VSS FILLER1
XFILLER_13_249 VDD VSS FILLER4
XFILLER_16_1025 VSS VDD FILLER2
XFILLER_41_569 VSS VDD FILLER2
XFILLER_55_1063 VSS VDD FILLER2
X_09308_ _17675_/Q _17470_/B VDD VSS _09316_/A NOR2X1
XFILLER_21_271 VDD VSS FILLER1
XFILLER_21_282 VDD VSS FILLER1
X_10580_ _10580_/A _10580_/B _10580_/C _10580_/D VDD VSS _10722_/B OAOI211X1
XFILLER_108_811 VDD VSS FILLER4
XFILLER_127_608 VDD VSS DECAPHV8
XTAP_TAPCELL_ROW_23_299 VDD VSS WELLTAP
X_09239_ _09239_/A _09239_/B VDD VSS _09240_/B _09239_/C NAND3X1
XFILLER_126_129 VDD VSS DECAPHV8
XFILLER_135_630 VSS VDD FILLER2
X_12250_ _12352_/A _12352_/B VDD VSS _14088_/B XNOR2X1
XFILLER_119_96 VDD VSS DECAPHV32
X_11201_ _17998_/Q VDD VSS _11206_/A INVX1
X_12181_ _12379_/B _12207_/C VDD VSS _14292_/B NAND2X1
XFILLER_135_696 VDD VSS FILLER4
X_11132_ _11132_/A _11132_/B _11132_/C VDD VSS _11141_/A MIN3X1
XFILLER_122_335 VDD VSS FILLER1
XFILLER_1_654 VDD VSS DECAPHV32
X_11063_ _17971_/Q VDD VSS _11069_/A INVX1
X_15940_ _16109_/A _16266_/B _16266_/C _16196_/A VDD VSS _15986_/A OA211X2
XFILLER_48_124 VDD VSS FILLER1
XFILLER_77_956 VSS VDD FILLER2
X_10014_ _10014_/A VDD VSS _10222_/A INVX1
X_15871_ _16456_/A _15871_/B _15871_/C VDD VSS _18895_/D OAI21X1
XFILLER_91_403 VSS VDD FILLER2
XFILLER_95_88 VDD VSS FILLER4
X_17610_ _19034_/CK _17610_/D _17610_/Q VDD VSS DFFQX1
X_14822_ _14823_/B _14822_/B VDD VSS _14824_/B NOR2BX1
XFILLER_17_500 VDD VSS FILLER1
XFILLER_29_371 VDD VSS FILLER1
XFILLER_45_820 VDD VSS FILLER1
XFILLER_64_639 VDD VSS FILLER1
XFILLER_92_937 VSS VDD FILLER2
X_18590_ clkload7/A _18590_/D _18590_/Q VDD VSS DFFQX1
XFILLER_45_853 VDD VSS FILLER4
XFILLER_91_447 VDD VSS FILLER1
X_11965_ _12054_/D _12054_/C VDD VSS _12039_/C NAND2BX1
X_17541_ _17542_/A _17542_/B _17544_/C VDD VSS _17542_/C OAI21X1
X_14753_ _14758_/C _14753_/B VDD VSS _14754_/B XNOR2X1
XFILLER_32_514 VDD VSS DECAPHV8
X_10916_ _10916_/A _10916_/B _10916_/C VDD VSS _10924_/A OA21X2
X_17472_ _17479_/A _17472_/B VDD VSS _17677_/D NOR2X1
X_14684_ _14684_/A _14684_/B _14684_/C _14684_/D VDD VSS _14689_/C AOAI211X1
X_13704_ _13705_/D _14279_/B VDD VSS _13762_/D NAND2X1
XFILLER_71_182 VDD VSS FILLER4
XTAP_TAPCELL_ROW_42_520 VDD VSS WELLTAP
X_11896_ _11984_/A _11984_/B _12104_/C VDD VSS _14409_/B XNOR3X1
X_16423_ _16423_/A _16423_/B _16423_/C _16423_/D VDD VSS _16490_/A AOAI211X1
X_13635_ _18376_/Q _13635_/B _14339_/C VDD VSS _13754_/B XNOR3X1
XFILLER_44_81 VDD VSS FILLER4
XTAP_TAPCELL_ROW_70_862 VDD VSS WELLTAP
X_10847_ _17929_/Q _10847_/B _10847_/C VDD VSS _10849_/A MIN3X1
X_10778_ _17915_/Q _10781_/B VDD VSS _10782_/B XNOR2X1
X_16354_ _18847_/Q _18685_/Q VDD VSS _16405_/C NAND2X1
X_13566_ _13566_/A _13566_/B _13566_/C VDD VSS _14214_/B NOR3X1
XFILLER_12_282 VDD VSS DECAPHV8
X_12517_ _12844_/A _12844_/B _12844_/C VDD VSS _12619_/B AOI21X1
X_16285_ _18045_/Q _18655_/Q VDD VSS _16286_/D AND2X1
X_15305_ _15307_/A _18046_/Q VDD VSS _18845_/D AND2X1
X_13497_ _18322_/Q _13497_/B _13556_/C VDD VSS _13558_/C XNOR3X1
X_12448_ _12448_/A _14090_/B _14090_/C VDD VSS _12653_/C NOR3X1
X_18024_ _18024_/CK _18024_/D _18024_/Q VDD VSS DFFQX1
X_15236_ hold96/Y _18804_/Q VDD VSS _18777_/D AND2X1
XFILLER_126_674 VDD VSS DECAPHV16
XFILLER_126_696 VDD VSS FILLER1
XFILLER_5_64 VDD VSS DECAPHV16
X_12379_ _12379_/A _12379_/B _12379_/C VDD VSS _14294_/B AOI21X1
X_15167_ _15250_/A _18737_/Q VDD VSS _18710_/D AND2X1
XFILLER_125_184 VSS VDD FILLER2
XFILLER_99_547 VDD VSS FILLER4
X_15098_ _17079_/A _15098_/B VDD VSS _18642_/D NOR2X1
X_14118_ _14108_/Y _14118_/B _14118_/C VDD VSS _18182_/D AND3BX1
XFILLER_68_901 VDD VSS DECAPHV16
XFILLER_79_260 VDD VSS DECAPHV8
X_18926_ _18934_/CK _18926_/D _18926_/Q VDD VSS DFFQX1
Xclkbuf_leaf_4__002_ clkbuf_leaf_9__002_/A VDD VSS _18247_/CK BUFX12
X_14049_ _14049_/A _14049_/B _14055_/C VDD VSS _18118_/D AOI21X1
XFILLER_95_731 VSS VDD FILLER2
XFILLER_83_926 VDD VSS FILLER4
XTAP_TAPCELL_ROW_78_951 VDD VSS WELLTAP
X_18857_ _18857_/CK _18857_/D _18857_/Q VDD VSS DFFQX1
XFILLER_54_127 VDD VSS FILLER4
XFILLER_83_959 VSS VDD FILLER2
XTAP_TAPCELL_ROW_124_1501 VDD VSS WELLTAP
X_09590_ _09591_/A _09591_/B _09591_/C VDD VSS _09600_/C OA21X2
X_18788_ _18815_/CK _18788_/D _18788_/Q VDD VSS DFFQX1
X_17808_ _17854_/CK _17808_/D _17808_/Q VDD VSS DFFQX1
XFILLER_36_864 VDD VSS DECAPHV8
XTAP_TAPCELL_ROW_124_1512 VDD VSS WELLTAP
X_17739_ clkload5/A _17739_/D _17739_/Q VDD VSS DFFQX1
XFILLER_78_1074 VDD VSS FILLER1
Xclkbuf_leaf_7_clk_fs_regs clkbuf_leaf_9_clk_fs_regs/A VDD VSS _18863_/CK BUFX12
XFILLER_50_344 VDD VSS DECAPHV8
XFILLER_50_366 VDD VSS FILLER1
XFILLER_10_219 VSS VDD FILLER2
XFILLER_109_608 VSS VDD FILLER2
XFILLER_108_129 VDD VSS DECAPHV8
XTAP_TAPCELL_ROW_20_258 VDD VSS WELLTAP
X_09024_ _09045_/A VDD VSS _09025_/C INVX1
XFILLER_102_1050 VSS VDD FILLER2
XFILLER_102_1072 VSS VDD FILLER2
XTAP_TAPCELL_ROW_135_1641 VDD VSS WELLTAP
XFILLER_105_825 VDD VSS DECAPHV8
XFILLER_46_1018 VDD VSS FILLER1
XFILLER_120_817 VSS VDD FILLER2
XFILLER_58_400 VDD VSS FILLER1
X_09926_ _17790_/Q _09926_/B _09926_/C VDD VSS _09927_/D OR3BX1
Xclkbuf_leaf_23__001_ clkbuf_2_1__f__001_/Y VDD VSS _17865_/CK BUFX12
XFILLER_105_32 VDD VSS DECAPHV32
XFILLER_131_176 VDD VSS DECAPHV8
XFILLER_58_433 VDD VSS FILLER1
XFILLER_100_552 VDD VSS DECAPHV8
XFILLER_112_390 VDD VSS DECAPHV8
XFILLER_59_978 VSS VDD FILLER2
XFILLER_86_753 VDD VSS FILLER1
X_09857_ _17780_/Q _17781_/Q VDD VSS _09860_/B _09857_/C NAND3X1
XFILLER_100_585 VSS VDD FILLER2
XFILLER_46_639 VSS VDD FILLER2
XFILLER_73_414 VDD VSS DECAPHV16
XFILLER_74_948 VSS VDD FILLER2
X_09788_ _17759_/Q _17758_/Q _17760_/Q VDD VSS _09880_/B AOI21X1
Xclkbuf_leaf_38__001_ clkload73/A VDD VSS _17716_/CK BUFX12
XFILLER_22_1062 VDD VSS FILLER4
XFILLER_73_458 VDD VSS FILLER4
XTAP_TAPCELL_ROW_28_358 VDD VSS WELLTAP
XTAP_TAPCELL_ROW_56_689 VDD VSS WELLTAP
X_11750_ _11750_/A _14166_/B VDD VSS _11765_/A NOR2X1
XFILLER_121_64 VDD VSS DECAPHV16
XFILLER_54_694 VSS VDD FILLER2
XFILLER_81_480 VSS VDD FILLER2
X_10701_ _17901_/Q _10701_/B _10701_/C VDD VSS _10705_/C XNOR3X1
X_11681_ _18172_/Q _14107_/B VDD VSS _11769_/A NAND2X1
XFILLER_14_40 VDD VSS FILLER4
XFILLER_41_377 VDD VSS FILLER1
X_10632_ _10638_/A _10638_/B VDD VSS _10634_/A NAND2X1
X_13420_ _13421_/B _13421_/C _18320_/Q VDD VSS _13473_/B AOI21X1
X_10563_ _10576_/A _10576_/B _10576_/C VDD VSS _10709_/B OAI21X1
X_13351_ _18397_/Q _14366_/B VDD VSS _13352_/D _14366_/C NAND3X1
XFILLER_10_764 VDD VSS DECAPHV8
X_12302_ _14230_/A _14230_/B _14230_/C VDD VSS _12304_/B OAI21X1
X_16070_ _16926_/A _16070_/B VDD VSS _16071_/D NOR2X1
XTAP_TAPCELL_ROW_97_1179 VDD VSS WELLTAP
X_10494_ _10499_/B _10499_/C _17868_/Q VDD VSS _10497_/B AOI21X1
X_13282_ _13289_/A _13289_/B VDD VSS _14304_/B _13289_/C NAND3X1
X_15021_ _18626_/Q _19004_/Q VDD VSS _15022_/B XNOR2X1
XFILLER_30_83 VDD VSS DECAPHV8
XTAP_TAPCELL_ROW_1_32 VDD VSS WELLTAP
X_12233_ _18178_/Q _14114_/B VDD VSS _12338_/A NAND2X1
XFILLER_107_184 VSS VDD FILLER2
XFILLER_123_644 VDD VSS FILLER4
XFILLER_135_493 VDD VSS DECAPHV16
XFILLER_64_1129 VDD VSS FILLER4
X_12164_ _18153_/Q _12446_/A _12352_/B VDD VSS _12335_/D XNOR3X1
XFILLER_2_974 VSS VDD FILLER2
XFILLER_49_400 VDD VSS FILLER1
X_11115_ _17059_/C _17060_/B VDD VSS _18007_/D AND2X1
X_12095_ _12095_/A _12095_/B _14470_/B VDD VSS _12191_/B MIN3X1
X_16972_ _18937_/Q _16972_/B VDD VSS _16973_/C NAND2X1
XFILLER_77_731 VDD VSS FILLER1
XFILLER_89_580 VDD VSS DECAPHV8
X_11046_ _11046_/A _11048_/C VDD VSS _11181_/B XNOR2X1
X_18711_ _18818_/CK _18711_/D _18711_/Q VDD VSS DFFQX1
X_15923_ _16778_/A _15923_/B _15923_/C VDD VSS _15980_/B OA21X2
XFILLER_36_105 VDD VSS DECAPHV32
XFILLER_64_425 VSS VDD FILLER2
XFILLER_92_723 VDD VSS FILLER1
XTAP_TAPCELL_ROW_75_921 VDD VSS WELLTAP
X_18642_ clkload2/A _18642_/D _18642_/Q VDD VSS DFFQX1
X_15854_ _15855_/A _15855_/B _15855_/D _15855_/C VDD VSS _15931_/B OAOI211X1
XFILLER_52_609 VDD VSS FILLER1
XFILLER_91_244 VSS VDD FILLER2
X_18573_ clkload2/A _18573_/D _18573_/Q VDD VSS DFFQX1
X_15785_ _15874_/D _15785_/B _15785_/C _16206_/A _15785_/E VDD VSS _15860_/D AOI221X1
X_14805_ _14803_/Y _14808_/A _17525_/B VDD VSS _18579_/D AND3BX1
XFILLER_45_650 VDD VSS FILLER1
XFILLER_55_80 VDD VSS DECAPHV8
XFILLER_92_789 VDD VSS FILLER1
X_12997_ _13105_/A _13105_/B VDD VSS _13002_/B NOR2X1
X_17524_ _17726_/Q _18515_/Q VDD VSS _17524_/Y NOR2X1
X_14736_ _14740_/A _14737_/B _17266_/C VDD VSS _14737_/C OAI21X1
XFILLER_44_182 VDD VSS DECAPHV16
XTAP_TAPCELL_ROW_106_1286 VDD VSS WELLTAP
X_11948_ _12064_/A _12045_/A _12052_/B VDD VSS _12026_/C XNOR3X1
X_11879_ _11931_/A _11931_/B _11931_/C VDD VSS _11883_/B OAI21X1
X_17455_ _17455_/A _17455_/B VDD VSS _17661_/D AND2X1
X_14667_ _14696_/A _14667_/B VDD VSS _18550_/D NOR2X1
XFILLER_13_580 VDD VSS FILLER1
XFILLER_38_1091 VDD VSS DECAPHV8
X_17386_ _17395_/A _17386_/B VDD VSS _17596_/D NOR2X1
X_16406_ _16407_/A _16435_/C _16657_/D VDD VSS _16407_/C OAI21X1
X_14598_ _18534_/Q _18566_/Q _14598_/C VDD VSS _14602_/B MIN3X1
X_13618_ _18349_/Q _14308_/B VDD VSS _14339_/A AND2X1
XFILLER_9_551 VSS VDD FILLER2
X_16337_ _16299_/B _16336_/Y _16554_/A VDD VSS _16412_/B MUXI2X1
X_13549_ _18374_/Q _14337_/B VDD VSS _13675_/A AND2X1
XFILLER_118_449 VDD VSS FILLER4
X_18007_ _18025_/CK _18007_/D _18007_/Q VDD VSS DFFQX1
X_16268_ _16268_/A _16349_/B VDD VSS _16273_/C XOR2X1
XFILLER_126_471 VDD VSS DECAPHV16
X_16199_ _18816_/Q _18708_/Q VDD VSS _16200_/B XNOR2X1
X_15219_ _15250_/A _18788_/Q VDD VSS _18761_/D AND2X1
XFILLER_114_644 VDD VSS FILLER4
XFILLER_114_677 VSS VDD FILLER2
XFILLER_59_208 VDD VSS DECAPHV8
XFILLER_99_366 VDD VSS FILLER1
XFILLER_113_176 VSS VDD FILLER2
XFILLER_99_399 VDD VSS FILLER1
XTAP_TAPCELL_ROW_130_1582 VDD VSS WELLTAP
X_09711_ _17594_/Q _17384_/B VDD VSS _09712_/D NAND2BX1
XFILLER_56_915 VDD VSS FILLER1
XFILLER_67_241 VDD VSS FILLER1
XFILLER_95_561 VDD VSS FILLER4
X_18909_ _18913_/CK _18909_/D _18909_/Q VDD VSS DFFQX1
XFILLER_67_274 VDD VSS FILLER4
XFILLER_83_723 VDD VSS FILLER4
X_09642_ _17656_/Q _17450_/B VDD VSS _09660_/B XOR2X1
X_09573_ _09573_/A _09573_/B _09573_/C VDD VSS _09596_/A AOI21X1
XFILLER_36_694 VSS VDD FILLER2
XTAP_TAPCELL_ROW_25_317 VDD VSS WELLTAP
XFILLER_51_664 VDD VSS FILLER1
XTAP_TAPCELL_ROW_53_659 VDD VSS WELLTAP
XFILLER_109_438 VDD VSS FILLER1
XFILLER_52_1077 VDD VSS FILLER4
XFILLER_52_1088 VSS VDD FILLER2
XFILLER_105_611 VDD VSS DECAPHV8
XFILLER_118_983 VSS VDD FILLER2
XFILLER_136_268 VSS VDD FILLER2
X_09007_ _17664_/Q _09007_/B _17458_/B VDD VSS _09028_/A MIN3X1
XFILLER_133_986 VDD VSS DECAPHV32
XFILLER_120_658 VDD VSS FILLER1
XFILLER_120_669 VDD VSS FILLER1
XFILLER_24_1124 VDD VSS DECAPHV8
XFILLER_47_904 VDD VSS FILLER1
XFILLER_59_742 VSS VDD FILLER2
X_09909_ _10093_/B _09909_/B _09909_/C _09909_/D VDD VSS _10111_/B OAOI211X1
X_12920_ _12920_/A _14483_/B _12920_/C VDD VSS _13033_/B MIN3X1
XFILLER_47_959 VDD VSS DECAPHV8
XFILLER_73_211 VDD VSS DECAPHV8
X_12851_ _12953_/A _14266_/B VDD VSS _12955_/A NOR2X1
XFILLER_27_672 VDD VSS FILLER1
XFILLER_62_918 VDD VSS FILLER1
XFILLER_74_789 VDD VSS FILLER1
X_11802_ _18226_/Q _14167_/B VDD VSS _11803_/D _14167_/C NAND3X1
XFILLER_15_834 VSS VDD FILLER2
XFILLER_33_119 VDD VSS FILLER4
XFILLER_54_480 VDD VSS FILLER4
XFILLER_61_439 VSS VDD FILLER2
X_12782_ _18986_/Q _18107_/Q VDD VSS _12891_/D XNOR2X1
X_15570_ _15557_/Y _15569_/Y _15648_/A VDD VSS _15570_/Y MUX2X1
XFILLER_14_344 VDD VSS DECAPHV8
XFILLER_15_878 VSS VDD FILLER2
XFILLER_70_973 VSS VDD FILLER2
X_11733_ _18356_/Q _11733_/B _11824_/C VDD VSS _11811_/B MIN3X1
X_14521_ _14522_/B _14521_/B VDD VSS _14523_/B NOR2BX1
XTAP_TAPCELL_ROW_99_1208 VDD VSS WELLTAP
X_11664_ _11664_/A _11664_/B _14252_/B VDD VSS _11665_/B MIN3X1
X_17240_ _17241_/A _17241_/B _17241_/C _17241_/D VDD VSS _17242_/B OA211X2
X_14452_ _14542_/A VDD VSS _14480_/A BUFX3
X_10615_ _17884_/Q _10616_/B VDD VSS _10620_/C NAND2X1
X_17171_ _17176_/D _17176_/B VDD VSS _17173_/B NOR2BX1
X_13403_ _14157_/A _14157_/B VDD VSS _13489_/B NAND2X1
X_11595_ _11595_/A _11595_/B _14251_/B VDD VSS _11596_/B MIN3X1
X_16122_ _16567_/A _16194_/A VDD VSS _16149_/A NOR2X1
X_14383_ _14389_/A _14383_/B VDD VSS _18412_/D NOR2X1
XFILLER_116_909 VDD VSS FILLER4
XFILLER_128_758 VDD VSS FILLER4
X_10546_ _10630_/A _10698_/B VDD VSS _17900_/D NOR2X1
X_13334_ _13346_/B _13346_/C VDD VSS _14454_/B NAND2X1
X_10477_ _17865_/Q _10477_/B _10477_/C VDD VSS _10492_/C MIN3X1
X_13265_ _13265_/A _13265_/B _13265_/C _13265_/D VDD VSS _13352_/B AOAI211X1
X_16053_ _16102_/A _16053_/B VDD VSS _16054_/D XNOR2X1
X_12216_ _12216_/A _12216_/B _12216_/C _12216_/D VDD VSS _12308_/B AOAI211X1
X_15004_ _15009_/C _15009_/B VDD VSS _15006_/B NAND2BX1
XFILLER_123_452 VDD VSS FILLER4
XFILLER_29_1057 VDD VSS DECAPHV16
X_13196_ _14181_/B _14181_/C _18239_/Q VDD VSS _13297_/B AO21X2
XFILLER_110_113 VDD VSS DECAPHV16
XFILLER_123_474 VDD VSS FILLER1
XFILLER_2_793 VDD VSS DECAPHV32
X_12147_ _12244_/A _12335_/B VDD VSS _14114_/B XNOR2X1
XFILLER_111_658 VSS VDD FILLER2
XFILLER_2_32 VDD VSS DECAPHV8
X_12078_ _12079_/B _12079_/C _18280_/Q VDD VSS _12080_/B AOI21X1
X_16955_ _18934_/Q _16972_/B VDD VSS _16956_/C NAND2X1
XFILLER_38_948 VDD VSS FILLER1
X_11029_ _11062_/A _11164_/B VDD VSS _17990_/D AND2X1
X_16886_ _18927_/Q _16886_/B VDD VSS _16887_/A NAND2X1
X_15906_ _15945_/B _15906_/B VDD VSS _15909_/B XNOR2X1
XFILLER_49_296 VDD VSS DECAPHV16
XTAP_TAPCELL_ROW_108_1315 VDD VSS WELLTAP
X_18625_ _19004_/CK _18625_/D _18625_/Q VDD VSS DFFQX1
X_15837_ _15838_/A _15838_/B _15838_/D _15838_/C VDD VSS _15925_/B AOAI211X1
XFILLER_18_650 VDD VSS DECAPHV8
XFILLER_46_970 VDD VSS FILLER1
XFILLER_64_255 VSS VDD FILLER2
X_18556_ clkload7/A _18556_/D _18556_/Q VDD VSS DFFQX1
X_15768_ _18862_/Q _15768_/B _16084_/A _15785_/C VDD VSS _15771_/B OA211X2
XFILLER_17_193 VDD VSS FILLER1
X_18487_ _18514_/CK _18487_/D _18487_/Q VDD VSS DFFQX1
X_17507_ _17561_/C _17742_/Q VDD VSS _17710_/D AND2X1
X_15699_ _15737_/A _17008_/A _15699_/C VDD VSS _18885_/D OAI21X1
X_14719_ _14723_/A _14723_/B _14719_/C VDD VSS _18561_/D AOI21X1
XFILLER_32_174 VSS VDD FILLER2
XFILLER_33_675 VDD VSS FILLER1
XTAP_TAPCELL_ROW_50_618 VDD VSS WELLTAP
Xclkbuf_leaf_22__002_ clkload27/A VDD VSS _18261_/CK BUFX12
X_17438_ _17561_/C _17438_/B VDD VSS _17645_/D AND2X1
XANTENNA_15 _17536_/D VDD VSS ANTENNA2
XFILLER_32_196 VDD VSS DECAPHV8
XFILLER_119_747 VDD VSS FILLER4
XFILLER_70_0 VDD VSS DECAPHV32
X_17369_ _17378_/A _17369_/B VDD VSS _17580_/D NOR2X1
XFILLER_107_909 VDD VSS FILLER4
XFILLER_118_224 VDD VSS FILLER1
XFILLER_119_769 VSS VDD FILLER2
XTAP_TAPCELL_ROW_119_1444 VDD VSS WELLTAP
XTAP_TAPCELL_ROW_30_375 VDD VSS WELLTAP
XTAP_TAPCELL_ROW_132_1600 VDD VSS WELLTAP
X_19039_ _19042_/CK _19039_/D _19039_/Q VDD VSS DFFQX1
Xclkbuf_leaf_37__002_ clkload26/A VDD VSS _18500_/CK BUFX12
XFILLER_47_1113 VSS VDD FILLER2
XFILLER_99_152 VDD VSS FILLER1
XFILLER_114_474 VDD VSS FILLER4
XFILLER_87_325 VDD VSS DECAPHV16
XFILLER_99_185 VDD VSS FILLER1
XFILLER_29_904 VDD VSS FILLER1
XTAP_TAPCELL_ROW_58_718 VDD VSS WELLTAP
XFILLER_28_436 VDD VSS FILLER4
XFILLER_28_458 VSS VDD FILLER2
XFILLER_46_49 VDD VSS DECAPHV16
X_09625_ _09627_/B _09625_/B VDD VSS _09652_/B NAND2BX1
XFILLER_44_929 VDD VSS FILLER4
XFILLER_71_726 VSS VDD FILLER2
XTAP_TAPCELL_ROW_83_1009 VDD VSS WELLTAP
XFILLER_102_44 VSS VDD FILLER2
XFILLER_15_119 VDD VSS FILLER1
XTAP_TAPCELL_ROW_38_475 VDD VSS WELLTAP
X_09556_ _09556_/A _09556_/B _09556_/C VDD VSS _09585_/B AOI21X1
XFILLER_12_804 VDD VSS DECAPHV16
X_09487_ _17586_/Q _17375_/B VDD VSS _09488_/B XNOR2X1
XFILLER_52_995 VDD VSS FILLER1
XFILLER_109_235 VDD VSS DECAPHV8
X_10400_ _10400_/A _10569_/B _10400_/C _10400_/D VDD VSS _10579_/B AOAI211X1
X_11380_ _11380_/A _11380_/B _14101_/B VDD VSS _11381_/C MIN3X1
X_10331_ _17845_/Q _10331_/B _10331_/C VDD VSS _10523_/C XNOR3X1
XFILLER_118_780 VDD VSS FILLER4
XTAP_TAPCELL_ROW_94_1149 VDD VSS WELLTAP
X_10262_ _10262_/A _10262_/B _10262_/C VDD VSS _10266_/A MIN3X1
X_13050_ _13265_/A _13265_/B _13265_/C VDD VSS _13138_/B AOI21X1
X_12001_ _18411_/Q _12001_/B _12001_/C VDD VSS _12202_/B MIN3X1
XFILLER_127_96 VDD VSS DECAPHV32
XFILLER_133_783 VSS VDD FILLER2
X_10193_ _17825_/Q VDD VSS _10196_/A INVX1
XFILLER_121_956 VDD VSS DECAPHV8
XFILLER_59_561 VDD VSS DECAPHV16
XFILLER_93_328 VDD VSS FILLER1
X_16740_ _18918_/Q _16740_/B VDD VSS _16770_/C NOR2X1
X_13952_ _18960_/Q _18961_/Q _13955_/B _17536_/D VDD VSS _13952_/Y AOI31X1
XFILLER_101_680 VDD VSS FILLER4
XFILLER_19_436 VSS VDD FILLER2
XFILLER_4_1059 VDD VSS DECAPHV8
X_12903_ _18212_/Q _13191_/A _13191_/B VDD VSS _12977_/C XNOR3X1
XFILLER_35_929 VDD VSS FILLER1
XFILLER_47_789 VDD VSS DECAPHV16
X_16671_ _16671_/A _16678_/C VDD VSS _16677_/B XNOR2X1
X_13883_ _13884_/A _13884_/B _13884_/D _13884_/C VDD VSS _13913_/B OAOI211X1
XFILLER_34_417 VDD VSS FILLER1
XFILLER_98_1088 VDD VSS DECAPHV8
X_12834_ _12834_/A _14329_/B _14329_/C VDD VSS _13021_/C NOR3X1
X_18410_ _18436_/CK _18410_/D _18410_/Q VDD VSS DFFQX1
X_15622_ _16783_/A _15622_/B VDD VSS _15648_/C AND2X1
X_12765_ _12765_/A _14177_/B _12859_/C _12765_/D VDD VSS _12977_/A OAOI211X1
X_18341_ _18368_/CK _18341_/D _18341_/Q VDD VSS DFFQX1
X_15553_ _15563_/B _15553_/B VDD VSS _16988_/A XNOR2X1
XFILLER_15_686 VDD VSS DECAPHV32
XFILLER_43_995 VDD VSS FILLER1
XTAP_TAPCELL_ROW_103_1256 VDD VSS WELLTAP
XTAP_TAPCELL_ROW_7_97 VDD VSS WELLTAP
X_11716_ _18304_/Q _11836_/B _14285_/B VDD VSS _11827_/C XNOR3X1
X_18272_ _18340_/CK _18272_/D _18272_/Q VDD VSS DFFQX1
X_14504_ _14502_/Y _14507_/A _17525_/B VDD VSS _18515_/D AND3BX1
XFILLER_42_494 VDD VSS DECAPHV16
X_12696_ _12818_/A _12818_/B _12713_/C VDD VSS _14418_/B XNOR3X1
X_17223_ _17236_/B _17223_/B VDD VSS _17224_/B XOR2X1
X_15484_ _15686_/A _15599_/B _15599_/C _16782_/D VDD VSS _15490_/A OAI211X1
XFILLER_52_81 VDD VSS DECAPHV8
X_11647_ _18303_/Q _11739_/B _11735_/C VDD VSS _11731_/C XNOR3X1
X_14435_ _14435_/A _14435_/B _17534_/A VDD VSS _18459_/D OA21X2
XTAP_TAPCELL_ROW_0_8 VDD VSS WELLTAP
X_11578_ _11607_/D _11752_/B VDD VSS _14164_/B XNOR2X1
X_17154_ _17154_/A _17154_/B VDD VSS _18987_/D AND2X1
X_14366_ _14361_/Y _14366_/B _14366_/C VDD VSS _18397_/D AND3BX1
X_10529_ _10541_/A _10541_/B _10541_/D VDD VSS _10535_/B OAI21X1
X_17085_ _17224_/A _17085_/B VDD VSS _18974_/D NOR2X1
X_16105_ _16411_/A _16105_/B _16105_/C _16105_/D VDD VSS _16106_/C AND4X2
X_13317_ _13405_/A _13405_/B _13405_/C VDD VSS _13318_/C AOI21X1
XFILLER_115_249 VDD VSS FILLER1
X_16036_ _16036_/A VDD VSS _16089_/A INVX1
X_14297_ _17065_/A VDD VSS _14332_/A BUFX3
XFILLER_112_901 VDD VSS FILLER4
XFILLER_124_750 VDD VSS FILLER1
X_13248_ _13248_/A _13248_/B _14484_/B VDD VSS _13249_/B MIN3X1
XFILLER_69_303 VDD VSS FILLER4
XFILLER_97_612 VDD VSS FILLER4
XFILLER_97_634 VDD VSS FILLER4
XTAP_TAPCELL_ROW_114_1385 VDD VSS WELLTAP
X_13179_ _13234_/D _13417_/A _13287_/B VDD VSS _13181_/C XNOR3X1
XFILLER_78_881 VSS VDD FILLER2
XFILLER_84_306 VDD VSS FILLER4
XFILLER_84_328 VDD VSS DECAPHV16
X_17987_ _18011_/CK _17987_/D _17987_/Q VDD VSS DFFQX1
X_16938_ _16973_/A _16938_/B _16938_/C VDD VSS _18932_/D OAI21X1
XFILLER_25_406 VSS VDD FILLER2
XFILLER_26_929 VSS VDD FILLER2
XFILLER_38_767 VSS VDD FILLER2
XFILLER_53_704 VDD VSS DECAPHV16
XFILLER_77_1106 VDD VSS FILLER1
X_16869_ _16869_/A _16869_/B _16869_/C VDD VSS _16947_/B OAI21X1
XFILLER_19_981 VDD VSS DECAPHV8
XFILLER_52_203 VDD VSS FILLER1
XFILLER_65_597 VDD VSS FILLER1
X_09410_ _09437_/B _09410_/B VDD VSS _17770_/D NOR2X1
X_18608_ _18641_/CK _18608_/D _18608_/Q VDD VSS DFFQX1
XFILLER_52_247 VDD VSS FILLER1
XFILLER_53_759 VSS VDD FILLER2
XTAP_TAPCELL_ROW_35_434 VDD VSS WELLTAP
X_09341_ _17677_/Q _17472_/B VDD VSS _09342_/B XNOR2X1
X_18539_ clkload2/A _18539_/D _18539_/Q VDD VSS DFFQX1
XFILLER_34_995 VDD VSS FILLER4
XTAP_TAPCELL_ROW_63_776 VDD VSS WELLTAP
XFILLER_21_634 VDD VSS FILLER1
X_09272_ _09270_/Y _09297_/B VDD VSS _17765_/D NOR2BX1
XFILLER_21_678 VDD VSS FILLER1
XFILLER_101_1126 VDD VSS FILLER4
XFILLER_134_514 VSS VDD FILLER2
XFILLER_106_216 VSS VDD FILLER2
XFILLER_119_599 VDD VSS FILLER4
XTAP_TAPCELL_ROW_7_104 VDD VSS WELLTAP
XFILLER_0_538 VSS VDD FILLER2
XFILLER_103_923 VDD VSS FILLER4
XFILLER_103_956 VDD VSS FILLER4
XFILLER_102_477 VSS VDD FILLER2
XFILLER_60_1110 VDD VSS FILLER4
XFILLER_60_1132 VDD VSS FILLER4
X_08987_ _17726_/Q _17694_/Q VDD VSS _08994_/C NAND2BX1
XFILLER_102_499 VDD VSS DECAPHV8
XFILLER_69_892 VSS VDD FILLER2
XFILLER_113_32 VDD VSS DECAPHV32
XFILLER_84_873 VDD VSS DECAPHV8
XFILLER_16_417 VDD VSS FILLER1
XFILLER_44_726 VDD VSS FILLER1
X_09608_ _17751_/Q _17719_/Q VDD VSS _09609_/B XNOR2X1
X_10880_ _17936_/Q _10883_/B VDD VSS _10884_/B XOR2X1
XFILLER_19_1001 VDD VSS FILLER4
X_09539_ _17588_/Q _17377_/B VDD VSS _09550_/C XOR2X1
XFILLER_19_1056 VDD VSS DECAPHV8
X_12550_ _12550_/A _12550_/B _12550_/C _12550_/D VDD VSS _14118_/C OAI211X1
X_11501_ _18119_/Q _11560_/A _11637_/B VDD VSS _11562_/D XNOR3X1
X_12481_ _12588_/B _12587_/C _12481_/C VDD VSS _12587_/D NAND3BX1
XFILLER_22_40 VDD VSS FILLER4
X_11432_ _14133_/B _14133_/C _18195_/Q VDD VSS _11475_/B AOI21X1
X_14220_ _14220_/A _14220_/B VDD VSS _14221_/B XNOR2X1
XFILLER_118_0 VDD VSS DECAPHV32
X_14151_ _14149_/Y _14151_/B _14151_/C VDD VSS _18211_/D AND3BX1
XFILLER_125_536 VSS VDD FILLER2
XFILLER_98_44 VSS VDD FILLER2
X_11363_ _18969_/Q _18090_/Q VDD VSS _11397_/B XOR2X1
X_13102_ _13206_/A _13206_/B VDD VSS _13205_/B NOR2X1
XFILLER_65_1021 VSS VDD FILLER2
X_10314_ _10475_/A _10314_/B _10314_/C VDD VSS _10315_/C NOR3X1
X_11294_ _11294_/A _11294_/B _11294_/C _11294_/D VDD VSS _11345_/B AOAI211X1
X_14082_ _14074_/Y _14082_/B _14082_/C VDD VSS _18149_/D AND3BX1
XFILLER_0_0 VDD VSS DECAPHV32
XFILLER_78_111 VDD VSS FILLER1
X_10245_ _10707_/A _10433_/B VDD VSS _17857_/D AND2X1
X_13033_ _18499_/Q _13033_/B _13033_/C VDD VSS _13149_/B MIN3X1
X_17910_ _17913_/CK _17910_/D _17910_/Q VDD VSS DFFQX1
X_18890_ _18959_/CK _18890_/D _18890_/Q VDD VSS DFFQX1
XFILLER_105_282 VSS VDD FILLER2
XFILLER_120_230 VSS VDD FILLER2
XFILLER_26_1016 VDD VSS DECAPHV8
XFILLER_65_1076 VDD VSS FILLER1
XFILLER_79_645 VSS VDD FILLER2
X_10176_ _10176_/A _10176_/B _10176_/C VDD VSS _10183_/B XNOR3X1
X_17841_ _17871_/CK _17841_/D _17841_/Q VDD VSS DFFQX1
XFILLER_67_818 VDD VSS FILLER1
XFILLER_59_391 VSS VDD FILLER2
XFILLER_66_328 VSS VDD FILLER2
X_17772_ _19042_/CK _17772_/D _17772_/Q VDD VSS DFFQX1
X_14984_ _18618_/Q _18996_/Q VDD VSS _14986_/B XOR2X1
XFILLER_75_851 VDD VSS FILLER4
X_16723_ _16723_/A _16723_/B _16723_/C _16723_/D VDD VSS _16724_/B OAI211X1
X_13935_ _13935_/A _13935_/B _13935_/C VDD VSS _13937_/B AOI21X1
XFILLER_47_586 VSS VDD FILLER2
X_16654_ _18854_/Q _18692_/Q _16625_/C VDD VSS _16681_/C AOI21BX1
X_13866_ _18484_/Q _14462_/B VDD VSS _13867_/D _14462_/C NAND3X1
XFILLER_35_759 VDD VSS DECAPHV16
X_12817_ _18392_/Q _12827_/A _14359_/B VDD VSS _14389_/B XNOR3X1
X_15605_ _18877_/Q _15792_/D _15752_/C _16994_/A VDD VSS _18877_/D AO22X2
XFILLER_43_770 VSS VDD FILLER2
XFILLER_72_1014 VDD VSS DECAPHV8
XTAP_TAPCELL_ROW_32_404 VDD VSS WELLTAP
X_16585_ _18852_/Q _18690_/Q VDD VSS _16587_/C NAND2X1
X_13797_ _18403_/Q _14373_/B _14373_/C VDD VSS _13798_/D OR3BX1
XFILLER_63_80 VDD VSS DECAPHV8
XTAP_TAPCELL_ROW_60_735 VDD VSS WELLTAP
X_12748_ _12854_/A _14206_/B VDD VSS _12868_/A NOR2X1
X_18324_ _18431_/CK _18324_/D _18324_/Q VDD VSS DFFQX1
X_15536_ _15540_/A _15540_/C VDD VSS _15537_/B XNOR2X1
XFILLER_129_820 VDD VSS FILLER1
X_12679_ _14061_/A _14061_/B _12679_/C VDD VSS _12680_/E AO21X2
X_18255_ _18309_/CK _18255_/D _18255_/Q VDD VSS DFFQX1
X_15467_ _15485_/B _15467_/B _16783_/A VDD VSS _15468_/C OAI21X1
XFILLER_31_998 VSS VDD FILLER2
XTAP_TAPCELL_ROW_12_161 VDD VSS WELLTAP
X_18186_ _18249_/CK _18186_/D _18186_/Q VDD VSS DFFQX1
X_17206_ _18997_/Q _18998_/Q _17226_/C VDD VSS _17216_/D OAI21X1
X_14418_ _14440_/A _14418_/B VDD VSS _18444_/D NOR2X1
XFILLER_116_514 VSS VDD FILLER2
XTAP_TAPCELL_ROW_116_1414 VDD VSS WELLTAP
X_17137_ _17140_/A _17140_/B VDD VSS _17138_/B XNOR2X1
X_15398_ _18915_/Q _15398_/B VDD VSS _15398_/Y XOR2X1
X_14349_ _18358_/Q _14349_/B VDD VSS _14350_/B XNOR2X1
XFILLER_89_409 VDD VSS FILLER1
X_17068_ _17069_/A _17069_/B _17069_/C VDD VSS _17070_/B NOR3X1
X_08910_ _17738_/Q _18527_/Q VDD VSS _17551_/D XNOR2X1
X_09890_ _09896_/A _09896_/B VDD VSS _09904_/A OR2X2
X_16019_ _16180_/A _16056_/B _16056_/C _16056_/D VDD VSS _16107_/B AND4X2
XFILLER_33_0 VDD VSS DECAPHV32
XFILLER_97_453 VDD VSS DECAPHV8
XFILLER_111_241 VDD VSS FILLER4
XFILLER_131_1119 VDD VSS DECAPHV8
XFILLER_57_317 VDD VSS FILLER4
XFILLER_69_166 VDD VSS FILLER4
XFILLER_57_339 VDD VSS FILLER1
XTAP_TAPCELL_ROW_68_835 VDD VSS WELLTAP
XFILLER_38_553 VDD VSS FILLER1
XTAP_TAPCELL_ROW_127_1543 VDD VSS WELLTAP
XFILLER_129_1026 VDD VSS DECAPHV32
XFILLER_26_759 VSS VDD FILLER2
XTAP_TAPCELL_ROW_48_592 VDD VSS WELLTAP
XFILLER_41_718 VDD VSS DECAPHV16
Xclkbuf_leaf_5__000_ clkload110/A VDD VSS _18852_/CK BUFX12
XFILLER_80_397 VDD VSS FILLER1
XFILLER_90_1114 VSS VDD FILLER2
X_09324_ _19035_/Q _17335_/B VDD VSS _09325_/B XNOR2X1
XFILLER_22_987 VDD VSS FILLER1
X_09255_ _17737_/Q VDD VSS _17502_/B INVX1
XFILLER_105_1081 VDD VSS FILLER1
XFILLER_135_801 VDD VSS FILLER1
XFILLER_88_1010 VDD VSS DECAPHV16
X_09186_ _09201_/B _09186_/B VDD VSS _17398_/B XNOR2X1
XFILLER_107_514 VDD VSS FILLER1
XFILLER_135_856 VDD VSS DECAPHV16
XFILLER_49_1016 VSS VDD FILLER2
XFILLER_4_129 VDD VSS DECAPHV8
XFILLER_107_569 VDD VSS FILLER4
XFILLER_108_32 VDD VSS DECAPHV8
XFILLER_122_506 VDD VSS FILLER4
XFILLER_88_1076 VDD VSS DECAPHV16
XTAP_TAPCELL_ROW_91_1108 VDD VSS WELLTAP
XFILLER_122_539 VDD VSS FILLER1
XFILLER_89_921 VDD VSS DECAPHV8
XFILLER_0_313 VSS VDD FILLER2
XFILLER_103_742 VSS VDD FILLER2
X_10030_ _17804_/Q _10030_/B VDD VSS _10033_/A NOR2BX1
XFILLER_48_328 VDD VSS DECAPHV8
XFILLER_57_840 VDD VSS DECAPHV8
XFILLER_75_136 VDD VSS FILLER1
XFILLER_112_1030 VDD VSS FILLER4
XFILLER_29_553 VDD VSS FILLER4
X_11981_ _18359_/Q _12006_/B _14321_/B VDD VSS _12101_/C XOR3X1
X_10932_ _17946_/Q _10936_/B VDD VSS _10933_/B XOR2X1
X_13720_ _18480_/Q _14458_/B VDD VSS _13777_/A AND2X1
XFILLER_16_225 VDD VSS FILLER4
XFILLER_71_342 VSS VDD FILLER2
XFILLER_83_180 VDD VSS FILLER1
X_10863_ _10863_/A _10863_/B VDD VSS _10864_/C NAND2X1
X_13651_ _13651_/A _14457_/B _14457_/C VDD VSS _13655_/C NOR3X1
XFILLER_25_781 VDD VSS FILLER4
XTAP_TAPCELL_ROW_100_1215 VDD VSS WELLTAP
X_10794_ _17919_/Q VDD VSS _10798_/A INVX1
X_12602_ _12602_/A _12602_/B _14387_/B VDD VSS _12603_/B MIN3X1
X_16370_ _16582_/A _16370_/B _16370_/C _16370_/D VDD VSS _16371_/D AO211X2
X_13582_ _13653_/B _14456_/C _18478_/Q VDD VSS _13583_/D AND3BX1
X_12533_ _12652_/A _12652_/B VDD VSS _12640_/B NOR2X1
X_15321_ _18861_/Q _18862_/Q VDD VSS _15338_/A NAND2X1
X_18040_ _18840_/CK _18040_/D _18040_/Q VDD VSS DFFQX1
X_15252_ _15307_/A _18820_/Q VDD VSS _18793_/D AND2X1
XTAP_TAPCELL_ROW_4_65 VDD VSS WELLTAP
X_12464_ _18234_/Q _12743_/A _12742_/B VDD VSS _12626_/D XNOR3X1
X_14203_ _14217_/A _14203_/B VDD VSS _18259_/D NOR2X1
X_11415_ _18273_/Q _11415_/B _11415_/C VDD VSS _11463_/B MIN3X1
X_12395_ _18494_/Q VDD VSS _12588_/A INVX1
X_15183_ _15240_/A _18752_/Q VDD VSS _18725_/D AND2X1
XFILLER_125_355 VDD VSS FILLER1
XFILLER_126_878 VDD VSS FILLER4
X_11346_ _11388_/A _11388_/B VDD VSS _14073_/B XNOR2X1
X_14134_ _14174_/A _14134_/B _14134_/C VDD VSS _18196_/D NOR3X1
XFILLER_125_377 VDD VSS FILLER1
XFILLER_125_388 VDD VSS DECAPHV16
XFILLER_98_217 VDD VSS DECAPHV8
X_18942_ _18951_/CK _18942_/D _18942_/Q VDD VSS DFFQX1
X_14065_ _10382_/Y _14065_/B _14065_/C VDD VSS _18133_/D AND3BX1
XFILLER_3_184 VSS VDD FILLER2
XFILLER_79_431 VDD VSS FILLER1
X_11277_ _18965_/Q _18086_/Q VDD VSS _11278_/D NAND2X1
X_13016_ _18343_/Q _13060_/A _13234_/B VDD VSS _13170_/D XNOR3X1
XFILLER_121_561 VDD VSS DECAPHV16
XTAP_TAPCELL_ROW_111_1355 VDD VSS WELLTAP
X_10228_ _10019_/Y _10228_/B _17828_/Q VDD VSS _10414_/C AND3BX1
X_18873_ _18940_/CK _18873_/D _18873_/Q VDD VSS DFFQX1
XFILLER_66_136 VSS VDD FILLER2
X_10159_ _10338_/A _10338_/B _10343_/C VDD VSS _10352_/B OAI21X1
X_17824_ _19043_/CK _17824_/D _17824_/Q VDD VSS DFFQX1
XFILLER_48_862 VDD VSS FILLER4
XFILLER_82_607 VSS VDD FILLER2
XFILLER_94_456 VDD VSS FILLER4
XFILLER_95_979 VSS VDD FILLER2
X_17755_ clkload3/A _17755_/D _17755_/Q VDD VSS DFFQX1
X_14967_ _14965_/B _14967_/B VDD VSS _14968_/C NOR2BX1
XFILLER_63_810 VSS VDD FILLER2
XFILLER_75_670 VSS VDD FILLER2
X_16706_ _16706_/A _16706_/B _16706_/C VDD VSS _16709_/C OA21X2
XFILLER_90_651 VDD VSS DECAPHV32
XTAP_TAPCELL_ROW_17_220 VDD VSS WELLTAP
Xclkbuf_leaf_6_clk_fs_regs clkbuf_leaf_9_clk_fs_regs/A VDD VSS _18547_/CK BUFX12
X_17686_ _17722_/CK _17686_/D _17686_/Q VDD VSS DFFQX1
X_14898_ _14900_/A _14900_/B _14898_/C VDD VSS _18599_/D AOI21X1
X_13918_ _18486_/Q _14464_/B VDD VSS _13929_/A NOR2X1
XFILLER_23_718 VDD VSS DECAPHV8
XFILLER_50_504 VDD VSS FILLER4
XTAP_TAPCELL_ROW_45_562 VDD VSS WELLTAP
X_16637_ _18914_/Q _16637_/B _16637_/C VDD VSS _16643_/B MIN3X1
X_13849_ _18432_/Q _13876_/B _13849_/C VDD VSS _13868_/B XOR3X1
XFILLER_50_526 VSS VDD FILLER2
XFILLER_50_548 VSS VDD FILLER2
XFILLER_90_695 VSS VDD FILLER2
XTAP_TAPCELL_ROW_73_893 VDD VSS WELLTAP
X_16568_ _16568_/A _16568_/B VDD VSS _16602_/A NOR2X1
XFILLER_31_762 VSS VDD FILLER2
XTAP_TAPCELL_ROW_122_1484 VDD VSS WELLTAP
X_18307_ _18337_/CK _18307_/D _18307_/Q VDD VSS DFFQX1
X_15519_ _16782_/D _15519_/B _15519_/C VDD VSS _15523_/C AOI21X1
XFILLER_31_773 VDD VSS FILLER4
X_09040_ _09058_/B _09040_/B VDD VSS _17359_/B XNOR2X1
X_16499_ _16541_/A _16499_/B VDD VSS _16501_/B XNOR2X1
XFILLER_129_661 VDD VSS FILLER4
X_18238_ _18292_/CK _18238_/D _18238_/Q VDD VSS DFFQX1
X_18169_ _18195_/CK _18169_/D _18169_/Q VDD VSS DFFQX1
XFILLER_131_314 VDD VSS DECAPHV32
X_09942_ _09935_/Y _10151_/B _10151_/C VDD VSS _17819_/D AND3BX1
XFILLER_48_1060 VSS VDD FILLER2
XFILLER_86_913 VDD VSS DECAPHV16
X_09873_ _17786_/Q _09886_/C _09880_/B VDD VSS _09887_/C OR3BX1
XFILLER_58_659 VSS VDD FILLER2
XFILLER_98_795 VDD VSS FILLER1
XFILLER_39_840 VDD VSS FILLER1
XFILLER_57_158 VDD VSS DECAPHV8
XFILLER_79_1009 VDD VSS DECAPHV8
XFILLER_100_789 VDD VSS FILLER1
XFILLER_38_394 VSS VDD FILLER2
XFILLER_53_342 VSS VDD FILLER2
XTAP_TAPCELL_ROW_88_1070 VDD VSS WELLTAP
XFILLER_54_49 VDD VSS DECAPHV32
XFILLER_110_44 VSS VDD FILLER2
XFILLER_55_1020 VSS VDD FILLER2
XFILLER_94_1080 VSS VDD FILLER2
XFILLER_10_902 VSS VDD FILLER2
X_09307_ _09290_/B _09307_/B _09307_/C VDD VSS _09319_/A AOI2B1X1
XFILLER_103_1007 VSS VDD FILLER2
XFILLER_10_924 VDD VSS FILLER1
XFILLER_22_773 VSS VDD FILLER2
XTAP_TAPCELL_ROW_23_289 VDD VSS WELLTAP
X_09238_ _09239_/A _09239_/B _09239_/C VDD VSS _09246_/C AO21X2
XFILLER_108_845 VDD VSS DECAPHV16
XFILLER_119_160 VDD VSS DECAPHV16
X_09169_ _17392_/A _09169_/B VDD VSS _17761_/D AND2X1
XFILLER_119_64 VDD VSS DECAPHV16
XFILLER_123_804 VDD VSS FILLER4
XFILLER_135_642 VDD VSS DECAPHV8
X_11200_ _11205_/A _17144_/B VDD VSS _18023_/D NOR2X1
X_12180_ _12213_/A _12213_/B _12213_/D _12213_/C VDD VSS _12207_/C OAI211X1
XFILLER_107_377 VDD VSS FILLER1
XFILLER_134_174 VDD VSS DECAPHV32
X_11131_ _17154_/A _17076_/B VDD VSS _18010_/D AND2X1
XFILLER_122_347 VSS VDD FILLER2
X_11062_ _11062_/A _11192_/B VDD VSS _17996_/D AND2X1
XFILLER_135_96 VDD VSS DECAPHV32
XFILLER_49_648 VSS VDD FILLER2
X_10013_ _10009_/A _10013_/B VDD VSS _10014_/A NOR2BX1
X_15870_ _18895_/Q _16927_/B VDD VSS _15871_/C NAND2X1
XFILLER_48_158 VDD VSS DECAPHV8
XFILLER_76_467 VDD VSS FILLER4
X_14821_ _18583_/Q _18615_/Q VDD VSS _14822_/B XOR2X1
XFILLER_91_437 VDD VSS DECAPHV8
XFILLER_29_394 VDD VSS DECAPHV8
X_11964_ _18977_/Q _18098_/Q VDD VSS _12054_/C NAND2X1
X_17540_ _17540_/A _17540_/B _17540_/C VDD VSS _17733_/D AOI21X1
X_14752_ _18568_/Q _18600_/Q VDD VSS _14753_/B XNOR2X1
XFILLER_72_662 VDD VSS FILLER1
X_10915_ _17942_/Q _10915_/B VDD VSS _10916_/C NAND2X1
X_11895_ _18384_/Q _11895_/B _11983_/C VDD VSS _12104_/C XNOR3X1
X_17471_ _17561_/C _17471_/B VDD VSS _17676_/D AND2X1
X_14683_ _18553_/Q _18585_/Q VDD VSS _14684_/D NAND2X1
X_13703_ _18324_/Q VDD VSS _13705_/D INVX1
XTAP_TAPCELL_ROW_42_521 VDD VSS WELLTAP
X_10846_ _10846_/A VDD VSS _10847_/B INVX1
X_16422_ _18909_/Q _16422_/B VDD VSS _16423_/D NAND2X1
X_13634_ _18350_/Q _13688_/B _13688_/C VDD VSS _14339_/C XNOR3X1
XFILLER_32_559 VDD VSS DECAPHV16
XTAP_TAPCELL_ROW_70_863 VDD VSS WELLTAP
X_16353_ _18847_/Q _18685_/Q VDD VSS _16405_/D NOR2X1
XFILLER_13_773 VDD VSS FILLER1
XFILLER_40_570 VSS VDD FILLER2
X_10777_ _10777_/A _10777_/B _10777_/C VDD VSS _10782_/A MIN3X1
X_15304_ _15304_/A _18045_/Q VDD VSS _18844_/D AND2X1
X_13565_ _13566_/A _13566_/C _13566_/B VDD VSS _14214_/A OA21X2
X_12516_ _18286_/Q _14234_/B VDD VSS _12844_/C _14234_/C AND3X2
X_16284_ _16327_/A _16284_/B _16284_/C _16284_/D VDD VSS _16284_/Y AOAI211X1
X_13496_ _18296_/Q _13628_/A _13559_/B VDD VSS _13556_/C XNOR3X1
XFILLER_60_81 VDD VSS DECAPHV16
XFILLER_9_788 VDD VSS DECAPHV16
X_12447_ _12455_/A _12455_/B _12542_/C VDD VSS _14090_/C NOR3X1
X_18023_ _18024_/CK _18023_/D _18023_/Q VDD VSS DFFQX1
X_15235_ _15286_/A _18803_/Q VDD VSS _18776_/D AND2X1
XFILLER_8_298 VDD VSS DECAPHV16
X_15166_ _15304_/A _18736_/Q VDD VSS _18709_/D AND2X1
XFILLER_113_314 VDD VSS FILLER1
XFILLER_119_1014 VDD VSS DECAPHV8
XFILLER_5_32 VDD VSS DECAPHV32
XFILLER_99_515 VDD VSS FILLER1
X_12378_ _18337_/Q _12499_/A _12617_/B VDD VSS _12411_/D XNOR3X1
X_14117_ _14129_/A _14117_/B VDD VSS _18181_/D NOR2X1
XFILLER_119_1047 VSS VDD FILLER2
X_11329_ _18167_/Q _11381_/B _11342_/C VDD VSS _11420_/C XNOR3X1
X_15097_ _15097_/A _15097_/B VDD VSS _15098_/B XNOR2X1
X_18925_ _18934_/CK _18925_/D _18925_/Q VDD VSS DFFQX1
Xclkbuf_leaf_4__001_ clkload73/A VDD VSS _19043_/CK BUFX12
X_14048_ _10382_/Y _14048_/B _14048_/C VDD VSS _18117_/D AND3BX1
XFILLER_68_935 VDD VSS FILLER1
XFILLER_80_1135 VDD VSS FILLER1
X_18856_ _18856_/CK _18856_/D _18856_/Q VDD VSS DFFQX1
XFILLER_68_979 VSS VDD FILLER2
XTAP_TAPCELL_ROW_78_952 VDD VSS WELLTAP
X_17807_ _19051_/CK _17807_/D _17807_/Q VDD VSS DFFQX1
XFILLER_67_478 VSS VDD FILLER2
X_18787_ _18787_/CK _18787_/D _18787_/Q VDD VSS DFFQX1
X_15999_ _18039_/Q _18649_/Q VDD VSS _16042_/C NOR2X1
XTAP_TAPCELL_ROW_124_1502 VDD VSS WELLTAP
X_17738_ clkload5/A _17738_/D _17738_/Q VDD VSS DFFQX1
XFILLER_35_353 VSS VDD FILLER2
XFILLER_91_960 VDD VSS FILLER4
X_17669_ _17669_/CK _17669_/D _17669_/Q VDD VSS DFFQX1
XFILLER_51_857 VDD VSS DECAPHV8
XTAP_TAPCELL_ROW_20_259 VDD VSS WELLTAP
X_09023_ _17599_/Q _17389_/B _09047_/A VDD VSS _09045_/A MIN3X1
XTAP_TAPCELL_ROW_135_1642 VDD VSS WELLTAP
XFILLER_2_408 VDD VSS DECAPHV8
XFILLER_116_174 VDD VSS FILLER4
XFILLER_132_667 VDD VSS FILLER4
X_09925_ _17434_/A _10131_/B VDD VSS _17817_/D AND2X1
Xclkbuf_leaf_23__000_ clkload110/A VDD VSS _18066_/CK BUFX12
XFILLER_86_743 VDD VSS DECAPHV8
X_09856_ _09976_/A _10060_/B VDD VSS _17807_/D NOR2X1
XFILLER_46_607 VDD VSS DECAPHV8
XFILLER_105_88 VDD VSS FILLER4
XFILLER_22_1030 VDD VSS FILLER4
XFILLER_27_821 VDD VSS FILLER1
X_09787_ _09787_/A VDD VSS _09886_/C BUFX3
XFILLER_121_32 VDD VSS DECAPHV32
XFILLER_53_150 VDD VSS FILLER1
XTAP_TAPCELL_ROW_28_359 VDD VSS WELLTAP
XFILLER_14_526 VDD VSS DECAPHV8
XFILLER_42_824 VDD VSS FILLER4
X_10700_ _10700_/A _10700_/B _10700_/C VDD VSS _10701_/B AOI21X1
X_11680_ _18199_/Q VDD VSS _11760_/A INVX1
X_10631_ _17886_/Q _10631_/B VDD VSS _10638_/A NAND2X1
XFILLER_10_732 VDD VSS DECAPHV32
X_10562_ _17876_/Q _10565_/B _10562_/C VDD VSS _10576_/C XNOR3X1
X_13350_ _13350_/A _13350_/B _13350_/C _13350_/D VDD VSS _14366_/B AOAI211X1
XFILLER_10_776 VSS VDD FILLER2
X_12301_ _18336_/Q _12301_/B VDD VSS _12374_/C _12380_/B NAND3X1
X_13281_ _14367_/A _14367_/B VDD VSS _13325_/B NOR2X1
XFILLER_108_653 VDD VSS FILLER4
XFILLER_30_40 VDD VSS FILLER4
X_10493_ _17867_/Q _10493_/B _10493_/C VDD VSS _10497_/A MIN3X1
X_12232_ _12334_/A _12334_/B VDD VSS _12318_/B NOR2X1
X_15020_ _15020_/A _15020_/B _15020_/C VDD VSS _15026_/C OA21X2
XFILLER_100_0 VDD VSS DECAPHV32
XTAP_TAPCELL_ROW_1_33 VDD VSS WELLTAP
XFILLER_30_95 VSS VDD FILLER2
X_12163_ _18127_/Q _12360_/B _12360_/C VDD VSS _12352_/B XNOR3X1
XFILLER_111_807 VDD VSS FILLER4
XFILLER_96_507 VDD VSS FILLER4
X_11114_ _11118_/C _11114_/B VDD VSS _17060_/B XNOR2X1
X_12094_ _12095_/B _12094_/B _12094_/C VDD VSS _18034_/D AOI21X1
X_16971_ _16971_/A _16971_/B VDD VSS _16973_/B XNOR2X1
XFILLER_110_317 VDD VSS FILLER1
XFILLER_110_328 VDD VSS FILLER4
XFILLER_1_463 VSS VDD FILLER2
XFILLER_7_1013 VDD VSS DECAPHV8
XFILLER_89_592 VSS VDD FILLER2
X_11045_ _17966_/Q _11045_/B _11045_/C VDD VSS _11048_/C MIN3X1
X_18710_ _18818_/CK _18710_/D _18710_/Q VDD VSS DFFQX1
X_15922_ _16218_/A _18755_/Q VDD VSS _15923_/C NAND2X1
XFILLER_65_905 VSS VDD FILLER2
XFILLER_77_743 VDD VSS FILLER1
XFILLER_65_938 VDD VSS DECAPHV8
XFILLER_76_275 VSS VDD FILLER2
XFILLER_91_201 VDD VSS FILLER1
XTAP_TAPCELL_ROW_75_922 VDD VSS WELLTAP
X_18641_ _18641_/CK _18641_/D _18641_/Q VDD VSS DFFQX1
X_15853_ _18807_/Q _18699_/Q VDD VSS _15855_/C XNOR2X1
X_12996_ _13103_/A _14066_/B VDD VSS _13105_/A NOR2X1
X_18572_ clkload2/A _18572_/D _18572_/Q VDD VSS DFFQX1
X_15784_ _15784_/A _15784_/B _15784_/C _18862_/Q VDD VSS _15785_/E OAOI211X1
X_14804_ _18579_/Q _18611_/Q VDD VSS _14808_/A NAND2X1
XFILLER_17_353 VSS VDD FILLER2
XFILLER_44_150 VDD VSS DECAPHV32
X_11947_ _18150_/Q VDD VSS _12064_/A INVX1
X_17523_ _17523_/A _17757_/Q VDD VSS _17725_/D AND2X1
X_14735_ _14740_/C _14740_/B VDD VSS _14737_/B NAND2BX1
XFILLER_17_375 VSS VDD FILLER2
XFILLER_55_92 VDD VSS FILLER1
XTAP_TAPCELL_ROW_106_1287 VDD VSS WELLTAP
XFILLER_60_654 VSS VDD FILLER2
X_11878_ _18228_/Q _12032_/A _12123_/B VDD VSS _12122_/D XNOR3X1
X_17454_ _17463_/A _17454_/B VDD VSS _17660_/D NOR2X1
X_14666_ _14668_/B _14666_/B VDD VSS _14667_/B XOR2X1
XFILLER_60_687 VSS VDD FILLER2
X_10829_ _10832_/A _10832_/B VDD VSS _10830_/B XNOR2X1
X_17385_ _17395_/A _17385_/B VDD VSS _17595_/D NOR2X1
X_16405_ _16405_/A _16405_/B _16405_/C _16405_/D VDD VSS _16435_/C AOI31X1
X_14597_ _18535_/Q _18567_/Q VDD VSS _14602_/A XNOR2X1
X_13617_ _13705_/A _13617_/B VDD VSS _14308_/B XNOR2X1
XFILLER_118_406 VDD VSS FILLER1
XFILLER_119_929 VDD VSS FILLER1
XFILLER_71_91 VSS VDD FILLER2
X_16336_ _16316_/Y _16336_/B _16336_/C VDD VSS _16336_/Y AND3BX1
X_13548_ _13613_/A _13686_/B VDD VSS _14337_/B XNOR2X1
XFILLER_9_563 VDD VSS FILLER1
X_16267_ _16265_/Y _16459_/A _16267_/C VDD VSS _16349_/B AOI2B1X1
X_18006_ _18025_/CK _18006_/D _18006_/Q VDD VSS DFFQX1
X_15218_ _15274_/A _18787_/Q VDD VSS _18760_/D AND2X1
X_13479_ _13488_/A _13488_/B _13488_/C VDD VSS _14245_/C NOR3X1
XFILLER_126_461 VSS VDD FILLER2
X_16198_ _16250_/A _16250_/B _16250_/D VDD VSS _16200_/A AOI21X1
X_15149_ _15318_/A _18719_/Q VDD VSS _18692_/D AND2X1
XFILLER_87_518 VDD VSS FILLER1
XTAP_TAPCELL_ROW_130_1583 VDD VSS WELLTAP
X_09710_ _09710_/A _09710_/B VDD VSS _09733_/A NAND2X1
X_18908_ _18913_/CK _18908_/D _18908_/Q VDD VSS DFFQX1
XFILLER_28_607 VDD VSS DECAPHV8
XFILLER_67_231 VDD VSS DECAPHV8
XFILLER_95_540 VDD VSS FILLER1
XFILLER_132_1066 VSS VDD FILLER2
X_09641_ _09662_/B _09641_/B VDD VSS _17450_/B NOR2BX1
X_18839_ _18840_/CK _18839_/D _18839_/Q VDD VSS DFFQX1
XFILLER_55_437 VDD VSS FILLER4
XFILLER_55_448 VDD VSS DECAPHV8
X_09572_ _19044_/Q _17345_/B VDD VSS _09573_/C NOR2X1
XFILLER_64_971 VDD VSS FILLER4
XTAP_TAPCELL_ROW_85_1040 VDD VSS WELLTAP
XTAP_TAPCELL_ROW_25_318 VDD VSS WELLTAP
XFILLER_51_654 VDD VSS DECAPHV8
XTAP_TAPCELL_ROW_53_649 VDD VSS WELLTAP
XFILLER_13_1007 VDD VSS FILLER1
X_09006_ _17632_/Q _17425_/B _09006_/C VDD VSS _09037_/A OAI21X1
XFILLER_117_472 VSS VDD FILLER2
XFILLER_105_623 VDD VSS DECAPHV8
XFILLER_133_954 VDD VSS DECAPHV32
XFILLER_104_133 VSS VDD FILLER2
XFILLER_105_678 VDD VSS FILLER4
XFILLER_116_32 VDD VSS DECAPHV8
XFILLER_24_1103 VSS VDD FILLER2
XFILLER_63_1130 VDD VSS FILLER4
XFILLER_58_231 VDD VSS FILLER1
X_09908_ _09914_/A _09914_/B VDD VSS _10111_/A NOR2X1
XFILLER_19_629 VDD VSS FILLER1
XFILLER_47_927 VSS VDD FILLER2
X_09839_ _17776_/Q _09841_/B VDD VSS _10017_/B XOR2X1
XFILLER_58_286 VDD VSS FILLER4
XFILLER_86_595 VSS VDD FILLER2
X_12850_ _13010_/A _13010_/B VDD VSS _14266_/B XNOR2X1
XFILLER_61_407 VDD VSS DECAPHV8
X_11801_ _11801_/A _11801_/B _11801_/C _11801_/D VDD VSS _14167_/B AOAI211X1
X_12781_ _12781_/A _12781_/B _12781_/C _12781_/D VDD VSS wire27/A AOI31X1
X_14520_ _18519_/Q _18551_/Q VDD VSS _14521_/B XOR2X1
XFILLER_14_323 VSS VDD FILLER2
XFILLER_25_40 VDD VSS FILLER4
XFILLER_26_194 VDD VSS FILLER1
X_11732_ _11732_/A _11732_/B _14315_/B VDD VSS _11733_/B MIN3X1
XFILLER_14_367 VSS VDD FILLER2
XTAP_TAPCELL_ROW_80_980 VDD VSS WELLTAP
X_11663_ _18276_/Q _11663_/B _14223_/B VDD VSS _14252_/B XNOR3X1
Xclkbuf_leaf_3__002_ clkload25/A VDD VSS _18271_/CK BUFX12
X_14451_ _14451_/A _14451_/B VDD VSS _18474_/D NOR2X1
XFILLER_30_849 VDD VSS FILLER1
XTAP_TAPCELL_ROW_99_1209 VDD VSS WELLTAP
X_10614_ _17883_/Q _10614_/B _10614_/C VDD VSS _10620_/A AOI21X1
X_17170_ _18992_/Q _17232_/B VDD VSS _17176_/B NOR2BX1
X_14382_ _14389_/A _14382_/B VDD VSS _18411_/D NOR2X1
X_13402_ _13405_/A _13405_/B _13405_/D _13405_/C VDD VSS _14157_/B AO211X2
X_11594_ _11594_/A _11594_/B _11594_/C VDD VSS _14251_/B XNOR3X1
X_16121_ _16112_/B _16121_/B _16121_/C VDD VSS _16194_/A NOR3BX1
X_13333_ _13511_/A _13511_/B VDD VSS _13346_/C _13511_/C NAND3X1
XFILLER_41_72 VDD VSS FILLER4
X_10545_ _10700_/A _10700_/B VDD VSS _10698_/B XNOR2X1
XFILLER_109_962 VSS VDD FILLER2
XFILLER_127_269 VDD VSS DECAPHV8
X_10476_ _17864_/Q _10476_/B VDD VSS _10477_/C OR2X2
X_13264_ _18396_/Q _14365_/B VDD VSS _13352_/A NAND2X1
X_16052_ _18812_/Q _18704_/Q VDD VSS _16053_/B XOR2X1
XFILLER_123_420 VSS VDD FILLER2
X_12215_ _12215_/A _14200_/B VDD VSS _12308_/A OR2X2
X_13195_ _13195_/A _13195_/B _13195_/C _13195_/D VDD VSS _14210_/B OAOI211X1
X_15003_ _18622_/Q _19000_/Q VDD VSS _15009_/B NAND2X1
XFILLER_123_464 VDD VSS FILLER1
XFILLER_124_987 VDD VSS FILLER4
XFILLER_97_816 VDD VSS FILLER4
XFILLER_97_827 VSS VDD FILLER2
XFILLER_9_1108 VDD VSS FILLER1
X_12146_ _12146_/A _12146_/B _12146_/C _12146_/D VDD VSS _12331_/A OAOI211X1
XFILLER_116_1039 VDD VSS FILLER1
XFILLER_111_648 VSS VDD FILLER2
XFILLER_1_282 VDD VSS DECAPHV32
XFILLER_2_44 VSS VDD FILLER2
X_12077_ _12077_/A _12077_/B _12077_/C VDD VSS _12080_/A OA21X2
X_16954_ _16954_/A _16959_/B VDD VSS _16956_/B XOR2X1
XFILLER_110_158 VDD VSS FILLER4
XFILLER_77_584 VSS VDD FILLER2
XFILLER_92_510 VDD VSS FILLER1
X_11028_ _11032_/A _11028_/B VDD VSS _11164_/B XNOR2X1
X_16885_ _16973_/A _16885_/B _16885_/C VDD VSS _18927_/D OAI21X1
X_15905_ _15945_/A _15945_/C VDD VSS _15906_/B XNOR2X1
XFILLER_65_735 VDD VSS FILLER1
XTAP_TAPCELL_ROW_108_1316 VDD VSS WELLTAP
X_18624_ _19004_/CK _18624_/D _18624_/Q VDD VSS DFFQX1
X_15836_ _18834_/Q _18672_/Q VDD VSS _15838_/C XOR2X1
XFILLER_18_662 VSS VDD FILLER2
XFILLER_37_459 VDD VSS FILLER4
XFILLER_53_908 VDD VSS FILLER1
XFILLER_17_150 VDD VSS FILLER1
XFILLER_64_278 VDD VSS FILLER4
XFILLER_92_587 VDD VSS FILLER1
X_12979_ _12979_/A _12979_/B _12979_/C _12979_/D VDD VSS _13195_/A OAOI211X1
X_18555_ clkload7/A _18555_/D _18555_/Q VDD VSS DFFQX1
X_15767_ _18860_/Q _18861_/Q _18862_/Q VDD VSS _15785_/C OAI21X1
XFILLER_127_1113 VSS VDD FILLER2
XFILLER_127_1135 VDD VSS FILLER1
XFILLER_21_805 VSS VDD FILLER2
XFILLER_33_654 VDD VSS FILLER1
X_18486_ _18514_/CK _18486_/D _18486_/Q VDD VSS DFFQX1
X_17506_ _17561_/C _17741_/Q VDD VSS _17709_/D AND2X1
X_15698_ _18885_/Q _15736_/B VDD VSS _15699_/C NAND2X1
X_14718_ _14723_/A _14723_/B _17229_/A VDD VSS _14719_/C OAI21X1
XFILLER_32_142 VDD VSS FILLER1
XFILLER_60_473 VDD VSS FILLER1
XFILLER_75_1078 VDD VSS DECAPHV8
XTAP_TAPCELL_ROW_50_619 VDD VSS WELLTAP
Xclkbuf_leaf_22__001_ clkbuf_2_1__f__001_/Y VDD VSS _17867_/CK BUFX12
X_17437_ _17561_/C _17437_/B VDD VSS _17644_/D AND2X1
X_14649_ _18546_/Q _18578_/Q VDD VSS _14650_/B XNOR2X1
XANTENNA_16 _17536_/D VDD VSS ANTENNA2
XFILLER_119_737 VSS VDD FILLER2
X_17368_ _17434_/A _17368_/B VDD VSS _17579_/D AND2X1
XFILLER_9_371 VDD VSS FILLER1
XTAP_TAPCELL_ROW_119_1445 VDD VSS WELLTAP
XTAP_TAPCELL_ROW_30_376 VDD VSS WELLTAP
X_17299_ _17323_/A _17299_/B VDD VSS _19016_/D NOR2X1
X_16319_ _18792_/Q _18738_/Q VDD VSS _16321_/D XOR2X1
XFILLER_63_0 VDD VSS DECAPHV32
XTAP_TAPCELL_ROW_132_1601 VDD VSS WELLTAP
X_19038_ _19038_/CK _19038_/D _19038_/Q VDD VSS DFFQX1
Xclkbuf_leaf_37__001_ clkload73/A VDD VSS _17680_/CK BUFX12
XFILLER_115_921 VSS VDD FILLER2
XFILLER_114_464 VSS VDD FILLER2
XFILLER_102_615 VSS VDD FILLER2
XFILLER_99_175 VDD VSS DECAPHV8
XFILLER_130_968 VDD VSS FILLER1
XFILLER_68_540 VSS VDD FILLER2
XTAP_TAPCELL_ROW_58_719 VDD VSS WELLTAP
XFILLER_55_201 VDD VSS FILLER1
X_09624_ _09596_/A _09624_/B _09624_/C VDD VSS _09627_/B AOI2B1X1
XFILLER_43_407 VDD VSS DECAPHV8
XTAP_TAPCELL_ROW_38_476 VDD VSS WELLTAP
X_09555_ _17684_/Q _17479_/B VDD VSS _09556_/C NOR2X1
XFILLER_70_248 VSS VDD FILLER2
X_09486_ _09497_/A _09497_/B VDD VSS _17375_/B XNOR2X1
XFILLER_24_687 VSS VDD FILLER2
XFILLER_62_49 VDD VSS DECAPHV32
XFILLER_51_495 VDD VSS FILLER1
XFILLER_109_269 VDD VSS DECAPHV8
XFILLER_124_206 VDD VSS DECAPHV16
X_10330_ _10330_/A _10330_/B _10330_/C VDD VSS _10331_/B AOI21X1
X_10261_ _17835_/Q VDD VSS _10262_/A INVX1
XFILLER_127_64 VDD VSS DECAPHV16
X_12000_ _18412_/Q VDD VSS _12202_/A INVX1
X_10192_ _10192_/A _10370_/B _10192_/C _10192_/D VDD VSS _10385_/A AOAI211X1
XFILLER_87_871 VDD VSS DECAPHV8
X_13951_ _18959_/Q _14012_/B VDD VSS _13955_/B NOR2BX1
XFILLER_59_584 VDD VSS DECAPHV16
X_12902_ _12902_/A _14150_/B _12902_/C _12902_/D VDD VSS _13191_/B AOAI211X1
XFILLER_19_459 VSS VDD FILLER2
XFILLER_28_960 VDD VSS FILLER1
XFILLER_62_716 VDD VSS DECAPHV16
X_16670_ _16711_/A _16670_/B _16670_/C VDD VSS _16678_/C OAI21X1
X_13882_ _18511_/Q _13920_/A _13920_/B VDD VSS _13884_/C XNOR3X1
X_12833_ _12843_/A _14328_/B _12843_/C VDD VSS _14329_/C NOR3X1
X_15621_ _15621_/A _15621_/B _15621_/C VDD VSS _15640_/B OAI21X1
XFILLER_15_654 VDD VSS DECAPHV32
X_12764_ _13089_/B _14150_/C _18210_/Q VDD VSS _12765_/D AND3BX1
X_18340_ _18340_/CK _18340_/D _18340_/Q VDD VSS DFFQX1
X_15552_ _18873_/Q _15563_/C VDD VSS _15553_/B XNOR2X1
XFILLER_43_985 VDD VSS DECAPHV8
XFILLER_70_782 VSS VDD FILLER2
XTAP_TAPCELL_ROW_103_1257 VDD VSS WELLTAP
XTAP_TAPCELL_ROW_7_98 VDD VSS WELLTAP
X_11715_ _18278_/Q _11835_/B _14225_/B VDD VSS _14285_/B XNOR3X1
X_18271_ _18271_/CK _18271_/D _18271_/Q VDD VSS DFFQX1
X_15483_ _15483_/A _15550_/B VDD VSS _15599_/C NAND2X1
X_14503_ _18515_/Q _18547_/Q VDD VSS _14507_/A NAND2X1
X_12695_ _12718_/A _12827_/A _14359_/B VDD VSS _12713_/C XNOR3X1
X_17222_ _19001_/Q _17287_/B _17236_/A VDD VSS _17223_/B AOI21X1
XFILLER_52_93 VSS VDD FILLER2
X_11646_ _11666_/A _11738_/B _14224_/B VDD VSS _11735_/C XNOR3X1
X_14434_ _14440_/A _14434_/B VDD VSS _18458_/D NOR2X1
XFILLER_128_556 VDD VSS DECAPHV8
XFILLER_7_831 VSS VDD FILLER2
XTAP_TAPCELL_ROW_0_9 VDD VSS WELLTAP
X_11577_ _18223_/Q VDD VSS _11579_/A INVX1
X_17153_ _17156_/A _17156_/B VDD VSS _17154_/B XNOR2X1
X_14365_ _14423_/A _14365_/B VDD VSS _18396_/D AND2X1
XFILLER_116_729 VSS VDD FILLER2
XFILLER_122_1087 VDD VSS DECAPHV32
XFILLER_128_578 VDD VSS DECAPHV8
X_10528_ _17872_/Q _10532_/B VDD VSS _10544_/A NAND2X1
X_17084_ _17084_/A _17087_/B VDD VSS _17085_/B XOR2X1
X_16104_ _16104_/A _16104_/B _16104_/C _16104_/D VDD VSS _16142_/B AND4X2
X_14296_ _14296_/A _14296_/B _14296_/C VDD VSS _18338_/D NOR3X1
X_13316_ _14126_/A _14126_/B _13316_/C VDD VSS _13405_/C AOI21X1
XFILLER_108_280 VDD VSS FILLER1
XFILLER_109_781 VSS VDD FILLER2
X_13247_ _18475_/Q VDD VSS _13254_/A INVX1
X_16035_ _18785_/Q _18731_/Q VDD VSS _16036_/A XNOR2X1
XFILLER_124_740 VDD VSS DECAPHV8
X_10459_ _10462_/C _10459_/B VDD VSS _10642_/B XNOR2X1
XTAP_TAPCELL_ROW_114_1386 VDD VSS WELLTAP
X_13178_ _13178_/A _13178_/B _13178_/C _13178_/D VDD VSS _13417_/A OAOI211X1
XFILLER_112_968 VDD VSS FILLER1
XFILLER_69_348 VSS VDD FILLER2
X_12129_ _14230_/A _14230_/B VDD VSS _12169_/B NOR2X1
X_17986_ _18011_/CK _17986_/D _17986_/Q VDD VSS DFFQX1
XFILLER_38_702 VDD VSS FILLER1
XFILLER_81_1060 VDD VSS FILLER4
X_16937_ _18932_/Q _16972_/B VDD VSS _16938_/C NAND2X1
XFILLER_42_1055 VDD VSS FILLER1
XFILLER_77_381 VDD VSS DECAPHV16
XFILLER_26_908 VDD VSS FILLER1
XFILLER_26_919 VSS VDD FILLER2
XFILLER_92_340 VDD VSS FILLER4
X_16868_ _16957_/A _16868_/B VDD VSS _16871_/A NOR2X1
XFILLER_19_993 VSS VDD FILLER2
XFILLER_25_429 VDD VSS FILLER1
XFILLER_92_362 VDD VSS FILLER4
XFILLER_92_373 VDD VSS DECAPHV8
X_18607_ _18641_/CK _18607_/D _18607_/Q VDD VSS DFFQX1
X_16799_ _16866_/A _16817_/A VDD VSS _16806_/A NOR2X1
X_15819_ _15811_/Y _15819_/B _15819_/C _15819_/D VDD VSS _15860_/B AOI2B2X1
XFILLER_18_481 VDD VSS FILLER4
XFILLER_34_941 VDD VSS FILLER4
XTAP_TAPCELL_ROW_35_435 VDD VSS WELLTAP
X_09340_ _09362_/C _09340_/B VDD VSS _17472_/B XNOR2X1
X_18538_ clkload2/A _18538_/D _18538_/Q VDD VSS DFFQX1
XFILLER_21_602 VSS VDD FILLER2
XFILLER_33_473 VDD VSS DECAPHV16
XTAP_TAPCELL_ROW_63_777 VDD VSS WELLTAP
X_09271_ _09271_/A _09271_/B _09271_/C VDD VSS _09297_/B AOI21X1
XFILLER_20_101 VSS VDD FILLER2
X_18469_ _18470_/CK _18469_/D _18469_/Q VDD VSS DFFQX1
XFILLER_134_504 VDD VSS FILLER1
XFILLER_103_902 VDD VSS DECAPHV8
XTAP_TAPCELL_ROW_7_105 VDD VSS WELLTAP
XFILLER_76_808 VSS VDD FILLER2
XFILLER_87_112 VDD VSS DECAPHV8
X_08986_ _17663_/Q VDD VSS _08992_/A INVX1
XFILLER_29_702 VSS VDD FILLER2
XFILLER_29_724 VDD VSS FILLER4
XFILLER_113_88 VDD VSS FILLER4
XFILLER_43_204 VDD VSS DECAPHV16
X_09607_ _17516_/B _17718_/Q _09607_/C VDD VSS _09636_/C OAI21X1
XFILLER_43_226 VDD VSS FILLER1
XFILLER_71_557 VDD VSS FILLER1
X_09538_ _09551_/B _09538_/B VDD VSS _17377_/B XNOR2X1
XFILLER_58_1084 VDD VSS FILLER1
XFILLER_11_112 VDD VSS FILLER4
XFILLER_19_1046 VDD VSS FILLER1
XFILLER_19_1068 VSS VDD FILLER2
XFILLER_40_944 VDD VSS FILLER4
XFILLER_52_793 VDD VSS FILLER1
X_09469_ _17585_/Q _17374_/B VDD VSS _09471_/A NAND2BX1
X_11500_ _11500_/A VDD VSS _11637_/B BUFX3
XFILLER_19_1079 VSS VDD FILLER2
X_12480_ _12587_/C _12481_/C _12588_/B VDD VSS _12480_/Y AOI21BX1
XFILLER_8_639 VDD VSS DECAPHV32
X_11431_ _11437_/A _11437_/B _11437_/D _11437_/C VDD VSS _14133_/C OAI211X1
X_11362_ _11362_/A _11362_/B _11389_/C _11362_/D VDD VSS _11446_/A OAOI211X1
X_14150_ _14149_/Y _14150_/B _14150_/C VDD VSS _18210_/D AND3BX1
XFILLER_125_515 VSS VDD FILLER2
XFILLER_125_548 VDD VSS FILLER4
X_10313_ _10314_/B _10314_/C _10475_/A VDD VSS _10315_/B OAI21X1
X_13101_ _18187_/Q _14123_/B VDD VSS _13206_/A AND2X1
X_11293_ _11349_/A _14043_/B _14043_/C VDD VSS _11294_/C NOR3X1
X_14081_ _14074_/Y _14081_/B _14081_/C VDD VSS _18148_/D AND3BX1
XFILLER_117_1112 VDD VSS FILLER4
X_10244_ _10247_/C _10244_/B VDD VSS _10433_/B XNOR2X1
X_13032_ _13033_/B _13032_/B _13032_/C VDD VSS _18043_/D OA21X2
XFILLER_26_1028 VDD VSS FILLER1
XFILLER_65_1088 VDD VSS FILLER1
X_10175_ _10338_/A _10338_/B _10343_/C _10175_/D VDD VSS _10351_/B OAOI211X1
X_17840_ _17867_/CK _17840_/D _17840_/Q VDD VSS DFFQX1
XFILLER_78_167 VSS VDD FILLER2
XFILLER_94_616 VSS VDD FILLER2
Xclkbuf_leaf_21__002_ clkload27/A VDD VSS _18313_/CK BUFX12
XFILLER_19_212 VDD VSS FILLER1
XFILLER_94_649 VDD VSS FILLER1
X_17771_ _19042_/CK _17771_/D _17771_/Q VDD VSS DFFQX1
X_14983_ _14983_/A _14983_/B _14983_/C _14983_/D VDD VSS _14988_/C AOAI211X1
XFILLER_47_565 VDD VSS FILLER1
X_16722_ _16723_/A _16723_/B _16723_/D _16723_/C VDD VSS _16751_/C OAOI211X1
X_13934_ _13932_/Y _13934_/B _17525_/B VDD VSS _18058_/D AND3BX1
XFILLER_19_267 VDD VSS FILLER4
XFILLER_74_384 VDD VSS FILLER4
XFILLER_90_822 VDD VSS DECAPHV8
Xclkbuf_leaf_5_clk_fs_regs clkbuf_leaf_5_clk_fs_regs/A VDD VSS clkload5/A BUFX12
X_16653_ _16684_/A _16653_/B VDD VSS _16657_/B XNOR2X1
X_13865_ _14462_/B _14462_/C _18484_/Q VDD VSS _13867_/C AOI21X1
XFILLER_50_708 VSS VDD FILLER2
X_12816_ _12923_/A _12923_/B _14419_/B VDD VSS _13036_/B MIN3X1
Xclkbuf_leaf_36__002_ clkload26/A VDD VSS _18448_/CK BUFX12
X_15604_ _15617_/A _15604_/B VDD VSS _16994_/A XOR2X1
XFILLER_16_974 VSS VDD FILLER2
XTAP_TAPCELL_ROW_32_405 VDD VSS WELLTAP
X_18323_ _18376_/CK _18323_/D _18323_/Q VDD VSS DFFQX1
X_16584_ _16584_/A VDD VSS _16587_/D INVX1
X_13796_ _13840_/A _14431_/B VDD VSS _13861_/B NOR2X1
XFILLER_15_495 VDD VSS FILLER4
XFILLER_37_1135 VDD VSS FILLER1
XFILLER_63_92 VDD VSS FILLER1
XTAP_TAPCELL_ROW_60_736 VDD VSS WELLTAP
X_12747_ _12962_/A _12962_/B VDD VSS _14206_/B XNOR2X1
X_15535_ _15695_/A _15638_/B _15535_/C VDD VSS _15540_/C OAI21X1
XFILLER_129_810 VDD VSS FILLER1
XFILLER_8_32 VDD VSS DECAPHV8
X_12678_ _18130_/Q _12678_/B _12678_/C VDD VSS _12680_/B XNOR3X1
X_18254_ _18309_/CK _18254_/D _18254_/Q VDD VSS DFFQX1
X_15466_ _18902_/Q _15466_/B _18903_/Q VDD VSS _15467_/B AOI21X1
XTAP_TAPCELL_ROW_12_162 VDD VSS WELLTAP
X_11629_ _11635_/A _11635_/B _11686_/C VDD VSS _14079_/C NOR3X1
X_18185_ _18250_/CK _18185_/D _18185_/Q VDD VSS DFFQX1
X_17205_ _17205_/A _17205_/B VDD VSS _17216_/A NAND2X1
X_14417_ _14440_/A _14417_/B VDD VSS _18443_/D NOR2X1
XTAP_TAPCELL_ROW_116_1415 VDD VSS WELLTAP
XTAP_TAPCELL_ROW_40_493 VDD VSS WELLTAP
X_17136_ _18022_/Q _17139_/B VDD VSS _17140_/B XNOR2X1
X_15397_ _18916_/Q _15457_/C VDD VSS _15397_/Y XNOR2X1
X_14348_ _14378_/A _14348_/B VDD VSS _18383_/D NOR2X1
X_17067_ _18009_/Q _17071_/B VDD VSS _17069_/C XNOR2X1
X_14279_ _14313_/A _14279_/B VDD VSS _18324_/D NOR2X1
XFILLER_103_209 VDD VSS DECAPHV8
XFILLER_112_710 VDD VSS FILLER4
XFILLER_131_529 VDD VSS FILLER1
X_16018_ _16016_/Y _16018_/B _16018_/C VDD VSS _16056_/D OR3BX1
XFILLER_112_732 VDD VSS FILLER4
XFILLER_69_112 VDD VSS FILLER1
XFILLER_97_432 VDD VSS FILLER4
XFILLER_100_905 VDD VSS FILLER1
XFILLER_26_0 VDD VSS DECAPHV32
XFILLER_58_819 VSS VDD FILLER2
XFILLER_100_938 VDD VSS FILLER1
XFILLER_38_510 VDD VSS FILLER1
XFILLER_84_137 VSS VDD FILLER2
XFILLER_85_649 VSS VDD FILLER2
XTAP_TAPCELL_ROW_68_836 VDD VSS WELLTAP
X_17969_ _18016_/CK _17969_/D _17969_/Q VDD VSS DFFQX1
XFILLER_66_841 VDD VSS FILLER1
XTAP_TAPCELL_ROW_127_1544 VDD VSS WELLTAP
XFILLER_93_682 VDD VSS FILLER4
XFILLER_53_557 VDD VSS FILLER1
XFILLER_81_844 VSS VDD FILLER2
XTAP_TAPCELL_ROW_48_593 VDD VSS WELLTAP
XFILLER_81_888 VDD VSS FILLER1
X_09323_ _09330_/B _09323_/B VDD VSS _17335_/B XOR2X1
XFILLER_21_421 VDD VSS DECAPHV8
XFILLER_22_933 VDD VSS FILLER4
XFILLER_22_944 VDD VSS FILLER4
XFILLER_33_270 VDD VSS FILLER1
X_09254_ _17738_/Q _17706_/Q VDD VSS _09283_/A XNOR2X1
XFILLER_18_1090 VDD VSS FILLER1
X_09185_ _17639_/Q _09200_/A VDD VSS _09186_/B XNOR2X1
XFILLER_134_323 VSS VDD FILLER2
XFILLER_108_44 VSS VDD FILLER2
XTAP_TAPCELL_ROW_91_1109 VDD VSS WELLTAP
XFILLER_122_529 VSS VDD FILLER2
XFILLER_88_421 VDD VSS DECAPHV16
XFILLER_0_358 VSS VDD FILLER2
XFILLER_102_231 VDD VSS FILLER1
XFILLER_89_977 VDD VSS FILLER4
XFILLER_124_32 VDD VSS DECAPHV8
XFILLER_130_595 VSS VDD FILLER2
XFILLER_69_690 VDD VSS FILLER1
XFILLER_76_638 VDD VSS FILLER1
X_08969_ _08972_/A _08972_/B _17455_/A VDD VSS _08970_/C OAI21X1
XFILLER_25_1072 VDD VSS FILLER1
XFILLER_75_148 VSS VDD FILLER2
X_11980_ _12007_/A _12007_/B _14290_/B VDD VSS _14321_/B XNOR3X1
XFILLER_17_727 VDD VSS DECAPHV8
X_10931_ _17945_/Q _10931_/B VDD VSS _10935_/A NOR2X1
XFILLER_16_237 VDD VSS FILLER1
XFILLER_17_52 VSS VDD FILLER2
XFILLER_56_395 VDD VSS FILLER4
XFILLER_71_310 VDD VSS FILLER4
XFILLER_17_96 VDD VSS FILLER1
X_10862_ _17932_/Q VDD VSS _10864_/A INVX1
X_13650_ _13777_/B _14493_/C _18506_/Q VDD VSS _13660_/D AND3BX1
XFILLER_13_933 VDD VSS FILLER4
XFILLER_24_270 VDD VSS DECAPHV8
XFILLER_31_229 VDD VSS DECAPHV8
XTAP_TAPCELL_ROW_100_1216 VDD VSS WELLTAP
X_10793_ _10844_/A _10928_/B VDD VSS _17944_/D NOR2X1
X_12601_ _18390_/Q _12601_/B _12601_/C VDD VSS _14387_/B XNOR3X1
X_13581_ _13660_/B _15309_/A _13581_/C VDD VSS _18049_/D AND3BX1
X_12532_ _18234_/Q _14175_/B VDD VSS _12652_/A AND2X1
X_15320_ _17182_/D _18059_/Q VDD VSS _18858_/D AND2X1
XFILLER_129_128 VDD VSS DECAPHV32
XFILLER_130_0 VDD VSS DECAPHV32
XFILLER_13_999 VDD VSS DECAPHV8
XFILLER_40_774 VDD VSS FILLER4
X_12463_ _18208_/Q _12536_/B _12552_/C VDD VSS _12742_/B XNOR3X1
X_15251_ _15307_/A _18819_/Q VDD VSS _18792_/D AND2X1
XTAP_TAPCELL_ROW_4_66 VDD VSS WELLTAP
X_11414_ _18272_/Q _14216_/B VDD VSS _11415_/B OR2X2
X_14202_ _14198_/Y _14202_/B _14202_/C VDD VSS _18258_/D AND3BX1
XFILLER_32_1065 VDD VSS FILLER4
X_12394_ _14079_/A _12394_/B _12394_/C VDD VSS _18037_/D NOR3X1
X_15182_ _16984_/A _18751_/Q VDD VSS _18724_/D AND2X1
X_11345_ _11345_/A _11345_/B _11345_/C _11345_/D VDD VSS _11388_/A AOAI211X1
X_14133_ _14108_/Y _14133_/B _14133_/C VDD VSS _18195_/D AND3BX1
XFILLER_98_229 VSS VDD FILLER2
X_11276_ _11326_/A _11326_/B _14071_/B VDD VSS _11383_/A MIN3X1
X_18941_ _18951_/CK _18941_/D _18941_/Q VDD VSS DFFQX1
X_14064_ _14064_/A _14064_/B _17154_/A VDD VSS _18132_/D OA21X2
XFILLER_106_581 VSS VDD FILLER2
XTAP_TAPCELL_ROW_111_1345 VDD VSS WELLTAP
X_10227_ _10232_/A _10227_/B _10227_/C VDD VSS _10415_/C XNOR3X1
X_13015_ _13015_/A VDD VSS _13234_/B BUFX3
XFILLER_121_551 VSS VDD FILLER2
XTAP_TAPCELL_ROW_111_1356 VDD VSS WELLTAP
X_18872_ _18940_/CK _18872_/D _18872_/Q VDD VSS DFFQX1
XFILLER_48_830 VDD VSS DECAPHV16
XFILLER_58_81 VDD VSS DECAPHV32
XFILLER_67_627 VDD VSS DECAPHV8
XFILLER_67_649 VSS VDD FILLER2
X_10158_ _17821_/Q _10158_/B _10158_/C VDD VSS _10343_/C XNOR3X1
X_17823_ _17901_/CK _17823_/D _17823_/Q VDD VSS DFFQX1
X_10089_ _17813_/Q VDD VSS _10106_/A INVX1
X_17754_ clkload3/A _17754_/D _17754_/Q VDD VSS DFFQX1
X_14966_ _15093_/A _14966_/B VDD VSS _18614_/D NOR2X1
X_16705_ _16706_/A _16706_/B _16706_/C VDD VSS _16708_/B NOR3X1
X_13917_ _13917_/A _13917_/B VDD VSS _14464_/B XNOR2X1
XFILLER_62_332 VDD VSS FILLER1
XFILLER_63_844 VDD VSS FILLER1
X_17685_ _17716_/CK _17685_/D _17685_/Q VDD VSS DFFQX1
X_14897_ _14900_/A _14900_/B _17266_/C VDD VSS _14898_/C OAI21X1
XTAP_TAPCELL_ROW_17_221 VDD VSS WELLTAP
XTAP_TAPCELL_ROW_45_563 VDD VSS WELLTAP
X_16636_ _18915_/Q _16641_/B VDD VSS _16638_/A XOR2X1
X_13848_ _13876_/A _13876_/C VDD VSS _13849_/C NOR2X1
XFILLER_16_793 VDD VSS DECAPHV8
XFILLER_62_387 VDD VSS DECAPHV8
XTAP_TAPCELL_ROW_73_894 VDD VSS WELLTAP
X_16567_ _16567_/A VDD VSS _16866_/A BUFX3
X_13779_ _18508_/Q _14495_/B VDD VSS _13853_/A AND2X1
XFILLER_31_752 VDD VSS FILLER1
XTAP_TAPCELL_ROW_122_1485 VDD VSS WELLTAP
X_18306_ _18337_/CK _18306_/D _18306_/Q VDD VSS DFFQX1
X_15518_ _15526_/A _15518_/B _15518_/C _16782_/D VDD VSS _15519_/C AOI211X1
XFILLER_30_251 VDD VSS DECAPHV16
X_18237_ _18292_/CK _18237_/D _18237_/Q VDD VSS DFFQX1
X_16498_ _18851_/Q _18689_/Q VDD VSS _16499_/B XNOR2X1
X_15449_ _16782_/D _15575_/B _15449_/C _15449_/D VDD VSS _15455_/C AOI22X1
XFILLER_117_835 VSS VDD FILLER2
XFILLER_129_695 VDD VSS FILLER1
X_18168_ _18195_/CK _18168_/D _18168_/Q VDD VSS DFFQX1
XFILLER_116_345 VDD VSS FILLER4
X_18099_ _18978_/CK _18099_/D _18099_/Q VDD VSS DFFQX1
X_17119_ _18018_/Q _17119_/B VDD VSS _17122_/A NOR2BX1
XFILLER_89_229 VDD VSS FILLER1
X_09941_ _10138_/A _10147_/B VDD VSS _10151_/C _10139_/A NAND3X1
X_09872_ _09887_/A _09881_/C _09887_/B VDD VSS _10078_/A NOR3X1
XFILLER_85_468 VDD VSS DECAPHV8
XFILLER_39_885 VDD VSS FILLER1
XFILLER_54_822 VDD VSS FILLER1
XFILLER_53_321 VDD VSS DECAPHV8
XFILLER_93_490 VDD VSS DECAPHV16
XTAP_TAPCELL_ROW_88_1071 VDD VSS WELLTAP
XFILLER_41_516 VDD VSS FILLER1
XFILLER_55_1010 VDD VSS FILLER1
XFILLER_55_1065 VDD VSS FILLER1
X_09306_ _17643_/Q _17436_/B VDD VSS _09307_/C NOR2X1
XFILLER_16_1027 VDD VSS FILLER1
XFILLER_55_1087 VDD VSS FILLER1
XFILLER_70_49 VDD VSS DECAPHV32
X_09237_ _17577_/Q _17366_/B VDD VSS _09239_/C XNOR2X1
XFILLER_6_918 VDD VSS DECAPHV32
XFILLER_119_32 VDD VSS DECAPHV32
X_09168_ _09168_/A _09171_/B VDD VSS _09169_/B XNOR2X1
XFILLER_135_632 VDD VSS FILLER1
XFILLER_135_654 VDD VSS DECAPHV16
XFILLER_5_439 VDD VSS DECAPHV16
X_09099_ _09099_/A _09099_/B _09099_/C VDD VSS _09125_/B AO21X2
XFILLER_134_142 VDD VSS DECAPHV32
X_11130_ _11132_/C _11130_/B VDD VSS _17076_/B XNOR2X1
XFILLER_0_133 VSS VDD FILLER2
XFILLER_103_540 VSS VDD FILLER2
XFILLER_135_64 VDD VSS DECAPHV16
XFILLER_27_1134 VSS VDD FILLER2
XFILLER_62_1025 VDD VSS FILLER1
X_11061_ _11066_/C _11061_/B VDD VSS _11192_/B XNOR2X1
XFILLER_114_1104 VDD VSS DECAPHV32
XFILLER_88_262 VDD VSS DECAPHV8
X_10012_ _09935_/Y _10222_/B _10220_/C VDD VSS _17827_/D AND3BX1
XFILLER_28_40 VDD VSS FILLER4
XFILLER_48_137 VSS VDD FILLER2
X_14820_ _18582_/Q _18614_/Q _14820_/C VDD VSS _14823_/B AOI21X1
XFILLER_29_351 VDD VSS DECAPHV16
XFILLER_91_405 VDD VSS FILLER1
XFILLER_92_939 VDD VSS FILLER1
X_11963_ _18977_/Q _18098_/Q VDD VSS _12054_/D NOR2X1
X_14751_ _14751_/A _14751_/B _14751_/C VDD VSS _14758_/C OA21X2
XFILLER_45_866 VSS VDD FILLER2
X_10914_ _10914_/A _11052_/B VDD VSS _17968_/D NOR2X1
X_11894_ _18358_/Q _14350_/A _14349_/B VDD VSS _11983_/C XNOR3X1
X_17470_ _17479_/A _17470_/B VDD VSS _17675_/D NOR2X1
X_14682_ _14684_/A _14684_/B _14684_/C _14682_/D VDD VSS _18553_/D AOI31X1
X_13702_ _13702_/A _14280_/B VDD VSS _13707_/B XNOR2X1
XFILLER_72_696 VDD VSS FILLER1
X_10845_ _10922_/A VDD VSS _10914_/A BUFX3
X_16421_ _18909_/Q _16422_/B VDD VSS _16423_/C NOR2X1
X_13633_ _18324_/Q _14279_/B VDD VSS _13688_/C XNOR2X1
XTAP_TAPCELL_ROW_42_522 VDD VSS WELLTAP
XTAP_TAPCELL_ROW_70_853 VDD VSS WELLTAP
XTAP_TAPCELL_ROW_70_864 VDD VSS WELLTAP
X_16352_ _18846_/Q _18684_/Q VDD VSS _16405_/A NAND2X1
XFILLER_12_251 VSS VDD FILLER2
XFILLER_13_763 VDD VSS DECAPHV8
XFILLER_9_734 VDD VSS DECAPHV8
X_10776_ _17914_/Q VDD VSS _10777_/A INVX1
X_15303_ _15304_/A _18044_/Q VDD VSS _18843_/D AND2X1
X_13564_ _18271_/Q _14215_/B VDD VSS _13628_/D XNOR2X1
XFILLER_121_1119 VDD VSS DECAPHV16
XFILLER_8_222 VDD VSS DECAPHV8
X_12515_ _12629_/A _12530_/B _12530_/C VDD VSS _14234_/C OR3BX1
X_16283_ _16333_/A _16283_/B _16283_/C VDD VSS _16284_/D OAI21X1
X_13495_ _18270_/Q _13566_/B _13495_/C VDD VSS _13559_/B XOR3X1
XFILLER_126_621 VDD VSS FILLER4
XFILLER_8_266 VDD VSS DECAPHV32
X_12446_ _12446_/A _12446_/B _12446_/C _12446_/D VDD VSS _12455_/B OAOI211X1
X_18022_ _18024_/CK _18022_/D _18022_/Q VDD VSS DFFQX1
X_15234_ _15286_/A _18802_/Q VDD VSS _18775_/D AND2X1
X_12377_ _14293_/A _14293_/B _14293_/C _12377_/D VDD VSS _12499_/A OAOI211X1
X_15165_ _15250_/A _18735_/Q VDD VSS _18708_/D AND2X1
XFILLER_113_304 VDD VSS DECAPHV8
XFILLER_114_805 VDD VSS FILLER1
X_11328_ _18166_/Q _11328_/B _11328_/C VDD VSS _11342_/C MIN3X1
X_14116_ _14108_/Y _14116_/B _14116_/C VDD VSS _18180_/D AND3BX1
XFILLER_119_1026 VSS VDD FILLER2
XFILLER_5_88 VDD VSS FILLER4
Xclkbuf_leaf_4__000_ clkload110/A VDD VSS _18821_/CK BUFX12
X_15096_ _18642_/Q _19020_/Q VDD VSS _15097_/B XNOR2X1
XFILLER_113_359 VDD VSS FILLER1
XFILLER_69_80 VDD VSS DECAPHV8
X_11259_ _18112_/Q _11259_/B VDD VSS _11281_/C _11259_/C NAND3X1
X_18924_ _18934_/CK _18924_/D _18924_/Q VDD VSS DFFQX1
X_14047_ _14053_/A _14047_/B VDD VSS _18116_/D NOR2X1
XFILLER_39_115 VDD VSS FILLER4
XFILLER_41_1109 VDD VSS FILLER4
XFILLER_68_925 VSS VDD FILLER2
X_18855_ _18856_/CK _18855_/D _18855_/Q VDD VSS DFFQX1
XFILLER_39_126 VDD VSS FILLER4
XFILLER_67_468 VSS VDD FILLER2
XFILLER_94_243 VDD VSS FILLER1
XFILLER_95_766 VDD VSS DECAPHV16
XTAP_TAPCELL_ROW_78_953 VDD VSS WELLTAP
X_17806_ _17851_/CK _17806_/D _17806_/Q VDD VSS DFFQX1
X_18786_ _18787_/CK _18786_/D _18786_/Q VDD VSS DFFQX1
X_15998_ _18039_/Q _18649_/Q VDD VSS _16042_/D NAND2X1
XTAP_TAPCELL_ROW_124_1503 VDD VSS WELLTAP
X_17737_ clkload5/A _17737_/D _17737_/Q VDD VSS DFFQX1
X_14949_ _14949_/A _14949_/B VDD VSS _14950_/B XNOR2X1
X_17668_ _17701_/CK _17668_/D _17668_/Q VDD VSS DFFQX1
XFILLER_35_398 VSS VDD FILLER2
XFILLER_36_899 VSS VDD FILLER2
XFILLER_62_173 VDD VSS FILLER4
XFILLER_78_1098 VDD VSS DECAPHV8
XFILLER_90_471 VDD VSS FILLER1
X_16619_ _16620_/A _16620_/B _16620_/D _16620_/C VDD VSS _16646_/C OA211X2
XFILLER_126_1019 VDD VSS FILLER1
XFILLER_93_0 VDD VSS DECAPHV32
X_17599_ _19024_/CK _17599_/D _17599_/Q VDD VSS DFFQX1
XFILLER_102_1030 VDD VSS FILLER1
X_09022_ _17598_/Q _17388_/B VDD VSS _09047_/A NOR2BX1
XFILLER_102_1052 VDD VSS FILLER1
XTAP_TAPCELL_ROW_135_1643 VDD VSS WELLTAP
XFILLER_116_142 VDD VSS DECAPHV32
XFILLER_132_602 VSS VDD FILLER2
XFILLER_86_700 VDD VSS FILLER4
X_09924_ _10117_/B _10128_/B VDD VSS _10131_/B XNOR2X1
XFILLER_131_189 VDD VSS DECAPHV32
XFILLER_59_925 VDD VSS FILLER4
XFILLER_86_711 VDD VSS FILLER4
X_09855_ _17781_/Q _09855_/B VDD VSS _10060_/B XOR2X1
XFILLER_100_543 VSS VDD FILLER2
XFILLER_100_587 VDD VSS FILLER1
XFILLER_85_265 VDD VSS FILLER4
X_09786_ _17759_/Q _17758_/Q VDD VSS _09787_/A _17760_/Q AND3X2
XFILLER_26_310 VDD VSS DECAPHV8
XFILLER_27_844 VDD VSS DECAPHV8
XFILLER_22_1086 VSS VDD FILLER2
XFILLER_57_1105 VDD VSS FILLER1
XFILLER_92_1007 VDD VSS FILLER1
XTAP_TAPCELL_ROW_28_349 VDD VSS WELLTAP
XFILLER_14_538 VSS VDD FILLER2
XFILLER_54_696 VDD VSS FILLER1
XFILLER_81_482 VDD VSS FILLER1
XFILLER_121_88 VDD VSS FILLER4
X_10630_ _10630_/A _10765_/B VDD VSS _17912_/D NOR2X1
XFILLER_10_700 VDD VSS DECAPHV32
XFILLER_22_571 VDD VSS FILLER1
XFILLER_128_919 VDD VSS DECAPHV32
X_10561_ _10561_/A _10561_/B _10561_/C VDD VSS _10565_/B OAI21X1
X_10492_ _10492_/A _10492_/B _10492_/C VDD VSS _10493_/C MIN3X1
X_12300_ _12301_/B _12380_/B _18336_/Q VDD VSS _12374_/B AOI21X1
X_13280_ _18371_/Q _14333_/B VDD VSS _14367_/A AND2X1
XFILLER_108_621 VDD VSS FILLER4
X_12231_ _18231_/Q _14172_/B VDD VSS _12334_/A AND2X1
XFILLER_108_687 VDD VSS DECAPHV8
XFILLER_5_269 VDD VSS DECAPHV8
XTAP_TAPCELL_ROW_1_34 VDD VSS WELLTAP
X_12162_ _12261_/A _12261_/B VDD VSS _12360_/C NOR2X1
XFILLER_111_819 VSS VDD FILLER2
X_11113_ _17981_/Q _11118_/B VDD VSS _11114_/B XNOR2X1
X_12093_ _12095_/B _12094_/B _14423_/A VDD VSS _12094_/C OAI21X1
X_16970_ _18937_/Q _16970_/B VDD VSS _16971_/B XNOR2X1
X_11044_ _11048_/A _11048_/B VDD VSS _11046_/A XNOR2X1
X_15921_ _15955_/A _15955_/B VDD VSS _15923_/B XNOR2X1
XFILLER_7_1058 VDD VSS DECAPHV32
X_18640_ clkload1/A _18640_/D _18640_/Q VDD VSS DFFQX1
XFILLER_49_468 VDD VSS FILLER4
XFILLER_92_714 VDD VSS FILLER4
X_15852_ _18806_/Q _18698_/Q VDD VSS _15855_/D NAND2X1
XFILLER_18_833 VDD VSS FILLER4
XFILLER_92_769 VSS VDD FILLER2
XTAP_TAPCELL_ROW_75_923 VDD VSS WELLTAP
X_12995_ _12999_/A _13108_/A VDD VSS _14066_/B XNOR2X1
X_18571_ clkload2/A _18571_/D _18571_/Q VDD VSS DFFQX1
X_15783_ _18860_/Q _16537_/A VDD VSS _15784_/B NOR2BX1
X_14803_ _18579_/Q _18611_/Q VDD VSS _14803_/Y NOR2X1
XFILLER_18_877 VDD VSS FILLER4
XFILLER_91_246 VDD VSS FILLER1
X_11946_ _12123_/A _12123_/B _12123_/C VDD VSS _11975_/B AOI21X1
X_17522_ _17523_/A _17756_/Q VDD VSS _17724_/D AND2X1
X_14734_ _18564_/Q _18596_/Q VDD VSS _14740_/B NAND2X1
XFILLER_72_471 VDD VSS FILLER1
XFILLER_73_983 VSS VDD FILLER2
XFILLER_73_994 VDD VSS DECAPHV8
X_17453_ _17453_/A _17453_/B VDD VSS _17659_/D AND2X1
XFILLER_33_869 VDD VSS FILLER4
XFILLER_60_633 VDD VSS FILLER4
XTAP_TAPCELL_ROW_106_1288 VDD VSS WELLTAP
XTAP_TAPCELL_ROW_55_680 VDD VSS WELLTAP
X_11877_ _18202_/Q _12023_/B _12023_/C VDD VSS _12123_/B XNOR3X1
X_16404_ _18848_/Q _18686_/Q VDD VSS _16407_/A XOR2X1
X_14665_ _18550_/Q _18582_/Q VDD VSS _14666_/B XOR2X1
X_10828_ _17926_/Q VDD VSS _10832_/A INVX1
X_17384_ _17453_/A _17384_/B VDD VSS _17594_/D AND2X1
X_14596_ _14598_/C _14596_/B _14596_/C VDD VSS _18534_/D AOI21X1
X_13616_ _13675_/A _14370_/B _13675_/C _13616_/D VDD VSS _13748_/A OAOI211X1
XFILLER_9_553 VDD VSS FILLER1
X_10759_ _11062_/A _10886_/B VDD VSS _17937_/D AND2X1
X_16335_ _16757_/A _16335_/B _16390_/B _16335_/D VDD VSS _16336_/C AOI31X1
X_13547_ _13547_/A _14398_/B _13598_/C _13547_/D VDD VSS _13673_/A OAOI211X1
XFILLER_9_586 VDD VSS DECAPHV32
X_16266_ _16604_/A _16266_/B _16266_/C _16711_/A VDD VSS _16267_/C OA211X2
X_18005_ _18025_/CK _18005_/D _18005_/Q VDD VSS DFFQX1
X_15217_ _15274_/A _18786_/Q VDD VSS _18759_/D AND2X1
X_13478_ _13488_/A _13488_/B _13488_/C VDD VSS _14245_/B OA21X2
XFILLER_99_302 VDD VSS FILLER1
X_12429_ _12429_/A _14145_/B VDD VSS _12525_/A OR2X2
X_16197_ _18815_/Q _18707_/Q VDD VSS _16250_/D AND2X1
XFILLER_126_495 VDD VSS FILLER1
X_15148_ _15318_/A _18718_/Q VDD VSS _18691_/D AND2X1
XFILLER_99_379 VDD VSS DECAPHV16
X_15079_ _15082_/B _15082_/C _15080_/B _17318_/C VDD VSS _15080_/D OAI31X1
XFILLER_113_178 VDD VSS FILLER1
XFILLER_113_189 VDD VSS FILLER4
XFILLER_68_700 VSS VDD FILLER2
XTAP_TAPCELL_ROW_130_1573 VDD VSS WELLTAP
XTAP_TAPCELL_ROW_130_1584 VDD VSS WELLTAP
X_18907_ _18913_/CK _18907_/D _18907_/Q VDD VSS DFFQX1
XFILLER_95_552 VDD VSS FILLER4
X_09640_ _09640_/A _09640_/B _09640_/C VDD VSS _09641_/B NOR3X1
X_18838_ _18838_/CK _18838_/D _18838_/Q VDD VSS DFFQX1
XFILLER_82_235 VDD VSS DECAPHV8
X_09571_ _09573_/A _09573_/B _09571_/C VDD VSS _17776_/D AOI21X1
X_18769_ _18850_/CK _18769_/D _18769_/Q VDD VSS DFFQX1
XFILLER_71_909 VDD VSS FILLER1
XTAP_TAPCELL_ROW_85_1041 VDD VSS WELLTAP
XFILLER_36_696 VDD VSS FILLER1
XFILLER_91_791 VSS VDD FILLER2
XTAP_TAPCELL_ROW_25_319 VDD VSS WELLTAP
XFILLER_17_1100 VDD VSS DECAPHV8
XFILLER_35_195 VSS VDD FILLER2
XFILLER_51_644 VDD VSS FILLER4
XFILLER_17_1133 VSS VDD FILLER2
XFILLER_51_677 VDD VSS FILLER4
XFILLER_136_215 VDD VSS DECAPHV8
XFILLER_118_941 VDD VSS FILLER4
X_09005_ _09018_/A _09018_/B VDD VSS _09006_/C NAND2X1
XFILLER_117_451 VDD VSS DECAPHV8
XFILLER_3_718 VDD VSS DECAPHV16
XTAP_TAPCELL_ROW_96_1170 VDD VSS WELLTAP
XFILLER_133_933 VDD VSS FILLER4
XFILLER_2_206 VDD VSS DECAPHV16
XFILLER_132_443 VDD VSS DECAPHV16
XFILLER_116_44 VSS VDD FILLER2
XFILLER_120_638 VSS VDD FILLER2
XFILLER_132_487 VSS VDD FILLER2
X_09907_ _17790_/Q _09926_/B VDD VSS _09914_/B XOR2X1
XFILLER_86_541 VDD VSS FILLER4
XFILLER_18_107 VSS VDD FILLER2
XFILLER_19_619 VDD VSS DECAPHV8
XFILLER_58_276 VDD VSS FILLER4
XFILLER_59_777 VDD VSS DECAPHV8
X_09838_ _17774_/Q _17775_/Q VDD VSS _09841_/B _09838_/C NAND3X1
XFILLER_100_373 VDD VSS FILLER1
XFILLER_132_32 VDD VSS DECAPHV8
XFILLER_73_235 VDD VSS FILLER4
X_09769_ _17724_/Q VDD VSS _09770_/B INVX1
X_11800_ _11800_/A _11800_/B _11800_/C _11800_/D VDD VSS _12013_/B AOAI211X1
XFILLER_15_836 VDD VSS FILLER1
XFILLER_61_419 VSS VDD FILLER2
X_12780_ _14064_/A _14064_/B _18132_/Q VDD VSS _12781_/D OA21X2
XFILLER_70_942 VSS VDD FILLER2
X_11731_ _11736_/A _11736_/B _11731_/C VDD VSS _14315_/B XNOR3X1
XFILLER_25_96 VDD VSS FILLER1
XFILLER_41_143 VDD VSS DECAPHV8
XFILLER_41_165 VSS VDD FILLER2
XFILLER_70_975 VDD VSS FILLER1
X_11662_ _18329_/Q _11662_/B _11731_/C VDD VSS _11717_/B MIN3X1
Xclkbuf_leaf_3__001_ clkload73/A VDD VSS _17851_/CK BUFX12
X_14450_ _14451_/A _14484_/B VDD VSS _18473_/D NOR2X1
XFILLER_128_705 VSS VDD FILLER2
XTAP_TAPCELL_ROW_80_981 VDD VSS WELLTAP
X_10613_ _10630_/A _10750_/B VDD VSS _17909_/D NOR2X1
X_11593_ _18328_/Q _11593_/B _11656_/C VDD VSS _11736_/B MIN3X1
X_14381_ _14389_/A _14381_/B VDD VSS _18410_/D NOR2X1
X_13401_ _14127_/B _18190_/Q VDD VSS _14157_/A NAND2BX1
XFILLER_10_530 VDD VSS DECAPHV16
XFILLER_22_390 VDD VSS FILLER4
XFILLER_6_501 VDD VSS DECAPHV8
X_10544_ _10544_/A _10544_/B _10544_/C _10544_/D VDD VSS _10700_/B AOAI211X1
X_16120_ _16120_/A VDD VSS _16567_/A BUFX3
X_13332_ _13356_/A _13332_/B _13444_/D VDD VSS _13511_/C XNOR3X1
XFILLER_10_585 VSS VDD FILLER2
XFILLER_108_462 VDD VSS FILLER4
XFILLER_6_578 VDD VSS DECAPHV16
X_10475_ _10475_/A _10475_/B _10475_/C VDD VSS _10483_/B XNOR3X1
X_13263_ _13278_/A _14394_/B _13278_/C VDD VSS _14395_/B OAI21X1
X_16051_ _16051_/A _16051_/B _16051_/C _16051_/D VDD VSS _16102_/A OAOI211X1
XFILLER_108_473 VDD VSS DECAPHV8
X_12214_ _14293_/A _14293_/B VDD VSS _12271_/B NOR2X1
X_13194_ _18240_/Q _13383_/A _13383_/B VDD VSS _13195_/D XNOR3X1
X_15002_ _18622_/Q _19000_/Q VDD VSS _15009_/C NOR2X1
XFILLER_29_1026 VDD VSS FILLER4
XFILLER_68_1097 VSS VDD FILLER2
X_12145_ _12145_/A _14143_/B _14142_/C VDD VSS _12146_/D NOR3X1
XFILLER_124_999 VDD VSS DECAPHV8
XFILLER_96_316 VSS VDD FILLER2
XFILLER_110_137 VSS VDD FILLER2
X_12076_ _12076_/A _14228_/B VDD VSS _12121_/A NOR2X1
X_16953_ _16943_/B _16953_/B _16953_/C VDD VSS _16959_/B AOI2B1X1
XFILLER_92_500 VDD VSS DECAPHV8
X_11027_ _11033_/A _11033_/B VDD VSS _11028_/B XNOR2X1
X_16884_ _18927_/Q _16972_/B VDD VSS _16885_/C NAND2X1
X_15904_ _15904_/A _15904_/B VDD VSS _15945_/C XNOR2X1
XFILLER_49_276 VSS VDD FILLER2
XFILLER_66_81 VDD VSS DECAPHV32
XTAP_TAPCELL_ROW_108_1317 VDD VSS WELLTAP
X_18623_ clkload9/A _18623_/D _18623_/Q VDD VSS DFFQX1
X_15835_ _18833_/Q _18671_/Q VDD VSS _15838_/D AND2X1
XFILLER_64_235 VDD VSS DECAPHV16
XFILLER_65_769 VSS VDD FILLER2
X_18554_ clkload8/A _18554_/D _18554_/Q VDD VSS DFFQX1
XFILLER_18_674 VDD VSS FILLER4
X_12978_ _13120_/B _14180_/C _18238_/Q VDD VSS _12979_/D AND3BX1
X_17505_ _17518_/A _17505_/B VDD VSS _17708_/D NOR2X1
X_15766_ _18862_/Q _15768_/B _15766_/C _15815_/C VDD VSS _15771_/A OAOI211X1
XFILLER_36_1008 VSS VDD FILLER2
X_11929_ _11929_/A _11929_/B _11929_/C _11929_/D VDD VSS _14197_/B OAOI211X1
X_18485_ _18514_/CK _18485_/D _18485_/Q VDD VSS DFFQX1
X_15697_ _15703_/B _15697_/B VDD VSS _17008_/A XNOR2X1
X_14717_ _18560_/Q _18592_/Q _14717_/C VDD VSS _14723_/B MIN3X1
XFILLER_21_828 VDD VSS DECAPHV8
XFILLER_32_165 VSS VDD FILLER2
Xclkbuf_leaf_22__000_ clkload110/A VDD VSS _18082_/CK BUFX12
X_17436_ _17445_/A _17436_/B VDD VSS _17643_/D NOR2X1
X_14648_ _18545_/Q _18577_/Q _14648_/C VDD VSS _14650_/A MIN3X1
XFILLER_32_176 VDD VSS FILLER1
X_17367_ _17533_/A _17367_/B _17367_/C VDD VSS _17578_/D NOR3X1
X_16318_ _16321_/A _16321_/B VDD VSS _16320_/B AND2X1
X_14579_ _18562_/Q VDD VSS _14729_/A INVX1
XFILLER_9_383 VDD VSS FILLER4
XFILLER_9_394 VDD VSS DECAPHV8
XTAP_TAPCELL_ROW_119_1446 VDD VSS WELLTAP
XTAP_TAPCELL_ROW_30_377 VDD VSS WELLTAP
X_17298_ _17300_/B _17298_/B VDD VSS _17299_/B XOR2X1
XTAP_TAPCELL_ROW_132_1602 VDD VSS WELLTAP
X_19037_ _19038_/CK _19037_/D _19037_/Q VDD VSS DFFQX1
X_16249_ _18816_/Q _18708_/Q VDD VSS _16250_/C AND2X1
XFILLER_115_933 VDD VSS DECAPHV16
XFILLER_56_0 VDD VSS DECAPHV32
XFILLER_86_1131 VDD VSS FILLER1
XFILLER_115_966 VDD VSS DECAPHV8
XFILLER_47_1115 VDD VSS FILLER1
XFILLER_87_305 VDD VSS FILLER4
XFILLER_88_839 VSS VDD FILLER2
XFILLER_99_165 VDD VSS FILLER4
XFILLER_28_405 VDD VSS DECAPHV8
XTAP_TAPCELL_ROW_58_709 VDD VSS WELLTAP
XFILLER_56_736 VDD VSS FILLER1
XFILLER_56_758 VDD VSS FILLER1
XFILLER_68_585 VSS VDD FILLER2
XFILLER_68_596 VDD VSS FILLER1
XFILLER_95_382 VSS VDD FILLER2
XFILLER_96_894 VDD VSS DECAPHV8
X_09623_ _19045_/Q _17346_/B VDD VSS _09624_/C NOR2X1
XFILLER_44_909 VDD VSS DECAPHV16
XFILLER_24_600 VDD VSS FILLER4
XFILLER_71_728 VDD VSS FILLER1
XTAP_TAPCELL_ROW_38_477 VDD VSS WELLTAP
X_09554_ _17653_/Q VDD VSS _09578_/A INVX1
XFILLER_52_964 VDD VSS DECAPHV8
X_09485_ _17618_/Q _17409_/B VDD VSS _09497_/B XOR2X1
XFILLER_11_305 VDD VSS DECAPHV8
XFILLER_51_485 VDD VSS DECAPHV8
XFILLER_108_1091 VDD VSS FILLER1
XFILLER_11_32 VDD VSS DECAPHV16
XFILLER_125_708 VSS VDD FILLER2
XFILLER_106_911 VSS VDD FILLER2
XFILLER_118_771 VDD VSS FILLER1
XFILLER_118_793 VDD VSS FILLER1
XFILLER_127_32 VDD VSS DECAPHV32
X_10260_ _10707_/A _10449_/B VDD VSS _17860_/D AND2X1
XFILLER_121_903 VSS VDD FILLER2
XFILLER_3_548 VDD VSS DECAPHV8
XFILLER_133_785 VDD VSS FILLER1
X_10191_ _17824_/Q _10194_/B VDD VSS _10192_/D _10204_/B NAND3X1
XFILLER_94_809 VDD VSS FILLER4
XFILLER_87_883 VSS VDD FILLER2
XFILLER_93_308 VDD VSS FILLER1
X_13950_ _18957_/Q _18958_/Q VDD VSS _14012_/B _14009_/B NAND3X1
XFILLER_47_725 VSS VDD FILLER2
XFILLER_98_1024 VDD VSS DECAPHV16
X_12901_ _18185_/Q _13094_/B VDD VSS _12902_/D _12901_/C NAND3X1
Xclkbuf_leaf_4_clk_fs_regs clkbuf_leaf_5_clk_fs_regs/A VDD VSS clkload4/A BUFX12
XFILLER_46_235 VDD VSS FILLER4
XFILLER_59_1019 VDD VSS FILLER4
XFILLER_98_1068 VDD VSS FILLER1
X_15620_ _15669_/A _16996_/A _15620_/C VDD VSS _18878_/D OAI21X1
X_13881_ _18485_/Q _13881_/B _13892_/C VDD VSS _13920_/B XNOR3X1
XFILLER_27_471 VDD VSS DECAPHV8
XFILLER_28_972 VDD VSS FILLER4
XFILLER_36_40 VDD VSS FILLER4
XFILLER_36_73 VDD VSS FILLER4
X_12832_ _12933_/A _12933_/B _12933_/C VDD VSS _14329_/B AOI21X1
XFILLER_36_84 VSS VDD FILLER2
X_12763_ _12763_/A _12763_/B _12763_/C _12763_/D VDD VSS _14150_/C OAI211X1
X_15551_ _15651_/A _15551_/B _15551_/C VDD VSS _15563_/C AOI21X1
XFILLER_42_441 VSS VDD FILLER2
XFILLER_70_750 VDD VSS DECAPHV32
XTAP_TAPCELL_ROW_103_1258 VDD VSS WELLTAP
XTAP_TAPCELL_ROW_7_99 VDD VSS WELLTAP
X_11714_ _11843_/A _11843_/B VDD VSS _14225_/B XNOR2X1
X_18270_ _18271_/CK _18270_/D _18270_/Q VDD VSS DFFQX1
Xdelaybuf_0_clk_fs clk_fs VDD VSS delaybuf_1_clk_fs/A BUFX12
X_15482_ _15432_/Y _15436_/Y _15673_/A VDD VSS _15550_/B MUXI2X1
X_14502_ _18515_/Q _18547_/Q VDD VSS _14502_/Y NOR2X1
XFILLER_35_1030 VDD VSS DECAPHV16
X_12694_ _12824_/B _12824_/C VDD VSS _14359_/B NAND2X1
X_17221_ _17218_/B _17221_/B VDD VSS _17236_/A NOR2BX1
X_14433_ _14972_/A _14433_/B _14433_/C VDD VSS _18457_/D NOR3X1
X_11645_ _11743_/A _11743_/B _11670_/C VDD VSS _14224_/B XNOR3X1
XFILLER_10_360 VSS VDD FILLER2
XFILLER_10_371 VDD VSS FILLER4
XFILLER_11_883 VDD VSS DECAPHV16
XFILLER_122_1033 VSS VDD FILLER2
X_11576_ _11754_/B _11754_/C VDD VSS _14165_/B NAND2X1
X_17152_ _17149_/A _17152_/B _17152_/C VDD VSS _17156_/B AOI2B1X1
X_14364_ _14394_/A _14364_/B _14364_/C VDD VSS _18395_/D NOR3X1
XFILLER_10_382 VSS VDD FILLER2
XFILLER_122_1066 VSS VDD FILLER2
X_10527_ _10382_/Y _10544_/B _10685_/B VDD VSS _17898_/D AND3BX1
X_17083_ _18012_/Q _17086_/B VDD VSS _17087_/B XOR2X1
X_16103_ _16161_/C _16158_/B VDD VSS _16104_/D _16103_/C NAND3X1
X_14295_ _14377_/A _14295_/B VDD VSS _18337_/D AND2X1
X_13315_ _13316_/C _14126_/A VDD VSS _13405_/B _14126_/B NAND3X1
XFILLER_108_270 VDD VSS DECAPHV8
X_10458_ _17862_/Q _10468_/B VDD VSS _10459_/B XNOR2X1
X_13246_ _18476_/Q VDD VSS _13514_/A INVX1
X_16034_ _18899_/Q _16034_/B VDD VSS _16069_/A AND2X1
XTAP_TAPCELL_ROW_114_1387 VDD VSS WELLTAP
X_10389_ _17851_/Q VDD VSS _10390_/A INVX1
X_13177_ _13177_/A _14240_/B _14240_/C VDD VSS _13178_/D NOR3X1
XFILLER_112_958 VDD VSS DECAPHV8
XFILLER_96_113 VDD VSS DECAPHV8
X_12128_ _12215_/A _14200_/B VDD VSS _14230_/A NOR2X1
X_17985_ _18011_/CK _17985_/D _17985_/Q VDD VSS DFFQX1
XFILLER_111_468 VDD VSS FILLER4
XFILLER_77_80 VDD VSS DECAPHV8
X_12059_ _12356_/A _12261_/A VDD VSS _12157_/D NOR2X1
X_16936_ _16942_/A _16936_/B VDD VSS _16938_/B XNOR2X1
XFILLER_78_894 VSS VDD FILLER2
XFILLER_38_769 VDD VSS FILLER1
XFILLER_93_875 VDD VSS DECAPHV32
X_16867_ _16867_/A _16867_/B VDD VSS _16868_/B AND2X1
XFILLER_80_514 VDD VSS DECAPHV8
XFILLER_92_385 VSS VDD FILLER2
X_18606_ clkload1/A _18606_/D _18606_/Q VDD VSS DFFQX1
X_16798_ _16798_/A _16798_/B VDD VSS _16817_/A NOR2X1
X_15818_ _15885_/A _15885_/B VDD VSS _15819_/D NAND2X1
XFILLER_80_536 VDD VSS DECAPHV16
XTAP_TAPCELL_ROW_35_436 VDD VSS WELLTAP
XTAP_TAPCELL_ROW_82_1000 VDD VSS WELLTAP
X_18537_ clkload4/A _18537_/D _18537_/Q VDD VSS DFFQX1
X_15749_ _15686_/Y _15748_/Y _15651_/Y VDD VSS _15750_/B MUXI2X1
XFILLER_34_975 VDD VSS FILLER1
XTAP_TAPCELL_ROW_63_778 VDD VSS WELLTAP
X_09270_ _09271_/A _09271_/B _09271_/C _17536_/D VDD VSS _09270_/Y AOI31X1
X_18468_ _18470_/CK _18468_/D _18468_/Q VDD VSS DFFQX1
X_17419_ _17423_/A _17419_/B VDD VSS _17627_/D NOR2X1
XFILLER_119_502 VDD VSS FILLER1
XTAP_TAPCELL_ROW_15_193 VDD VSS WELLTAP
X_18399_ _18478_/CK _18399_/D _18399_/Q VDD VSS DFFQX1
XFILLER_106_218 VDD VSS FILLER1
XTAP_TAPCELL_ROW_93_1140 VDD VSS WELLTAP
XFILLER_114_251 VDD VSS FILLER4
XFILLER_114_262 VDD VSS FILLER4
XFILLER_115_774 VSS VDD FILLER2
XFILLER_115_785 VDD VSS DECAPHV8
XFILLER_130_700 VDD VSS FILLER1
XTAP_TAPCELL_ROW_7_106 VDD VSS WELLTAP
XFILLER_114_295 VSS VDD FILLER2
XFILLER_87_124 VSS VDD FILLER2
X_08985_ _09218_/A _08985_/B VDD VSS _17757_/D NOR2X1
Xclkbuf_leaf_2__002_ clkload25/A VDD VSS _18295_/CK BUFX12
XFILLER_28_202 VDD VSS FILLER1
XFILLER_29_747 VDD VSS FILLER4
XFILLER_87_179 VDD VSS FILLER4
XFILLER_28_235 VDD VSS DECAPHV8
XFILLER_83_330 VDD VSS DECAPHV8
XFILLER_44_717 VSS VDD FILLER2
XFILLER_84_886 VDD VSS FILLER4
X_09606_ _09606_/A _09606_/B VDD VSS _09607_/C NAND2X1
X_09537_ _17620_/Q _17412_/B VDD VSS _09538_/B XOR2X1
XFILLER_58_1096 VDD VSS FILLER4
X_09468_ _09468_/A _09468_/B VDD VSS _09493_/A NAND2X1
XFILLER_8_607 VDD VSS DECAPHV32
X_09399_ _09399_/A _09399_/B _09399_/C VDD VSS _09400_/B NOR3X1
XFILLER_7_128 VDD VSS DECAPHV32
X_11430_ _11430_/A _11430_/B _11430_/C _11430_/D VDD VSS _14133_/B AOAI211X1
X_11361_ _18968_/Q _18089_/Q VDD VSS _11362_/D AND2X1
X_10312_ _17840_/Q VDD VSS _10475_/A INVX1
X_13100_ _13216_/A _13225_/B VDD VSS _14123_/B XNOR2X1
XFILLER_4_857 VDD VSS DECAPHV16
X_11292_ _14043_/B _14043_/C _11349_/A VDD VSS _11294_/B OAI21X1
X_14080_ _14083_/A _14080_/B VDD VSS _18147_/D NOR2X1
X_10243_ _17832_/Q _10247_/B VDD VSS _10244_/B XNOR2X1
X_13031_ _13033_/B _13032_/B _17536_/D VDD VSS _13032_/C AOI21X1
XFILLER_105_284 VDD VSS FILLER1
XFILLER_117_1135 VDD VSS FILLER1
XFILLER_121_722 VDD VSS FILLER4
X_10174_ _10166_/B _10174_/B _17821_/Q VDD VSS _10175_/D AND3BX1
XFILLER_66_308 VDD VSS FILLER1
Xclkbuf_leaf_21__001_ clkbuf_2_1__f__001_/Y VDD VSS _17871_/CK BUFX12
X_17770_ _19042_/CK _17770_/D _17770_/Q VDD VSS DFFQX1
XFILLER_47_500 VSS VDD FILLER2
X_16721_ _18830_/Q _18722_/Q VDD VSS _16723_/C XNOR2X1
X_14982_ _18617_/Q _18995_/Q VDD VSS _14983_/D NAND2X1
XFILLER_59_393 VDD VSS FILLER1
X_13933_ _13935_/A _13935_/B _13935_/C _13937_/A VDD VSS _13934_/B AOAI211X1
XFILLER_47_588 VDD VSS FILLER1
XFILLER_62_514 VDD VSS FILLER4
XFILLER_74_352 VSS VDD FILLER2
Xclkbuf_leaf_36__001_ clkload73/A VDD VSS _19045_/CK BUFX12
X_16652_ _16684_/C _16684_/B VDD VSS _16653_/B NOR2BX1
X_13864_ _13870_/A _13870_/B _13870_/D _13870_/C VDD VSS _14462_/C OAI211X1
XFILLER_62_547 VDD VSS DECAPHV8
X_12815_ _12927_/A _12927_/B _12819_/C VDD VSS _14419_/B XNOR3X1
X_16583_ _18853_/Q _18691_/Q VDD VSS _16584_/A XOR2X1
X_15603_ _15617_/C _15617_/B VDD VSS _15604_/B NAND2BX1
X_18322_ _18376_/CK _18322_/D _18322_/Q VDD VSS DFFQX1
X_15534_ _15572_/A _15534_/B _15534_/C _15695_/A VDD VSS _15535_/C OAI211X1
X_13795_ _18430_/Q _14403_/B VDD VSS _13840_/A AND2X1
XFILLER_42_271 VSS VDD FILLER2
XFILLER_70_591 VSS VDD FILLER2
XTAP_TAPCELL_ROW_32_406 VDD VSS WELLTAP
XTAP_TAPCELL_ROW_60_737 VDD VSS WELLTAP
X_12746_ _12746_/A _14204_/B _12746_/C _12746_/D VDD VSS _12962_/A AOAI211X1
XFILLER_42_293 VDD VSS FILLER4
X_12677_ _12680_/D _14063_/B VDD VSS _12781_/A NAND2X1
X_18253_ _18253_/CK _18253_/D _18253_/Q VDD VSS DFFQX1
X_15465_ _15480_/A _15465_/B _15465_/C VDD VSS _15534_/B OAI21X1
XFILLER_30_466 VDD VSS FILLER1
XFILLER_8_44 VSS VDD FILLER2
X_11628_ _18119_/Q _14050_/B VDD VSS _11635_/A AND2X1
X_18184_ _18250_/CK _18184_/D _18184_/Q VDD VSS DFFQX1
X_17204_ _18999_/Q _17232_/B VDD VSS _17208_/A XOR2X1
X_15396_ _18915_/Q _15398_/B VDD VSS _15457_/C NOR2BX1
X_14416_ _14440_/A _14416_/B VDD VSS _18442_/D NOR2X1
XFILLER_129_855 VSS VDD FILLER2
XFILLER_129_877 VDD VSS FILLER4
XTAP_TAPCELL_ROW_116_1405 VDD VSS WELLTAP
XTAP_TAPCELL_ROW_12_163 VDD VSS WELLTAP
XTAP_TAPCELL_ROW_40_494 VDD VSS WELLTAP
X_17135_ _17135_/A _17135_/B _17135_/C VDD VSS _17140_/A OA21X2
X_14347_ _14542_/A VDD VSS _14378_/A BUFX3
XFILLER_116_516 VDD VSS FILLER1
XFILLER_128_387 VDD VSS FILLER1
XTAP_TAPCELL_ROW_116_1416 VDD VSS WELLTAP
X_11559_ _18146_/Q VDD VSS _11630_/A INVX1
X_17066_ _18008_/Q _17066_/B VDD VSS _17069_/A NOR2BX1
X_14278_ _14296_/A _14278_/B _14278_/C VDD VSS _18323_/D NOR3X1
XFILLER_131_519 VDD VSS DECAPHV8
XFILLER_83_1134 VSS VDD FILLER2
X_13229_ _18241_/Q _13229_/B _13303_/C VDD VSS _13380_/C XNOR3X1
X_16017_ _16051_/A _16051_/B _16051_/C VDD VSS _16018_/B NOR3X1
XFILLER_85_617 VDD VSS DECAPHV16
XFILLER_111_276 VSS VDD FILLER2
XFILLER_112_788 VSS VDD FILLER2
XTAP_TAPCELL_ROW_68_837 VDD VSS WELLTAP
X_17968_ _17993_/CK _17968_/D _17968_/Q VDD VSS DFFQX1
XFILLER_111_298 VSS VDD FILLER2
XFILLER_19_0 VDD VSS DECAPHV32
XFILLER_66_864 VSS VDD FILLER2
XFILLER_93_650 VDD VSS FILLER1
X_17899_ _17901_/CK _17899_/D _17899_/Q VDD VSS DFFQX1
X_16919_ _18930_/Q _16972_/B VDD VSS _16920_/C NAND2X1
XFILLER_38_577 VSS VDD FILLER2
XFILLER_66_886 VSS VDD FILLER2
XTAP_TAPCELL_ROW_127_1545 VDD VSS WELLTAP
XFILLER_19_791 VDD VSS DECAPHV16
XFILLER_53_547 VDD VSS DECAPHV8
XFILLER_80_322 VSS VDD FILLER2
XTAP_TAPCELL_ROW_48_594 VDD VSS WELLTAP
XFILLER_22_912 VDD VSS FILLER1
XFILLER_53_569 VDD VSS FILLER4
XFILLER_80_344 VDD VSS FILLER1
X_09322_ _17580_/Q _17369_/B VDD VSS _09323_/B XNOR2X1
XFILLER_22_956 VDD VSS DECAPHV16
XFILLER_33_282 VDD VSS FILLER4
XFILLER_33_293 VDD VSS FILLER4
XFILLER_61_591 VDD VSS DECAPHV8
X_09253_ _09281_/A _09281_/B VDD VSS _09259_/A NAND2X1
X_09184_ _09184_/A _09203_/C VDD VSS _09200_/A XNOR2X1
XFILLER_135_836 VDD VSS FILLER1
XFILLER_1_827 VDD VSS DECAPHV8
XFILLER_88_400 VDD VSS DECAPHV16
XFILLER_102_210 VDD VSS FILLER1
XFILLER_68_49 VDD VSS DECAPHV32
XFILLER_102_254 VSS VDD FILLER2
XFILLER_48_308 VDD VSS DECAPHV16
XFILLER_103_788 VDD VSS DECAPHV8
XFILLER_124_44 VSS VDD FILLER2
X_08968_ _17753_/Q _18542_/Q _08968_/C VDD VSS _08972_/B MIN3X1
XFILLER_112_1010 VSS VDD FILLER2
XFILLER_56_341 VDD VSS FILLER1
X_08899_ _17535_/B _08899_/B VDD VSS _17536_/B NAND2BX1
XFILLER_16_205 VDD VSS FILLER1
XFILLER_95_1016 VSS VDD FILLER2
X_10930_ _11024_/A _11069_/B VDD VSS _17971_/D NOR2X1
XFILLER_84_694 VSS VDD FILLER2
XFILLER_95_1049 VSS VDD FILLER2
XFILLER_44_569 VDD VSS FILLER4
XFILLER_71_344 VDD VSS FILLER1
X_10861_ _10914_/A _10998_/B VDD VSS _17958_/D NOR2X1
X_12600_ _18418_/Q VDD VSS _12818_/A INVX1
XFILLER_12_411 VDD VSS FILLER1
XFILLER_25_794 VDD VSS FILLER1
XFILLER_52_580 VDD VSS DECAPHV8
X_10792_ _17917_/Q _10792_/B _10792_/C VDD VSS _10928_/B MIN3X1
X_13580_ _13580_/A _13580_/B _13580_/C _13580_/D VDD VSS _13581_/C OAI211X1
XFILLER_13_978 VDD VSS FILLER4
XTAP_TAPCELL_ROW_100_1217 VDD VSS WELLTAP
X_12531_ _12743_/A _12742_/B VDD VSS _14175_/B XNOR2X1
XFILLER_9_949 VSS VDD FILLER2
X_12462_ _18182_/Q _12462_/B _12653_/D VDD VSS _12552_/C XNOR3X1
X_15250_ _15250_/A _18818_/Q VDD VSS _18791_/D AND2X1
XFILLER_123_0 VDD VSS DECAPHV32
XFILLER_71_1082 VDD VSS FILLER1
XTAP_TAPCELL_ROW_4_67 VDD VSS WELLTAP
X_11413_ _18299_/Q _14249_/B VDD VSS _11522_/B NOR2X1
X_14201_ _14198_/Y _14201_/B _14201_/C VDD VSS _18257_/D AND3BX1
XFILLER_126_814 VDD VSS FILLER4
X_12393_ _12479_/B _12393_/B VDD VSS _12394_/C AND2X1
X_15181_ _15286_/A _18750_/Q VDD VSS _18723_/D AND2X1
X_11344_ _18114_/Q _14045_/B VDD VSS _11345_/D _14045_/C NAND3X1
X_14132_ _14343_/A _14132_/B VDD VSS _18194_/D AND2X1
X_11275_ _11275_/A _11294_/D VDD VSS _14071_/B XNOR2X1
X_18940_ _18940_/CK _18940_/D _18940_/Q VDD VSS DFFQX1
X_14063_ _14083_/A _14063_/B VDD VSS _18131_/D NOR2X1
XFILLER_4_687 VDD VSS DECAPHV8
X_10226_ _17829_/Q VDD VSS _10232_/A INVX1
X_13014_ _13014_/A _13014_/B _13014_/C _13014_/D VDD VSS _13015_/A AO31X2
XFILLER_121_541 VDD VSS FILLER1
XTAP_TAPCELL_ROW_111_1346 VDD VSS WELLTAP
X_18871_ _18940_/CK _18871_/D _18871_/Q VDD VSS DFFQX1
XFILLER_121_585 VDD VSS FILLER1
XFILLER_48_820 VDD VSS FILLER1
XFILLER_67_639 VSS VDD FILLER2
X_10157_ _10157_/A _10157_/B _10157_/C VDD VSS _10158_/C OAI21X1
X_17822_ _19038_/CK _17822_/D _17822_/Q VDD VSS DFFQX1
XFILLER_66_138 VDD VSS FILLER1
XFILLER_82_609 VDD VSS FILLER1
X_10088_ _17812_/Q _10088_/B _10088_/C VDD VSS _10270_/A MIN3X1
X_17753_ clkload3/A _17753_/D _17753_/Q VDD VSS DFFQX1
X_14965_ _14967_/B _14965_/B VDD VSS _14966_/B XOR2X1
XFILLER_48_886 VSS VDD FILLER2
XFILLER_48_897 VDD VSS DECAPHV8
XFILLER_63_812 VDD VSS FILLER1
XFILLER_75_650 VDD VSS FILLER1
XFILLER_75_672 VDD VSS FILLER1
X_17684_ _17716_/CK _17684_/D _17684_/Q VDD VSS DFFQX1
X_16704_ _18917_/Q _16704_/B VDD VSS _16706_/C XNOR2X1
X_13916_ _18487_/Q _14465_/B VDD VSS _13929_/C XNOR2X1
XFILLER_90_631 VDD VSS FILLER4
X_16635_ _16635_/A _16678_/B VDD VSS _16641_/B XNOR2X1
X_14896_ _18598_/Q _18630_/Q _14896_/C VDD VSS _14900_/B MIN3X1
XFILLER_35_569 VSS VDD FILLER2
XFILLER_62_344 VDD VSS FILLER4
XFILLER_74_81 VDD VSS DECAPHV32
XTAP_TAPCELL_ROW_17_222 VDD VSS WELLTAP
XTAP_TAPCELL_ROW_45_553 VDD VSS WELLTAP
X_13847_ _13847_/A _13847_/B _14375_/B _18405_/Q _13847_/E VDD VSS _13876_/C AOI221X1
XFILLER_16_772 VDD VSS FILLER1
XTAP_TAPCELL_ROW_45_564 VDD VSS WELLTAP
XTAP_TAPCELL_ROW_73_895 VDD VSS WELLTAP
X_16566_ _16566_/A _16566_/B _16566_/C VDD VSS _16637_/B AO21X2
X_13778_ _13814_/A _13827_/B VDD VSS _14495_/B XNOR2X1
XFILLER_128_1072 VDD VSS DECAPHV32
XFILLER_31_742 VSS VDD FILLER2
XTAP_TAPCELL_ROW_122_1486 VDD VSS WELLTAP
X_12729_ _12843_/A _14328_/B VDD VSS _12825_/B NOR2X1
X_18305_ _18358_/CK _18305_/D _18305_/Q VDD VSS DFFQX1
X_16497_ _18850_/Q _18688_/Q _16497_/C VDD VSS _16541_/A AOI21X1
X_15517_ _15673_/A _15517_/B _15517_/C _15686_/A VDD VSS _15518_/C OA211X2
XFILLER_31_764 VDD VSS FILLER1
X_18236_ _18261_/CK _18236_/D _18236_/Q VDD VSS DFFQX1
X_15448_ _15480_/A _15448_/B _15483_/A VDD VSS _15449_/D OAI21X1
XFILLER_30_285 VDD VSS DECAPHV8
X_18167_ _18195_/CK _18167_/D _18167_/Q VDD VSS DFFQX1
X_15379_ _18864_/Q _18863_/Q _16537_/A VDD VSS _15978_/A NOR3X1
XFILLER_116_335 VDD VSS FILLER4
X_18098_ _18978_/CK _18098_/D _18098_/Q VDD VSS DFFQX1
X_17118_ _17242_/A _17118_/B _17122_/B VDD VSS _18980_/D NOR3X1
XFILLER_116_368 VSS VDD FILLER2
XFILLER_132_806 VDD VSS DECAPHV8
XFILLER_89_208 VSS VDD FILLER2
X_09940_ _10138_/A _10147_/B _10139_/A VDD VSS _10151_/B AO21X2
X_17049_ _18005_/Q _17049_/B VDD VSS _17050_/D NAND2X1
XFILLER_125_891 VDD VSS DECAPHV16
XFILLER_112_552 VDD VSS DECAPHV16
XFILLER_135_1021 VSS VDD FILLER2
X_09871_ _09886_/C _09880_/B _09880_/C VDD VSS _09887_/B OA21X2
XFILLER_58_617 VDD VSS DECAPHV16
XFILLER_39_831 VSS VDD FILLER2
XFILLER_26_514 VDD VSS DECAPHV8
XFILLER_38_396 VDD VSS FILLER1
XFILLER_53_311 VDD VSS FILLER4
XFILLER_81_642 VDD VSS DECAPHV8
XTAP_TAPCELL_ROW_88_1072 VDD VSS WELLTAP
XFILLER_55_1022 VDD VSS FILLER1
XFILLER_81_686 VDD VSS FILLER1
XFILLER_107_1134 VSS VDD FILLER2
XFILLER_16_1017 VDD VSS DECAPHV8
XFILLER_55_1044 VSS VDD FILLER2
X_09305_ _17611_/Q _09305_/B _17402_/B VDD VSS _09332_/A MIN3X1
X_09236_ _09236_/A _09248_/B VDD VSS _17366_/B XOR2X1
XFILLER_108_803 VDD VSS DECAPHV8
XFILLER_22_797 VDD VSS FILLER1
Xclkbuf_leaf_20__002_ clkload27/A VDD VSS _18292_/CK BUFX12
XFILLER_107_313 VDD VSS FILLER1
XFILLER_135_600 VDD VSS DECAPHV8
XFILLER_5_407 VDD VSS DECAPHV32
X_09167_ _19029_/Q _17329_/B VDD VSS _09171_/B XNOR2X1
XFILLER_119_184 VSS VDD FILLER2
X_09098_ _17428_/B _17635_/Q VDD VSS _09099_/C NOR2BX1
XFILLER_119_88 VDD VSS FILLER4
Xclkbuf_leaf_35__002_ clkload26/A VDD VSS _18397_/CK BUFX12
XFILLER_135_32 VDD VSS DECAPHV32
XFILLER_89_742 VSS VDD FILLER2
X_11060_ _17970_/Q _11066_/B VDD VSS _11061_/B XNOR2X1
XFILLER_122_349 VDD VSS FILLER1
X_10011_ _10213_/A _10213_/B _10214_/C _10213_/C VDD VSS _10220_/C AO211X2
XFILLER_0_178 VSS VDD FILLER2
XFILLER_130_360 VDD VSS DECAPHV16
XFILLER_131_894 VSS VDD FILLER2
XFILLER_88_274 VSS VDD FILLER2
XFILLER_88_285 VDD VSS FILLER1
XFILLER_89_786 VDD VSS FILLER4
XFILLER_92_929 VDD VSS FILLER1
X_14750_ _18567_/Q _18599_/Q VDD VSS _14751_/C NAND2X1
XFILLER_17_547 VDD VSS FILLER4
XFILLER_45_834 VSS VDD FILLER2
XFILLER_45_845 VDD VSS DECAPHV8
X_11962_ _12054_/A _14054_/B VDD VSS _14055_/A _12040_/C NAND3X1
X_13701_ _13701_/A _13701_/B _13701_/C VDD VSS _14280_/B OAI21X1
XFILLER_45_878 VDD VSS FILLER4
X_10913_ _10916_/A _10916_/B VDD VSS _11052_/B XNOR2X1
X_11893_ _18332_/Q _11913_/B _14289_/B VDD VSS _14349_/B XOR3X1
X_14681_ _14684_/A _14684_/B _14684_/C _17544_/C VDD VSS _14682_/D AOAI211X1
XFILLER_32_528 VSS VDD FILLER2
XFILLER_44_388 VSS VDD FILLER2
XFILLER_44_40 VDD VSS FILLER4
X_10844_ _10844_/A _10981_/B VDD VSS _17955_/D NOR2X1
X_16420_ _16456_/A _16420_/B _16420_/C VDD VSS _18909_/D OAI21X1
X_13632_ _13693_/B _13701_/B VDD VSS _14279_/B XNOR2X1
XFILLER_12_230 VSS VDD FILLER2
XFILLER_13_742 VSS VDD FILLER2
XTAP_TAPCELL_ROW_42_523 VDD VSS WELLTAP
XTAP_TAPCELL_ROW_70_854 VDD VSS WELLTAP
X_16351_ _16412_/A VDD VSS _16630_/A BUFX3
X_13563_ _13566_/A _13566_/C _13566_/B _13563_/D VDD VSS _14215_/B OAOI211X1
XFILLER_40_572 VDD VSS FILLER1
X_10775_ _11062_/A _10906_/B VDD VSS _17940_/D AND2X1
X_12514_ _12514_/A _14203_/B VDD VSS _12629_/A OR2X2
X_15302_ _15304_/A _18043_/Q VDD VSS _18842_/D AND2X1
XFILLER_12_296 VDD VSS DECAPHV16
X_18021_ _18024_/CK _18021_/D _18021_/Q VDD VSS DFFQX1
X_16282_ _16333_/A _16283_/B _16783_/D VDD VSS _16283_/C AOI21X1
X_13494_ _13566_/A _13566_/C VDD VSS _13495_/C NOR2X1
XFILLER_9_779 VDD VSS FILLER4
XTAP_TAPCELL_ROW_22_280 VDD VSS WELLTAP
X_12445_ _18128_/Q _14059_/B VDD VSS _12455_/A AND2X1
X_15233_ _15286_/A _18801_/Q VDD VSS _18774_/D AND2X1
X_12376_ _12376_/A _14261_/B _14261_/C VDD VSS _12377_/D NOR3X1
X_15164_ _15250_/A _18734_/Q VDD VSS _18707_/D AND2X1
XFILLER_114_817 VDD VSS DECAPHV16
X_11327_ _11327_/A _11327_/B _14100_/B VDD VSS _11328_/B MIN3X1
X_14115_ _14108_/Y _14115_/B _14115_/C VDD VSS _18179_/D AND3BX1
XFILLER_119_1049 VDD VSS FILLER1
XFILLER_125_176 VDD VSS DECAPHV8
XFILLER_99_539 VDD VSS DECAPHV8
X_15095_ _18641_/Q _19019_/Q _15095_/C VDD VSS _15097_/A MIN3X1
XFILLER_113_349 VSS VDD FILLER2
XFILLER_69_92 VDD VSS FILLER1
X_11258_ _11259_/B _11259_/C _18112_/Q VDD VSS _11281_/B AOI21X1
X_18923_ _18950_/CK _18923_/D _18923_/Q VDD VSS DFFQX1
X_14046_ _14079_/A _14046_/B _14046_/C VDD VSS _18115_/D NOR3X1
XFILLER_122_894 VDD VSS FILLER4
XFILLER_67_425 VDD VSS FILLER4
X_10209_ _10378_/B _10212_/B _10212_/D _10212_/C VDD VSS _10399_/C OAI211X1
X_11189_ _11189_/A _11189_/B VDD VSS _11190_/C NOR2X1
X_18854_ _18856_/CK _18854_/D _18854_/Q VDD VSS DFFQX1
XFILLER_121_382 VDD VSS FILLER1
XFILLER_121_393 VDD VSS FILLER4
XTAP_TAPCELL_ROW_78_954 VDD VSS WELLTAP
X_17805_ _17851_/CK _17805_/D _17805_/Q VDD VSS DFFQX1
XFILLER_48_650 VDD VSS DECAPHV8
XFILLER_55_609 VSS VDD FILLER2
XFILLER_83_918 VDD VSS DECAPHV8
XFILLER_85_80 VDD VSS DECAPHV8
X_18785_ _18787_/CK _18785_/D _18785_/Q VDD VSS DFFQX1
X_15997_ _15997_/A _15997_/B _15997_/C _15997_/D VDD VSS _16002_/C OAOI211X1
XFILLER_78_1011 VDD VSS FILLER1
XTAP_TAPCELL_ROW_124_1504 VDD VSS WELLTAP
X_17736_ clkload6/A _17736_/D _17736_/Q VDD VSS DFFQX1
X_14948_ _18610_/Q _18642_/Q VDD VSS _14949_/B XNOR2X1
XFILLER_35_355 VDD VSS FILLER1
XFILLER_39_1006 VDD VSS FILLER1
XFILLER_78_1055 VDD VSS FILLER1
XFILLER_90_450 VDD VSS FILLER1
X_17667_ _17698_/CK _17667_/D _17667_/Q VDD VSS DFFQX1
X_14879_ _14880_/A _14881_/C _17266_/C VDD VSS _14880_/C OAI21X1
XFILLER_51_826 VDD VSS FILLER4
X_17598_ _19024_/CK _17598_/D _17598_/Q VDD VSS DFFQX1
X_16618_ _18800_/Q _18746_/Q VDD VSS _16620_/D XOR2X1
X_16549_ _16549_/A _16549_/B _16549_/C _16549_/D VDD VSS _16551_/B OAI31X1
XFILLER_86_0 VDD VSS DECAPHV32
XFILLER_31_594 VSS VDD FILLER2
XFILLER_136_408 VDD VSS DECAPHV32
X_09021_ _17630_/Q _17422_/B VDD VSS _17388_/B XNOR2X1
X_18219_ _18271_/CK _18219_/D _18219_/Q VDD VSS DFFQX1
XFILLER_15_1083 VSS VDD FILLER2
XTAP_TAPCELL_ROW_135_1633 VDD VSS WELLTAP
XTAP_TAPCELL_ROW_135_1644 VDD VSS WELLTAP
XFILLER_132_625 VDD VSS FILLER4
XFILLER_113_850 VDD VSS FILLER1
XFILLER_120_809 VDD VSS DECAPHV8
X_09923_ _09928_/A _09928_/B VDD VSS _10128_/B XOR2X1
XFILLER_113_894 VDD VSS DECAPHV8
XFILLER_98_561 VDD VSS DECAPHV8
X_09854_ _17780_/Q _09857_/C VDD VSS _09855_/B NAND2X1
XFILLER_27_801 VDD VSS FILLER4
XFILLER_2_1104 VDD VSS DECAPHV32
X_09785_ _17392_/A _09879_/B VDD VSS _17785_/D AND2X1
XFILLER_27_834 VSS VDD FILLER2
XFILLER_38_160 VDD VSS FILLER1
XFILLER_96_1100 VSS VDD FILLER2
XFILLER_26_333 VDD VSS DECAPHV8
XFILLER_82_951 VDD VSS FILLER4
XFILLER_42_848 VDD VSS DECAPHV16
XFILLER_53_163 VDD VSS FILLER4
XFILLER_53_174 VDD VSS FILLER4
XFILLER_54_686 VDD VSS FILLER1
XFILLER_81_472 VDD VSS DECAPHV8
XFILLER_82_984 VSS VDD FILLER2
XFILLER_14_32 VDD VSS DECAPHV8
XFILLER_14_87 VSS VDD FILLER2
XFILLER_22_594 VDD VSS DECAPHV8
X_10560_ _10560_/A _10560_/B _10560_/C _10560_/D VDD VSS _10576_/B OAOI211X1
XFILLER_10_778 VDD VSS FILLER1
X_09219_ _09219_/A _09219_/B _17331_/B VDD VSS _09244_/A MIN3X1
X_10491_ _10516_/A _10665_/B VDD VSS _17894_/D NOR2X1
X_12230_ _12331_/A _12430_/B VDD VSS _14172_/B XNOR2X1
XFILLER_107_176 VDD VSS DECAPHV8
XFILLER_122_113 VDD VSS DECAPHV16
XFILLER_123_625 VDD VSS FILLER1
XFILLER_30_97 VDD VSS FILLER1
XTAP_TAPCELL_ROW_1_35 VDD VSS WELLTAP
X_12161_ _12161_/A _12161_/B _12161_/C _12356_/A VDD VSS _12261_/B OAOI211X1
XFILLER_123_658 VSS VDD FILLER2
XFILLER_2_966 VDD VSS DECAPHV8
X_11112_ _17980_/Q _11112_/B _11112_/C VDD VSS _11118_/C MIN3X1
X_12092_ _12095_/A _14470_/B VDD VSS _12094_/B XNOR2X1
XFILLER_118_1060 VDD VSS DECAPHV8
XFILLER_7_1026 VDD VSS DECAPHV32
XFILLER_89_561 VDD VSS DECAPHV8
X_11043_ _17967_/Q VDD VSS _11048_/A INVX1
X_15920_ _18782_/Q _18728_/Q VDD VSS _15955_/B XOR2X1
XFILLER_39_84 VSS VDD FILLER2
XFILLER_65_907 VDD VSS FILLER1
XFILLER_77_767 VDD VSS FILLER4
X_15851_ _15849_/Y _15919_/B _16206_/A VDD VSS _15858_/C AND3BX1
XFILLER_18_801 VSS VDD FILLER2
XFILLER_40_1132 VDD VSS FILLER4
XTAP_TAPCELL_ROW_75_913 VDD VSS WELLTAP
X_14802_ _14903_/A _14802_/B VDD VSS _18578_/D NOR2X1
XFILLER_76_288 VDD VSS DECAPHV16
XTAP_TAPCELL_ROW_75_924 VDD VSS WELLTAP
X_12994_ _12994_/A _12994_/B _12994_/C _12994_/D VDD VSS _12999_/A AO31X2
X_18570_ clkload1/A _18570_/D _18570_/Q VDD VSS DFFQX1
X_15782_ _16537_/A _18863_/Q _18864_/Q VDD VSS _16206_/A AND3BX2
XFILLER_29_182 VDD VSS FILLER1
X_11945_ _12023_/A _14140_/B _14140_/C VDD VSS _12123_/C NOR3X1
X_17521_ _17565_/A _17521_/B VDD VSS _17723_/D NOR2X1
X_14733_ _18564_/Q _18596_/Q VDD VSS _14740_/C NOR2X1
XFILLER_17_377 VDD VSS FILLER1
X_17452_ _17463_/A _17452_/B VDD VSS _17658_/D NOR2X1
X_14664_ _18549_/Q _18581_/Q _14664_/C VDD VSS _14668_/B AOI21X1
XFILLER_33_848 VDD VSS FILLER1
XFILLER_60_656 VDD VSS FILLER1
XTAP_TAPCELL_ROW_106_1289 VDD VSS WELLTAP
XTAP_TAPCELL_ROW_55_681 VDD VSS WELLTAP
X_11876_ _11952_/A _11876_/B _12025_/D VDD VSS _12023_/C XNOR3X1
X_16403_ _16429_/A _16429_/B _16403_/C VDD VSS _16408_/C AOI21X1
X_13615_ _13640_/A _14339_/B _14338_/C VDD VSS _13616_/D NOR3X1
XFILLER_13_561 VSS VDD FILLER2
X_10827_ _17925_/Q _10827_/B _10823_/Y VDD VSS _10832_/C AOI21BX1
X_17383_ _17453_/A _17383_/B VDD VSS _17593_/D AND2X1
X_14595_ _14598_/C _14596_/B _17514_/A VDD VSS _14596_/C OAI21X1
XFILLER_41_881 VDD VSS FILLER4
X_10758_ _10761_/C _10758_/B VDD VSS _10886_/B XNOR2X1
X_16334_ _16537_/A _18765_/Q VDD VSS _16335_/D AND2X1
X_13546_ _13546_/A _14370_/B _14370_/C VDD VSS _13547_/D NOR3X1
X_16265_ _16110_/B _16415_/B _16521_/A VDD VSS _16265_/Y MUX2X1
X_13477_ _13558_/A _14306_/B VDD VSS _13498_/B NOR2X1
XFILLER_127_953 VSS VDD FILLER2
X_10689_ _10822_/B _10822_/C VDD VSS _10827_/B XNOR2X1
X_12428_ _18233_/Q VDD VSS _12518_/A INVX1
X_18004_ _18025_/CK _18004_/D _18004_/Q VDD VSS DFFQX1
X_15216_ _15272_/A _18785_/Q VDD VSS _18758_/D AND2X1
XFILLER_126_441 VDD VSS FILLER1
XFILLER_126_463 VDD VSS FILLER1
X_16196_ _16196_/A VDD VSS _16459_/A BUFX3
XFILLER_114_614 VSS VDD FILLER2
XFILLER_114_636 VDD VSS DECAPHV8
X_12359_ _12448_/A _12542_/B _12542_/C VDD VSS _12653_/A XNOR3X1
X_15147_ _15313_/A _18717_/Q VDD VSS _18690_/D AND2X1
X_15078_ _15078_/A _15078_/B _15078_/C VDD VSS _15082_/B OA21X2
XFILLER_68_723 VSS VDD FILLER2
XTAP_TAPCELL_ROW_130_1574 VDD VSS WELLTAP
X_18906_ _18913_/CK _18906_/D _18906_/Q VDD VSS DFFQX1
X_14029_ _17122_/D _18977_/Q VDD VSS _18098_/D AND2X1
XFILLER_132_1068 VDD VSS FILLER1
XFILLER_49_970 VDD VSS FILLER1
XFILLER_56_929 VDD VSS FILLER4
XFILLER_67_266 VDD VSS DECAPHV8
X_18837_ _18837_/CK _18837_/D _18837_/Q VDD VSS DFFQX1
XFILLER_27_119 VDD VSS DECAPHV8
X_09570_ _09573_/A _09573_/B _17446_/A VDD VSS _09571_/C OAI21X1
X_18768_ _18821_/CK _18768_/D _18768_/Q VDD VSS DFFQX1
X_17719_ _17722_/CK _17719_/D _17719_/Q VDD VSS DFFQX1
XFILLER_63_483 VDD VSS DECAPHV8
XFILLER_91_770 VDD VSS FILLER1
XTAP_TAPCELL_ROW_85_1042 VDD VSS WELLTAP
X_18699_ _18780_/CK _18699_/D _18699_/Q VDD VSS DFFQX1
XFILLER_50_133 VDD VSS FILLER1
XFILLER_51_689 VSS VDD FILLER2
XFILLER_52_1003 VDD VSS DECAPHV16
XFILLER_109_408 VSS VDD FILLER2
XFILLER_52_1058 VSS VDD FILLER2
X_09004_ _17632_/Q _17425_/B VDD VSS _09018_/B XOR2X1
XFILLER_117_463 VSS VDD FILLER2
XFILLER_104_113 VDD VSS DECAPHV16
XFILLER_117_474 VDD VSS FILLER1
XTAP_TAPCELL_ROW_96_1171 VDD VSS WELLTAP
XFILLER_105_658 VSS VDD FILLER2
X_09906_ _17565_/A _10109_/B _10119_/B VDD VSS _17815_/D AND3BX1
XFILLER_24_1105 VDD VSS FILLER1
XFILLER_76_49 VDD VSS DECAPHV32
XFILLER_47_929 VDD VSS FILLER1
XFILLER_59_789 VSS VDD FILLER2
XFILLER_86_553 VDD VSS DECAPHV16
X_09837_ _09843_/A _10006_/B VDD VSS _17801_/D NOR2X1
Xclkbuf_leaf_3_clk_fs_regs clkbuf_leaf_5_clk_fs_regs/A VDD VSS clkload3/A BUFX12
XFILLER_132_44 VSS VDD FILLER2
XFILLER_46_417 VDD VSS FILLER1
XFILLER_46_439 VSS VDD FILLER2
XFILLER_74_748 VSS VDD FILLER2
X_09768_ _17692_/Q _17488_/B _09768_/C VDD VSS _09774_/A OAI21X1
XFILLER_15_826 VDD VSS DECAPHV8
XFILLER_42_601 VSS VDD FILLER2
XFILLER_54_450 VSS VDD FILLER2
XFILLER_54_461 VDD VSS FILLER1
XFILLER_70_910 VDD VSS FILLER1
X_09699_ _17658_/Q _17452_/B VDD VSS _09716_/B XOR2X1
X_11730_ _18329_/Q VDD VSS _11736_/A INVX1
XFILLER_109_1026 VSS VDD FILLER2
XFILLER_70_987 VDD VSS FILLER1
XTAP_TAPCELL_ROW_52_640 VDD VSS WELLTAP
X_11661_ _11661_/A _11661_/B _14283_/B VDD VSS _11662_/B MIN3X1
Xclkbuf_leaf_3__000_ clkload110/A VDD VSS _18801_/CK BUFX12
XTAP_TAPCELL_ROW_80_982 VDD VSS WELLTAP
X_10612_ _10614_/C _10612_/B VDD VSS _10750_/B OR2X2
X_11592_ _11592_/A _11592_/B _14282_/B VDD VSS _11593_/B MIN3X1
X_14380_ _14389_/A _14380_/B VDD VSS _18409_/D NOR2X1
X_13400_ _13493_/A _13493_/B _13493_/E VDD VSS _13410_/B AOI21X1
X_10543_ _17873_/Q _10543_/B VDD VSS _10544_/D _10543_/C NAND3X1
X_13331_ _18450_/Q VDD VSS _13356_/A INVX1
XFILLER_109_942 VDD VSS DECAPHV16
X_16050_ _18811_/Q _18703_/Q VDD VSS _16051_/D AND2X1
XFILLER_124_901 VSS VDD FILLER2
XFILLER_41_96 VSS VDD FILLER2
XFILLER_68_1010 VDD VSS FILLER4
XFILLER_6_546 VDD VSS DECAPHV32
X_10474_ _17866_/Q VDD VSS _10492_/A INVX1
X_13262_ _13262_/A _13262_/B _13262_/C _13262_/D VDD VSS _13512_/B OAOI211X1
X_15001_ _18621_/Q _18999_/Q _15001_/C VDD VSS _15009_/A MIN3X1
XFILLER_108_485 VSS VDD FILLER2
XFILLER_124_934 VSS VDD FILLER2
X_12213_ _12213_/A _12213_/B _12213_/C _12213_/D VDD VSS _14293_/B OAOI211X1
X_13193_ _13193_/A _14180_/B _13193_/C _13193_/D VDD VSS _13383_/A AOAI211X1
XFILLER_135_282 VDD VSS DECAPHV32
X_12144_ _14143_/B _14142_/C _12145_/A VDD VSS _12146_/C OAI21X1
XFILLER_97_829 VDD VSS FILLER1
X_12075_ _12210_/A _12210_/B _12210_/C VDD VSS _12179_/B AOI21X1
X_16952_ _18933_/Q _16952_/B VDD VSS _16953_/C AND2X1
XFILLER_38_907 VSS VDD FILLER2
XFILLER_49_266 VSS VDD FILLER2
X_11026_ _17964_/Q VDD VSS _11033_/A INVX1
X_16883_ _16883_/A _16888_/B VDD VSS _16885_/B XOR2X1
X_15903_ _16120_/A _15941_/B VDD VSS _15904_/B NOR2X1
XFILLER_64_203 VDD VSS FILLER4
XFILLER_77_586 VDD VSS FILLER1
XTAP_TAPCELL_ROW_108_1318 VDD VSS WELLTAP
X_18622_ clkload9/A _18622_/D _18622_/Q VDD VSS DFFQX1
X_15834_ _15834_/A _15834_/B _15834_/C VDD VSS _15872_/B MIN3X1
XFILLER_131_1090 VDD VSS DECAPHV16
XFILLER_92_545 VDD VSS FILLER4
X_18553_ clkload8/A _18553_/D _18553_/Q VDD VSS DFFQX1
XFILLER_75_1014 VDD VSS FILLER4
X_12977_ _12977_/A _12977_/B _12977_/C _12977_/D VDD VSS _14180_/C OAI211X1
X_17504_ _17561_/C _17739_/Q VDD VSS _17707_/D AND2X1
X_15765_ _18860_/Q _18861_/Q VDD VSS _15766_/C OR2X2
XFILLER_127_1115 VDD VSS FILLER1
XFILLER_17_185 VDD VSS FILLER1
X_11928_ _18228_/Q _12123_/A _12123_/B VDD VSS _11929_/D XNOR3X1
X_18484_ _18484_/CK _18484_/D _18484_/Q VDD VSS DFFQX1
X_15696_ _18885_/Q _15703_/C VDD VSS _15697_/B XOR2X1
X_14716_ _18561_/Q _18593_/Q VDD VSS _14723_/A XNOR2X1
XFILLER_21_807 VDD VSS FILLER1
XFILLER_60_464 VSS VDD FILLER2
XFILLER_82_81 VDD VSS DECAPHV32
X_11859_ _18176_/Q VDD VSS _11952_/A INVX1
X_17435_ _17561_/C _17435_/B VDD VSS _17642_/D AND2X1
X_14647_ _14696_/A _14647_/B VDD VSS _18545_/D NOR2X1
XFILLER_20_328 VDD VSS FILLER4
XFILLER_60_486 VDD VSS FILLER4
X_17366_ _17378_/A _17366_/B VDD VSS _17577_/D NOR2X1
X_14578_ _18530_/Q VDD VSS _14580_/A INVX1
X_16317_ _18791_/Q _18737_/Q VDD VSS _16321_/C AND2X1
X_13529_ _13653_/A _13653_/B VDD VSS _13588_/B NOR2X1
XFILLER_119_739 VDD VSS FILLER1
XTAP_TAPCELL_ROW_119_1447 VDD VSS WELLTAP
XTAP_TAPCELL_ROW_30_378 VDD VSS WELLTAP
X_17297_ _19015_/Q _17316_/B _17297_/C VDD VSS _17298_/B MIN3X1
X_19036_ _19036_/CK _19036_/D _19036_/Q VDD VSS DFFQX1
X_16248_ _18816_/Q _18708_/Q VDD VSS _16280_/A OR2X2
XFILLER_115_912 VSS VDD FILLER2
XFILLER_127_783 VDD VSS FILLER4
XTAP_TAPCELL_ROW_132_1603 VDD VSS WELLTAP
X_16179_ _16161_/Y _16179_/B _16179_/C VDD VSS _16181_/B NOR3BX1
XFILLER_130_904 VSS VDD FILLER2
XFILLER_49_0 VDD VSS DECAPHV32
XFILLER_114_466 VDD VSS FILLER1
XFILLER_102_639 VSS VDD FILLER2
XFILLER_68_542 VDD VSS FILLER1
XFILLER_28_428 VDD VSS DECAPHV8
XFILLER_55_225 VSS VDD FILLER2
XFILLER_95_394 VDD VSS DECAPHV8
X_09622_ _19046_/Q _17347_/B VDD VSS _09625_/B XNOR2X1
X_09553_ _09553_/A _09553_/B _09553_/C _09553_/D VDD VSS _09578_/B AOAI211X1
XFILLER_36_450 VDD VSS FILLER1
XFILLER_37_995 VSS VDD FILLER2
XFILLER_52_910 VSS VDD FILLER2
XFILLER_64_770 VDD VSS FILLER1
XFILLER_64_781 VSS VDD FILLER2
XFILLER_71_718 VDD VSS DECAPHV8
XFILLER_83_578 VDD VSS DECAPHV8
XTAP_TAPCELL_ROW_38_478 VDD VSS WELLTAP
X_09484_ _09484_/A _09499_/B VDD VSS _17409_/B XOR2X1
XFILLER_108_1081 VDD VSS DECAPHV8
XTAP_TAPCELL_ROW_98_1200 VDD VSS WELLTAP
XFILLER_109_216 VSS VDD FILLER2
XFILLER_132_230 VSS VDD FILLER2
X_10190_ _10194_/B _10204_/B _17824_/Q VDD VSS _10192_/C AOI21X1
XFILLER_127_88 VDD VSS FILLER4
XFILLER_79_818 VDD VSS FILLER4
XFILLER_78_339 VDD VSS FILLER1
XFILLER_8_1132 VDD VSS FILLER4
XFILLER_115_1052 VDD VSS FILLER1
XFILLER_120_469 VSS VDD FILLER2
XFILLER_98_1003 VSS VDD FILLER2
X_12900_ _13094_/B _12901_/C _18185_/Q VDD VSS _12902_/C AOI21X1
X_13880_ _18459_/Q _13898_/D _13895_/C VDD VSS _13892_/C XOR3X1
X_12831_ _12842_/A _12831_/B _13009_/D VDD VSS _12933_/C XNOR3X1
XFILLER_43_921 VDD VSS FILLER4
XFILLER_15_645 VDD VSS FILLER4
XFILLER_27_483 VSS VDD FILLER2
XFILLER_54_280 VDD VSS FILLER1
X_12762_ _12763_/A _12763_/B _12763_/D _12763_/C VDD VSS _13089_/B OAOI211X1
X_15550_ _15572_/A _15550_/B _15550_/C _15651_/A VDD VSS _15551_/C AOI211X1
XFILLER_42_453 VDD VSS DECAPHV16
XTAP_TAPCELL_ROW_103_1259 VDD VSS WELLTAP
X_11713_ _18252_/Q _11713_/B _11765_/C VDD VSS _11843_/B XNOR3X1
X_12693_ _12944_/A _12944_/B _12715_/C VDD VSS _12824_/C OAI21X1
X_15481_ _15431_/Y _15479_/Y _15596_/A VDD VSS _15599_/B MUX2X1
X_14501_ _14517_/A _14501_/B VDD VSS _18514_/D NOR2X1
XFILLER_14_177 VDD VSS FILLER4
XFILLER_30_615 VDD VSS FILLER4
XFILLER_52_40 VDD VSS FILLER4
X_11644_ _11742_/A _11678_/D VDD VSS _11670_/C XNOR2X1
X_17220_ _19002_/Q _17232_/B VDD VSS _17236_/B XNOR2X1
X_14432_ _17065_/A VDD VSS _14972_/A BUFX3
XFILLER_11_840 VDD VSS DECAPHV16
X_17151_ _17151_/A VDD VSS _17152_/C INVX1
XFILLER_52_95 VDD VSS FILLER1
XFILLER_7_811 VDD VSS DECAPHV16
X_11575_ _11675_/A _11623_/B _11623_/C VDD VSS _11754_/C OR3BX1
X_16102_ _16102_/A _16102_/B _16102_/C _16102_/D VDD VSS _16103_/C AOAI211X1
X_14363_ _14363_/A _14363_/B _14363_/C VDD VSS _14364_/C NOR3X1
X_10526_ _10533_/A _10533_/B _10533_/D _10533_/C VDD VSS _10685_/B OAI211X1
X_17082_ _17082_/A _17082_/B _17082_/C VDD VSS _17084_/A MIN3X1
X_14294_ _14296_/A _14294_/B _14294_/C VDD VSS _18336_/D NOR3X1
X_13314_ _13314_/A _13314_/B _13314_/C VDD VSS _14126_/B OR3X2
XFILLER_109_783 VDD VSS FILLER1
X_10457_ _10457_/A _10457_/B _10457_/C _10457_/D VDD VSS _10462_/C AOAI211X1
X_13245_ _14053_/A _13245_/B VDD VSS _18045_/D NOR2X1
X_16033_ _16973_/A _16069_/B _16033_/C _16033_/D VDD VSS _18899_/D OAI31X1
XFILLER_97_626 VDD VSS DECAPHV8
XTAP_TAPCELL_ROW_114_1388 VDD VSS WELLTAP
X_10388_ _10388_/A _10388_/B VDD VSS _10400_/A OR2X2
X_13176_ _18318_/Q VDD VSS _13234_/D INVX1
XFILLER_111_414 VDD VSS FILLER1
XFILLER_123_274 VDD VSS FILLER1
X_12127_ _12305_/A _12305_/B VDD VSS _14200_/B XNOR2X1
X_17984_ _18011_/CK _17984_/D _17984_/Q VDD VSS DFFQX1
X_12058_ _18979_/Q _18100_/Q VDD VSS _12261_/A AND2X1
X_16935_ _16942_/C _16942_/B VDD VSS _16936_/B NOR2BX1
XFILLER_120_970 VDD VSS FILLER1
XFILLER_120_981 VDD VSS FILLER1
XFILLER_77_92 VDD VSS FILLER1
XFILLER_93_810 VDD VSS DECAPHV8
X_11009_ _11015_/A _11015_/B VDD VSS _11012_/A NAND2X1
XFILLER_93_854 VDD VSS FILLER4
X_18605_ clkload1/A _18605_/D _18605_/Q VDD VSS DFFQX1
X_16866_ _16866_/A VDD VSS _16957_/A BUFX3
XFILLER_19_995 VDD VSS FILLER1
XFILLER_37_269 VSS VDD FILLER2
XFILLER_53_729 VDD VSS FILLER1
XFILLER_80_526 VDD VSS FILLER1
X_16797_ _16875_/A _16797_/B _16797_/C VDD VSS _18920_/D OAI21X1
X_15817_ _18034_/Q _18644_/Q VDD VSS _15885_/B XOR2X1
XFILLER_93_80 VDD VSS DECAPHV8
XTAP_TAPCELL_ROW_35_437 VDD VSS WELLTAP
XTAP_TAPCELL_ROW_82_1001 VDD VSS WELLTAP
X_18536_ clkload4/A _18536_/D _18536_/Q VDD VSS DFFQX1
X_15748_ _18937_/Q _15748_/B VDD VSS _15748_/Y XNOR2X1
XFILLER_21_604 VDD VSS FILLER1
XTAP_TAPCELL_ROW_63_779 VDD VSS WELLTAP
X_18467_ _18493_/CK _18467_/D _18467_/Q VDD VSS DFFQX1
XFILLER_20_103 VDD VSS FILLER1
XFILLER_61_784 VSS VDD FILLER2
X_17418_ _17423_/A _17418_/B VDD VSS _17626_/D NOR2X1
X_15679_ _18883_/Q _15736_/B VDD VSS _15680_/C NAND2X1
XFILLER_20_136 VSS VDD FILLER2
XTAP_TAPCELL_ROW_15_194 VDD VSS WELLTAP
X_18398_ _18478_/CK _18398_/D _18398_/Q VDD VSS DFFQX1
XFILLER_9_170 VDD VSS FILLER4
X_17349_ _17355_/A _17349_/B VDD VSS _19048_/D NOR2X1
X_19019_ _19019_/CK _19019_/D _19019_/Q VDD VSS DFFQX1
XFILLER_127_591 VDD VSS FILLER1
XTAP_TAPCELL_ROW_93_1130 VDD VSS WELLTAP
XFILLER_103_915 VDD VSS DECAPHV8
XFILLER_88_626 VSS VDD FILLER2
XTAP_TAPCELL_ROW_7_107 VDD VSS WELLTAP
XFILLER_103_948 VDD VSS DECAPHV8
XFILLER_115_797 VDD VSS FILLER1
X_08984_ _08984_/A _08984_/B VDD VSS _08985_/B XNOR2X1
XFILLER_102_469 VDD VSS DECAPHV8
XFILLER_87_147 VDD VSS FILLER1
Xclkbuf_leaf_2__001_ clkload74/A VDD VSS _17854_/CK BUFX12
XFILLER_28_247 VDD VSS FILLER1
XFILLER_83_342 VSS VDD FILLER2
XFILLER_95_191 VDD VSS FILLER1
X_09605_ _17750_/Q VDD VSS _17516_/B INVX1
XFILLER_83_375 VSS VDD FILLER2
X_09536_ _09536_/A _09553_/C VDD VSS _17412_/B XOR2X1
XFILLER_25_965 VDD VSS DECAPHV16
X_09467_ _19040_/Q _17341_/B VDD VSS _09468_/A NAND2BX1
XFILLER_24_497 VDD VSS FILLER4
XFILLER_52_773 VSS VDD FILLER2
XFILLER_106_1029 VSS VDD FILLER2
XFILLER_40_979 VDD VSS DECAPHV32
X_09398_ _09399_/A _09399_/B _09399_/C VDD VSS _09417_/C OA21X2
XFILLER_22_32 VDD VSS DECAPHV8
XFILLER_22_65 VDD VSS DECAPHV16
X_11360_ _11388_/A _11388_/B _11388_/C VDD VSS _11365_/B AOI21X1
XFILLER_4_825 VDD VSS DECAPHV32
X_10311_ _10311_/A _10311_/B _10311_/C VDD VSS _10314_/C NOR3X1
X_11291_ _18112_/Q VDD VSS _11349_/A INVX1
X_13030_ _18499_/Q _13033_/C VDD VSS _13032_/B XOR2X1
XFILLER_133_561 VDD VSS DECAPHV16
XFILLER_3_346 VDD VSS DECAPHV16
X_10242_ _17831_/Q _10242_/B _10242_/C VDD VSS _10247_/C MIN3X1
XFILLER_120_222 VDD VSS DECAPHV8
XFILLER_65_1068 VDD VSS FILLER1
X_10173_ _10356_/A _10356_/B _10356_/C _10357_/C VDD VSS _10370_/B AOAI211X1
XFILLER_78_147 VDD VSS DECAPHV16
XFILLER_78_169 VDD VSS FILLER1
Xclkbuf_leaf_21__000_ clkbuf_leaf_9__000_/A VDD VSS _18805_/CK BUFX12
X_16720_ _18829_/Q _18721_/Q VDD VSS _16723_/D NAND2X1
X_14981_ _14983_/A _14983_/B _14983_/C _14981_/D VDD VSS _18617_/D AOI31X1
X_13932_ _13935_/A _13935_/B _13937_/A _13935_/C VDD VSS _13932_/Y AOI211X1
XFILLER_75_876 VDD VSS DECAPHV16
X_16651_ _18056_/Q _18666_/Q VDD VSS _16684_/B NOR2X1
X_13863_ _18457_/Q _14433_/B _14433_/C VDD VSS _13870_/C OR3BX1
X_12814_ _18419_/Q VDD VSS _12927_/A INVX1
X_16582_ _16582_/A _16582_/B _16582_/C _16757_/A VDD VSS _16590_/B AOI22X1
X_15602_ _15600_/Y _18877_/Q VDD VSS _15617_/B NAND2BX1
X_13794_ _13794_/A _13794_/B _13794_/C _13794_/D VDD VSS _13860_/A AOAI211X1
XFILLER_16_987 VDD VSS FILLER4
X_12745_ _18235_/Q _12863_/B VDD VSS _12746_/D _12745_/C NAND3X1
X_18321_ _18376_/CK _18321_/D _18321_/Q VDD VSS DFFQX1
X_15533_ _15572_/A _15533_/B VDD VSS _15534_/C NAND2X1
XFILLER_15_464 VDD VSS FILLER1
XFILLER_43_784 VDD VSS FILLER4
XFILLER_70_570 VDD VSS DECAPHV16
XTAP_TAPCELL_ROW_32_407 VDD VSS WELLTAP
XTAP_TAPCELL_ROW_60_738 VDD VSS WELLTAP
X_12676_ _12783_/A _12783_/B VDD VSS _14063_/B XNOR2X1
X_18252_ _18252_/CK _18252_/D _18252_/Q VDD VSS DFFQX1
X_15464_ _15480_/A _15464_/B VDD VSS _15465_/C NAND2X1
X_11627_ _11696_/A _14078_/B _11686_/C VDD VSS _14079_/B AOI21BX1
X_18183_ _18250_/CK _18183_/D _18183_/Q VDD VSS DFFQX1
X_17203_ _17205_/B _17203_/B _17203_/C VDD VSS _18998_/D AOI21X1
X_15395_ _18914_/Q _15395_/B VDD VSS _15398_/B NAND2X1
X_14415_ _14542_/A VDD VSS _14440_/A BUFX3
XFILLER_128_344 VDD VSS FILLER1
XFILLER_128_355 VDD VSS DECAPHV32
XFILLER_7_641 VDD VSS DECAPHV8
XTAP_TAPCELL_ROW_116_1406 VDD VSS WELLTAP
XTAP_TAPCELL_ROW_12_164 VDD VSS WELLTAP
XTAP_TAPCELL_ROW_40_495 VDD VSS WELLTAP
X_11558_ _11558_/A _11558_/B _11614_/C _11558_/D VDD VSS _11691_/A OAOI211X1
X_17134_ _18021_/Q VDD VSS _17135_/A INVX1
X_14346_ _14346_/A _14346_/B VDD VSS _18382_/D NOR2X1
X_10509_ _10509_/A _10509_/B _10509_/C _10509_/D VDD VSS _10512_/B AOAI211X1
X_17065_ _17065_/A VDD VSS _17242_/A BUFX3
X_11489_ _11562_/A _11562_/B VDD VSS _14077_/B XNOR2X1
X_16016_ _16051_/A _16051_/B _16051_/C VDD VSS _16016_/Y OAI21X1
X_14277_ _14243_/Y _14277_/B _14277_/C VDD VSS _18322_/D AND3BX1
XFILLER_83_1113 VSS VDD FILLER2
X_13228_ _18215_/Q _13405_/A _13382_/C VDD VSS _13303_/C XNOR3X1
XFILLER_111_200 VDD VSS FILLER4
XFILLER_98_935 VDD VSS FILLER4
X_13159_ _13159_/A _14362_/B _13159_/C _13159_/D VDD VSS _13350_/A AOAI211X1
XFILLER_111_255 VDD VSS FILLER1
XFILLER_57_309 VDD VSS DECAPHV8
XTAP_TAPCELL_ROW_68_838 VDD VSS WELLTAP
X_17967_ _17993_/CK _17967_/D _17967_/Q VDD VSS DFFQX1
XFILLER_93_640 VDD VSS DECAPHV8
X_17898_ _18003_/CK _17898_/D _17898_/Q VDD VSS DFFQX1
X_16918_ _16925_/A _16918_/B VDD VSS _16920_/B XNOR2X1
XFILLER_19_770 VDD VSS FILLER1
XFILLER_92_150 VSS VDD FILLER2
XTAP_TAPCELL_ROW_127_1546 VDD VSS WELLTAP
X_16849_ _16850_/A _16850_/B _16850_/C VDD VSS _16854_/B OAI21X1
XFILLER_65_386 VSS VDD FILLER2
XFILLER_92_194 VDD VSS DECAPHV8
XFILLER_93_695 VDD VSS FILLER1
XTAP_TAPCELL_ROW_48_595 VDD VSS WELLTAP
XFILLER_81_868 VDD VSS DECAPHV16
X_09321_ _09332_/A _09332_/B VDD VSS _17369_/B XNOR2X1
X_18519_ clkload6/A _18519_/D _18519_/Q VDD VSS DFFQX1
XFILLER_22_979 VDD VSS DECAPHV8
X_09252_ _09232_/A _09252_/B VDD VSS _09281_/B NAND2BX1
X_09183_ _17671_/Q _17466_/B VDD VSS _09203_/C XNOR2X1
XFILLER_105_1073 VDD VSS DECAPHV8
XFILLER_119_333 VDD VSS DECAPHV8
XFILLER_30_990 VDD VSS DECAPHV16
XFILLER_0_305 VDD VSS DECAPHV8
XFILLER_102_200 VDD VSS FILLER1
XFILLER_130_531 VDD VSS FILLER4
XFILLER_76_607 VDD VSS FILLER4
XFILLER_88_445 VSS VDD FILLER2
XFILLER_102_277 VDD VSS DECAPHV8
XFILLER_29_501 VDD VSS DECAPHV16
X_08967_ _17754_/Q _18543_/Q VDD VSS _08972_/A XNOR2X1
XFILLER_5_1135 VDD VSS FILLER1
X_08898_ _17731_/Q _18520_/Q VDD VSS _08899_/B XOR2X1
XFILLER_17_32 VDD VSS DECAPHV16
XFILLER_56_353 VSS VDD FILLER2
XFILLER_84_49 VDD VSS DECAPHV32
X_10860_ _10863_/A _10863_/B VDD VSS _10998_/B XNOR2X1
XFILLER_17_87 VSS VDD FILLER2
XFILLER_25_740 VDD VSS FILLER4
X_09519_ _09519_/A _09543_/B VDD VSS _09520_/B XOR2X1
XFILLER_12_401 VDD VSS FILLER1
X_10791_ _10791_/A VDD VSS _10792_/B INVX1
XTAP_TAPCELL_ROW_100_1218 VDD VSS WELLTAP
X_12530_ _12530_/A _12530_/B _12530_/C _12530_/D VDD VSS _12846_/A OAOI211X1
XFILLER_8_416 VSS VDD FILLER2
X_12461_ _18156_/Q _12680_/A _12667_/B VDD VSS _12653_/D XNOR3X1
XTAP_TAPCELL_ROW_4_68 VDD VSS WELLTAP
X_11412_ _18273_/Q _11470_/B _11415_/C VDD VSS _14249_/B XNOR3X1
X_15180_ _17182_/D _18749_/Q VDD VSS _18722_/D AND2X1
X_14200_ _14217_/A _14200_/B VDD VSS _18256_/D NOR2X1
XFILLER_116_0 VDD VSS DECAPHV32
X_12392_ _12479_/B _12393_/B VDD VSS _12394_/B NOR2X1
X_14131_ _14160_/A _14131_/B VDD VSS _18193_/D NOR2X1
X_11343_ _18168_/Q VDD VSS _11426_/A INVX1
X_11274_ _18113_/Q _11314_/A _11319_/B VDD VSS _11294_/D XNOR3X1
X_14062_ _14253_/A VDD VSS _14083_/A BUFX3
XFILLER_3_176 VDD VSS DECAPHV8
X_10225_ _10268_/A _10411_/B VDD VSS _17853_/D NOR2X1
X_13013_ _14267_/B _14267_/C _18316_/Q VDD VSS _13014_/D AOI21X1
X_18870_ _18940_/CK _18870_/D _18870_/Q VDD VSS DFFQX1
XFILLER_121_531 VSS VDD FILLER2
XFILLER_133_391 VDD VSS DECAPHV8
XTAP_TAPCELL_ROW_111_1347 VDD VSS WELLTAP
X_17821_ _19038_/CK _17821_/D _17821_/Q VDD VSS DFFQX1
XFILLER_94_415 VSS VDD FILLER2
X_10156_ _10324_/B _10156_/B _10156_/C _10156_/D VDD VSS _10338_/B OAOI211X1
XFILLER_59_191 VDD VSS FILLER1
XFILLER_94_448 VDD VSS DECAPHV8
X_10087_ _17811_/Q _10087_/B VDD VSS _10088_/C OR2X2
X_17752_ clkload3/A _17752_/D _17752_/Q VDD VSS DFFQX1
X_14964_ _18614_/Q _18992_/Q VDD VSS _14965_/B XOR2X1
X_17683_ _17716_/CK _17683_/D _17683_/Q VDD VSS DFFQX1
X_16703_ _16703_/A _16746_/B VDD VSS _16704_/B XOR2X1
X_13915_ _13917_/A _13917_/B _13915_/C VDD VSS _14465_/B OA21X2
XFILLER_47_375 VDD VSS FILLER4
XFILLER_74_183 VSS VDD FILLER2
XFILLER_75_684 VDD VSS DECAPHV16
XFILLER_90_621 VDD VSS FILLER4
X_16634_ _16341_/B _16633_/Y _16800_/A VDD VSS _16678_/B MUX2X1
X_14895_ _18599_/Q _18631_/Q VDD VSS _14900_/A XNOR2X1
XTAP_TAPCELL_ROW_17_223 VDD VSS WELLTAP
XTAP_TAPCELL_ROW_45_554 VDD VSS WELLTAP
X_13846_ _18405_/Q _14375_/B VDD VSS _13876_/A NOR2X1
XFILLER_43_570 VDD VSS FILLER1
XFILLER_62_378 VSS VDD FILLER2
XTAP_TAPCELL_ROW_73_896 VDD VSS WELLTAP
X_10989_ _11148_/A _11126_/B VDD VSS _17983_/D AND2X1
X_16565_ _18913_/Q _16565_/B VDD VSS _16566_/C AND2X1
X_13777_ _13777_/A _13777_/B _13777_/C _13777_/D VDD VSS _13814_/A OAOI211X1
XTAP_TAPCELL_ROW_122_1487 VDD VSS WELLTAP
X_12728_ _12796_/A _12796_/B _12796_/D _12796_/C VDD VSS _14328_/B OAOI211X1
X_18304_ _18381_/CK _18304_/D _18304_/Q VDD VSS DFFQX1
X_16496_ _16531_/A _16531_/B _16567_/A VDD VSS _16524_/A AO21X2
X_15516_ _15433_/Y _15515_/Y _15526_/A VDD VSS _15519_/B MUXI2X1
XFILLER_90_81 VDD VSS DECAPHV32
X_12659_ _12765_/A _14177_/B VDD VSS _12859_/B NOR2X1
X_18235_ _18261_/CK _18235_/D _18235_/Q VDD VSS DFFQX1
Xclkbuf_leaf_1__002_ clkload25/A VDD VSS _18376_/CK BUFX12
Xclkbuf_2_1__f__002_ clkbuf_0__002_/Y VDD VSS clkbuf_leaf_9__002_/A BUFX12
X_15447_ _18902_/Q _15466_/B VDD VSS _15448_/B XOR2X1
XFILLER_30_297 VSS VDD FILLER2
X_18166_ _18195_/CK _18166_/D _18166_/Q VDD VSS DFFQX1
X_15378_ _16588_/A VDD VSS _16783_/A BUFX3
XFILLER_117_848 VDD VSS FILLER4
XFILLER_128_174 VDD VSS DECAPHV32
X_18097_ _18978_/CK _18097_/D _18097_/Q VDD VSS DFFQX1
X_17117_ _17117_/A _17117_/B _17117_/C VDD VSS _17122_/B OA21X2
X_14329_ _14332_/A _14329_/B _14329_/C VDD VSS _18367_/D NOR3X1
XFILLER_116_358 VDD VSS FILLER1
X_17048_ _17050_/A _17050_/B _17050_/C _17048_/D VDD VSS _18967_/D AOI31X1
XFILLER_112_520 VDD VSS FILLER1
XFILLER_87_1090 VSS VDD FILLER2
XTAP_TAPCELL_ROW_90_1100 VDD VSS WELLTAP
X_09870_ _09880_/C _09886_/C _09880_/B VDD VSS _09881_/C NOR3X1
XFILLER_31_0 VDD VSS DECAPHV32
XFILLER_58_607 VDD VSS FILLER4
XFILLER_97_220 VDD VSS FILLER1
XFILLER_97_242 VDD VSS FILLER4
XFILLER_98_743 VDD VSS DECAPHV16
XFILLER_39_810 VDD VSS FILLER4
X_18999_ clkload9/A _18999_/D _18999_/Q VDD VSS DFFQX1
XFILLER_66_662 VDD VSS FILLER4
XFILLER_66_695 VSS VDD FILLER2
XTAP_TAPCELL_ROW_88_1073 VDD VSS WELLTAP
XFILLER_53_334 VDD VSS DECAPHV8
XFILLER_54_879 VDD VSS FILLER4
XFILLER_80_142 VDD VSS FILLER4
XFILLER_81_654 VDD VSS FILLER1
XFILLER_13_209 VDD VSS DECAPHV16
XFILLER_94_1072 VDD VSS DECAPHV8
XFILLER_22_743 VDD VSS FILLER1
XFILLER_34_592 VDD VSS FILLER4
XFILLER_55_1034 VDD VSS FILLER1
X_09304_ _09304_/A _09304_/B VDD VSS _09330_/B NAND2X1
XFILLER_10_916 VDD VSS DECAPHV8
XFILLER_22_765 VDD VSS DECAPHV8
X_09235_ _17609_/Q _17400_/B VDD VSS _09248_/B XNOR2X1
Xclkbuf_leaf_20__001_ clkload75/A VDD VSS _18000_/CK BUFX12
X_09166_ _09172_/B _09166_/B VDD VSS _17329_/B XOR2X1
X_09097_ _17603_/Q _09097_/B _17393_/B VDD VSS _09123_/A MIN3X1
XFILLER_123_818 VSS VDD FILLER2
XFILLER_123_829 VDD VSS DECAPHV8
Xclkbuf_leaf_35__001_ clkload73/A VDD VSS _19042_/CK BUFX12
XFILLER_116_881 VSS VDD FILLER2
XFILLER_1_625 VDD VSS DECAPHV16
XFILLER_66_1130 VDD VSS FILLER4
XFILLER_131_840 VDD VSS FILLER1
XFILLER_88_231 VDD VSS FILLER1
X_10010_ _10213_/A _10213_/B _10213_/C _10214_/C VDD VSS _10222_/B AOAI211X1
XFILLER_135_88 VDD VSS FILLER4
XFILLER_76_404 VDD VSS FILLER4
XFILLER_77_927 VSS VDD FILLER2
X_09999_ _09999_/A VDD VSS _10000_/B INVX1
XFILLER_76_459 VDD VSS DECAPHV8
XFILLER_92_919 VDD VSS FILLER4
X_11961_ _18976_/Q _18097_/Q VDD VSS _12054_/A NAND2X1
XFILLER_29_375 VDD VSS FILLER4
XFILLER_44_312 VDD VSS FILLER4
XFILLER_56_183 VSS VDD FILLER2
XFILLER_91_429 VSS VDD FILLER2
X_10912_ _17942_/Q _10915_/B VDD VSS _10916_/B XNOR2X1
X_13700_ _18298_/Q _14248_/B VDD VSS _13701_/C NAND2X1
XFILLER_45_857 VDD VSS FILLER1
XFILLER_72_654 VDD VSS FILLER1
X_11892_ _18306_/Q _12174_/B _11917_/C VDD VSS _14289_/B XNOR3X1
X_14680_ _18553_/Q _18585_/Q VDD VSS _14684_/C XNOR2X1
XFILLER_60_849 VDD VSS FILLER4
XFILLER_73_1112 VDD VSS FILLER4
X_10843_ _10847_/C _10843_/B VDD VSS _10981_/B XNOR2X1
X_13631_ _13631_/A _14277_/B _13631_/C _13631_/D VDD VSS _13701_/B AOAI211X1
XFILLER_25_581 VSS VDD FILLER2
XFILLER_34_1107 VDD VSS FILLER1
XFILLER_44_85 VDD VSS FILLER1
XFILLER_71_197 VSS VDD FILLER2
XTAP_TAPCELL_ROW_42_524 VDD VSS WELLTAP
XTAP_TAPCELL_ROW_70_855 VDD VSS WELLTAP
X_10774_ _10777_/C _10774_/B VDD VSS _10906_/B XNOR2X1
X_16350_ _16567_/A _16424_/A VDD VSS _16378_/A OR2X2
X_13562_ _18244_/Q _14186_/B VDD VSS _13563_/D NOR2BX1
XFILLER_12_253 VDD VSS FILLER1
X_12513_ _12530_/A _12530_/B _12530_/C VDD VSS _14234_/B OAI21X1
X_16281_ _18818_/Q _18710_/Q VDD VSS _16283_/B XNOR2X1
X_15301_ _15304_/A _18042_/Q VDD VSS _18841_/D AND2X1
XFILLER_60_40 VDD VSS FILLER4
XFILLER_8_235 VDD VSS DECAPHV16
XFILLER_9_747 VDD VSS DECAPHV32
X_18020_ _18024_/CK _18020_/D _18020_/Q VDD VSS DFFQX1
X_13493_ _13493_/A _13493_/B _14185_/B _18243_/Q _13493_/E VDD VSS _13566_/C AOI221X1
XTAP_TAPCELL_ROW_22_281 VDD VSS WELLTAP
X_12444_ _12554_/A _14089_/B _12554_/C VDD VSS _14090_/B AOI21X1
X_15232_ _15286_/A _18800_/Q VDD VSS _18773_/D AND2X1
XFILLER_5_920 VDD VSS DECAPHV8
X_12375_ _12375_/A _12375_/B _12375_/C VDD VSS _12411_/A OAI21X1
X_15163_ _15274_/A _18733_/Q VDD VSS _18706_/D AND2X1
X_11326_ _11326_/A _11326_/B _11351_/C VDD VSS _14100_/B XNOR3X1
X_15094_ _17396_/A VDD VSS _17079_/A BUFX3
X_14114_ _14396_/A _14114_/B VDD VSS _18178_/D AND2X1
XFILLER_4_485 VDD VSS DECAPHV16
XFILLER_5_997 VDD VSS DECAPHV16
X_18922_ _18994_/CK _18922_/D _18922_/Q VDD VSS DFFQX1
X_14045_ _10382_/Y _14045_/B _14045_/C VDD VSS _18114_/D AND3BX1
XFILLER_122_840 VDD VSS DECAPHV8
X_11257_ _11278_/A _11278_/B VDD VSS _11259_/C _11278_/C NAND3X1
XFILLER_68_949 VSS VDD FILLER2
X_10208_ _17825_/Q _10208_/B VDD VSS _10212_/C _10208_/C NAND3X1
X_11188_ _11205_/A _17135_/B VDD VSS _18021_/D NOR2X1
X_18853_ _18853_/CK _18853_/D _18853_/Q VDD VSS DFFQX1
XFILLER_67_459 VDD VSS FILLER4
XFILLER_79_297 VDD VSS DECAPHV8
XTAP_TAPCELL_ROW_78_955 VDD VSS WELLTAP
X_10139_ _10139_/A VDD VSS _10149_/C INVX1
X_18784_ _18840_/CK _18784_/D _18784_/Q VDD VSS DFFQX1
X_17804_ _17851_/CK _17804_/D _17804_/Q VDD VSS DFFQX1
XFILLER_76_971 VDD VSS FILLER4
X_17735_ clkload6/A _17735_/D _17735_/Q VDD VSS DFFQX1
X_15996_ _18038_/Q _18648_/Q VDD VSS _16042_/A NAND2X1
XFILLER_75_470 VDD VSS FILLER1
XFILLER_85_92 VDD VSS FILLER1
XTAP_TAPCELL_ROW_124_1505 VDD VSS WELLTAP
X_14947_ _18609_/Q _18641_/Q _14947_/C VDD VSS _14949_/A MIN3X1
XFILLER_35_334 VDD VSS FILLER4
XFILLER_47_183 VSS VDD FILLER2
XFILLER_63_654 VDD VSS FILLER1
X_17666_ _17698_/CK _17666_/D _17666_/Q VDD VSS DFFQX1
X_14878_ _14878_/A _15026_/A _14878_/C VDD VSS _14881_/C MIN3X1
X_17597_ _17725_/CK _17597_/D _17597_/Q VDD VSS DFFQX1
X_16617_ _16617_/A _16617_/B _16757_/A VDD VSS _16626_/B OAI21X1
X_13829_ _18457_/Q VDD VSS _13861_/A INVX1
XFILLER_16_581 VDD VSS DECAPHV16
XFILLER_44_890 VDD VSS FILLER1
X_16548_ _18825_/Q _18717_/Q VDD VSS _16551_/A XNOR2X1
XFILLER_31_573 VDD VSS FILLER4
X_09020_ _09020_/A _09020_/B VDD VSS _17389_/B XNOR2X1
X_16479_ _16588_/A _16497_/C _16479_/C VDD VSS _16480_/C NOR3X1
XFILLER_102_1010 VDD VSS FILLER4
XFILLER_79_0 VDD VSS DECAPHV32
X_18218_ _18271_/CK _18218_/D _18218_/Q VDD VSS DFFQX1
XFILLER_8_780 VDD VSS DECAPHV8
XTAP_TAPCELL_ROW_135_1634 VDD VSS WELLTAP
X_18149_ _18200_/CK _18149_/D _18149_/Q VDD VSS DFFQX1
XFILLER_104_328 VDD VSS FILLER4
XFILLER_132_615 VDD VSS FILLER4
XFILLER_113_840 VDD VSS FILLER4
XFILLER_116_199 VDD VSS FILLER1
XFILLER_132_659 VDD VSS DECAPHV8
X_09922_ _17792_/Q _09936_/B VDD VSS _09928_/B XOR2X1
X_09853_ _09976_/A _10047_/A VDD VSS _17806_/D NOR2X1
XFILLER_112_372 VSS VDD FILLER2
XFILLER_59_949 VDD VSS FILLER4
X_09784_ _17759_/Q _17758_/Q VDD VSS _09879_/B XOR2X1
Xclkbuf_leaf_2_clk_fs_regs clkbuf_leaf_5_clk_fs_regs/A VDD VSS _18641_/CK BUFX12
XFILLER_22_1066 VSS VDD FILLER2
XFILLER_27_813 VDD VSS DECAPHV8
XFILLER_85_289 VSS VDD FILLER2
XFILLER_22_1088 VDD VSS FILLER1
XFILLER_14_44 VSS VDD FILLER2
XFILLER_50_882 VDD VSS FILLER1
X_09218_ _09218_/A _09218_/B VDD VSS _17763_/D NOR2X1
X_10490_ _10509_/A _10509_/B VDD VSS _10665_/B XNOR2X1
XFILLER_136_943 VSS VDD FILLER2
XFILLER_30_32 VDD VSS DECAPHV8
X_09149_ _09149_/A VDD VSS _17395_/B INVX1
XFILLER_135_464 VDD VSS FILLER1
XTAP_TAPCELL_ROW_1_25 VDD VSS WELLTAP
X_12160_ _18980_/Q _18101_/Q VDD VSS _12360_/B XOR2X1
XTAP_TAPCELL_ROW_1_36 VDD VSS WELLTAP
X_11111_ _11135_/A _17055_/B VDD VSS _18006_/D NOR2X1
XFILLER_104_851 VDD VSS FILLER1
XFILLER_123_648 VSS VDD FILLER2
X_12091_ _12194_/A _12194_/B _12097_/C VDD VSS _14470_/B XNOR3X1
XFILLER_110_309 VDD VSS DECAPHV8
XFILLER_1_455 VDD VSS DECAPHV8
X_11042_ _11062_/A _11175_/B VDD VSS _17992_/D AND2X1
XFILLER_118_1072 VDD VSS FILLER4
XFILLER_76_201 VDD VSS FILLER4
X_15850_ _15850_/A _15850_/B _15850_/C _15850_/D VDD VSS _15919_/B AOAI211X1
XFILLER_39_96 VSS VDD FILLER2
XFILLER_76_267 VDD VSS DECAPHV8
X_14801_ _14801_/A _14801_/B VDD VSS _14802_/B XNOR2X1
XFILLER_57_470 VDD VSS FILLER1
XFILLER_57_481 VDD VSS FILLER1
XTAP_TAPCELL_ROW_75_914 VDD VSS WELLTAP
X_12993_ _12993_/A _14121_/B _13085_/C _12993_/D VDD VSS _13216_/A OAOI211X1
X_15781_ _15917_/A _15781_/B _15781_/C _15781_/D VDD VSS _15804_/A OAI211X1
XFILLER_45_654 VSS VDD FILLER2
XFILLER_91_237 VSS VDD FILLER2
X_11944_ _11953_/A _11953_/B _12023_/C VDD VSS _14140_/C NOR3X1
X_17520_ _17523_/A _17754_/Q VDD VSS _17722_/D AND2X1
X_14732_ _18563_/Q _18595_/Q _14732_/C VDD VSS _14740_/A MIN3X1
XFILLER_17_367 VDD VSS FILLER4
XFILLER_33_827 VDD VSS FILLER1
XFILLER_44_142 VSS VDD FILLER2
XFILLER_45_698 VSS VDD FILLER2
XFILLER_72_451 VDD VSS DECAPHV16
XFILLER_73_985 VDD VSS FILLER1
XTAP_TAPCELL_ROW_27_340 VDD VSS WELLTAP
X_11875_ _18150_/Q _12045_/A _12052_/B VDD VSS _12025_/D XNOR3X1
X_17451_ _17453_/A _17451_/B VDD VSS _17657_/D AND2X1
X_14663_ _14661_/B _14663_/B VDD VSS _14664_/C NOR2BX1
XFILLER_60_646 VDD VSS DECAPHV8
XTAP_TAPCELL_ROW_55_682 VDD VSS WELLTAP
X_10826_ _17059_/C _10960_/B VDD VSS _17951_/D AND2X1
X_16402_ _16429_/A _16429_/B _16582_/A VDD VSS _16403_/C OAI21X1
X_13614_ _13686_/A _13686_/B _13686_/D _13686_/C VDD VSS _14338_/C AOI211X1
XFILLER_9_500 VDD VSS DECAPHV8
X_17382_ _17395_/A _17382_/B VDD VSS _17592_/D NOR2X1
X_14594_ _18534_/Q _18566_/Q VDD VSS _14596_/B XOR2X1
XFILLER_71_72 VSS VDD FILLER2
X_10757_ _17911_/Q _10761_/B VDD VSS _10758_/B XNOR2X1
X_16333_ _16333_/A _16333_/B _16333_/C _16333_/D VDD VSS _16390_/B AO211X2
X_13545_ _13639_/A _13639_/B _13639_/D _13639_/C VDD VSS _14370_/C AOI211X1
X_10688_ _17899_/Q _10691_/B _10688_/C VDD VSS _10822_/C XNOR3X1
X_19052_ _19052_/CK _19052_/D _19052_/Q VDD VSS DFFQX1
X_16264_ _16181_/Y _16263_/Y _16412_/A VDD VSS _16415_/B MUXI2X1
X_13476_ _18321_/Q _14276_/B VDD VSS _13558_/A NOR2BX1
X_12427_ _12530_/A _12530_/B VDD VSS _12466_/B NOR2X1
X_18003_ _18003_/CK _18003_/D _18003_/Q VDD VSS DFFQX1
X_15215_ _15299_/A _18784_/Q VDD VSS _18757_/D AND2X1
X_16195_ _16234_/A _16234_/B _16934_/A VDD VSS _16226_/A OAI21X1
X_12358_ _18129_/Q _12453_/D _12443_/C VDD VSS _12542_/C XOR3X1
X_15146_ _15313_/A _18716_/Q VDD VSS _18689_/D AND2X1
XFILLER_45_1011 VDD VSS DECAPHV8
X_11309_ _11379_/A _11309_/B _11309_/C VDD VSS _11383_/C NOR3X1
X_12289_ _18415_/Q VDD VSS _12490_/A INVX1
X_15077_ _18637_/Q _19015_/Q VDD VSS _15078_/C NAND2X1
XFILLER_110_810 VDD VSS FILLER4
XFILLER_68_702 VDD VSS FILLER1
XTAP_TAPCELL_ROW_130_1575 VDD VSS WELLTAP
X_18905_ _18913_/CK _18905_/D _18905_/Q VDD VSS DFFQX1
X_14028_ _17122_/D _18976_/Q VDD VSS _18097_/D AND2X1
X_18836_ _18837_/CK _18836_/D _18836_/Q VDD VSS DFFQX1
XFILLER_110_854 VDD VSS FILLER1
XFILLER_95_565 VSS VDD FILLER2
XFILLER_67_278 VDD VSS FILLER1
XFILLER_83_727 VDD VSS FILLER1
X_18767_ _18821_/CK _18767_/D _18767_/Q VDD VSS DFFQX1
X_15979_ _15979_/A _15979_/B VDD VSS _16020_/B _15979_/C _15979_/D NAND4X2
XFILLER_63_440 VDD VSS DECAPHV16
X_18698_ _18780_/CK _18698_/D _18698_/Q VDD VSS DFFQX1
X_17718_ _17722_/CK _17718_/D _17718_/Q VDD VSS DFFQX1
XTAP_TAPCELL_ROW_85_1043 VDD VSS WELLTAP
X_17649_ _17680_/CK _17649_/D _17649_/Q VDD VSS DFFQX1
XFILLER_91_1020 VSS VDD FILLER2
Xclkbuf_leaf_34__002_ clkload26/A VDD VSS _18368_/CK BUFX12
XFILLER_17_1135 VDD VSS FILLER1
XFILLER_118_910 VDD VSS FILLER1
Xclkbuf_leaf_49__002_ clkload25/A VDD VSS _18406_/CK BUFX12
XFILLER_136_228 VDD VSS DECAPHV32
X_09003_ _17631_/Q _17423_/B _09020_/A VDD VSS _09018_/A MIN3X1
XTAP_TAPCELL_ROW_96_1172 VDD VSS WELLTAP
XFILLER_105_648 VSS VDD FILLER2
XFILLER_63_1100 VDD VSS FILLER4
XFILLER_120_607 VDD VSS DECAPHV16
XFILLER_132_467 VDD VSS FILLER4
XFILLER_132_489 VDD VSS FILLER1
X_09905_ _10093_/B _09909_/B _09909_/D _09909_/C VDD VSS _10119_/B OAI211X1
XFILLER_101_832 VDD VSS FILLER4
XFILLER_113_670 VDD VSS FILLER1
XFILLER_113_681 VDD VSS FILLER1
X_09836_ _17775_/Q _09836_/B VDD VSS _10006_/B XOR2X1
XFILLER_18_109 VDD VSS FILLER1
X_09767_ _17660_/Q _17454_/B _09767_/C VDD VSS _09776_/A MIN3X1
XFILLER_27_654 VSS VDD FILLER2
XFILLER_39_481 VDD VSS FILLER1
X_09698_ _09718_/A _09718_/B VDD VSS _17452_/B XNOR2X1
XFILLER_14_304 VSS VDD FILLER2
XFILLER_26_131 VDD VSS FILLER1
XFILLER_26_142 VSS VDD FILLER2
XFILLER_82_782 VSS VDD FILLER2
XFILLER_92_49 VDD VSS DECAPHV32
XFILLER_25_32 VDD VSS DECAPHV8
XFILLER_25_54 VSS VDD FILLER2
XFILLER_54_484 VDD VSS FILLER1
XTAP_TAPCELL_ROW_24_310 VDD VSS WELLTAP
XFILLER_14_359 VDD VSS DECAPHV8
XTAP_TAPCELL_ROW_52_641 VDD VSS WELLTAP
X_11660_ _11664_/A _11664_/B _11660_/C VDD VSS _14283_/B XNOR3X1
XFILLER_10_510 VDD VSS FILLER1
XFILLER_22_370 VDD VSS FILLER1
XFILLER_41_167 VDD VSS FILLER1
XFILLER_41_189 VDD VSS FILLER1
XTAP_TAPCELL_ROW_80_983 VDD VSS WELLTAP
X_10611_ _10611_/A _10611_/B _10611_/C VDD VSS _10612_/B NOR3X1
X_11591_ _11595_/A _11595_/B _11591_/C VDD VSS _14282_/B XNOR3X1
X_10542_ _10543_/B _10543_/C _17873_/Q VDD VSS _10544_/C AOI21X1
X_13330_ _13330_/A _13330_/B _13330_/C _13343_/B VDD VSS _13511_/B AOAI211X1
XFILLER_10_587 VDD VSS FILLER1
XFILLER_41_64 VDD VSS DECAPHV8
XFILLER_6_514 VDD VSS DECAPHV32
X_13261_ _18448_/Q _13261_/B VDD VSS _13262_/C _13261_/C NAND3X1
X_10473_ _14310_/C _10654_/B VDD VSS _17891_/D AND2X1
X_12212_ _12296_/A _14260_/B VDD VSS _14293_/A NOR2X1
X_15000_ _15000_/A _15001_/C _15000_/C VDD VSS _18621_/D AOI21X1
XFILLER_109_987 VDD VSS FILLER4
X_13192_ _18213_/Q _14153_/B VDD VSS _13193_/D _14153_/C NAND3X1
XFILLER_124_979 VDD VSS DECAPHV8
XFILLER_68_1077 VDD VSS DECAPHV16
XFILLER_97_808 VDD VSS DECAPHV8
XFILLER_9_0 VDD VSS DECAPHV32
X_12143_ _18204_/Q VDD VSS _12145_/A INVX1
XFILLER_123_456 VDD VSS FILLER1
XFILLER_2_764 VDD VSS DECAPHV16
X_12074_ _12120_/A _12081_/B _12216_/D VDD VSS _12210_/C XNOR3X1
X_16951_ _16959_/C _16959_/A VDD VSS _16954_/A NOR2BX1
XFILLER_89_370 VSS VDD FILLER2
X_11025_ _11025_/A _11025_/B _11025_/C VDD VSS _11032_/A MIN3X1
X_15902_ _16196_/A _16155_/A _16023_/A _15902_/D VDD VSS _15941_/B AOI31X1
X_16882_ _18926_/Q _16882_/B _16882_/C VDD VSS _16888_/B MIN3X1
XFILLER_49_278 VDD VSS FILLER1
XTAP_TAPCELL_ROW_108_1319 VDD VSS WELLTAP
X_18621_ clkload9/A _18621_/D _18621_/Q VDD VSS DFFQX1
X_15833_ _16456_/A _15833_/B _15833_/C VDD VSS _18894_/D OAI21X1
XFILLER_80_708 VDD VSS FILLER4
X_18552_ clkload8/A _18552_/D _18552_/Q VDD VSS DFFQX1
X_15764_ _18862_/Q _15803_/B _15803_/C VDD VSS _15939_/C OAI21X1
XFILLER_61_922 VDD VSS FILLER1
X_12976_ _12977_/A _12977_/B _12977_/D _12977_/C VDD VSS _13120_/B OAOI211X1
X_17503_ _17518_/A _17503_/B VDD VSS _17706_/D NOR2X1
X_14715_ _14717_/C _14715_/B _14715_/C VDD VSS _18560_/D AOI21X1
XFILLER_127_1105 VDD VSS DECAPHV8
XFILLER_32_123 VDD VSS DECAPHV16
XFILLER_45_495 VDD VSS FILLER4
XFILLER_75_1026 VDD VSS DECAPHV16
X_11927_ _11930_/A _14167_/B _11927_/C _11927_/D VDD VSS _12123_/A AOAI211X1
X_18483_ _18509_/CK _18483_/D _18483_/Q VDD VSS DFFQX1
X_15695_ _15695_/A _15695_/B _15695_/C VDD VSS _15703_/C AOI21X1
XFILLER_14_860 VSS VDD FILLER2
XFILLER_61_988 VSS VDD FILLER2
X_11858_ _11953_/A _11953_/B VDD VSS _12023_/B NOR2X1
X_17434_ _17434_/A _17434_/B VDD VSS _17641_/D AND2X1
X_14646_ _14646_/A _14648_/C VDD VSS _14647_/B XNOR2X1
X_10809_ _10809_/A _10811_/C VDD VSS _10947_/B XNOR2X1
X_11789_ _11870_/A _11870_/B VDD VSS _11861_/B NOR2X1
X_17365_ _17434_/A _17365_/B VDD VSS _17576_/D AND2X1
X_14577_ _18531_/Q _18563_/Q VDD VSS _14582_/A XOR2X1
XFILLER_13_392 VDD VSS DECAPHV16
X_16316_ _16316_/A _16401_/B _16316_/C VDD VSS _16316_/Y NOR3X1
X_13528_ _13528_/A _13528_/B _13528_/C _13528_/D VDD VSS _13653_/B OAOI211X1
XFILLER_118_239 VDD VSS FILLER1
XFILLER_51_1070 VDD VSS FILLER4
XTAP_TAPCELL_ROW_119_1448 VDD VSS WELLTAP
XTAP_TAPCELL_ROW_30_379 VDD VSS WELLTAP
X_19035_ _19036_/CK _19035_/D _19035_/Q VDD VSS DFFQX1
X_17296_ _19016_/Q _17315_/B VDD VSS _17300_/B XNOR2X1
X_16247_ _16293_/A _16293_/C _16293_/B _16778_/A VDD VSS _16254_/B OAOI211X1
X_13459_ _13459_/A _14398_/B _14398_/C VDD VSS _13460_/D NOR3X1
XTAP_TAPCELL_ROW_132_1604 VDD VSS WELLTAP
X_16178_ _16239_/A _16239_/B _16178_/C VDD VSS _16179_/C AOI21X1
XFILLER_47_1106 VSS VDD FILLER2
X_15129_ _15295_/A _18699_/Q VDD VSS _18672_/D AND2X1
XFILLER_102_607 VDD VSS DECAPHV8
XFILLER_114_478 VDD VSS FILLER1
XFILLER_101_128 VDD VSS FILLER4
XFILLER_68_521 VDD VSS FILLER1
XFILLER_99_189 VDD VSS FILLER4
XFILLER_68_565 VDD VSS FILLER4
XFILLER_110_695 VSS VDD FILLER2
XFILLER_95_362 VDD VSS FILLER4
X_09621_ _09648_/B _09621_/B VDD VSS _17347_/B AND2X1
X_18819_ _18848_/CK _18819_/D _18819_/Q VDD VSS DFFQX1
XFILLER_110_1120 VDD VSS DECAPHV16
XFILLER_83_546 VDD VSS FILLER4
X_09552_ _17652_/Q _17445_/B VDD VSS _09553_/D OR2X2
XTAP_TAPCELL_ROW_38_479 VDD VSS WELLTAP
XFILLER_24_635 VDD VSS DECAPHV16
XFILLER_36_484 VDD VSS FILLER4
XFILLER_36_495 VSS VDD FILLER2
XFILLER_52_922 VDD VSS FILLER4
XFILLER_93_1115 VDD VSS FILLER1
X_09483_ _17650_/Q _17443_/B VDD VSS _09499_/B XOR2X1
XFILLER_51_443 VSS VDD FILLER2
XFILLER_23_189 VSS VDD FILLER2
XFILLER_51_476 VDD VSS FILLER4
XFILLER_30_1132 VDD VSS FILLER4
XFILLER_106_913 VDD VSS FILLER1
XFILLER_118_784 VDD VSS FILLER1
XFILLER_11_56 VDD VSS FILLER1
XFILLER_105_434 VDD VSS FILLER1
XFILLER_11_78 VDD VSS FILLER1
XFILLER_106_979 VSS VDD FILLER2
XFILLER_121_927 VSS VDD FILLER2
XFILLER_120_415 VSS VDD FILLER2
XFILLER_28_1072 VDD VSS FILLER4
XFILLER_47_727 VDD VSS FILLER1
XTAP_TAPCELL_ROW_57_700 VDD VSS WELLTAP
X_09819_ _09843_/A _09959_/B VDD VSS _17795_/D NOR2X1
XFILLER_28_952 VDD VSS DECAPHV8
XFILLER_98_1048 VDD VSS FILLER1
X_12830_ _18341_/Q VDD VSS _12842_/A INVX1
XFILLER_15_613 VDD VSS DECAPHV32
XFILLER_36_97 VDD VSS FILLER1
XFILLER_54_270 VDD VSS DECAPHV8
XFILLER_55_782 VDD VSS DECAPHV16
X_12761_ _18184_/Q _13086_/A _13086_/B VDD VSS _12763_/C XNOR3X1
XTAP_TAPCELL_ROW_103_1249 VDD VSS WELLTAP
X_11712_ _18226_/Q _11748_/B _11801_/D VDD VSS _11765_/C XNOR3X1
X_12692_ _18365_/Q _14327_/B VDD VSS _12944_/A AND2X1
X_15480_ _15480_/A VDD VSS _15596_/A BUFX3
X_14500_ _14500_/A _14500_/B _17388_/A VDD VSS _18513_/D OA21X2
XFILLER_35_1010 VDD VSS FILLER4
X_11643_ _18225_/Q wire28/Y _11801_/B VDD VSS _11678_/D XNOR3X1
X_14431_ _14431_/A _14431_/B _14431_/C VDD VSS _18456_/D NOR3X1
XFILLER_30_649 VDD VSS FILLER4
X_17150_ _18025_/Q _17155_/B VDD VSS _17156_/A XNOR2X1
XFILLER_10_362 VDD VSS FILLER1
XFILLER_122_1035 VDD VSS FILLER1
X_11574_ _11574_/A _14135_/B VDD VSS _11675_/A OR2X2
X_16101_ _16102_/A _16102_/B _16102_/D _16102_/C VDD VSS _16158_/B AO211X2
X_14362_ _14361_/Y _14362_/B _14362_/C VDD VSS _18394_/D AND3BX1
XFILLER_10_384 VDD VSS FILLER1
XFILLER_122_1068 VDD VSS FILLER1
X_10525_ _17871_/Q _10525_/B VDD VSS _10533_/C _10525_/C NAND3X1
X_17081_ _18011_/Q VDD VSS _17082_/A INVX1
X_14293_ _14293_/A _14293_/B _14293_/C VDD VSS _14294_/C NOR3X1
X_13313_ _13314_/A _13314_/C _13314_/B VDD VSS _14126_/A OAI21X1
X_10456_ _10456_/A _10456_/B VDD VSS _10457_/D OR2X2
X_13244_ _13338_/B _13244_/B VDD VSS _13245_/B XNOR2X1
X_16032_ _18899_/Q _16972_/B VDD VSS _16033_/D NAND2X1
X_13175_ _13350_/A _13350_/B _13350_/C VDD VSS _13269_/B AOI21X1
XFILLER_112_905 VSS VDD FILLER2
XFILLER_123_253 VDD VSS DECAPHV16
XFILLER_69_307 VDD VSS FILLER1
XFILLER_97_616 VDD VSS FILLER1
X_10387_ _10571_/A _10571_/B _10572_/C VDD VSS _10583_/B OAI21X1
X_12126_ _12126_/A _12126_/B _12126_/C _12126_/D VDD VSS _12305_/A AOAI211X1
XFILLER_112_938 VDD VSS FILLER4
XTAP_TAPCELL_ROW_114_1389 VDD VSS WELLTAP
X_17983_ _18011_/CK _17983_/D _17983_/Q VDD VSS DFFQX1
XFILLER_2_594 VDD VSS DECAPHV8
X_12057_ _18979_/Q _18100_/Q VDD VSS _12356_/A NOR2X1
X_16934_ _16934_/A _16934_/B _16934_/C _16934_/D VDD VSS _16942_/B OAOI211X1
XFILLER_37_204 VSS VDD FILLER2
XFILLER_78_896 VDD VSS FILLER1
XFILLER_81_1096 VDD VSS FILLER4
X_11008_ _17960_/Q _11008_/B VDD VSS _11015_/A NAND2X1
X_16865_ _16865_/A _16865_/B _16865_/C VDD VSS _16882_/B AO21X2
X_18604_ clkload1/A _18604_/D _18604_/Q VDD VSS DFFQX1
X_15816_ _18033_/Q _18643_/Q VDD VSS _15885_/A AND2X1
XFILLER_92_354 VDD VSS DECAPHV8
X_16796_ _18920_/Q _16862_/B VDD VSS _16797_/C NAND2X1
XFILLER_34_933 VDD VSS DECAPHV8
XFILLER_93_92 VDD VSS FILLER1
XTAP_TAPCELL_ROW_35_438 VDD VSS WELLTAP
XTAP_TAPCELL_ROW_82_1002 VDD VSS WELLTAP
X_12959_ _18290_/Q _14239_/B VDD VSS _13178_/A AND2X1
X_18535_ clkload4/A _18535_/D _18535_/Q VDD VSS DFFQX1
X_15747_ _16969_/A _15747_/B VDD VSS _15748_/B NOR2X1
XFILLER_60_240 VDD VSS FILLER4
XFILLER_61_741 VSS VDD FILLER2
XTAP_TAPCELL_ROW_63_769 VDD VSS WELLTAP
X_18466_ _18470_/CK _18466_/D _18466_/Q VDD VSS DFFQX1
X_15678_ _15689_/B _15678_/B VDD VSS _17004_/A XNOR2X1
XFILLER_34_999 VDD VSS FILLER1
X_17417_ _17453_/A _17417_/B VDD VSS _17625_/D AND2X1
X_14629_ _18541_/Q _18573_/Q VDD VSS _14630_/C NAND2X1
XFILLER_14_1105 VSS VDD FILLER2
XTAP_TAPCELL_ROW_15_195 VDD VSS WELLTAP
X_18397_ _18397_/CK _18397_/D _18397_/Q VDD VSS DFFQX1
X_17348_ _17355_/A _17348_/B VDD VSS _19047_/D NOR2X1
X_17279_ _19011_/Q _19012_/Q _17316_/B VDD VSS _17280_/B OAI21X1
XFILLER_61_0 VDD VSS DECAPHV32
X_19018_ _19019_/CK _19018_/D _19018_/Q VDD VSS DFFQX1
XTAP_TAPCELL_ROW_93_1131 VDD VSS WELLTAP
XFILLER_115_754 VDD VSS FILLER4
XTAP_TAPCELL_ROW_7_108 VDD VSS WELLTAP
XFILLER_102_426 VDD VSS DECAPHV16
XFILLER_87_126 VDD VSS FILLER1
X_08983_ _17757_/Q _18546_/Q VDD VSS _08984_/B XNOR2X1
XFILLER_114_297 VDD VSS FILLER1
XFILLER_130_757 VDD VSS DECAPHV8
XFILLER_60_1114 VSS VDD FILLER2
XFILLER_69_863 VDD VSS DECAPHV16
Xclkbuf_leaf_2__000_ clkload110/A VDD VSS _18853_/CK BUFX12
XFILLER_84_822 VSS VDD FILLER2
XFILLER_110_470 VDD VSS FILLER1
XFILLER_28_215 VDD VSS FILLER4
X_09604_ _09604_/A _09604_/B VDD VSS _09612_/B NAND2X1
XFILLER_37_760 VDD VSS FILLER1
XFILLER_44_719 VDD VSS FILLER1
XFILLER_56_568 VDD VSS FILLER4
XFILLER_25_933 VSS VDD FILLER2
X_09535_ _17652_/Q _17445_/B VDD VSS _09553_/C XNOR2X1
Xwire30 wire30/A VDD VSS wire30/Y BUFX4
XFILLER_19_1005 VSS VDD FILLER2
XFILLER_25_955 VDD VSS FILLER4
X_09466_ _09464_/Y _09468_/B _17446_/A VDD VSS _17772_/D AND3BX1
XFILLER_19_1038 VDD VSS FILLER1
XFILLER_40_914 VDD VSS FILLER4
XFILLER_40_936 VDD VSS DECAPHV8
XFILLER_51_273 VDD VSS FILLER4
X_09397_ _17647_/Q _17440_/B VDD VSS _09399_/C XNOR2X1
XFILLER_22_44 VSS VDD FILLER2
X_10310_ _10310_/A _10310_/B _10311_/C VDD VSS _10314_/B AOI21BX1
X_11290_ _11290_/A _11290_/B _14042_/B VDD VSS _11294_/A MIN3X1
XFILLER_3_314 VDD VSS DECAPHV32
X_10241_ _10268_/A _10427_/A VDD VSS _17856_/D NOR2X1
XFILLER_117_1104 VDD VSS DECAPHV8
X_10172_ _17823_/Q _10203_/A _10184_/B VDD VSS _10357_/C XNOR3X1
X_14980_ _14983_/A _14983_/B _14983_/C _17498_/A VDD VSS _14981_/D AOAI211X1
XFILLER_102_971 VDD VSS FILLER1
XFILLER_120_256 VSS VDD FILLER2
XFILLER_19_204 VDD VSS DECAPHV8
X_13931_ _18513_/Q _14500_/A _14500_/B VDD VSS _13935_/C NOR3X1
XFILLER_74_310 VDD VSS DECAPHV8
XFILLER_47_96 VDD VSS FILLER1
XFILLER_62_505 VDD VSS FILLER4
XFILLER_74_354 VDD VSS FILLER1
X_16650_ _18056_/Q _18666_/Q VDD VSS _16684_/C NAND2X1
X_13862_ _18458_/Q wire26/Y _13868_/B VDD VSS _13870_/D XOR3X1
XFILLER_28_793 VDD VSS FILLER4
X_12813_ _18445_/Q VDD VSS _12923_/A INVX1
X_16581_ _16616_/A _16581_/B VDD VSS _16582_/C XNOR2X1
X_15601_ _15600_/Y _18877_/Q VDD VSS _15617_/C NOR2BX1
X_13793_ _18456_/Q _14431_/B _14431_/C VDD VSS _13794_/D OR3BX1
XFILLER_103_80 VDD VSS DECAPHV8
XFILLER_90_869 VDD VSS FILLER4
X_12744_ _12863_/B _12745_/C _18235_/Q VDD VSS _12746_/C AOI21X1
X_18320_ _18397_/CK _18320_/D _18320_/Q VDD VSS DFFQX1
X_15532_ _15572_/A _15532_/B _15532_/C VDD VSS _15638_/B OAI21X1
XFILLER_15_487 VDD VSS DECAPHV8
XFILLER_31_925 VDD VSS FILLER1
XTAP_TAPCELL_ROW_32_408 VDD VSS WELLTAP
X_18251_ _18252_/CK _18251_/D _18251_/Q VDD VSS DFFQX1
XFILLER_70_593 VDD VSS FILLER1
XTAP_TAPCELL_ROW_60_739 VDD VSS WELLTAP
X_12675_ _18132_/Q _12891_/A _12779_/D VDD VSS _12781_/B XNOR3X1
X_17202_ _17205_/B _17203_/B _17544_/C VDD VSS _17203_/C OAI21X1
X_15463_ _15483_/A _15533_/B _15463_/C VDD VSS _15469_/B AOI21X1
X_11626_ _11693_/A _11693_/B VDD VSS _11760_/B NOR2X1
X_18182_ _18250_/CK _18182_/D _18182_/Q VDD VSS DFFQX1
X_15394_ _15392_/Y _15393_/Y _16588_/A VDD VSS _15401_/B MUX2X1
X_14414_ _14414_/A _14414_/B VDD VSS _18441_/D NOR2X1
XFILLER_128_323 VSS VDD FILLER2
XTAP_TAPCELL_ROW_12_165 VDD VSS WELLTAP
XTAP_TAPCELL_ROW_40_496 VDD VSS WELLTAP
X_11557_ _11635_/B _14078_/C _18145_/Q VDD VSS _11558_/D AND3BX1
X_17133_ _17131_/Y _17135_/C _17154_/A VDD VSS _18983_/D AND3BX1
X_14345_ _14346_/A _14345_/B VDD VSS _18381_/D NOR2X1
XFILLER_10_192 VDD VSS DECAPHV8
XFILLER_116_507 VDD VSS FILLER4
XTAP_TAPCELL_ROW_116_1407 VDD VSS WELLTAP
X_10508_ _10382_/Y _10673_/B _10673_/C VDD VSS _17896_/D AND3BX1
X_17064_ _17062_/Y _17069_/B VDD VSS _18970_/D NOR2BX1
XFILLER_6_174 VDD VSS DECAPHV32
XFILLER_7_686 VDD VSS DECAPHV32
X_11488_ _11488_/A _14075_/B _11488_/C _11488_/D VDD VSS _11562_/A AOAI211X1
X_16015_ _18811_/Q _18703_/Q VDD VSS _16051_/C XOR2X1
X_14276_ _14313_/A _14276_/B VDD VSS _18321_/D NOR2X1
X_10439_ _10436_/A _10439_/B VDD VSS _10440_/B NOR2BX1
X_13227_ _13316_/C _13314_/B _13227_/C VDD VSS _13382_/C XNOR3X1
XFILLER_88_81 VDD VSS DECAPHV32
X_13158_ _18369_/Q _14331_/B _14331_/C VDD VSS _13159_/D OR3BX1
XFILLER_111_234 VSS VDD FILLER2
XFILLER_111_245 VSS VDD FILLER2
XFILLER_69_137 VDD VSS DECAPHV16
XFILLER_97_468 VDD VSS DECAPHV8
XFILLER_98_969 VDD VSS FILLER1
X_12109_ _12109_/A _12109_/B _14322_/B VDD VSS _12205_/B MIN3X1
X_13089_ _13089_/A _13089_/B _13089_/C _13089_/D VDD VSS _13097_/B OAOI211X1
X_17966_ _17993_/CK _17966_/D _17966_/Q VDD VSS DFFQX1
XFILLER_111_278 VDD VSS FILLER1
XTAP_TAPCELL_ROW_68_839 VDD VSS WELLTAP
X_16917_ _16925_/D _16925_/B VDD VSS _16918_/B NAND2BX1
XFILLER_84_129 VDD VSS DECAPHV8
X_17897_ _18000_/CK _17897_/D _17897_/Q VDD VSS DFFQX1
XFILLER_53_505 VDD VSS DECAPHV8
XFILLER_66_866 VDD VSS FILLER1
XTAP_TAPCELL_ROW_127_1547 VDD VSS WELLTAP
X_16848_ _18924_/Q _16853_/B VDD VSS _16850_/C XOR2X1
XFILLER_53_538 VDD VSS FILLER4
XFILLER_66_899 VDD VSS DECAPHV8
XFILLER_80_324 VDD VSS FILLER1
XTAP_TAPCELL_ROW_48_596 VDD VSS WELLTAP
X_16779_ _18858_/Q _18696_/Q _16779_/C VDD VSS _16783_/B MIN3X1
X_09320_ _17612_/Q _17403_/B VDD VSS _09332_/B XOR2X1
X_18518_ _18990_/CK _18518_/D _18518_/Q VDD VSS DFFQX1
XFILLER_22_925 VDD VSS DECAPHV8
XFILLER_90_1107 VDD VSS FILLER4
X_09251_ _17673_/Q _17468_/B VDD VSS _09281_/A NAND2BX1
X_18449_ _18505_/CK _18449_/D _18449_/Q VDD VSS DFFQX1
XFILLER_21_468 VDD VSS DECAPHV16
X_09182_ _09206_/C _09182_/B VDD VSS _17466_/B XNOR2X1
XFILLER_134_315 VDD VSS DECAPHV8
XFILLER_103_702 VDD VSS FILLER4
XFILLER_115_584 VSS VDD FILLER2
XFILLER_130_510 VDD VSS FILLER1
XFILLER_88_468 VDD VSS DECAPHV16
XFILLER_89_969 VDD VSS DECAPHV8
XFILLER_25_1020 VSS VDD FILLER2
XFILLER_5_1114 VSS VDD FILLER2
XFILLER_69_660 VDD VSS FILLER1
X_08966_ _09218_/A _08966_/B VDD VSS _17753_/D NOR2X1
XFILLER_112_1001 VDD VSS FILLER1
X_08897_ _17730_/Q _18519_/Q _17533_/B VDD VSS _17535_/B AOI21X1
XFILLER_29_557 VDD VSS FILLER1
XFILLER_72_814 VDD VSS DECAPHV16
XFILLER_83_140 VSS VDD FILLER2
XFILLER_16_229 VSS VDD FILLER2
XFILLER_56_387 VDD VSS DECAPHV8
XFILLER_71_302 VDD VSS DECAPHV8
XFILLER_84_696 VDD VSS FILLER1
XFILLER_95_1018 VDD VSS FILLER1
X_09518_ _19042_/Q _17343_/B VDD VSS _09543_/B XOR2X1
XFILLER_25_763 VSS VDD FILLER2
XFILLER_25_785 VDD VSS FILLER1
XFILLER_71_368 VDD VSS FILLER4
X_10790_ _11062_/A _10918_/B VDD VSS _17943_/D AND2X1
XFILLER_13_958 VDD VSS DECAPHV8
XFILLER_24_295 VDD VSS FILLER1
XFILLER_33_32 VDD VSS DECAPHV16
XTAP_TAPCELL_ROW_100_1219 VDD VSS WELLTAP
X_09449_ _09449_/A _09449_/B VDD VSS _09450_/C NAND2X1
XFILLER_12_479 VDD VSS FILLER4
XFILLER_33_65 VDD VSS DECAPHV16
X_12460_ _12679_/C _12678_/B _12678_/C VDD VSS _12667_/B XNOR3X1
XTAP_TAPCELL_ROW_4_69 VDD VSS WELLTAP
X_11411_ _11473_/A _11473_/B _14189_/B VDD VSS _11415_/C XNOR3X1
X_12391_ _18493_/Q _12479_/C VDD VSS _12393_/B XOR2X1
X_11342_ _11342_/A _14102_/B _11342_/C VDD VSS _11430_/A MIN3X1
X_14130_ _14253_/A VDD VSS _14160_/A BUFX3
XFILLER_106_551 VDD VSS FILLER1
XFILLER_109_0 VDD VSS DECAPHV32
X_11273_ _18139_/Q VDD VSS _11326_/A INVX1
X_14061_ _14061_/A _14061_/B _15326_/C VDD VSS _18130_/D AOI21X1
XFILLER_106_562 VDD VSS FILLER4
XFILLER_133_370 VSS VDD FILLER2
XFILLER_134_871 VDD VSS FILLER1
X_10224_ _10414_/A _10414_/B VDD VSS _10411_/B XNOR2X1
X_13012_ _18316_/Q _14267_/B VDD VSS _13014_/C _14267_/C NAND3X1
XFILLER_58_40 VDD VSS FILLER4
XFILLER_95_906 VDD VSS FILLER4
XTAP_TAPCELL_ROW_111_1348 VDD VSS WELLTAP
X_10155_ _17820_/Q _10160_/B VDD VSS _10338_/A AND2X1
X_17820_ _19038_/CK _17820_/D _17820_/Q VDD VSS DFFQX1
XFILLER_79_468 VSS VDD FILLER2
X_10086_ _10114_/A _10282_/B VDD VSS _17838_/D NOR2X1
X_17751_ clkload3/A _17751_/D _17751_/Q VDD VSS DFFQX1
X_14963_ _18613_/Q _18991_/Q _14963_/C VDD VSS _14967_/B AOI21X1
XFILLER_48_866 VDD VSS FILLER1
XFILLER_48_888 VDD VSS FILLER1
X_17682_ _17716_/CK _17682_/D _17682_/Q VDD VSS DFFQX1
X_16702_ _16415_/Y _16701_/Y _16800_/A VDD VSS _16746_/B MUXI2X1
X_14894_ _14896_/C _14894_/B _14894_/C VDD VSS _18598_/D AOI21X1
X_13914_ _18460_/Q _14436_/B VDD VSS _13915_/C NAND2X1
XFILLER_62_324 VDD VSS FILLER1
X_16633_ _16857_/A _16633_/B _16633_/C VDD VSS _16633_/Y OAI21X1
X_13845_ _13845_/A _13845_/B VDD VSS _14375_/B XOR2X1
XFILLER_16_752 VDD VSS DECAPHV16
XTAP_TAPCELL_ROW_17_224 VDD VSS WELLTAP
XTAP_TAPCELL_ROW_45_555 VDD VSS WELLTAP
XTAP_TAPCELL_ROW_73_897 VDD VSS WELLTAP
X_10988_ _10988_/A _10991_/B VDD VSS _11126_/B XNOR2X1
X_18303_ _18381_/CK _18303_/D _18303_/Q VDD VSS DFFQX1
X_16564_ _16875_/A _16564_/B _16564_/C VDD VSS _18913_/D OAI21X1
X_13776_ _13776_/A _14459_/B _14459_/C VDD VSS _13777_/D NOR3X1
XFILLER_128_1063 VDD VSS FILLER4
XTAP_TAPCELL_ROW_122_1477 VDD VSS WELLTAP
XTAP_TAPCELL_ROW_122_1488 VDD VSS WELLTAP
X_12727_ _18340_/Q _13009_/A _13009_/B VDD VSS _12796_/C XNOR3X1
X_16495_ _16530_/A _16530_/B VDD VSS _16526_/A NAND2X1
X_15515_ _15479_/Y _15514_/Y _15596_/A VDD VSS _15515_/Y MUXI2X1
XFILLER_129_610 VDD VSS FILLER1
X_12658_ _12751_/A _14148_/B VDD VSS _12765_/A NOR2X1
X_18234_ _18261_/CK _18234_/D _18234_/Q VDD VSS DFFQX1
Xclkbuf_leaf_1__001_ clkload73/A VDD VSS _19051_/CK BUFX12
Xclkbuf_2_1__f__001_ clkbuf_0__001_/Y VDD VSS clkbuf_2_1__f__001_/Y BUFX12
X_15446_ _15673_/A _15517_/B _15517_/C _15526_/A VDD VSS _15449_/C OAI211X1
XFILLER_129_643 VDD VSS DECAPHV8
XFILLER_50_1124 VDD VSS DECAPHV8
X_11609_ _11623_/A _11623_/B _11623_/C VDD VSS _11612_/C NOR3X1
X_18165_ _18195_/CK _18165_/D _18165_/Q VDD VSS DFFQX1
XFILLER_11_1119 VDD VSS DECAPHV16
XFILLER_128_142 VDD VSS DECAPHV32
X_12589_ _12591_/B _12700_/A _12589_/C VDD VSS _12700_/B NOR3BX1
X_17116_ _17117_/A _17117_/B _17117_/C VDD VSS _17118_/B NOR3X1
X_15377_ _16326_/A VDD VSS _16588_/A BUFX3
X_18096_ _18982_/CK _18096_/D _18096_/Q VDD VSS DFFQX1
X_14328_ _14332_/A _14328_/B _14328_/C VDD VSS _18366_/D NOR3X1
XFILLER_48_1020 VDD VSS DECAPHV8
XFILLER_98_700 VDD VSS FILLER4
XFILLER_99_80 VDD VSS DECAPHV8
X_17047_ _17050_/A _17050_/B _17050_/C _17059_/C VDD VSS _17048_/D AOAI211X1
X_14259_ _14269_/A _14259_/B VDD VSS _18308_/D NOR2X1
XTAP_TAPCELL_ROW_90_1101 VDD VSS WELLTAP
Xclkbuf_leaf_1_clk_fs_regs clkbuf_leaf_5_clk_fs_regs/A VDD VSS clkload2/A BUFX12
XFILLER_100_716 VDD VSS FILLER1
XFILLER_24_0 VDD VSS DECAPHV32
X_18998_ clkload9/A _18998_/D _18998_/Q VDD VSS DFFQX1
XFILLER_66_630 VDD VSS FILLER4
X_17949_ _18003_/CK _17949_/D _17949_/Q VDD VSS DFFQX1
XFILLER_26_538 VDD VSS FILLER4
XFILLER_38_365 VDD VSS FILLER1
XFILLER_81_611 VDD VSS FILLER1
XTAP_TAPCELL_ROW_88_1074 VDD VSS WELLTAP
XFILLER_0_1033 VSS VDD FILLER2
XFILLER_0_80 VDD VSS DECAPHV8
XFILLER_80_121 VDD VSS FILLER1
XFILLER_22_700 VDD VSS FILLER1
XFILLER_55_1002 VDD VSS DECAPHV8
XFILLER_107_1114 VSS VDD FILLER2
XFILLER_55_1046 VDD VSS FILLER1
X_09303_ _09294_/A _09303_/B VDD VSS _09304_/B NAND2BX1
X_09234_ _09250_/B _09234_/B VDD VSS _17400_/B XNOR2X1
Xclkbuf_leaf_20__000_ clkbuf_leaf_9__000_/A VDD VSS _18780_/CK BUFX12
X_09165_ _17574_/Q _17363_/B VDD VSS _09166_/B XNOR2X1
X_09096_ _09096_/A _09096_/B _17360_/B VDD VSS _09119_/A MIN3X1
XFILLER_89_722 VDD VSS DECAPHV16
XFILLER_0_125 VDD VSS DECAPHV8
XFILLER_103_532 VDD VSS DECAPHV8
XFILLER_27_1126 VDD VSS DECAPHV8
XFILLER_62_1006 VSS VDD FILLER2
XFILLER_88_243 VDD VSS FILLER1
XFILLER_49_619 VDD VSS FILLER4
XFILLER_88_276 VDD VSS FILLER1
X_09998_ _10194_/A _10194_/B _10195_/A _09998_/D VDD VSS _10213_/A AOAI211X1
XFILLER_28_32 VDD VSS DECAPHV8
XFILLER_88_298 VDD VSS FILLER4
XFILLER_9_1080 VDD VSS DECAPHV16
X_08949_ _08952_/A _08949_/B _08949_/C VDD VSS _17749_/D AOI21X1
X_11960_ _12063_/A _14112_/B VDD VSS _11973_/B NOR2X1
XFILLER_45_836 VDD VSS FILLER1
XFILLER_57_685 VDD VSS FILLER1
X_10911_ _10911_/A _10911_/B _10911_/C VDD VSS _10916_/A AOI21X1
X_11891_ _18280_/Q _12173_/B _14227_/B VDD VSS _11917_/C XNOR3X1
X_10842_ _17929_/Q _10846_/A VDD VSS _10843_/B XNOR2X1
X_13630_ _14247_/A _14247_/B _18297_/Q VDD VSS _13631_/D OAI21X1
XFILLER_73_1135 VDD VSS FILLER1
XTAP_TAPCELL_ROW_42_525 VDD VSS WELLTAP
X_10773_ _17914_/Q _10777_/B VDD VSS _10774_/B XNOR2X1
X_13561_ _13631_/A _14277_/B VDD VSS _13611_/B AND2X1
XFILLER_52_390 VSS VDD FILLER2
XTAP_TAPCELL_ROW_70_856 VDD VSS WELLTAP
X_12512_ _12634_/A _14296_/B VDD VSS _12723_/B NOR2X1
X_16280_ _16280_/A _16280_/B _16280_/C _16280_/D VDD VSS _16333_/A AOI31X1
X_15300_ _15300_/A _18041_/Q VDD VSS _18840_/D AND2X1
XFILLER_100_81 VDD VSS DECAPHV32
X_15231_ _15286_/A _18799_/Q VDD VSS _18772_/D AND2X1
X_13492_ _18243_/Q _14185_/B VDD VSS _13566_/A NOR2X1
XFILLER_126_602 VSS VDD FILLER2
XTAP_TAPCELL_ROW_22_282 VDD VSS WELLTAP
X_12443_ _18129_/Q _12453_/D _12443_/C VDD VSS _12554_/C XNOR3X1
XFILLER_126_635 VDD VSS FILLER4
X_12374_ _12374_/A _12374_/B _12374_/C _12374_/D VDD VSS _14325_/B OAOI211X1
X_15162_ _15274_/A _18732_/Q VDD VSS _18705_/D AND2X1
XFILLER_5_965 VDD VSS DECAPHV32
X_11325_ _18165_/Q VDD VSS _11327_/A INVX1
X_15093_ _15093_/A _15093_/B VDD VSS _18641_/D NOR2X1
X_14113_ _14108_/Y _14113_/B _14113_/C VDD VSS _18177_/D AND3BX1
XFILLER_107_882 VSS VDD FILLER2
XFILLER_125_189 VDD VSS DECAPHV32
XFILLER_4_453 VDD VSS DECAPHV32
X_11256_ _11263_/A _11263_/B _11263_/C VDD VSS _11259_/B OAI21X1
X_18921_ _18994_/CK _18921_/D _18921_/Q VDD VSS DFFQX1
X_14044_ _14053_/A _14044_/B VDD VSS _18113_/D NOR2X1
XFILLER_121_362 VDD VSS FILLER4
XFILLER_68_917 VDD VSS FILLER1
X_10207_ _17826_/Q _10213_/A _10213_/B VDD VSS _10212_/D XNOR3X1
X_11187_ _11189_/A _11189_/B VDD VSS _17135_/B XNOR2X1
X_18852_ _18852_/CK _18852_/D _18852_/Q VDD VSS DFFQX1
XFILLER_94_202 VDD VSS FILLER1
XFILLER_94_235 VDD VSS DECAPHV8
X_10138_ _10138_/A _10147_/B VDD VSS _10149_/B AND2X1
X_18783_ _18837_/CK _18783_/D _18783_/Q VDD VSS DFFQX1
X_17803_ _17851_/CK _17803_/D _17803_/Q VDD VSS DFFQX1
X_15995_ _15995_/A VDD VSS _16973_/A BUFX3
XTAP_TAPCELL_ROW_78_956 VDD VSS WELLTAP
X_10069_ _10069_/A VDD VSS _10070_/B INVX1
X_17734_ clkload6/A _17734_/D _17734_/Q VDD VSS DFFQX1
X_14946_ _15093_/A _14946_/B VDD VSS _18609_/D NOR2X1
XFILLER_36_814 VSS VDD FILLER2
XFILLER_75_460 VDD VSS FILLER4
XTAP_TAPCELL_ROW_124_1506 VDD VSS WELLTAP
X_17665_ _17698_/CK _17665_/D _17665_/Q VDD VSS DFFQX1
X_14877_ _18626_/Q VDD VSS _15026_/A INVX1
XFILLER_78_1079 VDD VSS FILLER4
X_17596_ _19052_/CK _17596_/D _17596_/Q VDD VSS DFFQX1
X_16616_ _16616_/A _16616_/B _16616_/C VDD VSS _16617_/B AOI21X1
X_13828_ _13867_/A _13867_/B VDD VSS _13852_/B NAND2X1
X_16547_ _16542_/Y _16547_/B _16547_/C _16547_/D VDD VSS _16553_/B AOI2B2X1
X_13759_ _18352_/Q _14311_/B VDD VSS _13806_/D XOR2X1
XFILLER_31_596 VDD VSS FILLER1
X_18217_ _18295_/CK _18217_/D _18217_/Q VDD VSS DFFQX1
X_16478_ _16478_/A _16478_/B _16478_/C _16478_/D VDD VSS _16479_/C OA211X2
XFILLER_15_1063 VDD VSS DECAPHV16
X_15429_ _18916_/Q _15457_/C VDD VSS _15430_/B NAND2X1
XFILLER_129_473 VDD VSS FILLER4
XTAP_TAPCELL_ROW_135_1635 VDD VSS WELLTAP
X_18148_ _18152_/CK _18148_/D _18148_/Q VDD VSS DFFQX1
XFILLER_102_1066 VSS VDD FILLER2
X_18079_ _18835_/CK _18079_/D _18079_/Q VDD VSS DFFQX1
X_09921_ _17791_/Q _09921_/B VDD VSS _09928_/A NAND2X1
XFILLER_113_874 VDD VSS FILLER4
XFILLER_58_416 VSS VDD FILLER2
XFILLER_59_917 VDD VSS DECAPHV8
X_09852_ _17780_/Q _09857_/C VDD VSS _10047_/A XNOR2X1
X_09783_ _09783_/A _09783_/B _09783_/C _09783_/D VDD VSS _17784_/D OAOI211X1
XFILLER_22_1034 VDD VSS FILLER1
XFILLER_67_950 VDD VSS DECAPHV8
XFILLER_67_972 VDD VSS FILLER1
XFILLER_85_257 VDD VSS DECAPHV8
XFILLER_27_836 VDD VSS FILLER1
XFILLER_96_1102 VDD VSS FILLER1
XFILLER_27_869 VDD VSS FILLER1
XFILLER_53_132 VSS VDD FILLER2
XFILLER_81_441 VDD VSS FILLER4
XFILLER_26_357 VDD VSS DECAPHV8
XFILLER_42_828 VSS VDD FILLER2
XFILLER_54_666 VDD VSS FILLER4
XFILLER_57_1119 VDD VSS DECAPHV16
XFILLER_82_986 VDD VSS FILLER1
XFILLER_35_891 VDD VSS FILLER4
XFILLER_14_89 VDD VSS FILLER1
XFILLER_33_1130 VDD VSS FILLER4
X_09217_ _09219_/B _09217_/B VDD VSS _09218_/B XOR2X1
X_09148_ _09148_/A _09148_/B _09148_/C VDD VSS _09172_/B OA21X2
XFILLER_30_44 VSS VDD FILLER2
X_09079_ _09079_/A VDD VSS _17320_/B INVX1
XFILLER_136_988 VSS VDD FILLER2
XTAP_TAPCELL_ROW_1_26 VDD VSS WELLTAP
X_11110_ _11112_/C _11110_/B VDD VSS _17055_/B XNOR2X1
XFILLER_104_841 VDD VSS DECAPHV8
XFILLER_107_189 VDD VSS DECAPHV16
XFILLER_122_137 VSS VDD FILLER2
X_12090_ _18438_/Q _14411_/B _12193_/C VDD VSS _12097_/C XNOR3X1
XFILLER_2_979 VDD VSS DECAPHV32
XFILLER_89_574 VDD VSS FILLER1
X_11041_ _11045_/C _11041_/B VDD VSS _11175_/B XNOR2X1
XFILLER_39_64 VDD VSS DECAPHV16
XFILLER_18_803 VDD VSS FILLER1
XFILLER_76_235 VDD VSS DECAPHV32
XFILLER_92_706 VDD VSS DECAPHV8
Xclkbuf_leaf_0__002_ clkload25/A VDD VSS _18431_/CK BUFX12
X_14800_ _18578_/Q _18610_/Q VDD VSS _14801_/B XNOR2X1
XFILLER_18_825 VDD VSS DECAPHV8
XFILLER_29_151 VSS VDD FILLER2
XFILLER_45_611 VDD VSS FILLER4
XFILLER_73_920 VSS VDD FILLER2
XFILLER_85_780 VDD VSS DECAPHV8
XFILLER_92_739 VSS VDD FILLER2
XTAP_TAPCELL_ROW_75_915 VDD VSS WELLTAP
X_12992_ _13105_/B _14095_/C _18160_/Q VDD VSS _12993_/D AND3BX1
X_15780_ _15799_/B _18751_/Q _15978_/A _15780_/D VDD VSS _15781_/D AOI22X1
XFILLER_18_869 VDD VSS FILLER1
XFILLER_45_644 VDD VSS FILLER4
XFILLER_84_290 VDD VSS DECAPHV16
X_11943_ _12029_/A _14139_/B _12023_/C VDD VSS _14140_/B AOI21BX1
X_14731_ _14731_/A _14732_/C _14731_/C VDD VSS _18563_/D AOI21X1
XFILLER_55_96 VDD VSS DECAPHV8
XFILLER_73_975 VDD VSS DECAPHV8
XTAP_TAPCELL_ROW_27_341 VDD VSS WELLTAP
X_11874_ _18124_/Q _11874_/B _12040_/C VDD VSS _12052_/B XNOR3X1
X_17450_ _17453_/A _17450_/B VDD VSS _17656_/D AND2X1
X_14662_ _14696_/A _14662_/B VDD VSS _18549_/D NOR2X1
XTAP_TAPCELL_ROW_55_683 VDD VSS WELLTAP
X_10825_ _10823_/Y _10825_/B VDD VSS _10960_/B NOR2BX1
X_17381_ _17396_/A VDD VSS _17395_/A BUFX3
X_16401_ _16401_/A _16401_/B _16401_/C _16401_/D VDD VSS _16429_/B OAOI211X1
X_13613_ _13613_/A _13613_/B _13613_/C _13613_/D VDD VSS _14339_/B OAOI211X1
XFILLER_111_80 VDD VSS DECAPHV8
XFILLER_13_530 VDD VSS FILLER1
X_16332_ _16333_/A _16333_/B _16333_/C _16333_/D VDD VSS _16335_/B AOAI211X1
X_14593_ _18533_/Q _18565_/Q _14593_/C VDD VSS _14598_/C AO21X2
XFILLER_13_563 VDD VSS FILLER1
XFILLER_13_585 VSS VDD FILLER2
XFILLER_38_1085 VDD VSS FILLER1
XFILLER_9_512 VSS VDD FILLER2
X_10756_ _17910_/Q _10756_/B _10756_/C VDD VSS _10761_/C AOI21X1
X_13544_ _13544_/A _13544_/B _13544_/C _13544_/D VDD VSS _14370_/B OAOI211X1
XFILLER_9_578 VSS VDD FILLER2
X_10687_ _10687_/A _10687_/B VDD VSS _10691_/B NOR2X1
X_19051_ _19051_/CK _19051_/D _19051_/Q VDD VSS DFFQX1
X_16263_ _16411_/A _16263_/B _16263_/C VDD VSS _16263_/Y AOI21X1
X_13475_ _13475_/A _14335_/B _13475_/C _13475_/D VDD VSS _13613_/A OAOI211X1
XFILLER_126_421 VDD VSS DECAPHV16
XFILLER_127_933 VDD VSS DECAPHV16
X_12426_ _12514_/A _14203_/B VDD VSS _12530_/A NOR2X1
X_18002_ _18025_/CK _18002_/D _18002_/Q VDD VSS DFFQX1
X_16194_ _16194_/A _16194_/B VDD VSS _16234_/A NAND2X1
X_15214_ _15272_/A _18783_/Q VDD VSS _18756_/D AND2X1
XFILLER_127_977 VDD VSS FILLER4
X_15145_ _15313_/A _18715_/Q VDD VSS _18688_/D AND2X1
XFILLER_114_616 VDD VSS FILLER1
XFILLER_126_487 VDD VSS DECAPHV8
X_12357_ _18981_/Q _18102_/Q _12361_/B VDD VSS _12443_/C MIN3X1
XFILLER_84_1050 VDD VSS DECAPHV8
X_11308_ _11309_/B _11309_/C _11379_/A VDD VSS _11383_/B OAI21X1
X_12288_ _18440_/Q _12397_/B _12397_/C VDD VSS _12484_/B MIN3X1
X_15076_ _18638_/Q _19016_/Q VDD VSS _15080_/B AND2X1
XFILLER_84_1072 VDD VSS FILLER4
XTAP_TAPCELL_ROW_130_1576 VDD VSS WELLTAP
X_11239_ _18964_/Q _18085_/Q VDD VSS _11278_/A NAND2X1
X_18904_ _18961_/CK _18904_/D _18904_/Q VDD VSS DFFQX1
X_14027_ _17122_/D _18975_/Q VDD VSS _18096_/D AND2X1
XFILLER_45_1056 VSS VDD FILLER2
XFILLER_67_224 VSS VDD FILLER2
XFILLER_68_725 VDD VSS FILLER1
X_18835_ _18835_/CK _18835_/D _18835_/Q VDD VSS DFFQX1
XFILLER_96_81 VDD VSS DECAPHV32
XFILLER_49_994 VDD VSS FILLER4
X_18766_ _18821_/CK _18766_/D _18766_/Q VDD VSS DFFQX1
X_15978_ _15978_/A _16042_/B VDD VSS _15979_/D _15978_/C NAND3X1
X_18697_ _18805_/CK _18697_/D _18697_/Q VDD VSS DFFQX1
X_17717_ _17722_/CK _17717_/D _17717_/Q VDD VSS DFFQX1
X_14929_ _14929_/A _14929_/B _14929_/C VDD VSS _14935_/C OA21X2
XFILLER_64_975 VDD VSS FILLER1
XTAP_TAPCELL_ROW_85_1033 VDD VSS WELLTAP
XTAP_TAPCELL_ROW_85_1044 VDD VSS WELLTAP
X_17648_ _17680_/CK _17648_/D _17648_/Q VDD VSS DFFQX1
XFILLER_51_636 VDD VSS DECAPHV8
XFILLER_90_260 VDD VSS FILLER4
Xclkbuf_leaf_34__001_ clkload73/A VDD VSS _19038_/CK BUFX12
XFILLER_91_0 VDD VSS DECAPHV32
X_17579_ _19034_/CK _17579_/D _17579_/Q VDD VSS DFFQX1
XFILLER_17_1125 VDD VSS DECAPHV8
XFILLER_32_872 VDD VSS FILLER4
XFILLER_50_168 VDD VSS FILLER4
XFILLER_52_1027 VDD VSS FILLER4
XFILLER_118_933 VDD VSS DECAPHV8
X_09002_ _17630_/Q _17422_/B VDD VSS _09020_/A AND2X1
XFILLER_133_914 VDD VSS DECAPHV16
XTAP_TAPCELL_ROW_96_1173 VDD VSS WELLTAP
XFILLER_63_1134 VSS VDD FILLER2
XFILLER_99_861 VSS VDD FILLER2
X_09904_ _09904_/A _09904_/B VDD VSS _09909_/C OR2X2
XFILLER_112_170 VSS VDD FILLER2
XFILLER_59_747 VDD VSS DECAPHV8
XFILLER_86_533 VDD VSS DECAPHV8
X_09835_ _17774_/Q _09838_/C VDD VSS _09836_/B NAND2X1
XFILLER_100_332 VSS VDD FILLER2
XFILLER_47_909 VDD VSS FILLER1
XFILLER_58_235 VDD VSS FILLER4
XFILLER_6_1072 VDD VSS DECAPHV32
X_09766_ _09766_/A VDD VSS _17454_/B INVX1
XFILLER_73_227 VDD VSS DECAPHV8
X_09697_ _17690_/Q _17486_/B VDD VSS _09718_/B XNOR2X1
XFILLER_15_806 VDD VSS FILLER4
XFILLER_42_603 VDD VSS FILLER1
XFILLER_55_975 VDD VSS DECAPHV16
XFILLER_25_44 VSS VDD FILLER2
XFILLER_26_176 VSS VDD FILLER2
XFILLER_42_636 VDD VSS DECAPHV16
XFILLER_54_496 VDD VSS FILLER4
XFILLER_81_260 VDD VSS FILLER1
XTAP_TAPCELL_ROW_24_311 VDD VSS WELLTAP
XFILLER_41_157 VDD VSS FILLER1
XTAP_TAPCELL_ROW_105_1280 VDD VSS WELLTAP
XTAP_TAPCELL_ROW_52_642 VDD VSS WELLTAP
XFILLER_22_360 VDD VSS FILLER1
XTAP_TAPCELL_ROW_80_973 VDD VSS WELLTAP
XTAP_TAPCELL_ROW_80_984 VDD VSS WELLTAP
X_10610_ _10611_/A _10611_/B _10611_/C VDD VSS _10614_/C OA21X2
X_11590_ _18301_/Q VDD VSS _11595_/A INVX1
XFILLER_41_32 VDD VSS DECAPHV32
X_10541_ _10541_/A _10541_/B _10541_/C _10541_/D VDD VSS _10543_/C OAI211X1
X_13260_ _13260_/A _13260_/B _13260_/C VDD VSS _13262_/B OA21X2
XFILLER_108_421 VDD VSS DECAPHV8
XFILLER_41_76 VDD VSS FILLER1
XFILLER_41_98 VDD VSS FILLER1
X_10472_ _17865_/Q _10477_/B _10482_/C VDD VSS _10654_/B XNOR3X1
X_12211_ _12503_/A _12503_/B VDD VSS _14260_/B XNOR2X1
XFILLER_124_903 VDD VSS FILLER1
XFILLER_136_763 VSS VDD FILLER2
X_13191_ _13191_/A _13191_/B _13191_/C _13191_/D VDD VSS _14153_/B AOAI211X1
XFILLER_123_435 VSS VDD FILLER2
XFILLER_124_958 VDD VSS FILLER4
XFILLER_2_732 VDD VSS DECAPHV32
X_12142_ _12234_/A _12234_/B _12234_/D _12234_/C VDD VSS _14142_/C AOI211X1
XFILLER_123_468 VDD VSS FILLER4
X_12073_ _18256_/Q _12227_/A _12305_/B VDD VSS _12216_/D XNOR3X1
X_16950_ _16957_/A _16950_/B _16957_/C _18934_/Q VDD VSS _16959_/A AOI211X1
XFILLER_110_129 VDD VSS DECAPHV8
XFILLER_1_253 VDD VSS DECAPHV16
X_11024_ _11024_/A _11160_/A VDD VSS _17989_/D NOR2X1
X_15901_ _16064_/A _16155_/A _16224_/C VDD VSS _15904_/A AND3BX1
XFILLER_77_544 VSS VDD FILLER2
X_16881_ _18927_/Q _16886_/B VDD VSS _16883_/A XOR2X1
XFILLER_18_600 VDD VSS FILLER4
XFILLER_18_611 VSS VDD FILLER2
XFILLER_49_268 VDD VSS FILLER1
XFILLER_65_717 VDD VSS DECAPHV16
XFILLER_66_40 VDD VSS FILLER4
XFILLER_92_514 VDD VSS FILLER4
XTAP_TAPCELL_ROW_108_1309 VDD VSS WELLTAP
X_18620_ clkload8/A _18620_/D _18620_/Q VDD VSS DFFQX1
X_15832_ _18894_/Q _16927_/B VDD VSS _15833_/C NAND2X1
XFILLER_17_110 VDD VSS FILLER4
X_12975_ _13076_/A _13076_/B _13076_/C VDD VSS _13053_/B OAI21X1
X_18551_ clkload6/A _18551_/D _18551_/Q VDD VSS DFFQX1
X_15763_ _15800_/A _15874_/D _16161_/C VDD VSS _15803_/C OAI21X1
X_11926_ _18201_/Q _14139_/B VDD VSS _11927_/D _14139_/C NAND3X1
X_18482_ _18509_/CK _18482_/D _18482_/Q VDD VSS DFFQX1
X_17502_ _17518_/A _17502_/B VDD VSS _17705_/D NOR2X1
X_14714_ _14717_/C _14715_/B _17229_/A VDD VSS _14715_/C OAI21X1
XFILLER_32_102 VSS VDD FILLER2
XFILLER_60_400 VDD VSS FILLER1
XFILLER_61_945 VSS VDD FILLER2
X_17433_ _17445_/A _17433_/B VDD VSS _17640_/D NOR2X1
X_15694_ _15695_/A _15694_/B VDD VSS _15695_/C NOR2X1
XFILLER_33_647 VDD VSS FILLER4
X_11857_ _18175_/Q _14111_/B VDD VSS _11953_/A AND2X1
X_14645_ _14645_/A _14796_/A _14645_/C VDD VSS _14648_/C MIN3X1
XFILLER_20_319 VDD VSS FILLER4
X_10808_ _10808_/A _10808_/B _10808_/C VDD VSS _10811_/C MIN3X1
X_11788_ _11863_/A _14053_/B VDD VSS _11870_/A NOR2X1
X_17364_ _17434_/A _17364_/B VDD VSS _17575_/D AND2X1
X_14576_ _14696_/A _14576_/B VDD VSS _18530_/D NOR2X1
XFILLER_13_371 VDD VSS FILLER1
X_10739_ _17908_/Q _10743_/B VDD VSS _10740_/B XNOR2X1
X_17295_ _17323_/A _17295_/B VDD VSS _19015_/D NOR2X1
X_16315_ _16315_/A _16315_/B _16315_/C _16315_/D VDD VSS _16316_/C OA211X2
X_13527_ _18452_/Q _14426_/B VDD VSS _13653_/A AND2X1
XFILLER_9_375 VSS VDD FILLER2
XTAP_TAPCELL_ROW_119_1449 VDD VSS WELLTAP
X_19034_ _19034_/CK _19034_/D _19034_/Q VDD VSS DFFQX1
X_16246_ _16293_/A _16293_/B _16293_/C VDD VSS _16246_/Y NOR3X1
XFILLER_86_1101 VDD VSS FILLER4
X_13458_ _13532_/A _13532_/B _13532_/D _13532_/C VDD VSS _14398_/C AOI211X1
XFILLER_115_914 VDD VSS FILLER1
XFILLER_127_763 VDD VSS FILLER4
XTAP_TAPCELL_ROW_132_1605 VDD VSS WELLTAP
X_12409_ _12499_/A _12617_/B VDD VSS _14295_/B XNOR2X1
X_16177_ _16239_/A _16239_/B _16582_/A VDD VSS _16178_/C OAI21X1
X_13389_ _13395_/A _13395_/B _13395_/D _13395_/C VDD VSS _14244_/C OAI211X1
X_15128_ _15240_/A _18698_/Q VDD VSS _18671_/D AND2X1
XFILLER_130_906 VDD VSS FILLER1
XFILLER_99_157 VDD VSS DECAPHV8
X_15059_ _18634_/Q _19012_/Q VDD VSS _15065_/B NAND2X1
XFILLER_110_652 VDD VSS DECAPHV16
XFILLER_29_909 VSS VDD FILLER2
XFILLER_110_685 VDD VSS FILLER4
X_09620_ _09620_/A _09620_/B VDD VSS _09621_/B _09620_/C NAND3X1
X_18818_ _18818_/CK _18818_/D _18818_/Q VDD VSS DFFQX1
X_09551_ _17620_/Q _09551_/B _17412_/B VDD VSS _09577_/A MIN3X1
X_18749_ _18858_/CK _18749_/D _18749_/Q VDD VSS DFFQX1
XFILLER_52_912 VDD VSS FILLER1
XFILLER_64_750 VSS VDD FILLER2
XFILLER_70_208 VSS VDD FILLER2
XTAP_TAPCELL_ROW_38_469 VDD VSS WELLTAP
XFILLER_102_49 VDD VSS DECAPHV32
XFILLER_23_113 VDD VSS DECAPHV8
XFILLER_51_400 VDD VSS FILLER1
XFILLER_63_271 VDD VSS FILLER1
XFILLER_63_282 VDD VSS FILLER4
XFILLER_93_1127 VDD VSS FILLER4
X_09482_ _09482_/A _09501_/B VDD VSS _17443_/B XNOR2X1
XFILLER_23_146 VDD VSS FILLER4
XFILLER_108_1072 VDD VSS FILLER1
XFILLER_20_831 VDD VSS FILLER1
XFILLER_109_218 VDD VSS FILLER1
XFILLER_30_1100 VDD VSS FILLER4
XFILLER_133_711 VSS VDD FILLER2
XFILLER_106_947 VSS VDD FILLER2
XFILLER_105_446 VDD VSS FILLER4
XFILLER_105_468 VSS VDD FILLER2
XFILLER_115_1010 VDD VSS DECAPHV8
XFILLER_59_511 VSS VDD FILLER2
XFILLER_8_1112 VDD VSS FILLER4
XFILLER_101_641 VDD VSS FILLER1
XFILLER_59_555 VSS VDD FILLER2
XFILLER_115_1076 VDD VSS FILLER4
XFILLER_59_577 VSS VDD FILLER2
XFILLER_74_514 VDD VSS FILLER4
XTAP_TAPCELL_ROW_57_701 VDD VSS WELLTAP
X_09818_ _17769_/Q _09818_/B VDD VSS _09959_/B XOR2X1
XFILLER_28_942 VDD VSS FILLER1
X_09749_ _17660_/Q _09766_/A VDD VSS _09752_/A XNOR2X1
XFILLER_36_32 VDD VSS DECAPHV8
XFILLER_27_485 VDD VSS FILLER1
XFILLER_28_997 VSS VDD FILLER2
XFILLER_36_65 VDD VSS DECAPHV8
XFILLER_43_945 VDD VSS DECAPHV16
XFILLER_82_580 VDD VSS DECAPHV8
X_12760_ _12760_/A _14118_/B _12760_/C _12760_/D VDD VSS _13086_/A AOAI211X1
X_11711_ _18200_/Q _11853_/A _11924_/B VDD VSS _11801_/D XNOR3X1
X_12691_ _12799_/A _12944_/B _12715_/C VDD VSS _12824_/B OR3BX1
X_11642_ _18199_/Q _11760_/B _11760_/C VDD VSS _11801_/B XNOR3X1
X_14430_ _15310_/A _14430_/B VDD VSS _18455_/D AND2X1
X_14361_ _14361_/A VDD VSS _14361_/Y BUFX3
XFILLER_10_352 VDD VSS DECAPHV8
XFILLER_11_864 VDD VSS FILLER4
XFILLER_122_1014 VDD VSS FILLER4
XFILLER_35_1066 VSS VDD FILLER2
XFILLER_35_1099 VDD VSS FILLER1
X_11573_ _11623_/A _11623_/B _11623_/C VDD VSS _11754_/B OAI21X1
X_16100_ _18812_/Q _18704_/Q VDD VSS _16102_/C NOR2X1
X_13312_ _18190_/Q _14127_/B VDD VSS _13405_/D XOR2X1
XFILLER_6_323 VSS VDD FILLER2
X_10524_ _17872_/Q _10524_/B _10524_/C VDD VSS _10533_/D XNOR3X1
X_174_ _174_/CK _174_/E _174_/ECK VDD VSS CGX3
X_17080_ _17396_/A VDD VSS _17224_/A BUFX3
X_14292_ _14313_/A _14292_/B VDD VSS _18335_/D NOR2X1
XFILLER_108_251 VDD VSS FILLER1
X_10455_ _11148_/A _10637_/B VDD VSS _17887_/D AND2X1
X_13243_ _18501_/Q _14488_/B VDD VSS _13244_/B XNOR2X1
X_16031_ _16905_/B VDD VSS _16972_/B BUFX3
XFILLER_123_221 VDD VSS DECAPHV32
XFILLER_136_582 VSS VDD FILLER2
X_13174_ _13273_/A _14332_/B _14332_/C VDD VSS _13350_/C NOR3X1
XFILLER_124_766 VDD VSS DECAPHV8
X_10386_ _17851_/Q _10390_/B _10390_/C VDD VSS _10572_/C XNOR3X1
X_12125_ _18229_/Q _14170_/B VDD VSS _12126_/D _14170_/C NAND3X1
Xclkbuf_leaf_33__002_ clkload27/A VDD VSS _18340_/CK BUFX12
XFILLER_111_405 VDD VSS FILLER4
XFILLER_124_788 VSS VDD FILLER2
X_17982_ _17982_/CK _17982_/D _17982_/Q VDD VSS DFFQX1
XFILLER_111_438 VDD VSS FILLER4
XFILLER_120_950 VDD VSS FILLER1
XFILLER_77_330 VDD VSS DECAPHV8
XFILLER_81_1064 VSS VDD FILLER2
X_12056_ _12255_/A _12255_/B _12255_/D VDD VSS _12060_/B AOI21X1
X_16933_ _16934_/A _16934_/B _16934_/C _16934_/D VDD VSS _16942_/C OAI211X1
XFILLER_78_886 VDD VSS DECAPHV8
X_11007_ _11062_/A _11144_/B VDD VSS _17986_/D AND2X1
X_16864_ _18925_/Q _16864_/B VDD VSS _16865_/C AND2X1
X_18603_ clkload1/A _18603_/D _18603_/Q VDD VSS DFFQX1
Xclkbuf_leaf_48__002_ clkload25/A VDD VSS _18963_/CK BUFX12
X_15815_ _15842_/A _15842_/B _15815_/C VDD VSS _15819_/C AOI21X1
XFILLER_19_953 VDD VSS DECAPHV8
XFILLER_34_901 VDD VSS FILLER4
XFILLER_92_344 VSS VDD FILLER2
XFILLER_92_366 VSS VDD FILLER2
X_16795_ _16795_/A _16795_/B VDD VSS _16797_/B XNOR2X1
XFILLER_18_485 VSS VDD FILLER2
XFILLER_33_411 VSS VDD FILLER2
XFILLER_34_912 VDD VSS FILLER1
XFILLER_34_945 VDD VSS FILLER1
XTAP_TAPCELL_ROW_82_1003 VDD VSS WELLTAP
X_12958_ _13076_/A _13186_/B VDD VSS _14239_/B XNOR2X1
X_18534_ clkload4/A _18534_/D _18534_/Q VDD VSS DFFQX1
X_15746_ _18891_/Q _15746_/B _15746_/C VDD VSS _15751_/A MIN3X1
XTAP_TAPCELL_ROW_35_439 VDD VSS WELLTAP
X_11909_ _18358_/Q VDD VSS _11911_/A INVX1
X_12889_ _12891_/D _12994_/C _12994_/A VDD VSS _14065_/B NAND3BX1
X_18465_ _18493_/CK _18465_/D _18465_/Q VDD VSS DFFQX1
X_15677_ _18883_/Q _15689_/C VDD VSS _15678_/B XOR2X1
XFILLER_21_628 VDD VSS FILLER4
XFILLER_61_786 VDD VSS FILLER1
X_18396_ _18448_/CK _18396_/D _18396_/Q VDD VSS DFFQX1
X_17416_ _17423_/A _17416_/B VDD VSS _17624_/D NOR2X1
X_14628_ _14630_/A _14630_/B _14628_/C VDD VSS _18541_/D AOI21X1
XFILLER_20_138 VDD VSS FILLER1
X_17347_ _17453_/A _17347_/B VDD VSS _19046_/D AND2X1
XFILLER_119_527 VDD VSS FILLER1
XFILLER_14_1128 VDD VSS DECAPHV8
XTAP_TAPCELL_ROW_15_196 VDD VSS WELLTAP
X_14559_ _14562_/A _14559_/B _14559_/C VDD VSS _18526_/D AOI21X1
XFILLER_9_183 VSS VDD FILLER2
X_17278_ _17278_/A _17278_/B VDD VSS _17281_/C NOR2X1
X_19017_ _19019_/CK _19017_/D _19017_/Q VDD VSS DFFQX1
X_16229_ _16229_/A _16229_/B _16229_/C wire30/A VDD VSS _16231_/B OAI31X1
XFILLER_115_711 VSS VDD FILLER2
XFILLER_54_0 VDD VSS DECAPHV32
XTAP_TAPCELL_ROW_93_1132 VDD VSS WELLTAP
X_08982_ _17756_/Q _18545_/Q _08982_/C VDD VSS _08984_/A MIN3X1
XFILLER_3_80 VDD VSS DECAPHV8
XFILLER_68_374 VDD VSS DECAPHV16
XFILLER_95_182 VDD VSS FILLER4
X_09603_ _17686_/Q _17482_/B VDD VSS _09612_/A OR2X2
XFILLER_71_506 VDD VSS FILLER1
XFILLER_83_344 VDD VSS FILLER1
XFILLER_25_923 VDD VSS FILLER4
XFILLER_83_377 VDD VSS FILLER1
X_09534_ _09556_/A _09556_/B VDD VSS _17445_/B XNOR2X1
XFILLER_24_433 VDD VSS FILLER4
X_09465_ _09465_/A _09465_/B _09465_/C VDD VSS _09468_/B OAI21X1
XFILLER_51_252 VSS VDD FILLER2
XFILLER_106_1009 VDD VSS DECAPHV16
XFILLER_11_116 VDD VSS FILLER1
X_09396_ _09396_/A _09419_/B VDD VSS _17440_/B XNOR2X1
XFILLER_11_149 VDD VSS FILLER4
XFILLER_121_1080 VDD VSS FILLER1
XFILLER_98_49 VDD VSS DECAPHV32
X_10240_ _17831_/Q _10242_/B _10242_/C VDD VSS _10427_/A XNOR3X1
XFILLER_133_541 VDD VSS FILLER4
XFILLER_65_1004 VSS VDD FILLER2
XFILLER_78_105 VDD VSS FILLER4
XFILLER_79_617 VDD VSS FILLER1
X_10171_ _10176_/A _10179_/B _10179_/C VDD VSS _10356_/C AND3BX1
XFILLER_121_747 VDD VSS DECAPHV16
XFILLER_120_279 VDD VSS FILLER4
XFILLER_87_650 VDD VSS FILLER1
X_13930_ _18514_/Q _14501_/B VDD VSS _13937_/A XOR2X1
XFILLER_47_64 VDD VSS DECAPHV16
XFILLER_86_182 VDD VSS FILLER4
XFILLER_28_750 VSS VDD FILLER2
XFILLER_41_1070 VDD VSS FILLER4
XFILLER_74_344 VDD VSS FILLER4
X_15600_ _15695_/B _15651_/A _15600_/C VDD VSS _15600_/Y AOI2B1X1
X_13861_ _13861_/A _13861_/B _13861_/C VDD VSS _13870_/B XNOR3X1
XFILLER_16_934 VSS VDD FILLER2
XFILLER_74_388 VSS VDD FILLER2
XFILLER_76_1100 VDD VSS FILLER4
X_12812_ _18471_/Q _12812_/B _12812_/C VDD VSS _13037_/B MIN3X1
X_16580_ _18826_/Q _18718_/Q VDD VSS _16581_/B XOR2X1
X_13792_ _13792_/A _13792_/B _13792_/C _13792_/D VDD VSS _14431_/C OA211X2
XFILLER_103_92 VDD VSS FILLER1
XFILLER_27_282 VDD VSS DECAPHV16
X_12743_ _12743_/A _12743_/B _12743_/C _12743_/D VDD VSS _12745_/C OAI211X1
X_15531_ _15572_/A _15531_/B VDD VSS _15532_/C NAND2X1
X_18250_ _18250_/CK _18250_/D _18250_/Q VDD VSS DFFQX1
X_15462_ _15483_/A _15532_/B VDD VSS _15463_/C NOR2X1
XFILLER_124_1109 VDD VSS DECAPHV16
XFILLER_15_499 VSS VDD FILLER2
XFILLER_42_285 VDD VSS DECAPHV8
XFILLER_63_96 VDD VSS FILLER4
X_12674_ _12994_/A _12891_/B VDD VSS _12779_/D AND2X1
X_17201_ _18997_/Q _17287_/B _17205_/A VDD VSS _17203_/B AO21X2
X_14413_ _14414_/A _14413_/B VDD VSS _18440_/D NOR2X1
X_11625_ _18172_/Q _14107_/B VDD VSS _11693_/A AND2X1
X_18181_ _18250_/CK _18181_/D _18181_/Q VDD VSS DFFQX1
X_15393_ _18913_/Q _15393_/B VDD VSS _15393_/Y XOR2X1
XFILLER_129_869 VDD VSS DECAPHV8
XTAP_TAPCELL_ROW_12_166 VDD VSS WELLTAP
X_11556_ _11556_/A _11556_/B _11556_/C _11556_/D VDD VSS _14078_/C OAI211X1
X_17132_ _17132_/A _17132_/B _17132_/C VDD VSS _17135_/C OAI21X1
X_14344_ _14377_/A _14344_/B VDD VSS _18380_/D AND2X1
XFILLER_6_142 VDD VSS DECAPHV32
XFILLER_7_654 VDD VSS DECAPHV32
XTAP_TAPCELL_ROW_116_1408 VDD VSS WELLTAP
XTAP_TAPCELL_ROW_40_497 VDD VSS WELLTAP
X_10507_ _10512_/A _10669_/B _10670_/C VDD VSS _10673_/C OR3BX1
X_17063_ _17063_/A _17063_/B _17063_/C VDD VSS _17069_/B AOI21X1
X_14275_ _14542_/A VDD VSS _14313_/A BUFX3
X_11487_ _18117_/Q _14048_/B VDD VSS _11488_/D _14048_/C NAND3X1
X_13226_ _13314_/A _13314_/C VDD VSS _13227_/C NOR2X1
X_16014_ _18810_/Q _18702_/Q VDD VSS _16051_/A AND2X1
XFILLER_83_1115 VDD VSS FILLER1
X_10438_ _17858_/Q _10438_/B VDD VSS _10440_/A NOR2BX1
XFILLER_112_714 VSS VDD FILLER2
X_10369_ _10370_/B _10370_/C _17848_/Q VDD VSS _10371_/C AOI21X1
X_13157_ _18395_/Q _13157_/B VDD VSS _13161_/C _13157_/C NAND3X1
Xclkbuf_leaf_0_clk_fs_regs clkbuf_leaf_5_clk_fs_regs/A VDD VSS clkload1/A BUFX12
XFILLER_2_392 VDD VSS DECAPHV16
X_12108_ _18386_/Q _12201_/B _14353_/B VDD VSS _12290_/B MIN3X1
X_13088_ _13088_/A _14121_/B _14121_/C VDD VSS _13089_/D NOR3X1
X_17965_ _17993_/CK _17965_/D _17965_/Q VDD VSS DFFQX1
XFILLER_66_812 VSS VDD FILLER2
XTAP_TAPCELL_ROW_68_829 VDD VSS WELLTAP
X_12039_ _12039_/A _12039_/B _12039_/C VDD VSS _12042_/A NOR3X1
X_16916_ _16914_/Y _18930_/Q VDD VSS _16925_/B NAND2BX1
XFILLER_38_514 VDD VSS DECAPHV32
XFILLER_77_160 VDD VSS DECAPHV8
X_17896_ _18000_/CK _17896_/D _17896_/Q VDD VSS DFFQX1
XTAP_TAPCELL_ROW_127_1537 VDD VSS WELLTAP
XTAP_TAPCELL_ROW_127_1548 VDD VSS WELLTAP
X_16847_ _16847_/A _16855_/B VDD VSS _16853_/B XNOR2X1
XFILLER_92_152 VDD VSS FILLER1
XFILLER_92_174 VDD VSS FILLER4
XFILLER_93_686 VSS VDD FILLER2
X_16778_ _16778_/A _16778_/B VDD VSS _16784_/C NOR2X1
XTAP_TAPCELL_ROW_48_597 VDD VSS WELLTAP
X_18517_ _18990_/CK _18517_/D _18517_/Q VDD VSS DFFQX1
X_15729_ _18934_/Q _15730_/C _18935_/Q VDD VSS _15729_/Y AOI21X1
XFILLER_22_904 VDD VSS DECAPHV8
XFILLER_61_561 VSS VDD FILLER2
X_09250_ _09250_/A _09250_/B _17434_/B VDD VSS _09261_/A MIN3X1
XFILLER_22_937 VDD VSS FILLER1
XFILLER_22_948 VSS VDD FILLER2
X_18448_ _18448_/CK _18448_/D _18448_/Q VDD VSS DFFQX1
XFILLER_18_1072 VDD VSS DECAPHV16
X_09181_ _17735_/Q _17703_/Q VDD VSS _09182_/B XOR2X1
X_18379_ _18406_/CK _18379_/D _18379_/Q VDD VSS DFFQX1
XFILLER_135_828 VDD VSS DECAPHV8
XFILLER_88_1026 VDD VSS FILLER4
XFILLER_0_318 VDD VSS DECAPHV32
XFILLER_130_500 VDD VSS FILLER4
XFILLER_103_747 VSS VDD FILLER2
X_08965_ _08968_/C _08965_/B VDD VSS _08966_/B XNOR2X1
XFILLER_102_246 VDD VSS FILLER4
XFILLER_102_268 VSS VDD FILLER2
XFILLER_69_650 VDD VSS FILLER1
XFILLER_25_1054 VDD VSS FILLER1
XFILLER_29_525 VDD VSS FILLER1
XFILLER_96_491 VDD VSS DECAPHV16
X_08896_ _17532_/B _08896_/B VDD VSS _17533_/B NOR2BX1
XFILLER_25_1098 VDD VSS FILLER4
XFILLER_56_355 VDD VSS FILLER1
XFILLER_95_1008 VDD VSS DECAPHV8
XFILLER_72_859 VDD VSS DECAPHV8
X_09517_ _09517_/A _09522_/B VDD VSS _17343_/B XOR2X1
XFILLER_13_926 VDD VSS FILLER4
XFILLER_80_870 VDD VSS DECAPHV8
XFILLER_13_937 VDD VSS FILLER1
X_09448_ _17744_/Q VDD VSS _17509_/B INVX1
XFILLER_40_778 VSS VDD FILLER2
XFILLER_9_919 VDD VSS FILLER4
X_09379_ _09352_/A _09379_/B _09379_/C VDD VSS _09382_/B AOI2B1X1
XFILLER_21_970 VDD VSS FILLER4
XFILLER_32_1025 VDD VSS FILLER1
XFILLER_40_789 VDD VSS FILLER1
X_11410_ _11532_/B _11423_/B VDD VSS _14189_/B XNOR2X1
X_12390_ _18467_/Q _12485_/B _14475_/B VDD VSS _12479_/C XNOR3X1
XFILLER_71_1096 VDD VSS FILLER4
X_11341_ _11341_/A _11354_/D VDD VSS _14102_/B XNOR2X1
XFILLER_119_880 VDD VSS FILLER1
XFILLER_125_338 VSS VDD FILLER2
XFILLER_4_602 VSS VDD FILLER2
X_11272_ _18165_/Q _11272_/B _11272_/C VDD VSS _11380_/B MIN3X1
X_14060_ _10382_/Y _14060_/B _14060_/C VDD VSS _18129_/D AND3BX1
XFILLER_79_425 VDD VSS FILLER4
X_10223_ _17828_/Q _10223_/B _10223_/C VDD VSS _10414_/B XNOR3X1
X_13011_ _13011_/A _13011_/B _13011_/C _13011_/D VDD VSS _14267_/C OAI211X1
XFILLER_121_533 VDD VSS FILLER1
XFILLER_3_189 VDD VSS DECAPHV32
XTAP_TAPCELL_ROW_111_1349 VDD VSS WELLTAP
X_10154_ _14361_/A VDD VSS _10154_/Y BUFX3
XFILLER_121_577 VSS VDD FILLER2
XFILLER_48_801 VSS VDD FILLER2
XFILLER_94_417 VDD VSS FILLER1
XFILLER_59_160 VSS VDD FILLER2
X_10085_ _10107_/A _10270_/B VDD VSS _10282_/B XNOR2X1
X_17750_ clkload3/A _17750_/D _17750_/Q VDD VSS DFFQX1
X_14962_ _14960_/B _14962_/B VDD VSS _14963_/C NOR2BX1
XFILLER_101_290 VDD VSS FILLER4
XFILLER_47_355 VDD VSS DECAPHV16
X_17681_ _17716_/CK _17681_/D _17681_/Q VDD VSS DFFQX1
X_16701_ _16857_/A _16701_/B _16701_/C VDD VSS _16701_/Y OAI21X1
X_14893_ _14896_/C _14894_/B _17255_/D VDD VSS _14894_/C OAI21X1
X_13913_ _13913_/A _13913_/B _13913_/C _13913_/D VDD VSS _13935_/A OAOI211X1
XFILLER_74_40 VDD VSS FILLER4
X_16632_ _16857_/A _16632_/B VDD VSS _16633_/C NAND2X1
X_13844_ _18406_/Q _14376_/B VDD VSS _13876_/B XOR2X1
XFILLER_47_399 VSS VDD FILLER2
XFILLER_62_336 VDD VSS DECAPHV8
XFILLER_74_185 VDD VSS FILLER1
XTAP_TAPCELL_ROW_17_225 VDD VSS WELLTAP
XFILLER_128_1031 VDD VSS DECAPHV32
XTAP_TAPCELL_ROW_45_556 VDD VSS WELLTAP
X_10987_ _17957_/Q _10990_/B VDD VSS _10991_/B XOR2X1
X_18302_ _18361_/CK _18302_/D _18302_/Q VDD VSS DFFQX1
X_16563_ _18913_/Q _16862_/B VDD VSS _16564_/C NAND2X1
X_13775_ _13773_/Y _13853_/B VDD VSS _18052_/D NOR2BX1
XFILLER_15_274 VDD VSS FILLER4
XFILLER_31_734 VDD VSS FILLER1
XTAP_TAPCELL_ROW_122_1478 VDD VSS WELLTAP
XTAP_TAPCELL_ROW_73_898 VDD VSS WELLTAP
X_12726_ _12726_/A _12726_/B _12726_/C _12726_/D VDD VSS _13009_/A AOAI211X1
X_16494_ _16488_/B _18911_/Q VDD VSS _16530_/A NAND2BX1
X_15514_ _15496_/Y _15513_/Y _16757_/D VDD VSS _15514_/Y MUX2X1
X_12657_ _12769_/A _12769_/B VDD VSS _14148_/B XNOR2X1
X_18233_ _18261_/CK _18233_/D _18233_/Q VDD VSS DFFQX1
Xclkbuf_leaf_1__000_ clkload110/A VDD VSS _18856_/CK BUFX12
X_15445_ _16757_/D _15445_/B _15445_/C _15801_/B VDD VSS _15517_/C AOAI211X1
X_11608_ _11675_/A _11675_/B _11623_/C VDD VSS _11612_/B AOI21BX1
X_18164_ _18963_/CK _18164_/D _18164_/Q VDD VSS DFFQX1
X_15376_ _15784_/C VDD VSS _16326_/A BUFX3
XFILLER_30_299 VDD VSS FILLER1
XFILLER_8_974 VSS VDD FILLER2
X_12588_ _12588_/A _12588_/B _14478_/B VDD VSS _12591_/B MIN3X1
X_17115_ _18018_/Q _17119_/B VDD VSS _17117_/C XNOR2X1
X_14327_ _14423_/A _14327_/B VDD VSS _18365_/D AND2X1
X_11539_ _18170_/Q _14105_/B VDD VSS _11540_/D _14105_/C NAND3X1
X_18095_ _18982_/CK _18095_/D _18095_/Q VDD VSS DFFQX1
XFILLER_116_349 VSS VDD FILLER2
XFILLER_99_92 VDD VSS FILLER1
X_17046_ _18005_/Q _17049_/B VDD VSS _17050_/C XNOR2X1
X_14258_ _14269_/A _14258_/B VDD VSS _18307_/D NOR2X1
XFILLER_125_861 VDD VSS FILLER4
XTAP_TAPCELL_ROW_90_1102 VDD VSS WELLTAP
X_13209_ _18188_/Q _13209_/B _13216_/D VDD VSS _13218_/C XNOR3X1
X_14189_ _14191_/A _14189_/B VDD VSS _18247_/D NOR2X1
XFILLER_124_382 VDD VSS DECAPHV16
XFILLER_135_1013 VDD VSS DECAPHV8
XFILLER_86_929 VDD VSS FILLER4
XFILLER_97_277 VSS VDD FILLER2
X_18997_ clkload9/A _18997_/D _18997_/Q VDD VSS DFFQX1
XFILLER_38_322 VSS VDD FILLER2
XFILLER_39_823 VDD VSS DECAPHV8
X_17948_ _18003_/CK _17948_/D _17948_/Q VDD VSS DFFQX1
XFILLER_17_0 VDD VSS DECAPHV32
XFILLER_38_344 VDD VSS FILLER4
XFILLER_93_450 VDD VSS FILLER1
X_17879_ _17908_/CK _17879_/D _17879_/Q VDD VSS DFFQX1
XFILLER_94_995 VSS VDD FILLER2
XTAP_TAPCELL_ROW_88_1075 VDD VSS WELLTAP
XFILLER_19_580 VDD VSS DECAPHV8
XFILLER_54_859 VSS VDD FILLER2
XFILLER_0_1078 VSS VDD FILLER2
XFILLER_53_369 VSS VDD FILLER2
X_09302_ _17579_/Q _17368_/B VDD VSS _09304_/A NAND2BX1
XFILLER_110_49 VDD VSS DECAPHV32
X_09233_ _17641_/Q _17434_/B VDD VSS _09234_/B XNOR2X1
X_09164_ _09174_/A _09174_/B VDD VSS _17363_/B XNOR2X1
XFILLER_119_176 VDD VSS DECAPHV8
XFILLER_134_113 VDD VSS DECAPHV16
X_09095_ _17571_/Q VDD VSS _09096_/A INVX1
XFILLER_115_360 VDD VSS FILLER1
XFILLER_115_393 VDD VSS FILLER4
XFILLER_131_831 VDD VSS FILLER4
XFILLER_1_649 VSS VDD FILLER2
XFILLER_103_566 VDD VSS FILLER1
XFILLER_48_108 VDD VSS DECAPHV16
XFILLER_77_929 VDD VSS FILLER1
X_09997_ _17799_/Q _09997_/B _09997_/C VDD VSS _09998_/D OR3BX1
XFILLER_57_620 VDD VSS DECAPHV8
X_08948_ _08952_/A _08949_/B _17514_/A VDD VSS _08949_/C OAI21X1
XFILLER_28_44 VSS VDD FILLER2
XFILLER_29_344 VSS VDD FILLER2
X_08879_ _17742_/Q _18531_/Q VDD VSS _17562_/A XNOR2X1
XFILLER_28_88 VDD VSS FILLER4
XFILLER_45_826 VDD VSS DECAPHV8
XFILLER_57_675 VDD VSS FILLER4
X_10910_ _17941_/Q _10910_/B VDD VSS _10911_/C NOR2BX1
XFILLER_17_539 VDD VSS DECAPHV8
XFILLER_56_185 VDD VSS FILLER1
X_11890_ _12079_/B _12079_/C VDD VSS _14227_/B NAND2X1
XFILLER_44_32 VDD VSS DECAPHV8
XFILLER_72_689 VDD VSS FILLER1
X_10841_ _10841_/A _10841_/B _10841_/C VDD VSS _10847_/C OAI21X1
XFILLER_13_734 VDD VSS DECAPHV8
XTAP_TAPCELL_ROW_42_526 VDD VSS WELLTAP
X_10772_ _17913_/Q _10772_/B _10768_/Y VDD VSS _10777_/C AOI21BX1
X_13560_ _18296_/Q _14246_/B VDD VSS _13631_/A NAND2X1
XTAP_TAPCELL_ROW_70_857 VDD VSS WELLTAP
X_12511_ _12616_/A _14263_/B VDD VSS _12634_/A NOR2X1
X_13491_ _13491_/A _13491_/B VDD VSS _14185_/B XNOR2X1
XFILLER_12_266 VDD VSS DECAPHV16
XFILLER_13_789 VDD VSS DECAPHV16
X_12442_ _12552_/A _12552_/B VDD VSS _12536_/B NOR2X1
X_15230_ _17079_/A _16570_/A VDD VSS _18771_/D NOR2X1
XFILLER_121_0 VDD VSS DECAPHV32
XFILLER_8_259 VSS VDD FILLER2
XTAP_TAPCELL_ROW_22_283 VDD VSS WELLTAP
XFILLER_126_625 VDD VSS FILLER1
XFILLER_5_933 VDD VSS DECAPHV32
XFILLER_60_97 VDD VSS DECAPHV8
X_12373_ _18337_/Q _12617_/A _12617_/B VDD VSS _12374_/D XNOR3X1
X_15161_ _15272_/A _18731_/Q VDD VSS _18704_/D AND2X1
XFILLER_4_421 VDD VSS DECAPHV32
X_11324_ _11341_/A _11383_/D VDD VSS _11381_/B XNOR2X1
X_15092_ _15095_/C _15092_/B VDD VSS _15093_/B XNOR2X1
X_14112_ _14122_/A _14112_/B _14112_/C VDD VSS _18176_/D NOR3X1
XFILLER_109_80 VDD VSS DECAPHV8
X_11255_ _18138_/Q _11255_/B _11255_/C VDD VSS _11326_/B MIN3X1
X_18920_ _18959_/CK _18920_/D _18920_/Q VDD VSS DFFQX1
X_14043_ _14079_/A _14043_/B _14043_/C VDD VSS _18112_/D NOR3X1
X_10206_ _17825_/Q _10206_/B _10206_/C VDD VSS _10212_/B XNOR3X1
XFILLER_121_341 VDD VSS FILLER1
XFILLER_122_886 VDD VSS DECAPHV8
XFILLER_95_715 VDD VSS DECAPHV16
X_11186_ _17995_/Q _11190_/B VDD VSS _11189_/B XNOR2X1
X_18851_ _18851_/CK _18851_/D _18851_/Q VDD VSS DFFQX1
X_10137_ _10305_/A _10317_/B _10137_/C _10137_/D VDD VSS _10330_/A AOAI211X1
X_18782_ _18808_/CK _18782_/D _18782_/Q VDD VSS DFFQX1
X_17802_ _17851_/CK _17802_/D _17802_/Q VDD VSS DFFQX1
X_15994_ _16456_/A _15994_/B _15994_/C VDD VSS _18898_/D OAI21X1
XTAP_TAPCELL_ROW_78_957 VDD VSS WELLTAP
X_10068_ _10068_/A _10068_/B _10068_/C VDD VSS _10075_/C AO21X2
X_17733_ clkload6/A _17733_/D _17733_/Q VDD VSS DFFQX1
X_14945_ _14945_/A _14947_/C VDD VSS _14946_/B XNOR2X1
XFILLER_35_303 VDD VSS FILLER4
XFILLER_35_314 VDD VSS FILLER4
XTAP_TAPCELL_ROW_124_1507 VDD VSS WELLTAP
XFILLER_47_185 VDD VSS FILLER1
XFILLER_78_1036 VSS VDD FILLER2
X_17664_ _17698_/CK _17664_/D _17664_/Q VDD VSS DFFQX1
X_14876_ _18595_/Q _18627_/Q VDD VSS _14880_/A XOR2X1
XFILLER_51_807 VDD VSS FILLER4
XFILLER_63_678 VDD VSS DECAPHV16
XFILLER_91_998 VDD VSS FILLER4
X_17595_ _19052_/CK _17595_/D _17595_/Q VDD VSS DFFQX1
X_16615_ _16616_/A _16616_/B _16615_/C _16616_/C VDD VSS _16658_/C AOI211X1
X_13827_ _13827_/A _13827_/B _13827_/C _13827_/D VDD VSS _13867_/B AOAI211X1
X_16546_ _16546_/A _16570_/C VDD VSS _16547_/C XNOR2X1
X_13758_ _13762_/D _13762_/C _13762_/A _13758_/D VDD VSS _14311_/B AOAI211X1
X_12709_ _18418_/Q _12818_/B _12713_/C VDD VSS _12810_/C XNOR3X1
X_18216_ _18295_/CK _18216_/D _18216_/Q VDD VSS DFFQX1
X_16477_ _16478_/A _16478_/B _16478_/D _16478_/C VDD VSS _16497_/C OAOI211X1
X_13689_ _13690_/A _13690_/B _13690_/C VDD VSS _14340_/B AOI21X1
XFILLER_129_441 VSS VDD FILLER2
XTAP_TAPCELL_ROW_5_80 VDD VSS WELLTAP
X_15428_ _16582_/A VDD VSS _16782_/D BUFX3
XFILLER_116_113 VDD VSS DECAPHV16
XFILLER_117_614 VDD VSS FILLER1
XTAP_TAPCELL_ROW_135_1636 VDD VSS WELLTAP
X_18147_ _18152_/CK _18147_/D _18147_/Q VDD VSS DFFQX1
X_15359_ _18901_/Q _18900_/Q VDD VSS _15466_/B _15769_/B AND3X2
XFILLER_8_793 VDD VSS DECAPHV32
X_18078_ _18082_/CK _18078_/D _18078_/Q VDD VSS DFFQX1
XFILLER_102_1089 VDD VSS DECAPHV16
X_09920_ _09920_/A VDD VSS _09921_/B INVX1
X_17029_ _17079_/A _17029_/B VDD VSS _18963_/D NOR2X1
XFILLER_98_531 VDD VSS DECAPHV8
XFILLER_59_929 VDD VSS FILLER1
XFILLER_86_704 VSS VDD FILLER2
XFILLER_86_715 VSS VDD FILLER2
X_09851_ _17779_/Q _09851_/B VDD VSS _09857_/C NOR2BX1
XFILLER_100_514 VSS VDD FILLER2
XFILLER_39_620 VDD VSS FILLER1
XFILLER_98_586 VSS VDD FILLER2
X_09782_ _09783_/A _09783_/B _09783_/C _17453_/A VDD VSS _09783_/D OAI31X1
XFILLER_85_247 VDD VSS FILLER4
XFILLER_66_450 VDD VSS DECAPHV8
XFILLER_85_269 VSS VDD FILLER2
XFILLER_22_1068 VDD VSS FILLER1
XFILLER_53_100 VDD VSS FILLER1
XFILLER_53_155 VDD VSS DECAPHV8
XFILLER_81_464 VDD VSS FILLER1
X_09216_ _09219_/A _17331_/B VDD VSS _09217_/B XNOR2X1
X_09147_ _09147_/A _17362_/B VDD VSS _09148_/C NAND2X1
X_09078_ _17566_/Q _17354_/B VDD VSS _09079_/A XOR2X1
XFILLER_107_168 VSS VDD FILLER2
XTAP_TAPCELL_ROW_1_27 VDD VSS WELLTAP
XFILLER_103_352 VDD VSS FILLER1
XFILLER_1_468 VDD VSS DECAPHV32
XFILLER_39_32 VDD VSS DECAPHV32
X_11040_ _17966_/Q _11045_/B VDD VSS _11041_/B XNOR2X1
XFILLER_104_886 VDD VSS DECAPHV8
XFILLER_49_417 VDD VSS FILLER1
XFILLER_49_439 VDD VSS FILLER1
XFILLER_77_737 VDD VSS FILLER4
XFILLER_77_759 VDD VSS DECAPHV8
Xclkbuf_leaf_0__001_ clkload73/A VDD VSS _19052_/CK BUFX12
XFILLER_17_303 VDD VSS DECAPHV8
XTAP_TAPCELL_ROW_75_916 VDD VSS WELLTAP
X_12991_ wire27/Y _13091_/B _13091_/D _13091_/C VDD VSS _14095_/C AOAI211X1
XFILLER_18_837 VSS VDD FILLER2
XFILLER_85_792 VDD VSS FILLER1
X_11942_ _18175_/Q _14111_/B VDD VSS _12029_/A NAND2X1
X_14730_ _14731_/A _14732_/C _17229_/A VDD VSS _14731_/C OAI21X1
XFILLER_44_144 VDD VSS FILLER1
XFILLER_55_64 VDD VSS DECAPHV16
XTAP_TAPCELL_ROW_27_342 VDD VSS WELLTAP
X_11873_ _18977_/Q _18098_/Q VDD VSS _12040_/C XOR2X1
X_14661_ _14663_/B _14661_/B VDD VSS _14662_/B XOR2X1
XFILLER_32_328 VSS VDD FILLER2
XTAP_TAPCELL_ROW_55_673 VDD VSS WELLTAP
XTAP_TAPCELL_ROW_55_684 VDD VSS WELLTAP
X_10824_ _10824_/A _10824_/B _10824_/C _10824_/D VDD VSS _10825_/B AOI211X1
X_17380_ _17446_/A _17380_/B VDD VSS _17591_/D AND2X1
X_16400_ _18048_/Q _18658_/Q VDD VSS _16401_/D AND2X1
X_14592_ _14593_/C _17514_/A _14592_/C VDD VSS _18533_/D AND3BX1
X_13612_ _18349_/Q _13705_/A _13705_/B VDD VSS _13613_/D XNOR3X1
XFILLER_111_92 VDD VSS FILLER1
XFILLER_25_391 VDD VSS DECAPHV8
X_16331_ _18819_/Q _18711_/Q VDD VSS _16333_/D XNOR2X1
X_13543_ _18374_/Q _13686_/A _13686_/B VDD VSS _13544_/D XNOR3X1
XFILLER_125_1056 VDD VSS FILLER4
XFILLER_41_873 VDD VSS DECAPHV8
XFILLER_71_74 VDD VSS FILLER1
X_10755_ _11062_/A _10883_/B VDD VSS _17936_/D AND2X1
XFILLER_40_394 VDD VSS DECAPHV16
XFILLER_71_96 VDD VSS DECAPHV32
X_10686_ _10817_/A _10817_/B _10818_/C _10686_/D VDD VSS _10822_/B OAOI211X1
X_19050_ _19051_/CK _19050_/D _19050_/Q VDD VSS DFFQX1
X_16262_ _16411_/A _16298_/B VDD VSS _16263_/C NOR2X1
X_13474_ _13474_/A _14306_/B _14306_/C VDD VSS _13475_/D NOR3X1
X_12425_ _12626_/A _12626_/B VDD VSS _14203_/B XNOR2X1
X_18001_ _18025_/CK _18001_/D _18001_/Q VDD VSS DFFQX1
X_16193_ _16193_/A _16193_/B VDD VSS _16229_/B NOR2X1
X_15213_ _15272_/A _18782_/Q VDD VSS _18755_/D AND2X1
X_12356_ _12356_/A _12356_/B _12356_/C _12356_/D VDD VSS _12361_/B OAI31X1
X_15144_ _15313_/A _18714_/Q VDD VSS _18687_/D AND2X1
X_11307_ _18140_/Q VDD VSS _11379_/A INVX1
X_12287_ _18414_/Q _12403_/B _12292_/C VDD VSS _12397_/C XNOR3X1
X_15075_ _18638_/Q _19016_/Q VDD VSS _15082_/C NOR2X1
XFILLER_84_1062 VSS VDD FILLER2
X_11238_ _18111_/Q _11238_/B _11238_/C VDD VSS _11349_/B MIN3X1
X_18903_ _18961_/CK _18903_/D _18903_/Q VDD VSS DFFQX1
X_14026_ _17122_/D _18974_/Q VDD VSS _18095_/D AND2X1
XFILLER_121_160 VDD VSS DECAPHV16
XTAP_TAPCELL_ROW_130_1577 VDD VSS WELLTAP
X_11169_ _17991_/Q _11169_/B VDD VSS _11170_/C NOR2BX1
X_18834_ _18835_/CK _18834_/D _18834_/Q VDD VSS DFFQX1
XFILLER_67_258 VDD VSS FILLER1
XFILLER_83_707 VDD VSS DECAPHV16
XFILLER_95_556 VSS VDD FILLER2
XFILLER_95_567 VDD VSS FILLER1
XFILLER_110_889 VDD VSS DECAPHV16
XFILLER_76_770 VSS VDD FILLER2
X_18765_ _18818_/CK _18765_/D _18765_/Q VDD VSS DFFQX1
X_15977_ _15997_/A _15997_/B _15997_/D _15997_/C VDD VSS _15978_/C OAI211X1
XFILLER_35_111 VDD VSS DECAPHV16
XFILLER_63_420 VDD VSS FILLER4
X_18696_ _18857_/CK _18696_/D _18696_/Q VDD VSS DFFQX1
X_17716_ _17716_/CK _17716_/D _17716_/Q VDD VSS DFFQX1
X_14928_ _18605_/Q _18637_/Q VDD VSS _14929_/C NAND2X1
XFILLER_21_1090 VDD VSS DECAPHV16
XFILLER_63_464 VDD VSS FILLER1
XTAP_TAPCELL_ROW_85_1034 VDD VSS WELLTAP
X_17647_ _17680_/CK _17647_/D _17647_/Q VDD VSS DFFQX1
X_14859_ _18591_/Q _18623_/Q VDD VSS _14861_/D XNOR2X1
XFILLER_56_1131 VDD VSS FILLER1
XFILLER_51_648 VSS VDD FILLER2
XFILLER_91_1022 VDD VSS FILLER1
X_17578_ _19034_/CK _17578_/D _17578_/Q VDD VSS DFFQX1
XFILLER_31_361 VDD VSS FILLER1
X_16529_ _18912_/Q _16529_/B VDD VSS _16530_/D NAND2X1
XFILLER_84_0 VDD VSS DECAPHV32
X_09001_ _17662_/Q _17456_/B VDD VSS _17422_/B XOR2X1
XFILLER_118_945 VDD VSS FILLER1
XFILLER_129_282 VDD VSS DECAPHV32
XFILLER_133_937 VDD VSS FILLER1
XTAP_TAPCELL_ROW_96_1174 VDD VSS WELLTAP
XFILLER_117_499 VSS VDD FILLER2
XFILLER_132_414 VDD VSS FILLER1
XFILLER_99_840 VSS VDD FILLER2
X_09903_ _17790_/Q _09926_/B _09914_/A VDD VSS _09909_/D XNOR3X1
XFILLER_101_801 VDD VSS DECAPHV16
XFILLER_99_895 VDD VSS FILLER4
X_09834_ _09843_/A _09999_/A VDD VSS _17800_/D NOR2X1
XFILLER_101_845 VDD VSS DECAPHV16
XFILLER_86_545 VSS VDD FILLER2
XFILLER_55_910 VDD VSS FILLER4
XFILLER_74_729 VDD VSS DECAPHV8
X_09765_ _17628_/Q _09765_/B _17420_/B VDD VSS _09778_/A MIN3X1
XFILLER_26_100 VSS VDD FILLER2
XFILLER_27_645 VDD VSS FILLER4
XFILLER_39_494 VSS VDD FILLER2
XFILLER_73_239 VSS VDD FILLER2
X_09696_ _09696_/A _09720_/C VDD VSS _17486_/B XNOR2X1
XFILLER_14_306 VDD VSS FILLER1
XFILLER_14_328 VDD VSS FILLER4
XFILLER_42_615 VDD VSS FILLER4
XTAP_TAPCELL_ROW_24_301 VDD VSS WELLTAP
XFILLER_23_840 VDD VSS DECAPHV8
XFILLER_70_979 VDD VSS DECAPHV8
XTAP_TAPCELL_ROW_105_1281 VDD VSS WELLTAP
XTAP_TAPCELL_ROW_24_312 VDD VSS WELLTAP
XTAP_TAPCELL_ROW_52_643 VDD VSS WELLTAP
XTAP_TAPCELL_ROW_80_974 VDD VSS WELLTAP
XFILLER_109_901 VDD VSS FILLER1
XFILLER_22_394 VSS VDD FILLER2
XFILLER_23_895 VSS VDD FILLER2
X_10540_ _17874_/Q _10551_/B _10551_/C VDD VSS _10700_/A XNOR3X1
X_10471_ _17864_/Q _10476_/B VDD VSS _10482_/C NOR2X1
XFILLER_68_1002 VDD VSS DECAPHV8
X_12210_ _12210_/A _12210_/B _12210_/C _12210_/D VDD VSS _12503_/A AOAI211X1
XFILLER_124_926 VDD VSS DECAPHV8
XFILLER_2_700 VDD VSS DECAPHV32
XFILLER_68_1046 VSS VDD FILLER2
X_13190_ _13287_/A _13287_/B _13287_/C VDD VSS _13232_/B AOI21X1
X_12141_ _18177_/Q _14113_/B VDD VSS _12234_/C _14113_/C AND3X2
XFILLER_1_221 VDD VSS DECAPHV32
X_12072_ _18230_/Q _12221_/B _12221_/C VDD VSS _12305_/B XNOR3X1
XFILLER_2_788 VSS VDD FILLER2
X_11023_ _11023_/A _11025_/C VDD VSS _11160_/A XOR2X1
X_15900_ _15982_/A _15982_/B _16107_/A _15900_/D VDD VSS _16224_/C OAOI211X1
XFILLER_103_193 VSS VDD FILLER2
XFILLER_106_81 VDD VSS DECAPHV32
XFILLER_131_480 VDD VSS FILLER1
XFILLER_2_49 VDD VSS DECAPHV32
X_16880_ _16889_/A _16880_/B VDD VSS _16886_/B XNOR2X1
X_15831_ _15834_/B _15831_/B VDD VSS _15833_/B XNOR2X1
XFILLER_18_634 VDD VSS DECAPHV16
X_12974_ _18264_/Q _14208_/B VDD VSS _13076_/C _14208_/C NAND3X1
X_18550_ clkload6/A _18550_/D _18550_/Q VDD VSS DFFQX1
X_15762_ _18861_/Q _18862_/Q _18860_/Q VDD VSS _15800_/A AOI21X1
XFILLER_18_678 VSS VDD FILLER2
X_11925_ _14139_/B _14139_/C _18201_/Q VDD VSS _11927_/C AOI21X1
X_18481_ _18509_/CK _18481_/D _18481_/Q VDD VSS DFFQX1
X_17501_ _17501_/A VDD VSS _17518_/A BUFX3
X_14713_ _18560_/Q _18592_/Q VDD VSS _14715_/B XOR2X1
XFILLER_73_784 VDD VSS FILLER4
XFILLER_82_40 VDD VSS FILLER4
X_17432_ _17445_/A _17432_/B VDD VSS _17639_/D NOR2X1
X_15693_ _15693_/A _15693_/B _15693_/C VDD VSS _15703_/B MIN3X1
X_11856_ wire29/Y _12025_/B VDD VSS _14111_/B XNOR2X1
X_14644_ _18576_/Q VDD VSS _14796_/A INVX1
XFILLER_14_862 VDD VSS FILLER1
X_10807_ _17921_/Q VDD VSS _10808_/A INVX1
X_11787_ _11954_/A _11787_/B VDD VSS _14053_/B XOR2X1
X_17363_ _17378_/A _17363_/B VDD VSS _17574_/D NOR2X1
X_14575_ _14580_/C _14575_/B VDD VSS _14576_/B XNOR2X1
X_10738_ _17907_/Q _10738_/B _10738_/C VDD VSS _10744_/B MIN3X1
X_17294_ _17294_/A _17297_/C VDD VSS _17295_/B XOR2X1
X_16314_ _16315_/A _16315_/B _16315_/D _16315_/C VDD VSS _16401_/B OAOI211X1
X_13526_ _13605_/A _13597_/B VDD VSS _14426_/B XNOR2X1
XFILLER_9_365 VDD VSS FILLER4
X_19033_ _19033_/CK _19033_/D _19033_/Q VDD VSS DFFQX1
X_16245_ _18789_/Q _18735_/Q _16245_/C _16245_/D _16245_/E VDD VSS _16293_/C AOI221X1
X_13457_ _13457_/A _13457_/B _13457_/C _13457_/D VDD VSS _14398_/B OAOI211X1
X_10669_ _10669_/A _10669_/B VDD VSS _10670_/B NOR2X1
X_12408_ _18363_/Q _12408_/B _12408_/C VDD VSS _12614_/A MIN3X1
XFILLER_126_230 VSS VDD FILLER2
XTAP_TAPCELL_ROW_132_1606 VDD VSS WELLTAP
X_16176_ _16176_/A _16176_/B _16176_/C _16176_/D VDD VSS _16239_/B AOI31X1
X_13388_ _18267_/Q _14211_/B _14211_/C VDD VSS _13395_/C OR3BX1
XFILLER_114_436 VDD VSS DECAPHV8
X_12339_ _12522_/A _12522_/B VDD VSS _14145_/B XNOR2X1
X_15127_ _16984_/A _18697_/Q VDD VSS _18670_/D AND2X1
XFILLER_5_593 VDD VSS DECAPHV32
XFILLER_99_136 VDD VSS FILLER4
XFILLER_99_169 VSS VDD FILLER2
X_15058_ _18634_/Q _19012_/Q VDD VSS _15065_/C NOR2X1
XFILLER_123_981 VDD VSS DECAPHV16
X_14009_ _18957_/Q _14009_/B _18958_/Q VDD VSS _14010_/C AOI21X1
XFILLER_110_642 VDD VSS FILLER4
XFILLER_95_375 VSS VDD FILLER2
X_18817_ _18844_/CK _18817_/D _18817_/Q VDD VSS DFFQX1
XFILLER_110_1100 VDD VSS FILLER1
X_09550_ _09550_/A _09550_/B _09550_/C _09550_/D VDD VSS _09575_/B AOAI211X1
X_18748_ _18857_/CK _18748_/D _18748_/Q VDD VSS DFFQX1
XFILLER_37_954 VDD VSS FILLER4
XFILLER_37_987 VDD VSS DECAPHV8
X_09481_ _17682_/Q _17477_/B VDD VSS _09501_/B XNOR2X1
X_18679_ _18841_/CK _18679_/D _18679_/Q VDD VSS DFFQX1
XFILLER_23_125 VDD VSS FILLER4
XFILLER_51_445 VDD VSS FILLER1
XFILLER_51_456 VDD VSS FILLER4
XFILLER_91_592 VSS VDD FILLER2
XFILLER_31_191 VDD VSS FILLER1
XFILLER_117_285 VDD VSS DECAPHV16
XFILLER_132_222 VDD VSS DECAPHV8
XFILLER_120_417 VDD VSS FILLER1
XFILLER_121_929 VDD VSS FILLER1
XFILLER_115_1022 VDD VSS FILLER1
XFILLER_132_299 VDD VSS DECAPHV16
XFILLER_101_664 VDD VSS DECAPHV16
XTAP_TAPCELL_ROW_57_702 VDD VSS WELLTAP
X_09817_ _17768_/Q _09821_/C VDD VSS _09818_/B NAND2X1
X_09748_ _09768_/C _09748_/B VDD VSS _09766_/A AND2X1
XFILLER_27_453 VDD VSS FILLER4
XFILLER_28_965 VSS VDD FILLER2
XFILLER_36_44 VSS VDD FILLER2
XFILLER_36_77 VSS VDD FILLER2
XFILLER_70_721 VDD VSS DECAPHV8
X_09679_ _19048_/Q _17349_/B VDD VSS _09681_/C XOR2X1
X_11710_ _18174_/Q _11845_/B _11845_/C VDD VSS _11924_/B XNOR3X1
X_12690_ _18366_/Q _12690_/B _12940_/C VDD VSS _12715_/C XNOR3X1
XFILLER_30_607 VDD VSS DECAPHV8
XFILLER_52_32 VDD VSS DECAPHV8
X_11641_ _18173_/Q _11641_/B _11766_/D VDD VSS _11760_/C XNOR3X1
XFILLER_11_832 VDD VSS FILLER4
X_11572_ _18198_/Q _11572_/B _11672_/D VDD VSS _11623_/C XNOR3X1
X_14360_ _14423_/A _14360_/B VDD VSS _18393_/D AND2X1
X_10523_ _10523_/A _10523_/B _10523_/C VDD VSS _10533_/B XNOR3X1
X_173_ _174_/CK _173_/E _173_/ECK VDD VSS CGX3
X_13311_ _13314_/A _13314_/C _13314_/B _13311_/D VDD VSS _14127_/B OAOI211X1
X_14291_ _15300_/A _14291_/B VDD VSS _18334_/D AND2X1
XFILLER_109_753 VDD VSS FILLER1
X_10454_ _10454_/A _10457_/C VDD VSS _10637_/B XNOR2X1
X_13242_ _13344_/B _13337_/B VDD VSS _14488_/B XNOR2X1
X_16030_ _16030_/A _16030_/B _16030_/C _16030_/D VDD VSS _16033_/C OA211X2
X_10385_ _10385_/A _10385_/B _10385_/C VDD VSS _10390_/B AOI21X1
X_13173_ _13183_/A _14331_/B _13273_/C VDD VSS _14332_/C NOR3X1
XFILLER_112_907 VDD VSS FILLER1
X_12124_ _14170_/B _14170_/C _18229_/Q VDD VSS _12126_/C AOI21X1
Xclkbuf_leaf_33__001_ clkbuf_2_1__f__001_/Y VDD VSS _19036_/CK BUFX12
X_17981_ _17982_/CK _17981_/D _17981_/Q VDD VSS DFFQX1
XFILLER_78_865 VDD VSS DECAPHV16
X_12055_ _18978_/Q _18099_/Q VDD VSS _12255_/D AND2X1
X_16932_ _16934_/B _16932_/B _16948_/A VDD VSS _16934_/C OAI21X1
XFILLER_38_718 VDD VSS DECAPHV16
XFILLER_93_802 VSS VDD FILLER2
X_11006_ _11015_/B _11006_/B VDD VSS _11144_/B NOR2BX1
X_16863_ _16875_/A _16863_/B _16863_/C VDD VSS _18925_/D OAI21X1
XFILLER_37_217 VSS VDD FILLER2
XFILLER_77_397 VDD VSS FILLER4
XFILLER_92_323 VSS VDD FILLER2
X_18602_ clkload1/A _18602_/D _18602_/Q VDD VSS DFFQX1
X_15814_ _18034_/Q _18644_/Q VDD VSS _15842_/B XNOR2X1
X_18533_ clkload4/A _18533_/D _18533_/Q VDD VSS DFFQX1
X_16794_ _16815_/A _16808_/C VDD VSS _16795_/B AND2X1
XTAP_TAPCELL_ROW_82_1004 VDD VSS WELLTAP
X_12957_ _13170_/A _13170_/B _13170_/C VDD VSS _13046_/B AOI21X1
X_15745_ _18891_/Q _15792_/D _15752_/C _17018_/A VDD VSS _18891_/D AO22X2
XFILLER_33_445 VSS VDD FILLER2
XFILLER_34_979 VDD VSS DECAPHV16
XFILLER_61_743 VDD VSS FILLER1
X_11908_ _18384_/Q _11983_/B _11983_/C VDD VSS _12101_/B MIN3X1
X_12888_ _13103_/A _13112_/A _13108_/A VDD VSS _13091_/C XNOR3X1
X_18464_ _18493_/CK _18464_/D _18464_/Q VDD VSS DFFQX1
X_15676_ _15695_/A _15676_/B _15676_/C VDD VSS _15689_/C OAI21X1
X_11839_ _18279_/Q _12013_/B VDD VSS _12077_/C _11839_/C NAND3X1
X_18395_ _18448_/CK _18395_/D _18395_/Q VDD VSS DFFQX1
X_17415_ _17423_/A _17415_/B VDD VSS _17623_/D NOR2X1
X_14627_ _14630_/A _14630_/B _17455_/A VDD VSS _14628_/C OAI21X1
XFILLER_33_489 VDD VSS FILLER4
X_17346_ _17355_/A _17346_/B VDD VSS _19045_/D NOR2X1
XTAP_TAPCELL_ROW_15_197 VDD VSS WELLTAP
X_14558_ _14562_/A _14559_/B _17229_/A VDD VSS _14559_/C OAI21X1
XFILLER_9_162 VDD VSS DECAPHV8
X_17277_ _17277_/A _17277_/B _17278_/B _17277_/D VDD VSS _19012_/D AOI31X1
X_14489_ _14517_/A _14489_/B VDD VSS _18502_/D NOR2X1
X_13509_ _13525_/A _13583_/B _13583_/C VDD VSS _14491_/C OR3BX1
X_19016_ _19019_/CK _19016_/D _19016_/Q VDD VSS DFFQX1
X_16228_ _16229_/A _16229_/B _16229_/C VDD VSS _16232_/C OA21X2
XTAP_TAPCELL_ROW_93_1133 VDD VSS WELLTAP
X_16159_ _18815_/Q _18707_/Q VDD VSS _16250_/B XOR2X1
XFILLER_47_0 VDD VSS DECAPHV32
XFILLER_88_607 VSS VDD FILLER2
XFILLER_114_266 VSS VDD FILLER2
X_08981_ _09218_/A _08981_/B VDD VSS _17756_/D NOR2X1
XFILLER_111_973 VDD VSS FILLER4
XFILLER_3_92 VDD VSS FILLER1
XFILLER_69_887 VDD VSS FILLER1
XFILLER_3_1021 VSS VDD FILLER2
X_09602_ _09588_/A _09602_/B _09602_/C VDD VSS _09632_/B AOI2B1X1
X_09533_ _17683_/Q _09533_/B _17478_/B VDD VSS _09556_/B MIN3X1
X_09464_ _09465_/A _09465_/B _09465_/C VDD VSS _09464_/Y NOR3X1
XFILLER_12_607 VDD VSS DECAPHV8
XFILLER_12_618 VDD VSS DECAPHV32
XFILLER_24_478 VSS VDD FILLER2
XTAP_TAPCELL_ROW_62_760 VDD VSS WELLTAP
X_09395_ _17679_/Q _17474_/B VDD VSS _09419_/B XNOR2X1
XTAP_TAPCELL_ROW_102_1240 VDD VSS WELLTAP
XFILLER_118_594 VSS VDD FILLER2
XFILLER_105_233 VDD VSS DECAPHV16
XFILLER_106_767 VDD VSS FILLER4
XFILLER_105_277 VSS VDD FILLER2
XFILLER_106_789 VDD VSS FILLER1
XFILLER_121_726 VSS VDD FILLER2
XFILLER_65_1049 VDD VSS FILLER1
X_10170_ _17822_/Q VDD VSS _10176_/A INVX1
XTAP_TAPCELL_ROW_113_1380 VDD VSS WELLTAP
XFILLER_120_258 VDD VSS FILLER1
XFILLER_87_662 VDD VSS FILLER4
XFILLER_47_32 VDD VSS DECAPHV32
XFILLER_59_375 VDD VSS FILLER4
XFILLER_75_835 VSS VDD FILLER2
X_13860_ _13860_/A _13860_/B _13860_/C _13860_/D VDD VSS _14462_/B AOAI211X1
XFILLER_55_570 VDD VSS DECAPHV16
XFILLER_62_518 VDD VSS FILLER1
X_12811_ _12811_/A _12811_/B _14447_/B VDD VSS _12812_/B MIN3X1
X_13791_ _13792_/A _13792_/B _13792_/D _13792_/C VDD VSS _14431_/B OAOI211X1
XFILLER_43_743 VDD VSS FILLER1
XFILLER_43_754 VDD VSS DECAPHV16
X_12742_ _12742_/A _12742_/B _12742_/C _12742_/D VDD VSS _12863_/B AOAI211X1
X_15530_ _15497_/Y _15529_/Y _15596_/A VDD VSS _15531_/B MUXI2X1
XFILLER_15_456 VDD VSS DECAPHV8
XFILLER_16_979 VDD VSS DECAPHV8
XFILLER_42_264 VSS VDD FILLER2
XFILLER_63_64 VDD VSS DECAPHV16
X_12673_ _18985_/Q _18106_/Q VDD VSS _12891_/B NAND2X1
X_15461_ _15480_/A _15461_/B _15461_/C VDD VSS _15532_/B OAI21X1
X_11624_ _11691_/A _11766_/B VDD VSS _14107_/B XNOR2X1
X_17200_ _18998_/Q _17232_/B VDD VSS _17205_/B XNOR2X1
X_14412_ _14414_/A _14412_/B VDD VSS _18439_/D NOR2X1
X_18180_ _18200_/CK _18180_/D _18180_/Q VDD VSS DFFQX1
X_15392_ _18914_/Q _15395_/B VDD VSS _15392_/Y XNOR2X1
XTAP_TAPCELL_ROW_12_167 VDD VSS WELLTAP
X_11555_ _11556_/A _11556_/B _11556_/D _11556_/C VDD VSS _11635_/B OAOI211X1
X_17131_ _17132_/A _17132_/B _17132_/C VDD VSS _17131_/Y NOR3X1
X_14343_ _14343_/A _14343_/B VDD VSS _18379_/D AND2X1
XTAP_TAPCELL_ROW_116_1409 VDD VSS WELLTAP
XTAP_TAPCELL_ROW_40_498 VDD VSS WELLTAP
X_10506_ _17869_/Q _10506_/B VDD VSS _10512_/A NAND2X1
X_11486_ _14048_/B _14048_/C _18117_/Q VDD VSS _11488_/C AOI21X1
X_17062_ _17063_/A _17063_/B _17063_/C _17536_/D VDD VSS _17062_/Y AOI31X1
X_14274_ _16977_/A VDD VSS _14542_/A BUFX3
XFILLER_109_583 VSS VDD FILLER2
X_10437_ _10707_/A _10616_/B VDD VSS _17884_/D AND2X1
X_13225_ _13225_/A _13225_/B _14097_/B _18162_/Q _13225_/E VDD VSS _13314_/C AOI221X1
X_16013_ _16007_/Y _16013_/B _16011_/Y _16013_/D VDD VSS _16056_/C AOI2B2BX1
XFILLER_83_1105 VDD VSS DECAPHV8
XFILLER_3_872 VDD VSS DECAPHV32
XFILLER_98_927 VDD VSS DECAPHV8
X_10368_ _10524_/B _10524_/C _10368_/C _10535_/C VDD VSS _10543_/B AOAI211X1
X_13156_ _13157_/B _13157_/C _18395_/Q VDD VSS _13161_/B AOI21X1
XFILLER_111_225 VSS VDD FILLER2
XFILLER_2_360 VDD VSS DECAPHV32
X_10299_ _10299_/A _10299_/B VDD VSS _10318_/A OR2X2
X_12107_ _18387_/Q VDD VSS _12204_/A INVX1
X_13087_ _14121_/B _14121_/C _13088_/A VDD VSS _13089_/C OAI21X1
X_17964_ _17993_/CK _17964_/D _17964_/Q VDD VSS DFFQX1
X_12038_ _18151_/Q VDD VSS _12065_/A INVX1
X_16915_ _16914_/Y _18930_/Q VDD VSS _16925_/D NOR2BX1
XFILLER_120_781 VDD VSS DECAPHV8
X_17895_ _18000_/CK _17895_/D _17895_/Q VDD VSS DFFQX1
XFILLER_92_142 VDD VSS DECAPHV8
XFILLER_93_654 VDD VSS FILLER4
XTAP_TAPCELL_ROW_127_1538 VDD VSS WELLTAP
X_16846_ _16670_/B _16931_/B _16947_/A VDD VSS _16855_/B MUX2X1
XFILLER_20_1133 VSS VDD FILLER2
XFILLER_65_378 VDD VSS DECAPHV8
X_16777_ _18804_/Q _18750_/Q _16777_/C VDD VSS _16778_/B MIN3X1
X_13989_ _13991_/B _14013_/A _13989_/C VDD VSS _13990_/B OR3BX1
XFILLER_33_220 VDD VSS FILLER1
XTAP_TAPCELL_ROW_48_598 VDD VSS WELLTAP
X_18516_ _18989_/CK _18516_/D _18516_/Q VDD VSS DFFQX1
X_15728_ _15737_/A _17015_/A _15728_/C VDD VSS _18889_/D OAI21X1
XFILLER_34_765 VDD VSS FILLER4
X_18447_ _18500_/CK _18447_/D _18447_/Q VDD VSS DFFQX1
XFILLER_33_297 VDD VSS FILLER1
X_15659_ _16934_/D _15659_/B VDD VSS _15673_/B XNOR2X1
XFILLER_105_1021 VSS VDD FILLER2
X_09180_ _17734_/Q _09180_/B _09180_/C VDD VSS _09206_/C MIN3X1
X_18378_ _18431_/CK _18378_/D _18378_/Q VDD VSS DFFQX1
X_17329_ _17392_/A _17329_/B VDD VSS _19029_/D AND2X1
XFILLER_128_881 VSS VDD FILLER2
XFILLER_134_328 VDD VSS DECAPHV32
XFILLER_108_49 VDD VSS DECAPHV32
XFILLER_89_905 VDD VSS DECAPHV16
XFILLER_103_726 VDD VSS DECAPHV16
XFILLER_115_586 VDD VSS FILLER1
XFILLER_130_523 VDD VSS DECAPHV8
XFILLER_88_437 VDD VSS DECAPHV8
X_08964_ _17753_/Q _18542_/Q VDD VSS _08965_/B XOR2X1
XFILLER_25_1022 VDD VSS FILLER1
XFILLER_25_1066 VDD VSS FILLER4
XFILLER_64_1093 VDD VSS FILLER4
XFILLER_96_470 VDD VSS FILLER1
X_08895_ _17729_/Q _18518_/Q _08895_/C VDD VSS _08896_/B AOI21X1
XFILLER_83_142 VDD VSS FILLER1
XFILLER_84_665 VSS VDD FILLER2
XFILLER_99_1134 VSS VDD FILLER2
XFILLER_72_838 VDD VSS FILLER4
XFILLER_17_79 VDD VSS DECAPHV8
XFILLER_25_721 VDD VSS FILLER4
X_09516_ _17587_/Q _17376_/B VDD VSS _09522_/B XNOR2X1
XFILLER_13_905 VDD VSS FILLER4
XFILLER_24_242 VDD VSS DECAPHV8
X_09447_ _17680_/Q _17475_/B _09447_/C VDD VSS _09476_/A OAI21X1
XFILLER_80_882 VDD VSS FILLER1
Xclkbuf_leaf_32__002_ clkload27/A VDD VSS _18417_/CK BUFX12
XFILLER_33_56 VDD VSS FILLER4
XFILLER_71_1042 VDD VSS FILLER1
XFILLER_8_408 VDD VSS DECAPHV8
X_09378_ _19036_/Q _17336_/B VDD VSS _09379_/C NOR2X1
XFILLER_20_470 VDD VSS FILLER4
X_11340_ _11382_/A _11399_/A _11388_/B VDD VSS _11354_/D XNOR3X1
Xclkbuf_leaf_47__002_ clkload25/A VDD VSS _18484_/CK BUFX12
XFILLER_125_306 VDD VSS FILLER1
XFILLER_126_829 VDD VSS FILLER1
X_11271_ _18164_/Q _14099_/B VDD VSS _11272_/B OR2X2
X_13010_ _13010_/A _13010_/B _13010_/C _13010_/D VDD VSS _14267_/B AOAI211X1
X_10222_ _10222_/A _10222_/B VDD VSS _10223_/B NAND2X1
X_10153_ _09935_/Y _10349_/B _10349_/C VDD VSS _17845_/D AND3BX1
XFILLER_0_853 VSS VDD FILLER2
XFILLER_88_960 VDD VSS FILLER4
XFILLER_102_781 VDD VSS DECAPHV8
XFILLER_47_312 VDD VSS DECAPHV8
XFILLER_48_846 VSS VDD FILLER2
XFILLER_75_610 VDD VSS DECAPHV8
X_10084_ _17813_/Q _10106_/B VDD VSS _10270_/B XNOR2X1
X_16700_ _16857_/A _16700_/B VDD VSS _16701_/C NAND2X1
X_14961_ _15093_/A _14961_/B VDD VSS _18613_/D NOR2X1
XFILLER_75_654 VDD VSS DECAPHV16
X_17680_ _17680_/CK _17680_/D _17680_/Q VDD VSS DFFQX1
X_14892_ _18598_/Q _18630_/Q VDD VSS _14894_/B XOR2X1
X_13912_ _13912_/A _13912_/B _13912_/C VDD VSS _13913_/D NOR3X1
XFILLER_114_81 VDD VSS DECAPHV32
XFILLER_74_153 VDD VSS FILLER4
X_16631_ _16819_/A _16631_/B _16631_/C VDD VSS _16633_/B AOI21X1
X_13843_ _13843_/A _13845_/B _13843_/C VDD VSS _14376_/B OAI21X1
XFILLER_16_732 VDD VSS FILLER4
XFILLER_62_348 VSS VDD FILLER2
XFILLER_90_635 VDD VSS FILLER1
XTAP_TAPCELL_ROW_17_226 VDD VSS WELLTAP
X_16562_ _16905_/B VDD VSS _16862_/B BUFX3
XFILLER_71_871 VDD VSS FILLER4
XTAP_TAPCELL_ROW_45_557 VDD VSS WELLTAP
X_10986_ _17956_/Q _10986_/B _10986_/C VDD VSS _10988_/A MIN3X1
X_18301_ _18361_/CK _18301_/D _18301_/Q VDD VSS DFFQX1
X_15513_ _18921_/Q _15527_/B VDD VSS _15513_/Y XOR2X1
X_13774_ _13774_/A _13774_/B _13774_/C _13774_/D VDD VSS _13853_/B OAOI211X1
XFILLER_70_370 VDD VSS DECAPHV16
XTAP_TAPCELL_ROW_122_1479 VDD VSS WELLTAP
XTAP_TAPCELL_ROW_73_899 VDD VSS WELLTAP
X_12725_ _18313_/Q _14264_/B _14264_/C VDD VSS _12726_/D OR3BX1
X_16493_ _16926_/A VDD VSS _16875_/A BUFX3
XFILLER_90_40 VDD VSS FILLER4
X_12656_ _12656_/A _14146_/B _12656_/C _12656_/D VDD VSS _12769_/A AOAI211X1
X_18232_ _18253_/CK _18232_/D _18232_/Q VDD VSS DFFQX1
X_15444_ _15760_/B _15444_/B VDD VSS _15445_/C NOR2X1
XFILLER_30_267 VSS VDD FILLER2
X_11607_ _11607_/A _11607_/B _11607_/C _11607_/D VDD VSS _11675_/B AOAI211X1
X_12587_ _12700_/A _12589_/C _12587_/C _12587_/D VDD VSS _12590_/B OA211X2
X_18163_ _18247_/CK _18163_/D _18163_/Q VDD VSS DFFQX1
X_15375_ _18863_/Q _16537_/A _18864_/Q VDD VSS _15784_/C OR3BX1
XFILLER_8_953 VSS VDD FILLER2
X_17114_ _18017_/Q _17114_/B VDD VSS _17117_/A NOR2BX1
X_14326_ _14346_/A _14326_/B VDD VSS _18364_/D NOR2X1
XFILLER_129_689 VDD VSS FILLER4
XFILLER_7_463 VSS VDD FILLER2
X_11538_ _14105_/B _14105_/C _18170_/Q VDD VSS _11540_/C AOI21X1
X_18094_ _18988_/CK _18094_/D _18094_/Q VDD VSS DFFQX1
XFILLER_116_339 VDD VSS FILLER1
XFILLER_125_840 VDD VSS FILLER1
X_11469_ _18247_/Q _11473_/B _14189_/B VDD VSS _14217_/B XNOR3X1
X_17045_ _18004_/Q _17045_/B VDD VSS _17050_/A NAND2X1
X_14257_ _14269_/A _14257_/B VDD VSS _18306_/D NOR2X1
XFILLER_124_350 VDD VSS FILLER4
XFILLER_87_1082 VDD VSS DECAPHV8
XTAP_TAPCELL_ROW_90_1103 VDD VSS WELLTAP
X_13208_ _18162_/Q _13223_/A _13223_/B VDD VSS _13216_/D XNOR3X1
X_14188_ _14191_/A _14188_/B VDD VSS _18246_/D NOR2X1
XFILLER_97_212 VDD VSS DECAPHV8
X_13139_ _13257_/A _13257_/B _13257_/C VDD VSS _14422_/C NOR3X1
XFILLER_135_1058 VDD VSS DECAPHV32
XFILLER_39_802 VDD VSS DECAPHV8
X_18996_ clkload9/A _18996_/D _18996_/Q VDD VSS DFFQX1
XFILLER_97_289 VDD VSS DECAPHV16
X_17947_ _17972_/CK _17947_/D _17947_/Q VDD VSS DFFQX1
XFILLER_39_857 VDD VSS FILLER1
XFILLER_65_120 VSS VDD FILLER2
X_17878_ _17908_/CK _17878_/D _17878_/Q VDD VSS DFFQX1
XFILLER_53_315 VSS VDD FILLER2
X_16829_ _16829_/A _16829_/B _16825_/B VDD VSS _16837_/B AOI21BX1
XTAP_TAPCELL_ROW_88_1076 VDD VSS WELLTAP
XFILLER_0_93 VDD VSS DECAPHV32
X_09301_ _09301_/A _09301_/B VDD VSS _09328_/B NAND2X1
XFILLER_21_201 VDD VSS FILLER1
XFILLER_55_1026 VDD VSS DECAPHV8
XFILLER_80_178 VSS VDD FILLER2
XFILLER_94_1097 VDD VSS DECAPHV8
XFILLER_21_234 VSS VDD FILLER2
X_09232_ _09232_/A _09252_/B VDD VSS _17434_/B XNOR2X1
XFILLER_9_80 VDD VSS DECAPHV8
X_09163_ _17606_/Q _17397_/B VDD VSS _09174_/B XOR2X1
X_09094_ _09091_/A _09094_/B _09094_/C VDD VSS _09115_/A AOI2B1X1
XFILLER_66_1122 VDD VSS DECAPHV8
XFILLER_103_512 VDD VSS FILLER4
XFILLER_62_1008 VDD VSS FILLER1
XFILLER_0_138 VDD VSS DECAPHV32
X_09996_ _10922_/A VDD VSS _10114_/A BUFX3
X_08947_ _08952_/C _08952_/B VDD VSS _08949_/B NAND2BX1
XFILLER_57_654 VDD VSS FILLER4
XFILLER_84_440 VDD VSS DECAPHV8
X_08878_ _17743_/Q _18532_/Q VDD VSS _08922_/A NAND2X1
XFILLER_29_367 VDD VSS FILLER4
XFILLER_56_164 VDD VSS DECAPHV8
XFILLER_72_613 VDD VSS DECAPHV16
X_10840_ _17928_/Q _10840_/B VDD VSS _10841_/C NAND2X1
XFILLER_44_44 VSS VDD FILLER2
XFILLER_72_679 VSS VDD FILLER2
XFILLER_53_871 VDD VSS FILLER1
XFILLER_71_189 VDD VSS DECAPHV8
XTAP_TAPCELL_ROW_42_527 VDD VSS WELLTAP
X_10771_ _11062_/A _10901_/B VDD VSS _17939_/D AND2X1
XTAP_TAPCELL_ROW_70_858 VDD VSS WELLTAP
X_12510_ _12844_/A _12844_/B VDD VSS _14263_/B XNOR2X1
X_13490_ _18244_/Q _14186_/B VDD VSS _13566_/B XNOR2X1
XFILLER_13_779 VSS VDD FILLER2
X_12441_ _12538_/A _14117_/B VDD VSS _12552_/A NOR2X1
XFILLER_60_32 VDD VSS DECAPHV8
XTAP_TAPCELL_ROW_22_284 VDD VSS WELLTAP
X_12372_ _18311_/Q _12372_/B _12421_/C VDD VSS _12617_/B XNOR3X1
X_15160_ _15299_/A _18730_/Q VDD VSS _18703_/D AND2X1
XFILLER_107_840 VDD VSS FILLER1
XFILLER_114_0 VDD VSS DECAPHV32
X_11323_ _18141_/Q _11399_/A _11388_/B VDD VSS _11383_/D XNOR3X1
X_15091_ _18641_/Q _19019_/Q VDD VSS _15092_/B XOR2X1
X_14111_ _14396_/A _14111_/B VDD VSS _18175_/D AND2X1
XFILLER_109_92 VDD VSS FILLER1
X_11254_ _18137_/Q _14069_/B VDD VSS _11255_/B OR2X2
X_14042_ _14053_/A _14042_/B VDD VSS _18111_/D NOR2X1
XFILLER_106_394 VDD VSS FILLER1
X_10205_ _10364_/A _10364_/B _10376_/C _10205_/D VDD VSS _10378_/B OAOI211X1
X_18850_ _18850_/CK _18850_/D _18850_/Q VDD VSS DFFQX1
XFILLER_69_96 VDD VSS DECAPHV16
X_11185_ _17994_/Q _11185_/B _11185_/C VDD VSS _11189_/A MIN3X1
X_17801_ _19043_/CK _17801_/D _17801_/Q VDD VSS DFFQX1
XFILLER_121_375 VDD VSS FILLER1
XFILLER_122_898 VSS VDD FILLER2
XFILLER_67_429 VDD VSS FILLER1
XFILLER_94_215 VDD VSS FILLER4
XFILLER_94_226 VDD VSS FILLER1
X_10136_ _17818_/Q _10147_/B VDD VSS _10137_/D _10147_/C NAND3X1
X_18781_ _18808_/CK _18781_/D _18781_/Q VDD VSS DFFQX1
X_15993_ _18898_/Q _16527_/B VDD VSS _15994_/C NAND2X1
XFILLER_121_397 VSS VDD FILLER2
XFILLER_125_80 VDD VSS DECAPHV8
XFILLER_76_941 VDD VSS FILLER4
XTAP_TAPCELL_ROW_78_958 VDD VSS WELLTAP
X_10067_ _10064_/A _10067_/B VDD VSS _10068_/C NOR2BX1
X_17732_ clkload6/A _17732_/D _17732_/Q VDD VSS DFFQX1
X_14944_ _14944_/A _15090_/A _14944_/C VDD VSS _14947_/C MIN3X1
XFILLER_36_816 VDD VSS FILLER1
XFILLER_36_827 VSS VDD FILLER2
X_17663_ _17698_/CK _17663_/D _17663_/Q VDD VSS DFFQX1
XFILLER_29_890 VSS VDD FILLER2
XFILLER_47_175 VDD VSS FILLER1
XTAP_TAPCELL_ROW_124_1508 VDD VSS WELLTAP
X_16614_ _18826_/Q _18718_/Q VDD VSS _16616_/C NOR2X1
X_14875_ _14903_/A _14875_/B VDD VSS _18594_/D NOR2X1
XFILLER_16_540 VSS VDD FILLER2
XFILLER_62_134 VDD VSS FILLER4
XFILLER_90_465 VDD VSS FILLER4
X_17594_ _19052_/CK _17594_/D _17594_/Q VDD VSS DFFQX1
X_13826_ _18483_/Q _14461_/B VDD VSS _13867_/A NAND2X1
XFILLER_50_307 VSS VDD FILLER2
X_10969_ _10969_/A VDD VSS _10970_/B INVX1
X_16545_ _18797_/Q _18743_/Q _16545_/C VDD VSS _16570_/C MIN3X1
X_13757_ _18325_/Q _14280_/B VDD VSS _13758_/D NAND2X1
X_12708_ _18470_/Q _12708_/B _12708_/C VDD VSS _12924_/B MIN3X1
X_16476_ _18850_/Q _18688_/Q VDD VSS _16478_/C XNOR2X1
X_18215_ _18267_/CK _18215_/D _18215_/Q VDD VSS DFFQX1
X_15427_ _15737_/A VDD VSS _15669_/A BUFX3
X_13688_ _13696_/A _13688_/B _13688_/C VDD VSS _13690_/C XNOR3X1
XFILLER_102_1002 VDD VSS DECAPHV8
XFILLER_89_1111 VDD VSS FILLER1
XTAP_TAPCELL_ROW_5_81 VDD VSS WELLTAP
X_12639_ _18261_/Q VDD VSS _12640_/A INVX1
XFILLER_102_1046 VDD VSS FILLER4
XFILLER_129_464 VDD VSS FILLER1
XTAP_TAPCELL_ROW_135_1637 VDD VSS WELLTAP
X_18146_ _18171_/CK _18146_/D _18146_/Q VDD VSS DFFQX1
X_15358_ _18864_/Q _18863_/Q _16784_/A VDD VSS _15769_/B AO21X2
XFILLER_102_1068 VDD VSS FILLER1
XFILLER_7_282 VDD VSS DECAPHV32
X_18077_ _18082_/CK _18077_/D output9/A VDD VSS DFFQX1
X_15289_ _15318_/A _18856_/Q VDD VSS _18829_/D AND2X1
X_14309_ _14332_/A _14309_/B _14309_/C VDD VSS _18350_/D NOR3X1
XFILLER_104_309 VSS VDD FILLER2
XFILLER_132_607 VDD VSS DECAPHV8
X_17028_ _17030_/C _17028_/B VDD VSS _17029_/B XOR2X1
XFILLER_131_128 VDD VSS DECAPHV32
X_09850_ _09976_/A _10042_/B VDD VSS _17805_/D NOR2X1
XFILLER_100_504 VDD VSS FILLER1
XFILLER_58_429 VDD VSS FILLER4
X_09781_ _19052_/Q _17353_/B VDD VSS _09783_/C XNOR2X1
X_18979_ _18982_/CK _18979_/D _18979_/Q VDD VSS DFFQX1
XFILLER_27_805 VDD VSS FILLER1
XFILLER_61_1085 VDD VSS FILLER4
XFILLER_66_462 VDD VSS FILLER1
XFILLER_66_495 VDD VSS DECAPHV8
XFILLER_82_955 VSS VDD FILLER2
XFILLER_94_793 VDD VSS FILLER4
XFILLER_26_348 VDD VSS FILLER4
XFILLER_42_808 VDD VSS DECAPHV16
XFILLER_22_510 VDD VSS FILLER1
XFILLER_53_167 VSS VDD FILLER2
XFILLER_53_178 VSS VDD FILLER2
XFILLER_53_189 VDD VSS DECAPHV16
X_09215_ _09215_/A _09221_/B VDD VSS _17331_/B XNOR2X1
XFILLER_136_935 VDD VSS DECAPHV8
X_09146_ _09143_/A _09146_/B _09146_/C VDD VSS _09168_/A AOI2B1X1
X_09077_ _17567_/Q _17355_/B VDD VSS _09083_/B XOR2X1
XFILLER_135_456 VDD VSS DECAPHV8
XFILLER_30_57 VSS VDD FILLER2
XTAP_TAPCELL_ROW_1_28 VDD VSS WELLTAP
XFILLER_116_692 VDD VSS FILLER4
XFILLER_89_510 VDD VSS FILLER4
XFILLER_103_375 VDD VSS DECAPHV32
XFILLER_131_662 VDD VSS FILLER1
XFILLER_131_684 VDD VSS DECAPHV16
X_09979_ _17799_/Q _09997_/B VDD VSS _09989_/C XOR2X1
Xclkbuf_leaf_0__000_ clkload110/A VDD VSS _18857_/CK BUFX12
XFILLER_29_153 VDD VSS FILLER1
XFILLER_58_974 VSS VDD FILLER2
XTAP_TAPCELL_ROW_75_917 VDD VSS WELLTAP
X_12990_ wire27/Y _13091_/B _13091_/C _13091_/D VDD VSS _13105_/B AOI211X1
XFILLER_17_326 VSS VDD FILLER2
XFILLER_55_32 VDD VSS DECAPHV32
XFILLER_73_933 VDD VSS DECAPHV16
XFILLER_91_229 VDD VSS DECAPHV8
X_11941_ _18202_/Q VDD VSS _12023_/A INVX1
XFILLER_33_819 VDD VSS DECAPHV8
XFILLER_72_443 VSS VDD FILLER2
XTAP_TAPCELL_ROW_27_343 VDD VSS WELLTAP
X_11872_ _12039_/A _12039_/B VDD VSS _11874_/B NOR2X1
X_14660_ _18549_/Q _18581_/Q VDD VSS _14661_/B XOR2X1
XFILLER_25_370 VSS VDD FILLER2
XTAP_TAPCELL_ROW_55_674 VDD VSS WELLTAP
X_10823_ _10824_/A _10824_/B _10824_/D _10824_/C VDD VSS _10823_/Y AOAI211X1
X_14591_ _14591_/A _14591_/B _14591_/C _14591_/D VDD VSS _14592_/C AOAI211X1
X_13611_ _18323_/Q _13611_/B _13621_/C VDD VSS _13705_/B XNOR3X1
XFILLER_41_852 VDD VSS FILLER1
X_16330_ _18818_/Q _18710_/Q VDD VSS _16333_/C NOR2X1
X_13542_ _13542_/A _13542_/B _13542_/C _13542_/D VDD VSS _13686_/A AOAI211X1
XFILLER_13_554 VDD VSS FILLER4
XFILLER_40_362 VSS VDD FILLER2
XFILLER_71_64 VDD VSS DECAPHV8
X_10754_ _10756_/C _10754_/B VDD VSS _10883_/B NOR2X1
XFILLER_13_587 VDD VSS FILLER1
X_10685_ _10687_/B _10685_/B _17898_/Q VDD VSS _10686_/D AND3BX1
X_18000_ _18000_/CK _18000_/D _18000_/Q VDD VSS DFFQX1
X_16261_ _16261_/A _16261_/B VDD VSS _16298_/B _16261_/C NAND3X1
X_13473_ _13473_/A _13473_/B _13473_/C _13473_/D VDD VSS _14306_/C OA211X2
X_12424_ _12424_/A _14201_/B _12424_/C _12424_/D VDD VSS _12626_/A AOAI211X1
X_16192_ _18903_/Q _16192_/B VDD VSS _16229_/A AND2X1
X_15212_ _15240_/A _18781_/Q VDD VSS _18754_/D AND2X1
X_12355_ _18980_/Q _18101_/Q VDD VSS _12356_/D NAND2X1
X_15143_ _15281_/A _18713_/Q VDD VSS _18686_/D AND2X1
XFILLER_4_230 VSS VDD FILLER2
XFILLER_5_742 VSS VDD FILLER2
X_11306_ _11316_/A _11316_/B _11316_/C VDD VSS _11309_/C NOR3X1
XFILLER_113_128 VDD VSS DECAPHV32
XFILLER_99_329 VDD VSS DECAPHV8
X_12286_ _18441_/Q VDD VSS _12400_/A INVX1
X_15074_ _15078_/A _15078_/B _15074_/C VDD VSS _18637_/D AOI21X1
X_11237_ _18110_/Q _14041_/B VDD VSS _11238_/B OR2X2
X_18902_ _18959_/CK _18902_/D _18902_/Q VDD VSS DFFQX1
X_14025_ _17154_/A _18973_/Q VDD VSS _18094_/D AND2X1
XFILLER_95_524 VDD VSS DECAPHV16
XTAP_TAPCELL_ROW_130_1578 VDD VSS WELLTAP
X_11168_ _11205_/A _17114_/B VDD VSS _18017_/D NOR2X1
X_18833_ _18835_/CK _18833_/D _18833_/Q VDD VSS DFFQX1
XFILLER_110_835 VDD VSS FILLER4
XFILLER_49_952 VDD VSS DECAPHV8
X_10119_ _10111_/B _10119_/B _17815_/Q VDD VSS _10120_/D AND3BX1
X_18764_ _18818_/CK _18764_/D _18764_/Q VDD VSS DFFQX1
X_11099_ _11099_/A _11099_/B _11099_/C VDD VSS _11103_/C MIN3X1
X_17715_ _17716_/CK _17715_/D _17715_/Q VDD VSS DFFQX1
X_15976_ _18037_/Q _18647_/Q VDD VSS _15997_/C NAND2X1
XFILLER_64_922 VDD VSS FILLER1
XFILLER_82_229 VSS VDD FILLER2
X_18695_ _18857_/CK _18695_/D _18695_/Q VDD VSS DFFQX1
X_14927_ _17396_/A VDD VSS _15093_/A BUFX3
XFILLER_36_668 VDD VSS FILLER1
XTAP_TAPCELL_ROW_85_1035 VDD VSS WELLTAP
X_17646_ _17680_/CK _17646_/D _17646_/Q VDD VSS DFFQX1
X_14858_ _14861_/A _14858_/B _14858_/C VDD VSS _18590_/D AOI21X1
XFILLER_17_882 VSS VDD FILLER2
XFILLER_23_329 VSS VDD FILLER2
XFILLER_35_189 VSS VDD FILLER2
XFILLER_90_251 VDD VSS FILLER4
X_17577_ _19034_/CK _17577_/D _17577_/Q VDD VSS DFFQX1
X_13809_ _13809_/A _13809_/B _13809_/C _13809_/D VDD VSS _13845_/B AOAI211X1
XFILLER_16_370 VDD VSS FILLER4
XFILLER_32_852 VDD VSS FILLER4
X_16528_ _16875_/A _16528_/B _16528_/C VDD VSS _18912_/D OAI21X1
X_14789_ _14789_/A _14790_/C _14789_/C VDD VSS _18575_/D AOI21X1
XFILLER_31_384 VDD VSS FILLER1
X_09000_ _09000_/A _09000_/B VDD VSS _17423_/B XNOR2X1
X_16459_ _16459_/A VDD VSS _16800_/A BUFX3
XFILLER_77_0 VDD VSS DECAPHV32
X_18129_ _18985_/CK _18129_/D _18129_/Q VDD VSS DFFQX1
XFILLER_118_979 VDD VSS FILLER4
XTAP_TAPCELL_ROW_96_1175 VDD VSS WELLTAP
XFILLER_6_81 VDD VSS DECAPHV32
XFILLER_113_640 VDD VSS FILLER4
XFILLER_116_49 VDD VSS DECAPHV32
XFILLER_132_459 VDD VSS DECAPHV8
XFILLER_59_705 VSS VDD FILLER2
X_09902_ _09904_/A _09904_/B VDD VSS _09909_/B XNOR2X1
X_09833_ _17774_/Q _09838_/C VDD VSS _09999_/A XNOR2X1
XFILLER_100_323 VSS VDD FILLER2
XFILLER_112_172 VDD VSS FILLER1
XFILLER_112_194 VDD VSS DECAPHV8
X_09764_ _09764_/A VDD VSS _17420_/B INVX1
XFILLER_54_421 VDD VSS FILLER1
X_09695_ _17753_/Q _17721_/Q _09695_/C VDD VSS _09720_/C AOI2B1X1
XFILLER_82_774 VDD VSS DECAPHV8
XTAP_TAPCELL_ROW_24_302 VDD VSS WELLTAP
XFILLER_23_852 VSS VDD FILLER2
XFILLER_25_46 VDD VSS FILLER1
XFILLER_41_126 VDD VSS DECAPHV8
XFILLER_81_295 VDD VSS DECAPHV8
XTAP_TAPCELL_ROW_105_1282 VDD VSS WELLTAP
XTAP_TAPCELL_ROW_52_644 VDD VSS WELLTAP
XTAP_TAPCELL_ROW_80_975 VDD VSS WELLTAP
XFILLER_50_693 VDD VSS FILLER4
XFILLER_136_710 VDD VSS DECAPHV8
X_10470_ _17839_/Q _10470_/B _10470_/C VDD VSS _10477_/B XNOR3X1
X_09129_ _17732_/Q _09129_/B _09129_/C VDD VSS _09155_/C MIN3X1
XFILLER_135_253 VDD VSS DECAPHV16
XFILLER_68_1014 VSS VDD FILLER2
X_12140_ _14113_/B _14113_/C _18177_/Q VDD VSS _12234_/B AO21X2
X_12071_ _12224_/C VDD VSS _12221_/C INVX1
XFILLER_1_277 VSS VDD FILLER2
XFILLER_77_513 VDD VSS FILLER4
XFILLER_89_362 VDD VSS DECAPHV8
X_11022_ _17962_/Q _11022_/B _11022_/C VDD VSS _11025_/C MIN3X1
XFILLER_104_695 VSS VDD FILLER2
X_15830_ _15834_/A _15834_/C VDD VSS _15831_/B XNOR2X1
XFILLER_64_207 VDD VSS FILLER1
XFILLER_79_1132 VDD VSS FILLER4
XFILLER_92_549 VSS VDD FILLER2
X_12973_ _14208_/B _14208_/C _18264_/Q VDD VSS _13076_/B AOI21X1
X_15761_ _15784_/A _16316_/A _15761_/C VDD VSS _15803_/B OA21X2
XFILLER_17_123 VSS VDD FILLER2
X_11924_ _11924_/A _11924_/B _11924_/C _11924_/D VDD VSS _14139_/B AOAI211X1
X_18480_ _18480_/CK _18480_/D _18480_/Q VDD VSS DFFQX1
X_17500_ _17561_/C _17736_/Q VDD VSS _17704_/D AND2X1
X_15692_ _15737_/A _17006_/A _15692_/C VDD VSS _18884_/D OAI21X1
X_14712_ _18559_/Q _18591_/Q _14712_/C VDD VSS _14717_/C AO21X2
XFILLER_122_81 VDD VSS DECAPHV32
XFILLER_61_914 VDD VSS DECAPHV8
X_17431_ _17561_/C _17431_/B VDD VSS _17638_/D AND2X1
X_14643_ _18545_/Q _18577_/Q VDD VSS _14646_/A XOR2X1
XFILLER_127_1119 VDD VSS DECAPHV16
XFILLER_17_189 VDD VSS FILLER4
XFILLER_32_115 VDD VSS FILLER1
XFILLER_61_947 VDD VSS FILLER1
XFILLER_72_284 VDD VSS FILLER4
XFILLER_72_295 VDD VSS DECAPHV16
X_11855_ _11931_/A _11931_/B _11931_/C _11855_/D VDD VSS _12032_/A OAOI211X1
X_10806_ _17922_/Q _10811_/B VDD VSS _10809_/A XOR2X1
X_11786_ _11786_/A _11786_/B _11845_/C _11786_/D VDD VSS wire29/A OAOI211X1
X_17362_ _17392_/A _17362_/B VDD VSS _17573_/D AND2X1
X_14574_ _18530_/Q _18562_/Q VDD VSS _14575_/B XNOR2X1
XFILLER_40_170 VDD VSS DECAPHV32
XFILLER_9_333 VDD VSS DECAPHV32
X_10737_ _11148_/A _10868_/B VDD VSS _17933_/D AND2X1
X_17293_ _17302_/A _17302_/D VDD VSS _17297_/C NAND2X1
X_16313_ _16313_/A VDD VSS _16315_/C INVX1
X_13525_ _13525_/A _13525_/B _13525_/C _13525_/D VDD VSS _13655_/A AOAI211X1
XFILLER_9_377 VDD VSS FILLER1
X_19032_ _19033_/CK _19032_/D _19032_/Q VDD VSS DFFQX1
X_16244_ _18790_/Q _18736_/Q VDD VSS _16293_/B XNOR2X1
X_13456_ _18399_/Q _13639_/A _13639_/B VDD VSS _13457_/D XNOR3X1
XFILLER_127_743 VDD VSS FILLER1
X_10668_ _17895_/Q _10668_/B _10668_/C VDD VSS _10676_/A MIN3X1
X_12407_ _12489_/A _12489_/B _14356_/B VDD VSS _12601_/B MIN3X1
XTAP_TAPCELL_ROW_132_1607 VDD VSS WELLTAP
X_10599_ _10599_/A _10602_/B VDD VSS _10738_/B XNOR2X1
X_16175_ _18042_/Q _18652_/Q VDD VSS _16176_/D NOR2X1
X_13387_ _18268_/Q _13493_/A _13493_/B VDD VSS _13395_/D XNOR3X1
XFILLER_115_949 VDD VSS FILLER1
XFILLER_127_787 VSS VDD FILLER2
XFILLER_127_798 VSS VDD FILLER2
XFILLER_5_561 VDD VSS DECAPHV32
X_12338_ _12338_/A _12338_/B _12338_/C _12338_/D VDD VSS _12522_/A AOAI211X1
X_15126_ _17182_/D _18696_/Q VDD VSS _18669_/D AND2X1
XFILLER_99_148 VDD VSS FILLER4
X_12269_ _18284_/Q _12419_/A _12506_/B VDD VSS _12503_/D XNOR3X1
X_15057_ _18633_/Q _19011_/Q _15057_/C VDD VSS _15065_/A MIN3X1
X_14008_ _14013_/A _14008_/B _14008_/C _14013_/D VDD VSS _18080_/D OAOI211X1
XFILLER_68_557 VDD VSS DECAPHV8
XFILLER_95_354 VDD VSS DECAPHV8
X_18816_ _18844_/CK _18816_/D _18816_/Q VDD VSS DFFQX1
XFILLER_37_911 VDD VSS DECAPHV8
XFILLER_37_933 VDD VSS FILLER4
XFILLER_83_538 VDD VSS DECAPHV8
X_18747_ _18801_/CK _18747_/D _18747_/Q VDD VSS DFFQX1
X_15959_ _18809_/Q _18701_/Q VDD VSS _15961_/C NAND2X1
X_09480_ _09502_/A _09502_/B VDD VSS _17477_/B XOR2X1
X_18678_ _18841_/CK _18678_/D _18678_/Q VDD VSS DFFQX1
XFILLER_23_104 VDD VSS FILLER1
XFILLER_91_571 VDD VSS FILLER1
XFILLER_51_435 VDD VSS DECAPHV8
X_17629_ _17725_/CK _17629_/D _17629_/Q VDD VSS DFFQX1
XFILLER_51_468 VDD VSS DECAPHV8
XFILLER_108_1096 VSS VDD FILLER2
XFILLER_31_181 VDD VSS FILLER4
XFILLER_30_1113 VSS VDD FILLER2
XFILLER_117_242 VSS VDD FILLER2
XFILLER_11_48 VDD VSS DECAPHV8
XFILLER_105_426 VDD VSS DECAPHV8
XFILLER_106_949 VDD VSS FILLER1
XFILLER_121_919 VDD VSS DECAPHV8
XFILLER_120_429 VSS VDD FILLER2
XFILLER_132_267 VDD VSS DECAPHV32
XFILLER_59_513 VDD VSS FILLER1
XFILLER_101_621 VDD VSS DECAPHV8
XFILLER_115_1034 VSS VDD FILLER2
XFILLER_100_142 VDD VSS FILLER4
XFILLER_101_654 VDD VSS FILLER1
XFILLER_59_557 VDD VSS FILLER1
XTAP_TAPCELL_ROW_57_703 VDD VSS WELLTAP
X_09816_ _09843_/A _09945_/A VDD VSS _17794_/D NOR2X1
XFILLER_100_175 VDD VSS FILLER1
XFILLER_115_1089 VDD VSS FILLER1
XFILLER_28_922 VDD VSS FILLER4
XTAP_TAPCELL_ROW_107_1300 VDD VSS WELLTAP
X_09747_ _09747_/A _09747_/B VDD VSS _09748_/B _09747_/C NAND3X1
XFILLER_55_763 VSS VDD FILLER2
XFILLER_43_925 VDD VSS FILLER1
XTAP_TAPCELL_ROW_37_460 VDD VSS WELLTAP
X_09678_ _09712_/B _09678_/B VDD VSS _17349_/B NAND2X1
XFILLER_15_649 VSS VDD FILLER2
XFILLER_42_424 VSS VDD FILLER2
XFILLER_42_446 VDD VSS FILLER1
XFILLER_30_619 VDD VSS FILLER1
XFILLER_42_479 VDD VSS DECAPHV8
X_11640_ _18147_/Q _11784_/A _11847_/B VDD VSS _11766_/D XNOR3X1
XFILLER_35_1046 VSS VDD FILLER2
XFILLER_52_44 VSS VDD FILLER2
X_11571_ _18172_/Q _11691_/A _11766_/B VDD VSS _11672_/D XNOR3X1
X_10522_ _10669_/A _10669_/B _10670_/C _10522_/D VDD VSS _10533_/A OAOI211X1
X_172_ _172_/CK _172_/E _172_/ECK VDD VSS CGX3
X_13310_ _18163_/Q _14098_/B VDD VSS _13311_/D NOR2BX1
XFILLER_11_899 VSS VDD FILLER2
X_14290_ _14313_/A _14290_/B VDD VSS _18333_/D NOR2X1
XFILLER_136_551 VDD VSS FILLER4
XTAP_TAPCELL_ROW_118_1440 VDD VSS WELLTAP
X_10453_ _10456_/A _10456_/B VDD VSS _10457_/C XNOR2X1
X_13241_ _18475_/Q _13343_/A _13343_/B VDD VSS _13337_/B XNOR3X1
XFILLER_136_584 VDD VSS FILLER1
X_10384_ _10561_/A _10561_/B _10561_/C _10562_/C VDD VSS _10571_/B OAOI211X1
X_13172_ _13267_/A _13267_/B _13267_/C VDD VSS _14332_/B AOI21X1
XFILLER_7_0 VDD VSS DECAPHV32
XTAP_TAPCELL_ROW_9_130 VDD VSS WELLTAP
X_12123_ _12123_/A _12123_/B _12123_/C _12123_/D VDD VSS _14170_/B AOAI211X1
X_17980_ _17982_/CK _17980_/D _17980_/Q VDD VSS DFFQX1
XFILLER_78_822 VDD VSS FILLER1
X_12054_ _12054_/A _14054_/B _12054_/C _12054_/D VDD VSS _12255_/B AOI31X1
X_16931_ _16947_/A _16931_/B _16932_/B _16957_/A VDD VSS _16948_/A OAOI211X1
XFILLER_117_92 VDD VSS FILLER1
XFILLER_123_289 VSS VDD FILLER2
XFILLER_81_1033 VDD VSS FILLER1
XFILLER_77_96 VDD VSS DECAPHV16
X_11005_ _11005_/A _11005_/B _11005_/C VDD VSS _11006_/B NOR3X1
X_16862_ _18925_/Q _16862_/B VDD VSS _16863_/C NAND2X1
XFILLER_19_933 VSS VDD FILLER2
X_18601_ clkload1/A _18601_/D _18601_/Q VDD VSS DFFQX1
X_16793_ _18920_/Q _16793_/B VDD VSS _16808_/C NAND2X1
X_15813_ _18033_/Q _18643_/Q VDD VSS _15842_/A NAND2X1
XFILLER_133_80 VDD VSS DECAPHV8
XFILLER_92_346 VDD VSS FILLER1
XFILLER_93_858 VDD VSS FILLER1
X_18532_ clkload4/A _18532_/D _18532_/Q VDD VSS DFFQX1
X_15744_ _15746_/B _15744_/B VDD VSS _17018_/A XNOR2X1
X_12956_ _18342_/Q _14301_/B VDD VSS _13170_/C _14301_/C AND3X2
XFILLER_33_413 VDD VSS FILLER1
XFILLER_61_755 VDD VSS FILLER4
XTAP_TAPCELL_ROW_82_1005 VDD VSS WELLTAP
X_11907_ _12102_/A _12102_/B _14348_/B VDD VSS _11983_/B MIN3X1
X_12887_ _18987_/Q _18108_/Q VDD VSS _13108_/A XOR2X1
X_18463_ _18493_/CK _18463_/D _18463_/Q VDD VSS DFFQX1
X_15675_ _15695_/A _15675_/B VDD VSS _15676_/C NAND2X1
X_11838_ _12013_/B _11839_/C _18279_/Q VDD VSS _12077_/B AOI21X1
X_18394_ _18448_/CK _18394_/D _18394_/Q VDD VSS DFFQX1
X_17414_ _17446_/A _17414_/B VDD VSS _17622_/D AND2X1
X_14626_ _18540_/Q _18572_/Q _14626_/C VDD VSS _14630_/B MIN3X1
XFILLER_14_671 VDD VSS DECAPHV16
X_17345_ _17355_/A _17345_/B VDD VSS _19044_/D NOR2X1
X_14557_ _14562_/C _14562_/B VDD VSS _14559_/B NAND2BX1
XTAP_TAPCELL_ROW_15_198 VDD VSS WELLTAP
X_11769_ _11769_/A _14136_/B _11769_/C _11769_/D VDD VSS _11924_/A AOAI211X1
X_13508_ _18477_/Q _14455_/B VDD VSS _13525_/A NAND2X1
XFILLER_9_174 VSS VDD FILLER2
XFILLER_9_185 VDD VSS FILLER1
X_19015_ _19019_/CK _19015_/D _19015_/Q VDD VSS DFFQX1
X_17276_ _17277_/A _17277_/B _17278_/B _17455_/A VDD VSS _17277_/D AOAI211X1
X_14488_ _14517_/A _14488_/B VDD VSS _18501_/D NOR2X1
X_16227_ _18904_/Q _16227_/B VDD VSS _16229_/C XNOR2X1
X_13439_ _18477_/Q _14455_/B VDD VSS _13583_/A AND2X1
XFILLER_6_881 VSS VDD FILLER2
X_16158_ _16158_/A _16158_/B _16158_/C _16158_/D VDD VSS _16250_/A AOAI211X1
XTAP_TAPCELL_ROW_93_1134 VDD VSS WELLTAP
X_15109_ _15274_/A _18680_/Q VDD VSS _18653_/D AND2X1
X_08980_ _08980_/A _08982_/C VDD VSS _08981_/B XNOR2X1
Xclkbuf_0_clk_fs_regs clkbuf_regs_0_clk_fs/Y VDD VSS clkbuf_0_clk_fs_regs/Y BUFX12
X_16089_ _16089_/A _16089_/B _16089_/C _16089_/D VDD VSS _16090_/C AOI211X1
XFILLER_68_310 VDD VSS DECAPHV8
XFILLER_29_708 VDD VSS DECAPHV16
XFILLER_96_674 VDD VSS FILLER1
XFILLER_110_484 VSS VDD FILLER2
XFILLER_28_207 VDD VSS DECAPHV8
XFILLER_28_229 VSS VDD FILLER2
XFILLER_56_538 VDD VSS FILLER1
XFILLER_95_162 VSS VDD FILLER2
XFILLER_96_696 VDD VSS FILLER1
X_09601_ _17654_/Q _17448_/B VDD VSS _09602_/C NOR2X1
XFILLER_37_730 VDD VSS FILLER4
X_09532_ _17684_/Q _17479_/B VDD VSS _09556_/A XOR2X1
XFILLER_37_774 VDD VSS FILLER1
XFILLER_52_711 VDD VSS FILLER4
XFILLER_25_947 VDD VSS DECAPHV8
XFILLER_51_221 VSS VDD FILLER2
XFILLER_52_722 VSS VDD FILLER2
X_09463_ _19040_/Q _17341_/B VDD VSS _09465_/C XNOR2X1
XFILLER_40_906 VDD VSS DECAPHV8
XFILLER_51_254 VDD VSS FILLER1
XFILLER_52_788 VSS VDD FILLER2
XFILLER_58_1068 VDD VSS FILLER1
XTAP_TAPCELL_ROW_34_430 VDD VSS WELLTAP
XTAP_TAPCELL_ROW_62_761 VDD VSS WELLTAP
X_09394_ _09423_/C _09394_/B VDD VSS _17474_/B XNOR2X1
XFILLER_51_265 VSS VDD FILLER2
XTAP_TAPCELL_ROW_102_1241 VDD VSS WELLTAP
XFILLER_20_652 VDD VSS FILLER4
XFILLER_20_685 VDD VSS FILLER4
XFILLER_65_1006 VDD VSS FILLER1
XFILLER_102_941 VDD VSS FILLER1
XFILLER_59_310 VSS VDD FILLER2
XTAP_TAPCELL_ROW_113_1370 VDD VSS WELLTAP
XFILLER_102_963 VDD VSS DECAPHV8
XFILLER_75_814 VDD VSS DECAPHV16
XFILLER_47_538 VDD VSS FILLER4
XFILLER_59_365 VSS VDD FILLER2
XFILLER_59_387 VDD VSS FILLER4
XFILLER_87_696 VDD VSS FILLER1
XFILLER_28_752 VDD VSS FILLER1
XFILLER_41_1050 VDD VSS FILLER4
XFILLER_47_549 VSS VDD FILLER2
XFILLER_47_88 VDD VSS FILLER1
X_12810_ _18444_/Q _12810_/B _12810_/C VDD VSS _14447_/B XNOR3X1
XFILLER_74_368 VDD VSS DECAPHV16
X_13790_ _13790_/A _13838_/A _13847_/B VDD VSS _13792_/C XNOR3X1
XFILLER_15_435 VSS VDD FILLER2
XFILLER_16_936 VDD VSS FILLER1
XFILLER_63_32 VDD VSS DECAPHV32
X_12741_ _12741_/A _14264_/B _12741_/C _12741_/D VDD VSS _13011_/A OAOI211X1
XFILLER_15_468 VDD VSS FILLER1
XFILLER_31_917 VDD VSS DECAPHV8
XFILLER_42_243 VSS VDD FILLER2
X_12672_ _18985_/Q _18106_/Q VDD VSS _12994_/A OR2X2
X_15460_ _15874_/B _15460_/B VDD VSS _15461_/C NAND2X1
X_11623_ _11623_/A _11623_/B _11623_/C _11623_/D VDD VSS wire28/A OAOI211X1
X_14411_ _14414_/A _14411_/B VDD VSS _18438_/D NOR2X1
XFILLER_8_49 VDD VSS DECAPHV32
X_17130_ _18021_/Q _17135_/B VDD VSS _17132_/C XNOR2X1
X_15391_ _18913_/Q _15393_/B VDD VSS _15395_/B NOR2BX1
XFILLER_128_315 VDD VSS DECAPHV8
XTAP_TAPCELL_ROW_12_157 VDD VSS WELLTAP
XTAP_TAPCELL_ROW_12_168 VDD VSS WELLTAP
X_11554_ _18119_/Q _11637_/A _11637_/B VDD VSS _11556_/C XNOR3X1
X_14342_ _14342_/A _14342_/B _14343_/A VDD VSS _18378_/D OA21X2
XTAP_TAPCELL_ROW_40_499 VDD VSS WELLTAP
X_10505_ _10669_/A _10669_/B _10670_/C VDD VSS _10673_/B OAI21X1
X_11485_ _11603_/A _11603_/B _11603_/C _11485_/D VDD VSS _11621_/A OAOI211X1
X_17061_ _18008_/Q _17066_/B VDD VSS _17063_/C XOR2X1
X_14273_ _14296_/A _14273_/B _14273_/C VDD VSS _18320_/D NOR3X1
XFILLER_124_510 VDD VSS FILLER1
X_10436_ _10436_/A _10439_/B VDD VSS _10616_/B XNOR2X1
X_13224_ _18162_/Q _14097_/B VDD VSS _13314_/A NOR2X1
X_16012_ _16038_/A _16038_/B _16038_/C _16778_/A VDD VSS _16013_/D AOI31X1
XFILLER_3_840 VDD VSS DECAPHV32
XFILLER_88_40 VDD VSS FILLER4
XFILLER_98_939 VDD VSS FILLER1
X_10367_ _10707_/A _10564_/B VDD VSS _17875_/D AND2X1
X_13155_ _14363_/A _14363_/B _14363_/C VDD VSS _13157_/B OAI21X1
XFILLER_111_204 VSS VDD FILLER2
XFILLER_112_749 VSS VDD FILLER2
X_10298_ _10488_/A _10488_/B _10489_/C VDD VSS _10499_/B OAI21X1
X_12106_ _18412_/Q _12106_/B _12106_/C VDD VSS _12291_/B MIN3X1
X_13086_ _13086_/A _13086_/B _13086_/C _13086_/D VDD VSS _14121_/C AOI211X1
X_17963_ _18011_/CK _17963_/D _17963_/Q VDD VSS DFFQX1
XFILLER_78_663 VDD VSS DECAPHV16
X_12037_ _12146_/A _12146_/B VDD VSS _12221_/B NOR2X1
X_16914_ _16957_/A _16914_/B _16922_/A _16914_/D VDD VSS _16914_/Y AOI22X1
XFILLER_120_793 VDD VSS DECAPHV16
XFILLER_65_313 VSS VDD FILLER2
XFILLER_93_600 VDD VSS DECAPHV16
X_17894_ _17972_/CK _17894_/D _17894_/Q VDD VSS DFFQX1
XFILLER_20_1101 VDD VSS FILLER4
XFILLER_38_549 VDD VSS FILLER4
XFILLER_65_346 VSS VDD FILLER2
XFILLER_77_195 VDD VSS DECAPHV8
XFILLER_81_806 VSS VDD FILLER2
XFILLER_92_121 VDD VSS FILLER4
XTAP_TAPCELL_ROW_127_1539 VDD VSS WELLTAP
X_16845_ _16869_/C _16845_/B VDD VSS _16931_/B NAND2X1
XFILLER_34_700 VDD VSS FILLER1
XFILLER_34_711 VDD VSS DECAPHV8
XFILLER_93_688 VDD VSS FILLER1
X_16776_ _16934_/A _16798_/A VDD VSS _16791_/A NAND2X1
X_13988_ _18948_/Q _13988_/B _18949_/Q VDD VSS _13989_/C AOI21X1
XFILLER_33_210 VDD VSS FILLER1
XTAP_TAPCELL_ROW_48_599 VDD VSS WELLTAP
X_12939_ _12939_/A _14392_/B _14392_/C VDD VSS _13020_/C NOR3X1
X_18515_ _18547_/CK _18515_/D _18515_/Q VDD VSS DFFQX1
X_15727_ _18889_/Q _15736_/B VDD VSS _15728_/C NAND2X1
XFILLER_61_552 VDD VSS FILLER4
X_18446_ _18500_/CK _18446_/D _18446_/Q VDD VSS DFFQX1
X_15658_ _18931_/Q _15682_/C VDD VSS _15659_/B NAND2X1
X_14609_ _14611_/A _14611_/B _14609_/C VDD VSS _18537_/D AOI21X1
XFILLER_105_1011 VDD VSS FILLER1
X_18377_ _18431_/CK _18377_/D _18377_/Q VDD VSS DFFQX1
X_15589_ _18876_/Q _15668_/B VDD VSS _15590_/C NAND2X1
X_17328_ _17338_/A _17328_/B VDD VSS _19028_/D NOR2X1
X_17259_ _17259_/A _17259_/B _17259_/C _17259_/D VDD VSS _17262_/B AOI211X1
XFILLER_115_554 VDD VSS FILLER4
XFILLER_88_416 VSS VDD FILLER2
XFILLER_102_204 VDD VSS FILLER4
XFILLER_103_749 VDD VSS FILLER1
XFILLER_130_535 VSS VDD FILLER2
X_08963_ _08963_/A _08963_/B _08963_/C VDD VSS _08968_/C OAI21X1
XFILLER_130_557 VDD VSS FILLER1
XFILLER_130_579 VDD VSS DECAPHV16
XFILLER_25_1034 VDD VSS FILLER1
XFILLER_5_1106 VDD VSS DECAPHV8
XFILLER_64_1072 VDD VSS FILLER4
XFILLER_124_49 VDD VSS DECAPHV32
XFILLER_56_302 VSS VDD FILLER2
XFILLER_68_173 VDD VSS DECAPHV16
XFILLER_69_696 VDD VSS DECAPHV16
XFILLER_84_622 VDD VSS FILLER4
X_08894_ _17530_/B _17530_/A VDD VSS _08895_/C NOR2BX1
XFILLER_56_335 VDD VSS FILLER4
XTAP_TAPCELL_ROW_67_820 VDD VSS WELLTAP
XFILLER_71_338 VDD VSS FILLER4
X_09515_ _09525_/C _09515_/B VDD VSS _17376_/B NOR2BX1
XFILLER_24_254 VDD VSS DECAPHV16
XFILLER_80_850 VDD VSS FILLER4
X_09446_ _09426_/B _09446_/B VDD VSS _09447_/C NAND2BX1
XFILLER_25_799 VSS VDD FILLER2
XFILLER_52_574 VSS VDD FILLER2
Xclkbuf_leaf_32__001_ clkbuf_2_1__f__001_/Y VDD VSS _19033_/CK BUFX12
XFILLER_71_1021 VSS VDD FILLER2
X_09377_ _19037_/Q _17337_/B VDD VSS _09380_/B XNOR2X1
XFILLER_106_532 VDD VSS FILLER4
XFILLER_134_841 VDD VSS FILLER1
X_11270_ _18166_/Q VDD VSS _11380_/A INVX1
XFILLER_133_362 VDD VSS DECAPHV8
XFILLER_134_863 VDD VSS DECAPHV8
X_10221_ _10221_/A _10399_/B _10221_/C _10221_/D VDD VSS _10414_/A AOAI211X1
X_10152_ _10324_/B _10156_/B _10156_/D _10156_/C VDD VSS _10349_/C OAI211X1
XFILLER_48_803 VDD VSS FILLER1
XFILLER_58_32 VDD VSS DECAPHV8
X_10083_ _10083_/A _10083_/B _10083_/C VDD VSS _10107_/A MIN3X1
X_14960_ _14962_/B _14960_/B VDD VSS _14961_/B XOR2X1
XFILLER_0_898 VSS VDD FILLER2
XFILLER_121_579 VDD VSS FILLER1
XFILLER_130_1104 VDD VSS DECAPHV32
XFILLER_59_162 VDD VSS FILLER1
XFILLER_75_622 VDD VSS FILLER1
XFILLER_87_482 VSS VDD FILLER2
XFILLER_88_983 VSS VDD FILLER2
X_13911_ _13912_/B _13912_/C _13912_/A VDD VSS _13913_/C OAI21X1
XFILLER_47_335 VDD VSS FILLER1
X_14891_ _18597_/Q _18629_/Q _14891_/C VDD VSS _14896_/C AO21X2
XFILLER_16_700 VDD VSS DECAPHV32
XFILLER_47_379 VSS VDD FILLER2
X_16630_ _16630_/A _16630_/B VDD VSS _16631_/C NOR2X1
X_13842_ _18379_/Q _14343_/B VDD VSS _13843_/C NAND2X1
XTAP_TAPCELL_ROW_17_227 VDD VSS WELLTAP
X_16561_ _16566_/A _16566_/B VDD VSS _16564_/B XNOR2X1
X_13773_ _13774_/C _13773_/B _13774_/D _17536_/D VDD VSS _13773_/Y AOI31X1
XFILLER_128_1011 VDD VSS FILLER1
XTAP_TAPCELL_ROW_45_558 VDD VSS WELLTAP
X_10985_ _10985_/A VDD VSS _10986_/B INVX1
X_12724_ _18339_/Q _14298_/B _14298_/C VDD VSS _12796_/D OR3BX1
X_18300_ _18361_/CK _18300_/D _18300_/Q VDD VSS DFFQX1
X_15512_ _18919_/Q _18920_/Q VDD VSS _15527_/B _15512_/C NAND3X1
XFILLER_130_81 VDD VSS DECAPHV32
XFILLER_71_883 VDD VSS FILLER1
XTAP_TAPCELL_ROW_73_889 VDD VSS WELLTAP
X_18231_ _18253_/CK _18231_/D _18231_/Q VDD VSS DFFQX1
X_16492_ _18911_/Q _16927_/B _16530_/B _16492_/D VDD VSS _18911_/D AO22X2
X_12655_ _18182_/Q _14118_/B VDD VSS _12656_/D _14118_/C NAND3X1
X_15443_ _18864_/Q _15799_/B VDD VSS _15760_/B NOR2X1
X_11606_ _11606_/A _14134_/B _14134_/C VDD VSS _11607_/C NOR3X1
X_12586_ _18495_/Q _14479_/B VDD VSS _12589_/C NOR2X1
X_18162_ _18247_/CK _18162_/D _18162_/Q VDD VSS DFFQX1
X_15374_ _16657_/D _15374_/B _15374_/C VDD VSS _15374_/Y OAI21X1
X_11537_ _11537_/A _11537_/B _11537_/C _11537_/D VDD VSS _14105_/B AOAI211X1
X_18093_ _18988_/CK _18093_/D _18093_/Q VDD VSS DFFQX1
X_17113_ _17242_/A _17113_/B _17117_/B VDD VSS _18979_/D NOR3X1
X_14325_ _14332_/A _14325_/B _14325_/C VDD VSS _18363_/D NOR3X1
X_17044_ _17044_/A _17044_/B _17044_/C _17044_/D VDD VSS _18966_/D AOI31X1
X_11468_ _18273_/Q VDD VSS _11470_/A INVX1
X_14256_ _14269_/A _14256_/B VDD VSS _18305_/D NOR2X1
XTAP_TAPCELL_ROW_90_1104 VDD VSS WELLTAP
X_10419_ _10229_/Y _17854_/Q _10419_/C VDD VSS _10420_/D AND3BX1
X_11399_ _11399_/A _11399_/B _11399_/C _11399_/D VDD VSS _11448_/B OAOI211X1
X_13207_ _18187_/Q _14123_/B VDD VSS _13218_/A NAND2X1
X_14187_ _14372_/A _14187_/B VDD VSS _18245_/D AND2X1
XFILLER_135_1026 VDD VSS DECAPHV32
XFILLER_48_1056 VDD VSS FILLER4
X_13138_ _18422_/Q _13138_/B _13265_/D VDD VSS _13257_/C XNOR3X1
XFILLER_79_961 VSS VDD FILLER2
X_18995_ clkload9/A _18995_/D _18995_/Q VDD VSS DFFQX1
XFILLER_39_814 VSS VDD FILLER2
X_13069_ _12788_/A _14151_/B _14151_/C VDD VSS _13071_/C AND3BX1
X_17946_ _17972_/CK _17946_/D _17946_/Q VDD VSS DFFQX1
XFILLER_120_590 VDD VSS DECAPHV8
XFILLER_38_324 VDD VSS FILLER1
XFILLER_78_482 VDD VSS FILLER1
XFILLER_93_430 VDD VSS FILLER4
X_17877_ _17932_/CK _17877_/D _17877_/Q VDD VSS DFFQX1
XFILLER_26_508 VSS VDD FILLER2
XFILLER_66_666 VSS VDD FILLER2
XFILLER_93_463 VSS VDD FILLER2
XFILLER_94_975 VDD VSS FILLER1
XFILLER_94_997 VDD VSS FILLER1
X_16828_ _18922_/Q _16828_/B VDD VSS _16837_/A AND2X1
XFILLER_0_1025 VDD VSS DECAPHV8
XFILLER_54_839 VDD VSS DECAPHV16
XFILLER_80_113 VDD VSS DECAPHV8
XTAP_TAPCELL_ROW_88_1077 VDD VSS WELLTAP
XFILLER_80_146 VDD VSS FILLER1
X_09300_ _19034_/Q _17334_/B VDD VSS _09301_/A NAND2BX1
X_16759_ _18059_/Q _18669_/Q VDD VSS _16782_/B XOR2X1
XFILLER_55_1016 VDD VSS FILLER4
XFILLER_34_596 VSS VDD FILLER2
X_09231_ _17673_/Q _17468_/B VDD VSS _09252_/B XNOR2X1
X_18429_ _18480_/CK _18429_/D _18429_/Q VDD VSS DFFQX1
X_09162_ _09176_/B _09162_/B VDD VSS _17397_/B XNOR2X1
X_09093_ _19026_/Q _17326_/B VDD VSS _09094_/C NOR2X1
XFILLER_119_189 VDD VSS DECAPHV16
XFILLER_134_137 VSS VDD FILLER2
XFILLER_66_1134 VSS VDD FILLER2
XFILLER_89_747 VDD VSS DECAPHV8
XFILLER_76_408 VDD VSS FILLER1
XTAP_TAPCELL_ROW_110_1340 VDD VSS WELLTAP
X_09995_ _09935_/Y _10208_/B _10208_/C VDD VSS _17825_/D AND3BX1
XFILLER_130_376 VDD VSS DECAPHV8
X_08946_ _17749_/Q _18538_/Q VDD VSS _08952_/B NAND2X1
XFILLER_85_942 VDD VSS FILLER1
X_08877_ _08876_/B _17392_/A VDD VSS _173_/E NAND2BX1
XFILLER_56_132 VSS VDD FILLER2
XFILLER_84_452 VDD VSS FILLER1
XFILLER_44_316 VSS VDD FILLER2
XFILLER_60_809 VDD VSS DECAPHV32
XTAP_TAPCELL_ROW_42_517 VDD VSS WELLTAP
XTAP_TAPCELL_ROW_42_528 VDD VSS WELLTAP
X_10770_ _10768_/Y _10770_/B VDD VSS _10901_/B NOR2BX1
XFILLER_100_40 VDD VSS FILLER4
XFILLER_12_224 VDD VSS FILLER1
XFILLER_12_235 VDD VSS DECAPHV16
XFILLER_13_747 VDD VSS DECAPHV16
XFILLER_9_718 VDD VSS DECAPHV16
XTAP_TAPCELL_ROW_70_859 VDD VSS WELLTAP
X_09429_ _17616_/Q _17407_/B VDD VSS _09431_/C XNOR2X1
XFILLER_40_566 VDD VSS FILLER4
XFILLER_40_588 VSS VDD FILLER2
XFILLER_8_206 VDD VSS DECAPHV16
X_12440_ _12653_/A _12653_/B VDD VSS _14117_/B XNOR2X1
XFILLER_60_44 VSS VDD FILLER2
XTAP_TAPCELL_ROW_22_285 VDD VSS WELLTAP
X_12371_ _18285_/Q _12371_/B _12419_/C VDD VSS _12421_/C XNOR3X1
X_14110_ _14122_/A _14110_/B _14110_/C VDD VSS _18174_/D NOR3X1
X_11322_ _11359_/A _11389_/B _11389_/C VDD VSS _11388_/B XNOR3X1
X_15090_ _15090_/A _17312_/A _15090_/C VDD VSS _15095_/C MIN3X1
XFILLER_107_0 VDD VSS DECAPHV32
XFILLER_107_874 VSS VDD FILLER2
X_11253_ _18164_/Q _14099_/B VDD VSS _11327_/B NOR2X1
X_14041_ _14310_/C _14041_/B VDD VSS _18110_/D AND2X1
XFILLER_69_64 VDD VSS DECAPHV16
X_10204_ _10203_/Y _10204_/B _17824_/Q VDD VSS _10205_/D AND3BX1
X_11184_ _11184_/A VDD VSS _11185_/B INVX1
X_17800_ _19043_/CK _17800_/D _17800_/Q VDD VSS DFFQX1
XFILLER_0_673 VSS VDD FILLER2
XFILLER_121_354 VDD VSS DECAPHV8
X_10135_ _10147_/B _10147_/C _17818_/Q VDD VSS _10137_/C AOI21X1
X_18780_ _18780_/CK _18780_/D _18780_/Q VDD VSS DFFQX1
X_15992_ _16030_/A _15992_/B VDD VSS _15994_/B XOR2X1
XFILLER_125_92 VDD VSS FILLER1
XTAP_TAPCELL_ROW_78_959 VDD VSS WELLTAP
X_10066_ _10114_/A _10256_/B VDD VSS _17834_/D NOR2X1
X_17731_ clkload6/A _17731_/D _17731_/Q VDD VSS DFFQX1
X_14943_ _18640_/Q VDD VSS _15090_/A INVX1
XFILLER_76_975 VDD VSS FILLER1
XFILLER_78_1005 VDD VSS FILLER4
X_17662_ _19024_/CK _17662_/D _17662_/Q VDD VSS DFFQX1
X_14874_ _14878_/C _14874_/B VDD VSS _14875_/B XNOR2X1
XFILLER_35_338 VSS VDD FILLER2
XFILLER_78_1038 VDD VSS FILLER1
XFILLER_85_96 VDD VSS DECAPHV32
XTAP_TAPCELL_ROW_124_1509 VDD VSS WELLTAP
X_16613_ _16617_/A VDD VSS _16615_/C INVX1
X_13825_ _13870_/A _13860_/B VDD VSS _14461_/B XNOR2X1
XFILLER_44_850 VDD VSS FILLER4
XFILLER_63_669 VSS VDD FILLER2
XFILLER_91_978 VDD VSS FILLER1
X_17593_ _19052_/CK _17593_/D _17593_/Q VDD VSS DFFQX1
XFILLER_31_511 VDD VSS FILLER1
XFILLER_43_371 VDD VSS FILLER1
X_10968_ _11024_/A _11108_/B VDD VSS _17979_/D NOR2X1
X_16544_ _18798_/Q _18744_/Q VDD VSS _16546_/A XOR2X1
X_13756_ _18325_/Q _14280_/B VDD VSS _13762_/A NOR2X1
XFILLER_31_533 VDD VSS FILLER4
X_12707_ _12707_/A _12707_/B _14446_/B VDD VSS _12708_/B MIN3X1
X_16475_ _16731_/A _16475_/B _16514_/C VDD VSS _16480_/B NOR3X1
X_13687_ _18350_/Q VDD VSS _13696_/A INVX1
XFILLER_31_577 VSS VDD FILLER2
X_10899_ _10901_/C _10899_/B VDD VSS _11039_/B XNOR2X1
X_12638_ _18288_/Q VDD VSS _12740_/A INVX1
X_18214_ _18267_/CK _18214_/D _18214_/Q VDD VSS DFFQX1
X_15426_ _15737_/A _15455_/B _15426_/C _15426_/D VDD VSS _18866_/D OAI31X1
XFILLER_129_443 VDD VSS FILLER1
XTAP_TAPCELL_ROW_5_82 VDD VSS WELLTAP
XFILLER_117_627 VDD VSS FILLER1
X_12569_ _18183_/Q _12756_/B _12756_/C VDD VSS _12769_/B XNOR3X1
X_18145_ _18171_/CK _18145_/D _18145_/Q VDD VSS DFFQX1
X_15357_ _15785_/B VDD VSS _16161_/C BUFX3
XFILLER_102_1058 VDD VSS DECAPHV8
XFILLER_116_137 VSS VDD FILLER2
XTAP_TAPCELL_ROW_135_1638 VDD VSS WELLTAP
X_18076_ _18082_/CK _18076_/D output8/A VDD VSS DFFQX1
X_15288_ _17079_/A _16681_/A VDD VSS _18828_/D NOR2X1
X_14308_ _14372_/A _14308_/B VDD VSS _18349_/D AND2X1
XFILLER_132_619 VSS VDD FILLER2
X_17027_ _18001_/Q _17030_/B VDD VSS _17028_/B XNOR2X1
X_14239_ _14372_/A _14239_/B VDD VSS _18290_/D AND2X1
XFILLER_125_693 VDD VSS DECAPHV8
XFILLER_112_321 VDD VSS FILLER4
XFILLER_113_866 VDD VSS DECAPHV8
Xclkbuf_leaf_31__002_ clkload26/A VDD VSS _18461_/CK BUFX12
XFILLER_22_0 VDD VSS DECAPHV32
XFILLER_58_408 VDD VSS DECAPHV8
XFILLER_67_920 VSS VDD FILLER2
XFILLER_98_588 VDD VSS FILLER1
X_09780_ _09780_/A _09780_/B VDD VSS _17353_/B XNOR2X1
X_18978_ _18978_/CK _18978_/D _18978_/Q VDD VSS DFFQX1
XFILLER_112_398 VSS VDD FILLER2
XFILLER_39_633 VSS VDD FILLER2
XFILLER_61_1064 VDD VSS FILLER1
X_17929_ _17932_/CK _17929_/D _17929_/Q VDD VSS DFFQX1
XFILLER_54_603 VDD VSS FILLER1
XFILLER_61_1097 VDD VSS FILLER4
XFILLER_93_271 VDD VSS DECAPHV8
Xclkbuf_leaf_46__002_ clkload25/A VDD VSS _18514_/CK BUFX12
XFILLER_53_124 VDD VSS DECAPHV8
XFILLER_81_433 VDD VSS DECAPHV8
XFILLER_50_831 VDD VSS FILLER1
XFILLER_50_853 VDD VSS DECAPHV16
XFILLER_50_886 VDD VSS FILLER4
X_09214_ _17576_/Q _17365_/B VDD VSS _09221_/B XNOR2X1
XFILLER_136_903 VDD VSS DECAPHV32
X_09145_ _19028_/Q _17328_/B VDD VSS _09146_/C NOR2X1
X_09076_ _09076_/A _09076_/B VDD VSS _17325_/B XNOR2X1
XFILLER_123_619 VDD VSS FILLER1
XFILLER_135_468 VDD VSS FILLER4
XFILLER_30_69 VDD VSS FILLER4
XTAP_TAPCELL_ROW_1_29 VDD VSS WELLTAP
XFILLER_122_129 VDD VSS DECAPHV8
XFILLER_103_332 VDD VSS DECAPHV16
XFILLER_89_544 VDD VSS FILLER1
XFILLER_118_1076 VSS VDD FILLER2
XFILLER_76_205 VDD VSS FILLER1
XFILLER_89_588 VDD VSS FILLER4
X_09978_ _17798_/Q _09989_/B VDD VSS _09980_/A NOR2BX1
X_08929_ _09218_/A _08929_/B VDD VSS _17745_/D NOR2X1
XFILLER_40_1115 VDD VSS FILLER1
XFILLER_45_603 VDD VSS DECAPHV8
XFILLER_57_463 VSS VDD FILLER2
XTAP_TAPCELL_ROW_75_918 VDD VSS WELLTAP
X_11940_ _12034_/A _14197_/B VDD VSS _11976_/B NOR2X1
XFILLER_18_839 VDD VSS FILLER1
XFILLER_45_636 VDD VSS DECAPHV8
XFILLER_72_411 VSS VDD FILLER2
XFILLER_17_349 VDD VSS FILLER4
XFILLER_72_433 VSS VDD FILLER2
X_11871_ _18976_/Q _18097_/Q VDD VSS _12039_/A AND2X1
XFILLER_55_88 VDD VSS FILLER4
XTAP_TAPCELL_ROW_27_344 VDD VSS WELLTAP
XTAP_TAPCELL_ROW_55_675 VDD VSS WELLTAP
X_10822_ _17925_/Q _10822_/B _10822_/C VDD VSS _10824_/C XNOR3X1
X_14590_ _14591_/A _14591_/B _14591_/D _14591_/C VDD VSS _14593_/C AOI211X1
X_13610_ _18348_/Q _14307_/B VDD VSS _13613_/C _14307_/C NAND3X1
X_10753_ _10753_/A _10753_/B _10753_/C VDD VSS _10754_/B NOR3X1
X_13541_ _18347_/Q _14306_/B _14306_/C VDD VSS _13542_/D OR3BX1
XFILLER_38_1077 VDD VSS DECAPHV8
XFILLER_38_1099 VSS VDD FILLER2
XFILLER_71_32 VDD VSS DECAPHV32
X_16260_ _16537_/A _18763_/Q wire35/Y _16260_/D VDD VSS _16261_/C AOI22X1
XFILLER_125_1069 VDD VSS DECAPHV32
XFILLER_71_87 VDD VSS FILLER4
X_10684_ _10682_/Y _17043_/A _10821_/C VDD VSS _17924_/D AND3BX1
X_15211_ _15240_/A _18780_/Q VDD VSS _18753_/D AND2X1
X_13472_ _13473_/A _13473_/B _13473_/D _13473_/C VDD VSS _14306_/B OAOI211X1
X_12423_ _18232_/Q _14173_/B _14173_/C VDD VSS _12424_/D OR3BX1
X_16191_ _16193_/A _16193_/B _16191_/C _16191_/D VDD VSS _18903_/D AOAI211X1
X_12354_ _18982_/Q _18103_/Q VDD VSS _12453_/D XNOR2X1
X_15142_ _15281_/A _18712_/Q VDD VSS _18685_/D AND2X1
X_11305_ _11345_/A _11345_/B _11345_/C VDD VSS _11309_/B AOI21X1
X_15073_ _15078_/A _15078_/B _17318_/C VDD VSS _15074_/C OAI21X1
X_12285_ _18466_/Q _12285_/B _12285_/C VDD VSS _12485_/B MIN3X1
X_18901_ _18959_/CK _18901_/D _18901_/Q VDD VSS DFFQX1
X_14024_ _17154_/A _18972_/Q VDD VSS _18093_/D AND2X1
XFILLER_106_170 VDD VSS FILLER1
XFILLER_136_80 VDD VSS DECAPHV8
XFILLER_45_1026 VDD VSS DECAPHV8
XFILLER_84_1064 VDD VSS FILLER1
X_11236_ _18137_/Q _14069_/B VDD VSS _11350_/B NOR2X1
XFILLER_96_40 VDD VSS FILLER4
XTAP_TAPCELL_ROW_130_1579 VDD VSS WELLTAP
X_11167_ _11170_/A _11170_/B VDD VSS _17114_/B XNOR2X1
X_18832_ _18835_/CK _18832_/D _18832_/Q VDD VSS DFFQX1
XFILLER_121_184 VSS VDD FILLER2
X_10118_ _10296_/A _10296_/B _10296_/C _10297_/C VDD VSS _10317_/B AOAI211X1
X_18763_ _18844_/CK _18763_/D _18763_/Q VDD VSS DFFQX1
X_11098_ _17977_/Q VDD VSS _11099_/A INVX1
X_17714_ _17716_/CK _17714_/D _17714_/Q VDD VSS DFFQX1
X_15975_ _15975_/A _15975_/B _15975_/C _15975_/D VDD VSS _15997_/A OAOI211X1
X_10049_ _17807_/Q _10060_/B VDD VSS _10053_/B XOR2X1
X_18694_ _18856_/CK _18694_/D _18694_/Q VDD VSS DFFQX1
X_14926_ _14929_/A _14929_/B _14926_/C VDD VSS _18605_/D AOI21X1
XTAP_TAPCELL_ROW_85_1036 VDD VSS WELLTAP
X_17645_ _17710_/CK _17645_/D _17645_/Q VDD VSS DFFQX1
X_14857_ _14861_/A _14858_/B _17554_/C VDD VSS _14858_/C OAI21X1
XFILLER_23_308 VDD VSS DECAPHV8
XFILLER_35_157 VSS VDD FILLER2
XFILLER_91_1002 VSS VDD FILLER2
X_17576_ _19034_/CK _17576_/D _17576_/Q VDD VSS DFFQX1
X_14788_ _14789_/A _14790_/C _17318_/C VDD VSS _14789_/C OAI21X1
X_13808_ _14342_/A _14342_/B _18378_/Q VDD VSS _13809_/D OAI21X1
XFILLER_17_894 VDD VSS FILLER4
X_16527_ _18912_/Q _16527_/B VDD VSS _16528_/C NAND2X1
X_13739_ _13798_/A _13798_/B _13798_/C VDD VSS _14402_/B AOI21X1
XFILLER_31_330 VSS VDD FILLER2
XFILLER_32_886 VDD VSS DECAPHV8
XFILLER_52_1019 VDD VSS DECAPHV8
XFILLER_91_1046 VSS VDD FILLER2
X_16458_ _16567_/A _16531_/A VDD VSS _16487_/A NOR2X1
X_16389_ _18820_/Q _18712_/Q VDD VSS _16390_/D NAND2X1
X_15409_ _15480_/A _15466_/B _15409_/C VDD VSS _15420_/B NOR3X1
X_18128_ _18152_/CK _18128_/D _18128_/Q VDD VSS DFFQX1
XFILLER_117_468 VDD VSS FILLER4
XTAP_TAPCELL_ROW_96_1165 VDD VSS WELLTAP
XTAP_TAPCELL_ROW_96_1176 VDD VSS WELLTAP
X_09901_ _10099_/A _10099_/B _10099_/C _10100_/C VDD VSS _10109_/B AOAI211X1
X_18059_ _18858_/CK _18059_/D _18059_/Q VDD VSS DFFQX1
XFILLER_104_129 VDD VSS FILLER4
XFILLER_125_490 VDD VSS FILLER1
XFILLER_99_842 VDD VSS FILLER1
XFILLER_99_853 VDD VSS DECAPHV8
XFILLER_86_514 VSS VDD FILLER2
XFILLER_98_352 VDD VSS FILLER4
XFILLER_98_363 VDD VSS FILLER1
X_09832_ _17773_/Q _09832_/B VDD VSS _09838_/C NOR2BX1
XFILLER_101_836 VDD VSS FILLER1
XFILLER_86_547 VDD VSS FILLER1
XFILLER_98_385 VDD VSS FILLER1
X_09763_ _17596_/Q _09763_/B _17386_/B VDD VSS _09780_/A MIN3X1
XFILLER_86_569 VSS VDD FILLER2
XFILLER_132_49 VDD VSS DECAPHV32
XFILLER_39_463 VSS VDD FILLER2
XFILLER_73_219 VDD VSS FILLER1
X_09694_ _17721_/Q _17753_/Q _09694_/C VDD VSS _09695_/C AOI2B1X1
XFILLER_82_731 VDD VSS FILLER4
XFILLER_41_138 VDD VSS FILLER1
XTAP_TAPCELL_ROW_24_303 VDD VSS WELLTAP
XTAP_TAPCELL_ROW_105_1283 VDD VSS WELLTAP
XTAP_TAPCELL_ROW_52_645 VDD VSS WELLTAP
XTAP_TAPCELL_ROW_80_976 VDD VSS WELLTAP
XFILLER_109_958 VDD VSS FILLER4
X_09128_ _17700_/Q VDD VSS _09129_/B INVX1
XFILLER_135_221 VDD VSS DECAPHV32
XFILLER_136_755 VDD VSS DECAPHV8
X_09059_ _09059_/A VDD VSS _09060_/C INVX1
XFILLER_116_490 VSS VDD FILLER2
X_12070_ _18204_/Q _12234_/D _12070_/C VDD VSS _12224_/C XNOR3X1
XFILLER_103_140 VSS VDD FILLER2
XFILLER_104_663 VDD VSS FILLER1
X_11021_ _11021_/A VDD VSS _11022_/B INVX1
XFILLER_77_525 VSS VDD FILLER2
XFILLER_89_396 VSS VDD FILLER2
XFILLER_44_1081 VDD VSS DECAPHV16
XFILLER_58_761 VSS VDD FILLER2
XFILLER_66_32 VDD VSS DECAPHV8
XFILLER_100_891 VDD VSS DECAPHV8
XFILLER_17_102 VDD VSS DECAPHV8
XFILLER_46_923 VSS VDD FILLER2
XFILLER_64_219 VSS VDD FILLER2
X_12972_ _13074_/A _12979_/B _12979_/C VDD VSS _14208_/C OR3BX1
X_15760_ _15760_/A _15760_/B _18861_/Q _15801_/B VDD VSS _15761_/C AOAI211X1
XFILLER_18_658 VDD VSS FILLER4
XFILLER_57_293 VDD VSS FILLER1
XFILLER_73_731 VDD VSS FILLER1
X_11923_ _12173_/B _12016_/B _12016_/C VDD VSS _12010_/A AOI21X1
X_15691_ _18884_/Q _15736_/B VDD VSS _15692_/C NAND2X1
X_14711_ _14712_/C _17229_/A _14711_/C VDD VSS _18559_/D AND3BX1
X_11854_ _11953_/B _14139_/C _18201_/Q VDD VSS _11855_/D AND3BX1
X_17430_ _17445_/A _17430_/B VDD VSS _17637_/D NOR2X1
X_14642_ _14645_/C _14642_/B _14642_/C VDD VSS _18544_/D AOI21X1
XFILLER_45_499 VSS VDD FILLER2
X_10805_ _14310_/C _10938_/B VDD VSS _17947_/D AND2X1
XFILLER_32_149 VDD VSS DECAPHV16
XFILLER_9_301 VDD VSS DECAPHV32
X_11785_ _11870_/B _14081_/C _18148_/Q VDD VSS _11786_/D AND3BX1
X_17361_ _17378_/A _17361_/B VDD VSS _17572_/D NOR2X1
X_14573_ _14573_/A _14573_/B _14573_/C VDD VSS _14580_/C OA21X2
XFILLER_14_886 VDD VSS FILLER4
X_10736_ _10738_/C _10736_/B VDD VSS _10868_/B XNOR2X1
X_17292_ _19013_/Q _19014_/Q _17316_/B VDD VSS _17302_/D OAI21X1
X_16312_ _18047_/Q _18657_/Q VDD VSS _16313_/A XOR2X1
X_13524_ _18478_/Q _14456_/B VDD VSS _13525_/D _14456_/C NAND3X1
X_10667_ _10731_/A _10808_/B VDD VSS _17921_/D NOR2X1
X_19031_ _19033_/CK _19031_/D _19031_/Q VDD VSS DFFQX1
X_16243_ _18789_/Q _18735_/Q VDD VSS _16293_/A NOR2X1
X_13455_ _13455_/A _14366_/B _13455_/C _13455_/D VDD VSS _13639_/A AOAI211X1
X_12406_ _18363_/Q _12408_/B _12408_/C VDD VSS _14356_/B XNOR3X1
X_16174_ _18042_/Q _18652_/Q VDD VSS _16176_/C NAND2X1
XFILLER_12_1047 VDD VSS FILLER4
XTAP_TAPCELL_ROW_132_1608 VDD VSS WELLTAP
X_10598_ _17881_/Q _10601_/B VDD VSS _10602_/B XOR2X1
X_15125_ _17182_/D _18695_/Q VDD VSS _18668_/D AND2X1
X_13386_ _13386_/A _13386_/B _13386_/C _13386_/D VDD VSS _13493_/A AOAI211X1
XFILLER_114_405 VDD VSS FILLER4
XFILLER_31_90 VSS VDD FILLER2
X_12337_ _18179_/Q _14115_/B VDD VSS _12338_/D _14115_/C NAND3X1
X_12268_ _18258_/Q _12318_/B _12334_/C VDD VSS _12506_/B XNOR3X1
X_15056_ _15056_/A _15057_/C _15056_/C VDD VSS _18633_/D AOI21X1
XFILLER_96_812 VDD VSS DECAPHV16
X_11219_ _18030_/Q _11221_/C _11219_/C VDD VSS _18030_/D AOI21X1
X_14007_ _18957_/Q _14009_/B VDD VSS _14008_/B XNOR2X1
XFILLER_68_536 VDD VSS FILLER4
X_12199_ _12283_/A _12283_/B _14412_/B VDD VSS _12397_/B MIN3X1
X_18815_ _18815_/CK _18815_/D _18815_/Q VDD VSS DFFQX1
XFILLER_23_1132 VDD VSS FILLER4
XFILLER_49_761 VDD VSS FILLER1
XFILLER_95_366 VSS VDD FILLER2
XFILLER_95_377 VDD VSS FILLER1
X_18746_ _18801_/CK _18746_/D _18746_/Q VDD VSS DFFQX1
X_15958_ _18810_/Q _18702_/Q VDD VSS _15961_/D XNOR2X1
X_18677_ _18840_/CK _18677_/D _18677_/Q VDD VSS DFFQX1
X_14909_ _18601_/Q _18633_/Q _14909_/C VDD VSS _14917_/A MIN3X1
XFILLER_52_926 VDD VSS FILLER1
XFILLER_91_561 VDD VSS DECAPHV8
XFILLER_93_1119 VDD VSS DECAPHV8
X_17628_ _19052_/CK _17628_/D _17628_/Q VDD VSS DFFQX1
X_15889_ _15912_/A _15912_/B _15912_/C VDD VSS _15889_/Y AOI21X1
XFILLER_51_414 VDD VSS FILLER1
XFILLER_52_948 VDD VSS DECAPHV16
XFILLER_20_801 VDD VSS FILLER4
X_17559_ _17560_/A _17560_/B _17561_/C VDD VSS _17560_/C OAI21X1
XFILLER_32_672 VSS VDD FILLER2
XFILLER_20_845 VSS VDD FILLER2
XFILLER_132_235 VDD VSS DECAPHV32
XFILLER_114_972 VDD VSS FILLER4
XFILLER_59_503 VDD VSS FILLER1
XFILLER_67_1092 VDD VSS DECAPHV8
XFILLER_8_1104 VDD VSS DECAPHV8
XFILLER_113_493 VDD VSS FILLER1
XFILLER_86_300 VDD VSS FILLER4
X_09815_ _17768_/Q _09821_/C VDD VSS _09945_/A XNOR2X1
XFILLER_115_1068 VDD VSS DECAPHV8
XFILLER_86_366 VSS VDD FILLER2
XFILLER_101_688 VDD VSS FILLER1
XFILLER_28_934 VDD VSS DECAPHV8
XTAP_TAPCELL_ROW_57_704 VDD VSS WELLTAP
X_09746_ _09747_/A _09747_/B _09747_/C VDD VSS _09768_/C AO21X2
XFILLER_39_282 VDD VSS FILLER4
XFILLER_67_591 VDD VSS FILLER1
XTAP_TAPCELL_ROW_107_1301 VDD VSS WELLTAP
X_09677_ _09677_/A _09677_/B _09677_/C VDD VSS _09678_/B OR3X2
XFILLER_28_989 VDD VSS DECAPHV8
XFILLER_43_904 VDD VSS FILLER4
XFILLER_54_241 VDD VSS FILLER1
XTAP_TAPCELL_ROW_37_461 VDD VSS WELLTAP
XFILLER_42_469 VSS VDD FILLER2
XFILLER_11_812 VDD VSS FILLER4
X_11570_ _11630_/A _11686_/B _11686_/C VDD VSS _11766_/B XNOR3X1
XFILLER_10_344 VSS VDD FILLER2
XFILLER_11_856 VDD VSS DECAPHV8
XFILLER_35_1058 VDD VSS DECAPHV8
XFILLER_52_89 VDD VSS FILLER4
X_10521_ _10513_/B _10521_/B _17870_/Q VDD VSS _10522_/D AND3BX1
XFILLER_6_315 VDD VSS DECAPHV8
XFILLER_7_827 VDD VSS FILLER4
X_13240_ _18449_/Q _13354_/A _13444_/B VDD VSS _13343_/B XNOR3X1
XTAP_TAPCELL_ROW_118_1430 VDD VSS WELLTAP
X_10452_ _17861_/Q VDD VSS _10456_/A INVX1
XFILLER_109_777 VDD VSS FILLER4
XFILLER_136_574 VDD VSS DECAPHV8
X_10383_ _10388_/A _10388_/B VDD VSS _10571_/A NOR2X1
X_13171_ _18344_/Q _13171_/B _13171_/C VDD VSS _13267_/C XNOR3X1
XTAP_TAPCELL_ROW_9_131 VDD VSS WELLTAP
X_12122_ _12122_/A _12122_/B _12122_/C _12122_/D VDD VSS _12126_/B AOAI211X1
X_12053_ _12249_/A _12249_/B VDD VSS _12239_/B NAND2X1
X_16930_ _16930_/A _16930_/B VDD VSS _16932_/B AND2X1
XFILLER_77_64 VDD VSS DECAPHV16
XFILLER_89_160 VDD VSS FILLER1
X_11004_ _11005_/A _11005_/B _11005_/C VDD VSS _11015_/B OAI21X1
XFILLER_133_1135 VDD VSS FILLER1
XFILLER_93_804 VDD VSS FILLER1
X_16861_ _16865_/A _16865_/B VDD VSS _16863_/B XNOR2X1
XFILLER_120_997 VDD VSS FILLER1
XFILLER_37_219 VDD VSS FILLER1
X_18600_ clkload1/A _18600_/D _18600_/Q VDD VSS DFFQX1
X_16792_ _18920_/Q _16793_/B VDD VSS _16815_/A OR2X2
X_15812_ _15850_/A _15850_/B VDD VSS _15819_/B NAND2X1
XFILLER_133_92 VDD VSS FILLER1
XFILLER_19_967 VDD VSS FILLER1
XTAP_TAPCELL_ROW_129_1570 VDD VSS WELLTAP
X_12955_ _12955_/A _14300_/B _12955_/C VDD VSS _14301_/C OAI21X1
X_18531_ clkload4/A _18531_/D _18531_/Q VDD VSS DFFQX1
X_15743_ _18891_/Q _15746_/C VDD VSS _15744_/B XNOR2X1
XFILLER_19_989 VDD VSS FILLER4
XFILLER_46_764 VDD VSS FILLER4
XFILLER_46_786 VDD VSS FILLER4
XFILLER_73_550 VDD VSS FILLER1
X_11906_ _18357_/Q _11906_/B _11906_/C VDD VSS _14348_/B XNOR3X1
XFILLER_33_425 VDD VSS FILLER4
XFILLER_60_200 VDD VSS FILLER1
XFILLER_93_96 VDD VSS DECAPHV16
XTAP_TAPCELL_ROW_82_1006 VDD VSS WELLTAP
X_12886_ _12994_/A _12994_/B _12994_/C _12994_/D VDD VSS _13112_/A AOI31X1
X_18462_ _18493_/CK _18462_/D _18462_/Q VDD VSS DFFQX1
X_15674_ _15674_/A _15674_/B _15674_/C VDD VSS _15676_/B OAI21X1
XFILLER_60_244 VDD VSS FILLER1
X_11837_ _18305_/Q _11837_/B _11837_/C VDD VSS _12174_/B MIN3X1
X_18393_ _18470_/CK _18393_/D _18393_/Q VDD VSS DFFQX1
X_17413_ _17423_/A _17413_/B VDD VSS _17621_/D NOR2X1
X_14625_ _18541_/Q _18573_/Q VDD VSS _14630_/A XNOR2X1
XFILLER_60_288 VDD VSS DECAPHV16
X_11768_ _18173_/Q _14109_/B VDD VSS _11769_/D _14109_/C NAND3X1
X_17344_ _17446_/A _17344_/B VDD VSS _19043_/D AND2X1
X_14556_ _18526_/Q _18558_/Q VDD VSS _14562_/B NAND2X1
XFILLER_119_519 VDD VSS DECAPHV8
XFILLER_13_193 VDD VSS DECAPHV8
XFILLER_41_480 VDD VSS FILLER1
XTAP_TAPCELL_ROW_15_199 VDD VSS WELLTAP
X_10719_ _11148_/A _10851_/B VDD VSS _17930_/D AND2X1
X_13507_ _13583_/A _13583_/B _13583_/C VDD VSS _14491_/B OAI21X1
X_11699_ _11786_/A _11786_/B VDD VSS _11845_/B NOR2X1
X_19014_ _19019_/CK _19014_/D _19014_/Q VDD VSS DFFQX1
X_17275_ _19012_/Q _17315_/B VDD VSS _17278_/B XOR2X1
X_14487_ _14517_/A _14487_/B VDD VSS _18500_/D NOR2X1
XFILLER_127_541 VSS VDD FILLER2
X_16226_ _16226_/A _16234_/C VDD VSS _16227_/B XOR2X1
X_13438_ _13528_/A _13516_/B VDD VSS _14455_/B XNOR2X1
X_16157_ _18814_/Q _18706_/Q VDD VSS _16158_/D NAND2X1
X_13369_ _18345_/Q _14304_/B VDD VSS _13371_/C _14304_/C NAND3X1
XFILLER_115_747 VSS VDD FILLER2
XFILLER_115_758 VDD VSS FILLER1
XFILLER_5_370 VSS VDD FILLER2
XTAP_TAPCELL_ROW_93_1135 VDD VSS WELLTAP
X_16088_ _16089_/A _16089_/B _16089_/D _16089_/C VDD VSS _16165_/B AOAI211X1
X_15108_ _15274_/A _18679_/Q VDD VSS _18652_/D AND2X1
XFILLER_88_609 VDD VSS FILLER1
X_15039_ _18629_/Q _19007_/Q _15039_/C VDD VSS _15044_/C AO21X2
XFILLER_96_631 VDD VSS FILLER1
XFILLER_28_219 VDD VSS FILLER1
X_09600_ _17622_/Q _17414_/B _09600_/C VDD VSS _09631_/B AOI2B1X1
XFILLER_49_591 VDD VSS FILLER1
X_09531_ _09531_/A _09558_/C VDD VSS _17479_/B XNOR2X1
X_18729_ _18787_/CK _18729_/D _18729_/Q VDD VSS DFFQX1
XFILLER_58_1014 VSS VDD FILLER2
Xwire34 wire34/A VDD VSS wire34/Y BUFX6
XFILLER_24_425 VDD VSS DECAPHV8
X_09462_ _09462_/A _09470_/B VDD VSS _17341_/B XNOR2X1
XFILLER_40_918 VDD VSS FILLER1
XTAP_TAPCELL_ROW_34_431 VDD VSS WELLTAP
X_09393_ _17743_/Q _17711_/Q VDD VSS _09394_/B XNOR2X1
XFILLER_51_277 VSS VDD FILLER2
XTAP_TAPCELL_ROW_102_1242 VDD VSS WELLTAP
XTAP_TAPCELL_ROW_62_762 VDD VSS WELLTAP
XFILLER_106_747 VSS VDD FILLER2
XFILLER_118_596 VDD VSS FILLER1
XFILLER_117_1119 VDD VSS DECAPHV16
XFILLER_79_609 VDD VSS DECAPHV8
XFILLER_102_920 VSS VDD FILLER2
XTAP_TAPCELL_ROW_113_1371 VDD VSS WELLTAP
X_09729_ _17595_/Q _17385_/B VDD VSS _09737_/B XOR2X1
XFILLER_55_561 VDD VSS FILLER4
XFILLER_62_509 VSS VDD FILLER2
XFILLER_27_274 VDD VSS FILLER4
XFILLER_28_797 VSS VDD FILLER2
X_12740_ _12740_/A _14236_/B _14236_/C VDD VSS _12741_/D NOR3X1
XFILLER_70_564 VDD VSS FILLER1
XFILLER_82_391 VSS VDD FILLER2
X_12671_ _12783_/A _12783_/B _12783_/D VDD VSS _12891_/A OA21X2
XFILLER_30_428 VDD VSS FILLER1
XFILLER_63_88 VDD VSS FILLER4
XFILLER_70_586 VDD VSS FILLER1
X_11622_ _11693_/B _14136_/C _18198_/Q VDD VSS _11623_/D AND3BX1
X_15390_ _18912_/Q _18911_/Q VDD VSS _15393_/B _15390_/C NAND3X1
X_14410_ _14414_/A _14410_/B VDD VSS _18437_/D NOR2X1
XFILLER_129_806 VDD VSS FILLER4
X_14341_ _14346_/A _14341_/B VDD VSS _18377_/D NOR2X1
XTAP_TAPCELL_ROW_12_158 VDD VSS WELLTAP
X_11553_ _18972_/Q _18093_/Q VDD VSS _11637_/A XNOR2X1
XFILLER_11_686 VDD VSS DECAPHV32
X_10504_ _17870_/Q _10504_/B _10504_/C VDD VSS _10670_/C XNOR3X1
X_11484_ _11558_/B _14105_/C _18170_/Q VDD VSS _11485_/D AND3BX1
X_17060_ _18007_/Q _17060_/B VDD VSS _17063_/A NAND2X1
X_14272_ _14272_/A _14272_/B VDD VSS _14273_/C NOR2X1
XFILLER_109_552 VDD VSS FILLER1
XFILLER_109_585 VDD VSS FILLER1
X_10435_ _17858_/Q _10438_/B VDD VSS _10439_/B XOR2X1
X_13223_ _13223_/A _13223_/B VDD VSS _14097_/B XOR2X1
X_16011_ _16038_/A _16038_/B _16038_/C VDD VSS _16011_/Y AOI21X1
XFILLER_128_81 VDD VSS DECAPHV32
X_13154_ _13330_/A _13330_/B _13330_/C VDD VSS _13343_/A AOI21X1
XFILLER_124_555 VDD VSS FILLER1
XFILLER_97_417 VDD VSS FILLER1
X_10366_ _10561_/A _10555_/C VDD VSS _10564_/B XNOR2X1
X_12105_ _12105_/A _14382_/B _12105_/C VDD VSS _12106_/B MIN3X1
X_10297_ _17842_/Q _10297_/B _10297_/C VDD VSS _10489_/C XNOR3X1
X_13085_ _13085_/A _13085_/B _13085_/C VDD VSS _13097_/A XNOR3X1
X_17962_ _18011_/CK _17962_/D _17962_/Q VDD VSS DFFQX1
X_12036_ _18203_/Q _14141_/B VDD VSS _12146_/A NOR2BX1
X_17893_ _17972_/CK _17893_/D _17893_/Q VDD VSS DFFQX1
X_16913_ _16914_/B _16913_/B VDD VSS _16914_/D NAND2X1
XFILLER_120_761 VDD VSS FILLER1
XFILLER_38_506 VDD VSS FILLER4
XFILLER_66_837 VDD VSS FILLER4
XFILLER_77_152 VSS VDD FILLER2
X_16844_ _16857_/A _16844_/B VDD VSS _16845_/B NAND2X1
XFILLER_19_742 VSS VDD FILLER2
XFILLER_20_1135 VDD VSS FILLER1
XFILLER_46_561 VDD VSS FILLER4
XFILLER_81_829 VDD VSS DECAPHV8
X_16775_ _16746_/Y _16775_/B _16775_/C VDD VSS _16798_/A NAND3BX1
X_13987_ _13999_/A _13987_/B _14008_/C _14013_/D VDD VSS _18071_/D OAOI211X1
XFILLER_74_881 VSS VDD FILLER2
XTAP_TAPCELL_ROW_48_589 VDD VSS WELLTAP
X_12938_ _14392_/B _14392_/C _12939_/A VDD VSS _13020_/B OAI21X1
X_18514_ _18514_/CK _18514_/D _18514_/Q VDD VSS DFFQX1
X_15726_ _15734_/A _15726_/B VDD VSS _17015_/A XOR2X1
XFILLER_33_233 VSS VDD FILLER2
X_18445_ _18470_/CK _18445_/D _18445_/Q VDD VSS DFFQX1
X_15657_ _18932_/Q VDD VSS _16934_/D INVX1
X_12869_ _12977_/A _13071_/B VDD VSS _14179_/B XNOR2X1
X_14608_ _14611_/A _14611_/B _17266_/C VDD VSS _14609_/C OAI21X1
X_18376_ _18376_/CK _18376_/D _18376_/Q VDD VSS DFFQX1
X_15588_ _15591_/A _15591_/B VDD VSS _16993_/A XNOR2X1
X_17327_ _17338_/A _17327_/B VDD VSS _19027_/D NOR2X1
X_14539_ _18522_/Q _18554_/Q _14539_/C VDD VSS _14544_/B MIN3X1
X_17258_ _19007_/Q _19008_/Q _17316_/B VDD VSS _17259_/C OA21X2
X_16209_ _18789_/Q _18735_/Q VDD VSS _16210_/B XOR2X1
XFILLER_127_382 VDD VSS FILLER4
XFILLER_52_0 VDD VSS DECAPHV32
X_17189_ _18996_/Q _17260_/B VDD VSS _17193_/D XOR2X1
XFILLER_103_706 VSS VDD FILLER2
XFILLER_89_929 VDD VSS FILLER1
XFILLER_130_514 VDD VSS FILLER1
XFILLER_64_1040 VDD VSS FILLER1
X_08962_ _17752_/Q _18541_/Q VDD VSS _08963_/C NAND2X1
XFILLER_102_238 VDD VSS DECAPHV8
X_08893_ _17728_/Q _18517_/Q _08893_/C VDD VSS _17530_/A AOI21X1
XFILLER_111_783 VSS VDD FILLER2
XFILLER_25_1046 VDD VSS FILLER1
XFILLER_29_517 VDD VSS DECAPHV8
XFILLER_56_314 VSS VDD FILLER2
XFILLER_69_686 VDD VSS FILLER4
XFILLER_97_984 VDD VSS FILLER1
XFILLER_99_1114 VSS VDD FILLER2
XFILLER_110_271 VDD VSS DECAPHV8
XFILLER_57_848 VDD VSS FILLER1
XTAP_TAPCELL_ROW_67_821 VDD VSS WELLTAP
XFILLER_56_369 VDD VSS DECAPHV8
XFILLER_17_48 VDD VSS FILLER4
XFILLER_37_572 VDD VSS FILLER1
X_09514_ _09514_/A _09514_/B _09514_/C VDD VSS _09515_/B NOR3X1
X_09445_ _09474_/A _09474_/B VDD VSS _09456_/A NAND2X1
XFILLER_123_1101 VDD VSS DECAPHV8
X_09376_ _09376_/A _09386_/B VDD VSS _17337_/B XNOR2X1
XFILLER_21_962 VDD VSS DECAPHV8
XFILLER_71_1088 VDD VSS DECAPHV8
XTAP_TAPCELL_ROW_115_1400 VDD VSS WELLTAP
XFILLER_118_382 VSS VDD FILLER2
X_10220_ _17827_/Q _10222_/B VDD VSS _10221_/D _10220_/C NAND3X1
XFILLER_106_566 VDD VSS FILLER1
XFILLER_0_800 VDD VSS DECAPHV8
XFILLER_121_514 VDD VSS FILLER4
X_10151_ _17819_/Q _10151_/B VDD VSS _10156_/C _10151_/C NAND3X1
XFILLER_58_44 VSS VDD FILLER2
X_10082_ _17812_/Q VDD VSS _10083_/A INVX1
XFILLER_43_1135 VDD VSS FILLER1
X_13910_ _18512_/Q VDD VSS _13912_/A INVX1
XFILLER_101_282 VDD VSS DECAPHV8
XFILLER_48_848 VDD VSS FILLER1
X_14890_ _14891_/C _17255_/D _14890_/C VDD VSS _18597_/D AND3BX1
XFILLER_74_32 VDD VSS DECAPHV8
X_13841_ _18379_/Q _14343_/B VDD VSS _13843_/A NOR2X1
XFILLER_56_892 VDD VSS FILLER4
XFILLER_62_328 VDD VSS FILLER4
XTAP_TAPCELL_ROW_17_217 VDD VSS WELLTAP
X_10984_ _11024_/A _11121_/B VDD VSS _17982_/D NOR2X1
X_16560_ _18913_/Q _16565_/B VDD VSS _16566_/B XOR2X1
X_13772_ _18508_/Q _13827_/A _13827_/B VDD VSS _13774_/D XNOR3X1
XFILLER_71_840 VDD VSS FILLER1
XTAP_TAPCELL_ROW_17_228 VDD VSS WELLTAP
XTAP_TAPCELL_ROW_45_559 VDD VSS WELLTAP
X_12723_ _12723_/A _12723_/B _12723_/C VDD VSS _12796_/B XNOR3X1
X_15511_ _15511_/A _15511_/B _15511_/C VDD VSS _15523_/B OAI21X1
XFILLER_16_789 VDD VSS FILLER1
XFILLER_43_564 VDD VSS FILLER4
X_18230_ _18253_/CK _18230_/D _18230_/Q VDD VSS DFFQX1
X_16491_ _16926_/A _16491_/B VDD VSS _16492_/D NOR2X1
XFILLER_128_1067 VSS VDD FILLER2
X_12654_ _14118_/B _14118_/C _18182_/Q VDD VSS _12656_/C AOI21X1
X_15442_ _15385_/B _15410_/Y _16783_/A VDD VSS _15517_/B MUXI2X1
XFILLER_12_951 VDD VSS FILLER1
X_11605_ _14134_/B _14134_/C _11606_/A VDD VSS _11607_/B OAI21X1
X_12585_ _18495_/Q _14479_/B VDD VSS _12700_/A AND2X1
X_18161_ _18249_/CK _18161_/D _18161_/Q VDD VSS DFFQX1
X_15373_ _16657_/D _15373_/B VDD VSS _15374_/C NAND2X1
XFILLER_128_113 VDD VSS DECAPHV16
XFILLER_8_955 VDD VSS FILLER1
X_11536_ _18197_/Q VDD VSS _11574_/A INVX1
X_18092_ _18988_/CK _18092_/D _18092_/Q VDD VSS DFFQX1
X_17112_ _17112_/A _17112_/B _17112_/C VDD VSS _17117_/B OA21X2
X_14324_ _14346_/A _14324_/B VDD VSS _18362_/D NOR2X1
X_17043_ _17043_/A _17050_/B VDD VSS _17044_/D NAND2X1
X_14255_ _14269_/A _14255_/B VDD VSS _18304_/D NOR2X1
X_11467_ _18300_/Q _11467_/B _11467_/C VDD VSS _11595_/B MIN3X1
X_13206_ _13206_/A _13206_/B _13206_/C VDD VSS _14154_/B OAI21X1
XFILLER_125_875 VDD VSS FILLER1
XFILLER_98_704 VSS VDD FILLER2
X_10418_ _17855_/Q VDD VSS _10423_/A INVX1
X_11398_ _11440_/A _14047_/B VDD VSS _11448_/A NOR2X1
X_14186_ _14191_/A _14186_/B VDD VSS _18244_/D NOR2X1
XFILLER_112_514 VDD VSS FILLER4
XFILLER_48_1079 VSS VDD FILLER2
X_10349_ _17845_/Q _10349_/B VDD VSS _10350_/D _10349_/C NAND3X1
X_13137_ _13137_/A _13137_/B _13137_/C _13137_/D VDD VSS _13257_/B OAOI211X1
X_18994_ _18994_/CK _18994_/D _18994_/Q VDD VSS DFFQX1
XFILLER_98_759 VDD VSS FILLER4
X_13068_ _13234_/A _13234_/B _13234_/E VDD VSS _13171_/B OAI21X1
X_17945_ _17972_/CK _17945_/D _17945_/Q VDD VSS DFFQX1
XFILLER_78_450 VDD VSS FILLER1
X_12019_ _18228_/Q _14169_/B VDD VSS _12126_/A NAND2X1
XFILLER_66_634 VSS VDD FILLER2
XFILLER_94_943 VDD VSS DECAPHV16
X_17876_ _17932_/CK _17876_/D _17876_/Q VDD VSS DFFQX1
XFILLER_54_818 VDD VSS FILLER4
XFILLER_65_144 VDD VSS FILLER4
XFILLER_65_155 VSS VDD FILLER2
X_16827_ _16875_/A _16827_/B _16827_/C VDD VSS _18922_/D OAI21X1
XFILLER_0_40 VDD VSS FILLER4
XFILLER_111_1071 VDD VSS FILLER1
XFILLER_19_561 VDD VSS FILLER4
XTAP_TAPCELL_ROW_88_1078 VDD VSS WELLTAP
X_16758_ _18058_/Q _18668_/Q _16758_/C VDD VSS _16782_/A MIN3X1
XFILLER_46_391 VSS VDD FILLER2
Xdelaybuf_1_clk_fs delaybuf_1_clk_fs/A VDD VSS delaybuf_2_clk_fs/A BUFX12
X_15709_ _18887_/Q _15715_/C VDD VSS _15710_/B XOR2X1
XFILLER_94_1066 VSS VDD FILLER2
X_09230_ _09256_/C _09230_/B VDD VSS _17468_/B XNOR2X1
X_16689_ _16723_/A _16723_/B _16783_/D VDD VSS _16690_/C AOI21X1
X_18428_ _18480_/CK _18428_/D _18428_/Q VDD VSS DFFQX1
XFILLER_21_269 VSS VDD FILLER2
X_09161_ _17638_/Q _17431_/B VDD VSS _09162_/B XNOR2X1
X_18359_ _18408_/CK _18359_/D _18359_/Q VDD VSS DFFQX1
XFILLER_30_770 VSS VDD FILLER2
X_09092_ _17392_/A _09092_/B VDD VSS _17758_/D AND2X1
XFILLER_116_842 VSS VDD FILLER2
XFILLER_131_823 VDD VSS DECAPHV8
XFILLER_27_1108 VDD VSS DECAPHV8
X_09994_ _10194_/A _10194_/B VDD VSS _10208_/C _10195_/A NAND3X1
XFILLER_57_601 VSS VDD FILLER2
XFILLER_69_450 VSS VDD FILLER2
XTAP_TAPCELL_ROW_110_1341 VDD VSS WELLTAP
X_08945_ _17749_/Q _18538_/Q VDD VSS _08952_/C NOR2X1
XFILLER_111_591 VDD VSS FILLER4
X_08876_ _18031_/Q _08876_/B _17533_/A VDD VSS _174_/E AO21X2
XFILLER_38_881 VSS VDD FILLER2
XFILLER_44_328 VDD VSS DECAPHV8
XFILLER_53_840 VDD VSS DECAPHV8
XFILLER_71_158 VSS VDD FILLER2
XFILLER_53_884 VDD VSS DECAPHV16
XTAP_TAPCELL_ROW_42_518 VDD VSS WELLTAP
XTAP_TAPCELL_ROW_121_1470 VDD VSS WELLTAP
X_09428_ _09428_/A _09444_/B VDD VSS _17407_/B XNOR2X1
X_09359_ _17677_/Q _17472_/B VDD VSS _09360_/C NOR2X1
X_12370_ _12514_/A _12528_/A _12626_/B VDD VSS _12419_/C XNOR3X1
XTAP_TAPCELL_ROW_22_286 VDD VSS WELLTAP
X_11321_ _18968_/Q _18089_/Q VDD VSS _11389_/C XOR2X1
XFILLER_126_639 VDD VSS FILLER1
XFILLER_118_190 VDD VSS FILLER1
XFILLER_122_801 VDD VSS FILLER1
XFILLER_69_32 VDD VSS DECAPHV32
X_11252_ _18138_/Q _11350_/B _11255_/C VDD VSS _14099_/B XNOR3X1
X_14040_ _14107_/A _18988_/Q VDD VSS _18109_/D AND2X1
XFILLER_106_374 VDD VSS FILLER4
XFILLER_133_160 VDD VSS DECAPHV16
XFILLER_79_203 VSS VDD FILLER2
X_10203_ _10203_/A _10203_/B _10203_/C _10203_/D VDD VSS _10203_/Y OAOI211X1
X_11183_ _11205_/A _17129_/B VDD VSS _18020_/D NOR2X1
XFILLER_79_225 VDD VSS DECAPHV8
X_10134_ _10922_/A VDD VSS _10268_/A BUFX3
XFILLER_121_366 VDD VSS FILLER1
XFILLER_67_409 VDD VSS FILLER1
X_15991_ _16030_/D _16030_/B VDD VSS _15992_/B NOR2BX1
XFILLER_121_388 VDD VSS FILLER1
XFILLER_121_399 VDD VSS FILLER1
XFILLER_47_111 VSS VDD FILLER2
XTAP_TAPCELL_ROW_78_949 VDD VSS WELLTAP
X_10065_ _10068_/A _10068_/B VDD VSS _10256_/B XNOR2X1
X_17730_ _18990_/CK _17730_/D _17730_/Q VDD VSS DFFQX1
X_14942_ _18609_/Q _18641_/Q VDD VSS _14945_/A XOR2X1
XFILLER_75_464 VDD VSS FILLER1
XFILLER_85_64 VDD VSS DECAPHV16
X_17661_ _17725_/CK _17661_/D _17661_/Q VDD VSS DFFQX1
X_14873_ _18594_/Q _18626_/Q VDD VSS _14874_/B XNOR2X1
X_16612_ _18827_/Q _18719_/Q VDD VSS _16617_/A XOR2X1
X_13824_ _15310_/A _13824_/B VDD VSS _18053_/D AND2X1
XFILLER_16_542 VDD VSS FILLER1
X_17592_ _19052_/CK _17592_/D _17592_/Q VDD VSS DFFQX1
X_10967_ _10970_/C _10967_/B VDD VSS _11108_/B XNOR2X1
X_16543_ _16587_/A _16587_/B _16588_/A VDD VSS _16547_/B AOI21X1
X_13755_ _13809_/A _13809_/B VDD VSS _13767_/B NAND2X1
XFILLER_16_597 VDD VSS FILLER1
X_10898_ _17939_/Q _10901_/B VDD VSS _10899_/B XOR2X1
X_12706_ _12706_/A _12706_/B _12706_/C VDD VSS _14446_/B XNOR3X1
X_16474_ _16474_/A _16474_/B _16474_/C VDD VSS _16514_/C OA21X2
X_13686_ _13686_/A _13686_/B _13686_/C _13686_/D VDD VSS _13690_/B AOAI211X1
X_12637_ _12741_/A _14264_/B VDD VSS _12688_/B NOR2X1
X_18213_ _18267_/CK _18213_/D _18213_/Q VDD VSS DFFQX1
X_15425_ _18866_/Q _15736_/B VDD VSS _15426_/D NAND2X1
XFILLER_54_1072 VSS VDD FILLER2
XTAP_TAPCELL_ROW_5_83 VDD VSS WELLTAP
X_18144_ _18171_/CK _18144_/D _18144_/Q VDD VSS DFFQX1
XFILLER_129_477 VDD VSS FILLER1
XFILLER_89_1135 VDD VSS FILLER1
X_12568_ _18157_/Q _12568_/B _12667_/D VDD VSS _12756_/C XNOR3X1
X_15356_ _18864_/Q _18863_/Q _16784_/A VDD VSS _15785_/B NOR3BX1
XTAP_TAPCELL_ROW_135_1639 VDD VSS WELLTAP
X_11519_ _18327_/Q _11519_/B _11519_/C VDD VSS _11661_/B MIN3X1
X_12499_ _12499_/A _12499_/B _12499_/C _12499_/D VDD VSS _14296_/B OAOI211X1
X_18075_ _18082_/CK _18075_/D output7/A VDD VSS DFFQX1
X_15287_ _18855_/Q VDD VSS _16681_/A INVX1
X_14307_ _14243_/Y _14307_/B _14307_/C VDD VSS _18348_/D AND3BX1
XFILLER_125_650 VDD VSS FILLER1
X_17026_ _17026_/A _17026_/B _17026_/C VDD VSS _17030_/C OAI21X1
X_14238_ _14296_/A _14238_/B _14238_/C VDD VSS _18289_/D NOR3X1
X_14169_ _14396_/A _14169_/B VDD VSS _18228_/D AND2X1
XFILLER_98_545 VDD VSS FILLER1
Xclkbuf_leaf_31__001_ clkbuf_2_1__f__001_/Y VDD VSS _19034_/CK BUFX12
XFILLER_113_878 VDD VSS FILLER1
X_18977_ _18978_/CK _18977_/D _18977_/Q VDD VSS DFFQX1
XFILLER_22_1005 VDD VSS FILLER4
XFILLER_79_781 VDD VSS FILLER4
XFILLER_85_239 VDD VSS DECAPHV8
X_17928_ _17982_/CK _17928_/D _17928_/Q VDD VSS DFFQX1
XFILLER_15_0 VDD VSS DECAPHV32
X_17859_ _17861_/CK _17859_/D _17859_/Q VDD VSS DFFQX1
XFILLER_38_177 VDD VSS FILLER1
XFILLER_54_615 VDD VSS FILLER1
XFILLER_66_475 VSS VDD FILLER2
XFILLER_35_840 VSS VDD FILLER2
XFILLER_81_445 VDD VSS FILLER1
XFILLER_82_957 VDD VSS FILLER1
XFILLER_82_979 VDD VSS FILLER1
XFILLER_34_350 VDD VSS FILLER1
XFILLER_53_169 VDD VSS FILLER1
XFILLER_34_394 VSS VDD FILLER2
XFILLER_35_895 VSS VDD FILLER2
X_09213_ _09222_/B _09213_/B VDD VSS _17365_/B XNOR2X1
XFILLER_33_1134 VSS VDD FILLER2
X_09144_ _09218_/A _09144_/B VDD VSS _17760_/D NOR2X1
XFILLER_120_1104 VDD VSS DECAPHV32
XFILLER_136_948 VDD VSS DECAPHV32
X_09075_ _19026_/Q _17326_/B VDD VSS _09091_/A XNOR2X1
XFILLER_104_801 VSS VDD FILLER2
XFILLER_115_160 VDD VSS DECAPHV16
XFILLER_118_1011 VDD VSS FILLER4
XFILLER_104_867 VDD VSS DECAPHV16
XFILLER_89_556 VSS VDD FILLER2
XFILLER_103_366 VDD VSS FILLER1
XFILLER_49_409 VDD VSS FILLER1
X_09977_ _09986_/A _09986_/B VDD VSS _10184_/C NOR2X1
Xclkbuf_1_1__f__000_ clkbuf_0__000_/Y VDD VSS clkbuf_leaf_9__000_/A BUFX12
XFILLER_130_174 VDD VSS DECAPHV32
XFILLER_76_228 VDD VSS FILLER4
X_08928_ _08931_/C _08928_/B VDD VSS _08929_/B XNOR2X1
XFILLER_58_987 VSS VDD FILLER2
XTAP_TAPCELL_ROW_75_919 VDD VSS WELLTAP
XFILLER_44_136 VSS VDD FILLER2
XFILLER_45_648 VSS VDD FILLER2
X_11870_ _11870_/A _11870_/B _11870_/C _11870_/D VDD VSS _12045_/A OAOI211X1
XFILLER_72_467 VDD VSS FILLER4
XTAP_TAPCELL_ROW_27_345 VDD VSS WELLTAP
XTAP_TAPCELL_ROW_55_676 VDD VSS WELLTAP
X_10821_ _10682_/Y _17924_/Q _10821_/C VDD VSS _10824_/D AND3BX1
XFILLER_77_1083 VDD VSS FILLER1
X_10752_ _10753_/A _10753_/B _10753_/C VDD VSS _10756_/C OA21X2
X_13540_ _18373_/Q _14336_/B VDD VSS _13544_/C _14336_/C NAND3X1
XFILLER_40_353 VSS VDD FILLER2
X_13471_ _18321_/Q _13556_/A _13556_/B VDD VSS _13473_/C XNOR3X1
XFILLER_13_578 VSS VDD FILLER2
XFILLER_40_364 VDD VSS FILLER1
X_10683_ _10817_/A _10817_/B _10818_/C VDD VSS _10821_/C OAI21X1
X_12422_ _14173_/B _14173_/C _12422_/C VDD VSS _12424_/C OA21X2
X_15210_ _15240_/A _18779_/Q VDD VSS _18752_/D AND2X1
XFILLER_127_904 VSS VDD FILLER2
X_16190_ _18903_/Q _16905_/B VDD VSS _16191_/D NAND2X1
X_12353_ _12554_/A _14089_/B VDD VSS _12542_/B NAND2X1
X_15141_ _15309_/A _18711_/Q VDD VSS _18684_/D AND2X1
XFILLER_107_650 VDD VSS FILLER1
X_11304_ _18192_/Q _11304_/B _11304_/C VDD VSS _11420_/B MIN3X1
X_12284_ _14471_/A _12284_/B _14442_/B VDD VSS _12285_/B MIN3X1
X_15072_ _18636_/Q _19014_/Q _15072_/C VDD VSS _15078_/B MIN3X1
X_11235_ _18111_/Q _11290_/B _11238_/C VDD VSS _14069_/B XNOR3X1
X_18900_ _18959_/CK _18900_/D _18900_/Q VDD VSS DFFQX1
X_14023_ _17154_/A _18971_/Q VDD VSS _18092_/D AND2X1
XFILLER_122_653 VSS VDD FILLER2
XFILLER_84_1076 VDD VSS FILLER1
X_11166_ _17991_/Q _11169_/B VDD VSS _11170_/B XNOR2X1
X_18831_ _18857_/CK _18831_/D _18831_/Q VDD VSS DFFQX1
XFILLER_67_239 VSS VDD FILLER2
X_10117_ _17817_/Q _10117_/B _10128_/B VDD VSS _10297_/C XNOR3X1
X_11097_ _17059_/C _17040_/B VDD VSS _18003_/D AND2X1
X_18762_ _18818_/CK _18762_/D _18762_/Q VDD VSS DFFQX1
X_15974_ _18036_/Q _18646_/Q VDD VSS _15975_/D AND2X1
XFILLER_0_493 VSS VDD FILLER2
XFILLER_49_965 VDD VSS FILLER1
XFILLER_49_976 VSS VDD FILLER2
XFILLER_76_762 VDD VSS DECAPHV8
X_10048_ _17806_/Q _10048_/B VDD VSS _10053_/A NAND2X1
X_17713_ _17716_/CK _17713_/D _17713_/Q VDD VSS DFFQX1
X_14925_ _14929_/A _14929_/B _17455_/A VDD VSS _14926_/C OAI21X1
XFILLER_63_412 VDD VSS DECAPHV8
XFILLER_75_272 VDD VSS FILLER4
X_18693_ _18856_/CK _18693_/D _18693_/Q VDD VSS DFFQX1
XFILLER_17_840 VSS VDD FILLER2
XFILLER_63_456 VDD VSS DECAPHV8
XFILLER_90_220 VSS VDD FILLER2
XFILLER_90_231 VDD VSS FILLER1
XFILLER_91_732 VDD VSS FILLER4
XTAP_TAPCELL_ROW_85_1037 VDD VSS WELLTAP
X_17644_ _17710_/CK _17644_/D _17644_/Q VDD VSS DFFQX1
X_14856_ _14861_/C _14861_/B VDD VSS _14858_/B NAND2BX1
XFILLER_17_884 VDD VSS FILLER1
XFILLER_90_264 VDD VSS FILLER1
XFILLER_91_787 VDD VSS FILLER4
X_17575_ _17669_/CK _17575_/D _17575_/Q VDD VSS DFFQX1
X_14787_ _14787_/A _14935_/A _14787_/C VDD VSS _14790_/C MIN3X1
X_13807_ _18378_/Q _14342_/A _14342_/B VDD VSS _13809_/C NOR3X1
XFILLER_90_297 VDD VSS DECAPHV8
X_11999_ _18463_/Q _14468_/A _11999_/C VDD VSS _12194_/B MIN3X1
X_16526_ _16526_/A _16530_/C VDD VSS _16528_/B XOR2X1
X_13738_ _13738_/A _13738_/B _13738_/C _13738_/D VDD VSS _13798_/B AOAI211X1
XFILLER_32_876 VSS VDD FILLER2
XFILLER_31_375 VSS VDD FILLER2
X_16457_ _16386_/B _16457_/B _16457_/C VDD VSS _16531_/A AND3BX1
X_13669_ _13784_/A _13784_/B _13784_/C VDD VSS _13718_/B AOI21X1
XFILLER_118_904 VDD VSS FILLER4
X_16388_ _18820_/Q _18712_/Q VDD VSS _16390_/C NOR2X1
X_15408_ _18900_/Q _15769_/B _18901_/Q VDD VSS _15409_/C AOI21X1
X_18127_ _18152_/CK _18127_/D _18127_/Q VDD VSS DFFQX1
X_15339_ _18863_/Q _15340_/B VDD VSS _15344_/B NAND2X1
XTAP_TAPCELL_ROW_96_1166 VDD VSS WELLTAP
X_18058_ _18856_/CK _18058_/D _18058_/Q VDD VSS DFFQX1
XFILLER_132_406 VDD VSS DECAPHV8
X_09900_ _17790_/Q _09926_/B _09914_/A VDD VSS _10100_/C XOR3X1
X_17009_ _18955_/Q _17016_/B VDD VSS _17010_/C NAND2X1
XFILLER_99_832 VDD VSS FILLER4
XFILLER_99_887 VDD VSS DECAPHV8
X_09831_ _09843_/A _09997_/B VDD VSS _17799_/D NOR2X1
XFILLER_58_239 VDD VSS FILLER1
X_09762_ _09762_/A VDD VSS _17386_/B INVX1
XFILLER_67_762 VDD VSS DECAPHV16
XFILLER_6_1043 VDD VSS DECAPHV16
X_09693_ _17754_/Q _17722_/Q VDD VSS _09696_/A XNOR2X1
XFILLER_27_637 VDD VSS DECAPHV8
XFILLER_54_445 VDD VSS FILLER1
XFILLER_81_231 VDD VSS DECAPHV8
XFILLER_42_607 VDD VSS DECAPHV8
XFILLER_70_927 VDD VSS FILLER1
XFILLER_70_938 VDD VSS FILLER4
XFILLER_35_681 VDD VSS FILLER4
XTAP_TAPCELL_ROW_105_1273 VDD VSS WELLTAP
XTAP_TAPCELL_ROW_24_304 VDD VSS WELLTAP
XTAP_TAPCELL_ROW_105_1284 VDD VSS WELLTAP
XTAP_TAPCELL_ROW_52_646 VDD VSS WELLTAP
XTAP_TAPCELL_ROW_80_977 VDD VSS WELLTAP
XFILLER_50_662 VSS VDD FILLER2
XFILLER_108_403 VDD VSS FILLER4
XFILLER_108_414 VDD VSS FILLER4
XFILLER_136_723 VDD VSS DECAPHV32
X_09127_ _09107_/A _09127_/B VDD VSS _09134_/B NOR2BX1
X_09058_ _09058_/A _09058_/B _17392_/B VDD VSS _09097_/B MIN3X1
XFILLER_135_277 VSS VDD FILLER2
XFILLER_104_631 VDD VSS DECAPHV8
XFILLER_132_940 VDD VSS FILLER1
XFILLER_89_353 VSS VDD FILLER2
X_11020_ _11025_/A _11020_/B VDD VSS _11023_/A XNOR2X1
XFILLER_103_163 VDD VSS FILLER4
XFILLER_106_40 VDD VSS FILLER4
XFILLER_44_1060 VDD VSS DECAPHV8
XFILLER_66_44 VSS VDD FILLER2
XFILLER_100_881 VSS VDD FILLER2
XFILLER_57_250 VSS VDD FILLER2
XFILLER_58_773 VDD VSS FILLER1
XFILLER_85_581 VDD VSS FILLER1
XFILLER_92_518 VDD VSS FILLER1
XFILLER_92_529 VDD VSS DECAPHV16
X_12971_ _18237_/Q _14179_/B VDD VSS _13074_/A NAND2X1
XFILLER_17_114 VSS VDD FILLER2
XFILLER_72_231 VDD VSS FILLER1
XFILLER_73_754 VDD VSS FILLER4
X_11922_ _12173_/A _11922_/B _11922_/C VDD VSS _12016_/C NOR3X1
X_15690_ _15690_/A _15693_/C VDD VSS _17006_/A XNOR2X1
X_14710_ _14710_/A _14710_/B _14710_/C _14710_/D VDD VSS _14711_/C AOAI211X1
XFILLER_60_404 VDD VSS FILLER1
XFILLER_82_32 VDD VSS DECAPHV8
X_11853_ _11853_/A _11853_/B _11853_/C _11853_/D VDD VSS _14139_/C OAI211X1
X_14641_ _14645_/C _14642_/B _17455_/A VDD VSS _14642_/C OAI21X1
XFILLER_60_437 VDD VSS FILLER4
X_10804_ _10808_/C _10804_/B VDD VSS _10938_/B XNOR2X1
X_17360_ _17392_/A _17360_/B VDD VSS _17571_/D AND2X1
X_11784_ _11784_/A _11784_/B _11784_/C _11784_/D VDD VSS _14081_/C OAI211X1
X_16311_ _16349_/A _16349_/B _16349_/C _16567_/A VDD VSS _16342_/A AOI31X1
X_14572_ _18529_/Q _18561_/Q VDD VSS _14573_/C NAND2X1
XFILLER_13_375 VDD VSS FILLER4
XFILLER_15_70 VDD VSS DECAPHV8
X_10735_ _17907_/Q _10738_/B VDD VSS _10736_/B XNOR2X1
Xclkbuf_leaf_30__002_ clkload27/A VDD VSS _18436_/CK BUFX12
X_17291_ _17291_/A _17291_/B VDD VSS _17302_/A NAND2X1
X_13523_ _14456_/B _14456_/C _18478_/Q VDD VSS _13525_/C AOI21X1
XFILLER_90_1091 VDD VSS DECAPHV16
X_10666_ _17895_/Q _10668_/B _10668_/C VDD VSS _10808_/B XNOR3X1
X_19030_ _19033_/CK _19030_/D _19030_/Q VDD VSS DFFQX1
X_16242_ _16240_/Y _16242_/B _16316_/A VDD VSS _16261_/A OR3BX1
X_13454_ _18372_/Q _14335_/B _14335_/C VDD VSS _13455_/D OR3BX1
X_12405_ _18389_/Q VDD VSS _12489_/A INVX1
X_16173_ _18043_/Q _18653_/Q VDD VSS _16239_/A XOR2X1
X_13385_ _18241_/Q _14183_/B VDD VSS _13386_/D _14183_/C NAND3X1
XFILLER_126_222 VDD VSS DECAPHV8
XFILLER_127_767 VDD VSS FILLER1
XTAP_TAPCELL_ROW_2_40 VDD VSS WELLTAP
X_10597_ _17880_/Q _10597_/B _10597_/C VDD VSS _10599_/A MIN3X1
X_15124_ _15318_/A _18694_/Q VDD VSS _18667_/D AND2X1
XFILLER_127_789 VDD VSS FILLER1
XFILLER_86_1127 VDD VSS FILLER4
X_12336_ _14115_/B _14115_/C _18179_/Q VDD VSS _12338_/C AOI21X1
Xclkbuf_leaf_45__002_ clkload25/A VDD VSS _18509_/CK BUFX12
XFILLER_126_299 VDD VSS DECAPHV8
XFILLER_99_128 VDD VSS DECAPHV8
X_12267_ _18232_/Q _12267_/B _12430_/D VDD VSS _12334_/C XNOR3X1
X_15055_ _15056_/A _15057_/C _17266_/C VDD VSS _15056_/C OAI21X1
X_11218_ _18030_/Q _11221_/C _17392_/A VDD VSS _11219_/C OAI21X1
X_12198_ _12291_/A _12291_/B _12203_/C VDD VSS _14412_/B XNOR3X1
X_14006_ _14013_/A _14006_/B _14008_/C _14013_/D VDD VSS _18079_/D OAOI211X1
XFILLER_110_623 VDD VSS FILLER4
X_11149_ _17987_/Q _11149_/B VDD VSS _11150_/D NAND2X1
X_18814_ _18841_/CK _18814_/D _18814_/Q VDD VSS DFFQX1
XFILLER_110_689 VDD VSS FILLER1
X_18745_ _18801_/CK _18745_/D _18745_/Q VDD VSS DFFQX1
X_15957_ _16206_/A _15957_/B _16038_/B _15957_/D VDD VSS _15979_/A AOI31X1
XFILLER_36_434 VDD VSS DECAPHV16
XFILLER_76_581 VSS VDD FILLER2
X_18676_ _18838_/CK _18676_/D _18676_/Q VDD VSS DFFQX1
X_15888_ _15912_/D _15975_/C VDD VSS _15912_/C NAND2X1
X_14908_ _14908_/A _14909_/C _14908_/C VDD VSS _18601_/D AOI21X1
XFILLER_91_551 VDD VSS FILLER4
X_17627_ _19052_/CK _17627_/D _17627_/Q VDD VSS DFFQX1
X_14839_ _18587_/Q _18619_/Q VDD VSS _14844_/A XNOR2X1
XFILLER_63_275 VDD VSS FILLER4
XFILLER_63_286 VSS VDD FILLER2
XFILLER_91_584 VDD VSS FILLER4
X_17558_ _17741_/Q _18530_/Q VDD VSS _17560_/B XOR2X1
X_17489_ _17499_/A _17489_/B VDD VSS _17693_/D NOR2X1
X_16509_ _18824_/Q _18716_/Q VDD VSS _16549_/C AND2X1
XFILLER_108_1098 VDD VSS FILLER1
XFILLER_82_0 VDD VSS DECAPHV32
XFILLER_30_1104 VSS VDD FILLER2
XFILLER_30_1115 VDD VSS FILLER1
XFILLER_106_907 VDD VSS FILLER4
XFILLER_105_417 VSS VDD FILLER2
XFILLER_133_737 VDD VSS FILLER1
XFILLER_67_1082 VSS VDD FILLER2
XFILLER_87_813 VDD VSS DECAPHV16
XFILLER_28_1066 VSS VDD FILLER2
X_09814_ _10922_/A VDD VSS _09843_/A BUFX3
XFILLER_86_334 VDD VSS FILLER4
XFILLER_87_879 VDD VSS FILLER4
XFILLER_86_389 VDD VSS FILLER1
XTAP_TAPCELL_ROW_57_705 VDD VSS WELLTAP
X_09745_ _17692_/Q _17488_/B VDD VSS _09747_/C XNOR2X1
XFILLER_55_743 VDD VSS FILLER1
XTAP_TAPCELL_ROW_107_1302 VDD VSS WELLTAP
X_09676_ _09677_/A _09677_/B _09677_/C VDD VSS _09712_/B OAI21X1
XFILLER_27_445 VDD VSS DECAPHV8
XFILLER_28_979 VDD VSS FILLER1
XFILLER_43_916 VDD VSS FILLER1
XFILLER_54_231 VDD VSS FILLER1
XFILLER_55_765 VDD VSS FILLER1
XFILLER_42_426 VDD VSS FILLER1
XFILLER_54_297 VDD VSS DECAPHV8
XFILLER_55_798 VDD VSS FILLER4
XFILLER_82_595 VDD VSS FILLER4
XTAP_TAPCELL_ROW_37_462 VDD VSS WELLTAP
XTAP_TAPCELL_ROW_65_793 VDD VSS WELLTAP
XFILLER_74_1053 VDD VSS DECAPHV16
XFILLER_50_470 VDD VSS DECAPHV8
XFILLER_51_982 VDD VSS FILLER4
XFILLER_51_993 VDD VSS FILLER4
X_10520_ _10680_/A _10680_/B _10680_/C _10681_/C VDD VSS _10544_/B AOAI211X1
X_10451_ _10457_/A _10457_/B VDD VSS _10454_/A NAND2X1
XTAP_TAPCELL_ROW_118_1431 VDD VSS WELLTAP
X_10382_ _14361_/A VDD VSS _10382_/Y BUFX3
X_13170_ _13170_/A _13170_/B _13170_/C _13170_/D VDD VSS _13267_/B AOAI211X1
XFILLER_124_748 VSS VDD FILLER2
XTAP_TAPCELL_ROW_9_121 VDD VSS WELLTAP
XTAP_TAPCELL_ROW_9_132 VDD VSS WELLTAP
X_12121_ _12121_/A _12121_/B _12121_/C _12121_/D VDD VSS _12310_/A OAOI211X1
X_12052_ _12052_/A _12052_/B _12052_/C _12065_/C VDD VSS _12249_/B AOAI211X1
XFILLER_105_995 VDD VSS DECAPHV16
XFILLER_133_1114 VSS VDD FILLER2
XFILLER_42_1008 VSS VDD FILLER2
XFILLER_77_32 VDD VSS DECAPHV32
XFILLER_78_846 VDD VSS FILLER1
X_11003_ _17960_/Q _11008_/B VDD VSS _11005_/C XOR2X1
X_16860_ _18925_/Q _16864_/B VDD VSS _16865_/B XOR2X1
X_16791_ _16791_/A _16798_/B VDD VSS _16793_/B XNOR2X1
X_15811_ _15850_/A _15850_/B _16206_/A VDD VSS _15811_/Y OAI21X1
XFILLER_18_434 VDD VSS FILLER1
XTAP_TAPCELL_ROW_129_1571 VDD VSS WELLTAP
X_12954_ _13014_/A _14300_/B _12955_/C VDD VSS _14301_/B OR3BX1
X_18530_ clkload4/A _18530_/D _18530_/Q VDD VSS DFFQX1
X_15742_ _15676_/B _15741_/Y _15651_/Y VDD VSS _15746_/C MUXI2X1
XFILLER_18_456 VSS VDD FILLER2
XFILLER_93_64 VDD VSS DECAPHV16
X_11905_ _18383_/Q VDD VSS _12102_/A INVX1
X_18461_ _18461_/CK _18461_/D _18461_/Q VDD VSS DFFQX1
XFILLER_45_286 VDD VSS FILLER4
XTAP_TAPCELL_ROW_82_1007 VDD VSS WELLTAP
X_12885_ _18986_/Q _18107_/Q VDD VSS _12994_/D AND2X1
X_17412_ _17423_/A _17412_/B VDD VSS _17620_/D NOR2X1
X_15673_ _15673_/A _15673_/B _15673_/C _15674_/A VDD VSS _15674_/C OAI211X1
XFILLER_26_80 VDD VSS FILLER1
XFILLER_33_459 VDD VSS FILLER1
XFILLER_92_1131 VDD VSS FILLER1
X_11836_ _14285_/A _11836_/B _14255_/B VDD VSS _11837_/B MIN3X1
X_18392_ _18417_/CK _18392_/D _18392_/Q VDD VSS DFFQX1
X_14624_ _14626_/C _14624_/B _14624_/C VDD VSS _18540_/D AOI21X1
X_11767_ _14109_/B _14109_/C _18173_/Q VDD VSS _11769_/C AOI21X1
X_17343_ _17355_/A _17343_/B VDD VSS _19042_/D NOR2X1
X_14555_ _18526_/Q _18558_/Q VDD VSS _14562_/C NOR2X1
XFILLER_13_183 VSS VDD FILLER2
XFILLER_14_695 VSS VDD FILLER2
X_10718_ _10718_/A _10718_/B VDD VSS _10851_/B XNOR2X1
X_17274_ _19011_/Q _17287_/B VDD VSS _17277_/A NAND2X1
X_13506_ _13580_/A _13580_/B _13506_/C VDD VSS _18048_/D OA21X2
XFILLER_9_176 VDD VSS FILLER1
X_11698_ _11774_/A _14080_/B VDD VSS _11786_/A NOR2X1
X_19013_ _19019_/CK _19013_/D _19013_/Q VDD VSS DFFQX1
X_16225_ _16459_/A _16225_/B _16225_/C VDD VSS _16234_/C AO21X2
X_14486_ _14517_/A _14486_/B VDD VSS _18499_/D NOR2X1
X_10649_ _10649_/A _10651_/C VDD VSS _10787_/B XNOR2X1
X_13437_ _18503_/Q _13437_/B _13437_/C VDD VSS _13580_/A MIN3X1
X_16156_ _16180_/A VDD VSS _16554_/A BUFX3
X_13368_ _14304_/B _14304_/C _18345_/Q VDD VSS _13371_/B AOI21X1
XTAP_TAPCELL_ROW_93_1136 VDD VSS WELLTAP
X_12319_ _12334_/A _12334_/B _12334_/C VDD VSS _14202_/B OAI21X1
X_16087_ _16087_/A VDD VSS _16089_/C INVX1
X_15107_ _15272_/A _18678_/Q VDD VSS _18651_/D AND2X1
X_13299_ _13305_/A _14210_/B _13380_/C VDD VSS _14211_/C NOR3X1
X_15038_ _15039_/C _17255_/D _15038_/C VDD VSS _18629_/D AND3BX1
XFILLER_69_824 VSS VDD FILLER2
XFILLER_68_356 VDD VSS FILLER4
XFILLER_69_879 VDD VSS DECAPHV8
XFILLER_95_120 VDD VSS FILLER4
XFILLER_95_164 VDD VSS FILLER1
XFILLER_96_687 VSS VDD FILLER2
X_16989_ _16989_/A _17019_/B _17019_/C _18943_/Q VDD VSS _18943_/D AO22X2
XFILLER_114_1080 VDD VSS FILLER1
XFILLER_36_220 VDD VSS DECAPHV8
XFILLER_3_1013 VDD VSS DECAPHV8
XFILLER_77_890 VSS VDD FILLER2
X_09530_ _17513_/B _17715_/Q _09530_/C VDD VSS _09558_/C MIN3X1
X_18728_ _18808_/CK _18728_/D _18728_/Q VDD VSS DFFQX1
XFILLER_37_754 VDD VSS FILLER4
XFILLER_97_1042 VSS VDD FILLER2
X_09461_ _17585_/Q _17374_/B VDD VSS _09470_/B XNOR2X1
Xwire35 wire35/A VDD VSS wire35/Y BUFX6
XFILLER_24_415 VSS VDD FILLER2
XFILLER_25_927 VSS VDD FILLER2
XFILLER_36_286 VSS VDD FILLER2
XFILLER_37_798 VDD VSS FILLER1
XFILLER_58_1048 VDD VSS FILLER4
XFILLER_64_584 VDD VSS DECAPHV16
XFILLER_92_882 VDD VSS FILLER1
XFILLER_97_1097 VDD VSS DECAPHV8
X_18659_ _18846_/CK _18659_/D _18659_/Q VDD VSS DFFQX1
XFILLER_24_437 VSS VDD FILLER2
XFILLER_51_223 VDD VSS FILLER1
XFILLER_52_757 VDD VSS FILLER1
XTAP_TAPCELL_ROW_34_421 VDD VSS WELLTAP
XTAP_TAPCELL_ROW_34_432 VDD VSS WELLTAP
X_09392_ _17742_/Q _09392_/B _09392_/C VDD VSS _09423_/C MIN3X1
XFILLER_33_993 VDD VSS DECAPHV8
XTAP_TAPCELL_ROW_102_1243 VDD VSS WELLTAP
XTAP_TAPCELL_ROW_62_763 VDD VSS WELLTAP
XFILLER_106_715 VSS VDD FILLER2
XFILLER_106_759 VDD VSS DECAPHV8
XFILLER_121_1095 VDD VSS DECAPHV16
XFILLER_133_545 VSS VDD FILLER2
XFILLER_120_206 VDD VSS DECAPHV16
XFILLER_78_109 VSS VDD FILLER2
XTAP_TAPCELL_ROW_113_1372 VDD VSS WELLTAP
XFILLER_87_654 VDD VSS DECAPHV8
XFILLER_99_492 VDD VSS FILLER1
XFILLER_47_518 VDD VSS FILLER1
XFILLER_86_142 VDD VSS FILLER4
XFILLER_101_497 VSS VDD FILLER2
XFILLER_86_186 VDD VSS FILLER1
X_09728_ _09739_/A _09739_/B VDD VSS _17385_/B XNOR2X1
XFILLER_16_905 VDD VSS DECAPHV16
XFILLER_76_1104 VSS VDD FILLER2
XFILLER_83_860 VDD VSS FILLER4
XFILLER_27_264 VDD VSS FILLER4
XFILLER_28_787 VSS VDD FILLER2
XFILLER_82_381 VSS VDD FILLER2
X_09659_ _17450_/B _17656_/Q VDD VSS _09671_/A NOR2BX1
XFILLER_103_96 VDD VSS DECAPHV32
XFILLER_42_245 VDD VSS FILLER1
X_12670_ _18984_/Q _18105_/Q VDD VSS _12783_/D NAND2X1
XFILLER_24_971 VDD VSS FILLER4
X_11621_ _11621_/A _11621_/B _11621_/C _11621_/D VDD VSS _14136_/C OAI211X1
XFILLER_129_818 VSS VDD FILLER2
X_14340_ _14394_/A _14340_/B _14340_/C VDD VSS _18376_/D NOR3X1
XFILLER_11_654 VDD VSS DECAPHV32
XFILLER_128_328 VDD VSS DECAPHV16
XFILLER_7_625 VDD VSS DECAPHV16
XTAP_TAPCELL_ROW_12_159 VDD VSS WELLTAP
X_11552_ _14049_/A _14049_/B _11552_/C VDD VSS _11556_/D AO21X2
XFILLER_13_1132 VDD VSS FILLER4
XFILLER_6_113 VDD VSS DECAPHV16
X_10503_ _10503_/A _10503_/B _10503_/C VDD VSS _10504_/B AOI21X1
X_11483_ _11483_/A _11483_/B _11483_/C _11483_/D VDD VSS _14105_/C OAI211X1
X_14271_ _14272_/A _14272_/B VDD VSS _14273_/B AND2X1
XFILLER_109_575 VDD VSS DECAPHV8
XFILLER_136_350 VDD VSS DECAPHV8
X_10434_ _10434_/A _10434_/B _10434_/C VDD VSS _10436_/A OAI21X1
X_13222_ _18163_/Q _14098_/B VDD VSS _13314_/B XNOR2X1
X_16010_ _18784_/Q _18730_/Q VDD VSS _16038_/C XNOR2X1
XFILLER_109_597 VDD VSS FILLER4
X_10365_ _17849_/Q _10376_/B _10376_/C VDD VSS _10555_/C XNOR3X1
X_13153_ _13153_/A _14422_/B _14422_/C VDD VSS _13330_/C NOR3X1
XFILLER_124_545 VDD VSS FILLER4
X_12104_ _18410_/Q _12104_/B _12104_/C VDD VSS _12105_/C MIN3X1
XFILLER_105_781 VDD VSS FILLER4
X_10296_ _10296_/A _10296_/B _10296_/C VDD VSS _10297_/B AOI21X1
X_13084_ _18266_/Q VDD VSS _13199_/A INVX1
X_17961_ _17961_/CK _17961_/D _17961_/Q VDD VSS DFFQX1
X_12035_ _12234_/A _12035_/B VDD VSS _14141_/B XNOR2X1
X_17892_ _17972_/CK _17892_/D _17892_/Q VDD VSS DFFQX1
X_16912_ _16957_/A _16930_/A VDD VSS _16922_/A NOR2X1
X_16843_ _16866_/A _16855_/A VDD VSS _16847_/A NOR2X1
XFILLER_19_721 VDD VSS DECAPHV8
XFILLER_65_315 VDD VSS FILLER1
XFILLER_93_624 VDD VSS FILLER4
XFILLER_18_231 VDD VSS FILLER1
XFILLER_19_754 VDD VSS DECAPHV16
XFILLER_20_1125 VDD VSS DECAPHV8
XFILLER_46_551 VSS VDD FILLER2
XFILLER_81_808 VDD VSS FILLER1
X_18513_ _18514_/CK _18513_/D _18513_/Q VDD VSS DFFQX1
X_16774_ _16808_/A _16808_/B VDD VSS _16795_/A NAND2X1
X_13986_ _18948_/Q _13988_/B VDD VSS _13987_/B XNOR2X1
XFILLER_46_584 VSS VDD FILLER2
X_12937_ _12949_/A _12949_/B _12949_/C VDD VSS _14392_/C NOR3X1
X_15725_ _15734_/B _15734_/C VDD VSS _15726_/B NOR2BX1
X_12868_ _12868_/A _14236_/B _12960_/C _12868_/D VDD VSS _13076_/A OAOI211X1
X_18444_ _18470_/CK _18444_/D _18444_/Q VDD VSS DFFQX1
X_15656_ _15669_/A _17000_/A _15656_/C VDD VSS _18881_/D OAI21X1
XFILLER_33_278 VDD VSS FILLER1
X_11819_ _18382_/Q VDD VSS _11825_/A INVX1
X_18375_ _18376_/CK _18375_/D _18375_/Q VDD VSS DFFQX1
X_14607_ _18536_/Q _18568_/Q _14607_/C VDD VSS _14611_/B MIN3X1
XFILLER_14_470 VDD VSS FILLER1
XFILLER_30_941 VDD VSS DECAPHV8
X_12799_ _12799_/A _12799_/B _12799_/C _12799_/D VDD VSS _13021_/B AOAI211X1
X_17326_ _17338_/A _17326_/B VDD VSS _19026_/D NOR2X1
X_15587_ _18875_/Q _15587_/B _15587_/C VDD VSS _15591_/B MIN3X1
XFILLER_119_317 VDD VSS DECAPHV16
X_14538_ _18523_/Q _18555_/Q VDD VSS _14544_/A XNOR2X1
X_17257_ _17251_/C _17257_/B VDD VSS _17259_/B NOR2BX1
X_14469_ _14480_/A _14469_/B VDD VSS _18489_/D NOR2X1
X_17188_ _17498_/A _17188_/B VDD VSS _18995_/D AND2X1
X_16208_ _16245_/C _16245_/D _16245_/E VDD VSS _16210_/A AOI21X1
X_16139_ _18787_/Q _18733_/Q VDD VSS _16140_/B XNOR2X1
XFILLER_45_0 VDD VSS DECAPHV32
X_08961_ _08963_/A _08963_/B _08961_/C VDD VSS _17752_/D AOI21X1
XFILLER_64_1063 VDD VSS FILLER1
XFILLER_68_131 VDD VSS DECAPHV8
XFILLER_69_654 VDD VSS FILLER1
X_08892_ _17528_/B _17528_/A VDD VSS _08893_/C NOR2BX1
XFILLER_110_250 VDD VSS FILLER1
XFILLER_111_751 VDD VSS FILLER1
XFILLER_112_1006 VDD VSS FILLER4
XFILLER_5_1119 VDD VSS DECAPHV16
XFILLER_68_142 VDD VSS FILLER4
XFILLER_69_676 VSS VDD FILLER2
XFILLER_97_974 VSS VDD FILLER2
XTAP_TAPCELL_ROW_67_822 VDD VSS WELLTAP
XFILLER_65_871 VDD VSS FILLER1
XFILLER_65_893 VDD VSS DECAPHV8
XFILLER_83_178 VSS VDD FILLER2
XFILLER_83_189 VDD VSS FILLER1
X_09513_ _09514_/A _09514_/B _09514_/C VDD VSS _09525_/C OAI21X1
X_09444_ _09428_/A _09444_/B VDD VSS _09474_/B NAND2BX1
XFILLER_24_278 VDD VSS FILLER4
XFILLER_21_941 VDD VSS FILLER4
XFILLER_33_48 VDD VSS DECAPHV8
X_09375_ _17582_/Q _17371_/B VDD VSS _09386_/B XNOR2X1
XFILLER_123_1113 VSS VDD FILLER2
XFILLER_123_1135 VDD VSS FILLER1
XFILLER_119_840 VDD VSS DECAPHV8
XTAP_TAPCELL_ROW_115_1401 VDD VSS WELLTAP
XFILLER_4_639 VDD VSS DECAPHV32
XFILLER_133_375 VDD VSS DECAPHV16
XFILLER_79_429 VSS VDD FILLER2
XFILLER_82_1130 VSS VDD FILLER2
X_10150_ _17820_/Q _10157_/A _10150_/C VDD VSS _10156_/D XNOR3X1
XFILLER_0_845 VDD VSS DECAPHV8
X_10081_ _17392_/A _10277_/B VDD VSS _17837_/D AND2X1
XFILLER_88_974 VSS VDD FILLER2
XFILLER_114_40 VDD VSS FILLER4
XFILLER_101_294 VSS VDD FILLER2
XFILLER_56_860 VDD VSS FILLER1
XTAP_TAPCELL_ROW_126_1530 VDD VSS WELLTAP
X_13840_ _13840_/A _14431_/B _13861_/C _13840_/D VDD VSS wire26/A OAOI211X1
XFILLER_28_562 VDD VSS FILLER4
XFILLER_28_584 VSS VDD FILLER2
XFILLER_55_370 VSS VDD FILLER2
XFILLER_74_167 VDD VSS DECAPHV16
XFILLER_74_44 VSS VDD FILLER2
XTAP_TAPCELL_ROW_17_218 VDD VSS WELLTAP
X_10983_ _10986_/C _10983_/B VDD VSS _11121_/B XNOR2X1
X_13771_ _18482_/Q _13771_/B _13816_/C VDD VSS _13827_/B XNOR3X1
XFILLER_16_768 VDD VSS FILLER4
XFILLER_43_532 VDD VSS FILLER1
X_12722_ _18340_/Q _14299_/B VDD VSS _12843_/A AND2X1
X_16490_ _16490_/A _16490_/B _16490_/C _16490_/D VDD VSS _16491_/B AOI211X1
X_15510_ _18870_/Q _15510_/B VDD VSS _15511_/C NAND2X1
XFILLER_15_278 VDD VSS FILLER1
XFILLER_71_863 VDD VSS DECAPHV8
X_15441_ _15801_/B VDD VSS _15673_/A BUFX3
XFILLER_90_32 VDD VSS DECAPHV8
X_12653_ _12653_/A _12653_/B _12653_/C _12653_/D VDD VSS _14118_/B AOAI211X1
XFILLER_129_604 VDD VSS FILLER4
X_11604_ _18196_/Q VDD VSS _11606_/A INVX1
X_12584_ _18469_/Q _12707_/B _12595_/C VDD VSS _14479_/B XNOR3X1
X_18160_ _18250_/CK _18160_/D _18160_/Q VDD VSS DFFQX1
X_15372_ _18912_/Q _15372_/B VDD VSS _15373_/B XOR2X1
XFILLER_11_462 VSS VDD FILLER2
XFILLER_129_637 VDD VSS FILLER1
XFILLER_8_945 VDD VSS DECAPHV8
X_11535_ _18249_/Q _11535_/B _11535_/C VDD VSS _11669_/B MIN3X1
X_18091_ _18971_/CK _18091_/D _18091_/Q VDD VSS DFFQX1
X_17111_ _17112_/A _17112_/B _17112_/C VDD VSS _17113_/B NOR3X1
X_14323_ _14377_/A _14323_/B VDD VSS _18361_/D AND2X1
XFILLER_109_350 VDD VSS FILLER1
XFILLER_7_455 VDD VSS DECAPHV8
X_17042_ _17044_/A _17044_/B _17044_/C VDD VSS _17050_/B AO21X2
X_14254_ _14269_/A _14254_/B VDD VSS _18303_/D NOR2X1
XFILLER_87_1030 VSS VDD FILLER2
X_11466_ _18299_/Q _14249_/B VDD VSS _11467_/B OR2X2
X_13205_ _13205_/A _13205_/B _13206_/C VDD VSS _13303_/B XNOR3X1
XFILLER_109_394 VDD VSS FILLER1
XFILLER_124_342 VDD VSS DECAPHV8
XFILLER_125_865 VDD VSS FILLER1
XFILLER_99_96 VDD VSS DECAPHV32
X_10417_ _10707_/A _10597_/B VDD VSS _17880_/D AND2X1
X_11397_ _11446_/A _11397_/B VDD VSS _14047_/B XOR2X1
X_14185_ _14372_/A _14185_/B VDD VSS _18243_/D AND2X1
X_10348_ _10349_/B _10349_/C _17845_/Q VDD VSS _10350_/C AOI21X1
X_13136_ _18421_/Q _14393_/B VDD VSS _13257_/A AND2X1
X_18993_ _18994_/CK _18993_/D _18993_/Q VDD VSS DFFQX1
X_10279_ _10309_/A _10470_/B _10470_/C VDD VSS _10482_/B XNOR3X1
X_13067_ _18317_/Q _14268_/B VDD VSS _13234_/E _14268_/C NAND3X1
X_17944_ _17993_/CK _17944_/D _17944_/Q VDD VSS DFFQX1
XFILLER_94_911 VDD VSS FILLER1
X_12018_ _12034_/A _14197_/B _12034_/C VDD VSS _14199_/B OAI21X1
XFILLER_65_112 VDD VSS DECAPHV8
X_17875_ _17932_/CK _17875_/D _17875_/Q VDD VSS DFFQX1
X_16826_ _18922_/Q _16862_/B VDD VSS _16827_/C NAND2X1
XFILLER_111_1061 VDD VSS DECAPHV8
XFILLER_34_510 VDD VSS FILLER1
XTAP_TAPCELL_ROW_88_1079 VDD VSS WELLTAP
X_16757_ _16757_/A _16757_/B _16757_/C _16757_/D VDD VSS _16762_/C AOI22X1
X_13969_ _18942_/Q _13972_/B VDD VSS _13970_/B XNOR2X1
XFILLER_0_1038 VDD VSS DECAPHV32
X_15708_ _15625_/Y _15673_/B _15651_/Y VDD VSS _15715_/C MUXI2X1
XFILLER_34_565 VDD VSS FILLER1
X_16688_ _16688_/A _16688_/B _16688_/C VDD VSS _16723_/B OA21X2
XFILLER_22_749 VDD VSS DECAPHV16
XTAP_TAPCELL_ROW_72_880 VDD VSS WELLTAP
X_18427_ _18453_/CK _18427_/D _18427_/Q VDD VSS DFFQX1
X_15639_ _18880_/Q _15644_/B VDD VSS _15641_/A XNOR2X1
X_09160_ _09203_/B _09160_/B VDD VSS _17431_/B NOR2BX1
X_18358_ _18358_/CK _18358_/D _18358_/Q VDD VSS DFFQX1
X_09091_ _09091_/A _09094_/B VDD VSS _09092_/B XNOR2X1
X_18289_ _18313_/CK _18289_/D _18289_/Q VDD VSS DFFQX1
X_17309_ _17312_/C _17310_/B _17318_/C VDD VSS _17310_/C OAI21X1
XFILLER_66_1114 VSS VDD FILLER2
XFILLER_103_504 VDD VSS DECAPHV8
XFILLER_131_835 VSS VDD FILLER2
XFILLER_89_738 VDD VSS FILLER4
X_09993_ _10194_/A _10194_/B _10195_/A VDD VSS _10208_/B AO21X2
XFILLER_115_397 VSS VDD FILLER2
XFILLER_130_323 VSS VDD FILLER2
XFILLER_131_846 VDD VSS FILLER4
X_08944_ _08944_/A _08944_/B _08944_/C VDD VSS _08952_/A OA21X2
XFILLER_9_1063 VDD VSS FILLER1
XTAP_TAPCELL_ROW_110_1342 VDD VSS WELLTAP
XFILLER_84_421 VDD VSS FILLER4
XFILLER_9_1096 VDD VSS DECAPHV8
X_08875_ _16977_/A VDD VSS _17533_/A BUFX3
XFILLER_57_679 VDD VSS FILLER1
XFILLER_85_966 VDD VSS FILLER4
XFILLER_85_988 VDD VSS DECAPHV8
XFILLER_25_543 VSS VDD FILLER2
XFILLER_80_660 VDD VSS FILLER1
XTAP_TAPCELL_ROW_42_519 VDD VSS WELLTAP
X_09427_ _17648_/Q _17441_/B VDD VSS _09444_/B XNOR2X1
XTAP_TAPCELL_ROW_121_1471 VDD VSS WELLTAP
X_09358_ _17645_/Q _17438_/B VDD VSS _09369_/A NAND2BX1
XFILLER_20_281 VDD VSS FILLER1
XFILLER_5_904 VDD VSS DECAPHV16
XTAP_TAPCELL_ROW_22_287 VDD VSS WELLTAP
X_09289_ _17643_/Q _17436_/B VDD VSS _09290_/B XNOR2X1
X_11320_ _11356_/A _14045_/B VDD VSS _11389_/B NAND2X1
XFILLER_125_128 VDD VSS DECAPHV32
XFILLER_10_1135 VDD VSS FILLER1
X_11251_ _18112_/Q _11349_/B _11349_/C VDD VSS _11255_/C XNOR3X1
XFILLER_107_876 VDD VSS FILLER1
X_10202_ _10385_/A _10385_/B _10385_/C _10390_/C VDD VSS _10399_/B AOAI211X1
X_11182_ _11182_/A _11185_/C VDD VSS _17129_/B XNOR2X1
XFILLER_0_620 VDD VSS DECAPHV8
XFILLER_121_312 VDD VSS FILLER4
XFILLER_121_323 VDD VSS FILLER4
XFILLER_69_88 VDD VSS FILLER4
X_10133_ _09935_/Y _10325_/B _10325_/C VDD VSS _17843_/D AND3BX1
XFILLER_47_1080 VDD VSS FILLER4
XFILLER_47_1091 VDD VSS DECAPHV8
X_15990_ _18898_/Q _15990_/B VDD VSS _16030_/B NOR2X1
XFILLER_102_581 VDD VSS FILLER1
XFILLER_134_1072 VDD VSS DECAPHV32
XFILLER_48_624 VSS VDD FILLER2
XFILLER_85_32 VDD VSS DECAPHV32
XFILLER_88_793 VSS VDD FILLER2
X_10064_ _10064_/A _10067_/B VDD VSS _10068_/B XNOR2X1
X_14941_ _14944_/C _14941_/B _14941_/C VDD VSS _18608_/D AOI21X1
XFILLER_75_432 VDD VSS FILLER4
X_17660_ _17725_/CK _17660_/D _17660_/Q VDD VSS DFFQX1
X_14872_ _14872_/A _14872_/B _14872_/C VDD VSS _14878_/C OA21X2
XFILLER_29_882 VDD VSS DECAPHV8
XFILLER_47_167 VDD VSS DECAPHV8
XFILLER_47_189 VDD VSS FILLER1
X_17591_ _17656_/CK _17591_/D _17591_/Q VDD VSS DFFQX1
X_16611_ _18826_/Q _18718_/Q VDD VSS _16616_/B NAND2X1
X_13823_ _13823_/A _13823_/B VDD VSS _13824_/B XOR2X1
XFILLER_16_521 VSS VDD FILLER2
XFILLER_44_830 VDD VSS FILLER1
X_16542_ _16587_/A _16587_/B VDD VSS _16542_/Y NOR2X1
X_10966_ _17953_/Q _10969_/A VDD VSS _10967_/B XNOR2X1
X_13754_ _13754_/A _13754_/B _13754_/C _13754_/D VDD VSS _13809_/B AOAI211X1
X_10897_ _10897_/A _10897_/B _10897_/C VDD VSS _10901_/C OAI21X1
X_12705_ _18469_/Q VDD VSS _12707_/A INVX1
X_16473_ _16474_/A _16474_/B _16474_/C VDD VSS _16475_/B NOR3X1
X_13685_ _18349_/Q _14308_/B VDD VSS _13690_/A NAND2X1
XFILLER_15_1013 VDD VSS FILLER4
X_12636_ _18287_/Q _14235_/B VDD VSS _12741_/A AND2X1
X_18212_ _18267_/CK _18212_/D _18212_/Q VDD VSS DFFQX1
X_15424_ _15509_/B VDD VSS _15736_/B BUFX3
XTAP_TAPCELL_ROW_5_73 VDD VSS WELLTAP
XTAP_TAPCELL_ROW_5_84 VDD VSS WELLTAP
X_18143_ _18171_/CK _18143_/D _18143_/Q VDD VSS DFFQX1
X_15355_ _18910_/Q VDD VSS _16452_/A INVX1
XFILLER_129_456 VDD VSS FILLER1
XFILLER_15_1079 VDD VSS FILLER4
XFILLER_8_764 VDD VSS DECAPHV16
X_12567_ _12680_/D _12783_/A _12783_/B VDD VSS _12667_/D XNOR3X1
X_14306_ _14332_/A _14306_/B _14306_/C VDD VSS _18347_/D NOR3X1
X_11518_ _18326_/Q _14281_/B VDD VSS _11519_/B OR2X2
X_12498_ _12616_/A _12631_/A _12844_/B VDD VSS _12499_/D XNOR3X1
X_18074_ _18838_/CK _18074_/D output6/A VDD VSS DFFQX1
X_15286_ _15286_/A _18854_/Q VDD VSS _18827_/D AND2X1
X_11449_ _18118_/Q VDD VSS _11552_/C INVX1
X_17025_ _17079_/A _17025_/B VDD VSS _18962_/D NOR2X1
X_14237_ _17065_/A VDD VSS _14296_/A BUFX3
X_14168_ _14174_/A _14168_/B _14168_/C VDD VSS _18227_/D NOR3X1
X_13119_ _18240_/Q _13303_/A _13383_/B VDD VSS _13297_/D XNOR3X1
XFILLER_112_345 VSS VDD FILLER2
XFILLER_85_207 VDD VSS DECAPHV32
X_18976_ _18978_/CK _18976_/D _18976_/Q VDD VSS DFFQX1
X_14099_ _14310_/C _14099_/B VDD VSS _18164_/D AND2X1
XFILLER_121_890 VSS VDD FILLER2
XFILLER_67_922 VDD VSS FILLER1
XFILLER_79_793 VDD VSS FILLER4
X_17927_ _17982_/CK _17927_/D _17927_/Q VDD VSS DFFQX1
XFILLER_94_741 VSS VDD FILLER2
X_17858_ _17861_/CK _17858_/D _17858_/Q VDD VSS DFFQX1
XFILLER_54_627 VDD VSS FILLER1
XFILLER_94_774 VDD VSS FILLER1
X_16809_ _16815_/A _16815_/C VDD VSS _16810_/B AND2X1
X_17789_ _19033_/CK _17789_/D _17789_/Q VDD VSS DFFQX1
XFILLER_35_863 VDD VSS FILLER4
X_09212_ _17608_/Q _17399_/B VDD VSS _09213_/B XOR2X1
X_09143_ _09143_/A _09146_/B VDD VSS _09144_/B XOR2X1
XFILLER_107_128 VDD VSS DECAPHV32
X_09074_ _09096_/B _09074_/B VDD VSS _17326_/B XNOR2X1
XFILLER_30_49 VDD VSS DECAPHV8
XFILLER_2_918 VDD VSS DECAPHV32
XFILLER_131_610 VSS VDD FILLER2
XFILLER_1_439 VDD VSS DECAPHV16
XFILLER_118_1078 VDD VSS FILLER1
XFILLER_130_142 VDD VSS DECAPHV32
XFILLER_131_654 VDD VSS DECAPHV8
XFILLER_58_911 VDD VSS FILLER1
X_09976_ _09976_/A _10187_/B VDD VSS _17823_/D NOR2X1
XFILLER_57_410 VDD VSS DECAPHV8
X_08927_ _17745_/Q _18534_/Q VDD VSS _08928_/B XOR2X1
XFILLER_29_134 VDD VSS FILLER4
XFILLER_85_752 VSS VDD FILLER2
XFILLER_17_318 VDD VSS DECAPHV8
XFILLER_72_413 VDD VSS FILLER1
XFILLER_57_498 VDD VSS DECAPHV8
XFILLER_72_435 VDD VSS FILLER1
XTAP_TAPCELL_ROW_123_1500 VDD VSS WELLTAP
XTAP_TAPCELL_ROW_27_346 VDD VSS WELLTAP
XTAP_TAPCELL_ROW_55_677 VDD VSS WELLTAP
X_10820_ _10844_/A _10956_/B VDD VSS _17950_/D NOR2X1
XFILLER_25_362 VDD VSS DECAPHV8
XFILLER_53_671 VSS VDD FILLER2
X_10751_ _17910_/Q _10756_/B VDD VSS _10753_/C XOR2X1
XFILLER_111_96 VDD VSS DECAPHV32
XFILLER_38_1068 VDD VSS FILLER1
XFILLER_52_181 VDD VSS DECAPHV16
X_13470_ _13639_/A _13639_/B _13639_/C VDD VSS _13534_/B AOI21X1
X_10682_ _10817_/A _10817_/B _10818_/C VDD VSS _10682_/Y NOR3X1
X_12421_ _12421_/A _14261_/B _12421_/C _12421_/D VDD VSS _12631_/A OAOI211X1
XFILLER_126_415 VSS VDD FILLER2
XFILLER_127_927 VSS VDD FILLER2
XFILLER_127_949 VDD VSS FILLER4
X_12352_ _12352_/A _12352_/B _12352_/C _12352_/D VDD VSS _14089_/B AOAI211X1
X_15140_ _15309_/A _18710_/Q VDD VSS _18683_/D AND2X1
XFILLER_112_0 VDD VSS DECAPHV32
XFILLER_126_437 VDD VSS FILLER4
XFILLER_4_222 VDD VSS DECAPHV8
XFILLER_5_734 VDD VSS DECAPHV8
X_11303_ _18166_/Q _11380_/B _11328_/C VDD VSS _11304_/C XNOR3X1
X_12283_ _12283_/A _12283_/B _12283_/C VDD VSS _14442_/B XNOR3X1
X_15071_ _18637_/Q _19015_/Q VDD VSS _15078_/A XNOR2X1
XFILLER_101_1082 VDD VSS FILLER1
X_11234_ _11289_/A _11240_/D VDD VSS _11238_/C XNOR2X1
X_14022_ _17154_/A _18970_/Q VDD VSS _18091_/D AND2X1
XFILLER_136_1123 VSS VDD FILLER2
XFILLER_20_71 VDD VSS DECAPHV8
XFILLER_4_299 VDD VSS DECAPHV16
XFILLER_136_93 VDD VSS DECAPHV32
XFILLER_68_719 VDD VSS FILLER4
X_11165_ _11165_/A _11165_/B _11165_/C VDD VSS _11170_/A OAI21X1
X_18830_ _18857_/CK _18830_/D _18830_/Q VDD VSS DFFQX1
XFILLER_110_827 VDD VSS FILLER1
XFILLER_122_687 VSS VDD FILLER2
XFILLER_49_911 VSS VDD FILLER2
X_10116_ _10121_/A _10123_/B _10123_/C VDD VSS _10296_/C AND3BX1
X_11096_ _11099_/C _11096_/B VDD VSS _17040_/B XNOR2X1
X_18761_ _18815_/CK _18761_/D _18761_/Q VDD VSS DFFQX1
X_15973_ _18035_/Q _18645_/Q VDD VSS _15975_/A AND2X1
XFILLER_48_421 VSS VDD FILLER2
XFILLER_64_903 VSS VDD FILLER2
X_10047_ _10047_/A VDD VSS _10048_/B INVX1
X_17712_ _17716_/CK _17712_/D _17712_/Q VDD VSS DFFQX1
X_14924_ _18604_/Q _18636_/Q _14924_/C VDD VSS _14929_/B MIN3X1
XFILLER_75_240 VSS VDD FILLER2
X_18692_ _18853_/CK _18692_/D _18692_/Q VDD VSS DFFQX1
XFILLER_64_947 VSS VDD FILLER2
XFILLER_90_210 VSS VDD FILLER2
XTAP_TAPCELL_ROW_85_1038 VDD VSS WELLTAP
X_17643_ _17710_/CK _17643_/D _17643_/Q VDD VSS DFFQX1
X_14855_ _18590_/Q _18622_/Q VDD VSS _14861_/B NAND2X1
XFILLER_35_159 VDD VSS FILLER1
X_11998_ _12089_/A _12089_/B _14410_/B VDD VSS _11999_/C XNOR3X1
X_17574_ _19033_/CK _17574_/D _17574_/Q VDD VSS DFFQX1
X_14786_ _18606_/Q VDD VSS _14935_/A INVX1
X_13806_ _13806_/A _13806_/B _13806_/C _13806_/D VDD VSS _14342_/B OAOI211X1
XFILLER_16_362 VDD VSS DECAPHV8
XFILLER_91_1026 VSS VDD FILLER2
X_10949_ _10951_/C _10949_/B VDD VSS _11087_/B XNOR2X1
X_16525_ _18912_/Q _16529_/B VDD VSS _16530_/C XNOR2X1
X_13737_ _18402_/Q _14372_/B VDD VSS _13798_/A NAND2X1
XFILLER_17_1108 VDD VSS FILLER1
XFILLER_31_332 VDD VSS FILLER1
XFILLER_32_844 VDD VSS FILLER4
XFILLER_91_1048 VDD VSS FILLER1
X_16456_ _16456_/A _16456_/B _16456_/C VDD VSS _18910_/D OAI21X1
X_15407_ _15874_/B VDD VSS _15480_/A BUFX3
X_13668_ _14429_/B _13725_/C _18454_/Q VDD VSS _13784_/C AND3BX1
XFILLER_129_253 VDD VSS DECAPHV16
X_12619_ _12633_/A _12619_/B _12844_/D VDD VSS _12726_/C XNOR3X1
X_16387_ _18821_/Q _18713_/Q VDD VSS _16391_/A XOR2X1
X_13599_ _18426_/Q _14399_/B _14399_/C VDD VSS _13605_/C OR3BX1
XFILLER_117_415 VSS VDD FILLER2
X_18126_ _18152_/CK _18126_/D _18126_/Q VDD VSS DFFQX1
X_15338_ _15338_/A _15338_/B VDD VSS _15340_/B NOR2X1
XFILLER_117_459 VDD VSS FILLER4
XFILLER_6_40 VDD VSS FILLER4
XTAP_TAPCELL_ROW_96_1167 VDD VSS WELLTAP
X_18057_ _18853_/CK _18057_/D _18057_/Q VDD VSS DFFQX1
X_15269_ _15299_/A _18837_/Q VDD VSS _18810_/D AND2X1
X_17008_ _17008_/A _17017_/B _17008_/C VDD VSS _18954_/D OAI21X1
XFILLER_112_142 VDD VSS DECAPHV16
XFILLER_59_719 VDD VSS FILLER1
X_09830_ _17773_/Q _09832_/B VDD VSS _09997_/B XOR2X1
XFILLER_58_229 VSS VDD FILLER2
XFILLER_6_1011 VDD VSS DECAPHV32
XFILLER_86_516 VDD VSS FILLER1
XFILLER_99_899 VDD VSS FILLER1
X_09761_ _19051_/Q _17352_/B VDD VSS _09783_/A NOR2X1
X_18959_ _18959_/CK _18959_/D _18959_/Q VDD VSS DFFQX1
XFILLER_27_605 VDD VSS DECAPHV16
XFILLER_55_914 VSS VDD FILLER2
XFILLER_66_251 VDD VSS FILLER1
X_09692_ _09668_/B _09692_/B _09692_/C VDD VSS _09718_/A AOI2B1X1
XFILLER_27_649 VSS VDD FILLER2
XFILLER_66_284 VDD VSS FILLER4
XFILLER_81_210 VDD VSS FILLER1
XFILLER_42_619 VDD VSS FILLER1
XFILLER_81_243 VSS VDD FILLER2
XFILLER_41_118 VDD VSS FILLER1
XFILLER_81_276 VSS VDD FILLER2
XTAP_TAPCELL_ROW_24_305 VDD VSS WELLTAP
XTAP_TAPCELL_ROW_105_1274 VDD VSS WELLTAP
XTAP_TAPCELL_ROW_52_647 VDD VSS WELLTAP
XTAP_TAPCELL_ROW_80_978 VDD VSS WELLTAP
XFILLER_6_509 VSS VDD FILLER2
X_09126_ _17668_/Q _17462_/B VDD VSS _09134_/A NOR2X1
XFILLER_136_768 VDD VSS DECAPHV32
X_09057_ _17602_/Q VDD VSS _09058_/A INVX1
XFILLER_116_492 VDD VSS FILLER1
XFILLER_1_269 VDD VSS DECAPHV8
XFILLER_77_527 VDD VSS FILLER1
X_09959_ _17795_/Q _09959_/B _09959_/C VDD VSS _09970_/A OR3BX1
XFILLER_44_1072 VDD VSS FILLER4
XFILLER_58_741 VDD VSS DECAPHV16
XFILLER_58_763 VDD VSS FILLER1
XFILLER_92_508 VSS VDD FILLER2
X_12970_ _12979_/A _12979_/B _12979_/C VDD VSS _14208_/B OAI21X1
XFILLER_122_40 VDD VSS FILLER4
X_11921_ _11922_/B _11922_/C _12173_/A VDD VSS _12016_/B OAI21X1
XFILLER_17_148 VSS VDD FILLER2
XFILLER_17_159 VDD VSS FILLER1
XFILLER_33_619 VSS VDD FILLER2
XFILLER_72_243 VDD VSS FILLER4
XFILLER_73_766 VSS VDD FILLER2
XFILLER_73_788 VSS VDD FILLER2
X_11852_ _11853_/A _11853_/B _11853_/D _11853_/C VDD VSS _11953_/B OAOI211X1
X_14640_ _18544_/Q _18576_/Q VDD VSS _14642_/B XNOR2X1
XFILLER_26_682 VDD VSS DECAPHV8
XFILLER_54_991 VDD VSS FILLER4
XFILLER_60_416 VSS VDD FILLER2
XFILLER_82_44 VSS VDD FILLER2
X_10803_ _17921_/Q _10808_/B VDD VSS _10804_/B XNOR2X1
X_14571_ _14573_/A _14573_/B _14571_/C VDD VSS _18529_/D AOI21X1
X_11783_ _11784_/A _11784_/B _11784_/D _11784_/C VDD VSS _11870_/B OAOI211X1
X_16310_ _18906_/Q _16310_/B VDD VSS _16345_/A NOR2BX1
X_13522_ _13528_/A _13528_/B _13528_/D _13528_/C VDD VSS _14456_/C OAI211X1
XFILLER_15_60 VDD VSS FILLER4
XFILLER_40_162 VSS VDD FILLER2
XFILLER_41_663 VSS VDD FILLER2
X_10734_ _10734_/A _10734_/B _10734_/C VDD VSS _10738_/C OAI21X1
Xclkbuf_leaf_30__001_ clkbuf_2_1__f__001_/Y VDD VSS _17710_/CK BUFX12
X_17290_ _19015_/Q _17315_/B VDD VSS _17294_/A XOR2X1
XFILLER_51_1032 VDD VSS FILLER1
X_10665_ _10665_/A _10665_/B _10665_/C VDD VSS _10668_/C MIN3X1
X_16241_ _16286_/A _16286_/C _16286_/B VDD VSS _16242_/B AOI21X1
X_13453_ _18398_/Q _13453_/B VDD VSS _13457_/C _13453_/C NAND3X1
XFILLER_127_735 VDD VSS DECAPHV8
XFILLER_12_1027 VSS VDD FILLER2
XFILLER_9_369 VSS VDD FILLER2
X_12404_ _18415_/Q _12404_/B _12404_/C VDD VSS _12602_/B MIN3X1
X_16172_ _16166_/Y _16172_/B _16171_/Y _16326_/A VDD VSS _16179_/B OAI2B2BX1
X_13384_ _14183_/B _14183_/C _18241_/Q VDD VSS _13386_/C AOI21X1
XFILLER_115_908 VDD VSS FILLER4
X_10596_ _10630_/A _10734_/B VDD VSS _17906_/D NOR2X1
X_12335_ _12335_/A _12335_/B _12335_/C _12335_/D VDD VSS _14115_/B AOAI211X1
X_15123_ _17079_/A _16681_/B VDD VSS _18666_/D NOR2X1
XFILLER_108_960 VDD VSS FILLER1
XFILLER_126_267 VDD VSS DECAPHV32
XFILLER_31_92 VDD VSS FILLER1
XTAP_TAPCELL_ROW_2_41 VDD VSS WELLTAP
X_12266_ _18206_/Q _12436_/A _12522_/B VDD VSS _12430_/D XNOR3X1
X_15054_ _15054_/A _17269_/A _15054_/C VDD VSS _15057_/C MIN3X1
X_11217_ _14079_/A _11217_/B _11221_/C VDD VSS _18029_/D NOR3X1
X_12197_ _18413_/Q VDD VSS _12291_/A INVX1
X_14005_ _18956_/Q _14005_/B VDD VSS _14006_/B XOR2X1
XFILLER_96_836 VSS VDD FILLER2
X_11148_ _11148_/A _17092_/B VDD VSS _18013_/D AND2X1
X_18813_ _18841_/CK _18813_/D _18813_/Q VDD VSS DFFQX1
XFILLER_110_646 VSS VDD FILLER2
XFILLER_23_1101 VSS VDD FILLER2
XFILLER_49_730 VDD VSS FILLER1
XFILLER_95_346 VDD VSS FILLER1
XFILLER_110_1104 VDD VSS FILLER1
XFILLER_110_668 VDD VSS FILLER1
X_11079_ _11079_/A _11082_/B VDD VSS _17022_/B XNOR2X1
X_18744_ _18821_/CK _18744_/D _18744_/Q VDD VSS DFFQX1
X_15956_ _16218_/A _18756_/Q VDD VSS _15957_/D AND2X1
XFILLER_37_958 VDD VSS FILLER1
XFILLER_48_273 VDD VSS DECAPHV16
X_18675_ _18837_/CK _18675_/D _18675_/Q VDD VSS DFFQX1
X_15887_ _18036_/Q _18646_/Q VDD VSS _15975_/C OR2X2
X_14907_ _14908_/A _14909_/C _17266_/C VDD VSS _14908_/C OAI21X1
XFILLER_52_906 VDD VSS FILLER4
XFILLER_64_777 VDD VSS FILLER4
X_17626_ _19052_/CK _17626_/D _17626_/Q VDD VSS DFFQX1
X_14838_ _14840_/C _14838_/B _14838_/C VDD VSS _18586_/D AOI21X1
XFILLER_63_265 VDD VSS FILLER4
XFILLER_64_799 VDD VSS DECAPHV8
XFILLER_16_170 VDD VSS DECAPHV16
XFILLER_32_641 VDD VSS FILLER4
XFILLER_60_950 VDD VSS FILLER1
X_17557_ _17557_/A _17557_/B _17557_/C VDD VSS _17740_/D AOI21X1
X_14769_ _14769_/A _14769_/B _14769_/C _14769_/D VDD VSS _14770_/C AOAI211X1
X_17488_ _17499_/A _17488_/B VDD VSS _17692_/D NOR2X1
X_16508_ _16549_/A _16549_/B VDD VSS _16513_/A NOR2X1
X_16439_ _16478_/A _16439_/B VDD VSS _16443_/B XNOR2X1
XFILLER_75_0 VDD VSS DECAPHV32
X_18109_ _18247_/CK _18109_/D _18109_/Q VDD VSS DFFQX1
XFILLER_113_451 VDD VSS FILLER1
XFILLER_113_473 VDD VSS DECAPHV16
XFILLER_115_1026 VDD VSS DECAPHV8
X_09813_ _16977_/A VDD VSS _10922_/A BUFX3
XFILLER_101_635 VDD VSS FILLER4
XFILLER_100_167 VDD VSS DECAPHV8
XFILLER_28_914 VDD VSS DECAPHV8
XFILLER_39_262 VDD VSS DECAPHV16
XFILLER_67_571 VDD VSS FILLER1
XTAP_TAPCELL_ROW_57_706 VDD VSS WELLTAP
X_09744_ _09744_/A _09770_/C VDD VSS _17488_/B XNOR2X1
XTAP_TAPCELL_ROW_107_1303 VDD VSS WELLTAP
X_09675_ _17593_/Q _17383_/B VDD VSS _09677_/C XNOR2X1
XFILLER_27_457 VSS VDD FILLER2
XFILLER_82_563 VSS VDD FILLER2
XFILLER_27_479 VDD VSS FILLER4
XTAP_TAPCELL_ROW_37_463 VDD VSS WELLTAP
XTAP_TAPCELL_ROW_65_794 VDD VSS WELLTAP
XFILLER_11_836 VDD VSS FILLER1
XFILLER_109_724 VDD VSS FILLER4
XFILLER_136_510 VSS VDD FILLER2
XFILLER_22_195 VDD VSS DECAPHV8
X_10450_ _10447_/A _10450_/B VDD VSS _10457_/B NAND2BX1
XFILLER_108_212 VDD VSS FILLER4
XFILLER_136_543 VDD VSS DECAPHV8
XFILLER_6_328 VDD VSS DECAPHV32
XTAP_TAPCELL_ROW_118_1432 VDD VSS WELLTAP
X_09109_ _09125_/B _09109_/B VDD VSS _17394_/B XNOR2X1
X_10381_ _10154_/Y _10569_/B _10575_/B VDD VSS _17876_/D AND3BX1
XFILLER_108_278 VSS VDD FILLER2
XFILLER_2_501 VDD VSS DECAPHV8
XTAP_TAPCELL_ROW_9_122 VDD VSS WELLTAP
X_12120_ _12120_/A _14230_/B _14229_/C VDD VSS _12121_/D NOR3X1
XFILLER_105_974 VDD VSS FILLER1
XFILLER_46_1101 VSS VDD FILLER2
XFILLER_81_1003 VSS VDD FILLER2
X_12051_ _18125_/Q _14056_/B VDD VSS _12249_/A NAND2X1
XFILLER_117_84 VDD VSS DECAPHV8
XFILLER_132_793 VDD VSS FILLER4
XFILLER_2_578 VDD VSS DECAPHV16
X_11002_ _11002_/A _11002_/B VDD VSS _11005_/B AND2X1
XFILLER_77_88 VDD VSS FILLER4
X_16790_ _16790_/A VDD VSS _16798_/B INVX1
X_15810_ _18779_/Q _18725_/Q VDD VSS _15850_/B XOR2X1
XFILLER_93_32 VDD VSS DECAPHV32
XTAP_TAPCELL_ROW_129_1561 VDD VSS WELLTAP
XTAP_TAPCELL_ROW_129_1572 VDD VSS WELLTAP
X_12953_ _12953_/A _14266_/B VDD VSS _13014_/A OR2X2
X_15741_ _16969_/A _15747_/B VDD VSS _15741_/Y XNOR2X1
X_11904_ _18436_/Q _11995_/B _11995_/C VDD VSS _12089_/B MIN3X1
X_18460_ _18514_/CK _18460_/D _18460_/Q VDD VSS DFFQX1
X_15672_ _15673_/A _15694_/B VDD VSS _15673_/C NAND2X1
XFILLER_60_213 VDD VSS FILLER4
XFILLER_61_725 VDD VSS FILLER4
XTAP_TAPCELL_ROW_82_1008 VDD VSS WELLTAP
X_12884_ _18986_/Q _18107_/Q VDD VSS _12994_/B OR2X2
X_17411_ _17501_/A VDD VSS _17423_/A BUFX3
X_14623_ _14626_/C _14624_/B _17455_/A VDD VSS _14624_/C OAI21X1
XFILLER_42_950 VDD VSS DECAPHV8
XFILLER_61_747 VDD VSS DECAPHV8
X_11835_ _18278_/Q _11835_/B _11835_/C VDD VSS _14255_/B XNOR3X1
X_18391_ _18461_/CK _18391_/D _18391_/Q VDD VSS DFFQX1
XFILLER_41_460 VDD VSS FILLER4
XFILLER_60_257 VDD VSS DECAPHV8
X_11766_ _11766_/A _11766_/B _11766_/C _11766_/D VDD VSS _14109_/B AOAI211X1
X_17342_ _17355_/A _17342_/B VDD VSS _19041_/D NOR2X1
X_14554_ _18525_/Q _18557_/Q _14554_/C VDD VSS _14562_/A MIN3X1
X_10717_ _17904_/Q _10717_/B VDD VSS _10718_/B XNOR2X1
X_17273_ _17271_/Y _17277_/B _17455_/A VDD VSS _19011_/D AND3BX1
X_14485_ _14485_/A _14485_/B VDD VSS _14486_/B XNOR2X1
X_13505_ _13580_/A _13580_/B _17536_/D VDD VSS _13506_/C AOI21X1
X_11697_ _11847_/A _11847_/B VDD VSS _14080_/B XNOR2X1
X_19012_ _19019_/CK _19012_/D _19012_/Q VDD VSS DFFQX1
X_16224_ _16459_/A _16521_/A _16224_/C VDD VSS _16225_/C AND3BX1
X_13436_ _13436_/A _13440_/D VDD VSS _13437_/C XNOR2X1
XFILLER_127_543 VDD VSS FILLER1
X_10648_ _17889_/Q _10648_/B _10648_/C VDD VSS _10651_/C MIN3X1
XFILLER_6_873 VDD VSS DECAPHV8
X_10579_ _17878_/Q _10579_/B _10582_/C VDD VSS _10580_/D XNOR3X1
X_16155_ _16155_/A VDD VSS _16521_/A BUFX3
X_13367_ _13532_/A _13532_/B _13532_/C VDD VSS _13446_/B AOI21X1
XTAP_TAPCELL_ROW_93_1137 VDD VSS WELLTAP
X_12318_ _12318_/A _12318_/B _12334_/C VDD VSS _12419_/B XNOR3X1
X_13298_ _13386_/A _13386_/B _13380_/C VDD VSS _14211_/B AOI21BX1
X_16086_ _18786_/Q _18732_/Q VDD VSS _16087_/A XNOR2X1
X_15106_ _15272_/A _18677_/Q VDD VSS _18650_/D AND2X1
X_12249_ _12249_/A _12249_/B _12249_/C _12249_/D VDD VSS _12352_/A AOAI211X1
X_15037_ _15037_/A _15037_/B _15037_/C _15037_/D VDD VSS _15038_/C AOAI211X1
XFILLER_69_836 VDD VSS FILLER1
XFILLER_110_421 VDD VSS DECAPHV16
XFILLER_111_966 VSS VDD FILLER2
XFILLER_68_335 VDD VSS FILLER4
XFILLER_69_847 VDD VSS FILLER1
XFILLER_110_476 VDD VSS DECAPHV8
XFILLER_3_96 VDD VSS DECAPHV32
XFILLER_83_305 VDD VSS FILLER4
XFILLER_95_154 VDD VSS DECAPHV8
X_16988_ _16988_/A _17019_/B _17019_/C _18942_/Q VDD VSS _18942_/D AO22X2
XFILLER_37_722 VDD VSS DECAPHV8
XFILLER_83_338 VDD VSS FILLER4
X_18727_ _18805_/CK _18727_/D _18727_/Q VDD VSS DFFQX1
X_15939_ _16802_/A _15939_/B _15939_/C VDD VSS _16266_/C OAI21X1
XFILLER_37_766 VDD VSS DECAPHV8
XFILLER_3_1058 VDD VSS DECAPHV32
X_09460_ _09472_/C _09460_/B VDD VSS _17374_/B AND2X1
XFILLER_51_202 VSS VDD FILLER2
XFILLER_92_894 VSS VDD FILLER2
X_18658_ _18848_/CK _18658_/D _18658_/Q VDD VSS DFFQX1
XFILLER_51_235 VDD VSS FILLER4
XFILLER_52_769 VDD VSS FILLER4
XTAP_TAPCELL_ROW_34_422 VDD VSS WELLTAP
X_09391_ _17710_/Q VDD VSS _09392_/B INVX1
X_18589_ clkload7/A _18589_/D _18589_/Q VDD VSS DFFQX1
X_17609_ _19034_/CK _17609_/D _17609_/Q VDD VSS DFFQX1
XFILLER_20_600 VDD VSS FILLER4
XTAP_TAPCELL_ROW_102_1244 VDD VSS WELLTAP
XTAP_TAPCELL_ROW_62_764 VDD VSS WELLTAP
XFILLER_20_644 VDD VSS DECAPHV8
XTAP_TAPCELL_ROW_14_190 VDD VSS WELLTAP
XFILLER_34_1093 VSS VDD FILLER2
XFILLER_121_1052 VSS VDD FILLER2
XFILLER_105_204 VDD VSS FILLER1
XFILLER_106_749 VDD VSS FILLER1
XTAP_TAPCELL_ROW_113_1373 VDD VSS WELLTAP
XFILLER_101_443 VDD VSS FILLER1
XFILLER_59_379 VDD VSS FILLER1
XFILLER_87_666 VDD VSS FILLER1
XFILLER_87_688 VDD VSS DECAPHV8
XFILLER_101_476 VDD VSS FILLER1
XFILLER_41_1042 VDD VSS DECAPHV8
X_09727_ _17627_/Q _17419_/B VDD VSS _09739_/B XOR2X1
XFILLER_27_232 VDD VSS DECAPHV16
XFILLER_103_64 VDD VSS DECAPHV16
X_09658_ _09658_/A _09658_/B _09658_/C VDD VSS _09674_/A AOI21X1
Xclkbuf_leaf_44__002_ clkload25/A VDD VSS _18480_/CK BUFX12
XFILLER_27_298 VDD VSS FILLER1
XFILLER_42_235 VDD VSS FILLER1
XFILLER_82_393 VDD VSS FILLER1
X_09589_ _17622_/Q _17414_/B VDD VSS _09591_/C XNOR2X1
X_11620_ _11621_/A _11621_/B _11621_/D _11621_/C VDD VSS _11693_/B OAOI211X1
X_11551_ _18118_/Q _11551_/B _11551_/C VDD VSS _11556_/B XNOR3X1
X_10502_ _17869_/Q _10506_/B VDD VSS _10669_/A AND2X1
XFILLER_109_532 VDD VSS DECAPHV16
X_11482_ _11483_/A _11483_/B _11483_/D _11483_/C VDD VSS _11558_/B OAOI211X1
X_14270_ _14296_/A _14270_/B _14270_/C VDD VSS _18319_/D NOR3X1
X_10433_ _17857_/Q _10433_/B VDD VSS _10434_/C NAND2X1
X_13221_ _13223_/B _13223_/A _13221_/C VDD VSS _14098_/B AOI2B1X1
X_10364_ _10364_/A _10364_/B VDD VSS _10376_/B NOR2X1
X_13152_ _14422_/B _14422_/C _13153_/A VDD VSS _13330_/A OAI21X1
XFILLER_124_568 VDD VSS DECAPHV32
XFILLER_136_395 VDD VSS DECAPHV8
XFILLER_5_0 VDD VSS DECAPHV32
XFILLER_88_32 VDD VSS DECAPHV8
X_12103_ _12103_/A _12103_/B _14380_/B VDD VSS _12104_/B MIN3X1
XFILLER_78_611 VSS VDD FILLER2
X_10295_ _10475_/C _10295_/B _10295_/C _10480_/B VDD VSS _10488_/B OAOI211X1
X_13083_ _13200_/A _14240_/B VDD VSS _13128_/B NOR2X1
X_17960_ _17961_/CK _17960_/D _17960_/Q VDD VSS DFFQX1
XFILLER_120_730 VSS VDD FILLER2
X_12034_ _12034_/A _14197_/B _12034_/C _12034_/D VDD VSS _12227_/A OAOI211X1
X_17891_ _17972_/CK _17891_/D _17891_/Q VDD VSS DFFQX1
X_16911_ _16911_/A _16913_/B VDD VSS _16930_/A NOR2X1
XFILLER_65_305 VDD VSS DECAPHV8
X_16842_ _16842_/A _16842_/B VDD VSS _16855_/A NOR2X1
XFILLER_19_733 VSS VDD FILLER2
XFILLER_92_113 VDD VSS DECAPHV8
XFILLER_93_658 VSS VDD FILLER2
X_18512_ _18514_/CK _18512_/D _18512_/Q VDD VSS DFFQX1
X_16773_ _18919_/Q _16773_/B VDD VSS _16808_/A NAND2X1
X_13985_ _13999_/A _13985_/B _14008_/C _14013_/D VDD VSS _18070_/D OAOI211X1
XFILLER_37_80 VSS VDD FILLER2
X_12936_ _13023_/A _13023_/B _13023_/C VDD VSS _14392_/B AOI21X1
X_15724_ _18889_/Q _15724_/B VDD VSS _15734_/C NOR2X1
XFILLER_34_769 VDD VSS FILLER1
X_12867_ _12979_/B _14207_/C _18263_/Q VDD VSS _12868_/D AND3BX1
X_18443_ _18470_/CK _18443_/D _18443_/Q VDD VSS DFFQX1
X_15655_ _18881_/Q _15668_/B VDD VSS _15656_/C NAND2X1
XFILLER_57_1060 VDD VSS FILLER4
X_11818_ _18408_/Q VDD VSS _11821_/A INVX1
X_18374_ _18453_/CK _18374_/D _18374_/Q VDD VSS DFFQX1
X_15586_ _18876_/Q _15592_/B VDD VSS _15591_/A XNOR2X1
X_14606_ _18537_/Q _18569_/Q VDD VSS _14611_/A XNOR2X1
XFILLER_42_780 VDD VSS FILLER1
XFILLER_57_1093 VDD VSS FILLER4
XFILLER_61_599 VDD VSS FILLER4
X_12798_ _18366_/Q _12933_/B VDD VSS _12799_/D _12798_/C NAND3X1
X_17325_ _17338_/A _17325_/B VDD VSS _19025_/D NOR2X1
X_14537_ _14539_/C _14537_/B _14537_/C VDD VSS _18522_/D AOI21X1
XFILLER_18_1088 VSS VDD FILLER2
XFILLER_30_953 VSS VDD FILLER2
X_11749_ _11803_/A _11803_/B _11803_/C VDD VSS _14195_/B AOI21X1
X_17256_ _17256_/A _17256_/B _17257_/B _17256_/D VDD VSS _19008_/D AOI31X1
X_14468_ _14468_/A _14468_/B VDD VSS _14469_/B XNOR2X1
X_17187_ _17193_/C _17190_/C VDD VSS _17188_/B XNOR2X1
X_16207_ _18788_/Q _18734_/Q VDD VSS _16245_/E AND2X1
X_14399_ _14431_/A _14399_/B _14399_/C VDD VSS _18426_/D NOR3X1
X_13419_ _13392_/A _14270_/B _14272_/B VDD VSS _13421_/C OR3BX1
X_16138_ _16165_/A _16165_/B VDD VSS _16140_/A NAND2X1
XFILLER_103_708 VDD VSS FILLER1
X_08960_ _08963_/A _08963_/B _17455_/A VDD VSS _08961_/C OAI21X1
X_16069_ _16069_/A _16069_/B _16069_/C VDD VSS _16070_/B NOR3X1
XFILLER_38_0 VDD VSS DECAPHV32
X_08891_ _17727_/Q _18516_/Q _08891_/C VDD VSS _17528_/A AOI21X1
XFILLER_25_1026 VDD VSS DECAPHV8
XFILLER_57_817 VDD VSS FILLER4
XFILLER_64_1097 VSS VDD FILLER2
XFILLER_96_485 VDD VSS FILLER1
XTAP_TAPCELL_ROW_67_823 VDD VSS WELLTAP
XFILLER_49_390 VSS VDD FILLER2
X_09512_ _17619_/Q _09524_/A VDD VSS _09514_/C XNOR2X1
XFILLER_25_725 VDD VSS FILLER1
XFILLER_92_680 VDD VSS FILLER1
XFILLER_13_909 VDD VSS FILLER1
XFILLER_24_213 VDD VSS FILLER1
XFILLER_25_747 VDD VSS DECAPHV16
XTAP_TAPCELL_ROW_47_580 VDD VSS WELLTAP
X_09443_ _17648_/Q _17441_/B VDD VSS _09474_/A NAND2BX1
XFILLER_36_1111 VDD VSS FILLER1
XFILLER_52_566 VDD VSS DECAPHV8
X_09374_ _09387_/C _09374_/B VDD VSS _17371_/B AND2X1
XFILLER_71_1013 VDD VSS DECAPHV8
XFILLER_32_290 VSS VDD FILLER2
XFILLER_20_474 VSS VDD FILLER2
XFILLER_119_852 VSS VDD FILLER2
XFILLER_4_607 VDD VSS DECAPHV32
XTAP_TAPCELL_ROW_115_1402 VDD VSS WELLTAP
XFILLER_3_128 VDD VSS DECAPHV32
XFILLER_0_813 VDD VSS DECAPHV32
XFILLER_43_1115 VDD VSS FILLER1
XFILLER_88_942 VSS VDD FILLER2
XFILLER_99_290 VDD VSS FILLER4
X_10080_ _17812_/Q _10088_/B _10083_/C VDD VSS _10277_/B XNOR3X1
XFILLER_88_964 VSS VDD FILLER2
XFILLER_101_262 VSS VDD FILLER2
XFILLER_47_327 VDD VSS DECAPHV8
XFILLER_74_113 VDD VSS FILLER4
XFILLER_28_530 VDD VSS FILLER4
XFILLER_74_157 VSS VDD FILLER2
XTAP_TAPCELL_ROW_126_1531 VDD VSS WELLTAP
XFILLER_28_574 VSS VDD FILLER2
X_10982_ _17956_/Q _10985_/A VDD VSS _10983_/B XNOR2X1
X_13770_ _18456_/Q _13786_/B _13786_/C VDD VSS _13816_/C XNOR3X1
XFILLER_43_544 VDD VSS FILLER4
XTAP_TAPCELL_ROW_17_219 VDD VSS WELLTAP
X_12721_ _12840_/A _13009_/B VDD VSS _14299_/B XNOR2X1
XFILLER_130_40 VDD VSS FILLER4
X_12652_ _12652_/A _12652_/B _12652_/C _12652_/D VDD VSS _12866_/A OAOI211X1
X_15440_ _15433_/Y _15518_/B _15483_/A VDD VSS _15575_/B MUXI2X1
XFILLER_90_44 VSS VDD FILLER2
X_11603_ _11603_/A _11603_/B _11603_/C VDD VSS _14134_/C NOR3X1
XFILLER_50_1108 VDD VSS FILLER4
X_12583_ _18443_/Q _12706_/B _12706_/C VDD VSS _12595_/C XNOR3X1
X_15371_ _18911_/Q _15390_/C VDD VSS _15372_/B NAND2X1
XFILLER_128_137 VSS VDD FILLER2
XFILLER_12_975 VDD VSS FILLER1
X_11534_ _11753_/B _11534_/B VDD VSS _11535_/C XNOR2X1
X_18090_ _18971_/CK _18090_/D _18090_/Q VDD VSS DFFQX1
X_17110_ _18017_/Q _17114_/B VDD VSS _17112_/C XNOR2X1
X_14322_ _14346_/A _14322_/B VDD VSS _18360_/D NOR2X1
XFILLER_109_340 VDD VSS FILLER1
XFILLER_8_979 VDD VSS DECAPHV32
X_11465_ _18326_/Q _14281_/B VDD VSS _11592_/B NOR2X1
X_17041_ _18004_/Q _17045_/B VDD VSS _17044_/C XNOR2X1
X_14253_ _14253_/A VDD VSS _14269_/A BUFX3
XFILLER_124_310 VDD VSS FILLER4
XFILLER_99_64 VDD VSS DECAPHV16
X_10416_ _10416_/A _10420_/C VDD VSS _10597_/B XNOR2X1
X_13204_ _18214_/Q VDD VSS _13205_/A INVX1
XFILLER_124_321 VDD VSS FILLER1
XFILLER_136_170 VDD VSS DECAPHV8
XFILLER_98_706 VDD VSS FILLER1
X_11396_ _11396_/A _11396_/B _11396_/C _11396_/D VDD VSS _11537_/A AOAI211X1
X_14184_ _14149_/Y _14184_/B _14184_/C VDD VSS _18242_/D AND3BX1
XFILLER_112_505 VDD VSS FILLER4
XFILLER_124_354 VDD VSS FILLER1
X_10347_ _10541_/A _10541_/B _10541_/D _10541_/C VDD VSS _10553_/B OAOI211X1
X_13135_ _13258_/A _13258_/B _13258_/C VDD VSS _14422_/B AOI21X1
X_18992_ _18994_/CK _18992_/D _18992_/Q VDD VSS DFFQX1
XFILLER_124_398 VDD VSS DECAPHV8
XFILLER_79_953 VDD VSS DECAPHV8
XFILLER_97_249 VDD VSS DECAPHV8
X_10278_ _17838_/Q _10278_/B _10278_/C VDD VSS _10470_/C MIN3X1
X_13066_ _13080_/A _14267_/B VDD VSS _14268_/C _13080_/C NAND3X1
X_17943_ _17993_/CK _17943_/D _17943_/Q VDD VSS DFFQX1
X_12017_ _18282_/Q VDD VSS _12120_/A INVX1
XFILLER_93_422 VDD VSS FILLER4
X_17874_ _17901_/CK _17874_/D _17874_/Q VDD VSS DFFQX1
XFILLER_93_455 VDD VSS DECAPHV8
X_16825_ _16825_/A _16825_/B VDD VSS _16827_/B XNOR2X1
XFILLER_34_500 VSS VDD FILLER2
XFILLER_59_1111 VDD VSS FILLER4
XTAP_TAPCELL_ROW_88_1069 VDD VSS WELLTAP
X_16756_ _16779_/C _16756_/B VDD VSS _16757_/C XNOR2X1
X_13968_ _14011_/A _13968_/B _14055_/C VDD VSS _18064_/D AOI21X1
XFILLER_47_894 VDD VSS FILLER4
XFILLER_94_1013 VDD VSS DECAPHV16
X_12919_ _12919_/A _12920_/C _12919_/C VDD VSS _18042_/D AOI21X1
X_15707_ _15707_/A _15707_/B _15707_/C VDD VSS _15715_/B MIN3X1
XFILLER_94_1068 VDD VSS FILLER1
XTAP_TAPCELL_ROW_44_550 VDD VSS WELLTAP
X_18426_ _18453_/CK _18426_/D _18426_/Q VDD VSS DFFQX1
X_16687_ _18829_/Q _18721_/Q VDD VSS _16723_/A XNOR2X1
X_13899_ _18459_/Q _14435_/A _14435_/B VDD VSS _13901_/C NOR3X1
XTAP_TAPCELL_ROW_72_881 VDD VSS WELLTAP
X_15638_ _15695_/A _15638_/B _15638_/C VDD VSS _15644_/B AOI21X1
X_18357_ _18381_/CK _18357_/D _18357_/Q VDD VSS DFFQX1
X_15569_ _18925_/Q _15593_/C VDD VSS _15569_/Y XNOR2X1
XFILLER_30_761 VDD VSS FILLER1
XFILLER_30_772 VDD VSS FILLER1
X_09090_ _19025_/Q _17325_/B _09090_/C VDD VSS _09094_/B MIN3X1
X_18288_ _18313_/CK _18288_/D _18288_/Q VDD VSS DFFQX1
X_17308_ _19018_/Q _17315_/B VDD VSS _17310_/B XOR2X1
XFILLER_135_608 VDD VSS FILLER1
XFILLER_31_1030 VDD VSS FILLER4
X_17239_ _19005_/Q _17315_/B VDD VSS _17241_/D XOR2X1
XFILLER_134_129 VDD VSS DECAPHV8
XFILLER_116_844 VDD VSS FILLER1
XFILLER_103_516 VDD VSS FILLER1
X_09992_ _09992_/A _09997_/C VDD VSS _10195_/A XOR2X1
XFILLER_115_387 VDD VSS FILLER1
X_08943_ _17748_/Q _18537_/Q VDD VSS _08944_/C NAND2X1
XFILLER_57_603 VDD VSS FILLER1
XFILLER_69_463 VSS VDD FILLER2
XTAP_TAPCELL_ROW_110_1343 VDD VSS WELLTAP
XFILLER_84_411 VDD VSS FILLER4
X_08874_ _16984_/A VDD VSS _16977_/A INVX3
XFILLER_57_658 VDD VSS FILLER1
XFILLER_38_861 VSS VDD FILLER2
XFILLER_37_371 VDD VSS FILLER1
XFILLER_53_820 VDD VSS FILLER4
XFILLER_71_149 VDD VSS FILLER1
XFILLER_84_499 VDD VSS DECAPHV8
XFILLER_25_566 VDD VSS FILLER1
X_09426_ _09446_/B _09426_/B VDD VSS _17441_/B XNOR2X1
XFILLER_12_216 VDD VSS DECAPHV8
XFILLER_52_396 VDD VSS DECAPHV16
XFILLER_100_32 VDD VSS DECAPHV8
XFILLER_40_558 VDD VSS DECAPHV8
XTAP_TAPCELL_ROW_121_1472 VDD VSS WELLTAP
X_09357_ _09348_/A _09357_/B VDD VSS _09373_/B NAND2BX1
X_09288_ _09288_/A _09309_/B VDD VSS _17436_/B XOR2X1
XTAP_TAPCELL_ROW_22_277 VDD VSS WELLTAP
XTAP_TAPCELL_ROW_22_288 VDD VSS WELLTAP
X_11250_ _14043_/B _14043_/C VDD VSS _11349_/C NOR2X1
XFILLER_109_96 VDD VSS DECAPHV32
XFILLER_79_205 VDD VSS FILLER1
X_10201_ _10216_/A _10213_/A _10213_/B VDD VSS _10390_/C XNOR3X1
X_11181_ _11181_/A _11181_/B _11181_/C VDD VSS _11185_/C MIN3X1
XFILLER_133_184 VSS VDD FILLER2
X_10132_ _10305_/A _10148_/B _10322_/C VDD VSS _10325_/C OR3BX1
XFILLER_0_665 VDD VSS DECAPHV8
XFILLER_47_113 VDD VSS FILLER1
X_10063_ _17809_/Q _10069_/A VDD VSS _10067_/B XOR2X1
X_14940_ _14944_/C _14941_/B _17318_/C VDD VSS _14941_/C OAI21X1
XFILLER_48_658 VSS VDD FILLER2
XFILLER_87_282 VSS VDD FILLER2
X_14871_ _18593_/Q _18625_/Q VDD VSS _14872_/C NAND2X1
XFILLER_62_105 VSS VDD FILLER2
XFILLER_63_628 VDD VSS FILLER1
XFILLER_78_1019 VDD VSS FILLER1
XFILLER_85_88 VDD VSS FILLER4
X_17590_ _17656_/CK _17590_/D _17590_/Q VDD VSS DFFQX1
X_16610_ _16784_/A _18773_/Q VDD VSS _16627_/C NAND2X1
X_13822_ _13853_/D _13853_/C VDD VSS _13823_/B NAND2BX1
XFILLER_62_138 VDD VSS FILLER1
X_16541_ _16541_/A _16541_/B _16541_/C VDD VSS _16587_/B OA21X2
X_13753_ _14341_/B _18377_/Q VDD VSS _13809_/A NAND2BX1
XFILLER_43_341 VDD VSS FILLER1
XFILLER_71_650 VDD VSS FILLER1
XFILLER_90_469 VSS VDD FILLER2
X_10965_ _10965_/A _10965_/B _10965_/C VDD VSS _10970_/C MIN3X1
X_12704_ _12916_/B _12704_/B _12704_/C VDD VSS _12807_/A AOI2B1X1
XFILLER_44_886 VDD VSS FILLER4
X_10896_ _10896_/A _10896_/B VDD VSS _10897_/C NAND2X1
X_16472_ _18051_/Q _18661_/Q VDD VSS _16474_/C XOR2X1
X_13684_ _13751_/A _14401_/B VDD VSS _13728_/B NOR2X1
X_12635_ _12846_/A _12845_/B VDD VSS _14235_/B XNOR2X1
X_18211_ _18292_/CK _18211_/D _18211_/Q VDD VSS DFFQX1
X_15423_ _18866_/Q _15423_/B VDD VSS _15426_/C NOR2X1
XFILLER_106_1131 VDD VSS FILLER1
XFILLER_12_772 VDD VSS FILLER1
XFILLER_12_783 VDD VSS FILLER1
XFILLER_8_732 VDD VSS DECAPHV32
XTAP_TAPCELL_ROW_5_74 VDD VSS WELLTAP
X_12566_ _12566_/A _14060_/B _12566_/C _12566_/D VDD VSS _12783_/B AO31X2
X_18142_ _18195_/CK _18142_/D _18142_/Q VDD VSS DFFQX1
X_15354_ wire35/Y VDD VSS _16657_/D BUFX3
XFILLER_11_282 VDD VSS FILLER1
X_11517_ _18353_/Q _14312_/B VDD VSS _11657_/B NOR2X1
X_14305_ _14372_/A _14305_/B VDD VSS _18346_/D AND2X1
XFILLER_7_253 VDD VSS DECAPHV16
X_12497_ _18312_/Q VDD VSS _12616_/A INVX1
X_18073_ _18837_/CK _18073_/D output5/A VDD VSS DFFQX1
X_15285_ _15286_/A _18853_/Q VDD VSS _18826_/D AND2X1
XFILLER_116_129 VDD VSS DECAPHV8
X_11448_ _11448_/A _11448_/B _11478_/C _11448_/D VDD VSS _11556_/A OAOI211X1
X_17024_ _17026_/A _17024_/B VDD VSS _17025_/B XOR2X1
X_14236_ _14236_/A _14236_/B _14236_/C VDD VSS _18288_/D NOR3X1
XFILLER_98_514 VSS VDD FILLER2
X_11379_ _11379_/A _11383_/A _14072_/B VDD VSS _14101_/B XNOR3X1
X_14167_ _14149_/Y _14167_/B _14167_/C VDD VSS _18226_/D AND3BX1
XFILLER_113_836 VDD VSS FILLER1
X_13118_ _18214_/Q _13205_/B _13206_/C VDD VSS _13383_/B XNOR3X1
XFILLER_98_569 VSS VDD FILLER2
X_18975_ _18982_/CK _18975_/D _18975_/Q VDD VSS DFFQX1
X_14098_ _14129_/A _14098_/B VDD VSS _18163_/D NOR2X1
XFILLER_61_1034 VDD VSS FILLER1
XFILLER_61_1056 VDD VSS DECAPHV8
X_13049_ _14364_/B _13157_/C _18395_/Q VDD VSS _13265_/C AND3BX1
X_17926_ _18003_/CK _17926_/D _17926_/Q VDD VSS DFFQX1
XFILLER_61_1089 VSS VDD FILLER2
XTAP_TAPCELL_ROW_77_940 VDD VSS WELLTAP
X_17857_ _17861_/CK _17857_/D _17857_/Q VDD VSS DFFQX1
XFILLER_66_477 VDD VSS FILLER1
X_16808_ _16808_/A _16808_/B VDD VSS _16815_/C _16808_/C NAND3X1
XFILLER_19_371 VDD VSS FILLER1
XFILLER_19_393 VSS VDD FILLER2
XFILLER_35_842 VDD VSS FILLER1
XFILLER_81_425 VSS VDD FILLER2
X_17788_ _17867_/CK _17788_/D _17788_/Q VDD VSS DFFQX1
XFILLER_50_801 VSS VDD FILLER2
X_16739_ _18918_/Q _16740_/B VDD VSS _16770_/A NAND2X1
XFILLER_22_514 VDD VSS DECAPHV8
XFILLER_22_569 VSS VDD FILLER2
XFILLER_34_396 VDD VSS FILLER1
XFILLER_61_182 VDD VSS FILLER4
X_09211_ _09223_/A _09211_/B VDD VSS _17399_/B XNOR2X1
X_18409_ _18436_/CK _18409_/D _18409_/Q VDD VSS DFFQX1
X_09142_ _19028_/Q _17328_/B VDD VSS _09146_/B XOR2X1
XFILLER_129_991 VDD VSS FILLER1
XFILLER_135_427 VDD VSS DECAPHV8
X_09073_ _17571_/Q _17360_/B VDD VSS _09074_/B XNOR2X1
XFILLER_128_490 VDD VSS FILLER1
XFILLER_1_407 VDD VSS DECAPHV32
XFILLER_104_825 VDD VSS DECAPHV16
XFILLER_115_184 VSS VDD FILLER2
XFILLER_116_696 VDD VSS FILLER1
XFILLER_118_1068 VDD VSS FILLER1
X_09975_ _10184_/A _10184_/B VDD VSS _10187_/B XNOR2X1
X_08926_ _17744_/Q _18533_/Q _08926_/C VDD VSS _08931_/C AO21X2
XFILLER_69_282 VDD VSS FILLER4
XFILLER_58_989 VDD VSS FILLER1
XFILLER_73_904 VDD VSS DECAPHV16
XFILLER_85_764 VDD VSS DECAPHV16
XFILLER_44_138 VDD VSS FILLER1
XFILLER_53_650 VDD VSS FILLER1
XTAP_TAPCELL_ROW_27_347 VDD VSS WELLTAP
XFILLER_111_64 VDD VSS DECAPHV16
XFILLER_13_503 VSS VDD FILLER2
XFILLER_26_886 VDD VSS DECAPHV16
XFILLER_52_171 VDD VSS FILLER4
XTAP_TAPCELL_ROW_55_678 VDD VSS WELLTAP
X_10750_ _17909_/Q _10750_/B VDD VSS _10753_/A NOR2BX1
X_09409_ _09409_/A _09409_/B _17446_/A VDD VSS _09410_/B OAI21X1
X_10681_ _17898_/Q _10681_/B _10681_/C VDD VSS _10818_/C XNOR3X1
XFILLER_40_377 VDD VSS FILLER1
XFILLER_71_79 VDD VSS DECAPHV8
X_12420_ _12530_/B _14233_/C _18285_/Q VDD VSS _12421_/D AND3BX1
X_12351_ _18128_/Q _14059_/B VDD VSS _12554_/A NAND2X1
XFILLER_14_1080 VDD VSS FILLER4
XTAP_TAPCELL_ROW_134_1630 VDD VSS WELLTAP
X_11302_ _18218_/Q _14158_/B VDD VSS _11421_/B NOR2X1
X_12282_ _18465_/Q VDD VSS _14471_/A INVX1
X_15070_ _15072_/C _15070_/B _15070_/C VDD VSS _18636_/D AOI21X1
XFILLER_105_0 VDD VSS DECAPHV32
XFILLER_49_1132 VDD VSS FILLER4
XFILLER_4_267 VDD VSS DECAPHV32
XFILLER_5_779 VDD VSS DECAPHV32
X_11233_ _18964_/Q _18085_/Q VDD VSS _11240_/D XOR2X1
X_14021_ _17043_/A _18969_/Q VDD VSS _18090_/D AND2X1
XFILLER_101_1094 VDD VSS FILLER1
XFILLER_134_471 VSS VDD FILLER2
XFILLER_84_1045 VDD VSS FILLER1
XFILLER_0_440 VDD VSS DECAPHV8
XFILLER_122_655 VDD VSS FILLER1
XFILLER_96_32 VDD VSS DECAPHV8
X_11164_ _17990_/Q _11164_/B VDD VSS _11165_/C NAND2X1
XFILLER_121_176 VDD VSS DECAPHV8
XFILLER_48_400 VSS VDD FILLER2
XFILLER_48_411 VDD VSS FILLER4
XFILLER_67_208 VDD VSS DECAPHV16
X_10115_ _17816_/Q VDD VSS _10121_/A INVX1
X_11095_ _17977_/Q _11099_/B VDD VSS _11096_/B XNOR2X1
X_18760_ _18815_/CK _18760_/D _18760_/Q VDD VSS DFFQX1
X_15972_ _15972_/A _15972_/B _15972_/C _15972_/D VDD VSS _16042_/B AOAI211X1
XFILLER_49_945 VSS VDD FILLER2
X_10046_ _10046_/A _10235_/A _10046_/C _10046_/D VDD VSS _10054_/A AOAI211X1
X_18691_ _18853_/CK _18691_/D _18691_/Q VDD VSS DFFQX1
X_17711_ _17716_/CK _17711_/D _17711_/Q VDD VSS DFFQX1
X_14923_ _18605_/Q _18637_/Q VDD VSS _14929_/A XNOR2X1
XFILLER_36_617 VSS VDD FILLER2
XFILLER_48_466 VSS VDD FILLER2
XFILLER_49_978 VDD VSS FILLER1
X_17642_ _17706_/CK _17642_/D _17642_/Q VDD VSS DFFQX1
XFILLER_17_831 VDD VSS FILLER1
XFILLER_21_1040 VDD VSS FILLER1
XFILLER_36_639 VDD VSS DECAPHV8
XTAP_TAPCELL_ROW_74_910 VDD VSS WELLTAP
X_14854_ _18590_/Q _18622_/Q VDD VSS _14861_/C NOR2X1
XFILLER_56_1103 VSS VDD FILLER2
XFILLER_90_255 VDD VSS FILLER1
XTAP_TAPCELL_ROW_85_1039 VDD VSS WELLTAP
X_11997_ _18437_/Q VDD VSS _12089_/A INVX1
X_17573_ _17669_/CK _17573_/D _17573_/Q VDD VSS DFFQX1
X_14785_ _18574_/Q VDD VSS _14787_/A INVX1
X_13805_ _18379_/Q _14343_/B VDD VSS _13845_/A XOR2X1
XFILLER_16_374 VSS VDD FILLER2
XFILLER_45_80 VDD VSS DECAPHV8
X_10948_ _17949_/Q _10951_/B VDD VSS _10949_/B XNOR2X1
X_16524_ _16524_/A _16531_/C VDD VSS _16529_/B XOR2X1
X_13736_ _13816_/A _14459_/B VDD VSS _13771_/B NOR2X1
XFILLER_32_856 VSS VDD FILLER2
XFILLER_43_171 VDD VSS FILLER1
X_16455_ _18910_/Q _16527_/B VDD VSS _16456_/C NAND2X1
X_10879_ _17935_/Q _10879_/B _10879_/C VDD VSS _10881_/A MIN3X1
X_15406_ _18863_/Q _16784_/A VDD VSS _15874_/B NOR2X1
X_13667_ _13667_/A _14427_/B VDD VSS _13725_/C _13667_/C NAND3X1
XFILLER_129_221 VDD VSS DECAPHV32
X_12618_ _18313_/Q VDD VSS _12633_/A INVX1
X_16386_ _16934_/A _16386_/B VDD VSS _16417_/A NAND2X1
X_13598_ _13598_/A _13598_/B _13598_/C VDD VSS _13605_/B XNOR3X1
XFILLER_8_562 VDD VSS FILLER4
XFILLER_8_573 VDD VSS DECAPHV16
X_12549_ _12550_/A _12550_/B _12550_/D _12550_/C VDD VSS _12669_/B OAOI211X1
X_18125_ _18152_/CK _18125_/D _18125_/Q VDD VSS DFFQX1
X_15337_ _18862_/Q _15337_/B _15337_/C VDD VSS _18862_/D AO21X2
XANTENNA_1 _17533_/A VDD VSS ANTENNA2
XTAP_TAPCELL_ROW_96_1168 VDD VSS WELLTAP
X_18056_ _18851_/CK _18056_/D _18056_/Q VDD VSS DFFQX1
X_15268_ _15299_/A _18836_/Q VDD VSS _18809_/D AND2X1
X_17007_ _18954_/Q _17007_/B VDD VSS _17008_/C NAND2X1
X_14219_ _14219_/A _14219_/B VDD VSS _14220_/B XNOR2X1
XFILLER_113_600 VSS VDD FILLER2
XFILLER_125_482 VDD VSS DECAPHV8
X_15199_ _15281_/A _18768_/Q VDD VSS _18741_/D AND2X1
XFILLER_113_644 VSS VDD FILLER2
XFILLER_101_817 VSS VDD FILLER2
XFILLER_113_677 VDD VSS FILLER4
XFILLER_58_219 VDD VSS FILLER4
XFILLER_98_377 VDD VSS DECAPHV8
X_09760_ _15326_/C _09760_/B _09783_/B VDD VSS _17783_/D NOR3X1
X_18958_ _18958_/CK _18958_/D _18958_/Q VDD VSS DFFQX1
XFILLER_20_0 VDD VSS DECAPHV32
XFILLER_39_433 VDD VSS FILLER4
X_09691_ _17689_/Q _17485_/B VDD VSS _09692_/C NOR2X1
X_17909_ _17913_/CK _17909_/D _17909_/Q VDD VSS DFFQX1
XFILLER_6_1067 VSS VDD FILLER2
X_18889_ _18959_/CK _18889_/D _18889_/Q VDD VSS DFFQX1
XFILLER_35_650 VDD VSS FILLER1
XTAP_TAPCELL_ROW_24_306 VDD VSS WELLTAP
XFILLER_50_620 VDD VSS FILLER1
XFILLER_50_642 VDD VSS DECAPHV16
XTAP_TAPCELL_ROW_105_1275 VDD VSS WELLTAP
XTAP_TAPCELL_ROW_52_637 VDD VSS WELLTAP
XTAP_TAPCELL_ROW_52_648 VDD VSS WELLTAP
XFILLER_10_506 VDD VSS FILLER4
XTAP_TAPCELL_ROW_80_979 VDD VSS WELLTAP
XFILLER_37_1080 VDD VSS DECAPHV16
XFILLER_109_928 VSS VDD FILLER2
X_09125_ _09125_/A _09125_/B _17429_/B VDD VSS _09151_/B MIN3X1
X_09056_ _17570_/Q _17359_/B _09056_/C VDD VSS _09096_/B OAI21X1
XFILLER_131_441 VSS VDD FILLER2
XFILLER_132_975 VDD VSS FILLER1
XFILLER_89_333 VDD VSS FILLER1
XFILLER_132_986 VDD VSS DECAPHV8
XFILLER_77_517 VDD VSS FILLER1
X_09958_ _09935_/Y _10164_/B _10174_/B VDD VSS _17821_/D AND3BX1
XFILLER_131_1021 VSS VDD FILLER2
XFILLER_131_496 VDD VSS DECAPHV16
X_08909_ _17737_/Q _18526_/Q VDD VSS _17551_/C NOR2X1
XFILLER_57_252 VDD VSS FILLER1
XFILLER_85_561 VDD VSS DECAPHV16
X_09889_ _17788_/Q VDD VSS _09896_/A INVX1
XFILLER_17_116 VDD VSS FILLER1
XFILLER_73_723 VSS VDD FILLER2
X_11920_ _18280_/Q VDD VSS _12173_/A INVX1
X_11851_ _18175_/Q _12025_/A _12025_/B VDD VSS _11853_/C XNOR3X1
X_10802_ _17920_/Q _10802_/B _10802_/C VDD VSS _10808_/C MIN3X1
X_11782_ _11863_/A _11954_/A _11787_/B VDD VSS _11784_/C XNOR3X1
X_14570_ _14573_/A _14573_/B _17229_/A VDD VSS _14571_/C OAI21X1
XFILLER_13_322 VDD VSS DECAPHV16
XFILLER_53_491 VDD VSS FILLER1
X_10733_ _10733_/A _10733_/B VDD VSS _10734_/C NAND2X1
X_13521_ _18451_/Q _14425_/B _14425_/C VDD VSS _13528_/C OR3BX1
XFILLER_41_686 VDD VSS DECAPHV32
XFILLER_16_1131 VDD VSS FILLER4
X_10664_ _10669_/B _10664_/B VDD VSS _10668_/B NOR2X1
X_16240_ _16286_/A _16286_/B VDD VSS _16240_/Y _16286_/C NAND3X1
X_13452_ _13453_/B _13453_/C _18398_/Q VDD VSS _13457_/B AOI21X1
XFILLER_103_1134 VSS VDD FILLER2
X_10595_ _17880_/Q _10597_/B _10597_/C VDD VSS _10734_/B XNOR3X1
X_12403_ _12403_/A _12403_/B _14385_/B VDD VSS _12404_/B MIN3X1
X_16171_ _16257_/C _16257_/D VDD VSS _16171_/Y XOR2X1
X_13383_ _13383_/A _13383_/B _13383_/C _13383_/D VDD VSS _14183_/B AOAI211X1
XFILLER_126_235 VDD VSS DECAPHV32
XFILLER_127_747 VDD VSS DECAPHV16
XFILLER_5_532 VDD VSS DECAPHV16
X_12334_ _12334_/A _12334_/B _12334_/C _12334_/D VDD VSS _12528_/A OAOI211X1
X_15122_ _18693_/Q VDD VSS _16681_/B INVX1
XTAP_TAPCELL_ROW_2_42 VDD VSS WELLTAP
X_15053_ _19010_/Q VDD VSS _17269_/A INVX1
X_12265_ _18180_/Q _12343_/B _12346_/C VDD VSS _12522_/B XNOR3X1
Xoutput3 output3/A VDD VSS data_out[0] BUFX3
X_14004_ _14011_/A _14004_/B _14055_/C VDD VSS _18078_/D AOI21X1
XFILLER_123_953 VDD VSS DECAPHV16
X_11216_ _18027_/Q _18026_/Q _18028_/Q _18029_/Q VDD VSS _11221_/C AND4X2
X_12196_ _18439_/Q VDD VSS _12283_/A INVX1
XFILLER_123_997 VSS VDD FILLER2
XFILLER_95_314 VDD VSS FILLER1
X_11147_ _11147_/A _11150_/C VDD VSS _17092_/B XNOR2X1
X_18812_ _18840_/CK _18812_/D _18812_/Q VDD VSS DFFQX1
XFILLER_96_859 VDD VSS FILLER4
X_18743_ _18821_/CK _18743_/D _18743_/Q VDD VSS DFFQX1
XFILLER_23_1124 VDD VSS DECAPHV8
X_11078_ _17974_/Q _11081_/B VDD VSS _11082_/B XOR2X1
X_15955_ _15955_/A _15955_/B _15955_/C _15955_/D VDD VSS _16038_/B AOAI211X1
XFILLER_37_937 VSS VDD FILLER2
XFILLER_63_211 VDD VSS FILLER1
X_10029_ _10029_/A _10029_/B VDD VSS _10035_/D NOR2X1
X_18674_ _18837_/CK _18674_/D _18674_/Q VDD VSS DFFQX1
X_15886_ _18036_/Q _18646_/Q VDD VSS _15912_/D NAND2X1
X_14906_ _14906_/A _15054_/A _14906_/C VDD VSS _14909_/C MIN3X1
XFILLER_17_650 VDD VSS FILLER1
X_17625_ _19052_/CK _17625_/D _17625_/Q VDD VSS DFFQX1
X_14837_ _14840_/C _14838_/B _17544_/C VDD VSS _14838_/C OAI21X1
XFILLER_16_160 VDD VSS FILLER4
XFILLER_45_970 VSS VDD FILLER2
XFILLER_63_288 VDD VSS FILLER1
X_17556_ _17557_/A _17557_/B _17561_/C VDD VSS _17557_/C OAI21X1
XFILLER_16_193 VDD VSS DECAPHV8
X_16507_ _18823_/Q _18715_/Q VDD VSS _16549_/A AND2X1
X_14768_ _14769_/A _14769_/B _14769_/D _14769_/C VDD VSS _14771_/C AOI211X1
XFILLER_108_1056 VDD VSS DECAPHV8
X_17487_ _17523_/A _17487_/B VDD VSS _17691_/D AND2X1
X_14699_ _14699_/A _14850_/A _14699_/C VDD VSS _14702_/C MIN3X1
X_13719_ _13733_/A _14493_/B _13733_/C VDD VSS _14494_/B AOI21X1
XFILLER_108_1089 VSS VDD FILLER2
XFILLER_31_185 VDD VSS FILLER1
X_16438_ _16478_/D _16478_/B VDD VSS _16439_/B NOR2BX1
X_16369_ _16390_/A _16390_/B _16369_/C _16369_/D VDD VSS _16370_/D AOI31X1
X_18108_ _18247_/CK _18108_/D _18108_/Q VDD VSS DFFQX1
XFILLER_118_769 VSS VDD FILLER2
XFILLER_8_392 VDD VSS DECAPHV16
XFILLER_105_419 VDD VSS FILLER1
XFILLER_126_780 VDD VSS FILLER4
X_18039_ _18838_/CK _18039_/D _18039_/Q VDD VSS DFFQX1
XFILLER_113_441 VDD VSS FILLER1
XFILLER_67_1084 VDD VSS FILLER1
XFILLER_28_1068 VDD VSS FILLER1
XFILLER_99_675 VDD VSS DECAPHV8
X_09812_ _09812_/A _09943_/B VDD VSS _17793_/D NOR2X1
XFILLER_100_113 VDD VSS DECAPHV16
XFILLER_101_647 VDD VSS FILLER4
XFILLER_59_539 VDD VSS DECAPHV16
XFILLER_28_926 VSS VDD FILLER2
XFILLER_67_561 VDD VSS DECAPHV8
XFILLER_74_509 VSS VDD FILLER2
XFILLER_86_358 VDD VSS DECAPHV8
XTAP_TAPCELL_ROW_57_707 VDD VSS WELLTAP
X_09743_ _17521_/B _17723_/Q _09743_/C VDD VSS _09770_/C MIN3X1
XFILLER_54_200 VDD VSS FILLER1
XFILLER_67_583 VDD VSS DECAPHV8
XTAP_TAPCELL_ROW_107_1304 VDD VSS WELLTAP
X_09674_ _09674_/A _09687_/B VDD VSS _17383_/B XNOR2X1
XFILLER_36_49 VDD VSS DECAPHV16
XFILLER_74_1000 VDD VSS DECAPHV8
XTAP_TAPCELL_ROW_37_464 VDD VSS WELLTAP
XTAP_TAPCELL_ROW_65_795 VDD VSS WELLTAP
XFILLER_109_747 VSS VDD FILLER2
XTAP_TAPCELL_ROW_118_1433 VDD VSS WELLTAP
X_09108_ _17636_/Q _17429_/B VDD VSS _09109_/B XNOR2X1
XFILLER_108_235 VDD VSS DECAPHV16
XFILLER_109_769 VDD VSS DECAPHV8
XFILLER_136_555 VDD VSS FILLER1
X_10380_ _10561_/A _10561_/B _10562_/C _10561_/C VDD VSS _10575_/B OAI211X1
XFILLER_11_1083 VDD VSS FILLER1
XFILLER_136_588 VDD VSS DECAPHV32
XTAP_TAPCELL_ROW_9_123 VDD VSS WELLTAP
X_09039_ _17602_/Q _17392_/B VDD VSS _09040_/B XNOR2X1
XFILLER_2_546 VDD VSS DECAPHV32
X_12050_ _12255_/A _12161_/B VDD VSS _14056_/B XNOR2X1
XFILLER_104_452 VDD VSS FILLER1
XFILLER_117_96 VDD VSS DECAPHV32
XFILLER_132_761 VDD VSS FILLER1
XFILLER_132_783 VDD VSS FILLER4
XFILLER_89_152 VDD VSS DECAPHV8
X_11001_ _17959_/Q _11001_/B VDD VSS _11005_/A NOR2BX1
XFILLER_131_282 VDD VSS DECAPHV32
XFILLER_89_196 VDD VSS DECAPHV8
XFILLER_58_561 VDD VSS DECAPHV8
XFILLER_93_818 VSS VDD FILLER2
XFILLER_45_200 VDD VSS FILLER1
XFILLER_85_380 VDD VSS FILLER4
XFILLER_92_328 VDD VSS DECAPHV8
XTAP_TAPCELL_ROW_129_1562 VDD VSS WELLTAP
X_12952_ _14363_/A _14363_/B VDD VSS _13018_/B NOR2X1
X_15740_ _18936_/Q VDD VSS _16969_/A INVX1
XFILLER_73_531 VDD VSS FILLER1
X_11903_ _18410_/Q _11984_/B _12104_/C VDD VSS _11995_/C XNOR3X1
X_15671_ _15671_/A _15671_/B _15671_/C VDD VSS _15689_/B OAI21X1
XFILLER_33_406 VDD VSS FILLER1
XFILLER_93_88 VDD VSS FILLER4
X_12883_ _18134_/Q VDD VSS _13103_/A INVX1
X_17410_ _17410_/A _17410_/B VDD VSS _17619_/D NOR2X1
X_14622_ _18540_/Q _18572_/Q VDD VSS _14624_/B XOR2X1
XFILLER_61_759 VSS VDD FILLER2
X_11834_ _18304_/Q VDD VSS _14285_/A INVX1
X_18390_ _18417_/CK _18390_/D _18390_/Q VDD VSS DFFQX1
XFILLER_13_141 VDD VSS FILLER1
XFILLER_53_1128 VDD VSS DECAPHV8
X_11765_ _11765_/A _11765_/B _11765_/C _11765_/D VDD VSS _11929_/A OAOI211X1
X_17341_ _17446_/A _17341_/B VDD VSS _19040_/D AND2X1
X_14553_ _14553_/A _14554_/C _14553_/C VDD VSS _18525_/D AOI21X1
XFILLER_13_174 VDD VSS FILLER4
XFILLER_13_185 VDD VSS FILLER1
X_10716_ _10723_/A _10723_/B VDD VSS _10718_/A NOR2X1
X_11696_ _11696_/A _14078_/B _11696_/C _11696_/D VDD VSS _11847_/A AOAI211X1
X_17272_ _17281_/A _17272_/B _17281_/B _17272_/D VDD VSS _17277_/B OAI211X1
X_14484_ _18473_/Q _14484_/B VDD VSS _14485_/B XNOR2X1
X_13504_ _18504_/Q _13504_/B _13583_/C VDD VSS _13580_/B XOR3X1
X_10647_ _17890_/Q _10651_/B VDD VSS _10649_/A XNOR2X1
X_19011_ _19011_/CK _19011_/D _19011_/Q VDD VSS DFFQX1
X_16223_ _16376_/B _16222_/Y _16521_/A VDD VSS _16225_/B MUXI2X1
X_13435_ _18477_/Q _13516_/A _13516_/B VDD VSS _13440_/D XNOR3X1
XFILLER_127_533 VSS VDD FILLER2
XFILLER_42_81 VDD VSS FILLER1
XFILLER_9_189 VDD VSS DECAPHV32
X_10578_ _17877_/Q _10583_/B VDD VSS _10580_/C _10583_/C NAND3X1
X_16154_ _16194_/A _16194_/B _16567_/A VDD VSS _16187_/A AOI21X1
X_13366_ _14368_/B _13453_/C _18398_/Q VDD VSS _13532_/C AND3BX1
XFILLER_115_728 VDD VSS DECAPHV16
XFILLER_5_362 VDD VSS DECAPHV8
XTAP_TAPCELL_ROW_93_1138 VDD VSS WELLTAP
X_12317_ _18258_/Q VDD VSS _12318_/A INVX1
X_13297_ _13297_/A _13297_/B _13297_/C _13297_/D VDD VSS _13386_/B AOAI211X1
X_16085_ _18785_/Q _18731_/Q VDD VSS _16089_/D AND2X1
X_15105_ _15299_/A _18676_/Q VDD VSS _18649_/D AND2X1
X_12248_ _14057_/A _14057_/B _18126_/Q VDD VSS _12249_/D OAI21X1
X_15036_ _15037_/A _15037_/B _15037_/D _15037_/C VDD VSS _15039_/C AOI211X1
XFILLER_3_64 VDD VSS DECAPHV16
X_12179_ _18308_/Q _12179_/B _12179_/C VDD VSS _12213_/C OR3BX1
XFILLER_37_701 VDD VSS FILLER1
XFILLER_84_818 VDD VSS FILLER4
XFILLER_96_689 VDD VSS FILLER1
X_16987_ _16987_/A _17006_/B _16987_/C VDD VSS _18941_/D OAI21X1
XFILLER_37_734 VSS VDD FILLER2
XFILLER_3_1026 VDD VSS DECAPHV32
XFILLER_77_892 VDD VSS FILLER1
X_18726_ _18780_/CK _18726_/D _18726_/Q VDD VSS DFFQX1
X_15938_ _16021_/A _16021_/B _16107_/A _15938_/D VDD VSS _16266_/B OAOI211X1
XFILLER_58_1006 VDD VSS DECAPHV8
XFILLER_64_542 VDD VSS FILLER1
XFILLER_64_553 VDD VSS DECAPHV16
XFILLER_76_391 VDD VSS FILLER1
X_18657_ _18848_/CK _18657_/D _18657_/Q VDD VSS DFFQX1
Xwire26 wire26/A VDD VSS wire26/Y BUFX4
XFILLER_24_417 VDD VSS FILLER1
XFILLER_25_929 VDD VSS FILLER1
XFILLER_36_255 VSS VDD FILLER2
XFILLER_52_715 VSS VDD FILLER2
XFILLER_91_350 VSS VDD FILLER2
X_17608_ _19034_/CK _17608_/D _17608_/Q VDD VSS DFFQX1
X_15869_ _15872_/B _15869_/B VDD VSS _15871_/B XNOR2X1
XFILLER_18_992 VDD VSS FILLER4
XFILLER_33_940 VDD VSS DECAPHV8
XFILLER_36_288 VDD VSS FILLER1
XFILLER_91_383 VDD VSS DECAPHV16
XTAP_TAPCELL_ROW_34_423 VDD VSS WELLTAP
X_09390_ _09366_/A _09390_/B _09390_/C VDD VSS _09396_/A AOI2B1X1
X_18588_ clkload8/A _18588_/D _18588_/Q VDD VSS DFFQX1
XTAP_TAPCELL_ROW_102_1245 VDD VSS WELLTAP
XTAP_TAPCELL_ROW_62_765 VDD VSS WELLTAP
X_17539_ _17540_/A _17540_/B _17544_/C VDD VSS _17540_/C OAI21X1
XFILLER_20_656 VSS VDD FILLER2
XTAP_TAPCELL_ROW_14_191 VDD VSS WELLTAP
XFILLER_118_533 VDD VSS FILLER1
XFILLER_20_689 VDD VSS FILLER1
XFILLER_34_1072 VDD VSS FILLER1
XFILLER_69_1113 VSS VDD FILLER2
XFILLER_69_1135 VDD VSS FILLER1
XFILLER_106_717 VDD VSS FILLER1
XFILLER_106_739 VDD VSS DECAPHV8
XFILLER_133_503 VDD VSS FILLER1
XFILLER_133_547 VDD VSS FILLER1
XFILLER_87_601 VDD VSS FILLER4
XFILLER_87_612 VDD VSS FILLER4
XTAP_TAPCELL_ROW_113_1374 VDD VSS WELLTAP
XFILLER_113_271 VDD VSS DECAPHV8
XFILLER_113_282 VDD VSS FILLER4
XFILLER_41_1010 VDD VSS FILLER1
XFILLER_41_1054 VSS VDD FILLER2
XFILLER_74_328 VDD VSS DECAPHV16
XFILLER_86_166 VDD VSS DECAPHV16
X_09726_ _09751_/B _09726_/B VDD VSS _17419_/B XNOR2X1
XFILLER_103_32 VDD VSS DECAPHV32
XFILLER_83_840 VDD VSS FILLER4
XFILLER_28_789 VDD VSS FILLER1
XFILLER_55_586 VDD VSS FILLER1
XFILLER_76_1106 VDD VSS FILLER1
XFILLER_82_361 VDD VSS DECAPHV16
X_09657_ _17624_/Q _17416_/B VDD VSS _09658_/C NOR2X1
XFILLER_55_597 VDD VSS DECAPHV8
XFILLER_82_383 VDD VSS FILLER1
X_09588_ _09588_/A _09602_/B VDD VSS _17414_/B XNOR2X1
XFILLER_42_258 VDD VSS FILLER1
XFILLER_70_556 VDD VSS DECAPHV8
X_11550_ _11672_/A _11672_/B _11672_/C VDD VSS _11572_/B AOI21X1
X_10501_ _15326_/C _10669_/B _10664_/B VDD VSS _17895_/D NOR3X1
XFILLER_109_500 VDD VSS DECAPHV16
XFILLER_10_166 VSS VDD FILLER2
XFILLER_7_649 VSS VDD FILLER2
X_11481_ _11546_/A _11556_/A _11562_/B VDD VSS _11483_/C XNOR3X1
X_13220_ _18136_/Q _14068_/B VDD VSS _13221_/C NOR2BX1
XFILLER_100_1104 VDD VSS FILLER1
XFILLER_109_566 VDD VSS FILLER1
XFILLER_12_40 VDD VSS FILLER4
XFILLER_6_137 VSS VDD FILLER2
X_10432_ _17857_/Q _10433_/B VDD VSS _10434_/B NOR2X1
XFILLER_124_514 VDD VSS FILLER4
XFILLER_128_40 VDD VSS FILLER4
XFILLER_136_363 VDD VSS DECAPHV32
XFILLER_3_811 VDD VSS DECAPHV16
X_10363_ _10539_/A _10553_/B _10551_/C _10363_/D VDD VSS _10561_/A OAOI211X1
X_13151_ _13151_/A _13151_/B _14451_/B VDD VSS _13344_/B MIN3X1
XFILLER_88_44 VSS VDD FILLER2
X_12102_ _12102_/A _12102_/B _12102_/C VDD VSS _14380_/B XNOR3X1
X_13082_ _18265_/Q _14209_/B VDD VSS _13200_/A NOR2BX1
XFILLER_78_601 VSS VDD FILLER2
XFILLER_97_409 VDD VSS DECAPHV8
X_10294_ _10299_/A _10294_/B _10296_/B VDD VSS _10480_/B XNOR3X1
X_12033_ _12146_/B _14170_/C _18229_/Q VDD VSS _12034_/D AND3BX1
X_16910_ _16910_/A _16910_/B VDD VSS _16913_/B NAND2X1
X_17890_ _17941_/CK _17890_/D _17890_/Q VDD VSS DFFQX1
X_16841_ _16841_/A _16841_/B VDD VSS _16842_/A NAND2X1
XFILLER_93_648 VSS VDD FILLER2
X_16772_ _16772_/A _16772_/B VDD VSS _18919_/D NAND2X1
XFILLER_20_1105 VSS VDD FILLER2
XFILLER_46_531 VDD VSS DECAPHV16
XFILLER_92_125 VSS VDD FILLER2
X_18511_ _18514_/CK _18511_/D _18511_/Q VDD VSS DFFQX1
X_15723_ _18889_/Q _15724_/B VDD VSS _15734_/B NAND2X1
X_13984_ _18947_/Q _13984_/B VDD VSS _13985_/B XOR2X1
XFILLER_46_553 VDD VSS FILLER1
XFILLER_80_309 VSS VDD FILLER2
X_12935_ _18394_/Q _12935_/B _12947_/C VDD VSS _13023_/C XNOR3X1
XFILLER_18_299 VDD VSS FILLER4
X_12866_ _12866_/A _12866_/B _12866_/C _12866_/D VDD VSS _14207_/C OAI211X1
X_18442_ _18470_/CK _18442_/D _18442_/Q VDD VSS DFFQX1
X_15654_ _15666_/B _15654_/B VDD VSS _17000_/A XNOR2X1
XFILLER_18_1012 VSS VDD FILLER2
XFILLER_61_556 VSS VDD FILLER2
X_11817_ _18410_/Q VDD VSS _11984_/A INVX1
X_18373_ _18453_/CK _18373_/D _18373_/Q VDD VSS DFFQX1
X_15585_ _15469_/B _15584_/Y _15651_/A VDD VSS _15592_/B MUXI2X1
X_14605_ _14696_/A _14605_/B VDD VSS _18536_/D NOR2X1
XFILLER_15_984 VDD VSS FILLER4
XFILLER_42_770 VSS VDD FILLER2
XFILLER_53_80 VDD VSS DECAPHV8
X_12797_ _12933_/B _12798_/C _18366_/Q VDD VSS _12799_/C AOI21X1
X_17324_ _17396_/A VDD VSS _17338_/A BUFX3
X_14536_ _14539_/C _14537_/B _17544_/C VDD VSS _14537_/C OAI21X1
XFILLER_105_1026 VDD VSS FILLER1
XFILLER_119_308 VSS VDD FILLER2
XFILLER_18_1067 VSS VDD FILLER2
X_11748_ _18226_/Q _11748_/B _11763_/C VDD VSS _11803_/C XNOR3X1
XFILLER_128_820 VDD VSS FILLER1
X_11679_ _11803_/A _11803_/B VDD VSS _11713_/B NAND2X1
X_17255_ _17256_/A _17256_/B _17257_/B _17255_/D VDD VSS _17256_/D AOAI211X1
X_14467_ _18463_/Q _14467_/B VDD VSS _14468_/B XNOR2X1
XFILLER_127_330 VDD VSS FILLER4
XFILLER_128_853 VSS VDD FILLER2
XTAP_TAPCELL_ROW_11_150 VDD VSS WELLTAP
X_17186_ _17193_/A _17193_/B _17195_/A VDD VSS _17190_/C OAI21X1
X_16206_ _16206_/A VDD VSS _16547_/D BUFX3
X_14398_ _14431_/A _14398_/B _14398_/C VDD VSS _18425_/D NOR3X1
X_13418_ _18293_/Q _14242_/B _14270_/B _14272_/B VDD VSS _13421_/B AOAI211X1
XFILLER_128_886 VDD VSS FILLER1
XFILLER_6_671 VDD VSS DECAPHV16
X_16137_ _18786_/Q _18732_/Q VDD VSS _16165_/A NAND2X1
X_13349_ _18423_/Q _14395_/B VDD VSS _13354_/C _14395_/C NAND3X1
XFILLER_102_208 VSS VDD FILLER2
X_16068_ _16069_/A _16069_/B _16069_/C VDD VSS _16119_/B OAI21X1
XFILLER_25_1016 VDD VSS FILLER4
XFILLER_69_623 VDD VSS FILLER1
X_08890_ _17526_/A _17526_/B VDD VSS _08891_/C NOR2X1
X_15019_ _18625_/Q _19003_/Q VDD VSS _15020_/C NAND2X1
XFILLER_69_678 VDD VSS FILLER1
XFILLER_97_976 VDD VSS FILLER1
XFILLER_84_626 VSS VDD FILLER2
XTAP_TAPCELL_ROW_67_824 VDD VSS WELLTAP
XFILLER_56_339 VSS VDD FILLER2
XFILLER_65_840 VSS VDD FILLER2
XFILLER_83_136 VDD VSS FILLER4
X_09511_ _09553_/B _09511_/B VDD VSS _09524_/A NOR2BX1
X_18709_ _18844_/CK _18709_/D _18709_/Q VDD VSS DFFQX1
XFILLER_52_545 VDD VSS FILLER1
XFILLER_91_180 VDD VSS FILLER1
XTAP_TAPCELL_ROW_19_250 VDD VSS WELLTAP
XTAP_TAPCELL_ROW_47_581 VDD VSS WELLTAP
X_09442_ _17616_/Q _17407_/B VDD VSS _09459_/A NAND2BX1
XFILLER_12_409 VSS VDD FILLER2
XFILLER_40_718 VDD VSS DECAPHV8
X_09373_ _09373_/A _09373_/B VDD VSS _09374_/B _09373_/C NAND3X1
XFILLER_123_1115 VDD VSS FILLER1
XTAP_TAPCELL_ROW_115_1403 VDD VSS WELLTAP
XFILLER_121_506 VDD VSS DECAPHV8
XFILLER_114_580 VDD VSS DECAPHV8
XFILLER_133_399 VDD VSS FILLER1
XFILLER_88_932 VSS VDD FILLER2
XFILLER_0_858 VDD VSS DECAPHV32
XFILLER_102_753 VDD VSS FILLER4
XFILLER_87_431 VSS VDD FILLER2
XFILLER_102_797 VDD VSS FILLER1
XFILLER_71_810 VDD VSS FILLER4
XTAP_TAPCELL_ROW_126_1532 VDD VSS WELLTAP
X_09709_ _19049_/Q _17350_/B VDD VSS _09710_/A NAND2BX1
X_10981_ _10981_/A _10981_/B _10981_/C VDD VSS _10986_/C MIN3X1
XFILLER_43_512 VDD VSS FILLER4
XFILLER_83_681 VDD VSS DECAPHV16
X_12720_ _18367_/Q VDD VSS _12834_/A INVX1
XFILLER_15_236 VDD VSS DECAPHV8
XFILLER_15_247 VDD VSS FILLER4
XFILLER_15_258 VDD VSS DECAPHV16
XFILLER_43_556 VSS VDD FILLER2
X_12651_ _12651_/A _14177_/B _14177_/C VDD VSS _12652_/D NOR3X1
XFILLER_70_386 VDD VSS FILLER1
X_11602_ _11602_/A _14133_/B _11603_/C VDD VSS _14134_/B AOI21BX1
XFILLER_8_903 VDD VSS DECAPHV16
X_12582_ _18417_/Q _12712_/B _12603_/C VDD VSS _12706_/C XNOR3X1
X_15370_ _18911_/Q _15390_/C VDD VSS _15374_/B XOR2X1
XFILLER_11_464 VDD VSS FILLER1
XFILLER_11_475 VDD VSS FILLER1
XFILLER_135_0 VDD VSS DECAPHV32
X_11533_ _11533_/A _14163_/B _11533_/C VDD VSS _11753_/B MIN3X1
X_14321_ _14377_/A _14321_/B VDD VSS _18359_/D AND2X1
X_11464_ _18300_/Q _11522_/B _11467_/C VDD VSS _14281_/B XNOR3X1
X_17040_ _18003_/Q _17040_/B VDD VSS _17044_/A NAND2X1
X_14252_ _14252_/A _14252_/B VDD VSS _18302_/D NOR2X1
XFILLER_7_468 VDD VSS DECAPHV32
XFILLER_87_1010 VDD VSS FILLER4
XFILLER_99_32 VDD VSS DECAPHV32
X_10415_ _17854_/Q _10415_/B _10415_/C VDD VSS _10420_/C XNOR3X1
X_13203_ _13305_/A _14210_/B VDD VSS _13380_/B NOR2X1
X_11395_ _18142_/Q _14075_/B VDD VSS _11396_/D _14075_/C NAND3X1
X_14183_ _14149_/Y _14183_/B _14183_/C VDD VSS _18241_/D AND3BX1
XFILLER_3_641 VDD VSS DECAPHV8
X_10346_ _10359_/A _10351_/B _10356_/B VDD VSS _10541_/C XNOR3X1
X_13134_ _13163_/A _13138_/B _13265_/D VDD VSS _13258_/C XNOR3X1
X_18991_ _18994_/CK _18991_/D _18991_/Q VDD VSS DFFQX1
X_10277_ _17837_/Q _10277_/B VDD VSS _10278_/C OR2X2
X_13065_ _18290_/Q _14239_/B VDD VSS _13080_/A NAND2X1
X_17942_ _17993_/CK _17942_/D _17942_/Q VDD VSS DFFQX1
X_12016_ _12173_/B _12016_/B _12016_/C _12016_/D VDD VSS _12210_/B AOAI211X1
X_17873_ _17901_/CK _17873_/D _17873_/Q VDD VSS DFFQX1
XFILLER_38_306 VDD VSS DECAPHV16
XFILLER_38_328 VDD VSS DECAPHV16
X_16824_ _18922_/Q _16828_/B VDD VSS _16825_/B XOR2X1
XFILLER_65_136 VDD VSS DECAPHV8
XFILLER_93_434 VDD VSS FILLER1
XFILLER_94_968 VDD VSS FILLER4
XFILLER_94_979 VDD VSS FILLER1
XFILLER_0_32 VDD VSS DECAPHV8
XFILLER_81_607 VDD VSS FILLER4
X_16755_ _18858_/Q _18696_/Q VDD VSS _16756_/B XOR2X1
X_13967_ _17501_/A VDD VSS _14055_/C BUFX3
XFILLER_46_383 VDD VSS DECAPHV8
X_12918_ _12919_/A _12920_/C _14423_/A VDD VSS _12919_/C OAI21X1
X_16686_ _16686_/A _16686_/B VDD VSS _16728_/B OR2X2
X_15706_ _15737_/A _17010_/A _15706_/C VDD VSS _18886_/D OAI21X1
XFILLER_62_876 VSS VDD FILLER2
X_18425_ _18478_/CK _18425_/D _18425_/Q VDD VSS DFFQX1
X_15637_ _15695_/A _15637_/B VDD VSS _15638_/C NOR2X1
X_13898_ wire26/Y _13898_/B _13898_/C _13898_/D VDD VSS _14435_/B OAOI211X1
XTAP_TAPCELL_ROW_44_551 VDD VSS WELLTAP
XTAP_TAPCELL_ROW_72_882 VDD VSS WELLTAP
X_12849_ _12849_/A _12849_/B _12849_/C _12849_/D VDD VSS _13010_/A AOAI211X1
X_18356_ _18381_/CK _18356_/D _18356_/Q VDD VSS DFFQX1
X_15568_ _18924_/Q _15568_/B VDD VSS _15593_/C NOR2BX1
XFILLER_9_96 VDD VSS FILLER1
X_18287_ _18313_/CK _18287_/D _18287_/Q VDD VSS DFFQX1
X_17307_ _19017_/Q _17316_/B _17307_/C VDD VSS _17312_/C MIN3X1
X_15499_ _15401_/Y _15498_/Y _15526_/A VDD VSS _15613_/B MUXI2X1
X_14519_ _18518_/Q _18550_/Q _14519_/C VDD VSS _14522_/B AOI21X1
XFILLER_31_1020 VSS VDD FILLER2
X_17238_ _19004_/Q _17316_/B _17238_/C _17238_/D VDD VSS _17241_/C AOI211X1
XFILLER_127_160 VDD VSS DECAPHV16
XFILLER_128_661 VDD VSS DECAPHV8
XFILLER_115_322 VSS VDD FILLER2
XFILLER_116_834 VDD VSS DECAPHV8
XFILLER_50_0 VDD VSS DECAPHV32
XFILLER_66_1116 VDD VSS FILLER1
X_17169_ _18992_/Q _17232_/B VDD VSS _17176_/D NAND2BX1
XFILLER_88_206 VSS VDD FILLER2
X_09991_ _17800_/Q _09999_/A VDD VSS _09997_/C XOR2X1
Xclkbuf_leaf_43__002_ clkload25/A VDD VSS _18453_/CK BUFX12
XFILLER_115_399 VDD VSS FILLER1
XFILLER_9_1021 VSS VDD FILLER2
X_08942_ _08944_/A _08944_/B _08942_/C VDD VSS _17748_/D AOI21X1
XFILLER_9_1043 VDD VSS DECAPHV16
XTAP_TAPCELL_ROW_110_1333 VDD VSS WELLTAP
XTAP_TAPCELL_ROW_110_1344 VDD VSS WELLTAP
XFILLER_29_328 VSS VDD FILLER2
XFILLER_97_795 VSS VDD FILLER2
X_08873_ _15793_/B VDD VSS _172_/E BUFX3
XFILLER_38_840 VDD VSS FILLER1
XFILLER_25_501 VSS VDD FILLER2
XFILLER_72_629 VDD VSS FILLER4
XFILLER_84_467 VDD VSS DECAPHV32
XFILLER_25_523 VDD VSS FILLER4
XFILLER_37_394 VDD VSS FILLER4
XFILLER_65_670 VDD VSS FILLER4
XFILLER_25_545 VDD VSS FILLER1
XFILLER_44_49 VDD VSS DECAPHV32
XFILLER_53_854 VDD VSS FILLER4
XFILLER_80_640 VDD VSS DECAPHV16
X_09425_ _17680_/Q _17475_/B VDD VSS _09426_/B XNOR2X1
XFILLER_13_718 VDD VSS DECAPHV16
XFILLER_52_364 VDD VSS FILLER4
XFILLER_52_386 VDD VSS FILLER4
XFILLER_100_44 VSS VDD FILLER2
XTAP_TAPCELL_ROW_121_1473 VDD VSS WELLTAP
X_09356_ _17613_/Q _17404_/B VDD VSS _09373_/A NAND2BX1
XFILLER_20_250 VSS VDD FILLER2
X_09287_ _17675_/Q _17470_/B VDD VSS _09309_/B XNOR2X1
XTAP_TAPCELL_ROW_22_278 VDD VSS WELLTAP
XFILLER_107_823 VDD VSS FILLER1
XFILLER_119_650 VDD VSS FILLER1
XFILLER_119_672 VDD VSS FILLER4
XFILLER_4_416 VSS VDD FILLER2
XFILLER_5_928 VSS VDD FILLER2
XFILLER_109_64 VDD VSS DECAPHV16
X_10200_ _17826_/Q VDD VSS _10216_/A INVX1
X_11180_ _17993_/Q VDD VSS _11181_/A INVX1
XFILLER_122_848 VDD VSS FILLER4
X_10131_ _17817_/Q _10131_/B VDD VSS _10305_/A NAND2X1
XFILLER_0_633 VDD VSS DECAPHV32
XFILLER_47_1071 VDD VSS FILLER4
X_10062_ _17808_/Q _10062_/B VDD VSS _10064_/A NOR2BX1
XFILLER_48_615 VDD VSS FILLER4
XFILLER_48_626 VDD VSS FILLER1
XFILLER_88_784 VDD VSS FILLER4
XFILLER_125_96 VDD VSS DECAPHV32
XFILLER_76_979 VDD VSS FILLER1
X_14870_ _14872_/A _14872_/B _14870_/C VDD VSS _18593_/D AOI21X1
XFILLER_78_1009 VSS VDD FILLER2
X_13821_ _14496_/B _14496_/C _13821_/C VDD VSS _13853_/C OAI21X1
XFILLER_44_810 VDD VSS DECAPHV8
XFILLER_90_448 VSS VDD FILLER2
X_16540_ _18851_/Q _18689_/Q VDD VSS _16541_/C NAND2X1
X_13752_ _13806_/A _13752_/B VDD VSS _14341_/B XOR2X1
XFILLER_16_556 VSS VDD FILLER2
XFILLER_44_854 VSS VDD FILLER2
X_10964_ _17952_/Q VDD VSS _10965_/A INVX1
X_12703_ _12916_/A _14480_/B VDD VSS _12704_/C NOR2X1
XFILLER_43_375 VDD VSS DECAPHV32
X_10895_ _17938_/Q VDD VSS _10897_/A INVX1
X_18210_ _18261_/CK _18210_/D _18210_/Q VDD VSS DFFQX1
X_16471_ _18050_/Q _18660_/Q VDD VSS _16474_/A AND2X1
X_13683_ _18402_/Q _14372_/B VDD VSS _13751_/A AND2X1
XTAP_TAPCELL_ROW_41_510 VDD VSS WELLTAP
X_12634_ _12634_/A _14296_/B _12723_/C _12634_/D VDD VSS _12840_/A OAOI211X1
X_15422_ _18866_/Q _15423_/B VDD VSS _15455_/B AND2X1
XFILLER_15_1026 VDD VSS FILLER1
XFILLER_8_700 VDD VSS DECAPHV32
XTAP_TAPCELL_ROW_5_75 VDD VSS WELLTAP
X_12565_ _18983_/Q _18104_/Q VDD VSS _12566_/D NOR2X1
X_18141_ _18966_/CK _18141_/D _18141_/Q VDD VSS DFFQX1
X_15353_ _18863_/Q _16784_/A _18864_/Q VDD VSS wire35/A NOR3BX1P5
XFILLER_54_1097 VDD VSS DECAPHV8
XFILLER_7_221 VDD VSS DECAPHV32
X_11516_ _18327_/Q _11592_/B _11519_/C VDD VSS _14312_/B XNOR3X1
X_18072_ _18837_/CK _18072_/D output4/A VDD VSS DFFQX1
X_14304_ _14243_/Y _14304_/B _14304_/C VDD VSS _18345_/D AND3BX1
XFILLER_8_788 VSS VDD FILLER2
X_12496_ _18311_/Q _14262_/B VDD VSS _12499_/C _14262_/C NAND3X1
X_17023_ _17026_/C _17026_/B VDD VSS _17024_/B NOR2BX1
X_15284_ _15313_/A _18852_/Q VDD VSS _18825_/D AND2X1
XFILLER_50_81 VDD VSS FILLER4
X_11447_ _18117_/Q _14048_/B VDD VSS _11448_/D _14048_/C AND3X2
X_14235_ _15300_/A _14235_/B VDD VSS _18287_/D AND2X1
XFILLER_4_950 VDD VSS DECAPHV16
X_11378_ _18194_/Q _11378_/B _14132_/B VDD VSS _11531_/A MIN3X1
X_14166_ _14191_/A _14166_/B VDD VSS _18225_/D NOR2X1
XFILLER_124_174 VDD VSS DECAPHV32
X_10329_ _10498_/B _10329_/B _10329_/C _10329_/D VDD VSS _10513_/B OAOI211X1
X_13117_ _18188_/Q _13209_/B _13213_/C VDD VSS _13206_/C XNOR3X1
X_18974_ _18982_/CK _18974_/D _18974_/Q VDD VSS DFFQX1
X_14097_ _14372_/A _14097_/B VDD VSS _18162_/D AND2X1
X_13048_ _13159_/A _14362_/B VDD VSS _13157_/C _13159_/C NAND3X1
X_17925_ _18003_/CK _17925_/D _17925_/Q VDD VSS DFFQX1
XFILLER_67_968 VDD VSS FILLER4
XFILLER_78_294 VDD VSS FILLER4
XTAP_TAPCELL_ROW_49_610 VDD VSS WELLTAP
XTAP_TAPCELL_ROW_77_941 VDD VSS WELLTAP
X_17856_ _17861_/CK _17856_/D _17856_/Q VDD VSS DFFQX1
XFILLER_38_158 VSS VDD FILLER2
XFILLER_54_607 VDD VSS DECAPHV8
X_17787_ _17867_/CK _17787_/D _17787_/Q VDD VSS DFFQX1
X_16807_ _18921_/Q _16813_/B VDD VSS _16815_/B XOR2X1
X_16738_ _16738_/A _16775_/B VDD VSS _16740_/B XNOR2X1
X_14999_ _15000_/A _15001_/C _17554_/C VDD VSS _15000_/C OAI21X1
X_16669_ _16711_/A _16669_/B VDD VSS _16670_/C NAND2X1
XFILLER_22_537 VDD VSS FILLER4
XFILLER_98_0 VDD VSS DECAPHV32
X_09210_ _17640_/Q _17433_/B VDD VSS _09211_/B XOR2X1
X_18408_ _18408_/CK _18408_/D _18408_/Q VDD VSS DFFQX1
X_09141_ _09148_/A _09148_/B VDD VSS _17328_/B XNOR2X1
X_18339_ _18340_/CK _18339_/D _18339_/Q VDD VSS DFFQX1
X_09072_ _09097_/B _09072_/B VDD VSS _17360_/B XNOR2X1
XFILLER_103_358 VDD VSS DECAPHV8
XFILLER_118_1036 VDD VSS FILLER1
X_09974_ _09986_/A _09986_/B VDD VSS _10184_/B XOR2X1
X_08925_ _14361_/A VDD VSS _09218_/A BUFX3
XFILLER_85_754 VDD VSS FILLER1
XFILLER_29_147 VDD VSS FILLER4
XFILLER_58_979 VDD VSS DECAPHV8
XFILLER_84_231 VDD VSS FILLER1
XFILLER_44_128 VDD VSS DECAPHV8
XFILLER_73_949 VDD VSS DECAPHV8
XFILLER_25_342 VDD VSS FILLER1
XTAP_TAPCELL_ROW_27_337 VDD VSS WELLTAP
XTAP_TAPCELL_ROW_27_348 VDD VSS WELLTAP
XFILLER_111_32 VDD VSS DECAPHV32
XFILLER_25_375 VDD VSS DECAPHV16
XFILLER_38_1037 VDD VSS FILLER4
XTAP_TAPCELL_ROW_55_679 VDD VSS WELLTAP
XFILLER_125_1007 VSS VDD FILLER2
XFILLER_41_857 VDD VSS DECAPHV16
XFILLER_9_508 VDD VSS FILLER4
X_09408_ _09409_/A _09409_/B VDD VSS _09437_/B AND2X1
X_10680_ _10680_/A _10680_/B _10680_/C VDD VSS _10681_/B AOI21X1
XFILLER_9_519 VDD VSS DECAPHV32
X_09339_ _17741_/Q _17709_/Q VDD VSS _09340_/B XNOR2X1
XFILLER_126_417 VDD VSS FILLER1
XFILLER_127_929 VDD VSS FILLER1
X_12350_ _12453_/A _12361_/C VDD VSS _14059_/B XNOR2X1
XFILLER_107_631 VSS VDD FILLER2
XFILLER_5_747 VDD VSS DECAPHV32
XTAP_TAPCELL_ROW_134_1631 VDD VSS WELLTAP
X_11301_ _18192_/Q _11304_/B _14129_/B VDD VSS _14158_/B XNOR3X1
X_12281_ _12281_/A _12281_/B _14474_/B VDD VSS _12479_/B MIN3X1
XFILLER_20_40 VDD VSS FILLER1
XFILLER_4_235 VDD VSS DECAPHV32
X_11232_ _11240_/A _11240_/B _11240_/C VDD VSS _11289_/A AOI21X1
X_14020_ _17059_/C _18968_/Q VDD VSS _18089_/D AND2X1
XFILLER_136_40 VDD VSS FILLER4
XFILLER_1_920 VDD VSS DECAPHV8
X_11163_ _11205_/A _17109_/B VDD VSS _18016_/D NOR2X1
XFILLER_122_645 VDD VSS DECAPHV8
XFILLER_45_1019 VDD VSS FILLER4
XFILLER_96_44 VSS VDD FILLER2
X_10114_ _10114_/A _10299_/B VDD VSS _17841_/D NOR2X1
XFILLER_122_689 VDD VSS FILLER1
XFILLER_1_997 VDD VSS DECAPHV16
X_11094_ _11094_/A _11094_/B _11094_/C VDD VSS _11099_/C OA21X2
X_15971_ _15997_/D VDD VSS _15972_/D INVX1
XFILLER_0_485 VDD VSS DECAPHV8
XFILLER_88_592 VDD VSS FILLER4
X_10045_ _10707_/A _10242_/B VDD VSS _17831_/D AND2X1
X_18690_ _18852_/CK _18690_/D _18690_/Q VDD VSS DFFQX1
X_17710_ _17710_/CK _17710_/D _17710_/Q VDD VSS DFFQX1
X_14922_ _14924_/C _14922_/B _14922_/C VDD VSS _18604_/D AOI21X1
XFILLER_29_82 VDD VSS FILLER4
XFILLER_64_905 VDD VSS FILLER1
XFILLER_75_242 VDD VSS FILLER1
XFILLER_75_264 VDD VSS DECAPHV8
X_17641_ _17669_/CK _17641_/D _17641_/Q VDD VSS DFFQX1
X_14853_ _18589_/Q _18621_/Q _14853_/C VDD VSS _14861_/A MIN3X1
XFILLER_21_1063 VSS VDD FILLER2
XFILLER_64_949 VDD VSS FILLER1
XFILLER_75_297 VDD VSS DECAPHV8
XFILLER_90_212 VDD VSS FILLER1
XTAP_TAPCELL_ROW_74_911 VDD VSS WELLTAP
X_13804_ _18352_/Q _14311_/B _14342_/A VDD VSS _14343_/B AO21X2
XFILLER_1_1135 VDD VSS FILLER1
XFILLER_91_768 VSS VDD FILLER2
X_11996_ _11996_/A _11996_/B _14438_/B VDD VSS _14468_/A MIN3X1
X_17572_ _17669_/CK _17572_/D _17572_/Q VDD VSS DFFQX1
X_14784_ _18575_/Q _18607_/Q VDD VSS _14789_/A XOR2X1
XFILLER_17_898 VSS VDD FILLER2
X_10947_ _10947_/A _10947_/B _10947_/C VDD VSS _10951_/C MIN3X1
X_16523_ _16225_/B _16522_/Y _16800_/A VDD VSS _16531_/C MUXI2X1
X_13735_ _18455_/Q _14430_/B VDD VSS _13816_/A AND2X1
XFILLER_16_397 VDD VSS FILLER4
X_16454_ _16490_/A _16454_/B VDD VSS _16456_/B XOR2X1
X_13666_ _13667_/A _14427_/B _13667_/C VDD VSS _14429_/B AOI21X1
X_10878_ _10878_/A VDD VSS _10879_/B INVX1
X_12617_ _12617_/A _12617_/B _12617_/C _12617_/D VDD VSS _12726_/B AOAI211X1
X_15405_ _15501_/B _15401_/Y _15526_/A VDD VSS _15421_/B MUXI2X1
XFILLER_12_581 VSS VDD FILLER2
XFILLER_40_890 VDD VSS DECAPHV16
X_18124_ _18978_/CK _18124_/D _18124_/Q VDD VSS DFFQX1
X_16385_ _16424_/A _16424_/B VDD VSS _16386_/B NAND2X1
X_13597_ _13597_/A _13597_/B _13597_/C _13597_/D VDD VSS _14427_/B AOAI211X1
XFILLER_117_417 VDD VSS FILLER1
XFILLER_129_277 VSS VDD FILLER2
XFILLER_61_80 VDD VSS DECAPHV8
X_12548_ _12661_/A _12680_/A _12667_/B VDD VSS _12550_/C XNOR3X1
X_15336_ _18859_/Q _172_/E _15784_/A _15336_/D VDD VSS _15337_/C NOR4BX1
XANTENNA_2 _17533_/A VDD VSS ANTENNA2
X_12479_ _18493_/Q _12479_/B _12479_/C VDD VSS _12588_/B MIN3X1
X_18055_ _18851_/CK _18055_/D _18055_/Q VDD VSS DFFQX1
X_15267_ _15295_/A _18835_/Q VDD VSS _18808_/D AND2X1
XFILLER_125_450 VDD VSS FILLER1
XTAP_TAPCELL_ROW_96_1169 VDD VSS WELLTAP
X_17006_ _17006_/A _17006_/B _17006_/C VDD VSS _18953_/D OAI21X1
X_14218_ _14253_/A VDD VSS _14252_/A BUFX3
XFILLER_113_612 VDD VSS FILLER4
XFILLER_4_780 VDD VSS DECAPHV8
X_15198_ _15281_/A _18767_/Q VDD VSS _18740_/D AND2X1
XFILLER_98_356 VSS VDD FILLER2
X_14149_ _14361_/A VDD VSS _14149_/Y BUFX3
XFILLER_112_166 VDD VSS FILLER4
X_18957_ _18959_/CK _18957_/D _18957_/Q VDD VSS DFFQX1
XFILLER_100_328 VDD VSS FILLER4
X_09690_ _09690_/A _09690_/B VDD VSS _09716_/A NAND2X1
X_17908_ _17908_/CK _17908_/D _17908_/Q VDD VSS DFFQX1
XFILLER_13_0 VDD VSS DECAPHV32
X_18888_ _18958_/CK _18888_/D _18888_/Q VDD VSS DFFQX1
XFILLER_54_415 VSS VDD FILLER2
XFILLER_54_426 VDD VSS FILLER1
XFILLER_54_437 VDD VSS DECAPHV8
XFILLER_94_584 VDD VSS FILLER1
X_17839_ _17865_/CK _17839_/D _17839_/Q VDD VSS DFFQX1
XFILLER_54_459 VSS VDD FILLER2
XFILLER_81_256 VDD VSS FILLER4
XFILLER_81_278 VDD VSS FILLER1
XTAP_TAPCELL_ROW_24_307 VDD VSS WELLTAP
XTAP_TAPCELL_ROW_105_1276 VDD VSS WELLTAP
XTAP_TAPCELL_ROW_52_638 VDD VSS WELLTAP
XFILLER_22_356 VDD VSS FILLER4
X_09124_ _17636_/Q VDD VSS _09125_/A INVX1
X_09055_ _09076_/A _09076_/B VDD VSS _09056_/C NAND2X1
XFILLER_135_269 VDD VSS DECAPHV8
XFILLER_132_932 VDD VSS DECAPHV8
XFILLER_106_32 VDD VSS DECAPHV8
XFILLER_132_998 VDD VSS DECAPHV32
X_09957_ _10157_/A _10150_/C _10158_/B _10157_/B VDD VSS _10174_/B AO211X2
X_08908_ _17547_/A _17547_/B _08908_/C VDD VSS _17551_/B OA21X2
XFILLER_18_607 VDD VSS FILLER4
XFILLER_85_540 VSS VDD FILLER2
X_09888_ _09888_/A _09888_/B _09888_/C VDD VSS _10093_/B MIN3X1
XFILLER_58_787 VSS VDD FILLER2
XFILLER_73_768 VDD VSS FILLER1
X_11850_ _11850_/A _14109_/B _11850_/C _11850_/D VDD VSS _12025_/A AOAI211X1
XFILLER_14_813 VDD VSS FILLER1
X_10801_ _14310_/C _10936_/B VDD VSS _17946_/D AND2X1
X_11781_ _18122_/Q VDD VSS _11863_/A INVX1
X_10732_ _17906_/Q VDD VSS _10734_/A INVX1
X_13520_ _18452_/Q _13597_/A _13597_/B VDD VSS _13528_/D XNOR3X1
XFILLER_13_367 VDD VSS FILLER4
XFILLER_14_879 VDD VSS FILLER4
XFILLER_16_1110 VSS VDD FILLER2
XFILLER_40_142 VDD VSS DECAPHV16
XFILLER_41_654 VSS VDD FILLER2
XFILLER_40_164 VDD VSS FILLER1
XFILLER_51_1012 VDD VSS FILLER4
XFILLER_90_1072 VDD VSS FILLER1
X_10663_ _14310_/C _10802_/B VDD VSS _17920_/D AND2X1
X_13451_ _14367_/A _14367_/B _14367_/C VDD VSS _13453_/B OAI21X1
X_10594_ _10594_/A _10594_/B _10594_/C _10594_/D VDD VSS _10597_/C AOAI211X1
X_12402_ _18388_/Q _12402_/B _12402_/C VDD VSS _14385_/B XNOR3X1
X_16170_ _18842_/Q _18680_/Q VDD VSS _16257_/D XOR2X1
X_13382_ _18215_/Q _13405_/A _13382_/C VDD VSS _13383_/D XOR3X1
XFILLER_12_1029 VDD VSS FILLER1
XFILLER_5_500 VDD VSS DECAPHV32
X_12333_ _12422_/C _14173_/B _14173_/C VDD VSS _12334_/D NOR3X1
X_15121_ _15318_/A _18692_/Q VDD VSS _18665_/D AND2X1
XFILLER_114_409 VSS VDD FILLER2
XTAP_TAPCELL_ROW_2_43 VDD VSS WELLTAP
X_15052_ _18633_/Q _19011_/Q VDD VSS _15056_/A XOR2X1
X_12264_ _18154_/Q _12264_/B _12352_/D VDD VSS _12346_/C XNOR3X1
Xoutput4 output4/A VDD VSS data_out[10] BUFX3
X_14003_ _14005_/B _14013_/A _14003_/C VDD VSS _14004_/B OR3BX1
X_11215_ _18027_/Q _18026_/Q _18028_/Q _18029_/Q VDD VSS _11217_/B AOI31X1
X_12195_ _18465_/Q _14472_/A _14471_/B VDD VSS _12398_/B MIN3X1
XFILLER_123_976 VDD VSS FILLER1
XFILLER_96_838 VDD VSS FILLER1
X_11146_ _17987_/Q _11149_/B VDD VSS _11150_/C XNOR2X1
X_18811_ _18838_/CK _18811_/D _18811_/Q VDD VSS DFFQX1
XFILLER_0_260 VDD VSS DECAPHV8
XFILLER_23_1103 VDD VSS FILLER1
XFILLER_23_1114 VSS VDD FILLER2
X_11077_ _17973_/Q _11077_/B _11077_/C VDD VSS _11079_/A MIN3X1
X_18742_ _18850_/CK _18742_/D _18742_/Q VDD VSS DFFQX1
X_15954_ _15955_/A _15955_/B _15955_/D _15955_/C VDD VSS _15957_/B AO211X2
XFILLER_48_253 VDD VSS FILLER1
X_10028_ _10114_/A _10232_/B VDD VSS _17829_/D NOR2X1
X_14905_ _18632_/Q VDD VSS _15054_/A INVX1
XFILLER_64_724 VSS VDD FILLER2
XFILLER_76_573 VDD VSS DECAPHV8
X_18673_ _18808_/CK _18673_/D _18673_/Q VDD VSS DFFQX1
X_15885_ _15885_/A _15885_/B _15885_/C _15885_/D VDD VSS _15912_/B AOAI211X1
XFILLER_48_297 VDD VSS FILLER1
XFILLER_5_1090 VDD VSS DECAPHV16
XFILLER_64_768 VSS VDD FILLER2
XFILLER_91_543 VDD VSS FILLER1
X_17624_ _17656_/CK _17624_/D _17624_/Q VDD VSS DFFQX1
X_14836_ _18586_/Q _18618_/Q VDD VSS _14838_/B XOR2X1
XFILLER_16_150 VDD VSS FILLER4
XFILLER_45_982 VSS VDD FILLER2
XFILLER_91_576 VDD VSS DECAPHV8
X_17555_ _17555_/A _17555_/B _17555_/C VDD VSS _17739_/D AOI21X1
X_14767_ _18571_/Q _18603_/Q VDD VSS _14769_/D XNOR2X1
X_11979_ _12011_/A _12011_/B _12175_/C VDD VSS _14290_/B XNOR3X1
X_16506_ _16545_/C _16506_/B _16506_/C VDD VSS _16518_/B AOI21X1
X_13718_ _13776_/A _13718_/B _13784_/D VDD VSS _13733_/C XNOR3X1
XFILLER_20_805 VSS VDD FILLER2
X_17486_ _17499_/A _17486_/B VDD VSS _17690_/D NOR2X1
X_14698_ _18588_/Q VDD VSS _14850_/A INVX1
X_16437_ _18849_/Q _18687_/Q VDD VSS _16478_/B NOR2X1
X_13649_ _13649_/A _13649_/B _13649_/C _13649_/D VDD VSS _14493_/C OAI211X1
X_16368_ _16390_/A _16390_/B _16369_/C _16757_/A VDD VSS _16369_/D AOAI211X1
XFILLER_117_225 VDD VSS FILLER1
XFILLER_118_737 VDD VSS DECAPHV32
XFILLER_8_360 VDD VSS DECAPHV32
X_18107_ _18985_/CK _18107_/D _18107_/Q VDD VSS DFFQX1
X_15319_ _17182_/D _18058_/Q VDD VSS _18857_/D AND2X1
XFILLER_133_718 VDD VSS FILLER1
X_18038_ _18838_/CK _18038_/D _18038_/Q VDD VSS DFFQX1
X_16299_ _16554_/A _16299_/B _16299_/C VDD VSS _16374_/B AOI21X1
XFILLER_132_206 VDD VSS DECAPHV16
XFILLER_98_131 VDD VSS FILLER1
XFILLER_99_643 VDD VSS FILLER1
XFILLER_113_464 VDD VSS FILLER1
XFILLER_114_987 VSS VDD FILLER2
XFILLER_28_1058 VDD VSS DECAPHV8
X_09811_ _09821_/C _09811_/B VDD VSS _09943_/B OR2X2
X_09742_ _17756_/Q _17724_/Q VDD VSS _09744_/A XNOR2X1
XFILLER_39_220 VDD VSS FILLER1
XFILLER_39_253 VDD VSS FILLER4
XFILLER_95_860 VDD VSS FILLER4
XTAP_TAPCELL_ROW_57_708 VDD VSS WELLTAP
XFILLER_39_286 VSS VDD FILLER2
XFILLER_82_510 VDD VSS FILLER1
XTAP_TAPCELL_ROW_107_1305 VDD VSS WELLTAP
X_09673_ _17625_/Q _17417_/B VDD VSS _09687_/B XNOR2X1
XFILLER_27_459 VDD VSS FILLER1
XFILLER_43_908 VSS VDD FILLER2
XFILLER_36_982 VDD VSS FILLER4
XFILLER_42_407 VDD VSS FILLER4
XFILLER_54_278 VSS VDD FILLER2
XFILLER_70_705 VDD VSS DECAPHV16
XTAP_TAPCELL_ROW_37_465 VDD VSS WELLTAP
XFILLER_35_470 VDD VSS FILLER1
XFILLER_74_1034 VSS VDD FILLER2
XTAP_TAPCELL_ROW_65_796 VDD VSS WELLTAP
XFILLER_11_816 VSS VDD FILLER2
XFILLER_23_643 VSS VDD FILLER2
XFILLER_50_440 VDD VSS FILLER1
XFILLER_52_49 VDD VSS DECAPHV32
XFILLER_136_512 VDD VSS FILLER1
XFILLER_136_534 VDD VSS FILLER4
XTAP_TAPCELL_ROW_118_1434 VDD VSS WELLTAP
X_09107_ _09107_/A _09127_/B VDD VSS _17429_/B XNOR2X1
XFILLER_124_707 VSS VDD FILLER2
XFILLER_105_921 VDD VSS FILLER1
XFILLER_11_1051 VSS VDD FILLER2
XFILLER_2_514 VDD VSS DECAPHV32
XTAP_TAPCELL_ROW_9_124 VDD VSS WELLTAP
X_09038_ _09038_/A _09059_/A VDD VSS _17392_/B XNOR2X1
XFILLER_117_792 VSS VDD FILLER2
XFILLER_46_1103 VDD VSS FILLER1
XFILLER_104_442 VSS VDD FILLER2
XFILLER_133_1106 VDD VSS DECAPHV8
X_11000_ _11024_/A _11138_/B VDD VSS _17985_/D NOR2X1
XFILLER_78_838 VDD VSS DECAPHV8
XFILLER_120_968 VSS VDD FILLER2
XFILLER_120_979 VSS VDD FILLER2
XFILLER_18_415 VSS VDD FILLER2
XFILLER_18_426 VDD VSS DECAPHV8
XFILLER_19_927 VSS VDD FILLER2
XFILLER_46_724 VSS VDD FILLER2
XFILLER_86_882 VDD VSS FILLER1
XTAP_TAPCELL_ROW_129_1563 VDD VSS WELLTAP
X_12951_ _18368_/Q _14330_/B VDD VSS _14363_/A AND2X1
XFILLER_133_96 VDD VSS DECAPHV32
XFILLER_46_768 VSS VDD FILLER2
XFILLER_73_521 VDD VSS DECAPHV8
XFILLER_85_392 VDD VSS FILLER1
X_11902_ _18462_/Q _11902_/B _11902_/C VDD VSS _12096_/B MIN3X1
X_12882_ _12993_/A _14121_/B VDD VSS _13085_/B NOR2X1
X_15670_ _18882_/Q _15670_/B VDD VSS _15671_/C NAND2X1
XFILLER_27_960 VDD VSS FILLER1
XFILLER_27_971 VSS VDD FILLER2
X_11833_ _11833_/A _14318_/A _14288_/B VDD VSS _11913_/B MIN3X1
X_14621_ _18539_/Q _18571_/Q _14621_/C VDD VSS _14626_/C AO21X2
XFILLER_26_72 VDD VSS DECAPHV8
XFILLER_27_993 VDD VSS FILLER1
XFILLER_33_429 VDD VSS FILLER1
XFILLER_92_1134 VSS VDD FILLER2
X_17340_ _17355_/A _17340_/B VDD VSS _19039_/D NOR2X1
X_11764_ _11931_/B _14167_/C _18226_/Q VDD VSS _11765_/D AND3BX1
X_14552_ _14553_/A _14554_/C _17229_/A VDD VSS _14553_/C OAI21X1
XFILLER_14_687 VDD VSS DECAPHV8
XFILLER_9_124 VDD VSS FILLER4
X_10715_ _10715_/A _10715_/B _10715_/C _10715_/D VDD VSS _10723_/B OAOI211X1
X_11695_ _14051_/A _14051_/B _18120_/Q VDD VSS _11696_/D OAI21X1
X_17271_ _17281_/A _17272_/B _17272_/D _17281_/B VDD VSS _17271_/Y OAOI211X1
X_14483_ _14517_/A _14483_/B VDD VSS _18498_/D NOR2X1
X_13503_ _18478_/Q _13503_/B _13516_/D VDD VSS _13583_/C XNOR3X1
XFILLER_9_146 VDD VSS DECAPHV16
X_10646_ _10731_/A _10781_/B VDD VSS _17915_/D NOR2X1
X_19010_ _19011_/CK _19010_/D _19010_/Q VDD VSS DFFQX1
X_16222_ _16802_/A _16222_/B _16222_/C VDD VSS _16222_/Y OAI21X1
X_13434_ _13511_/A _13511_/B _13511_/C _13434_/D VDD VSS _13516_/A AOAI211X1
X_16153_ _18902_/Q _16153_/B _16153_/C VDD VSS _16193_/A MIN3X1
XFILLER_115_707 VDD VSS FILLER4
X_10577_ _10583_/B _10583_/C _17877_/Q VDD VSS _10580_/B AOI21X1
X_15104_ _15299_/A _18675_/Q VDD VSS _18648_/D AND2X1
X_13365_ _13455_/A _14366_/B VDD VSS _13453_/C _13455_/C NAND3X1
XFILLER_127_589 VSS VDD FILLER2
XFILLER_6_886 VDD VSS DECAPHV32
XTAP_TAPCELL_ROW_93_1139 VDD VSS WELLTAP
X_12316_ _12421_/A _14261_/B VDD VSS _12372_/B NOR2X1
X_13296_ _18240_/Q _14182_/B VDD VSS _13386_/A NAND2X1
X_16084_ _16084_/A _16084_/B _16169_/B _16084_/D VDD VSS _16104_/A AOI31X1
X_12247_ _18126_/Q _14057_/A _14057_/B VDD VSS _12249_/C NOR3X1
X_15035_ _18629_/Q _19007_/Q VDD VSS _15037_/D XNOR2X1
XFILLER_69_805 VSS VDD FILLER2
XFILLER_96_602 VSS VDD FILLER2
XFILLER_122_283 VSS VDD FILLER2
XFILLER_3_32 VDD VSS DECAPHV32
XFILLER_95_112 VDD VSS DECAPHV8
X_12178_ _12296_/A _12310_/A _12503_/B VDD VSS _12213_/D XNOR3X1
XFILLER_110_445 VSS VDD FILLER2
XFILLER_77_860 VSS VDD FILLER2
XFILLER_84_808 VDD VSS FILLER1
XFILLER_96_657 VDD VSS FILLER1
X_11129_ _11132_/A _11129_/B VDD VSS _11130_/B XNOR2X1
X_16986_ _18941_/Q _17007_/B VDD VSS _16987_/C NAND2X1
XFILLER_114_1072 VDD VSS FILLER4
XFILLER_37_713 VSS VDD FILLER2
XFILLER_64_510 VDD VSS FILLER1
XFILLER_95_189 VSS VDD FILLER2
X_18725_ _18780_/CK _18725_/D _18725_/Q VDD VSS DFFQX1
X_15937_ _16802_/A _15937_/B VDD VSS _15938_/D AND2X1
XFILLER_49_595 VDD VSS DECAPHV16
XFILLER_97_1034 VDD VSS FILLER4
X_18656_ _18846_/CK _18656_/D _18656_/Q VDD VSS DFFQX1
Xwire27 wire27/A VDD VSS wire27/Y BUFX6
X_15868_ _18895_/Q _15872_/C VDD VSS _15869_/B XOR2X1
XFILLER_51_204 VDD VSS FILLER1
X_17607_ _17669_/CK _17607_/D _17607_/Q VDD VSS DFFQX1
X_14819_ _14817_/B _14819_/B VDD VSS _14820_/C NOR2BX1
XFILLER_17_481 VDD VSS FILLER1
XTAP_TAPCELL_ROW_34_424 VDD VSS WELLTAP
X_18587_ clkload8/A _18587_/D _18587_/Q VDD VSS DFFQX1
X_15799_ _15798_/Y _15799_/B _15801_/A VDD VSS _15800_/E AND3BX1
XTAP_TAPCELL_ROW_102_1246 VDD VSS WELLTAP
XTAP_TAPCELL_ROW_62_766 VDD VSS WELLTAP
X_17538_ _17733_/Q _18522_/Q VDD VSS _17540_/B XOR2X1
X_17469_ _17479_/A _17469_/B VDD VSS _17674_/D NOR2X1
XFILLER_80_0 VDD VSS DECAPHV32
XTAP_TAPCELL_ROW_14_181 VDD VSS WELLTAP
XFILLER_118_501 VSS VDD FILLER2
XTAP_TAPCELL_ROW_14_192 VDD VSS WELLTAP
XFILLER_121_1076 VDD VSS FILLER4
XFILLER_34_1095 VDD VSS FILLER1
XFILLER_113_250 VSS VDD FILLER2
XTAP_TAPCELL_ROW_113_1375 VDD VSS WELLTAP
XFILLER_87_646 VDD VSS FILLER4
XFILLER_101_434 VDD VSS FILLER4
XFILLER_102_979 VDD VSS FILLER1
XFILLER_28_713 VSS VDD FILLER2
XFILLER_74_318 VDD VSS FILLER1
XFILLER_80_1093 VSS VDD FILLER2
X_09725_ _17659_/Q _17453_/B VDD VSS _09726_/B XNOR2X1
XFILLER_28_746 VDD VSS FILLER4
X_09656_ _17592_/Q _17382_/B VDD VSS _09677_/A NOR2X1
XFILLER_28_779 VDD VSS DECAPHV8
XFILLER_103_88 VDD VSS FILLER4
XFILLER_27_278 VDD VSS FILLER1
X_09587_ _17654_/Q _17448_/B VDD VSS _09602_/B XOR2X1
XFILLER_24_963 VSS VDD FILLER2
XFILLER_11_635 VDD VSS DECAPHV16
XFILLER_23_495 VSS VDD FILLER2
X_10500_ _10509_/A _10509_/B _10509_/D _10509_/C VDD VSS _10664_/B AOI211X1
XFILLER_13_1102 VSS VDD FILLER2
X_11480_ _18144_/Q VDD VSS _11546_/A INVX1
X_10431_ _10707_/A _10614_/B VDD VSS _17883_/D AND2X1
X_10362_ _10364_/B _10370_/C _17848_/Q VDD VSS _10363_/D AND3BX1
X_13150_ _18448_/Q _13150_/B _13330_/B VDD VSS _14451_/B XNOR3X1
XFILLER_124_537 VDD VSS DECAPHV8
X_10293_ _10299_/A _10299_/B VDD VSS _10488_/A NOR2X1
X_12101_ _12101_/A _12101_/B _12101_/C VDD VSS _14382_/B XNOR3X1
X_13081_ _13297_/A _13081_/B VDD VSS _14209_/B XNOR2X1
X_12032_ _12032_/A _12032_/B _12032_/C _12032_/D VDD VSS _14170_/C OAI211X1
XFILLER_77_112 VDD VSS FILLER4
XFILLER_66_808 VDD VSS FILLER4
XFILLER_78_679 VSS VDD FILLER2
X_16840_ _18923_/Q _16840_/B VDD VSS _16850_/A AND2X1
XFILLER_46_510 VDD VSS FILLER1
XFILLER_93_616 VDD VSS DECAPHV8
X_16771_ wire30/Y _16808_/B VDD VSS _16772_/B _16771_/C NAND3X1
X_13983_ _14011_/A _13983_/B _14055_/C VDD VSS _18069_/D AOI21X1
X_12934_ _18368_/Q _13170_/A _13170_/B VDD VSS _12947_/C XNOR3X1
X_18510_ _18514_/CK _18510_/D _18510_/Q VDD VSS DFFQX1
X_15722_ _15650_/Y _15721_/Y _15651_/Y VDD VSS _15724_/B MUXI2X1
XFILLER_27_790 VSS VDD FILLER2
XFILLER_34_749 VDD VSS DECAPHV16
X_12865_ _12866_/A _12866_/B _12866_/D _12866_/C VDD VSS _12979_/B OAOI211X1
X_18441_ _18470_/CK _18441_/D _18441_/Q VDD VSS DFFQX1
X_15653_ _18881_/Q _15666_/C VDD VSS _15654_/B XOR2X1
X_11816_ _11816_/A _11816_/B _14408_/B VDD VSS _11995_/B MIN3X1
X_12796_ _12796_/A _12796_/B _12796_/C _12796_/D VDD VSS _12798_/C OAI211X1
X_18372_ _18478_/CK _18372_/D _18372_/Q VDD VSS DFFQX1
X_15584_ _15531_/B _15583_/Y _15674_/A VDD VSS _15584_/Y MUXI2X1
X_14604_ _14607_/C _14604_/B VDD VSS _14605_/B XNOR2X1
XFILLER_42_760 VSS VDD FILLER2
X_11747_ _11880_/A _11853_/A _11924_/B VDD VSS _11763_/C XNOR3X1
X_17323_ _17323_/A _17323_/B VDD VSS _19024_/D NOR2X1
X_14535_ _18522_/Q _18554_/Q VDD VSS _14537_/B XOR2X1
XFILLER_42_793 VSS VDD FILLER2
XFILLER_53_92 VDD VSS FILLER1
X_17254_ _19008_/Q _17260_/B VDD VSS _17257_/B XOR2X1
XFILLER_128_810 VDD VSS DECAPHV8
X_11678_ _11678_/A _11678_/B _11678_/C _11678_/D VDD VSS _11803_/B AOAI211X1
X_16205_ wire35/Y _16205_/B VDD VSS _16219_/C _16205_/C NAND3X1
X_14466_ _15300_/A _14466_/B VDD VSS _18488_/D AND2X1
XTAP_TAPCELL_ROW_11_151 VDD VSS WELLTAP
X_10629_ _10638_/B _10629_/B VDD VSS _10765_/B NAND2X1
X_17185_ _18993_/Q _18994_/Q _17226_/C VDD VSS _17195_/A OAI21X1
X_14397_ _17065_/A VDD VSS _14431_/A BUFX3
X_13417_ _13417_/A _13417_/B _13417_/C _13417_/D VDD VSS _14270_/B OAOI211X1
XFILLER_127_375 VSS VDD FILLER2
X_16136_ _16316_/A _16136_/B _16136_/C _16136_/D _16136_/E VDD VSS _16180_/B OAI221X1
X_13348_ _14395_/B _14395_/C _18423_/Q VDD VSS _13354_/B AOI21X1
XFILLER_127_386 VDD VSS FILLER1
XFILLER_5_160 VDD VSS DECAPHV16
X_16067_ _18900_/Q _16067_/B VDD VSS _16069_/C XNOR2X1
XFILLER_64_1000 VDD VSS DECAPHV8
XFILLER_64_1022 VSS VDD FILLER2
X_13279_ _13371_/A _13466_/B VDD VSS _14333_/B XNOR2X1
X_15018_ _15020_/A _15020_/B _15018_/C VDD VSS _18625_/D AOI21X1
XFILLER_96_421 VSS VDD FILLER2
XFILLER_97_933 VSS VDD FILLER2
XFILLER_110_242 VDD VSS DECAPHV8
XFILLER_116_1134 VSS VDD FILLER2
XFILLER_64_1099 VDD VSS FILLER1
XFILLER_97_966 VDD VSS DECAPHV8
XFILLER_68_189 VSS VDD FILLER2
XTAP_TAPCELL_ROW_67_825 VDD VSS WELLTAP
XFILLER_49_392 VDD VSS FILLER1
X_09510_ _09510_/A _09510_/B _09510_/C VDD VSS _09511_/B NOR3X1
X_18708_ _18815_/CK _18708_/D _18708_/Q VDD VSS DFFQX1
X_16969_ _16969_/A _16970_/B _16969_/C VDD VSS _16971_/A MIN3X1
XFILLER_25_705 VDD VSS DECAPHV16
XTAP_TAPCELL_ROW_19_251 VDD VSS WELLTAP
XTAP_TAPCELL_ROW_47_582 VDD VSS WELLTAP
X_09441_ _09441_/A _09441_/B _17373_/B VDD VSS _09462_/A MIN3X1
X_18639_ _19019_/CK _18639_/D _18639_/Q VDD VSS DFFQX1
X_09372_ _09373_/A _09373_/B _09373_/C VDD VSS _09387_/C AO21X2
XFILLER_21_933 VDD VSS DECAPHV8
XFILLER_32_292 VDD VSS FILLER1
XFILLER_71_1059 VSS VDD FILLER2
XFILLER_118_375 VSS VDD FILLER2
XTAP_TAPCELL_ROW_115_1404 VDD VSS WELLTAP
XFILLER_87_421 VDD VSS FILLER1
XFILLER_101_264 VDD VSS FILLER1
XFILLER_114_32 VDD VSS DECAPHV8
XFILLER_59_156 VDD VSS FILLER4
XFILLER_28_510 VDD VSS FILLER1
XFILLER_56_830 VDD VSS DECAPHV16
XFILLER_59_189 VSS VDD FILLER2
XFILLER_74_137 VSS VDD FILLER2
X_09708_ _09706_/Y _09710_/B _17453_/A VDD VSS _17781_/D AND3BX1
XFILLER_28_576 VDD VSS FILLER1
XFILLER_74_159 VDD VSS FILLER1
XTAP_TAPCELL_ROW_126_1533 VDD VSS WELLTAP
X_10980_ _17955_/Q VDD VSS _10981_/A INVX1
X_09639_ _09640_/A _09640_/B _09640_/C VDD VSS _09662_/B OAI21X1
XFILLER_43_568 VSS VDD FILLER2
X_12650_ _12742_/A _12742_/B _12742_/D _12742_/C VDD VSS _14177_/C AOI211X1
X_11601_ _18250_/Q _11601_/B _11601_/C VDD VSS _11743_/B MIN3X1
XFILLER_129_618 VDD VSS DECAPHV8
XFILLER_24_793 VDD VSS DECAPHV8
X_12581_ _18391_/Q _12714_/A _14358_/B VDD VSS _12603_/C XOR3X1
X_14320_ _14346_/A _14320_/B VDD VSS _18358_/D NOR2X1
X_11532_ _18221_/Q _11532_/B _11532_/C VDD VSS _11533_/C MIN3X1
XFILLER_128_0 VDD VSS DECAPHV32
X_11463_ _18274_/Q _11463_/B _11521_/C VDD VSS _11467_/C XNOR3X1
X_14251_ _14252_/A _14251_/B VDD VSS _18301_/D NOR2X1
X_10414_ _10414_/A _10414_/B _10414_/C VDD VSS _10415_/B AOI21X1
X_13202_ _18240_/Q _14182_/B VDD VSS _13305_/A AND2X1
X_14182_ _14372_/A _14182_/B VDD VSS _18240_/D AND2X1
XFILLER_109_386 VDD VSS DECAPHV8
XFILLER_136_183 VDD VSS DECAPHV32
XFILLER_48_1006 VSS VDD FILLER2
XFILLER_99_88 VDD VSS FILLER4
X_11394_ _14075_/B _14075_/C _18142_/Q VDD VSS _11396_/C AOI21X1
X_13133_ _18396_/Q _13276_/A _13350_/B VDD VSS _13265_/D XNOR3X1
XFILLER_48_1028 VDD VSS FILLER4
X_10345_ _17847_/Q VDD VSS _10359_/A INVX1
X_18990_ _18990_/CK _18990_/D _18990_/Q VDD VSS DFFQX1
XFILLER_105_581 VDD VSS FILLER4
XFILLER_112_518 VSS VDD FILLER2
XFILLER_2_174 VDD VSS DECAPHV32
XFILLER_3_686 VDD VSS DECAPHV32
XFILLER_78_421 VDD VSS DECAPHV8
X_10276_ _10276_/A _10276_/B VDD VSS _10470_/B XNOR2X1
X_13064_ _13178_/A _13178_/B _13178_/C VDD VSS _14268_/B OAI21X1
X_17941_ _17941_/CK _17941_/D _17941_/Q VDD VSS DFFQX1
X_12015_ _12076_/A _14228_/B VDD VSS _12210_/A OR2X2
X_17872_ _18003_/CK _17872_/D _17872_/Q VDD VSS DFFQX1
X_16823_ _16823_/A _16841_/B VDD VSS _16828_/B XNOR2X1
XFILLER_24_1061 VDD VSS DECAPHV8
XFILLER_24_1072 VSS VDD FILLER2
XFILLER_48_81 VDD VSS DECAPHV8
XFILLER_93_446 VDD VSS FILLER4
XFILLER_0_44 VDD VSS FILLER1
XFILLER_111_1042 VDD VSS FILLER4
XFILLER_19_565 VSS VDD FILLER2
XFILLER_93_468 VDD VSS FILLER4
X_16754_ _18857_/Q _18695_/Q _16725_/C VDD VSS _16779_/C AOI21BX1
X_13966_ _13972_/B _13971_/A _13966_/C VDD VSS _13968_/B OR3X2
XFILLER_111_1086 VDD VSS DECAPHV16
XFILLER_34_502 VDD VSS FILLER1
XFILLER_34_535 VDD VSS FILLER4
XFILLER_46_373 VSS VDD FILLER2
XFILLER_59_1135 VDD VSS FILLER1
X_12917_ _18497_/Q _12917_/B _14481_/B VDD VSS _12920_/C MIN3X1
X_16685_ _16686_/A _16686_/B VDD VSS _16691_/B NAND2X1
X_15705_ _18886_/Q _15736_/B VDD VSS _15706_/C NAND2X1
X_13897_ wire26/Y _13898_/B _13898_/D _13898_/C VDD VSS _14435_/A OA211X2
XFILLER_0_88 VSS VDD FILLER2
XTAP_TAPCELL_ROW_16_210 VDD VSS WELLTAP
XTAP_TAPCELL_ROW_44_541 VDD VSS WELLTAP
X_12848_ _18288_/Q _12965_/B VDD VSS _12849_/D _12848_/C NAND3X1
X_18424_ _18478_/CK _18424_/D _18424_/Q VDD VSS DFFQX1
X_15636_ _15583_/Y _15686_/B _15674_/A VDD VSS _15637_/B MUXI2X1
XTAP_TAPCELL_ROW_44_552 VDD VSS WELLTAP
XTAP_TAPCELL_ROW_72_883 VDD VSS WELLTAP
X_12779_ _12783_/A _12783_/B _12783_/D _12779_/D VDD VSS _14064_/B OAOI211X1
X_18355_ _18381_/CK _18355_/D _18355_/Q VDD VSS DFFQX1
X_15567_ _15567_/A _15567_/B _15567_/C VDD VSS _15587_/B MIN3X1
XFILLER_9_64 VDD VSS DECAPHV16
X_18286_ _18313_/CK _18286_/D _18286_/Q VDD VSS DFFQX1
X_17306_ _17306_/A VDD VSS _17307_/C INVX1
X_15498_ _15460_/B _15497_/Y _15596_/A VDD VSS _15498_/Y MUXI2X1
X_14518_ _14516_/B _14518_/B VDD VSS _14519_/C NOR2BX1
XFILLER_119_128 VDD VSS DECAPHV32
X_17237_ _17237_/A _17237_/B VDD VSS _17241_/B NAND2X1
X_14449_ _14451_/A _14449_/B VDD VSS _18472_/D NOR2X1
X_17168_ _17168_/A _17232_/B _17168_/C VDD VSS _17176_/A MIN3X1
XFILLER_128_695 VSS VDD FILLER2
XFILLER_31_1087 VDD VSS DECAPHV8
X_16119_ _16119_/A _16119_/B _16119_/C _16119_/D VDD VSS _16153_/B AOAI211X1
XFILLER_43_0 VDD VSS DECAPHV32
X_09990_ _17799_/Q _09997_/B VDD VSS _09992_/A NOR2BX1
X_17099_ _18015_/Q _17099_/B VDD VSS _17103_/D NOR2X1
XFILLER_130_315 VDD VSS DECAPHV8
X_08941_ _08944_/A _08944_/B _17514_/A VDD VSS _08942_/C OAI21X1
XTAP_TAPCELL_ROW_110_1334 VDD VSS WELLTAP
X_08872_ _16984_/A wire34/Y VDD VSS _15793_/B NAND2X1
XFILLER_69_476 VSS VDD FILLER2
XFILLER_85_914 VDD VSS DECAPHV8
XFILLER_38_830 VDD VSS DECAPHV8
XFILLER_85_958 VDD VSS DECAPHV8
XFILLER_37_384 VSS VDD FILLER2
XFILLER_53_811 VSS VDD FILLER2
X_09424_ _09449_/A _09449_/B VDD VSS _17475_/B XNOR2X1
XTAP_TAPCELL_ROW_121_1474 VDD VSS WELLTAP
X_09355_ _17581_/Q _17370_/B _09355_/C VDD VSS _09376_/A AOI2B1X1
XFILLER_21_763 VDD VSS FILLER4
X_09286_ _09312_/C _09286_/B VDD VSS _17470_/B XNOR2X1
XFILLER_60_49 VDD VSS DECAPHV32
XTAP_TAPCELL_ROW_22_279 VDD VSS WELLTAP
XFILLER_109_32 VDD VSS DECAPHV32
XFILLER_10_1105 VDD VSS FILLER1
XFILLER_119_662 VDD VSS FILLER4
XFILLER_20_295 VDD VSS DECAPHV16
XFILLER_107_835 VSS VDD FILLER2
XFILLER_10_1127 VDD VSS DECAPHV8
X_10130_ _10148_/A _10148_/B _10322_/C VDD VSS _10325_/B OAI21X1
XFILLER_88_730 VDD VSS FILLER4
X_10061_ _10061_/A _10061_/B _10061_/C VDD VSS _10068_/A OAI21X1
XFILLER_0_678 VDD VSS DECAPHV32
XFILLER_102_551 VDD VSS FILLER1
XFILLER_125_64 VDD VSS DECAPHV16
XFILLER_76_925 VDD VSS DECAPHV16
XFILLER_18_40 VDD VSS FILLER4
XFILLER_29_852 VSS VDD FILLER2
XFILLER_29_874 VSS VDD FILLER2
XFILLER_75_468 VSS VDD FILLER2
X_13820_ _13821_/C _14496_/B _14496_/C VDD VSS _13853_/D NOR3X1
XFILLER_18_95 VDD VSS DECAPHV8
XFILLER_28_362 VDD VSS DECAPHV8
XFILLER_29_896 VDD VSS DECAPHV8
XFILLER_56_671 VDD VSS FILLER4
XFILLER_62_107 VDD VSS FILLER1
XTAP_TAPCELL_ROW_87_1060 VDD VSS WELLTAP
X_10963_ _17059_/C _11103_/B VDD VSS _17978_/D AND2X1
X_13751_ _13751_/A _14401_/B _13751_/C _13751_/D VDD VSS _13838_/A OAOI211X1
XFILLER_83_490 VSS VDD FILLER2
X_12702_ _18496_/Q VDD VSS _12916_/A INVX1
X_16470_ _16537_/A _18769_/Q _16757_/A _16470_/D _16470_/E VDD VSS _16470_/Y AOI221X1
XFILLER_31_505 VDD VSS FILLER4
XFILLER_44_899 VDD VSS FILLER4
X_10894_ _10914_/A _11033_/B VDD VSS _17964_/D NOR2X1
X_15421_ _16731_/A _15421_/B _15421_/C VDD VSS _15423_/B OAI21X1
X_13682_ _13748_/A _13754_/B VDD VSS _14372_/B XNOR2X1
XFILLER_106_1111 VSS VDD FILLER2
XTAP_TAPCELL_ROW_41_511 VDD VSS WELLTAP
X_12633_ _12633_/A _14264_/B _14264_/C VDD VSS _12634_/D NOR3X1
XFILLER_129_415 VSS VDD FILLER2
XTAP_TAPCELL_ROW_5_76 VDD VSS WELLTAP
X_12564_ _18983_/Q _18104_/Q VDD VSS _12566_/C NAND2X1
X_18140_ _18195_/CK _18140_/D _18140_/Q VDD VSS DFFQX1
X_15352_ _16316_/A VDD VSS _16731_/A BUFX3
X_11515_ _18301_/Q _11595_/B _11591_/C VDD VSS _11519_/C XNOR3X1
X_18071_ _18835_/CK _18071_/D _18071_/Q VDD VSS DFFQX1
X_15283_ _15313_/A _18851_/Q VDD VSS _18824_/D AND2X1
X_14303_ _14332_/A _14303_/B _14303_/C VDD VSS _18344_/D NOR3X1
X_12495_ _14262_/B _14262_/C _18311_/Q VDD VSS _12499_/B AOI21X1
X_17022_ _18000_/Q _17022_/B VDD VSS _17026_/B NOR2X1
X_14234_ _14198_/Y _14234_/B _14234_/C VDD VSS _18286_/D AND3BX1
XFILLER_125_610 VDD VSS FILLER1
XFILLER_7_277 VSS VDD FILLER2
X_11446_ _11446_/A _11446_/B _11446_/C _11446_/D VDD VSS _14048_/C AOAI211X1
XFILLER_124_142 VDD VSS DECAPHV32
XFILLER_125_654 VDD VSS FILLER1
X_11377_ _11417_/A _11417_/B _14160_/B VDD VSS _11532_/B MIN3X1
X_14165_ _14191_/A _14165_/B VDD VSS _18224_/D NOR2X1
X_10328_ _10333_/A _10333_/B VDD VSS _10513_/A NOR2X1
X_13116_ _18162_/Q _13223_/A _13223_/B VDD VSS _13213_/C XOR3X1
X_18973_ _18988_/CK _18973_/D _18973_/Q VDD VSS DFFQX1
X_14096_ _14074_/Y _14096_/B _14096_/C VDD VSS _18161_/D AND3BX1
XFILLER_112_337 VDD VSS DECAPHV8
XFILLER_59_80 VDD VSS DECAPHV8
X_13047_ _13159_/A _14362_/B _13159_/C VDD VSS _14364_/B AOI21X1
X_17924_ _18003_/CK _17924_/D _17924_/Q VDD VSS DFFQX1
XFILLER_121_882 VDD VSS DECAPHV8
XFILLER_39_616 VDD VSS FILLER4
XFILLER_79_785 VSS VDD FILLER2
X_10259_ _10262_/C _10259_/B VDD VSS _10449_/B XNOR2X1
XFILLER_61_1069 VDD VSS DECAPHV16
XFILLER_67_958 VSS VDD FILLER2
XTAP_TAPCELL_ROW_49_611 VDD VSS WELLTAP
XTAP_TAPCELL_ROW_77_942 VDD VSS WELLTAP
X_17855_ _17861_/CK _17855_/D _17855_/Q VDD VSS DFFQX1
X_17786_ _17865_/CK _17786_/D _17786_/Q VDD VSS DFFQX1
X_16806_ _16806_/A _16817_/B VDD VSS _16813_/B XNOR2X1
XFILLER_47_671 VSS VDD FILLER2
XFILLER_81_427 VDD VSS FILLER1
X_16737_ _16939_/A _16737_/B _16737_/C VDD VSS _16775_/B AOI21X1
X_14998_ _14998_/A _14998_/B _14998_/C VDD VSS _15001_/C MIN3X1
XFILLER_90_961 VDD VSS DECAPHV8
X_13949_ _18956_/Q _14005_/B VDD VSS _14009_/B NOR2BX1
XFILLER_50_803 VDD VSS FILLER1
X_16668_ _16857_/A _16668_/B _16668_/C VDD VSS _16670_/B AOI21X1
XFILLER_50_869 VDD VSS FILLER1
X_18407_ _18408_/CK _18407_/D _18407_/Q VDD VSS DFFQX1
X_16599_ _16637_/B _16599_/B VDD VSS _16601_/B XNOR2X1
X_15619_ _18878_/Q _15668_/B VDD VSS _15620_/C NAND2X1
X_09140_ _09147_/A _17362_/B VDD VSS _09148_/B XNOR2X1
X_18338_ _18340_/CK _18338_/D _18338_/Q VDD VSS DFFQX1
X_09071_ _17603_/Q _17393_/B VDD VSS _09072_/B XOR2X1
XFILLER_135_407 VDD VSS DECAPHV16
X_18269_ _18295_/CK _18269_/D _18269_/Q VDD VSS DFFQX1
XFILLER_104_849 VSS VDD FILLER2
XFILLER_118_1015 VSS VDD FILLER2
X_09973_ _17798_/Q _09989_/B VDD VSS _09986_/B XOR2X1
XFILLER_103_348 VDD VSS FILLER4
XFILLER_115_197 VSS VDD FILLER2
X_08924_ _16977_/A VDD VSS _14361_/A BUFX3
XFILLER_112_860 VDD VSS FILLER1
XFILLER_29_126 VDD VSS DECAPHV8
XFILLER_57_435 VSS VDD FILLER2
XFILLER_58_958 VDD VSS DECAPHV16
XFILLER_57_468 VSS VDD FILLER2
XFILLER_57_479 VSS VDD FILLER2
XFILLER_84_243 VSS VDD FILLER2
XFILLER_85_788 VDD VSS FILLER4
XTAP_TAPCELL_ROW_27_338 VDD VSS WELLTAP
XFILLER_13_505 VDD VSS FILLER1
XFILLER_111_88 VDD VSS FILLER4
XFILLER_80_482 VDD VSS FILLER4
X_09407_ _19038_/Q _17338_/B VDD VSS _09409_/B XOR2X1
X_09338_ _17505_/B _17708_/Q _09338_/C VDD VSS _09362_/C MIN3X1
XFILLER_126_407 VDD VSS DECAPHV8
XFILLER_14_1060 VDD VSS FILLER1
X_09269_ _16977_/A VDD VSS _17536_/D BUFX3
X_11300_ _11380_/A _11380_/B _11328_/C VDD VSS _14129_/B XNOR3X1
XTAP_TAPCELL_ROW_134_1621 VDD VSS WELLTAP
XTAP_TAPCELL_ROW_134_1632 VDD VSS WELLTAP
X_12280_ _18492_/Q VDD VSS _12281_/A INVX1
XFILLER_106_142 VDD VSS FILLER4
XFILLER_107_654 VDD VSS FILLER1
X_11231_ _18963_/Q _18084_/Q VDD VSS _11240_/C AND2X1
XFILLER_107_687 VDD VSS DECAPHV8
XFILLER_134_473 VDD VSS FILLER1
XFILLER_136_1115 VDD VSS DECAPHV8
X_11162_ _11165_/A _11165_/B VDD VSS _17109_/B XNOR2X1
XFILLER_84_1058 VDD VSS FILLER4
X_10113_ _10296_/A _10296_/B VDD VSS _10299_/B XNOR2X1
XFILLER_0_453 VDD VSS DECAPHV32
XFILLER_1_965 VDD VSS DECAPHV32
XFILLER_48_402 VDD VSS FILLER1
XFILLER_76_700 VDD VSS FILLER4
X_11093_ _11135_/A _17036_/B VDD VSS _18002_/D NOR2X1
X_15970_ _18038_/Q _18648_/Q VDD VSS _15997_/D XNOR2X1
XFILLER_121_189 VDD VSS DECAPHV32
XFILLER_48_435 VDD VSS FILLER4
XFILLER_49_947 VDD VSS FILLER1
XFILLER_76_733 VDD VSS FILLER4
X_10044_ _10044_/A _10046_/C VDD VSS _10242_/B XNOR2X1
X_14921_ _14924_/C _14922_/B _17318_/C VDD VSS _14922_/C OAI21X1
XFILLER_48_457 VSS VDD FILLER2
XFILLER_48_468 VDD VSS FILLER1
X_17640_ _17669_/CK _17640_/D _17640_/Q VDD VSS DFFQX1
X_14852_ _14852_/A _14853_/C _14852_/C VDD VSS _18589_/D AOI21X1
XFILLER_17_800 VSS VDD FILLER2
XFILLER_1_1114 VSS VDD FILLER2
XFILLER_64_939 VDD VSS DECAPHV8
XFILLER_75_276 VSS VDD FILLER2
XFILLER_76_788 VSS VDD FILLER2
XFILLER_91_736 VSS VDD FILLER2
XTAP_TAPCELL_ROW_74_901 VDD VSS WELLTAP
XTAP_TAPCELL_ROW_74_912 VDD VSS WELLTAP
Xhold94 rst_b VDD VSS input2/A BUFX3
X_13803_ _13806_/A _13806_/B _13806_/D _13806_/C VDD VSS _14342_/A OA211X2
XFILLER_16_321 VDD VSS FILLER1
XFILLER_90_235 VDD VSS DECAPHV16
XFILLER_91_747 VDD VSS FILLER1
X_11995_ _18436_/Q _11995_/B _11995_/C VDD VSS _14438_/B XNOR3X1
X_17571_ _19028_/CK _17571_/D _17571_/Q VDD VSS DFFQX1
X_14783_ _14903_/A _14783_/B VDD VSS _18574_/D NOR2X1
XFILLER_32_814 VDD VSS FILLER1
XFILLER_56_1105 VDD VSS FILLER1
XFILLER_56_1127 VDD VSS FILLER4
XFILLER_90_268 VDD VSS FILLER1
X_10946_ _17948_/Q VDD VSS _10947_/A INVX1
Xclkbuf_leaf_42__002_ clkload26/A VDD VSS _18478_/CK BUFX12
X_16522_ _16374_/Y _16520_/Y _16869_/A VDD VSS _16522_/Y MUXI2X1
X_13734_ _13792_/A _13734_/B VDD VSS _14430_/B XNOR2X1
XFILLER_31_302 VDD VSS FILLER1
XFILLER_43_184 VSS VDD FILLER2
XFILLER_44_696 VDD VSS FILLER1
X_10877_ _10914_/A _11014_/B VDD VSS _17961_/D NOR2X1
X_16453_ _16490_/D _16490_/B VDD VSS _16454_/B NAND2BX1
X_13665_ _18428_/Q _13738_/D _13665_/C VDD VSS _13667_/C XNOR3X1
X_12616_ _12616_/A _14263_/B VDD VSS _12726_/A OR2X2
X_16384_ _16423_/A _16423_/B VDD VSS _16418_/B NAND2X1
X_15404_ _16783_/D _16783_/A VDD VSS _15526_/A NAND2X1P5
XFILLER_118_908 VSS VDD FILLER2
XFILLER_12_571 VDD VSS FILLER1
X_18123_ _18978_/CK _18123_/D _18123_/Q VDD VSS DFFQX1
X_15335_ _15338_/A _15801_/A VDD VSS _15336_/D NAND2X1
X_13596_ _18479_/Q _14457_/B _14457_/C VDD VSS _13649_/D OR3BX1
XFILLER_117_407 VDD VSS DECAPHV8
XFILLER_61_92 VDD VSS FILLER1
X_12547_ _18156_/Q VDD VSS _12661_/A INVX1
XANTENNA_3 _17533_/A VDD VSS ANTENNA2
XFILLER_6_32 VDD VSS DECAPHV8
XFILLER_8_597 VDD VSS FILLER4
X_12478_ _12588_/A _14478_/B VDD VSS _12481_/C NAND2X1
X_18054_ _18851_/CK _18054_/D _18054_/Q VDD VSS DFFQX1
X_15266_ _15295_/A _18834_/Q VDD VSS _18807_/D AND2X1
X_11429_ _18169_/Q _11483_/A _11537_/B VDD VSS _11430_/D XNOR3X1
X_17005_ _18953_/Q _17007_/B VDD VSS _17006_/C NAND2X1
X_15197_ _15307_/A _18766_/Q VDD VSS _18739_/D AND2X1
X_14217_ _14217_/A _14217_/B VDD VSS _18273_/D NOR2X1
XFILLER_113_602 VDD VSS FILLER1
XFILLER_99_836 VDD VSS FILLER1
X_14148_ _14160_/A _14148_/B VDD VSS _18209_/D NOR2X1
XFILLER_113_646 VDD VSS FILLER1
XFILLER_99_869 VDD VSS FILLER1
XFILLER_98_368 VSS VDD FILLER2
X_18956_ _18958_/CK _18956_/D _18956_/Q VDD VSS DFFQX1
X_14079_ _14079_/A _14079_/B _14079_/C VDD VSS _18146_/D NOR3X1
X_18887_ _18958_/CK _18887_/D _18887_/Q VDD VSS DFFQX1
X_17907_ _17908_/CK _17907_/D _17907_/Q VDD VSS DFFQX1
XFILLER_39_468 VDD VSS FILLER4
X_17838_ _17865_/CK _17838_/D _17838_/Q VDD VSS DFFQX1
XFILLER_39_479 VSS VDD FILLER2
XFILLER_55_928 VSS VDD FILLER2
XFILLER_66_276 VDD VSS DECAPHV8
XFILLER_19_170 VSS VDD FILLER2
XFILLER_19_181 VDD VSS FILLER1
XFILLER_26_129 VSS VDD FILLER2
XFILLER_63_950 VSS VDD FILLER2
XFILLER_82_758 VDD VSS DECAPHV16
X_17769_ _19038_/CK _17769_/D _17769_/Q VDD VSS DFFQX1
XFILLER_23_803 VDD VSS FILLER4
XTAP_TAPCELL_ROW_24_308 VDD VSS WELLTAP
XFILLER_23_836 VDD VSS FILLER1
XTAP_TAPCELL_ROW_105_1277 VDD VSS WELLTAP
XTAP_TAPCELL_ROW_52_639 VDD VSS WELLTAP
XFILLER_22_368 VSS VDD FILLER2
X_09123_ _09123_/A _09123_/B _09123_/C VDD VSS _09150_/B AOI21X1
XFILLER_108_407 VSS VDD FILLER2
XFILLER_108_429 VSS VDD FILLER2
X_09054_ _17569_/Q _17358_/B _09054_/C VDD VSS _09076_/B MIN3X1
XFILLER_116_462 VDD VSS DECAPHV16
XFILLER_103_167 VSS VDD FILLER2
XFILLER_106_44 VSS VDD FILLER2
XFILLER_131_476 VDD VSS FILLER4
X_09956_ _10157_/A _10157_/B _10158_/B _10157_/C VDD VSS _10164_/B OAI211X1
X_08907_ _17736_/Q _18525_/Q VDD VSS _08908_/C NAND2X1
X_09887_ _09887_/A _09887_/B _09887_/C _09887_/D VDD VSS _09888_/B OAOI211X1
XFILLER_44_1097 VDD VSS FILLER4
XFILLER_122_32 VDD VSS DECAPHV8
XFILLER_39_980 VDD VSS DECAPHV16
XFILLER_57_276 VSS VDD FILLER2
XFILLER_26_641 VDD VSS DECAPHV8
XFILLER_54_950 VDD VSS FILLER1
XFILLER_72_235 VDD VSS DECAPHV8
XFILLER_73_758 VDD VSS FILLER1
XFILLER_25_140 VSS VDD FILLER2
XFILLER_72_257 VDD VSS DECAPHV16
XTAP_TAPCELL_ROW_84_1030 VDD VSS WELLTAP
X_10800_ _10802_/C _10800_/B VDD VSS _10936_/B XNOR2X1
X_11780_ _18121_/Q _14052_/B _14052_/C VDD VSS _11784_/D OR3BX1
XFILLER_25_173 VDD VSS FILLER4
X_10731_ _10731_/A _10864_/B VDD VSS _17932_/D NOR2X1
XFILLER_13_346 VSS VDD FILLER2
XFILLER_15_52 VSS VDD FILLER2
X_13450_ _13516_/A _13516_/B _13516_/C VDD VSS _13503_/B AOI21X1
XFILLER_13_379 VDD VSS FILLER1
XFILLER_15_85 VDD VSS FILLER4
X_10662_ _10665_/A _10665_/B _10665_/C VDD VSS _10802_/B XNOR3X1
X_12401_ _18416_/Q VDD VSS _12602_/A INVX1
X_10593_ _17879_/Q _10593_/B VDD VSS _10594_/D _10593_/C NAND3X1
X_13381_ _13205_/A _14154_/B _14154_/C VDD VSS _13383_/C AND3BX1
XFILLER_12_1019 VDD VSS DECAPHV8
X_12332_ _12430_/A _12430_/B _12430_/D _12430_/C VDD VSS _14173_/C AOI211X1
X_15120_ _17525_/B _18691_/Q VDD VSS _18664_/D AND2X1
XFILLER_110_0 VDD VSS DECAPHV32
XFILLER_5_556 VSS VDD FILLER2
XTAP_TAPCELL_ROW_2_44 VDD VSS WELLTAP
X_12263_ _18128_/Q _12453_/A _12361_/C VDD VSS _12352_/D XNOR3X1
X_15051_ _15093_/A _15051_/B VDD VSS _18632_/D NOR2X1
XFILLER_107_462 VSS VDD FILLER2
X_11214_ _17501_/A VDD VSS _14079_/A BUFX3
Xoutput5 output5/A VDD VSS data_out[11] BUFX3
X_14002_ _18954_/Q _14002_/B _18955_/Q VDD VSS _14003_/C AOI21X1
XFILLER_107_484 VSS VDD FILLER2
XFILLER_122_421 VDD VSS DECAPHV8
XFILLER_123_933 VDD VSS FILLER4
XFILLER_135_793 VDD VSS DECAPHV8
X_12194_ _12194_/A _12194_/B _14440_/B VDD VSS _14472_/A MIN3X1
XFILLER_122_454 VDD VSS FILLER4
XFILLER_96_828 VDD VSS DECAPHV8
X_11145_ _11150_/A _11150_/B VDD VSS _11147_/A NAND2X1
X_18810_ _18837_/CK _18810_/D _18810_/Q VDD VSS DFFQX1
XFILLER_62_1131 VDD VSS FILLER1
X_11076_ _11076_/A VDD VSS _11077_/C INVX1
X_18741_ _18821_/CK _18741_/D _18741_/Q VDD VSS DFFQX1
X_15953_ _18782_/Q _18728_/Q VDD VSS _15955_/C AND2X1
XFILLER_49_755 VDD VSS FILLER4
XFILLER_76_541 VDD VSS DECAPHV16
X_10027_ _10227_/B _10227_/C VDD VSS _10232_/B XNOR2X1
X_14904_ _18601_/Q _18633_/Q VDD VSS _14908_/A XOR2X1
XFILLER_37_928 VSS VDD FILLER2
XFILLER_37_939 VDD VSS FILLER1
X_18672_ _18808_/CK _18672_/D _18672_/Q VDD VSS DFFQX1
X_15884_ _18035_/Q _18645_/Q VDD VSS _15912_/A NAND2X1
XFILLER_56_81 VDD VSS DECAPHV16
XFILLER_91_555 VSS VDD FILLER2
X_17623_ _17656_/CK _17623_/D _17623_/Q VDD VSS DFFQX1
X_14835_ _14835_/A _14835_/B _14835_/C _14835_/D VDD VSS _14840_/C AOAI211X1
XFILLER_45_972 VDD VSS FILLER1
XFILLER_51_419 VDD VSS DECAPHV16
X_11978_ _12010_/A _12016_/D VDD VSS _12175_/C XNOR2X1
X_17554_ _17555_/A _17555_/B _17554_/C VDD VSS _17555_/C OAI21X1
X_14766_ _14769_/A _14766_/B _14766_/C VDD VSS _18570_/D AOI21X1
X_10929_ _11064_/B VDD VSS _11069_/B INVX1
X_16505_ _16545_/C _16506_/B _16547_/D VDD VSS _16506_/C OAI21X1
X_13717_ _18481_/Q VDD VSS _13776_/A INVX1
XFILLER_108_1025 VDD VSS FILLER4
X_17485_ _17499_/A _17485_/B VDD VSS _17689_/D NOR2X1
X_14697_ _18557_/Q _18589_/Q VDD VSS _14701_/A XOR2X1
X_16436_ _18849_/Q _18687_/Q VDD VSS _16478_/D NAND2X1
X_13648_ _13649_/A _13649_/B _13649_/D _13649_/C VDD VSS _13777_/B OAOI211X1
X_16367_ _18820_/Q _18712_/Q VDD VSS _16369_/C XNOR2X1
X_13579_ _13580_/A _13580_/B _13580_/D _13580_/C VDD VSS _13660_/B OAOI211X1
X_18106_ _18985_/CK _18106_/D _18106_/Q VDD VSS DFFQX1
X_16298_ _16554_/A _16298_/B VDD VSS _16299_/C NOR2X1
X_15318_ _15318_/A _18057_/Q VDD VSS _18856_/D AND2X1
X_18037_ _18838_/CK _18037_/D _18037_/Q VDD VSS DFFQX1
X_15249_ _15304_/A _18817_/Q VDD VSS _18790_/D AND2X1
XFILLER_67_1042 VDD VSS FILLER4
XFILLER_98_121 VSS VDD FILLER2
XFILLER_101_605 VDD VSS DECAPHV16
X_09810_ _17765_/Q _17766_/Q _09810_/C _17767_/Q VDD VSS _09811_/B AOI31X1
XFILLER_113_498 VDD VSS DECAPHV32
XFILLER_115_1018 VDD VSS FILLER4
XFILLER_86_338 VSS VDD FILLER2
X_09741_ _09741_/A _09741_/B VDD VSS _09747_/B OR2X2
X_18939_ _18951_/CK _18939_/D _18939_/Q VDD VSS DFFQX1
XFILLER_100_137 VSS VDD FILLER2
XFILLER_28_928 VDD VSS FILLER1
XFILLER_94_360 VDD VSS FILLER1
XTAP_TAPCELL_ROW_107_1306 VDD VSS WELLTAP
X_09672_ _09690_/B _09672_/B VDD VSS _17417_/B NOR2BX1
XFILLER_54_235 VDD VSS FILLER4
XFILLER_55_747 VDD VSS DECAPHV16
XFILLER_82_555 VSS VDD FILLER2
XTAP_TAPCELL_ROW_37_466 VDD VSS WELLTAP
XTAP_TAPCELL_ROW_65_797 VDD VSS WELLTAP
Xclkbuf_1_1__f_clk_fs_regs clkbuf_0_clk_fs_regs/Y VDD VSS clkbuf_leaf_9_clk_fs_regs/A
+ BUFX12
XFILLER_22_165 VDD VSS FILLER4
XFILLER_51_986 VDD VSS FILLER1
XFILLER_108_204 VDD VSS DECAPHV8
XFILLER_109_716 VDD VSS DECAPHV8
XTAP_TAPCELL_ROW_118_1435 VDD VSS WELLTAP
X_09106_ _17668_/Q _17462_/B VDD VSS _09127_/B XNOR2X1
X_09037_ _09037_/A _09037_/B _09037_/C VDD VSS _09059_/A AO21X2
XFILLER_104_410 VSS VDD FILLER2
XFILLER_105_933 VDD VSS FILLER1
XTAP_TAPCELL_ROW_9_125 VDD VSS WELLTAP
XFILLER_105_966 VDD VSS DECAPHV8
XFILLER_89_132 VDD VSS FILLER1
XFILLER_77_338 VDD VSS FILLER1
XFILLER_89_165 VSS VDD FILLER2
X_09939_ _09939_/A _09943_/C VDD VSS _10139_/A XOR2X1
XFILLER_133_64 VDD VSS DECAPHV16
XFILLER_85_371 VDD VSS FILLER1
XFILLER_92_319 VDD VSS FILLER4
XTAP_TAPCELL_ROW_129_1564 VDD VSS WELLTAP
X_12950_ _13056_/A _13170_/B VDD VSS _14330_/B XNOR2X1
X_11901_ _18461_/Q _14437_/B VDD VSS _11902_/B OR2X2
X_12881_ _12899_/A _12899_/B _12899_/D _12899_/C VDD VSS _14121_/B OAOI211X1
XFILLER_26_40 VDD VSS FILLER4
X_11832_ _11916_/A _11916_/B _11837_/C VDD VSS _14288_/B XNOR3X1
X_14620_ _14621_/C _17455_/A _14620_/C VDD VSS _18539_/D AND3BX1
XFILLER_73_588 VSS VDD FILLER2
X_14551_ _14551_/A _14699_/A _14551_/C VDD VSS _14554_/C MIN3X1
XFILLER_41_441 VDD VSS FILLER1
XFILLER_42_975 VDD VSS FILLER1
X_11763_ wire28/Y _11763_/B _11763_/C _11763_/D VDD VSS _14167_/C OAI211X1
X_10714_ _17903_/Q _10714_/B VDD VSS _10723_/A NOR2BX1
X_11694_ _18120_/Q _14051_/A _14051_/B VDD VSS _11696_/C NOR3X1
X_17270_ _19011_/Q _17315_/B VDD VSS _17281_/B XNOR2X1
X_14482_ _14542_/A VDD VSS _14517_/A BUFX3
X_13502_ _18452_/Q _13605_/A _13597_/B VDD VSS _13516_/D XNOR3X1
X_10645_ _10648_/C _10645_/B VDD VSS _10781_/B XNOR2X1
X_16221_ _16802_/A _16221_/B VDD VSS _16222_/C NAND2X1
X_13433_ _18450_/Q _14424_/B _14424_/C VDD VSS _13434_/D OR3BX1
X_16152_ _16456_/A _16152_/B _16152_/C VDD VSS _18902_/D OAI21X1
X_13364_ _13455_/A _14366_/B _13455_/C VDD VSS _14368_/B AOI21X1
X_10576_ _10576_/A _10576_/B _10576_/C _10576_/D VDD VSS _10580_/A OAOI211X1
X_12315_ _18284_/Q _14232_/B VDD VSS _12421_/A AND2X1
X_15103_ _15299_/A _18674_/Q VDD VSS _18647_/D AND2X1
XTAP_TAPCELL_ROW_93_1129 VDD VSS WELLTAP
X_13295_ _18267_/Q VDD VSS _13380_/A INVX1
X_16083_ _16218_/A _18759_/Q VDD VSS _16084_/D AND2X1
XFILLER_107_270 VDD VSS DECAPHV8
XFILLER_108_793 VDD VSS FILLER1
XFILLER_5_375 VDD VSS DECAPHV32
X_12246_ _14143_/A _14143_/B _14143_/C _12246_/D VDD VSS _12436_/A OAOI211X1
X_15034_ _15037_/A _15034_/B _15034_/C VDD VSS _18628_/D AOI21X1
XFILLER_123_741 VSS VDD FILLER2
X_12177_ _18309_/Q VDD VSS _12296_/A INVX1
X_11128_ _17984_/Q VDD VSS _11132_/A INVX1
XFILLER_3_88 VDD VSS FILLER4
XFILLER_77_850 VDD VSS FILLER1
XFILLER_95_124 VSS VDD FILLER2
X_16985_ _16985_/A _17019_/B _17019_/C _18940_/Q VDD VSS _18940_/D AO22X2
XFILLER_110_468 VSS VDD FILLER2
XFILLER_27_1092 VDD VSS DECAPHV16
XFILLER_67_80 VDD VSS DECAPHV8
X_11059_ _17969_/Q _11059_/B _11055_/Y VDD VSS _11066_/C AOI21BX1
X_18724_ _18805_/CK _18724_/D _18724_/Q VDD VSS DFFQX1
X_15936_ _15936_/A VDD VSS _16802_/A BUFX3
XFILLER_36_235 VDD VSS FILLER4
XFILLER_37_736 VDD VSS FILLER1
XFILLER_37_758 VSS VDD FILLER2
XFILLER_64_522 VDD VSS FILLER4
XFILLER_92_853 VSS VDD FILLER2
X_18655_ _18846_/CK _18655_/D _18655_/Q VDD VSS DFFQX1
X_15867_ _15867_/A _15867_/B VDD VSS _15872_/C XOR2X1
XFILLER_92_886 VDD VSS DECAPHV8
Xwire28 wire28/A VDD VSS wire28/Y BUFX4
X_17606_ _17669_/CK _17606_/D _17606_/Q VDD VSS DFFQX1
X_14818_ _14903_/A _14818_/B VDD VSS _18582_/D NOR2X1
XFILLER_17_460 VDD VSS FILLER4
XTAP_TAPCELL_ROW_34_425 VDD VSS WELLTAP
X_18586_ clkload8/A _18586_/D _18586_/Q VDD VSS DFFQX1
X_15798_ _18860_/Q _18861_/Q VDD VSS _15798_/Y NOR2X1
XTAP_TAPCELL_ROW_62_767 VDD VSS WELLTAP
X_17537_ _17536_/Y _17537_/B VDD VSS _17732_/D NOR2BX1
X_14749_ _14751_/A _14751_/B _14749_/C VDD VSS _18567_/D AOI21X1
XTAP_TAPCELL_ROW_102_1247 VDD VSS WELLTAP
X_17468_ _17561_/C _17468_/B VDD VSS _17673_/D AND2X1
XFILLER_20_658 VDD VSS FILLER1
XTAP_TAPCELL_ROW_14_182 VDD VSS WELLTAP
X_16419_ _18909_/Q _16527_/B VDD VSS _16420_/C NAND2X1
XFILLER_121_1022 VDD VSS FILLER1
XFILLER_73_0 VDD VSS DECAPHV32
X_17399_ _17410_/A _17399_/B VDD VSS _17608_/D NOR2X1
XFILLER_118_557 VSS VDD FILLER2
XFILLER_69_1115 VDD VSS FILLER1
XFILLER_102_903 VSS VDD FILLER2
XFILLER_86_113 VDD VSS DECAPHV16
XFILLER_99_474 VSS VDD FILLER2
XTAP_TAPCELL_ROW_113_1376 VDD VSS WELLTAP
XFILLER_59_349 VDD VSS DECAPHV16
XFILLER_101_468 VDD VSS DECAPHV8
XFILLER_68_872 VSS VDD FILLER2
XFILLER_80_1072 VSS VDD FILLER2
X_09724_ _09741_/A _09741_/B VDD VSS _17453_/B XOR2X1
XFILLER_27_213 VDD VSS FILLER4
XFILLER_67_371 VDD VSS FILLER1
X_09655_ _19047_/Q _17348_/B VDD VSS _09681_/A NOR2X1
XFILLER_27_268 VDD VSS FILLER1
XFILLER_70_514 VDD VSS FILLER1
X_09586_ _09604_/A _09604_/B VDD VSS _17448_/B XNOR2X1
XFILLER_11_603 VDD VSS DECAPHV32
XFILLER_24_975 VDD VSS FILLER1
XFILLER_10_113 VDD VSS DECAPHV8
X_10430_ _10434_/A _10430_/B VDD VSS _10614_/B XNOR2X1
XFILLER_10_179 VDD VSS FILLER1
XFILLER_12_53 VDD VSS FILLER1
X_10361_ _10154_/Y _10556_/B _10556_/C VDD VSS _17874_/D AND3BX1
XFILLER_2_323 VSS VDD FILLER2
XFILLER_3_835 VSS VDD FILLER2
X_10292_ _17841_/Q VDD VSS _10299_/A INVX1
X_12100_ _18411_/Q VDD VSS _12105_/A INVX1
X_13080_ _13080_/A _14267_/B _13080_/C _13080_/D VDD VSS _13287_/A AOAI211X1
XFILLER_105_741 VSS VDD FILLER2
XFILLER_78_603 VDD VSS FILLER1
X_12031_ _12032_/A _12032_/B _12032_/D _12032_/C VDD VSS _12146_/B OAOI211X1
XFILLER_105_796 VSS VDD FILLER2
XFILLER_120_700 VDD VSS FILLER4
XFILLER_120_722 VDD VSS FILLER1
XFILLER_77_168 VSS VDD FILLER2
XFILLER_93_628 VSS VDD FILLER2
X_16770_ _16770_/A _16770_/B _16770_/C _16770_/D VDD VSS _16771_/C AOAI211X1
X_13982_ _13984_/B _14013_/A _13982_/C VDD VSS _13983_/B OR3BX1
XFILLER_20_1107 VDD VSS FILLER1
XFILLER_46_522 VDD VSS FILLER4
X_12933_ _12933_/A _12933_/B _12933_/C _12933_/D VDD VSS _13170_/A AOAI211X1
X_15721_ _18934_/Q _15730_/C VDD VSS _15721_/Y XNOR2X1
XFILLER_18_235 VSS VDD FILLER2
XFILLER_74_886 VDD VSS DECAPHV8
X_18440_ _18461_/CK _18440_/D _18440_/Q VDD VSS DFFQX1
XFILLER_2_1072 VDD VSS DECAPHV32
XFILLER_33_205 VDD VSS FILLER1
X_12864_ _18237_/Q _13071_/A _13071_/B VDD VSS _12866_/C XNOR3X1
X_15652_ _15551_/B _15650_/Y _15651_/Y VDD VSS _15666_/C MUXI2X1
XFILLER_14_430 VDD VSS DECAPHV16
XFILLER_57_1052 VDD VSS DECAPHV8
X_11815_ _18461_/Q _14437_/B VDD VSS _11996_/B NOR2X1
X_12795_ _12940_/A _12940_/B _12940_/D _12940_/C VDD VSS _12933_/B AOAI211X1
X_18371_ _18397_/CK _18371_/D _18371_/Q VDD VSS DFFQX1
X_15583_ _15558_/Y _15662_/B _15596_/A VDD VSS _15583_/Y MUXI2X1
X_14603_ _18536_/Q _18568_/Q VDD VSS _14604_/B XOR2X1
XFILLER_109_1131 VDD VSS FILLER4
XFILLER_14_452 VDD VSS DECAPHV16
XFILLER_57_1085 VDD VSS DECAPHV8
X_11746_ _18200_/Q VDD VSS _11880_/A INVX1
X_17322_ _17323_/A _17322_/B VDD VSS _19023_/D NOR2X1
X_14534_ _14534_/A _14534_/B _14534_/C _14534_/D VDD VSS _14539_/C AOAI211X1
XFILLER_105_1017 VDD VSS FILLER4
X_17253_ _19007_/Q _17287_/B VDD VSS _17256_/A NAND2X1
X_11677_ _11750_/A _14166_/B VDD VSS _11803_/A OR2X2
X_16204_ _16257_/C _16257_/D _16204_/C _16257_/E VDD VSS _16205_/C AO211X2
X_14465_ _14480_/A _14465_/B VDD VSS _18487_/D NOR2X1
XTAP_TAPCELL_ROW_11_152 VDD VSS WELLTAP
X_10628_ _10628_/A _10628_/B _10628_/C VDD VSS _10629_/B OR3X2
X_17184_ _18995_/Q _17232_/B VDD VSS _17193_/C XOR2X1
X_14396_ _14396_/A _14396_/B VDD VSS _18424_/D AND2X1
X_13416_ _18293_/Q _13416_/B _13416_/C VDD VSS _13417_/D XNOR3X1
XFILLER_128_877 VDD VSS FILLER4
X_10559_ _17875_/Q _10564_/B VDD VSS _10576_/A AND2X1
X_16135_ _16169_/A _16169_/B _16169_/C _16135_/D VDD VSS _16136_/E AOAI211X1
X_13347_ _13440_/A _13440_/B _13440_/C VDD VSS _13436_/A OAI21X1
XFILLER_6_695 VSS VDD FILLER2
X_13278_ _13278_/A _14394_/B _13278_/C _13278_/D VDD VSS _13457_/A OAOI211X1
X_16066_ _16121_/B _16066_/B VDD VSS _16067_/B XOR2X1
XFILLER_130_508 VSS VDD FILLER2
XFILLER_64_1012 VSS VDD FILLER2
X_12229_ _14230_/A _14230_/B _14230_/C _12229_/D VDD VSS _12419_/A OAOI211X1
X_15017_ _15020_/A _15020_/B _17229_/A VDD VSS _15018_/C OAI21X1
XFILLER_111_700 VDD VSS FILLER1
XFILLER_116_1102 VDD VSS DECAPHV32
XFILLER_123_571 VDD VSS DECAPHV8
XFILLER_68_146 VDD VSS FILLER1
XFILLER_37_500 VSS VDD FILLER2
XFILLER_84_628 VDD VSS FILLER1
XTAP_TAPCELL_ROW_67_826 VDD VSS WELLTAP
X_16968_ _16973_/A _16968_/B _16968_/C VDD VSS _18936_/D OAI21X1
XFILLER_37_511 VDD VSS DECAPHV16
XFILLER_49_382 VDD VSS DECAPHV8
XFILLER_65_842 VDD VSS FILLER1
X_18707_ _18815_/CK _18707_/D _18707_/Q VDD VSS DFFQX1
X_15919_ _15919_/A _15919_/B _15919_/C _15919_/D VDD VSS _15955_/A AOAI211X1
X_09440_ _17584_/Q VDD VSS _09441_/A INVX1
X_16899_ _16939_/A _16899_/B _16946_/A VDD VSS _16910_/A AOI21X1
XFILLER_24_205 VDD VSS DECAPHV8
XTAP_TAPCELL_ROW_19_241 VDD VSS WELLTAP
XTAP_TAPCELL_ROW_19_252 VDD VSS WELLTAP
XTAP_TAPCELL_ROW_47_583 VDD VSS WELLTAP
X_18638_ _19019_/CK _18638_/D _18638_/Q VDD VSS DFFQX1
XFILLER_75_1130 VSS VDD FILLER2
XFILLER_80_878 VDD VSS FILLER4
X_09371_ _17614_/Q _17405_/B VDD VSS _09373_/C XNOR2X1
X_18569_ clkload2/A _18569_/D _18569_/Q VDD VSS DFFQX1
XFILLER_33_761 VSS VDD FILLER2
XFILLER_33_772 VDD VSS FILLER1
XFILLER_21_945 VDD VSS FILLER1
XFILLER_119_811 VSS VDD FILLER2
XFILLER_21_989 VSS VDD FILLER2
XFILLER_106_527 VDD VSS FILLER1
XFILLER_133_346 VDD VSS DECAPHV16
XFILLER_102_700 VDD VSS FILLER1
XFILLER_88_934 VDD VSS FILLER1
XFILLER_58_49 VDD VSS DECAPHV32
XFILLER_59_146 VDD VSS FILLER1
XFILLER_87_433 VDD VSS FILLER1
XFILLER_87_455 VSS VDD FILLER2
XFILLER_99_282 VDD VSS DECAPHV8
XFILLER_59_179 VSS VDD FILLER2
XFILLER_114_44 VSS VDD FILLER2
X_09707_ _09707_/A _09707_/B _09707_/C VDD VSS _09710_/B OAI21X1
XFILLER_28_566 VDD VSS FILLER1
XFILLER_83_650 VDD VSS FILLER1
XTAP_TAPCELL_ROW_126_1534 VDD VSS WELLTAP
XFILLER_56_886 VDD VSS FILLER1
XFILLER_70_300 VDD VSS DECAPHV8
XFILLER_82_171 VDD VSS DECAPHV8
X_09638_ _17688_/Q _17484_/B VDD VSS _09640_/C XNOR2X1
XFILLER_130_32 VDD VSS DECAPHV8
XFILLER_70_333 VDD VSS DECAPHV16
X_09569_ _19044_/Q _17345_/B VDD VSS _09573_/B XOR2X1
X_11600_ _11600_/A _11600_/B _14191_/B VDD VSS _11601_/B MIN3X1
X_12580_ _12799_/B _12606_/C VDD VSS _14358_/B NAND2X1
XFILLER_129_608 VSS VDD FILLER2
XFILLER_12_945 VDD VSS FILLER4
XFILLER_23_271 VSS VDD FILLER2
X_11531_ _11531_/A _11531_/B VDD VSS _11532_/C XNOR2X1
XFILLER_8_927 VSS VDD FILLER2
XFILLER_109_332 VDD VSS DECAPHV8
XFILLER_128_129 VDD VSS DECAPHV8
XFILLER_23_74 VDD VSS FILLER4
XFILLER_23_96 VDD VSS FILLER1
X_11462_ _18248_/Q _11530_/B _14219_/B VDD VSS _11521_/C XNOR3X1
X_14250_ _14252_/A _14250_/B VDD VSS _18300_/D NOR2X1
XFILLER_125_814 VDD VSS FILLER4
X_10413_ _10420_/A _10420_/B VDD VSS _10416_/A NOR2X1
X_11393_ _11399_/A _11399_/B _11399_/D _11399_/C VDD VSS _14075_/C OAI211X1
X_13201_ _13303_/A _13383_/B VDD VSS _14182_/B XNOR2X1
X_14181_ _14149_/Y _14181_/B _14181_/C VDD VSS _18239_/D AND3BX1
XFILLER_124_302 VDD VSS DECAPHV8
XFILLER_125_836 VDD VSS FILLER1
X_10344_ _17846_/Q _10352_/B VDD VSS _10541_/D _10352_/C NAND3X1
X_13132_ _18370_/Q _13273_/B _13273_/C VDD VSS _13350_/B XNOR3X1
XFILLER_3_0 VDD VSS DECAPHV32
XFILLER_3_654 VDD VSS DECAPHV32
XFILLER_133_880 VSS VDD FILLER2
XFILLER_2_142 VDD VSS DECAPHV32
X_10275_ _17839_/Q VDD VSS _10309_/A INVX1
X_13063_ _18344_/Q VDD VSS _13182_/A INVX1
X_17940_ _17941_/CK _17940_/D _17940_/Q VDD VSS DFFQX1
XFILLER_132_390 VDD VSS DECAPHV16
XFILLER_133_891 VDD VSS FILLER1
XFILLER_78_433 VSS VDD FILLER2
XFILLER_94_904 VSS VDD FILLER2
X_12014_ _12216_/A _12216_/B VDD VSS _14228_/B XNOR2X1
X_17871_ _17871_/CK _17871_/D _17871_/Q VDD VSS DFFQX1
XFILLER_120_563 VDD VSS FILLER1
XFILLER_120_574 VDD VSS DECAPHV16
X_16822_ _16595_/Y _16908_/B _16947_/A VDD VSS _16841_/B MUXI2X1
XFILLER_48_93 VDD VSS FILLER1
XFILLER_94_959 VDD VSS FILLER4
XFILLER_46_330 VDD VSS FILLER1
XFILLER_59_1103 VDD VSS DECAPHV8
XFILLER_74_661 VDD VSS FILLER4
XFILLER_98_1130 VDD VSS FILLER4
X_16753_ _16780_/C _16753_/B VDD VSS _16757_/B XNOR2X1
X_13965_ _18939_/Q _18938_/Q _18940_/Q _18941_/Q VDD VSS _13966_/C AOI31X1
XFILLER_34_514 VDD VSS FILLER4
XFILLER_47_886 VSS VDD FILLER2
X_12916_ _12916_/A _12916_/B _14480_/B VDD VSS _12917_/B MIN3X1
X_16684_ _16684_/A _16684_/B _16684_/C VDD VSS _16686_/B OA21X2
X_15704_ _15704_/A _15707_/C VDD VSS _17010_/A XNOR2X1
X_13896_ _18460_/Q _14436_/B VDD VSS _13917_/A XNOR2X1
XFILLER_34_547 VDD VSS FILLER4
XFILLER_61_322 VSS VDD FILLER2
XFILLER_64_81 VDD VSS DECAPHV32
XTAP_TAPCELL_ROW_16_211 VDD VSS WELLTAP
X_12847_ _12965_/B _12848_/C _18288_/Q VDD VSS _12849_/C AOI21X1
X_18423_ _18448_/CK _18423_/D _18423_/Q VDD VSS DFFQX1
X_15635_ _15610_/B _15661_/B _15685_/A VDD VSS _15686_/B MUX2X1
XTAP_TAPCELL_ROW_44_542 VDD VSS WELLTAP
XTAP_TAPCELL_ROW_72_884 VDD VSS WELLTAP
X_18354_ _18408_/CK _18354_/D _18354_/Q VDD VSS DFFQX1
XFILLER_9_32 VDD VSS DECAPHV32
X_12778_ _12783_/A _12783_/B _12779_/D _12783_/D VDD VSS _14064_/A OA211X2
X_17305_ _17306_/A _17305_/B _17305_/C VDD VSS _19017_/D AOI21X1
X_15566_ _15566_/A VDD VSS _15567_/B INVX1
X_11729_ _18382_/Q _11729_/B _11820_/C VDD VSS _12102_/B MIN3X1
X_18285_ _18309_/CK _18285_/D _18285_/Q VDD VSS DFFQX1
X_15497_ _15478_/Y _15496_/Y _16757_/D VDD VSS _15497_/Y MUX2X1
X_14517_ _14517_/A _14517_/B VDD VSS _18518_/D NOR2X1
XFILLER_31_1022 VDD VSS FILLER1
X_17236_ _17236_/A _17236_/B VDD VSS _17241_/A NAND2X1
X_14448_ _14451_/A _14448_/B VDD VSS _18471_/D NOR2X1
XFILLER_31_1066 VSS VDD FILLER2
X_17167_ _18991_/Q VDD VSS _17168_/A INVX1
XFILLER_115_302 VDD VSS FILLER4
XFILLER_115_324 VDD VSS FILLER1
XFILLER_127_184 VSS VDD FILLER2
X_16118_ _16456_/A _16118_/B _16118_/C VDD VSS _18901_/D OAI21X1
X_14379_ _14542_/A VDD VSS _14389_/A BUFX3
X_17098_ _17098_/A VDD VSS _17099_/B INVX1
XFILLER_115_368 VDD VSS FILLER4
XFILLER_115_379 VDD VSS DECAPHV8
XFILLER_88_208 VDD VSS FILLER1
X_08940_ _17747_/Q _18536_/Q _08940_/C VDD VSS _08944_/B MIN3X1
X_16049_ _16082_/A _16049_/B VDD VSS _16049_/Y XNOR2X1
XFILLER_36_0 VDD VSS DECAPHV32
XTAP_TAPCELL_ROW_110_1335 VDD VSS WELLTAP
X_08871_ _18031_/Q _18032_/Q VDD VSS wire34/A _08876_/B NAND3X1
XFILLER_57_628 VSS VDD FILLER2
XFILLER_84_403 VDD VSS DECAPHV8
XFILLER_97_764 VSS VDD FILLER2
XFILLER_56_105 VSS VDD FILLER2
XFILLER_69_488 VDD VSS DECAPHV16
XFILLER_97_797 VDD VSS FILLER1
XFILLER_37_341 VSS VDD FILLER2
XFILLER_84_458 VDD VSS FILLER4
XFILLER_53_867 VDD VSS FILLER4
XFILLER_92_480 VSS VDD FILLER2
X_09423_ _17508_/B _17711_/Q _09423_/C VDD VSS _09449_/B MIN3X1
X_09354_ _09354_/A _09354_/B VDD VSS _09355_/C NOR2X1
XTAP_TAPCELL_ROW_121_1475 VDD VSS WELLTAP
X_09285_ _17739_/Q _17707_/Q VDD VSS _09286_/B XNOR2X1
XFILLER_107_814 VSS VDD FILLER2
XFILLER_107_858 VDD VSS DECAPHV16
XFILLER_109_88 VDD VSS FILLER4
XFILLER_121_316 VSS VDD FILLER2
XFILLER_133_176 VDD VSS DECAPHV8
XFILLER_102_530 VDD VSS DECAPHV8
XFILLER_125_32 VDD VSS DECAPHV32
X_10060_ _17807_/Q _10060_/B _10060_/C VDD VSS _10061_/C OR3BX1
XFILLER_134_1043 VDD VSS DECAPHV16
XFILLER_75_436 VSS VDD FILLER2
XFILLER_16_503 VDD VSS DECAPHV8
XFILLER_90_417 VDD VSS FILLER1
XFILLER_90_428 VDD VSS FILLER4
XTAP_TAPCELL_ROW_87_1061 VDD VSS WELLTAP
X_10962_ _10965_/C _10962_/B VDD VSS _11103_/B XNOR2X1
X_13750_ _13750_/A _14373_/B _14373_/C VDD VSS _13751_/D NOR3X1
XFILLER_16_536 VDD VSS FILLER4
XFILLER_16_558 VDD VSS FILLER1
XFILLER_44_856 VDD VSS FILLER1
X_12701_ _12916_/B _12704_/B _12701_/C VDD VSS _18040_/D AOI2B1X1
XFILLER_34_40 VDD VSS FILLER4
X_10893_ _10896_/A _10896_/B VDD VSS _11033_/B XNOR2X1
X_15420_ _15526_/A _15420_/B _15420_/C VDD VSS _15421_/C OAI21X1
X_13681_ _14428_/A _14428_/B _14428_/C _13681_/D VDD VSS _13792_/A OAOI211X1
XFILLER_34_73 VSS VDD FILLER2
XTAP_TAPCELL_ROW_41_512 VDD VSS WELLTAP
X_12632_ _12844_/A _12844_/B _12844_/D _12844_/C VDD VSS _14264_/C AOI211X1
XFILLER_12_764 VDD VSS DECAPHV8
XFILLER_15_1017 VSS VDD FILLER2
X_12563_ _18984_/Q _18105_/Q VDD VSS _12783_/A XNOR2X1
X_15351_ _15815_/C VDD VSS _16316_/A BUFX3
XFILLER_129_449 VSS VDD FILLER2
XTAP_TAPCELL_ROW_5_77 VDD VSS WELLTAP
X_11514_ _18275_/Q _11594_/B _11594_/C VDD VSS _11591_/C XNOR3X1
X_12494_ _12469_/Y _12577_/B _18364_/Q VDD VSS _12614_/B NAND3BX1
X_18070_ _18805_/CK _18070_/D _18070_/Q VDD VSS DFFQX1
X_15282_ _17388_/A _18850_/Q VDD VSS _18823_/D AND2X1
X_14302_ _14423_/A _14302_/B VDD VSS _18343_/D AND2X1
X_11445_ _11446_/A _11446_/B _11446_/D _11446_/C VDD VSS _14048_/B AO211X2
X_17021_ _18000_/Q _17022_/B VDD VSS _17026_/C NAND2X1
X_14233_ _14198_/Y _14233_/B _14233_/C VDD VSS _18285_/D AND3BX1
XTAP_TAPCELL_ROW_98_1190 VDD VSS WELLTAP
X_11376_ _18194_/Q _11378_/B _14132_/B VDD VSS _14160_/B XNOR3X1
X_14164_ _14191_/A _14164_/B VDD VSS _18223_/D NOR2X1
XFILLER_113_828 VDD VSS DECAPHV8
XFILLER_4_974 VSS VDD FILLER2
XFILLER_98_539 VSS VDD FILLER2
X_10327_ _10154_/Y _10511_/B _10521_/B VDD VSS _17870_/D AND3BX1
X_13115_ _13115_/A _14095_/B _13115_/C _13115_/D VDD VSS _13223_/B AOAI211X1
X_18972_ _18988_/CK _18972_/D _18972_/Q VDD VSS DFFQX1
X_14095_ _14074_/Y _14095_/B _14095_/C VDD VSS _18160_/D AND3BX1
XFILLER_79_742 VSS VDD FILLER2
X_10258_ _17835_/Q _10262_/B VDD VSS _10259_/B XNOR2X1
X_13046_ _13058_/A _13046_/B _13170_/D VDD VSS _13159_/C XNOR3X1
X_17923_ _18000_/CK _17923_/D _17923_/Q VDD VSS DFFQX1
XFILLER_26_1135 VDD VSS FILLER1
XFILLER_59_92 VDD VSS FILLER1
XFILLER_61_1026 VDD VSS DECAPHV8
XFILLER_79_797 VSS VDD FILLER2
XTAP_TAPCELL_ROW_49_601 VDD VSS WELLTAP
XTAP_TAPCELL_ROW_49_612 VDD VSS WELLTAP
X_10189_ _10154_/Y _10379_/B _10379_/C VDD VSS _17849_/D AND3BX1
X_17854_ _17854_/CK _17854_/D _17854_/Q VDD VSS DFFQX1
XFILLER_19_330 VDD VSS FILLER1
XFILLER_66_458 VDD VSS FILLER4
XTAP_TAPCELL_ROW_77_943 VDD VSS WELLTAP
X_17785_ _17865_/CK _17785_/D _17785_/Q VDD VSS DFFQX1
X_16805_ _16947_/A _16899_/B _16805_/C VDD VSS _16817_/B AOI21X1
X_14997_ _18998_/Q VDD VSS _14998_/B INVX1
XFILLER_75_80 VDD VSS DECAPHV8
XFILLER_81_406 VSS VDD FILLER2
XFILLER_81_417 VDD VSS DECAPHV8
X_16736_ _16939_/A _16736_/B VDD VSS _16737_/C NOR2X1
X_13948_ _18954_/Q _18955_/Q VDD VSS _14005_/B _14002_/B NAND3X1
XFILLER_35_867 VDD VSS FILLER1
XFILLER_62_631 VDD VSS FILLER1
XFILLER_34_344 VSS VDD FILLER2
XFILLER_62_664 VSS VDD FILLER2
XFILLER_90_973 VSS VDD FILLER2
XFILLER_90_995 VDD VSS DECAPHV8
X_18406_ _18406_/CK _18406_/D _18406_/Q VDD VSS DFFQX1
X_16667_ _16857_/A _16667_/B VDD VSS _16668_/C NOR2X1
X_13879_ wire26/Y _13898_/B _13898_/C VDD VSS _13895_/C OAI21X1
XFILLER_72_1100 VSS VDD FILLER2
X_16598_ _18914_/Q _16637_/C VDD VSS _16599_/B XOR2X1
X_15618_ _15621_/C _15618_/B VDD VSS _16996_/A NAND2X1
X_18337_ _18337_/CK _18337_/D _18337_/Q VDD VSS DFFQX1
X_15549_ _15673_/A _15549_/B _15549_/C _15572_/A VDD VSS _15550_/C OAOI211X1
X_09070_ _09099_/A _09099_/B VDD VSS _17393_/B XNOR2X1
X_18268_ _18295_/CK _18268_/D _18268_/Q VDD VSS DFFQX1
X_17219_ _17224_/A _17219_/B VDD VSS _19001_/D NOR2X1
XFILLER_129_983 VDD VSS DECAPHV8
X_18199_ _18199_/CK _18199_/D _18199_/Q VDD VSS DFFQX1
XFILLER_115_176 VDD VSS DECAPHV8
XFILLER_89_528 VDD VSS DECAPHV16
X_09972_ _17797_/Q _09972_/B VDD VSS _09986_/A NAND2X1
XFILLER_118_1027 VSS VDD FILLER2
XFILLER_130_113 VDD VSS DECAPHV16
X_08923_ _08926_/C _17514_/A _08923_/C VDD VSS _17744_/D AND3BX1
XFILLER_85_701 VDD VSS DECAPHV8
XFILLER_97_561 VDD VSS FILLER1
XFILLER_111_371 VDD VSS FILLER1
XFILLER_29_138 VSS VDD FILLER2
XFILLER_38_683 VDD VSS FILLER4
XFILLER_66_981 VDD VSS FILLER1
XFILLER_73_929 VDD VSS FILLER1
XTAP_TAPCELL_ROW_27_339 VDD VSS WELLTAP
XFILLER_41_804 VSS VDD FILLER2
XFILLER_13_528 VSS VDD FILLER2
XFILLER_25_399 VSS VDD FILLER2
X_09406_ _09414_/C _09406_/B VDD VSS _17338_/B NAND2X1
X_09337_ _17740_/Q VDD VSS _17505_/B INVX1
XFILLER_21_561 VDD VSS FILLER4
X_09268_ _19033_/Q _17333_/B VDD VSS _09271_/C XNOR2X1
XFILLER_21_594 VDD VSS DECAPHV8
XFILLER_14_1072 VDD VSS DECAPHV8
XTAP_TAPCELL_ROW_134_1622 VDD VSS WELLTAP
X_09199_ _09188_/A _09199_/B _09199_/C VDD VSS _09222_/B AOI2B1X1
XFILLER_101_1042 VDD VSS FILLER1
XFILLER_49_1102 VSS VDD FILLER2
X_11230_ _18962_/Q _18083_/Q VDD VSS _11240_/A OR2X2
XFILLER_107_666 VSS VDD FILLER2
XFILLER_135_997 VDD VSS DECAPHV16
X_11161_ _17989_/Q _11161_/B _11161_/C VDD VSS _11165_/B MIN3X1
XFILLER_1_933 VDD VSS DECAPHV32
X_10112_ _17816_/Q _10121_/B _10121_/C VDD VSS _10296_/B XNOR3X1
X_11092_ _17031_/B VDD VSS _17036_/B INVX1
XFILLER_0_498 VDD VSS DECAPHV32
XFILLER_49_937 VDD VSS DECAPHV8
X_10043_ _10046_/D _10043_/B VDD VSS _10046_/C NAND2X1
X_14920_ _18604_/Q _18636_/Q VDD VSS _14922_/B XOR2X1
XFILLER_21_1010 VSS VDD FILLER2
X_14851_ _14852_/A _14853_/C _17229_/A VDD VSS _14852_/C OAI21X1
XFILLER_29_650 VDD VSS FILLER1
XTAP_TAPCELL_ROW_74_902 VDD VSS WELLTAP
Xhold95 input2/Y VDD VSS hold95/Y BUFX3
X_17570_ _19028_/CK _17570_/D _17570_/Q VDD VSS DFFQX1
X_13802_ _13847_/A _13847_/B _13847_/E VDD VSS _13811_/B AOI21X1
XFILLER_16_311 VDD VSS DECAPHV8
XFILLER_29_694 VDD VSS DECAPHV8
XFILLER_44_642 VDD VSS FILLER4
XFILLER_56_491 VDD VSS FILLER4
X_11994_ _18462_/Q VDD VSS _11996_/A INVX1
X_16521_ _16521_/A VDD VSS _16869_/A BUFX3
X_14782_ _14787_/C _14782_/B VDD VSS _14783_/B XNOR2X1
XFILLER_17_867 VSS VDD FILLER2
XFILLER_71_461 VDD VSS FILLER4
X_10945_ _17043_/A _11081_/B VDD VSS _17974_/D AND2X1
X_13733_ _13733_/A _14493_/B _13733_/C _13733_/D VDD VSS _13827_/A AOAI211X1
XFILLER_31_314 VSS VDD FILLER2
XTAP_TAPCELL_ROW_54_670 VDD VSS WELLTAP
X_10876_ _10879_/C _10876_/B VDD VSS _11014_/B XNOR2X1
X_16452_ _16452_/A _16452_/B VDD VSS _16490_/B NAND2X1
X_13664_ _14400_/B _18427_/Q VDD VSS _13667_/A NAND2BX1
X_12615_ _18339_/Q VDD VSS _12723_/A INVX1
X_16383_ _18908_/Q _16383_/B VDD VSS _16423_/A NAND2X1
X_15403_ _16018_/C VDD VSS _16783_/D BUFX3
X_18122_ _18982_/CK _18122_/D _18122_/Q VDD VSS DFFQX1
X_15334_ _18861_/Q _18862_/Q VDD VSS _15801_/A OR2X2
X_13595_ _13653_/A _13653_/B _13653_/C VDD VSS _14457_/C NOR3X1
XFILLER_12_583 VDD VSS FILLER1
X_12546_ _18155_/Q _14090_/B _14090_/C VDD VSS _12550_/D OR3BX1
X_12477_ _12588_/A _14478_/B VDD VSS _12587_/C OR2X2
X_18053_ _18851_/CK _18053_/D _18053_/Q VDD VSS DFFQX1
X_15265_ _15295_/A _18833_/Q VDD VSS _18806_/D AND2X1
XANTENNA_4 _17533_/A VDD VSS ANTENNA2
XFILLER_126_942 VSS VDD FILLER2
XFILLER_6_44 VSS VDD FILLER2
XFILLER_99_804 VDD VSS FILLER4
X_11428_ _11428_/A _11428_/B _11428_/C _11428_/D VDD VSS _11483_/A OAOI211X1
X_17004_ _17004_/A _17006_/B _17004_/C VDD VSS _18952_/D OAI21X1
X_15196_ _15307_/A _18765_/Q VDD VSS _18738_/D AND2X1
X_14216_ _15300_/A _14216_/B VDD VSS _18272_/D AND2X1
XFILLER_126_975 VDD VSS FILLER1
XFILLER_98_314 VDD VSS FILLER1
X_11359_ _11359_/A _14046_/B _14046_/C VDD VSS _11388_/C NOR3X1
X_14147_ _14108_/Y _14147_/B _14147_/C VDD VSS _18208_/D AND3BX1
XFILLER_112_113 VDD VSS DECAPHV16
XFILLER_4_793 VDD VSS DECAPHV32
XFILLER_98_336 VDD VSS DECAPHV16
XFILLER_79_561 VSS VDD FILLER2
X_18955_ _18958_/CK _18955_/D _18955_/Q VDD VSS DFFQX1
X_14078_ _14074_/Y _14078_/B _14078_/C VDD VSS _18145_/D AND3BX1
XFILLER_100_319 VDD VSS FILLER4
XFILLER_67_712 VDD VSS FILLER1
X_13029_ _13248_/A _13248_/B _14484_/B VDD VSS _13033_/C XNOR3X1
X_18886_ _18958_/CK _18886_/D _18886_/Q VDD VSS DFFQX1
X_17906_ _17908_/CK _17906_/D _17906_/Q VDD VSS DFFQX1
XFILLER_67_778 VSS VDD FILLER2
XFILLER_6_1059 VDD VSS DECAPHV8
X_17837_ _17865_/CK _17837_/D _17837_/Q VDD VSS DFFQX1
XFILLER_48_970 VDD VSS FILLER4
XFILLER_54_417 VDD VSS FILLER1
XFILLER_66_288 VDD VSS FILLER1
X_17768_ _19036_/CK _17768_/D _17768_/Q VDD VSS DFFQX1
X_17699_ _17701_/CK _17699_/D _17699_/Q VDD VSS DFFQX1
X_16719_ _16718_/B _16719_/B VDD VSS _16725_/C NAND2BX1
XTAP_TAPCELL_ROW_105_1278 VDD VSS WELLTAP
XTAP_TAPCELL_ROW_24_309 VDD VSS WELLTAP
XFILLER_22_336 VSS VDD FILLER2
XFILLER_124_1020 VDD VSS FILLER4
X_09122_ _17604_/Q _17394_/B VDD VSS _09123_/C NOR2X1
XTAP_TAPCELL_ROW_32_397 VDD VSS WELLTAP
X_09053_ _09086_/A VDD VSS _09054_/C INVX1
XFILLER_132_912 VDD VSS FILLER4
XFILLER_132_923 VSS VDD FILLER2
XFILLER_132_945 VDD VSS FILLER4
XFILLER_89_325 VDD VSS DECAPHV8
XFILLER_103_157 VSS VDD FILLER2
XFILLER_132_967 VDD VSS DECAPHV8
X_09955_ _09955_/A _09959_/C VDD VSS _10158_/B XNOR2X1
X_08906_ _17735_/Q _18524_/Q _17545_/A VDD VSS _17547_/B MIN3X1
X_09886_ _17761_/Q _17787_/Q _09886_/C VDD VSS _09887_/D XNOR3X1
XFILLER_100_853 VDD VSS FILLER4
XFILLER_66_49 VDD VSS DECAPHV32
XFILLER_57_266 VSS VDD FILLER2
XFILLER_58_789 VDD VSS FILLER1
XFILLER_73_715 VDD VSS DECAPHV8
XFILLER_122_44 VSS VDD FILLER2
XFILLER_54_940 VDD VSS FILLER1
XFILLER_57_299 VDD VSS FILLER4
XFILLER_72_214 VDD VSS FILLER4
XFILLER_26_653 VDD VSS FILLER1
XFILLER_54_984 VSS VDD FILLER2
XTAP_TAPCELL_ROW_84_1031 VDD VSS WELLTAP
XFILLER_14_837 VDD VSS FILLER1
XFILLER_54_995 VSS VDD FILLER2
X_10730_ _10733_/A _10733_/B VDD VSS _10864_/B XNOR2X1
XFILLER_15_64 VDD VSS FILLER1
XFILLER_40_122 VDD VSS DECAPHV16
XFILLER_41_645 VDD VSS FILLER4
X_10661_ _17893_/Q _10661_/B _10661_/C VDD VSS _10665_/C MIN3X1
XFILLER_16_1112 VDD VSS FILLER1
XFILLER_16_1123 VDD VSS DECAPHV8
XFILLER_90_1052 VSS VDD FILLER2
X_12400_ _12400_/A _12484_/B _14414_/B VDD VSS _12593_/B MIN3X1
X_10592_ _10593_/B _10593_/C _17879_/Q VDD VSS _10594_/C AOI21X1
X_13380_ _13380_/A _13380_/B _13380_/C VDD VSS _13395_/B XNOR3X1
XFILLER_31_52 VSS VDD FILLER2
X_12331_ _12331_/A _12331_/B _12331_/C _12331_/D VDD VSS _14173_/B OAOI211X1
XTAP_TAPCELL_ROW_2_45 VDD VSS WELLTAP
X_12262_ _18981_/Q _18102_/Q VDD VSS _12361_/C XOR2X1
X_15050_ _15054_/C _15050_/B VDD VSS _15051_/B XNOR2X1
XFILLER_103_0 VDD VSS DECAPHV32
XFILLER_123_901 VDD VSS FILLER1
XFILLER_31_96 VDD VSS FILLER1
XTAP_TAPCELL_ROW_95_1160 VDD VSS WELLTAP
X_11213_ _18027_/Q _18026_/Q _18028_/Q _11213_/D VDD VSS _18028_/D AOI31X1
Xoutput6 output6/A VDD VSS data_out[12] BUFX3
X_14001_ _14013_/A _14001_/B _14008_/C _14013_/D VDD VSS _18077_/D OAOI211X1
X_12193_ _18438_/Q _12193_/B _12193_/C VDD VSS _14440_/B XNOR3X1
X_11144_ _17986_/Q _11144_/B VDD VSS _11150_/A NAND2X1
XFILLER_0_273 VDD VSS DECAPHV32
XFILLER_48_200 VDD VSS FILLER4
X_11075_ _17043_/A _17020_/B VDD VSS _17999_/D AND2X1
X_18740_ _18821_/CK _18740_/D _18740_/Q VDD VSS DFFQX1
X_15952_ _15952_/A VDD VSS _15955_/D INVX1
XFILLER_48_211 VDD VSS FILLER4
XFILLER_76_520 VDD VSS FILLER1
XFILLER_76_531 VDD VSS FILLER1
X_10026_ _10029_/A _10029_/B VDD VSS _10227_/C XOR2X1
X_18671_ _18780_/CK _18671_/D _18671_/Q VDD VSS DFFQX1
X_14903_ _14903_/A _14903_/B VDD VSS _18600_/D NOR2X1
XFILLER_36_406 VDD VSS FILLER4
XFILLER_36_417 VDD VSS FILLER1
XFILLER_49_789 VDD VSS DECAPHV8
XFILLER_64_726 VDD VSS FILLER1
X_17622_ _17656_/CK _17622_/D _17622_/Q VDD VSS DFFQX1
X_15883_ _15925_/A _15925_/B _15925_/C _15883_/D VDD VSS _15911_/C AOAI211X1
XFILLER_36_428 VSS VDD FILLER2
X_14834_ _18585_/Q _18617_/Q VDD VSS _14835_/D NAND2X1
XFILLER_63_247 VDD VSS FILLER4
XFILLER_63_269 VSS VDD FILLER2
X_11977_ _18281_/Q _12118_/A _12216_/B VDD VSS _12016_/D XNOR3X1
X_17553_ _17739_/Q _18528_/Q VDD VSS _17555_/B XOR2X1
X_14765_ _14769_/A _14766_/B _17266_/C VDD VSS _14766_/C OAI21X1
XFILLER_17_686 VDD VSS FILLER1
XFILLER_45_995 VDD VSS DECAPHV16
XFILLER_60_932 VDD VSS FILLER1
X_10928_ _10928_/A _10928_/B _10928_/C VDD VSS _11064_/B MIN3X1
X_17484_ _17523_/A _17484_/B VDD VSS _17688_/D AND2X1
X_16504_ _18797_/Q _18743_/Q VDD VSS _16506_/B XOR2X1
X_13716_ _13774_/A _13774_/B _13716_/C VDD VSS _18051_/D AOI21X1
XFILLER_20_807 VDD VSS FILLER1
XFILLER_31_111 VSS VDD FILLER2
XFILLER_31_133 VSS VDD FILLER2
XFILLER_44_494 VDD VSS FILLER1
X_16435_ _18848_/Q _18686_/Q _16435_/C VDD VSS _16478_/A MIN3X1
X_14696_ _14696_/A _14696_/B VDD VSS _18556_/D NOR2X1
XFILLER_13_881 VDD VSS FILLER1
XFILLER_20_829 VSS VDD FILLER2
XFILLER_31_155 VSS VDD FILLER2
XFILLER_72_81 VDD VSS DECAPHV32
X_10859_ _17932_/Q _10864_/B VDD VSS _10863_/B XNOR2X1
X_13647_ _18480_/Q _13784_/A _13784_/B VDD VSS _13649_/C XNOR3X1
X_16366_ _18819_/Q _18711_/Q VDD VSS _16390_/A NAND2X1
X_13578_ _18505_/Q _13655_/A _13655_/B VDD VSS _13580_/C XNOR3X1
X_12529_ _12652_/B _14204_/C _18260_/Q VDD VSS _12530_/D AND3BX1
X_18105_ _18985_/CK _18105_/D _18105_/Q VDD VSS DFFQX1
X_16297_ _16284_/Y _16297_/B _16297_/C VDD VSS _16299_/B AND3BX1
X_15317_ _15318_/A _18056_/Q VDD VSS _18855_/D AND2X1
X_18036_ _18838_/CK _18036_/D _18036_/Q VDD VSS DFFQX1
X_15248_ _15250_/A _18816_/Q VDD VSS _18789_/D AND2X1
XFILLER_119_1111 VDD VSS FILLER4
XFILLER_125_282 VDD VSS DECAPHV16
X_15179_ _15318_/A _18748_/Q VDD VSS _18721_/D AND2X1
XFILLER_114_989 VDD VSS FILLER1
XFILLER_28_1027 VSS VDD FILLER2
XFILLER_87_829 VDD VSS DECAPHV8
XFILLER_101_639 VSS VDD FILLER2
X_09740_ _17691_/Q _17487_/B VDD VSS _09747_/A NAND2BX1
X_18938_ _18951_/CK _18938_/D _18938_/Q VDD VSS DFFQX1
.ends
