.subckt dsm2_core vi vcm di_clk di_ena di_rst_b di_trim[3] di_trim[2] di_trim[1] di_trim[0] di_dith_en di_dith_amp[1]
+ di_dith_amp[0] di_vcm_ext di_btest_en di_qout_en do_q do_q_b do_q_dec ibias_test vdd vss di_osc_en di_clk_sel do_clk_osc do_osc_oe
*.PININFO di_ena:I di_rst_b:I di_trim[3:0]:I di_dith_en:I di_dith_amp[1:0]:I di_vcm_ext:I di_btest_en:I di_qout_en:I vdd:B vss:B
*+ ibias_test:B vcm:B vi:I di_clk:I do_q:O do_q_b:O do_q_dec:O di_osc_en:I di_clk_sel:I do_clk_osc:O do_osc_oe:O
xio vdd vss di_ena di_rst_b di_trim[3] di_trim[2] di_trim[1] di_trim[0] di_dith_en di_dith_amp[1] di_dith_amp[0] di_vcm_ext
+ di_btest_en di_qout_en d_ena d_rst_b d_trim_b[3] d_trim_b[2] d_trim_b[1] d_trim_b[0] d_dith_en d_dith_amp[1] d_dith_amp[0] d_btest_en
+ d_qout_en d_vcm_ext d_vcm_ext_b dsm2_io
xesd vdd vss ibias_test ibias_test_esd vcm vcm_esd vi vi_esd dsm2_io_esd
xsc vdd vss vi_esd vcm_esd d_phi1 d_phi2 d_qi d_qi_b ibias_200n d_ena vo_p vo_n sc_int2
xioclk vdd vss di_clk d_clk dsm2_io_clk
xclk d_clk_mod d_ena d_phi1 d_phi1_b d_phi2 d_phi2_b d_qclk vdd vss clk_noverlap
xvcmg vdd vss d_vcm_ext d_vcm_ext_b d_phi1_b d_phi2 d_vcm_phi1_b d_vcm_phi2 dsm2_io_vcmg
xvcm d_vcm_phi1_b d_vcm_phi2 vdd vss vcm_esd vcm_gen
xbias vdd vss d_ena d_trim_b[3] d_trim_b[2] d_trim_b[1] d_trim_b[0] ibias_200n d_btest_or ibias_bank bias_gm
xq vo_p vo_n d_qclk d_dith[2] d_dith[1] d_dith[0] d_amp_s[3] d_amp_s[2] d_amp_s[1] d_amp_s[0] d_amp_s_b[3] d_amp_s_b[2]
+ d_amp_s_b[1] d_amp_s_b[0] d_qi d_qi_b do_q do_q_b do_q_dec vdd d_ena d_rst_b d_dith_en d_qout_en vss quantizer2_top
xlfsr d_qclk d_dith_amp[1] d_dith_amp[0] d_dith[2] d_dith[1] d_dith[0] d_amp_s[3] d_amp_s[2] d_amp_s[1] d_amp_s[0] d_amp_s_b[3]
+ d_amp_s_b[2] d_amp_s_b[1] d_amp_s_b[0] vdd d_dith_en vss quantizer2_lfsr
MXMDN vss vdd vss vss sg13_lv_nmos w=840n l=1u ng=2 m=123
MXMDP vdd vss vdd vdd sg13_lv_pmos w=2u l=1u ng=2 m=123
xosc vdd vss di_osc_en di_clk_sel d_btest_en ibias_bank d_clk d_btest_or ibias_test_esd d_clk_mod do_clk_osc do_osc_oe dsm2_osc
.ends

* expanding   symbol:  dsm2_io.sym # of pins=19
.subckt dsm2_io vdd vss di_ena di_rst_b di_trim[3] di_trim[2] di_trim[1] di_trim[0] di_dith_en di_dith_amp[1] di_dith_amp[0]
+ di_vcm_ext di_btest_en di_qout_en do_ena do_rst_b do_trim_b[3] do_trim_b[2] do_trim_b[1] do_trim_b[0] do_dith_en do_dith_amp[1]
+ do_dith_amp[0] do_btest_en do_qout_en do_vcm_ext do_vcm_ext_b
*.PININFO vdd:B vss:B di_ena:I do_ena:O di_rst_b:I do_rst_b:O di_vcm_ext:I do_vcm_ext_b:O do_vcm_ext:O di_trim[3:0]:I
*+ do_trim_b[3:0]:O di_dith_en:I do_dith_en:O di_dith_amp[1:0]:I do_dith_amp[1:0]:O di_btest_en:I do_btest_en:O di_qout_en:I do_qout_en:O
XHE vdd vss di_ena d_ena_b dsm2_io_rx
MMPS vsw_p d_ena_b vdd vdd sg13_hv_pmos w=1u l=0.45u ng=1
MMPL do_ena vss vsw_p vdd sg13_hv_pmos w=1u l=5u ng=1
MMNL1 do_ena vdd vln1 vss sg13_hv_nmos w=1u l=10u ng=1
MMNL2 vln1 vdd vsw_n vss sg13_hv_nmos w=1u l=10u ng=1
MMNS vsw_n d_ena_b vss vss sg13_hv_nmos w=1u l=0.45u ng=1
MMCP vdd do_ena vdd vdd sg13_hv_pmos w=1u l=10u ng=1 m=2
MMCN vss do_ena vss vss sg13_hv_nmos w=1u l=5u ng=1 m=4
MMCD vdd vss vdd vdd sg13_hv_pmos w=1u l=5u ng=1 m=3
XHR vdd vss di_rst_b d_rst dsm2_io_rx
XLR do_rst_b d_rst vdd vss sg13cmos5l_inv_1
XHV vdd vss di_vcm_ext do_vcm_ext_b dsm2_io_rx
XLV do_vcm_ext do_vcm_ext_b vdd vss sg13cmos5l_inv_1
XHT[3] vdd vss di_trim[3] do_trim_b[3] dsm2_io_rx
XHT[2] vdd vss di_trim[2] do_trim_b[2] dsm2_io_rx
XHT[1] vdd vss di_trim[1] do_trim_b[1] dsm2_io_rx
XHT[0] vdd vss di_trim[0] do_trim_b[0] dsm2_io_rx
XHD vdd vss di_dith_en d_dith_en_b dsm2_io_rx
XLD do_dith_en d_dith_en_b vdd vss sg13cmos5l_inv_1
XHA[1] vdd vss di_dith_amp[1] d_dith_amp_b[1] dsm2_io_rx
XHA[0] vdd vss di_dith_amp[0] d_dith_amp_b[0] dsm2_io_rx
XLA[1] do_dith_amp[1] d_dith_amp_b[1] vdd vss sg13cmos5l_inv_1
XLA[0] do_dith_amp[0] d_dith_amp_b[0] vdd vss sg13cmos5l_inv_1
XHB vdd vss di_btest_en d_btest_en_b dsm2_io_rx
XLB do_btest_en d_btest_en_b vdd vss sg13cmos5l_inv_1
XHQ vdd vss di_qout_en d_qout_en_b dsm2_io_rx
XLQ do_qout_en d_qout_en_b vdd vss sg13cmos5l_inv_1
.ends

* expanding   symbol:  dsm2_io_esd.sym # of pins=8
.subckt dsm2_io_esd vdd vss ibias_test_pad ibias_test vcm_pad vcm vi_pad vi
*.PININFO vdd:B vss:B vi_pad:I vi:O vcm_pad:B vcm:B ibias_test_pad:B ibias_test:B
XSP1 vi vss vi_pad vdd vss sg13cmos5l_SecondaryProtection
XSP2 vcm vss vcm_pad vdd vss sg13cmos5l_SecondaryProtection
XSP3 ibias_test vss ibias_test_pad vdd vss sg13cmos5l_SecondaryProtection
.ends

* expanding   symbol:  sc_int2.sym # of pins=12
.subckt sc_int2 vdd vss vi vcm di_phi1 di_phi2 di_q di_q_b ibias_200n di_ena vo_p vo_n
*.PININFO vi:I ibias_200n:I di_ena:I di_phi1:I di_phi2:I vdd:B vss:B vcm:I di_q:I di_q_b:I vo_p:O vo_n:O
XS_TI vc1l_p vi di_phi1 d_phi1_b vdd vss sw_tgate
XS_TVA vc1l_p vh_p di_phi2 d_phi2_b vdd vss sw_tgate
XS_TVB vh_p vdd di_q di_q_b vdd vss sw_tgate
XS_TBA vc1l_p vl_p di_phi2 d_phi2_b vdd vss sw_tgate
XS_TBB vl_p vss di_q_b di_q vdd vss sw_tgate
CC1P[1] vc1r_p vc1l_p cap_cmomf w=3e-6 l=11.39e-6
C1P[0] vc1r_p vc1l_p cap_cmomf w=3e-6 l=11.39e-6
XS_TRV vc1r_p vvg_n di_phi2 d_phi2_b vdd vss sw_tgate
XS_TRC vc1r_p vcm di_phi1 d_phi1_b vdd vss sw_tgate
XS_BI vc1l_n vi di_phi2 d_phi2_b vdd vss sw_tgate
XS_BVA vc1l_n vh_n di_phi1 d_phi1_b vdd vss sw_tgate
XS_BVB vh_n vdd di_q di_q_b vdd vss sw_tgate
XS_BBA vc1l_n vl_n di_phi1 d_phi1_b vdd vss sw_tgate
XS_BBB vl_n vss di_q_b di_q vdd vss sw_tgate
CC1N[1] vc1r_n vc1l_n cap_cmomf w=3e-6 l=11.39e-6
C1N[0] vc1r_n vc1l_n cap_cmomf w=3e-6 l=11.39e-6
XS_BRV vc1r_n vvg_p di_phi2 d_phi2_b vdd vss sw_tgate
XS_BRC vc1r_n vcm di_phi1 d_phi1_b vdd vss sw_tgate
xamp1 vdd vfb vo_p vo_n vvg_p vvg_n ibias_200n di_ena vss vbn ota_fcasc2_top
CC2P[11] vvg_n vo_p cap_cmomf w=3e-6 l=11.39e-6
C2P[10] vvg_n vo_p cap_cmomf w=3e-6 l=11.39e-6
C2P[9] vvg_n vo_p cap_cmomf w=3e-6 l=11.39e-6
C2P[8] vvg_n vo_p cap_cmomf w=3e-6 l=11.39e-6
C2P[7] vvg_n vo_p cap_cmomf w=3e-6 l=11.39e-6
C2P[6] vvg_n vo_p cap_cmomf w=3e-6 l=11.39e-6
C2P[5] vvg_n vo_p cap_cmomf w=3e-6 l=11.39e-6
C2P[4] vvg_n vo_p cap_cmomf w=3e-6 l=11.39e-6
C2P[3] vvg_n vo_p cap_cmomf w=3e-6 l=11.39e-6
C2P[2] vvg_n vo_p cap_cmomf w=3e-6 l=11.39e-6
C2P[1] vvg_n vo_p cap_cmomf w=3e-6 l=11.39e-6
C2P[0] vvg_n vo_p cap_cmomf w=3e-6 l=11.39e-6
CC2N[11] vvg_p vo_n cap_cmomf w=3e-6 l=11.39e-6
C2N[10] vvg_p vo_n cap_cmomf w=3e-6 l=11.39e-6
C2N[9] vvg_p vo_n cap_cmomf w=3e-6 l=11.39e-6
C2N[8] vvg_p vo_n cap_cmomf w=3e-6 l=11.39e-6
C2N[7] vvg_p vo_n cap_cmomf w=3e-6 l=11.39e-6
C2N[6] vvg_p vo_n cap_cmomf w=3e-6 l=11.39e-6
C2N[5] vvg_p vo_n cap_cmomf w=3e-6 l=11.39e-6
C2N[4] vvg_p vo_n cap_cmomf w=3e-6 l=11.39e-6
C2N[3] vvg_p vo_n cap_cmomf w=3e-6 l=11.39e-6
C2N[2] vvg_p vo_n cap_cmomf w=3e-6 l=11.39e-6
C2N[1] vvg_p vo_n cap_cmomf w=3e-6 l=11.39e-6
C2N[0] vvg_p vo_n cap_cmomf w=3e-6 l=11.39e-6
xcmfb1 di_phi2 di_phi1 vss vo_p vcm vbn vfb vo_n vdd cmfb_sc2
XINV_vphi1 di_phi1 d_phi1_b vdd vss inv_lv
XINV_vphi2 di_phi2 d_phi2_b vdd vss inv_lv
CCDUM_DCOL[17] vdd vss cap_cmomf w=3e-6 l=5.6e-6
CDUM_DCOL[16] vdd vss cap_cmomf w=3e-6 l=5.6e-6
CDUM_DCOL[15] vdd vss cap_cmomf w=3e-6 l=5.6e-6
CDUM_DCOL[14] vdd vss cap_cmomf w=3e-6 l=5.6e-6
CDUM_DCOL[13] vdd vss cap_cmomf w=3e-6 l=5.6e-6
CDUM_DCOL[12] vdd vss cap_cmomf w=3e-6 l=5.6e-6
CDUM_DCOL[11] vdd vss cap_cmomf w=3e-6 l=5.6e-6
CDUM_DCOL[10] vdd vss cap_cmomf w=3e-6 l=5.6e-6
CDUM_DCOL[9] vdd vss cap_cmomf w=3e-6 l=5.6e-6
CDUM_DCOL[8] vdd vss cap_cmomf w=3e-6 l=5.6e-6
CDUM_DCOL[7] vdd vss cap_cmomf w=3e-6 l=5.6e-6
CDUM_DCOL[6] vdd vss cap_cmomf w=3e-6 l=5.6e-6
CDUM_DCOL[5] vdd vss cap_cmomf w=3e-6 l=5.6e-6
CDUM_DCOL[4] vdd vss cap_cmomf w=3e-6 l=5.6e-6
CDUM_DCOL[3] vdd vss cap_cmomf w=3e-6 l=5.6e-6
CDUM_DCOL[2] vdd vss cap_cmomf w=3e-6 l=5.6e-6
CDUM_DCOL[1] vdd vss cap_cmomf w=3e-6 l=5.6e-6
CDUM_DCOL[0] vdd vss cap_cmomf w=3e-6 l=5.6e-6
CCDUM_STRIP[7] vdd vss cap_cmomf w=3e-6 l=11.39e-6
CDUM_STRIP[6] vdd vss cap_cmomf w=3e-6 l=11.39e-6
CDUM_STRIP[5] vdd vss cap_cmomf w=3e-6 l=11.39e-6
CDUM_STRIP[4] vdd vss cap_cmomf w=3e-6 l=11.39e-6
CDUM_STRIP[3] vdd vss cap_cmomf w=3e-6 l=11.39e-6
CDUM_STRIP[2] vdd vss cap_cmomf w=3e-6 l=11.39e-6
CDUM_STRIP[1] vdd vss cap_cmomf w=3e-6 l=11.39e-6
CDUM_STRIP[0] vdd vss cap_cmomf w=3e-6 l=11.39e-6
.ends

* expanding   symbol:  dsm2_io_clk.sym # of pins=4
.subckt dsm2_io_clk vdd vss di_clk do_clk
*.PININFO vdd:B vss:B di_clk:I do_clk:O
XBC do_clk di_clk vdd vss sg13cmos5l_buf_2
.ends

* expanding   symbol:  clk_noverlap.sym # of pins=9
.subckt clk_noverlap di_clk di_ena do_phi1 do_phi1_b do_phi2 do_phi2_b do_qclk vdd vss
*.PININFO di_clk:I di_ena:I do_phi1_b:O do_phi1:O do_phi2:O do_phi2_b:O vdd:B vss:B do_qclk:O
XAND0 d_clk_en di_clk di_ena vdd vss sg13cmos5l_and2_1
XINV0 d_clk_en_b d_clk_en vdd vss sg13cmos5l_inv_1
XNOR0 d_phi1_nor d_clk_en_b d_ena_b d_phi2_fb vdd vss sg13cmos5l_nor3_1
XNOR1 d_phi2_nor d_clk_en d_ena_b do_phi1 vdd vss sg13cmos5l_nor3_1
XINV_ENA d_ena_b di_ena vdd vss sg13cmos5l_inv_1
XINV11 d_phi1_1 d_phi1_nor vdd vss sg13cmos5l_inv_1
XINV21 d_phi2_1 d_phi2_nor vdd vss sg13cmos5l_inv_1
XINV12 d_phi1_2 d_phi1_1 vdd vss sg13cmos5l_inv_1
XINV22 d_phi2_2 d_phi2_1 vdd vss sg13cmos5l_inv_1
XINV13 do_phi1_b d_phi1_2 vdd vss sg13cmos5l_inv_1
XINV23 do_phi2_b d_phi2_2 vdd vss sg13cmos5l_inv_1
XINV14 do_phi1 do_phi1_b vdd vss sg13cmos5l_inv_1
XINV24 do_phi2 do_phi2_b vdd vss sg13cmos5l_inv_1
XDC8[11] vdd vss sg13cmos5l_decap_8
XDC8[10] vdd vss sg13cmos5l_decap_8
XDC8[9] vdd vss sg13cmos5l_decap_8
XDC8[8] vdd vss sg13cmos5l_decap_8
XDC8[7] vdd vss sg13cmos5l_decap_8
XDC8[6] vdd vss sg13cmos5l_decap_8
XDC8[5] vdd vss sg13cmos5l_decap_8
XDC8[4] vdd vss sg13cmos5l_decap_8
XDC8[3] vdd vss sg13cmos5l_decap_8
XDC8[2] vdd vss sg13cmos5l_decap_8
XDC8[1] vdd vss sg13cmos5l_decap_8
XDC8[0] vdd vss sg13cmos5l_decap_8
XDC4[1] vdd vss sg13cmos5l_decap_4
XDC4[0] vdd vss sg13cmos5l_decap_4
XDLY0 net1 do_phi2 vdd vss sg13cmos5l_dlygate4sd3_1
XDLY1 net2 net1 vdd vss sg13cmos5l_dlygate4sd3_1
XDLY2 net3 net2 vdd vss sg13cmos5l_dlygate4sd3_1
XDLY3 net4 net3 vdd vss sg13cmos5l_dlygate4sd3_1
XDLY4 net5 net4 vdd vss sg13cmos5l_dlygate4sd3_1
XDLY5 net6 net5 vdd vss sg13cmos5l_dlygate4sd3_1
XDLY6 net7 net6 vdd vss sg13cmos5l_dlygate4sd3_1
XDLY7 net8 net7 vdd vss sg13cmos5l_dlygate4sd3_1
XDLY8 net9 net8 vdd vss sg13cmos5l_dlygate4sd3_1
XDLY9 net10 net9 vdd vss sg13cmos5l_dlygate4sd3_1
XDLY10 net11 net10 vdd vss sg13cmos5l_dlygate4sd3_1
XDLY11 net12 net11 vdd vss sg13cmos5l_dlygate4sd3_1
XDLY12 net13 net12 vdd vss sg13cmos5l_dlygate4sd3_1
XDLY13 d_phi2_fb net13 vdd vss sg13cmos5l_dlygate4sd3_1
XQI1 d_qck1 do_phi2 vdd vss sg13cmos5l_inv_1
XQI2 d_qck2 d_qck1 vdd vss sg13cmos5l_inv_1
XQI3 d_qck3 d_qck2 vdd vss sg13cmos5l_inv_1
XQA do_qclk d_clk_en d_qck3 vdd vss sg13cmos5l_and2_1
.ends

* expanding   symbol:  dsm2_io_vcmg.sym # of pins=8
.subckt dsm2_io_vcmg vdd vss di_vcm_ext di_vcm_ext_b di_phi1_b di_phi2 do_phi1_b do_phi2
*.PININFO vdd:B vss:B di_phi1_b:I do_phi1_b:O di_vcm_ext:I di_vcm_ext_b:I di_phi2:I do_phi2:O
XOR do_phi1_b di_phi1_b di_vcm_ext vdd vss sg13cmos5l_or2_1
XAND do_phi2 di_phi2 di_vcm_ext_b vdd vss sg13cmos5l_and2_1
.ends

* expanding   symbol:  vcm_gen.sym # of pins=5
.subckt vcm_gen di_phi1_b di_phi2 vdd vss vcm
*.PININFO di_phi1_b:I di_phi2:I vdd:B vss:B vcm:B
MMS1 vcf_t di_phi1_b vdd vdd sg13_hv_pmos w=4u l=0.45u ng=1
MMS4 vcf_b di_phi2 vss vss sg13_hv_nmos w=2u l=0.45u ng=1
MMS2 vcf_b di_phi1_b vcm vdd sg13_lv_pmos w=4u l=0.5u ng=1
MMS3 vcf_t di_phi2 vcm vss sg13_lv_nmos w=4u l=0.5u ng=1
CCF1[3] vcf_t vcf_b cap_cmomf w=4.2e-6 l=12.4e-6
CF1[2] vcf_t vcf_b cap_cmomf w=4.2e-6 l=12.4e-6
CF1[1] vcf_t vcf_b cap_cmomf w=4.2e-6 l=12.4e-6
CF1[0] vcf_t vcf_b cap_cmomf w=4.2e-6 l=12.4e-6
CCF2[3] vcf_b vcf_t cap_cmomf w=4.2e-6 l=12.4e-6
CF2[2] vcf_b vcf_t cap_cmomf w=4.2e-6 l=12.4e-6
CF2[1] vcf_b vcf_t cap_cmomf w=4.2e-6 l=12.4e-6
CF2[0] vcf_b vcf_t cap_cmomf w=4.2e-6 l=12.4e-6
MCR vss vcm vss vss sg13_hv_nmos w=10u l=10u ng=1 m=7
MMDEC vss vdd vss vss sg13_hv_nmos w=4u l=10u ng=1 m=2
MMDR vss vss vss vss sg13_hv_nmos w=10u l=0.45u ng=1 m=2
MMDS vss vss vss vss sg13_hv_nmos w=1.5u l=0.45u ng=1
.ends

* expanding   symbol:  bias_gm.sym # of pins=7
.subckt bias_gm vdd vss di_ena di_trim_b[3] di_trim_b[2] di_trim_b[1] di_trim_b[0] ibias_200n di_btest_en ibias_test
*.PININFO vdd:B vss:B di_ena:I ibias_200n:B di_trim_b[3:0]:I di_btest_en:I ibias_test:B
MMCL1 vz di_ena vdd vdd sg13_lv_pmos w=0.5u l=5u ng=1
MMPI d_en_b di_ena vdd vdd sg13_lv_pmos w=0.5u l=0.5u ng=1
MMNI d_en_b di_ena vss vss sg13_lv_nmos w=0.5u l=1u ng=1
MMCL3 vx d_en_b vss vss sg13_hv_nmos w=0.5u l=1u ng=1
MMCL4 vy d_en_b vss vss sg13_hv_nmos w=0.5u l=1u ng=1
MMCL6 vs d_en_b vss vss sg13_lv_nmos w=0.5u l=1u ng=1
MM3 vy vz vdd vdd sg13_lv_pmos w=0.5u l=5u ng=1 m=24
MM5 vz vz vdd vdd sg13_lv_pmos w=0.5u l=5u ng=1 m=12
MM4 vx vz vdd vdd sg13_lv_pmos w=0.5u l=5u ng=1 m=24
MM6 vz vy vss vss sg13_hv_nmos w=0.5u l=10u ng=1 m=2
MM1 vy vx vss vss sg13_hv_nmos w=0.5u l=10u ng=1 m=4
MCC vss net1 vss vss sg13_hv_nmos w=10u l=10u ng=1 m=20
MM2 vx vx vnr vss sg13_lv_nmos w=0.5u l=10u ng=1 m=4
RR1 vnr vss 2.1734MEG $SUB=vss $[rhigh] w=0.5e-6 l=735e-6 b=0
MMSA[12] vua[1] vt1 vdd vdd sg13_lv_pmos w=0.5u l=10u ng=1
MSA[11] vua[2] vt1 vua[1] vdd sg13_lv_pmos w=0.5u l=10u ng=1
MSA[10] vua[3] vt1 vua[2] vdd sg13_lv_pmos w=0.5u l=10u ng=1
MSA[9] vua[4] vt1 vua[3] vdd sg13_lv_pmos w=0.5u l=10u ng=1
MSA[8] vua[5] vt1 vua[4] vdd sg13_lv_pmos w=0.5u l=10u ng=1
MSA[7] vua[6] vt1 vua[5] vdd sg13_lv_pmos w=0.5u l=10u ng=1
MSA[6] vua[7] vt1 vua[6] vdd sg13_lv_pmos w=0.5u l=10u ng=1
MSA[5] vua[8] vt1 vua[7] vdd sg13_lv_pmos w=0.5u l=10u ng=1
MSA[4] vua[9] vt1 vua[8] vdd sg13_lv_pmos w=0.5u l=10u ng=1
MSA[3] vua[10] vt1 vua[9] vdd sg13_lv_pmos w=0.5u l=10u ng=1
MSA[2] vua[11] vt1 vua[10] vdd sg13_lv_pmos w=0.5u l=10u ng=1
MSA[1] vua[12] vt1 vua[11] vdd sg13_lv_pmos w=0.5u l=10u ng=1
MSA[0] vt1 vt1 vua[12] vdd sg13_lv_pmos w=0.5u l=10u ng=1
MMSB[12] vub[1] vs vt1 vdd sg13_lv_pmos w=0.5u l=10u ng=1
MSB[11] vub[2] vs vub[1] vdd sg13_lv_pmos w=0.5u l=10u ng=1
MSB[10] vub[3] vs vub[2] vdd sg13_lv_pmos w=0.5u l=10u ng=1
MSB[9] vub[4] vs vub[3] vdd sg13_lv_pmos w=0.5u l=10u ng=1
MSB[8] vub[5] vs vub[4] vdd sg13_lv_pmos w=0.5u l=10u ng=1
MSB[7] vub[6] vs vub[5] vdd sg13_lv_pmos w=0.5u l=10u ng=1
MSB[6] vub[7] vs vub[6] vdd sg13_lv_pmos w=0.5u l=10u ng=1
MSB[5] vub[8] vs vub[7] vdd sg13_lv_pmos w=0.5u l=10u ng=1
MSB[4] vub[9] vs vub[8] vdd sg13_lv_pmos w=0.5u l=10u ng=1
MSB[3] vub[10] vs vub[9] vdd sg13_lv_pmos w=0.5u l=10u ng=1
MSB[2] vub[11] vs vub[10] vdd sg13_lv_pmos w=0.5u l=10u ng=1
MSB[1] vub[12] vs vub[11] vdd sg13_lv_pmos w=0.5u l=10u ng=1
MSB[0] vs vs vub[12] vdd sg13_lv_pmos w=0.5u l=10u ng=1
MMSN vs vx vss vss sg13_hv_nmos w=0.5u l=10u ng=1 m=2
MMINJ vz vs vss vss sg13_hv_nmos w=4u l=0.5u ng=1 m=2
MMPD vdd vdd vdd vdd sg13_lv_pmos w=0.5u l=5u ng=1 m=26
MMNDS vss vss vss vss sg13_hv_nmos w=10u l=1u ng=1 m=10
RRD1 vss vss 13.015k $SUB=vss $[rhigh] w=0.5e-6 l=17.5e-6 b=0 m=4
RRD2 vss vss 8.192k $SUB=vss $[rhigh] w=0.5e-6 l=10.975e-6 b=0 m=4
MMSD vdd vdd vdd vdd sg13_lv_pmos w=0.5u l=10u ng=1
MMSDS vs vs vs vdd sg13_lv_pmos w=0.5u l=10u ng=1
RRD3 vss vss 183.71 $SUB=vss $[rhigh] w=0.5e-6 l=2.75e-6 b=0 m=46
MMNDJ vss vss vss vss sg13_hv_nmos w=0.5u l=10u ng=1 m=4
xtrim vdd vss vz di_trim_b[3] di_trim_b[2] di_trim_b[1] di_trim_b[0] ibias_200n bias_trim
RRZ vy net1 130.11k $SUB=vss $[rhigh] w=0.5e-6 l=43.9e-6 b=0
MMCI vss ibias_200n vss vss sg13_hv_nmos w=0.5u l=10u ng=1 m=4
MMNDL vss vss vss vss sg13_lv_nmos w=0.5u l=10u ng=1 m=6
MMNDT vss vss vss vss sg13_hv_nmos w=1u l=10u ng=1 m=8
MMNDR vnr vss vnr vss sg13_lv_nmos w=0.5u l=10u ng=1 m=4
RRD4 vss vss 3.4696k $SUB=vss $[rhigh] w=0.5e-6 l=9.28e-6 b=0 m=8
MMPBI d_btest_b di_btest_en vdd vdd sg13_lv_pmos w=0.5u l=5u ng=1
MMNBI d_btest_b di_btest_en vss vss sg13_lv_nmos w=0.5u l=10u ng=1 m=2
xtrim2 vdd vss vz di_trim_b[3] di_trim_b[2] di_trim_b[1] di_trim_b[0] vbt bias_trim
MMBS ibias_test d_btest_b vbt vdd sg13_lv_pmos w=0.5u l=5u ng=1 m=6
MMBSD vbt vdd vbt vdd sg13_lv_pmos w=0.5u l=5u ng=1 m=2
.ends

* expanding   symbol:  quantizer2_top.sym # of pins=17
.subckt quantizer2_top vi_p vi_n di_clk di_dith[2] di_dith[1] di_dith[0] di_amp_s[3] di_amp_s[2] di_amp_s[1] di_amp_s[0]
+ di_amp_s_b[3] di_amp_s_b[2] di_amp_s_b[1] di_amp_s_b[0] do_qi do_qi_b do_q do_q_b do_q_dec vdd di_en di_rst_b di_dith_en di_qout_en vss
*.PININFO vi_p:B vi_n:B di_clk:I di_en:I do_qi:O do_qi_b:O di_rst_b:I vdd:B vss:B do_q:O do_q_b:O do_q_dec:O di_dith_en:I
*+ di_dith[2:0]:I di_amp_s[3:0]:I di_amp_s_b[3:0]:I di_qout_en:I
XSAL0 di_clk vdd vi_n vi_p d_n d_p vss di_en vg_q[2] vg_q[1] vg_q[0] vg_p[2] vg_p[1] vg_p[0] quantizer2_sal
XINV0 d_p_1 d_p vdd vss sg13cmos5l_inv_1
XINV1 d_p_2 d_p_1 vdd vss sg13cmos5l_inv_2
XGATE_P d_p_b d_p_2 d_preset_b vdd vss sg13cmos5l_nand2_2
XINV3 d_n_1 d_n vdd vss sg13cmos5l_inv_1
XINV4 d_n_2 d_n_1 vdd vss sg13cmos5l_inv_2
XGATE_N d_n_b d_n_2 d_preset vdd vss sg13cmos5l_nor2_2
XNOR0 do_qi d_p_b do_qi_b vdd vss sg13cmos5l_nor2_2
XNOR1 do_qi_b d_n_b do_qi vdd vss sg13cmos5l_nor2_2
XAND_RST d_preset_b di_en di_rst_b vdd vss sg13cmos5l_and2_2
XINV7 d_preset d_preset_b vdd vss sg13cmos5l_inv_4
MPDUMHV1 vdd vss vdd vdd sg13_hv_pmos w=3u l=450n ng=1
MNDUMHV1 vss vdd vss vss sg13_hv_nmos w=1u l=450n ng=1
MPDUMHV vdd vss vdd vdd sg13_hv_pmos w=3u l=450n ng=1
MNDUMHV vss vdd vss vss sg13_hv_nmos w=1u l=450n ng=1
XDITH di_clk di_dith[2] di_dith[1] di_dith[0] di_amp_s[3] di_amp_s[2] di_amp_s[1] di_amp_s[0] di_amp_s_b[3] di_amp_s_b[2]
+ di_amp_s_b[1] di_amp_s_b[0] vi_p vi_n vg_q[2] vg_q[1] vg_q[0] vg_p[2] vg_p[1] vg_p[0] vdd di_en di_dith_en vss quantizer2_dith
XAQ0 net1 do_qi di_qout_en vdd vss sg13cmos5l_and2_1
XQD10 net2 net1 vdd vss sg13cmos5l_inv_1
XQD20 do_q net2 vdd vss sg13cmos5l_inv_2
XAQ1 net3 do_qi_b di_qout_en vdd vss sg13cmos5l_and2_1
XQD11 net4 net3 vdd vss sg13cmos5l_inv_1
XQD21 do_q_b net4 vdd vss sg13cmos5l_inv_2
XDC1 net5 do_qi vdd vss sg13cmos5l_inv_1
XDC2 do_q_dec net5 vdd vss sg13cmos5l_inv_2
XDD1 net6 do_qi_b vdd vss sg13cmos5l_inv_1
XDD2 net7 net6 vdd vss sg13cmos5l_inv_2
XDDL d_qdum_x net7 vss vdd vss sg13cmos5l_and2_1
* noconn d_qdum_x
.ends

* expanding   symbol:  quantizer2_lfsr.sym # of pins=8
.subckt quantizer2_lfsr di_clk di_dith_amp[1] di_dith_amp[0] do_dith[2] do_dith[1] do_dith[0] do_amp_s[3] do_amp_s[2] do_amp_s[1]
+ do_amp_s[0] do_amp_s_b[3] do_amp_s_b[2] do_amp_s_b[1] do_amp_s_b[0] vdd di_dith_en vss
*.PININFO di_clk:I di_dith_en:I do_dith[2:0]:O di_dith_amp[1:0]:I do_amp_s_b[3:0]:O do_amp_s[3:0]:O vdd:B vss:B
XFF[16] s[16] di_clk s[13] di_dith_en vdd vss sg13cmos5l_dfrbpq_1
XFF[15] s[15] di_clk s[12] di_dith_en vdd vss sg13cmos5l_dfrbpq_1
XFF[14] s[14] di_clk s[11] di_dith_en vdd vss sg13cmos5l_dfrbpq_1
XFF[13] s[13] di_clk s[10] di_dith_en vdd vss sg13cmos5l_dfrbpq_1
XFF[12] s[12] di_clk s[9] di_dith_en vdd vss sg13cmos5l_dfrbpq_1
XFF[11] s[11] di_clk s[8] di_dith_en vdd vss sg13cmos5l_dfrbpq_1
XFF[10] s[10] di_clk s[7] di_dith_en vdd vss sg13cmos5l_dfrbpq_1
XFF[9] s[9] di_clk s[6] di_dith_en vdd vss sg13cmos5l_dfrbpq_1
XFF[8] s[8] di_clk s[5] di_dith_en vdd vss sg13cmos5l_dfrbpq_1
XFF[7] s[7] di_clk s[4] di_dith_en vdd vss sg13cmos5l_dfrbpq_1
XFF[6] s[6] di_clk s[3] di_dith_en vdd vss sg13cmos5l_dfrbpq_1
XFF[5] s[5] di_clk s[2] di_dith_en vdd vss sg13cmos5l_dfrbpq_1
XFF[4] s[4] di_clk s[1] di_dith_en vdd vss sg13cmos5l_dfrbpq_1
XFF[3] s[3] di_clk s[0] di_dith_en vdd vss sg13cmos5l_dfrbpq_1
XFF[2] s[2] di_clk d_nb[0] di_dith_en vdd vss sg13cmos5l_dfrbpq_1
XFF[1] s[1] di_clk d_nb[1] di_dith_en vdd vss sg13cmos5l_dfrbpq_1
XFF[0] s[0] di_clk d_nb[2] di_dith_en vdd vss sg13cmos5l_dfrbpq_1
XXN[2] d_nb[2] s[11] s[14] vdd vss sg13cmos5l_xnor2_1
XXN[1] d_nb[1] s[12] s[15] vdd vss sg13cmos5l_xnor2_1
XXN[0] d_nb[0] s[13] s[16] vdd vss sg13cmos5l_xnor2_1
XBO[2] do_dith[2] s[0] vdd vss sg13cmos5l_buf_1
XBO[1] do_dith[1] s[1] vdd vss sg13cmos5l_buf_1
XBO[0] do_dith[0] s[2] vdd vss sg13cmos5l_buf_1
XINVA[1] d_a_b[1] di_dith_amp[1] vdd vss sg13cmos5l_inv_1
XINVA[0] d_a_b[0] di_dith_amp[0] vdd vss sg13cmos5l_inv_1
XNORS[3] do_amp_s[3] d_a_b[1] d_a_b[0] vdd vss sg13cmos5l_nor2_1
XNORS[2] do_amp_s[2] d_a_b[1] di_dith_amp[0] vdd vss sg13cmos5l_nor2_1
XNORS[1] do_amp_s[1] di_dith_amp[1] d_a_b[0] vdd vss sg13cmos5l_nor2_1
XNORS[0] do_amp_s[0] di_dith_amp[1] di_dith_amp[0] vdd vss sg13cmos5l_nor2_1
XINVS[3] do_amp_s_b[3] do_amp_s[3] vdd vss sg13cmos5l_inv_1
XINVS[2] do_amp_s_b[2] do_amp_s[2] vdd vss sg13cmos5l_inv_1
XINVS[1] do_amp_s_b[1] do_amp_s[1] vdd vss sg13cmos5l_inv_1
XINVS[0] do_amp_s_b[0] do_amp_s[0] vdd vss sg13cmos5l_inv_1
.ends

* expanding   symbol:  dsm2_osc.sym # of pins=12
.subckt dsm2_osc vdd vss di_osc_en di_clk_sel d_btest_en ibias_in di_clk_ext d_btest_or ibias_pad do_clk_mod do_clk_osc do_osc_oe
*.PININFO di_osc_en:I di_clk_sel:I do_osc_oe:O d_btest_en:I d_btest_or:O ibias_in:I ibias_pad:O vdd:B vss:B di_clk_ext:I
*+ do_clk_mod:O do_clk_osc:O
XRX0 vdd vss di_osc_en d_osc_en_b dsm2_io_rx
XI0 d_osc_en d_osc_en_b vdd vss sg13cmos5l_inv_1
XRX1 vdd vss di_clk_sel d_sel_b dsm2_io_rx
XI1 do_osc_oe d_sel_b vdd vss sg13cmos5l_inv_1
XBO d_btest_or d_btest_en d_osc_en vdd vss sg13cmos5l_or2_1
MMSP ibias_pad d_osc_en ibias_in vdd sg13_lv_pmos w=1u l=0.5u ng=1 m=2
MMSN ibias_in d_osc_en vg vss sg13_hv_nmos w=1u l=0.45u ng=1
MMD vg vg vss vss sg13_lv_nmos w=0.5u l=0.5u ng=1 m=2
MMGD vg d_osc_en_b vss vss sg13_lv_nmos w=0.5u l=0.5u ng=1
MM2 vbp vg vss vss sg13_lv_nmos w=0.5u l=0.5u ng=1
MMPD vbp vbp vdd vdd sg13_lv_pmos w=0.5u l=0.5u ng=1
MMPK vbp d_osc_en vdd vdd sg13_lv_pmos w=0.5u l=0.5u ng=1
MXTP1 net6 vbp vdd vdd sg13_lv_pmos w=0.5u l=0.5u ng=1
MXP1 n1 n5 net6 vdd sg13_lv_pmos w=1u l=0.13u ng=1
MXN1 n1 n5 net7 vss sg13_lv_nmos w=1u l=0.13u ng=1
MXTN1 net7 vg vss vss sg13_lv_nmos w=0.5u l=0.5u ng=1
MXC1 vss n1 vss vss sg13_lv_nmos w=0.5u l=0.5u ng=1
MXK1 n1 d_osc_en_b vss vss sg13_lv_nmos w=0.5u l=0.13u ng=1
MXTP2 net8 vbp vdd vdd sg13_lv_pmos w=0.5u l=0.5u ng=1
MXP2 n2 n1 net8 vdd sg13_lv_pmos w=1u l=0.13u ng=1
MXN2 n2 n1 net9 vss sg13_lv_nmos w=1u l=0.13u ng=1
MXTN2 net9 vg vss vss sg13_lv_nmos w=0.5u l=0.5u ng=1
MXC2 vss n2 vss vss sg13_lv_nmos w=0.5u l=0.5u ng=1
MXK2 n2 d_osc_en vdd vdd sg13_lv_pmos w=0.5u l=0.13u ng=1
MXTP3 net10 vbp vdd vdd sg13_lv_pmos w=0.5u l=0.5u ng=1
MXP3 n3 n2 net10 vdd sg13_lv_pmos w=1u l=0.13u ng=1
MXN3 n3 n2 net11 vss sg13_lv_nmos w=1u l=0.13u ng=1
MXTN3 net11 vg vss vss sg13_lv_nmos w=0.5u l=0.5u ng=1
MXC3 vss n3 vss vss sg13_lv_nmos w=0.5u l=0.5u ng=1
MXK3 n3 d_osc_en_b vss vss sg13_lv_nmos w=0.5u l=0.13u ng=1
MXTP4 net12 vbp vdd vdd sg13_lv_pmos w=0.5u l=0.5u ng=1
MXP4 n4 n3 net12 vdd sg13_lv_pmos w=1u l=0.13u ng=1
MXN4 n4 n3 net13 vss sg13_lv_nmos w=1u l=0.13u ng=1
MXTN4 net13 vg vss vss sg13_lv_nmos w=0.5u l=0.5u ng=1
MXC4 vss n4 vss vss sg13_lv_nmos w=0.5u l=0.5u ng=1
MXK4 n4 d_osc_en vdd vdd sg13_lv_pmos w=0.5u l=0.13u ng=1
MXTP5 net14 vbp vdd vdd sg13_lv_pmos w=0.5u l=0.5u ng=1
MXP5 n5 n4 net14 vdd sg13_lv_pmos w=1u l=0.13u ng=1
MXN5 n5 n4 net15 vss sg13_lv_nmos w=1u l=0.13u ng=1
MXTN5 net15 vg vss vss sg13_lv_nmos w=0.5u l=0.5u ng=1
MXC5 vss n5 vss vss sg13_lv_nmos w=0.5u l=0.5u ng=1
MXK5 n5 d_osc_en_b vss vss sg13_lv_nmos w=0.5u l=0.13u ng=1
MXDN1 vss vss vss vss sg13_lv_nmos w=0.5u l=0.5u ng=1
MXDN2 vss vss vss vss sg13_lv_nmos w=0.5u l=0.5u ng=1
MXDP1 vdd vdd vdd vdd sg13_lv_pmos w=0.5u l=0.5u ng=1
MXDP2 vdd vdd vdd vdd sg13_lv_pmos w=0.5u l=0.5u ng=1
MXSP1 sa n5 vdd vdd sg13_lv_pmos w=0.5u l=0.5u ng=1
MXSP2 r1 n5 sa vdd sg13_lv_pmos w=0.5u l=0.5u ng=1
MXSN2 r1 n5 sb vss sg13_lv_nmos w=0.5u l=0.5u ng=1
MXSN1 sb n5 vss vss sg13_lv_nmos w=0.5u l=0.5u ng=1
MXSP3 vss r1 sa vdd sg13_lv_pmos w=0.5u l=0.5u ng=1
MXSN3 vdd r1 sb vss sg13_lv_nmos w=0.5u l=0.5u ng=1
XR3 net1 r1 vdd vss sg13cmos5l_inv_1
XFF q net2 net1 net2 d_osc_en vdd vss sg13cmos5l_dfrbp_1
XMUX net3 di_clk_ext q do_osc_oe vdd vss sg13cmos5l_mux2_1
XBM do_clk_mod net3 vdd vss sg13cmos5l_buf_2
XA net4 q d_osc_en vdd vss sg13cmos5l_and2_1
XO1 net5 net4 vdd vss sg13cmos5l_inv_1
XO2 do_clk_osc net5 vdd vss sg13cmos5l_inv_2
.ends

* expanding   symbol:  dsm2_io_rx.sym # of pins=4
.subckt dsm2_io_rx vdd vss di di_b
*.PININFO vdd:B vss:B di:I di_b:O
MP0 di_b di vdd vdd sg13_hv_pmos w=0.5u l=1u ng=1
MN0 di_b di vss vss sg13_hv_nmos w=1u l=450n ng=1
.ends

* expanding   symbol:  sg13cmos5l_stdcells/sg13cmos5l_inv_1.sym # of pins=2
.subckt sg13cmos5l_inv_1 Y A VDD VSS

*.PININFO Y:O A:I
MM1 Y A VSS VSS sg13_lv_nmos w=740.00n l=130.00n ng=1
MM2 Y A VDD VDD sg13_lv_pmos w=1.12u l=130.00n ng=1
.ends

* expanding   symbol:  sg13cmos5l_SecondaryProtection.sym # of pins=5
.subckt sg13cmos5l_SecondaryProtection core minus pad plus sub
*.PININFO pad:B core:B plus:B minus:B sub:B
RR0 core pad 586.9 $SUB=sub $[rppd] w=1e-6 l=2e-6 b=0
DD0 core plus dpantenna l=0.64u w=4.98u
DD1 sub core dantenna l=3.1u w=0.64u
RR1 minus sub ptap1 A=9.0304e-12 P=5.312e-05
.ends

* expanding   symbol:  sw_tgate.sym # of pins=6
.subckt sw_tgate p m g gb vdd vss
*.PININFO vdd:B vss:B p:B m:B gb:I g:I
MMN p g m vss sg13_lv_nmos w=2u l=1u ng=1
MMP p gb m vdd sg13_lv_pmos w=4u l=1u ng=1
MMND1 p gb p vss sg13_lv_nmos w=1u l=1u ng=1
MMND2 m gb m vss sg13_lv_nmos w=1u l=1u ng=1
MMPD1 p g p vdd sg13_lv_pmos w=2u l=1u ng=1
MMPD2 m g m vdd sg13_lv_pmos w=2u l=1u ng=1
.ends

* expanding   symbol:  ota_fcasc2_top.sym # of pins=10
.subckt ota_fcasc2_top vdd vfb voutp voutn vi_p vi_n ibias_200n di_ena vss vbn
*.PININFO ibias_200n:I vdd:B vss:B vi_p:I vi_n:I voutn:O voutp:O vfb:I vbn:O di_ena:I
xdp1 vtail vi_p vi_n vd1 vd2 ota_fcasc2_dp
xnbc1 d_ena_b ibias_200n voutp voutn d_ena vcp vd2 vd1 vbn vfb vss ota_fcasc2_nbiascasc
xpbc1 vdd vtail d_ena_b voutn voutp d_ena vcp ota_fcasc2_pbiascasc
xena1 vdd d_ena di_ena d_ena_b vss ota_fcasc2_ena
xcdec19 vdd vss cap_dec
xcdec18 vdd vss cap_dec
xcdec17 vdd vss cap_dec
xcdec16 vdd vss cap_dec
xcdec15 vdd vss cap_dec
xcdec14 vdd vss cap_dec
xcdec13 vdd vss cap_dec
xcdec12 vdd vss cap_dec
xcdec11 vdd vss cap_dec
xcdec10 vdd vss cap_dec
.ends

* expanding   symbol:  cmfb_sc2.sym # of pins=9
.subckt cmfb_sc2 di_phi2 di_phi1 vss vo_p vcm vbias vfb vo_n vdd
*.PININFO vfb:O vcm:I vbias:I vo_p:B vo_n:B di_phi1:I di_phi2:I vdd:B vss:B
XS4 vcm vsw_cm_p di_phi2 d_phi2_b vdd vss sw_tgate_cmfb2
XS3 vsw_cm_p vo_p di_phi1 d_phi1_b vdd vss sw_tgate_cmfb2
XS7 vbias vsw_vbias di_phi2 d_phi2_b vdd vss sw_tgate_cmfb2
XS6 vsw_vbias vfb di_phi1 d_phi1_b vdd vss sw_tgate_cmfb2
XS10 vcm vsw_cm_n di_phi2 d_phi2_b vdd vss sw_tgate_cmfb2
XS9 vsw_cm_n vo_n di_phi1 d_phi1_b vdd vss sw_tgate_cmfb2
CC2[3] vsw_cm_p vsw_vbias cap_cmomf w=3e-6 l=4.105e-6
C2[2] vsw_cm_p vsw_vbias cap_cmomf w=3e-6 l=4.105e-6
C2[1] vsw_cm_p vsw_vbias cap_cmomf w=3e-6 l=4.105e-6
C2[0] vsw_cm_p vsw_vbias cap_cmomf w=3e-6 l=4.105e-6
CC4[3] vsw_cm_n vsw_vbias cap_cmomf w=3e-6 l=4.105e-6
C4[2] vsw_cm_n vsw_vbias cap_cmomf w=3e-6 l=4.105e-6
C4[1] vsw_cm_n vsw_vbias cap_cmomf w=3e-6 l=4.105e-6
C4[0] vsw_cm_n vsw_vbias cap_cmomf w=3e-6 l=4.105e-6
CC1[2] vo_p vfb cap_cmomf w=3e-6 l=11.39e-6
C1[1] vo_p vfb cap_cmomf w=3e-6 l=11.39e-6
C1[0] vo_p vfb cap_cmomf w=3e-6 l=11.39e-6
CC3[2] vo_n vfb cap_cmomf w=3e-6 l=11.39e-6
C3[1] vo_n vfb cap_cmomf w=3e-6 l=11.39e-6
C3[0] vo_n vfb cap_cmomf w=3e-6 l=11.39e-6
XINV_vphi1 di_phi1 d_phi1_b vdd vss inv_lv
XINV_vphi2 di_phi2 d_phi2_b vdd vss inv_lv
CCDUM_COL[13] vdd vss cap_cmomf w=3e-6 l=2e-6
CDUM_COL[12] vdd vss cap_cmomf w=3e-6 l=2e-6
CDUM_COL[11] vdd vss cap_cmomf w=3e-6 l=2e-6
CDUM_COL[10] vdd vss cap_cmomf w=3e-6 l=2e-6
CDUM_COL[9] vdd vss cap_cmomf w=3e-6 l=2e-6
CDUM_COL[8] vdd vss cap_cmomf w=3e-6 l=2e-6
CDUM_COL[7] vdd vss cap_cmomf w=3e-6 l=2e-6
CDUM_COL[6] vdd vss cap_cmomf w=3e-6 l=2e-6
CDUM_COL[5] vdd vss cap_cmomf w=3e-6 l=2e-6
CDUM_COL[4] vdd vss cap_cmomf w=3e-6 l=2e-6
CDUM_COL[3] vdd vss cap_cmomf w=3e-6 l=2e-6
CDUM_COL[2] vdd vss cap_cmomf w=3e-6 l=2e-6
CDUM_COL[1] vdd vss cap_cmomf w=3e-6 l=2e-6
CDUM_COL[0] vdd vss cap_cmomf w=3e-6 l=2e-6
.ends

* expanding   symbol:  inv_lv.sym # of pins=4
.subckt inv_lv a y vdd vss
*.PININFO vdd:B vss:B a:I y:O
MMP y a vdd vdd sg13_lv_pmos w=2u l=0.13u ng=1
MMN y a vss vss sg13_lv_nmos w=1u l=0.13u ng=1
.ends

* expanding   symbol:  sg13cmos5l_stdcells/sg13cmos5l_buf_2.sym # of pins=2
.subckt sg13cmos5l_buf_2 X A VDD VSS

*.PININFO A:I X:O
MM1 net1 A VSS VSS sg13_lv_nmos w=640.00n l=130.00n ng=1
MM2 X net1 VSS VSS sg13_lv_nmos w=1.48u l=130.00n ng=2
MM3 net1 A VDD VDD sg13_lv_pmos w=1.000u l=130.00n ng=1
MM4 X net1 VDD VDD sg13_lv_pmos w=2.24u l=130.00n ng=2
.ends

* expanding   symbol:  sg13cmos5l_stdcells/sg13cmos5l_and2_1.sym # of pins=3
.subckt sg13cmos5l_and2_1 X A B VDD VSS

*.PININFO A:I B:I X:O
MM1 net1 A net2 VSS sg13_lv_nmos w=640.00n l=130.00n ng=1
MM2 net2 B VSS VSS sg13_lv_nmos w=640.00n l=130.00n ng=1
MM3 X net1 VSS VSS sg13_lv_nmos w=740.00n l=130.00n ng=1
MM4 net1 B VDD VDD sg13_lv_pmos w=840.00n l=130.00n ng=1
MM5 net1 A VDD VDD sg13_lv_pmos w=840.00n l=130.00n ng=1
MM6 X net1 VDD VDD sg13_lv_pmos w=1.12u l=130.00n ng=1
.ends

* expanding   symbol:  sg13cmos5l_stdcells/sg13cmos5l_nor3_1.sym # of pins=4
.subckt sg13cmos5l_nor3_1 Y A B C VDD VSS

*.PININFO B:I Y:O A:I C:I
MM1 Y A VSS VSS sg13_lv_nmos w=770.00n l=130.00n ng=1
MM2 Y B VSS VSS sg13_lv_nmos w=770.00n l=130.00n ng=1
MM3 Y C VSS VSS sg13_lv_nmos w=770.00n l=130.00n ng=1
MM4 net1 A VDD VDD sg13_lv_pmos w=1.12u l=130.00n ng=1
MM5 net2 B net1 VDD sg13_lv_pmos w=1.12u l=130.00n ng=1
MM6 Y C net2 VDD sg13_lv_pmos w=1.12u l=130.00n ng=1
.ends

* expanding   symbol:  sg13cmos5l_stdcells/sg13cmos5l_decap_8.sym # of pins=0
.subckt sg13cmos5l_decap_8 VDD VSS

MM1 VSS VDD VSS VSS sg13_lv_nmos w=840.00n l=1.000u ng=2
MM2 VDD VSS VDD VDD sg13_lv_pmos w=2.000u l=1.000u ng=2
.ends

* expanding   symbol:  sg13cmos5l_stdcells/sg13cmos5l_decap_4.sym # of pins=0
.subckt sg13cmos5l_decap_4 VDD VSS

MM1 VSS VDD VSS VSS sg13_lv_nmos w=420.00n l=1.000u ng=1
MM2 VDD VSS VDD VDD sg13_lv_pmos w=1.000u l=1.000u ng=1
.ends

* expanding   symbol:  sg13cmos5l_stdcells/sg13cmos5l_dlygate4sd3_1.sym # of pins=2
.subckt sg13cmos5l_dlygate4sd3_1 X A VDD VSS

*.PININFO A:I X:O
MM1 net3 A VSS VSS sg13_lv_nmos w=420.00n l=130.00n ng=1
MM2 net1 net3 VSS VSS sg13_lv_nmos w=420.00n l=500.0n ng=1
MM3 net2 net1 VSS VSS sg13_lv_nmos w=420.00n l=500.0n ng=1
MM4 X net2 VSS VSS sg13_lv_nmos w=740.00n l=130.00n ng=1
MM5 net3 A VDD VDD sg13_lv_pmos w=420.00n l=130.00n ng=1
MM6 net1 net3 VDD VDD sg13_lv_pmos w=1.000u l=500.0n ng=1
MM7 net2 net1 VDD VDD sg13_lv_pmos w=1.000u l=500.0n ng=1
MM8 X net2 VDD VDD sg13_lv_pmos w=1.12u l=130.00n ng=1
.ends

* expanding   symbol:  sg13cmos5l_stdcells/sg13cmos5l_or2_1.sym # of pins=3
.subckt sg13cmos5l_or2_1 X A B VDD VSS

*.PININFO X:O B:I A:I
MM1 net1 B VSS VSS sg13_lv_nmos w=550.00n l=130.00n ng=1
MM2 net1 A VSS VSS sg13_lv_nmos w=550.00n l=130.00n ng=1
MM3 X net1 VSS VSS sg13_lv_nmos w=740.00n l=130.00n ng=1
MM4 net2 A VDD VDD sg13_lv_pmos w=840.00n l=130.00n ng=1
MM5 net1 B net2 VDD sg13_lv_pmos w=840.00n l=130.00n ng=1
MM6 X net1 VDD VDD sg13_lv_pmos w=1.12u l=130.00n ng=1
.ends

* expanding   symbol:  bias_trim.sym # of pins=5
.subckt bias_trim vdd vss vz di_trim_b[3] di_trim_b[2] di_trim_b[1] di_trim_b[0] iout
*.PININFO vdd:B vz:I iout:B vss:B di_trim_b[3:0]:I
MMPF vdf vz vdd vdd sg13_lv_pmos w=0.5u l=5u ng=1 m=16
MMSF iout vss vdf vdd sg13_lv_pmos w=0.5u l=5u ng=1 m=2
MMP3 vd3 vz vdd vdd sg13_lv_pmos w=0.5u l=5u ng=1 m=16
MMS3 iout di_trim_b[3] vd3 vdd sg13_lv_pmos w=0.5u l=5u ng=1 m=2
MMP2 vd2 vz vdd vdd sg13_lv_pmos w=0.5u l=5u ng=1 m=8
MMS2 iout di_trim_b[2] vd2 vdd sg13_lv_pmos w=0.5u l=5u ng=1 m=2
MMP1 vd1 vz vdd vdd sg13_lv_pmos w=0.5u l=5u ng=1 m=4
MMS1 iout di_trim_b[1] vd1 vdd sg13_lv_pmos w=0.5u l=5u ng=1 m=2
MMP0 vd0 vz vdd vdd sg13_lv_pmos w=0.5u l=5u ng=1 m=2
MMS0 iout di_trim_b[0] vd0 vdd sg13_lv_pmos w=0.5u l=5u ng=1 m=2
MMPD vdd vdd vdd vdd sg13_lv_pmos w=0.5u l=5u ng=1 m=40
.ends

* expanding   symbol:  quantizer2_sal.sym # of pins=10
.subckt quantizer2_sal di_clk vdd vi_n vi_p do_n do_p vss di_en vg_q[2] vg_q[1] vg_q[0] vg_p[2] vg_p[1] vg_p[0]
*.PININFO vdd:B vss:B di_en:B di_clk:B do_p:B do_n:B vi_n:B vi_p:B vg_q[2:0]:B vg_p[2:0]:B
XINV0 vdd vss di_en d_en_b inv_en
XINV1 vdd vss d_en_b d_en inv_en
XAND0 d_gclk d_en di_clk vdd vss sg13cmos5l_and2_2
MP1 do_p do_n vdd vdd sg13_lv_pmos w=6u l=500n ng=4
MP0 do_n do_p vdd vdd sg13_lv_pmos w=6u l=500n ng=4
MN4 do_p do_n v_p vss sg13_lv_nmos w=2u l=500n ng=4
MN3 do_n do_p v_q vss sg13_lv_nmos w=2u l=500n ng=4
MN1 v_p vi_n vtail vss sg13_lv_nmos w=16u l=500n ng=4
MN0 v_q vi_p vtail vss sg13_lv_nmos w=16u l=500n ng=4
MN2 vtail d_gclk vss vss sg13_lv_nmos w=32u l=500n ng=8
MP5 v_p d_gclk vdd vdd sg13_lv_pmos w=6u l=500n ng=4
MP2 do_p d_gclk vdd vdd sg13_lv_pmos w=6u l=500n ng=4
MP3 do_n d_gclk vdd vdd sg13_lv_pmos w=6u l=500n ng=4
MP4 v_q d_gclk vdd vdd sg13_lv_pmos w=6u l=500n ng=4
MMN43[3] do_p vss vss vss sg13_lv_nmos w=500n l=500n ng=1
MN43[2] do_p vss vss vss sg13_lv_nmos w=500n l=500n ng=1
MN43[1] do_p vss vss vss sg13_lv_nmos w=500n l=500n ng=1
MN43[0] do_p vss vss vss sg13_lv_nmos w=500n l=500n ng=1
MMNDUM2[3] do_n vss vss vss sg13_lv_nmos w=500n l=500n ng=1
MNDUM2[2] do_n vss vss vss sg13_lv_nmos w=500n l=500n ng=1
MNDUM2[1] do_n vss vss vss sg13_lv_nmos w=500n l=500n ng=1
MNDUM2[0] do_n vss vss vss sg13_lv_nmos w=500n l=500n ng=1
MNDUM1 vss vss vss vss sg13_lv_nmos w=16u l=500n ng=4
MNDUM0 vtail vss vss vss sg13_lv_nmos w=8u l=500n ng=2
MMPDUM1[3] do_p vdd vdd vdd sg13_lv_pmos w=1.5u l=500n ng=1
MPDUM1[2] do_p vdd vdd vdd sg13_lv_pmos w=1.5u l=500n ng=1
MPDUM1[1] do_p vdd vdd vdd sg13_lv_pmos w=1.5u l=500n ng=1
MPDUM1[0] do_p vdd vdd vdd sg13_lv_pmos w=1.5u l=500n ng=1
MMPDUM0[3] do_n vdd vdd vdd sg13_lv_pmos w=1.5u l=500n ng=1
MPDUM0[2] do_n vdd vdd vdd sg13_lv_pmos w=1.5u l=500n ng=1
MPDUM0[1] do_n vdd vdd vdd sg13_lv_pmos w=1.5u l=500n ng=1
MPDUM0[0] do_n vdd vdd vdd sg13_lv_pmos w=1.5u l=500n ng=1
MMPDUM2[11] vdd vdd vdd vdd sg13_lv_pmos w=1.5u l=500n ng=1
MPDUM2[10] vdd vdd vdd vdd sg13_lv_pmos w=1.5u l=500n ng=1
MPDUM2[9] vdd vdd vdd vdd sg13_lv_pmos w=1.5u l=500n ng=1
MPDUM2[8] vdd vdd vdd vdd sg13_lv_pmos w=1.5u l=500n ng=1
MPDUM2[7] vdd vdd vdd vdd sg13_lv_pmos w=1.5u l=500n ng=1
MPDUM2[6] vdd vdd vdd vdd sg13_lv_pmos w=1.5u l=500n ng=1
MPDUM2[5] vdd vdd vdd vdd sg13_lv_pmos w=1.5u l=500n ng=1
MPDUM2[4] vdd vdd vdd vdd sg13_lv_pmos w=1.5u l=500n ng=1
MPDUM2[3] vdd vdd vdd vdd sg13_lv_pmos w=1.5u l=500n ng=1
MPDUM2[2] vdd vdd vdd vdd sg13_lv_pmos w=1.5u l=500n ng=1
MPDUM2[1] vdd vdd vdd vdd sg13_lv_pmos w=1.5u l=500n ng=1
MPDUM2[0] vdd vdd vdd vdd sg13_lv_pmos w=1.5u l=500n ng=1
MMNDUM3[5] vss vss vss vss sg13_lv_nmos w=500n l=500n ng=1
MNDUM3[4] vss vss vss vss sg13_lv_nmos w=500n l=500n ng=1
MNDUM3[3] vss vss vss vss sg13_lv_nmos w=500n l=500n ng=1
MNDUM3[2] vss vss vss vss sg13_lv_nmos w=500n l=500n ng=1
MNDUM3[1] vss vss vss vss sg13_lv_nmos w=500n l=500n ng=1
MNDUM3[0] vss vss vss vss sg13_lv_nmos w=500n l=500n ng=1
MMAQ0 v_q vg_q[0] vtail vss sg13_lv_nmos w=1.5u l=500n ng=1
MMAQ1 v_q vg_q[1] vtail vss sg13_lv_nmos w=3u l=500n ng=2
MMAQ2 v_q vg_q[2] vtail vss sg13_lv_nmos w=6u l=500n ng=4
MMAP0 v_p vg_p[0] vtail vss sg13_lv_nmos w=1.5u l=500n ng=1
MMAP1 v_p vg_p[1] vtail vss sg13_lv_nmos w=3u l=500n ng=2
MMAP2 v_p vg_p[2] vtail vss sg13_lv_nmos w=6u l=500n ng=4
MMNDA0[1] vss vss vss vss sg13_lv_nmos w=1.5u l=500n ng=1
MNDA0[0] vss vss vss vss sg13_lv_nmos w=1.5u l=500n ng=1
MMNDA1[1] vtail vss vss vss sg13_lv_nmos w=1.5u l=500n ng=1
MNDA1[0] vtail vss vss vss sg13_lv_nmos w=1.5u l=500n ng=1
MMNDA2[1] vtail vss vtail vss sg13_lv_nmos w=1.5u l=500n ng=1
MNDA2[0] vtail vss vtail vss sg13_lv_nmos w=1.5u l=500n ng=1
MMAQD v_q vss vtail vss sg13_lv_nmos w=1.5u l=500n ng=1
MMAPD v_p vss vtail vss sg13_lv_nmos w=1.5u l=500n ng=1
.ends

* expanding   symbol:  sg13cmos5l_stdcells/sg13cmos5l_inv_2.sym # of pins=2
.subckt sg13cmos5l_inv_2 Y A VDD VSS

*.PININFO Y:O A:I
MM1 Y A VSS VSS sg13_lv_nmos w=1.48u l=130.00n ng=2
MM2 Y A VDD VDD sg13_lv_pmos w=2.24u l=130.00n ng=2
.ends

* expanding   symbol:  sg13cmos5l_stdcells/sg13cmos5l_nand2_2.sym # of pins=3
.subckt sg13cmos5l_nand2_2 Y A B VDD VSS

*.PININFO Y:O B:I A:I
MM1 Y A net1 VSS sg13_lv_nmos w=1.44u l=130.00n ng=2
MM2 net1 B VSS VSS sg13_lv_nmos w=1.44u l=130.00n ng=2
MM3 Y A VDD VDD sg13_lv_pmos w=2.24u l=130.00n ng=2
MM4 Y B VDD VDD sg13_lv_pmos w=2.24u l=130.00n ng=2
.ends

* expanding   symbol:  sg13cmos5l_stdcells/sg13cmos5l_nor2_2.sym # of pins=3
.subckt sg13cmos5l_nor2_2 Y A B VDD VSS

*.PININFO Y:O B:I A:I
MM1 Y A VSS VSS sg13_lv_nmos w=1.48u l=130.00n ng=2
MM2 Y B VSS VSS sg13_lv_nmos w=1.48u l=130.00n ng=2
MM3 net1 A VDD VDD sg13_lv_pmos w=2.24u l=130.00n ng=2
MM4 Y B net1 VDD sg13_lv_pmos w=2.24u l=130.00n ng=2
.ends

* expanding   symbol:  sg13cmos5l_stdcells/sg13cmos5l_and2_2.sym # of pins=3
.subckt sg13cmos5l_and2_2 X A B VDD VSS

*.PININFO A:I B:I X:O
MM1 net1 A net2 VSS sg13_lv_nmos w=640.00n l=130.00n ng=1
MM2 net2 B VSS VSS sg13_lv_nmos w=640.00n l=130.00n ng=1
MM3 X net1 VSS VSS sg13_lv_nmos w=1.48u l=130.00n ng=2
MM4 net1 B VDD VDD sg13_lv_pmos w=840.00n l=130.00n ng=1
MM5 net1 A VDD VDD sg13_lv_pmos w=840.00n l=130.00n ng=1
MM6 X net1 VDD VDD sg13_lv_pmos w=2.24u l=130.00n ng=2
.ends

* expanding   symbol:  sg13cmos5l_stdcells/sg13cmos5l_inv_4.sym # of pins=2
.subckt sg13cmos5l_inv_4 Y A VDD VSS

*.PININFO A:I Y:O
MM1 Y A VSS VSS sg13_lv_nmos w=2.96u l=130.00n ng=4
MM2 Y A VDD VDD sg13_lv_pmos w=4.48u l=130.00n ng=4
.ends

* expanding   symbol:  quantizer2_dith.sym # of pins=12
.subckt quantizer2_dith di_clk di_dith[2] di_dith[1] di_dith[0] di_amp_s[3] di_amp_s[2] di_amp_s[1] di_amp_s[0] di_amp_s_b[3]
+ di_amp_s_b[2] di_amp_s_b[1] di_amp_s_b[0] vi_p vi_n vg_q[2] vg_q[1] vg_q[0] vg_p[2] vg_p[1] vg_p[0] vdd di_en di_dith_en vss
*.PININFO di_dith_en:I di_en:I di_clk:I di_dith[2:0]:I di_amp_s[3:0]:I di_amp_s_b[3:0]:I vg_q[2:0]:B vg_p[2:0]:B vi_p:B vi_n:B
*+ vdd:B vss:B
XINVEN d_en_b di_dith_en vdd vss sg13cmos5l_inv_1
XINVENL d_enl_b di_en vdd vss sg13cmos5l_inv_1
RRDLY d_rc di_clk 118.58k $SUB=vss $[rhigh] w=0.5e-6 l=40e-6 b=0
MMCDLY vss d_rc vss vss sg13_lv_nmos w=7u l=1u ng=2
XIRC1 d_rc_b d_rc vdd vss sg13cmos5l_inv_1
XIRC2 d_dl[1] d_rc_b vdd vss sg13cmos5l_inv_1
XDLY[3] d_dl[3] d_dl[2] vdd vss sg13cmos5l_dlygate4sd3_1
XDLY[2] d_dl[2] d_dl[1] vdd vss sg13cmos5l_dlygate4sd3_1
XAPH d_p12 d_dl[2] d_dl[3] vdd vss sg13cmos5l_and2_1
XAPHE d_ph d_p12 di_dith_en vdd vss sg13cmos5l_and2_1
XNORBI d_nph d_dl[2] d_dl[3] vdd vss sg13cmos5l_nor2_1
XABVI d_bvi d_nph di_dith_en vdd vss sg13cmos5l_and2_1
XIBVI d_bvi_b d_bvi vdd vss sg13cmos5l_inv_1
XOBVC d_bvc d_p12 d_en_b vdd vss sg13cmos5l_or2_1
XIBVC d_bvc_b d_bvc vdd vss sg13cmos5l_inv_1
XINVB[2] d_bb[2] di_dith[2] vdd vss sg13cmos5l_inv_1
XINVB[1] d_bb[1] di_dith[1] vdd vss sg13cmos5l_inv_1
XINVB[0] d_bb[0] di_dith[0] vdd vss sg13cmos5l_inv_1
XNA1[2] d_c1_b[2] d_ph di_dith[2] vdd vss sg13cmos5l_nand2_1
XNA1[1] d_c1_b[1] d_ph di_dith[1] vdd vss sg13cmos5l_nand2_1
XNA1[0] d_c1_b[0] d_ph di_dith[0] vdd vss sg13cmos5l_nand2_1
XIA1[2] d_c1[2] d_c1_b[2] vdd vss sg13cmos5l_inv_1
XIA1[1] d_c1[1] d_c1_b[1] vdd vss sg13cmos5l_inv_1
XIA1[0] d_c1[0] d_c1_b[0] vdd vss sg13cmos5l_inv_1
XNA0[2] d_c0_b[2] d_ph d_bb[2] vdd vss sg13cmos5l_nand2_1
XNA0[1] d_c0_b[1] d_ph d_bb[1] vdd vss sg13cmos5l_nand2_1
XNA0[0] d_c0_b[0] d_ph d_bb[0] vdd vss sg13cmos5l_nand2_1
XIA0[2] d_c0[2] d_c0_b[2] vdd vss sg13cmos5l_inv_1
XIA0[1] d_c0[1] d_c0_b[1] vdd vss sg13cmos5l_inv_1
XIA0[0] d_c0[0] d_c0_b[0] vdd vss sg13cmos5l_inv_1
MMPLAD net1 d_enl_b vdd vdd sg13_lv_pmos w=1u l=0.5u ng=1
RRTOP net1 t[24] 238.02k $SUB=vss $[rhigh] w=0.5e-6 l=80.4e-6 b=0
RRL[7] t[24] t[23] 12.383k $SUB=vss $[rhigh] w=0.5e-6 l=4.08e-6 b=0
RL[6] t[23] t[22] 12.383k $SUB=vss $[rhigh] w=0.5e-6 l=4.08e-6 b=0
RL[5] t[22] t[21] 12.383k $SUB=vss $[rhigh] w=0.5e-6 l=4.08e-6 b=0
RL[4] t[21] t[20] 12.383k $SUB=vss $[rhigh] w=0.5e-6 l=4.08e-6 b=0
RL[3] t[20] t[19] 12.383k $SUB=vss $[rhigh] w=0.5e-6 l=4.08e-6 b=0
RL[2] t[19] t[18] 12.383k $SUB=vss $[rhigh] w=0.5e-6 l=4.08e-6 b=0
RL[1] t[18] t[17] 12.383k $SUB=vss $[rhigh] w=0.5e-6 l=4.08e-6 b=0
RL[0] t[17] t[16] 12.383k $SUB=vss $[rhigh] w=0.5e-6 l=4.08e-6 b=0
RRBOT t[16] vss 238.02k $SUB=vss $[rhigh] w=0.5e-6 l=80.4e-6 b=0
MMCDLYD vss vdd vss vss sg13_lv_nmos w=7u l=1u ng=2
MMPLADD vdd vdd vdd vdd sg13_lv_pmos w=1u l=0.5u ng=1
RRDUM[1] vss vss 30.033k $SUB=vss $[rhigh] w=0.5e-6 l=10.05e-6 b=0
RDUM[0] vss vss 30.033k $SUB=vss $[rhigh] w=0.5e-6 l=10.05e-6 b=0
RRDUMT[1] vss vss 59.45k $SUB=vss $[rhigh] w=0.5e-6 l=20e-6 b=0
RDUMT[0] vss vss 59.45k $SUB=vss $[rhigh] w=0.5e-6 l=20e-6 b=0
MMAMHN[3] vh di_amp_s[3] t[21] vss sg13_lv_nmos w=0.5u l=0.13u ng=1
MAMHN[2] vh di_amp_s[2] t[24] vss sg13_lv_nmos w=0.5u l=0.13u ng=1
MAMHN[1] vh di_amp_s[1] t[22] vss sg13_lv_nmos w=0.5u l=0.13u ng=1
MAMHN[0] vh di_amp_s[0] t[23] vss sg13_lv_nmos w=0.5u l=0.13u ng=1
MMAMHP[3] t[21] di_amp_s_b[3] vh vdd sg13_lv_pmos w=0.5u l=0.13u ng=1
MAMHP[2] t[24] di_amp_s_b[2] vh vdd sg13_lv_pmos w=0.5u l=0.13u ng=1
MAMHP[1] t[22] di_amp_s_b[1] vh vdd sg13_lv_pmos w=0.5u l=0.13u ng=1
MAMHP[0] t[23] di_amp_s_b[0] vh vdd sg13_lv_pmos w=0.5u l=0.13u ng=1
MMAMLN[3] vl di_amp_s[3] t[19] vss sg13_lv_nmos w=0.5u l=0.13u ng=1
MAMLN[2] vl di_amp_s[2] t[16] vss sg13_lv_nmos w=0.5u l=0.13u ng=1
MAMLN[1] vl di_amp_s[1] t[18] vss sg13_lv_nmos w=0.5u l=0.13u ng=1
MAMLN[0] vl di_amp_s[0] t[17] vss sg13_lv_nmos w=0.5u l=0.13u ng=1
MMAMLP[3] t[19] di_amp_s_b[3] vl vdd sg13_lv_pmos w=0.5u l=0.13u ng=1
MAMLP[2] t[16] di_amp_s_b[2] vl vdd sg13_lv_pmos w=0.5u l=0.13u ng=1
MAMLP[1] t[18] di_amp_s_b[1] vl vdd sg13_lv_pmos w=0.5u l=0.13u ng=1
MAMLP[0] t[17] di_amp_s_b[0] vl vdd sg13_lv_pmos w=0.5u l=0.13u ng=1
MMGQHN[2] vg_q[2] d_c1[2] vh vss sg13_lv_nmos w=0.5u l=0.13u ng=1
MGQHN[1] vg_q[1] d_c1[1] vh vss sg13_lv_nmos w=0.5u l=0.13u ng=1
MGQHN[0] vg_q[0] d_c1[0] vh vss sg13_lv_nmos w=0.5u l=0.13u ng=1
MMGQHP[2] vh d_c1_b[2] vg_q[2] vdd sg13_lv_pmos w=0.5u l=0.13u ng=1
MGQHP[1] vh d_c1_b[1] vg_q[1] vdd sg13_lv_pmos w=0.5u l=0.13u ng=1
MGQHP[0] vh d_c1_b[0] vg_q[0] vdd sg13_lv_pmos w=0.5u l=0.13u ng=1
MMGQLN[2] vg_q[2] d_c0[2] vl vss sg13_lv_nmos w=0.5u l=0.13u ng=1
MGQLN[1] vg_q[1] d_c0[1] vl vss sg13_lv_nmos w=0.5u l=0.13u ng=1
MGQLN[0] vg_q[0] d_c0[0] vl vss sg13_lv_nmos w=0.5u l=0.13u ng=1
MMGQLP[2] vl d_c0_b[2] vg_q[2] vdd sg13_lv_pmos w=0.5u l=0.13u ng=1
MGQLP[1] vl d_c0_b[1] vg_q[1] vdd sg13_lv_pmos w=0.5u l=0.13u ng=1
MGQLP[0] vl d_c0_b[0] vg_q[0] vdd sg13_lv_pmos w=0.5u l=0.13u ng=1
MMGPHN[2] vg_p[2] d_c0[2] vh vss sg13_lv_nmos w=0.5u l=0.13u ng=1
MGPHN[1] vg_p[1] d_c0[1] vh vss sg13_lv_nmos w=0.5u l=0.13u ng=1
MGPHN[0] vg_p[0] d_c0[0] vh vss sg13_lv_nmos w=0.5u l=0.13u ng=1
MMGPHP[2] vh d_c0_b[2] vg_p[2] vdd sg13_lv_pmos w=0.5u l=0.13u ng=1
MGPHP[1] vh d_c0_b[1] vg_p[1] vdd sg13_lv_pmos w=0.5u l=0.13u ng=1
MGPHP[0] vh d_c0_b[0] vg_p[0] vdd sg13_lv_pmos w=0.5u l=0.13u ng=1
MMGPLN[2] vg_p[2] d_c1[2] vl vss sg13_lv_nmos w=0.5u l=0.13u ng=1
MGPLN[1] vg_p[1] d_c1[1] vl vss sg13_lv_nmos w=0.5u l=0.13u ng=1
MGPLN[0] vg_p[0] d_c1[0] vl vss sg13_lv_nmos w=0.5u l=0.13u ng=1
MMGPLP[2] vl d_c1_b[2] vg_p[2] vdd sg13_lv_pmos w=0.5u l=0.13u ng=1
MGPLP[1] vl d_c1_b[1] vg_p[1] vdd sg13_lv_pmos w=0.5u l=0.13u ng=1
MGPLP[0] vl d_c1_b[0] vg_p[0] vdd sg13_lv_pmos w=0.5u l=0.13u ng=1
MMPDQ[2] vg_q[2] d_en_b vss vss sg13_lv_nmos w=0.5u l=0.13u ng=1
MPDQ[1] vg_q[1] d_en_b vss vss sg13_lv_nmos w=0.5u l=0.13u ng=1
MPDQ[0] vg_q[0] d_en_b vss vss sg13_lv_nmos w=0.5u l=0.13u ng=1
MMPDP[2] vg_p[2] d_en_b vss vss sg13_lv_nmos w=0.5u l=0.13u ng=1
MPDP[1] vg_p[1] d_en_b vss vss sg13_lv_nmos w=0.5u l=0.13u ng=1
MPDP[0] vg_p[0] d_en_b vss vss sg13_lv_nmos w=0.5u l=0.13u ng=1
CCFQ0 v_bq vg_q[0] cap_cmomf w=7.6e-6 l=4.1e-6
CCFQ1[1] v_bq vg_q[1] cap_cmomf w=7.6e-6 l=4.1e-6
CFQ1[0] v_bq vg_q[1] cap_cmomf w=7.6e-6 l=4.1e-6
CCFQ2[1] v_bq vg_q[2] cap_cmomf w=7.6e-6 l=4.1e-6
CFQ2[0] v_bq vg_q[2] cap_cmomf w=7.6e-6 l=4.1e-6
CCFQ2[3] vg_q[2] v_bq cap_cmomf w=7.6e-6 l=4.1e-6
CFQ2[2] vg_q[2] v_bq cap_cmomf w=7.6e-6 l=4.1e-6
CCFQD v_bq v_bq cap_cmomf w=7.6e-6 l=4.1e-6
MMBCQN t[20] d_bvc v_bq vss sg13_lv_nmos w=21u l=0.13u ng=6
MMBCQP v_bq d_bvc_b t[20] vdd sg13_lv_pmos w=21u l=0.13u ng=6
MMBIQN vi_p d_bvi v_bq vss sg13_lv_nmos w=21u l=0.13u ng=6
MMBIQP v_bq d_bvi_b vi_p vdd sg13_lv_pmos w=21u l=0.13u ng=6
CCFP0 vg_p[0] v_bp cap_cmomf w=7.6e-6 l=4.1e-6
CCFP1[1] vg_p[1] v_bp cap_cmomf w=7.6e-6 l=4.1e-6
CFP1[0] vg_p[1] v_bp cap_cmomf w=7.6e-6 l=4.1e-6
CCFP2[1] vg_p[2] v_bp cap_cmomf w=7.6e-6 l=4.1e-6
CFP2[0] vg_p[2] v_bp cap_cmomf w=7.6e-6 l=4.1e-6
CCFP2[3] v_bp vg_p[2] cap_cmomf w=7.6e-6 l=4.1e-6
CFP2[2] v_bp vg_p[2] cap_cmomf w=7.6e-6 l=4.1e-6
CCFPD v_bp v_bp cap_cmomf w=7.6e-6 l=4.1e-6
MMBCPN t[20] d_bvc v_bp vss sg13_lv_nmos w=21u l=0.13u ng=6
MMBCPP v_bp d_bvc_b t[20] vdd sg13_lv_pmos w=21u l=0.13u ng=6
MMBIPN vi_n d_bvi v_bp vss sg13_lv_nmos w=21u l=0.13u ng=6
MMBIPP v_bp d_bvi_b vi_n vdd sg13_lv_pmos w=21u l=0.13u ng=6
.ends

* expanding   symbol:  sg13cmos5l_stdcells/sg13cmos5l_dfrbpq_1.sym # of pins=4
.subckt sg13cmos5l_dfrbpq_1 Q CLK D RESET_B VDD VSS

*.PININFO Q:O CLK:I D:I RESET_B:I
MM1 Db D net12 VSS sg13_lv_nmos w=420.00n l=130.00n ng=1
MM2 net12 RESET_B VSS VSS sg13_lv_nmos w=420.00n l=130.00n ng=1
MM3 net3 clkneg net11 VSS sg13_lv_nmos w=420.00n l=130.00n ng=1
MM4 net11 net1 VSS VSS sg13_lv_nmos w=420.00n l=130.00n ng=1
MM5 net1 net3 net7 VSS sg13_lv_nmos w=420.00n l=130.00n ng=1
MM6 net7 RESET_B VSS VSS sg13_lv_nmos w=420.00n l=130.00n ng=1
MM7 net2 net3 VSS VSS sg13_lv_nmos w=740.00n l=130.00n ng=1
MM8 Q net2 VSS VSS sg13_lv_nmos w=740.00n l=130.00n ng=1
MM9 clkneg CLK VSS VSS sg13_lv_nmos w=740.00n l=130.00n ng=1
MM10 clkpos clkneg VSS VSS sg13_lv_nmos w=740.00n l=130.00n ng=1
MM11 Db clkneg net5 VSS sg13_lv_nmos w=420.00n l=130.00n ng=1
MM12 net5 clkpos net10 VSS sg13_lv_nmos w=420.00n l=130.00n ng=1
MM13 net10 net4 net6 VSS sg13_lv_nmos w=420.00n l=130.00n ng=1
MM14 net6 RESET_B VSS VSS sg13_lv_nmos w=420.00n l=130.00n ng=1
MM15 net4 net5 VSS VSS sg13_lv_nmos w=740.00n l=130.00n ng=1
MM16 net4 clkpos net3 VSS sg13_lv_nmos w=740.00n l=130.00n ng=1
MM17 Db RESET_B VDD VDD sg13_lv_pmos w=420.00n l=130.00n ng=1
MM18 Db D VDD VDD sg13_lv_pmos w=420.00n l=130.00n ng=1
MM19 net9 net1 VDD VDD sg13_lv_pmos w=420.00n l=130.00n ng=1
MM20 net3 clkpos net9 VDD sg13_lv_pmos w=420.00n l=130.00n ng=1
MM21 net1 net3 VDD VDD sg13_lv_pmos w=420.00n l=130.00n ng=1
MM22 net1 RESET_B VDD VDD sg13_lv_pmos w=420.00n l=130.00n ng=1
MM23 net2 net3 VDD VDD sg13_lv_pmos w=1.12u l=130.00n ng=1
MM24 Q net2 VDD VDD sg13_lv_pmos w=1.12u l=130.00n ng=1
MM25 clkneg CLK VDD VDD sg13_lv_pmos w=1.12u l=130.00n ng=1
MM26 clkpos clkneg VDD VDD sg13_lv_pmos w=1.12u l=130.00n ng=1
MM27 Db clkpos net5 VDD sg13_lv_pmos w=420.00n l=130.00n ng=1
MM28 net8 net4 VDD VDD sg13_lv_pmos w=420.00n l=130.00n ng=1
MM29 net5 clkneg net8 VDD sg13_lv_pmos w=420.00n l=130.00n ng=1
MM30 net5 RESET_B VDD VDD sg13_lv_pmos w=420.00n l=130.00n ng=1
MM31 net4 net5 VDD VDD sg13_lv_pmos w=1.000u l=130.00n ng=1
MM32 net4 clkneg net3 VDD sg13_lv_pmos w=1.000u l=130.00n ng=1
.ends

* expanding   symbol:  sg13cmos5l_stdcells/sg13cmos5l_xnor2_1.sym # of pins=3
.subckt sg13cmos5l_xnor2_1 Y A B VDD VSS

*.PININFO A:I Y:O B:I
MM1 net1 B net4 VSS sg13_lv_nmos w=640.00n l=130.00n ng=1
MM2 net4 A VSS VSS sg13_lv_nmos w=640.00n l=130.00n ng=1
MM3 net2 A VSS VSS sg13_lv_nmos w=740.00n l=130.00n ng=1
MM4 Y net1 net2 VSS sg13_lv_nmos w=740.00n l=130.00n ng=1
MM5 net2 B VSS VSS sg13_lv_nmos w=740.00n l=130.00n ng=1
MM6 net1 A VDD VDD sg13_lv_pmos w=840.00n l=130.00n ng=1
MM7 net1 B VDD VDD sg13_lv_pmos w=840.00n l=130.00n ng=1
MM8 net3 A VDD VDD sg13_lv_pmos w=1.12u l=130.00n ng=1
MM9 Y B net3 VDD sg13_lv_pmos w=1.12u l=130.00n ng=1
MM10 Y net1 VDD VDD sg13_lv_pmos w=1.12u l=130.00n ng=1
.ends

* expanding   symbol:  sg13cmos5l_stdcells/sg13cmos5l_buf_1.sym # of pins=2
.subckt sg13cmos5l_buf_1 X A VDD VSS

*.PININFO A:I X:O
MM1 net1 A VSS VSS sg13_lv_nmos w=550.00n l=130.00n ng=1
MM2 X net1 VSS VSS sg13_lv_nmos w=740.00n l=130.00n ng=1
MM3 net1 A VDD VDD sg13_lv_pmos w=840.00n l=130.00n ng=1
MM4 X net1 VDD VDD sg13_lv_pmos w=1.12u l=130.00n ng=1
.ends

* expanding   symbol:  sg13cmos5l_stdcells/sg13cmos5l_nor2_1.sym # of pins=3
.subckt sg13cmos5l_nor2_1 Y A B VDD VSS

*.PININFO Y:O B:I A:I
MM1 Y A VSS VSS sg13_lv_nmos w=740.00n l=130.00n ng=1
MM2 Y B VSS VSS sg13_lv_nmos w=740.00n l=130.00n ng=1
MM3 net1 A VDD VDD sg13_lv_pmos w=1.12u l=130.00n ng=1
MM4 Y B net1 VDD sg13_lv_pmos w=1.12u l=130.00n ng=1
.ends

* expanding   symbol:  sg13cmos5l_stdcells/sg13cmos5l_dfrbp_1.sym # of pins=5
.subckt sg13cmos5l_dfrbp_1 Q Q_N CLK D RESET_B VDD VSS

*.PININFO D:I RESET_B:I CLK:I Q:O Q_N:O
MM1 Db D net12 VSS sg13_lv_nmos w=420.00n l=130.00n ng=1
MM2 net12 RESET_B VSS VSS sg13_lv_nmos w=420.00n l=130.00n ng=1
MM3 net2 clkneg net11 VSS sg13_lv_nmos w=420.00n l=130.00n ng=1
MM4 net11 net1 VSS VSS sg13_lv_nmos w=420.00n l=130.00n ng=1
MM5 net1 net2 net7 VSS sg13_lv_nmos w=420.00n l=130.00n ng=1
MM6 net7 RESET_B VSS VSS sg13_lv_nmos w=420.00n l=130.00n ng=1
MM7 Q_N net2 VSS VSS sg13_lv_nmos w=740.00n l=130.00n ng=1
MM8 net3 net2 VSS VSS sg13_lv_nmos w=740.00n l=130.00n ng=1
MM9 Q net3 VSS VSS sg13_lv_nmos w=740.00n l=130.00n ng=1
MM10 clkneg CLK VSS VSS sg13_lv_nmos w=740.00n l=130.00n ng=1
MM11 clkpos clkneg VSS VSS sg13_lv_nmos w=740.00n l=130.00n ng=1
MM12 Db clkneg net5 VSS sg13_lv_nmos w=420.00n l=130.00n ng=1
MM13 net5 clkpos net10 VSS sg13_lv_nmos w=420.00n l=130.00n ng=1
MM14 net10 net4 net6 VSS sg13_lv_nmos w=420.00n l=130.00n ng=1
MM15 net6 RESET_B VSS VSS sg13_lv_nmos w=420.00n l=130.00n ng=1
MM16 net4 net5 VSS VSS sg13_lv_nmos w=740.00n l=130.00n ng=1
MM17 net4 clkpos net2 VSS sg13_lv_nmos w=740.00n l=130.00n ng=1
MM18 Db RESET_B VDD VDD sg13_lv_pmos w=420.00n l=130.00n ng=1
MM19 Db D VDD VDD sg13_lv_pmos w=420.00n l=130.00n ng=1
MM20 net9 net1 VDD VDD sg13_lv_pmos w=420.00n l=130.00n ng=1
MM21 net2 clkpos net9 VDD sg13_lv_pmos w=420.00n l=130.00n ng=1
MM22 net1 net2 VDD VDD sg13_lv_pmos w=420.00n l=130.00n ng=1
MM23 net1 RESET_B VDD VDD sg13_lv_pmos w=420.00n l=130.00n ng=1
MM24 Q_N net2 VDD VDD sg13_lv_pmos w=1.12u l=130.00n ng=1
MM25 net3 net2 VDD VDD sg13_lv_pmos w=1.12u l=130.00n ng=1
MM26 Q net3 VDD VDD sg13_lv_pmos w=1.12u l=130.00n ng=1
MM27 clkneg CLK VDD VDD sg13_lv_pmos w=1.12u l=130.00n ng=1
MM28 clkpos clkneg VDD VDD sg13_lv_pmos w=1.12u l=130.00n ng=1
MM29 Db clkpos net5 VDD sg13_lv_pmos w=420.00n l=130.00n ng=1
MM30 net8 net4 VDD VDD sg13_lv_pmos w=420.00n l=130.00n ng=1
MM31 net5 clkneg net8 VDD sg13_lv_pmos w=420.00n l=130.00n ng=1
MM32 net5 RESET_B VDD VDD sg13_lv_pmos w=420.00n l=130.00n ng=1
MM33 net4 net5 VDD VDD sg13_lv_pmos w=1.000u l=130.00n ng=1
MM34 net4 clkneg net2 VDD sg13_lv_pmos w=1.000u l=130.00n ng=1
.ends

* expanding   symbol:  sg13cmos5l_stdcells/sg13cmos5l_mux2_1.sym # of pins=4
.subckt sg13cmos5l_mux2_1 X A0 A1 S VDD VSS

*.PININFO S:I A0:I A1:I X:O
MM1 Sb S VSS VSS sg13_lv_nmos w=550.00n l=130.00n ng=1
MM2 net1 A0 net5 VSS sg13_lv_nmos w=740.00n l=130.00n ng=1
MM3 net5 Sb VSS VSS sg13_lv_nmos w=740.00n l=130.00n ng=1
MM4 net1 A1 net4 VSS sg13_lv_nmos w=740.00n l=130.00n ng=1
MM5 net4 S VSS VSS sg13_lv_nmos w=740.00n l=130.00n ng=1
MM6 X net1 VSS VSS sg13_lv_nmos w=740.00n l=130.00n ng=1
MM7 Sb S VDD VDD sg13_lv_pmos w=840.00n l=130.00n ng=1
MM8 net2 S VDD VDD sg13_lv_pmos w=1.000u l=130.00n ng=1
MM9 net1 A0 net2 VDD sg13_lv_pmos w=1.000u l=130.00n ng=1
MM10 net3 Sb VDD VDD sg13_lv_pmos w=1.000u l=130.00n ng=1
MM11 net1 A1 net3 VDD sg13_lv_pmos w=1.000u l=130.00n ng=1
MM12 X net1 VDD VDD sg13_lv_pmos w=1.12u l=130.00n ng=1
.ends

* expanding   symbol:  ota_fcasc2_dp.sym # of pins=5
.subckt ota_fcasc2_dp itail vi_p vi_n io_p io_n
*.PININFO itail:I vi_p:I vi_n:I io_n:B io_p:B
MMP1 io_n vi_p itail itail sg13_lv_pmos w=2u l=1u ng=1 m=4
MMP2 io_p vi_n itail itail sg13_lv_pmos w=2u l=1u ng=1 m=4
MMPD1 itail itail itail itail sg13_lv_pmos w=2u l=1u ng=1 m=2
.ends

* expanding   symbol:  ota_fcasc2_nbiascasc.sym # of pins=11
.subckt ota_fcasc2_nbiascasc d_ena_b ibias_200n voutp voutn d_ena io_bias_200n vd2 vd1 vbn vfb vss
*.PININFO vss:B d_ena_b:I ibias_200n:I d_ena:I vbn:O io_bias_200n:I vd1:B voutp:B vd2:B voutn:B vfb:I
MMNSW3 vcn d_ena_b vss vss sg13_lv_nmos w=0.5u l=3u ng=1
MMNSW4 vbn d_ena_b vss vss sg13_lv_nmos w=0.5u l=3u ng=1
MMNSW5 ibias_200n d_ena vcn vss sg13_lv_nmos w=0.5u l=3u ng=1
MMN6 vcn vcn vbn vss sg13_lv_nmos w=0.5u l=3u ng=1
MMN5 vbn vbn vss vss sg13_lv_nmos w=0.5u l=3u ng=1
MMND2 vss vcn vss vss sg13_lv_nmos w=0.5u l=3u ng=1 m=27
MMND1 vss vbn vss vss sg13_lv_nmos w=0.5u l=3u ng=1 m=20
MMN7 vd7 vbn vss vss sg13_lv_nmos w=0.5u l=3u ng=1
MMN8 io_bias_200n vcn vd7 vss sg13_lv_nmos w=0.5u l=3u ng=1
MMN1 vd1 vfb vss vss sg13_lv_nmos w=0.5u l=3u ng=1 m=8
MMN3 voutp vcn vd1 vss sg13_lv_nmos w=0.5u l=3u ng=1 m=5
MMN2 vd2 vfb vss vss sg13_lv_nmos w=0.5u l=3u ng=1 m=8
MMN4 voutn vcn vd2 vss sg13_lv_nmos w=0.5u l=3u ng=1 m=5
MMNSW1 vfb d_ena_b vss vss sg13_lv_nmos w=0.5u l=3u ng=1
MMNC7 vss vd7 vss vss sg13_lv_nmos w=0.5u l=3u ng=1
.ends

* expanding   symbol:  ota_fcasc2_pbiascasc.sym # of pins=7
.subckt ota_fcasc2_pbiascasc vdd itail d_ena_b voutn voutp d_ena vcp
*.PININFO vdd:B d_ena:I d_ena_b:I vcp:B itail:O voutp:B voutn:B
MMPSW4 vcp d_ena vdd vdd sg13_lv_pmos w=3.5u l=2u ng=1
MMPSW3 vbp d_ena vdd vdd sg13_lv_pmos w=1u l=2u ng=1
MMP8 vp8 vbp vdd vdd sg13_lv_pmos w=1u l=2u ng=1
MMP9 vbp vcp vp8 vdd sg13_lv_pmos w=3.5u l=2u ng=1
MMPR vcp d_ena_b vbp vdd sg13_lv_pmos w=0.5u l=10u ng=1
MMP3 vp3 vbp vdd vdd sg13_lv_pmos w=1u l=2u ng=1 m=6
MMP10 itail vcp vp3 vdd sg13_lv_pmos w=3.5u l=2u ng=1 m=6
MMP4 vp4 vbp vdd vdd sg13_lv_pmos w=1u l=2u ng=1 m=5
MMP6 voutp vcp vp4 vdd sg13_lv_pmos w=3.5u l=2u ng=1 m=5
MMP5 vp5 vbp vdd vdd sg13_lv_pmos w=1u l=2u ng=1 m=5
MMP7 voutn vcp vp5 vdd sg13_lv_pmos w=3.5u l=2u ng=1 m=5
MMPD2 vdd vbp vdd vdd sg13_lv_pmos w=1u l=2u ng=1 m=48
MMPD3 vdd vcp vdd vdd sg13_lv_pmos w=3.5u l=2u ng=1 m=4
.ends

* expanding   symbol:  ota_fcasc2_ena.sym # of pins=5
.subckt ota_fcasc2_ena vdd d_ena di_ena d_ena_b vss
*.PININFO vdd:B vss:B di_ena:I d_ena_b:O d_ena:O
MMPEN0 d_ena_b di_ena vdd vdd sg13_lv_pmos w=1u l=2u ng=1
MMNEN0 d_ena_b di_ena vss vss sg13_lv_nmos w=0.5u l=3u ng=1
MMPEN1 d_ena d_ena_b vdd vdd sg13_lv_pmos w=1u l=2u ng=1
MMNEN1 d_ena d_ena_b vss vss sg13_lv_nmos w=0.5u l=3u ng=1
.ends

* expanding   symbol:  cap_dec.sym # of pins=2
.subckt cap_dec vdd vss
*.PININFO vdd:B vss:B
MM1 vdd vss vdd vdd sg13_hv_pmos w=1u l=4u ng=1
.ends

* expanding   symbol:  sw_tgate_cmfb2.sym # of pins=6
.subckt sw_tgate_cmfb2 p m g gb vdd vss
*.PININFO vdd:B vss:B p:B m:B gb:I g:I
MMN p g m vss sg13_lv_nmos w=1u l=1u ng=1
MMP p gb m vdd sg13_lv_pmos w=3u l=1u ng=1
MMND1 p gb p vss sg13_lv_nmos w=0.5u l=1u ng=1
MMND2 m gb m vss sg13_lv_nmos w=0.5u l=1u ng=1
MMPD1 p g p vdd sg13_lv_pmos w=1.5u l=1u ng=1
MMPD2 m g m vdd sg13_lv_pmos w=1.5u l=1u ng=1
MMNG1 m vss m vss sg13_lv_nmos w=0.5u l=1u ng=1
MMNG2 m vss m vss sg13_lv_nmos w=0.5u l=1u ng=1
MMPG1 m vdd m vdd sg13_lv_pmos w=1.5u l=1u ng=1
MMPG2 m vdd m vdd sg13_lv_pmos w=1.5u l=1u ng=1
.ends

* expanding   symbol:  inv_en.sym # of pins=4
.subckt inv_en vdd vss di di_b
*.PININFO vdd:B vss:B di:I di_b:O
MP0 di_b di vdd vdd sg13_hv_pmos w=3u l=450n ng=3
MN0 di_b di vss vss sg13_hv_nmos w=1u l=450n ng=1
.ends

* expanding   symbol:  sg13cmos5l_stdcells/sg13cmos5l_nand2_1.sym # of pins=3
.subckt sg13cmos5l_nand2_1 Y A B VDD VSS

*.PININFO A:I B:I Y:O
MM1 Y A net1 VSS sg13_lv_nmos w=740.00n l=130.00n ng=1
MM2 net1 B VSS VSS sg13_lv_nmos w=740.00n l=130.00n ng=1
MM3 Y A VDD VDD sg13_lv_pmos w=1.12u l=130.00n ng=1
MM4 Y B VDD VDD sg13_lv_pmos w=1.12u l=130.00n ng=1
.ends
