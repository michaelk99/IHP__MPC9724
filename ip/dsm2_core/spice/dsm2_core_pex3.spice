* dsm2_core extracted netlist (subckt dsm2_core_pex), Magic full RC (mode 3, hierarchy off), ngspice syntax
* extracted on 2026-10-31 from dsm2_core.gds md5 00624787128efe33ca6ddf5273170e56 (quantizer2_top.gds md5 59a8af67731cd92ffb1d162911e58fe4)
* MoM caps of sc_int2, vcm_gen and quantizer2_top added back as cap_cmomf devices at the model value
* SPDX-FileCopyrightText: 2026 Michael Koefinger
* SPDX-License-Identifier: Apache-2.0 WITH SHL-2.1
* PEX: sak-pex.sh mode 3 script rerun with ext2spice hierarchy off, pad layout of scripts/pex_gds.py
* NGSPICE file created from dsm2_core_pex.ext - technology: ihp-sg13cmos5l

.subckt dsm2_core_pex vi vcm di_clk di_ena di_rst_b di_trim[3] di_trim[2]
+ di_trim[1] di_trim[0] di_dith_en di_dith_amp[1] di_dith_amp[0] di_vcm_ext
+ di_btest_en di_qout_en do_q do_q_b do_q_dec ibias_test vdd vss di_osc_en
+ di_clk_sel do_clk_osc do_osc_oe
X0 vss.t1613 vdd.t1799 vss.t1611 vss.t1603 sg13_lv_nmos ad=79.8f pd=0.8u as=0 ps=0 w=0.42u l=1u
X1 vss.t1200 a_2034_14038# a_2034_14421# vss.t1213 sg13_lv_nmos ad=0.1406p pd=1.12u as=0.2516p ps=2.16u w=0.74u l=0.13u
X2 a_2034_3670# a_2049_2373# a_2070_3438# vss.t519 sg13_lv_nmos ad=0.12665p pd=1.145u as=0.1428p ps=1.52u w=0.42u l=0.13u
X3 xq_vg_p_0_.t1 sg13cmos5l_inv_1_19.Y.t2 vss.t841 vss.t840 sg13_lv_nmos ad=0.17p pd=1.68u as=95f ps=0.88u w=0.5u l=0.13u
X4 vdd.t778 a_5176_31117# vdd.t779 vdd.t764 sg13_lv_pmos ad=0.465p pd=1.93u as=0 ps=0 w=1u l=2u
X5 a_6884_8680# sg13cmos5l_inv_1_18.Y.t2 vdd.t877 vdd.t658 sg13_lv_pmos ad=0.34p pd=2.68u as=0.34p ps=2.68u w=1u l=0.5u
X6 a_1758_12850# d_dith_en.t29 vss.t1025 vss.t1024 sg13_lv_nmos ad=37.8f pd=0.6u as=79.8f ps=0.8u w=0.42u l=0.13u
X7 vdd.t44 vss.t2391 vdd.t52 vdd.t0 sg13_lv_pmos ad=0.34p pd=2.68u as=0 ps=0 w=1u l=1u
X8 vdd.t17 vss.t2377 vdd.t35 vdd.t10 sg13_lv_pmos ad=0.34p pd=2.68u as=0 ps=0 w=1u l=1u
X9 vss.t123 sw_tgate_cmfb2_1.p.t7 vss.t124 vss.t110 sg13_lv_nmos ad=95f pd=0.88u as=0 ps=0 w=0.5u l=3u
X10 a_8661_9028# a_10757_9168# vss.t52 rhigh l=10.05u w=0.5u
X11 xsc_xcmfb1_vsw_vbias.t11 vdd.t1305 xsc_xcmfb1_vsw_vbias.t12 vdd.t558 sg13_lv_pmos ad=0.51p pd=3.68u as=0 ps=0 w=1.5u l=1u
X12 vdd.t1111 di_dith_en dsm2_io_0.sg13cmos5l_inv_1_0.A vdd.t25 sg13_hv_pmos ad=0.17p pd=1.68u as=0.17p ps=1.68u w=0.5u l=1u
X13 vss.t205 a_17421_7164# a_17140_7466# vss.t204 sg13_lv_nmos ad=79.8f pd=0.8u as=0.1428p ps=1.52u w=0.42u l=0.5u
X14 vss.t1373 a_20328_23820# vss.t1374 vss.t267 sg13_hv_nmos ad=1.9p pd=10.38u as=0 ps=0 w=10u l=10u
X15 quantizer2_lfsr_0.sg13cmos5l_nor2_1_0.A quantizer2_lfsr_0.di_dith_amp[1].t2 vdd.t1194 vdd.t507 sg13_lv_pmos ad=0.3808p pd=2.92u as=0.3808p ps=2.92u w=1.12u l=0.13u
X16 vdd.t162 vss.t2235 vdd.t378 vdd.t85 sg13_lv_pmos ad=0.34p pd=2.68u as=0 ps=0 w=1u l=1u
X17 sg13cmos5l_nor2_1_0.Y sg13cmos5l_and2_1_5.B.t2 a_8618_15186# vdd.t502 sg13_lv_pmos ad=0.3808p pd=2.92u as=0.1176p ps=1.33u w=1.12u l=0.13u
X18 vss.t2044 vdd.t1698 vss.t2043 vss.t2042 sg13_lv_nmos ad=0.1428p pd=1.52u as=0 ps=0 w=0.42u l=1u
X19 vdd.t1160 vdd.t1467 vdd.t1468 vdd.t1173 sg13_lv_pmos ad=95f pd=0.88u as=0 ps=0 w=0.5u l=5u
X20 a_15491_15614# d_ena.t8 a_15721_15998# vss.t1433 sg13_lv_nmos ad=0.2176p pd=1.96u as=0.1216p ps=1.02u w=0.64u l=0.13u
X21 vss.t1492 vdd.t1825 vss.t1494 vss.t1493 sg13_lv_nmos ad=79.8f pd=0.8u as=0 ps=0 w=0.42u l=1u
X22 vdd.t1259 vdd.t1376 vdd.t1377 vdd.t1173 sg13_lv_pmos ad=95f pd=0.88u as=0 ps=0 w=0.5u l=5u
X23 vdd.t281 vss.t2228 vdd.t318 vdd.t159 sg13_lv_pmos ad=0.19p pd=1.38u as=0 ps=0 w=1u l=1u
X24 vdd.t725 dsm2_io_0.sg13cmos5l_inv_1_4.A quantizer2_lfsr_0.di_dith_amp[0].t1 vdd.t617 sg13_lv_pmos ad=0.3808p pd=2.92u as=0.3808p ps=2.92u w=1.12u l=0.13u
X25 vss.t1050 d_dith_en.t8 a_1758_3204# vss.t1125 sg13_lv_nmos ad=0.1626p pd=1.415u as=60.89999f ps=0.71u w=0.42u l=0.13u
X26 vss.t1245 vss.t1246 vss.t693 rhigh l=9.28u w=0.5u
X27 a_2083_2182# d_dith_en.t4 vss.t1124 vss.t1123 sg13_lv_nmos ad=37.8f pd=0.6u as=0.1701p ps=1.65u w=0.42u l=0.13u
X28 vdd.t742 d_dith_en.t21 a_567_8562# vdd.t504 sg13_lv_pmos ad=0.1563p pd=1.22u as=0.147p ps=1.54u w=0.42u l=0.13u
X29 a_9348_31505# a_5176_31117# vdd.t800 vdd.t764 sg13_lv_pmos ad=0.19p pd=1.38u as=0.34p ps=2.68u w=1u l=2u
X30 vdd.t944 vdd.t1579 vdd.t1580 vdd.t572 sg13_lv_pmos ad=95f pd=0.88u as=0 ps=0 w=0.5u l=5u
X31 a_567_786# a_537_1221# a_949_1161# vdd.t504 sg13_lv_pmos ad=79.8f pd=0.8u as=63f ps=0.72u w=0.42u l=0.13u
X32 vdd.t253 vss.t2406 vdd.t252 vdd.t0 sg13_lv_pmos ad=0.19p pd=1.38u as=0 ps=0 w=1u l=1u
X33 a_6874_16020# sg13cmos5l_inv_1_8.Y vss.t1250 vss.t1249 sg13_lv_nmos ad=0.1406p pd=1.12u as=0.2516p ps=2.16u w=0.74u l=0.13u
X34 xsc_vfb.t8 a_6817_30111# vss.t784 vss.t755 sg13_lv_nmos ad=0.17p pd=1.68u as=95f ps=0.88u w=0.5u l=3u
X35 vss.t1369 a_20328_23820# vss.t1370 vss.t267 sg13_hv_nmos ad=1.9p pd=10.38u as=0 ps=0 w=10u l=10u
X36 vdd.t441 vss.t2154 vdd.t440 vdd.t308 sg13_lv_pmos ad=0.34p pd=2.68u as=0 ps=0 w=1u l=1u
X37 a_1324_11172# a_1322_11954# a_1284_13167# vss.t559 sg13_lv_nmos ad=0.3473p pd=2.71u as=0.12665p ps=1.145u w=0.74u l=0.13u
X38 vss.t1561 vdd.t1811 vss.t1560 vss.t1559 sg13_lv_nmos ad=0.1428p pd=1.52u as=0 ps=0 w=0.42u l=1u
X39 xsc_vc1r_p.t6 sw_tgate_11.gb.t6 vcm_esd.t4 vdd.t556 sg13_lv_pmos ad=0.38p pd=2.38u as=0.38p ps=2.38u w=2u l=1u
X40 vdd.t1166 bias_gm_0.bias_trim_0.vz.t26 a_22252_4074# vdd.t570 sg13_lv_pmos ad=95f pd=0.88u as=95f ps=0.88u w=0.5u l=5u
X41 vdd.t549 a_21498_769# dsm2_osc_0.sg13cmos5l_mux2_1_0.A1 vdd.t515 sg13_lv_pmos ad=0.2128p pd=1.5u as=0.3808p ps=2.92u w=1.12u l=0.13u
X42 a_537_3813# d_qclk.t7 vdd.t511 vdd.t504 sg13_lv_pmos ad=0.4088p pd=2.97u as=1.1847p ps=7.385u w=1.12u l=0.13u
X43 vdd.t137 vss.t2329 vdd.t240 vdd.t135 sg13_lv_pmos ad=0.19p pd=1.38u as=0 ps=0 w=1u l=1u
X44 a_522_2184# a_567_786# vss.t1137 vss.t1416 sg13_lv_nmos ad=0.2516p pd=2.16u as=0.1626p ps=1.415u w=0.74u l=0.13u
X45 d_dith[0].t1 a_2034_698# vss.t636 vss.t635 sg13_lv_nmos ad=0.2886p pd=2.26u as=0.14875p ps=1.16u w=0.74u l=0.13u
X46 vss.t1976 vdd.t1712 vss.t1975 vss.t1974 sg13_lv_nmos ad=0.1428p pd=1.52u as=0 ps=0 w=0.42u l=1u
X47 vdd.t180 vss.t2278 vdd.t179 vdd.t153 sg13_lv_pmos ad=0.19p pd=1.38u as=0 ps=0 w=1u l=1u
X48 a_522_2354# d_dith_en.t6 vdd.t511 vdd.t504 sg13_lv_pmos ad=79.8f pd=0.8u as=1.1847p ps=7.385u w=0.42u l=0.13u
X49 vss.t939 d_dith_en.t15 a_558_5796# vss.t1110 sg13_lv_nmos ad=0.1626p pd=1.415u as=60.89999f ps=0.71u w=0.42u l=0.13u
X50 a_22252_11246# a_19984_17824# vss.t356 vss.t265 sg13_hv_nmos ad=95f pd=0.88u as=95f ps=0.88u w=0.5u l=10u
X51 vss.t799 d_qout_en.t2 a_11083_15998# vss.t1184 sg13_lv_nmos ad=0.1331p pd=1.12u as=0.1216p ps=1.02u w=0.64u l=0.13u
X52 vdd.t1650 vss.t2419 vdd.t1649 vdd.t0 sg13_lv_pmos ad=0.34p pd=2.68u as=0 ps=0 w=1u l=1u
X53 vo_p.t9 sg13cmos5l_inv_1_3.Y.t3 xq_dith_v_bq.t3 vdd.t624 sg13_lv_pmos ad=0.665p pd=3.88u as=0.665p ps=3.88u w=3.5u l=0.13u
X54 vdd.t485 vss.t2281 vdd.t154 vdd.t153 sg13_lv_pmos ad=0.34p pd=2.68u as=0 ps=0 w=1u l=1u
X55 vss.t657 vss.t658 vss.t531 rhigh l=2.75u w=0.5u
X56 a_21478_2578# a_21452_2308.t6 a_21276_2052# vdd.t514 sg13_lv_pmos ad=95f pd=0.88u as=0.17p ps=1.68u w=0.5u l=0.13u
X57 a_11293_11104.t8 xq_vg_p_2_.t3 a_9357_11104.t18 vss.t643 sg13_lv_nmos ad=0.285p pd=1.88u as=0.285p ps=1.88u w=1.5u l=0.5u
X58 vss.t1487 vdd.t1826 vss.t1486 vss.t1485 sg13_lv_nmos ad=0.1428p pd=1.52u as=0 ps=0 w=0.42u l=1u
X59 vo_p.t23 vdd.t1298 vo_p.t13 vdd.t900 sg13_lv_pmos ad=0.285p pd=1.88u as=0 ps=0 w=1.5u l=1u
X60 xq_vg_p_1_.t2 sg13cmos5l_inv_1_6.A.t2 a_6249_9100.t12 vdd.t763 sg13_lv_pmos ad=95f pd=0.88u as=0.17p ps=1.68u w=0.5u l=0.13u
X61 vdd.t981 sg13cmos5l_nand2_1_5.A.t2 sg13cmos5l_inv_1_17.A.t0 vdd.t502 sg13_lv_pmos ad=0.3808p pd=2.92u as=0.2128p ps=1.5u w=1.12u l=0.13u
X62 vss.t852 ibias_200n.t6 vss.t851 vss.t269 sg13_hv_nmos ad=95f pd=0.88u as=0 ps=0 w=0.5u l=10u
X63 vss.t800 vss.t801 vss.t39 rhigh l=2.75u w=0.5u
X64 vss.t2029 vdd.t1701 vss.t2028 vss.t2027 sg13_lv_nmos ad=0.1428p pd=1.52u as=0 ps=0 w=0.42u l=1u
X65 quantizer2_lfsr_0.sg13cmos5l_dfrbpq_1_4.Q a_2034_9237# vdd.t536 vdd.t507 sg13_lv_pmos ad=0.3808p pd=2.92u as=0.2128p ps=1.5u w=1.12u l=0.13u
X66 vdd.t1327 vdd.t1325 vdd.t1329 vdd.t863 sg13_lv_pmos ad=0.285p pd=1.88u as=0 ps=0 w=1.5u l=0.5u
X67 vss.t1257 a_6817_30111# a_12445_30191# vss.t1256 sg13_lv_nmos ad=95f pd=0.88u as=0.17p ps=1.68u w=0.5u l=3u
X68 vdd.t599 quantizer2_lfsr_0.sg13cmos5l_dfrbpq_1_0.Q a_2034_1466# vdd.t507 sg13_lv_pmos ad=0.2114p pd=1.54u as=0.2856p ps=2.36u w=0.84u l=0.13u
X69 a_9348_31505# a_5176_31117# vdd.t804 vdd.t764 sg13_lv_pmos ad=0.19p pd=1.38u as=0.34p ps=2.68u w=1u l=2u
X70 a_2034_8690# a_2034_8854# a_2070_8818# vss.t714 sg13_lv_nmos ad=0.1428p pd=1.52u as=37.8f ps=0.6u w=0.42u l=0.13u
X71 vdd.t511 a_537_8997# a_533_9920# vdd.t504 sg13_lv_pmos ad=1.21587p pd=7.58u as=0.3864p ps=2.93u w=1.12u l=0.13u
X72 a_7224_31505# a_5176_31469# w_9407_29481.t9 vdd.t764 sg13_lv_pmos ad=0.665p pd=3.88u as=1.19p ps=7.68u w=3.5u l=2u
X73 vss.t209 vss.t210 vss.t39 rhigh l=2.75u w=0.5u
X74 a_11115_8888# a_13211_9028# vss.t6 rhigh l=10.05u w=0.5u
X75 vdd.t1659 vss.t2194 vdd.t380 vdd.t379 sg13_lv_pmos ad=0.19p pd=1.38u as=0 ps=0 w=1u l=1u
X76 vss.t1807 vdd.t1752 vss.t1805 vss.t1797 sg13_lv_nmos ad=79.8f pd=0.8u as=0 ps=0 w=0.42u l=1u
X77 vss.t1084 a_522_15314# a_558_15246# vss.t1251 sg13_lv_nmos ad=79.8f pd=0.8u as=0.1428p ps=1.52u w=0.42u l=0.13u
X78 vdd.t1539 vdd.t1537 vdd.t1167 vdd.t1287 sg13_lv_pmos ad=0.17p pd=1.68u as=0 ps=0 w=0.5u l=5u
X79 vss.t1680 vdd.t1782 vss.t1679 vss.t1666 sg13_lv_nmos ad=0.1428p pd=1.52u as=0 ps=0 w=0.42u l=1u
X80 vss.t1547 vdd.t1814 vss.t1549 vss.t1548 sg13_lv_nmos ad=79.8f pd=0.8u as=0 ps=0 w=0.42u l=1u
X81 a_2074_14933# quantizer2_lfsr_0.sg13cmos5l_dfrbpq_1_6.Q vss.t1055 vss.t664 sg13_lv_nmos ad=0.1406p pd=1.12u as=0.1898p ps=1.36u w=0.74u l=0.13u
X82 vss.t237 a_1284_2799# a_1284_2901# vss.t236 sg13_lv_nmos ad=0.1406p pd=1.12u as=0.2516p ps=2.16u w=0.74u l=0.13u
X83 a_2070_6948# quantizer2_lfsr_0.sg13cmos5l_dfrbpq_1_3.Q a_2070_6854# vss.t577 sg13_lv_nmos ad=60.89999f pd=0.71u as=0.1428p ps=1.52u w=0.42u l=0.13u
X84 vss.t892 a_9721_7200# a_9833_7224# vss.t891 sg13_lv_nmos ad=0.1426p pd=1.16u as=0.1428p ps=1.52u w=0.42u l=0.5u
X85 vdd.t999 bias_gm_0.bias_trim_0.vz.t15 bias_gm_0.bias_trim_0.vz.t16 vdd.t573 sg13_lv_pmos ad=95f pd=0.88u as=95f ps=0.88u w=0.5u l=5u
X86 a_22252_11246# bias_gm_0.bias_trim_0.vz.t3 vdd.t1181 vdd.t566 sg13_lv_pmos ad=95f pd=0.88u as=95f ps=0.88u w=0.5u l=5u
X87 a_7129_7200# a_6859_7241# vss.t86 vss.t85 sg13_lv_nmos ad=0.1428p pd=1.52u as=79.8f ps=0.8u w=0.42u l=0.5u
X88 vss.t1598 vdd.t1802 vss.t1597 vss.t1588 sg13_lv_nmos ad=0.1428p pd=1.52u as=0 ps=0 w=0.42u l=1u
X89 xsc_vfb.t5 sw_tgate_cmfb2_3.gb.t2 xsc_xcmfb1_vsw_vbias.t7 vdd.t560 sg13_lv_pmos ad=0.285p pd=1.88u as=0.285p ps=1.88u w=1.5u l=1u
X90 vdd.t14 vss.t2371 vdd.t51 vdd.t3 sg13_lv_pmos ad=0.19p pd=1.38u as=0 ps=0 w=1u l=1u
X91 vss.t2130 di_trim[1] dsm2_io_0.do_trim_b[1].t0 vss.t2129 sg13_hv_nmos ad=0.34p pd=2.68u as=0.34p ps=2.68u w=1u l=0.45u
X92 vdd.t680 bias_gm_0.bias_trim_0.vz.t49 a_22252_8246# vdd.t384 sg13_lv_pmos ad=95f pd=0.88u as=95f ps=0.88u w=0.5u l=5u
X93 vdd.t921 d_dith_en.t28 a_2079_12306# vdd.t507 sg13_lv_pmos ad=0.1563p pd=1.22u as=0.147p ps=1.54u w=0.42u l=0.13u
X94 vdd.t16 vss.t2384 vdd.t15 vdd.t10 sg13_lv_pmos ad=0.19p pd=1.38u as=0 ps=0 w=1u l=1u
X95 vdd.t862 a_15130_14856# a_14849_15078# vdd.t502 sg13_lv_pmos ad=0.1523p pd=1.38u as=0.34p ps=2.68u w=1u l=0.5u
X96 vss.t1577 vdd.t1807 vss.t1576 vss.t1575 sg13_lv_nmos ad=0.1428p pd=1.52u as=0 ps=0 w=0.42u l=1u
X97 vss.t567 sg13cmos5l_inv_1_12.Y do_q_b.t1 vss.t566 sg13_lv_nmos ad=0.2516p pd=2.16u as=0.1406p ps=1.12u w=0.74u l=0.13u
X98 a_22184_2052# dsm2_osc_0.dsm2_io_rx_0.di_b.t5 vss.t541 vss.t540 sg13_lv_nmos ad=95f pd=0.88u as=0.17p ps=1.68u w=0.5u l=0.13u
X99 a_21830_2578# a_21276_2052# a_21736_2344# vdd.t514 sg13_lv_pmos ad=95f pd=0.88u as=0.17p ps=1.68u w=0.5u l=0.13u
X100 vss.t1188 vss.t1189 vss.t1187 rhigh l=20u w=0.5u
X101 vss.t2095 sg13cmos5l_inv_1_1.A vss.t2092 vss.t2090 sg13_lv_nmos ad=0.665p pd=3.88u as=0 ps=0 w=3.5u l=1u
X102 xsc_xcmfb1_vsw_vbias.t2 sw_tgate_cmfb2_1.gb.t2 sw_tgate_cmfb2_1.p.t3 vdd.t558 sg13_lv_pmos ad=0.285p pd=1.88u as=0.285p ps=1.88u w=1.5u l=1u
X103 a_22252_11246# a_19904_17646# vss.t1335 vss.t1169 sg13_hv_nmos ad=0.17p pd=1.68u as=0.17p ps=1.68u w=0.5u l=1u
X104 a_23289_752# dsm2_osc_0.sg13cmos5l_dfrbp_1_0.RESET_B.t2 vdd.t600 vdd.t515 sg13_lv_pmos ad=0.147p pd=1.54u as=0.1563p ps=1.22u w=0.42u l=0.13u
X105 vss.t1647 vdd.t1791 vss.t1645 vss.t1646 sg13_lv_nmos ad=79.8f pd=0.8u as=0 ps=0 w=0.42u l=1u
X106 clk_noverlap_0.do_phi2_b clk_noverlap_0.sg13cmos5l_inv_1_8.A vss.t716 vss.t715 sg13_lv_nmos ad=0.2516p pd=2.16u as=0.2516p ps=2.16u w=0.74u l=0.13u
X107 a_571_8868# a_533_9920# a_567_8562# vss.t844 sg13_lv_nmos ad=0.2373p pd=1.97u as=79.8f ps=0.8u w=0.42u l=0.13u
X108 a_558_2482# d_dith_en.t6 vss.t524 vss.t1130 sg13_lv_nmos ad=37.8f pd=0.6u as=79.8f ps=0.8u w=0.42u l=0.13u
X109 a_4362_8188.t4 sg13cmos5l_inv_1_9.Y.t3 xq_dith_v_bq.t1 vdd.t624 sg13_lv_pmos ad=0.665p pd=3.88u as=0.665p ps=3.88u w=3.5u l=0.13u
X110 a_562_16373# quantizer2_lfsr_0.sg13cmos5l_dfrbpq_1_1.Q vss.t987 vss.t1276 sg13_lv_nmos ad=0.1406p pd=1.12u as=0.1898p ps=1.36u w=0.74u l=0.13u
X111 a_1443_4857# a_1322_4178# a_1284_5391# vdd.t504 sg13_lv_pmos ad=93.45f pd=0.865u as=0.2048p ps=1.63u w=0.42u l=0.13u
X112 a_1758_612# quantizer2_lfsr_0.sg13cmos5l_dfrbpq_1_11.D.t2 a_1367_1349# vss.t472 sg13_lv_nmos ad=60.89999f pd=0.71u as=0.1428p ps=1.52u w=0.42u l=0.13u
X113 vdd.t1186 bias_gm_0.bias_trim_0.vz.t3 a_22252_11246# vdd.t570 sg13_lv_pmos ad=95f pd=0.88u as=95f ps=0.88u w=0.5u l=5u
X114 a_7804_29739.t0 xsc_vvg_p.t6 w_9407_29481.t1 w_9407_29481.t0 sg13_lv_pmos ad=0.38p pd=2.38u as=0.38p ps=2.38u w=2u l=1u
X115 d_qi.t2 sg13cmos5l_nor2_2_2.A vss.t1206 vss.t1205 sg13_lv_nmos ad=0.1406p pd=1.12u as=0.2516p ps=2.16u w=0.74u l=0.13u
X116 a_1367_14121# a_1324_13764# vdd.t1027 vdd.t504 sg13_lv_pmos ad=63f pd=0.72u as=0.1563p ps=1.22u w=0.42u l=0.13u
X117 vdd.t684 vdd.t1443 vdd.t1444 vdd.t1173 sg13_lv_pmos ad=95f pd=0.88u as=0 ps=0 w=0.5u l=5u
X118 vdd.t1553 vdd.t1552 vdd.t1152 vdd.t566 sg13_lv_pmos ad=95f pd=0.88u as=0 ps=0 w=0.5u l=5u
X119 vss.t1522 vdd.t1819 vss.t1521 vss.t1520 sg13_lv_nmos ad=0.1428p pd=1.52u as=0 ps=0 w=0.42u l=1u
X120 vdd.t1166 vdd.t1569 vdd.t1570 vdd.t1173 sg13_lv_pmos ad=95f pd=0.88u as=0 ps=0 w=0.5u l=5u
X121 a_1407_12722# d_dith_en.t29 vdd.t511 vdd.t504 sg13_lv_pmos ad=79.8f pd=0.8u as=1.1847p ps=7.385u w=0.42u l=0.13u
X122 xq_vg_p_0_.t0 sg13cmos5l_inv_1_20.Y.t2 a_5892_8400.t9 vss.t870 sg13_lv_nmos ad=95f pd=0.88u as=0.17p ps=1.68u w=0.5u l=0.13u
X123 a_20672_20460# a_24258_20320# vss.t207 rhigh l=17.5u w=0.5u
X124 sg13cmos5l_inv_1_3.A.t1 a_7437_15998# vdd.t1078 vdd.t502 sg13_lv_pmos ad=0.3808p pd=2.92u as=0.1918p ps=1.5u w=1.12u l=0.13u
X125 a_522_4946# a_522_5110# a_558_5074# vss.t15 sg13_lv_nmos ad=0.1428p pd=1.52u as=37.8f ps=0.6u w=0.42u l=0.13u
X126 sg13cmos5l_inv_1_2.A.t5 sg13cmos5l_inv_1_14.A.t10 a_9533_11104.t8 vss.t29 sg13_lv_nmos ad=95f pd=0.88u as=95f ps=0.88u w=0.5u l=0.5u
X127 vss.t1590 vdd.t1804 vss.t1589 vss.t1588 sg13_lv_nmos ad=0.1428p pd=1.52u as=0 ps=0 w=0.42u l=1u
X128 vss.t1066 d_dith_en.t22 a_2070_9540# vss.t1065 sg13_lv_nmos ad=0.1626p pd=1.415u as=60.89999f ps=0.71u w=0.42u l=0.13u
X129 vdd.t822 a_5176_31117# vdd.t820 vdd.t764 sg13_lv_pmos ad=0.465p pd=1.93u as=0 ps=0 w=1u l=2u
X130 vss.t1301 dsm2_io_0.sg13cmos5l_inv_1_0.A d_dith_en.t0 vss.t467 sg13_lv_nmos ad=0.2516p pd=2.16u as=0.2516p ps=2.16u w=0.74u l=0.13u
X131 vss.t1382 do_osc_oe.t2 a_20447_636# vss.t1381 sg13_lv_nmos ad=0.18945p pd=1.27u as=0.187p ps=1.78u w=0.55u l=0.13u
X132 vdd.t246 vss.t2238 vdd.t245 vdd.t138 sg13_lv_pmos ad=0.19p pd=1.38u as=0 ps=0 w=1u l=1u
X133 vdd.t227 vss.t2227 vdd.t349 vdd.t159 sg13_lv_pmos ad=0.34p pd=2.68u as=0 ps=0 w=1u l=1u
X134 a_522_9960# a_567_8562# vdd.t505 vdd.t504 sg13_lv_pmos ad=0.34p pd=2.68u as=0.36237p ps=2.605u w=1u l=0.13u
X135 vss.t2034 vdd.t1700 vss.t2033 vss.t2032 sg13_lv_nmos ad=0.1428p pd=1.52u as=0 ps=0 w=0.42u l=1u
X136 vdd.t1495 vdd.t1493 vdd.t989 vdd.t1287 sg13_lv_pmos ad=0.17p pd=1.68u as=0 ps=0 w=0.5u l=5u
X137 a_20672_21860# a_24258_22000# vss.t207 rhigh l=17.5u w=0.5u
X138 a_1758_3204# quantizer2_lfsr_0.sg13cmos5l_dfrbpq_1_11.Q.t3 a_1367_3941# vss.t927 sg13_lv_nmos ad=60.89999f pd=0.71u as=0.1428p ps=1.52u w=0.42u l=0.13u
X139 vdd.t511 a_1286_12023# a_1322_11954# vdd.t504 sg13_lv_pmos ad=1.21587p pd=7.58u as=0.3864p ps=2.93u w=1.12u l=0.13u
X140 vdd.t505 d_dith_en.t21 a_558_8294# vdd.t504 sg13_lv_pmos ad=0.36237p pd=2.605u as=79.8f ps=0.8u w=0.42u l=0.13u
X141 a_522_12722# d_dith_en.t30 vdd.t511 vdd.t504 sg13_lv_pmos ad=79.8f pd=0.8u as=1.1847p ps=7.385u w=0.42u l=0.13u
X142 ibias_200n.t2 dsm2_io_0.do_trim_b[0].t3 a_23328_9146# vdd.t572 sg13_lv_pmos ad=95f pd=0.88u as=95f ps=0.88u w=0.5u l=5u
X143 vss.t1482 vdd.t1827 vss.t1484 vss.t1483 sg13_lv_nmos ad=79.8f pd=0.8u as=0 ps=0 w=0.42u l=1u
X144 vss.t1756 vdd.t1764 vss.t1754 vss.t1746 sg13_lv_nmos ad=79.8f pd=0.8u as=0 ps=0 w=0.42u l=1u
X145 a_1367_14309# a_1322_14546# a_1288_13738# vdd.t504 sg13_lv_pmos ad=0.1428p pd=1.52u as=79.8f ps=0.8u w=0.42u l=0.13u
X146 vdd.t904 di_btest_en dsm2_io_0.sg13cmos5l_inv_1_5.A vdd.t25 sg13_hv_pmos ad=0.17p pd=1.68u as=0.17p ps=1.68u w=0.5u l=1u
X147 sg13cmos5l_nor2_2_0.B.t2 sg13cmos5l_nand2_2_0.B.t3 vdd.t872 vdd.t502 sg13_lv_pmos ad=0.2128p pd=1.5u as=0.3808p ps=2.92u w=1.12u l=0.13u
X148 a_9533_11104.t2 xq_vg_q_0_.t3 a_9357_11104.t10 vss.t387 sg13_lv_nmos ad=0.285p pd=1.88u as=0.285p ps=1.88u w=1.5u l=0.5u
X149 a_10198_6736# clk_noverlap_0.sg13cmos5l_inv_1_11.Y a_10096_6736# vdd.t308 sg13_lv_pmos ad=0.2464p pd=1.56u as=0.2128p ps=1.5u w=1.12u l=0.13u
X150 vdd.t1017 bias_gm_0.bias_trim_0.vz.t45 a_22252_8246# vdd.t570 sg13_lv_pmos ad=95f pd=0.88u as=95f ps=0.88u w=0.5u l=5u
X151 a_9357_11104.t8 vss.t427 a_9357_11104.t7 vss.t391 sg13_lv_nmos ad=0.285p pd=1.88u as=0 ps=0 w=1.5u l=0.5u
X152 vss.t1271 a_13870_15077# sg13cmos5l_and2_1_5.A.t0 vss.t855 sg13_lv_nmos ad=0.1426p pd=1.16u as=0.2516p ps=2.16u w=0.74u l=0.13u
X153 vo_n.t13 a_5176_30111# a_7804_29739.t3 vss.t761 sg13_lv_nmos ad=95f pd=0.88u as=95f ps=0.88u w=0.5u l=3u
X154 a_28746_14846# a_19964_18216# a_26670_15146# vdd.t1128 sg13_lv_pmos ad=0.17p pd=1.68u as=95f ps=0.88u w=0.5u l=10u
X155 vdd.t961 sg13cmos5l_and2_2_1.X.t3 a_11293_11104.t5 vdd.t863 sg13_lv_pmos ad=0.285p pd=1.88u as=0.285p ps=1.88u w=1.5u l=0.5u
X156 vdd.t527 dsm2_io_vcmg_0.di_phi1_b a_8974_5832# vdd.t526 sg13_lv_pmos ad=0.2226p pd=1.535u as=0.1596p ps=1.22u w=0.84u l=0.13u
X157 sw_tgate_cmfb2_3.gb.t0 d_phi1.t10 vss.t900 vss.t899 sg13_lv_nmos ad=0.34p pd=2.68u as=0.34p ps=2.68u w=1u l=0.13u
X158 vss.t712 a_2034_8690# a_2070_8622# vss.t711 sg13_lv_nmos ad=79.8f pd=0.8u as=0.1428p ps=1.52u w=0.42u l=0.13u
X159 vdd.t962 sg13cmos5l_and2_2_1.X.t3 a_11293_11104.t6 vdd.t863 sg13_lv_pmos ad=0.285p pd=1.88u as=0.285p ps=1.88u w=1.5u l=0.5u
X160 vss.t1452 vdd.t1833 vss.t1451 vss.t1450 sg13_lv_nmos ad=0.1428p pd=1.52u as=0 ps=0 w=0.42u l=1u
X161 a_12705_7467# a_12820_7466# vdd.t616 vdd.t308 sg13_lv_pmos ad=0.34p pd=2.68u as=0.2254p ps=1.53u w=1u l=0.5u
X162 a_2034_14038# a_2049_12741# a_2070_13806# vss.t821 sg13_lv_nmos ad=0.12665p pd=1.145u as=0.1428p ps=1.52u w=0.42u l=0.13u
X163 vdd.t511 a_1407_2354# a_1443_2265# vdd.t504 sg13_lv_pmos ad=1.21587p pd=7.58u as=93.45f ps=0.865u w=0.42u l=0.13u
X164 a_19964_18216# a_19964_18216# a_24602_14546# vdd.t1127 sg13_lv_pmos ad=95f pd=0.88u as=0.17p ps=1.68u w=0.5u l=10u
X165 vdd.t156 vss.t2233 vdd.t158 vdd.t147 sg13_hv_pmos ad=0.285p pd=1.88u as=0 ps=0 w=1.5u l=0.45u
X166 a_522_10130# a_522_10294# a_558_10258# vss.t1334 sg13_lv_nmos ad=0.1428p pd=1.52u as=37.8f ps=0.6u w=0.42u l=0.13u
X167 vss.t1139 di_dith_en dsm2_io_0.sg13cmos5l_inv_1_0.A vss.t1138 sg13_hv_nmos ad=0.34p pd=2.68u as=0.34p ps=2.68u w=1u l=0.45u
X168 clk_noverlap_0.sg13cmos5l_dlygate4sd3_1_1.X a_5513_7224# vss.t230 vss.t229 sg13_lv_nmos ad=0.2516p pd=2.16u as=0.1426p ps=1.16u w=0.74u l=0.13u
X169 a_24540_20600# a_28126_20740# vss.t34 rhigh l=17.5u w=0.5u
X170 a_8762_31505# a_5176_31469# vo_p.t18 vdd.t764 sg13_lv_pmos ad=1.19p pd=7.68u as=1.19p ps=7.68u w=3.5u l=2u
X171 vdd.t507 a_2034_3506# a_2385_3417# vdd.t507 sg13_lv_pmos ad=1.99007p pd=12.8u as=93.45f ps=0.865u w=0.42u l=0.13u
X172 a_22252_7946# bias_gm_0.bias_trim_0.vz.t46 vdd.t951 vdd.t566 sg13_lv_pmos ad=95f pd=0.88u as=95f ps=0.88u w=0.5u l=5u
X173 xsc_vc1l_p.t9 sw_tgate_11.gb.t4 xsc_vc1l_p.t8 vss.t601 sg13_lv_nmos ad=0.19p pd=1.38u as=0 ps=0 w=1u l=1u
X174 do_clk_osc.t0 dsm2_osc_0.sg13cmos5l_inv_1_2.Y vss.t154 vss.t153 sg13_lv_nmos ad=0.1406p pd=1.12u as=0.2516p ps=2.16u w=0.74u l=0.13u
X175 a_1745_8806# d_dith_en.t20 vss.t1106 vss.t1105 sg13_lv_nmos ad=37.8f pd=0.6u as=0.1701p ps=1.65u w=0.42u l=0.13u
X176 vss.t1624 vdd.t1796 vss.t1623 vss.t1622 sg13_lv_nmos ad=0.1428p pd=1.52u as=0 ps=0 w=0.42u l=1u
X177 vss.t1658 vdd.t1788 vss.t1659 vss.t1651 sg13_lv_nmos ad=79.8f pd=0.8u as=0 ps=0 w=0.42u l=1u
X178 vss.t808 vss.t809 vss.t39 rhigh l=2.75u w=0.5u
X179 sw_tgate_6.p.t1 sw_tgate_11.gb.t3 xsc_vc1l_n.t6 vdd.t562 sg13_lv_pmos ad=0.68p pd=4.68u as=0.38p ps=2.38u w=2u l=1u
X180 vdd.t772 a_5176_31117# vdd.t773 vdd.t764 sg13_lv_pmos ad=0.19p pd=1.38u as=0 ps=0 w=1u l=2u
X181 vdd.t157 vss.t2233 vdd.t156 vdd.t147 sg13_hv_pmos ad=0.51p pd=3.68u as=0 ps=0 w=1.5u l=0.45u
X182 xsc_vfb.t6 d_phi1.t6 xsc_xcmfb1_vsw_vbias.t10 vss.t908 sg13_lv_nmos ad=95f pd=0.88u as=95f ps=0.88u w=0.5u l=1u
X183 vdd.t859 di_trim[3] dsm2_io_0.do_trim_b[3].t1 vdd.t25 sg13_hv_pmos ad=0.17p pd=1.68u as=0.17p ps=1.68u w=0.5u l=1u
X184 vss.t2016 vdd.t1704 vss.t2014 vss.t2015 sg13_lv_nmos ad=79.8f pd=0.8u as=0 ps=0 w=0.42u l=1u
X185 vdd.t258 vss.t2411 vdd.t260 vdd.t0 sg13_lv_pmos ad=0.34p pd=2.68u as=0 ps=0 w=1u l=1u
X186 vdd.t12 vss.t2386 vdd.t38 vdd.t10 sg13_lv_pmos ad=0.19p pd=1.38u as=0 ps=0 w=1u l=1u
X187 xq_vg_p_1_.t1 sg13cmos5l_inv_1_6.Y.t2 a_6249_9100.t11 vss.t956 sg13_lv_nmos ad=95f pd=0.88u as=0.17p ps=1.68u w=0.5u l=0.13u
X188 vdd.t115 vss.t2177 vdd.t114 vdd.t113 sg13_lv_pmos ad=0.34p pd=2.68u as=0 ps=0 w=1u l=1u
X189 vss.t1266 vss.t1267 vss.t39 rhigh l=2.75u w=0.5u
X190 a_522_15478# a_537_14181# a_558_15246# vss.t1175 sg13_lv_nmos ad=0.12665p pd=1.145u as=0.1428p ps=1.52u w=0.42u l=0.13u
X191 a_1286_1655# d_qclk.t3 vdd.t511 vdd.t504 sg13_lv_pmos ad=0.4088p pd=2.97u as=1.1847p ps=7.385u w=1.12u l=0.13u
X192 a_17421_7164# d_phi2.t3 vdd.t564 vdd.t308 sg13_lv_pmos ad=0.1428p pd=1.52u as=0.1523p ps=1.38u w=0.42u l=0.13u
X193 vss.t1565 vdd.t1810 vss.t1566 vss.t1562 sg13_lv_nmos ad=79.8f pd=0.8u as=0 ps=0 w=0.42u l=1u
X194 a_9556_15186# sg13cmos5l_nor2_2_0.B.t4 sg13cmos5l_nor2_2_0.Y vdd.t502 sg13_lv_pmos ad=0.2128p pd=1.5u as=0.2128p ps=1.5u w=1.12u l=0.13u
X195 a_23328_5574# bias_gm_0.bias_trim_0.vz.t30 vdd.t1152 vdd.t384 sg13_lv_pmos ad=95f pd=0.88u as=95f ps=0.88u w=0.5u l=5u
X196 vdd.t411 vss.t2159 vdd.t353 vdd.t308 sg13_lv_pmos ad=0.19p pd=1.38u as=0 ps=0 w=1u l=1u
X197 vss.t22 a_21736_2344# vss.t510 vss.t509 sg13_lv_nmos ad=0.17p pd=1.68u as=0 ps=0 w=0.5u l=0.5u
X198 vss.t722 xsc_vfb.t12 a_7804_29739.t6 vss.t106 sg13_lv_nmos ad=95f pd=0.88u as=95f ps=0.88u w=0.5u l=3u
X199 sg13cmos5l_inv_1_4.A.t0 sg13cmos5l_nand2_1_5.A.t6 a_6874_16020# vss.t955 sg13_lv_nmos ad=0.2516p pd=2.16u as=0.1406p ps=1.12u w=0.74u l=0.13u
X200 vdd.t956 bias_gm_0.bias_trim_0.vz.t46 a_22252_7946# vdd.t570 sg13_lv_pmos ad=95f pd=0.88u as=95f ps=0.88u w=0.5u l=5u
X201 a_22252_11246# bias_gm_0.bias_trim_0.vz.t51 vdd.t727 vdd.t572 sg13_lv_pmos ad=95f pd=0.88u as=95f ps=0.88u w=0.5u l=5u
X202 vss.t1876 vdd.t1735 vss.t1874 vss.t1875 sg13_lv_nmos ad=79.8f pd=0.8u as=0 ps=0 w=0.42u l=1u
X203 a_21498_769# a_21617_558# vdd.t549 vdd.t515 sg13_lv_pmos ad=0.3864p pd=2.93u as=0.2128p ps=1.5u w=1.12u l=0.13u
X204 vi_esd.t1 d_phi2.t5 vi_esd.t0 vdd.t562 sg13_lv_pmos ad=0.68p pd=4.68u as=0 ps=0 w=2u l=1u
X205 vss.t579 d_dith_en.t14 a_1758_5796# vss.t1060 sg13_lv_nmos ad=0.1626p pd=1.415u as=60.89999f ps=0.71u w=0.42u l=0.13u
X206 vdd.t348 vss.t2324 vdd.t213 vdd.t135 sg13_lv_pmos ad=0.34p pd=2.68u as=0 ps=0 w=1u l=1u
X207 a_2083_4774# d_dith_en.t10 vss.t1132 vss.t660 sg13_lv_nmos ad=37.8f pd=0.6u as=0.1701p ps=1.65u w=0.42u l=0.13u
X208 xq_dith_v_bp.t13 sg13cmos5l_inv_1_3.Y.t2 vo_n.t16 vdd.t623 sg13_lv_pmos ad=0.665p pd=3.88u as=0.665p ps=3.88u w=3.5u l=0.13u
X209 a_567_3378# a_537_3813# a_949_3753# vdd.t504 sg13_lv_pmos ad=79.8f pd=0.8u as=63f ps=0.72u w=0.42u l=0.13u
X210 d_vcm_phi1_b.t0 a_8880_5832# vss.t58 vss.t57 sg13_lv_nmos ad=0.2516p pd=2.16u as=0.1469p ps=1.155u w=0.74u l=0.13u
X211 a_24214_15746# a_20138_14766# a_22138_15746# vdd.t898 sg13_lv_pmos ad=0.17p pd=1.68u as=95f ps=0.88u w=0.5u l=10u
X212 d_vcm_phi2 a_16941_5500# vss.t469 vss.t683 sg13_lv_nmos ad=0.2516p pd=2.16u as=0.1331p ps=1.12u w=0.74u l=0.13u
X213 sg13cmos5l_nand2_2_0.B.t0 a_15491_15614# vss.t1305 vss.t1304 sg13_lv_nmos ad=0.1406p pd=1.12u as=0.2812p ps=2.24u w=0.74u l=0.13u
X214 vss.t1962 vdd.t1715 vss.t1963 vss.t1950 sg13_lv_nmos ad=79.8f pd=0.8u as=0 ps=0 w=0.42u l=1u
X215 dsm2_osc_0.sg13cmos5l_buf_2_0.A a_20770_598# vss.t158 vss.t259 sg13_lv_nmos ad=0.4033p pd=2.57u as=0.148p ps=1.14u w=0.74u l=0.13u
X216 sg13cmos5l_and2_1_2.X a_10989_15998# vss.t799 vss.t798 sg13_lv_nmos ad=0.2516p pd=2.16u as=0.1331p ps=1.12u w=0.74u l=0.13u
X217 vdd.t416 vss.t2200 vdd.t393 vdd.t187 sg13_lv_pmos ad=0.19p pd=1.38u as=0 ps=0 w=1u l=1u
X218 a_1284_13167# a_1286_12023# a_1324_11172# vdd.t504 sg13_lv_pmos ad=0.2048p pd=1.63u as=0.34p ps=2.68u w=1u l=0.13u
X219 a_537_6405# d_qclk.t10 vdd.t511 vdd.t504 sg13_lv_pmos ad=0.4088p pd=2.97u as=1.1847p ps=7.385u w=1.12u l=0.13u
X220 a_1324_5988# a_1288_5962# vss.t579 vss.t578 sg13_lv_nmos ad=0.2516p pd=2.16u as=0.1626p ps=1.415u w=0.74u l=0.13u
X221 clk_noverlap_0.sg13cmos5l_inv_1_0.A a_10784_6484# vss.t12 vss.t11 sg13_lv_nmos ad=0.2516p pd=2.16u as=0.1331p ps=1.12u w=0.74u l=0.13u
X222 vo_n.t15 sg13cmos5l_inv_1_3.Y.t2 xq_dith_v_bp.t11 vdd.t623 sg13_lv_pmos ad=0.665p pd=3.88u as=1.19p ps=7.68u w=3.5u l=0.13u
X223 vdd.t783 a_5176_31117# vdd.t784 vdd.t764 sg13_lv_pmos ad=0.465p pd=1.93u as=0 ps=0 w=1u l=2u
X224 a_21554_2052.t1 a_21554_2052.t0 vss.t518 vss.t534 sg13_lv_nmos ad=95f pd=0.88u as=95f ps=0.88u w=0.5u l=0.5u
X225 vdd.t70 vss.t2262 vdd.t69 vdd.t68 sg13_lv_pmos ad=0.19p pd=1.38u as=0 ps=0 w=1u l=1u
X226 vdd.t1190 sg13cmos5l_inv_1_14.A.t10 sg13cmos5l_inv_1_2.A.t7 vdd.t863 sg13_lv_pmos ad=0.285p pd=1.88u as=0.285p ps=1.88u w=1.5u l=0.5u
X227 sg13cmos5l_inv_1_19.Y.t1 d_dith_en.t35 vdd.t1061 vdd.t502 sg13_lv_pmos ad=0.3808p pd=2.92u as=0.3808p ps=2.92u w=1.12u l=0.13u
X228 vdd.t189 vss.t2203 vdd.t188 vdd.t187 sg13_lv_pmos ad=0.34p pd=2.68u as=0 ps=0 w=1u l=1u
X229 vss.t2121 dsm2_osc_0.sg13cmos5l_inv_1_3.A a_23674_2578# vdd.t514 sg13_lv_pmos ad=0.17p pd=1.68u as=0.17p ps=1.68u w=0.5u l=0.5u
X230 vdd.t1017 vdd.t1462 vdd.t1463 vdd.t1173 sg13_lv_pmos ad=95f pd=0.88u as=0 ps=0 w=0.5u l=5u
X231 vdd.t776 a_5176_31117# vdd.t777 vdd.t764 sg13_lv_pmos ad=0.465p pd=1.93u as=0 ps=0 w=1u l=2u
X232 vdd.t828 a_5176_31117# vdd.t826 vdd.t764 sg13_lv_pmos ad=0.465p pd=1.93u as=0 ps=0 w=1u l=2u
X233 a_2083_7428# a_2034_8520# a_2083_7366# vss.t610 sg13_lv_nmos ad=0.1428p pd=1.52u as=37.8f ps=0.6u w=0.42u l=0.13u
X234 vdd.t671 a_14829_7164# a_14548_7466# vdd.t308 sg13_lv_pmos ad=0.1523p pd=1.38u as=0.34p ps=2.68u w=1u l=0.5u
X235 vdd.t1317 vdd.t1315 vdd.t1316 vdd.t863 sg13_lv_pmos ad=0.51p pd=3.68u as=0 ps=0 w=1.5u l=0.5u
X236 a_7224_31505# a_5176_31117# vdd.t797 vdd.t764 sg13_lv_pmos ad=0.34p pd=2.68u as=0.19p ps=1.38u w=1u l=2u
X237 vdd.t344 vss.t2265 vdd.t343 vdd.t68 sg13_lv_pmos ad=0.34p pd=2.68u as=0 ps=0 w=1u l=1u
X238 vss.t1527 vdd.t1818 vss.t1529 vss.t1528 sg13_lv_nmos ad=79.8f pd=0.8u as=0 ps=0 w=0.42u l=1u
X239 vss.t1563 vdd.t1811 vss.t1561 vss.t1562 sg13_lv_nmos ad=79.8f pd=0.8u as=0 ps=0 w=0.42u l=1u
X240 a_24404_4674# bias_gm_0.bias_trim_0.vz.t25 vdd.t938 vdd.t572 sg13_lv_pmos ad=95f pd=0.88u as=95f ps=0.88u w=0.5u l=5u
X241 a_2034_3670# a_2049_2373# a_2034_3336# vdd.t507 sg13_lv_pmos ad=0.2048p pd=1.63u as=0.34p ps=2.68u w=1u l=0.13u
X242 quantizer2_lfsr_0.sg13cmos5l_dfrbpq_1_11.D.t1 quantizer2_lfsr_0.sg13cmos5l_dfrbpq_1_1.Q a_856_16467# vdd.t504 sg13_lv_pmos ad=0.2408p pd=1.55u as=0.1428p ps=1.375u w=1.12u l=0.13u
X243 a_20672_21580# a_24258_21440# vss.t207 rhigh l=17.5u w=0.5u
X244 a_2368_15027# quantizer2_lfsr_0.sg13cmos5l_dfrbpq_1_5.Q vdd.t1055 vdd.t507 sg13_lv_pmos ad=0.1428p pd=1.375u as=0.2891p ps=1.695u w=1.12u l=0.13u
X245 vdd.t199 vss.t2230 vdd.t244 vdd.t176 sg13_lv_pmos ad=0.19p pd=1.38u as=0 ps=0 w=1u l=1u
X246 vdd.t356 vss.t2165 vdd.t312 vdd.t308 sg13_lv_pmos ad=0.19p pd=1.38u as=0 ps=0 w=1u l=1u
X247 vss.t1332 a_522_10294# a_522_10677# vss.t1333 sg13_lv_nmos ad=0.1406p pd=1.12u as=0.2516p ps=2.16u w=0.74u l=0.13u
X248 vdd.t973 sg13cmos5l_and2_2_1.X.t4 a_9533_11104.t4 vdd.t863 sg13_lv_pmos ad=0.285p pd=1.88u as=0.285p ps=1.88u w=1.5u l=0.5u
X249 sw_tgate_cmfb2_1.p.t1 sw_tgate_cmfb2_1.p.t0 vss.t60 vss.t59 sg13_lv_nmos ad=95f pd=0.88u as=95f ps=0.88u w=0.5u l=3u
X250 a_23942_594# dsm2_osc_0.sg13cmos5l_dfrbp_1_0.RESET_B.t2 vss.t241 vss.t240 sg13_lv_nmos ad=60.89999f pd=0.71u as=0.1626p ps=1.415u w=0.42u l=0.13u
X251 clk_noverlap_0.sg13cmos5l_dlygate4sd3_1_0.X a_4649_7224# vdd.t506 vdd.t308 sg13_lv_pmos ad=0.4256p pd=3u as=0.2254p ps=1.53u w=1.12u l=0.13u
X252 vdd.t969 sg13cmos5l_and2_2_1.X.t4 sg13cmos5l_inv_1_2.A.t3 vdd.t863 sg13_lv_pmos ad=0.285p pd=1.88u as=0.285p ps=1.88u w=1.5u l=0.5u
X253 vss.t857 vss.t858 vss.t531 rhigh l=2.75u w=0.5u
X254 quantizer2_lfsr_0.sg13cmos5l_dfrbpq_1_2.D.t1 a_1284_16630# a_1690_16373# vss.t457 sg13_lv_nmos ad=0.2516p pd=2.16u as=0.1406p ps=1.12u w=0.74u l=0.13u
X255 vss.t771 a_5176_30111# vss.t770 vss.t749 sg13_lv_nmos ad=0.17p pd=1.68u as=0 ps=0 w=0.5u l=3u
X256 bias_gm_0.bias_trim_0.vz.t18 a_22252_11246# vss.t353 vss.t265 sg13_hv_nmos ad=95f pd=0.88u as=95f ps=0.88u w=0.5u l=10u
X257 a_20947_892# dsm2_osc_0.sg13cmos5l_mux2_1_0.A1 a_20770_598# vdd.t515 sg13_lv_pmos ad=0.2975p pd=1.595u as=0.2225p ps=1.445u w=1u l=0.13u
X258 a_537_11589# d_qclk.t16 vss.t143 vss.t1401 sg13_lv_nmos ad=0.2516p pd=2.16u as=3.67165p ps=23.42u w=0.74u l=0.13u
X259 vss.t769 a_5176_30111# vss.t768 vss.t61 sg13_lv_nmos ad=0.17p pd=1.68u as=0 ps=0 w=0.5u l=3u
X260 a_1758_2482# d_dith_en.t5 vss.t18 vss.t17 sg13_lv_nmos ad=37.8f pd=0.6u as=79.8f ps=0.8u w=0.42u l=0.13u
X261 vss.t504 a_21276_2052# vss.t444 vss.t503 sg13_lv_nmos ad=95f pd=0.88u as=0 ps=0 w=0.5u l=0.5u
X262 vdd.t29 d_ena.t11 vdd.t1292 vdd.t25 sg13_hv_pmos ad=0.19p pd=1.38u as=0 ps=0 w=1u l=10u
X263 vdd.t358 vss.t2157 vdd.t328 vdd.t308 sg13_lv_pmos ad=0.19p pd=1.38u as=0 ps=0 w=1u l=1u
X264 a_20260_17236# a_19984_17824# a_19984_17824# vss.t267 sg13_lv_nmos ad=95f pd=0.88u as=95f ps=0.88u w=0.5u l=10u
X265 vss.t38 sg13cmos5l_nor2_2_0.Y d_qi_b.t0 vss.t37 sg13_lv_nmos ad=0.2516p pd=2.16u as=0.1406p ps=1.12u w=0.74u l=0.13u
X266 a_2070_9446# quantizer2_lfsr_0.sg13cmos5l_dfrbpq_1_4.Q vdd.t649 vdd.t507 sg13_lv_pmos ad=79.8f pd=0.8u as=0.1428p ps=1.52u w=0.42u l=0.13u
X267 vdd.t1178 bias_gm_0.bias_trim_0.vz.t33 a_24404_4674# vdd.t573 sg13_lv_pmos ad=95f pd=0.88u as=95f ps=0.88u w=0.5u l=5u
X268 vss.t138 a_15693_7164# a_15412_7466# vss.t137 sg13_lv_nmos ad=79.8f pd=0.8u as=0.1428p ps=1.52u w=0.42u l=0.5u
X269 sg13cmos5l_inv_2_0.Y sg13cmos5l_inv_1_2.Y vdd.t1215 vdd.t502 sg13_lv_pmos ad=0.2128p pd=1.5u as=0.3864p ps=2.93u w=1.12u l=0.13u
X270 vss.t1415 a_1286_1655# a_1322_1586# vss.t1414 sg13_lv_nmos ad=2.71757p pd=16.785u as=0.2516p ps=2.16u w=0.74u l=0.13u
X271 vdd.t140 vss.t2245 vdd.t409 vdd.t138 sg13_lv_pmos ad=0.34p pd=2.68u as=0 ps=0 w=1u l=1u
X272 vss.t516 a_22644_2344# vss.t687 vss.t686 sg13_lv_nmos ad=0.17p pd=1.68u as=0 ps=0 w=0.5u l=0.5u
X273 vss.t1662 vdd.t1787 vss.t1661 vss.t1660 sg13_lv_nmos ad=0.1428p pd=1.52u as=0 ps=0 w=0.42u l=1u
X274 vss.t850 ibias_200n.t7 vss.t849 vss.t269 sg13_hv_nmos ad=95f pd=0.88u as=0 ps=0 w=0.5u l=10u
X275 a_2070_12038# quantizer2_lfsr_0.sg13cmos5l_dfrbpq_1_5.Q vdd.t1209 vdd.t507 sg13_lv_pmos ad=79.8f pd=0.8u as=0.1428p ps=1.52u w=0.42u l=0.13u
X276 vdd.t5 vss.t2370 vdd.t4 vdd.t3 sg13_lv_pmos ad=0.34p pd=2.68u as=0 ps=0 w=1u l=1u
X277 a_856_16467# quantizer2_lfsr_0.sg13cmos5l_dfrbpq_1_1.D.t3 vdd.t1003 vdd.t504 sg13_lv_pmos ad=0.1428p pd=1.375u as=0.2891p ps=1.695u w=1.12u l=0.13u
X278 vss.t2006 vdd.t1706 vss.t2004 vss.t2005 sg13_lv_nmos ad=79.8f pd=0.8u as=0 ps=0 w=0.42u l=1u
X279 sg13cmos5l_inv_1_14.A.t0 vss.t384 vss.t396 vss.t401 sg13_lv_nmos ad=95f pd=0.88u as=95f ps=0.88u w=0.5u l=0.5u
X280 vss.t1692 vdd.t1779 vss.t1691 vss.t1686 sg13_lv_nmos ad=0.1428p pd=1.52u as=0 ps=0 w=0.42u l=1u
X281 vdd.t1231 a_5176_31469# vdd.t1229 vdd.t764 sg13_lv_pmos ad=0.665p pd=3.88u as=0 ps=0 w=3.5u l=2u
X282 vss.t1730 vdd.t1770 vss.t1727 vss.t1729 sg13_lv_nmos ad=79.8f pd=0.8u as=0 ps=0 w=0.42u l=1u
X283 vdd.t809 a_5176_31117# a_7224_31505# vdd.t764 sg13_lv_pmos ad=0.19p pd=1.38u as=0.34p ps=2.68u w=1u l=2u
X284 vdd.t507 a_2034_3670# a_2034_3506# vdd.t507 sg13_lv_pmos ad=1.99007p pd=12.8u as=79.8f ps=0.8u w=0.42u l=0.13u
X285 a_22094_594# a_21617_558# a_22000_594# vss.t164 sg13_lv_nmos ad=37.8f pd=0.6u as=0.1428p ps=1.52u w=0.42u l=0.13u
X286 vdd.t1534 vdd.t1532 vdd.t1239 vdd.t1287 sg13_lv_pmos ad=0.17p pd=1.68u as=0 ps=0 w=0.5u l=5u
X287 dsm2_osc_0.ibias_pad.t3 vdd.t553 dpantenna l=0.64u w=4.98u
X288 vss.t99 sw_tgate_cmfb2_1.p.t10 vss.t98 vss.t61 sg13_lv_nmos ad=0.17p pd=1.68u as=0 ps=0 w=0.5u l=3u
X289 a_1288_5962# a_1286_6839# a_1367_6345# vdd.t504 sg13_lv_pmos ad=79.8f pd=0.8u as=63f ps=0.72u w=0.42u l=0.13u
X290 a_1407_4946# a_1284_5391# a_1758_5074# vss.t549 sg13_lv_nmos ad=0.1428p pd=1.52u as=37.8f ps=0.6u w=0.42u l=0.13u
X291 vss.t128 a_2034_8854# a_2034_9237# vss.t713 sg13_lv_nmos ad=0.1406p pd=1.12u as=0.2516p ps=2.16u w=0.74u l=0.13u
X292 vss.t1579 vdd.t1807 vss.t1577 vss.t1578 sg13_lv_nmos ad=79.8f pd=0.8u as=0 ps=0 w=0.42u l=1u
X293 a_8762_31505# a_5176_31117# vdd.t802 vdd.t764 sg13_lv_pmos ad=0.19p pd=1.38u as=0.34p ps=2.68u w=1u l=2u
X294 a_24540_21720# a_28126_21860# vss.t34 rhigh l=17.5u w=0.5u
X295 a_22836_1332# dsm2_osc_0.sg13cmos5l_dfrbp_1_0.RESET_B.t6 vss.t249 vss.t248 sg13_lv_nmos ad=0.1045p pd=0.93u as=0.187p ps=1.78u w=0.55u l=0.13u
X296 vdd.t928 bias_gm_0.bias_trim_0.vz.t50 a_22252_11246# vdd.t573 sg13_lv_pmos ad=95f pd=0.88u as=95f ps=0.88u w=0.5u l=5u
X297 a_22252_11246# bias_gm_0.bias_trim_0.vz.t53 vdd.t931 vdd.t566 sg13_lv_pmos ad=95f pd=0.88u as=95f ps=0.88u w=0.5u l=5u
X298 a_2079_7122# a_2049_7557# a_2461_7497# vdd.t507 sg13_lv_pmos ad=79.8f pd=0.8u as=63f ps=0.72u w=0.42u l=0.13u
X299 vss.t78 sw_tgate_cmfb2_1.p.t8 vss.t112 vss.t110 sg13_lv_nmos ad=95f pd=0.88u as=0 ps=0 w=0.5u l=3u
X300 vo_p.t17 sg13cmos5l_inv_1_3.A.t3 xq_dith_v_bq.t10 vss.t1233 sg13_lv_nmos ad=0.665p pd=3.88u as=0.665p ps=3.88u w=3.5u l=0.13u
X301 vss.t1472 vdd.t1829 vss.t1471 vss.t1470 sg13_lv_nmos ad=0.1428p pd=1.52u as=0 ps=0 w=0.42u l=1u
X302 vss.t1949 vdd.t1718 vss.t1951 vss.t1950 sg13_lv_nmos ad=79.8f pd=0.8u as=0 ps=0 w=0.42u l=1u
X303 vdd.t775 a_5176_31117# vdd.t776 vdd.t764 sg13_lv_pmos ad=0.19p pd=1.38u as=0 ps=0 w=1u l=2u
X304 xsc_xcmfb1_vsw_vbias.t13 vdd.t1306 xsc_xcmfb1_vsw_vbias.t1 vdd.t558 sg13_lv_pmos ad=0.285p pd=1.88u as=0 ps=0 w=1.5u l=1u
X305 vdd.t1427 vdd.t1423 vdd.t1429 vdd.t384 sg13_lv_pmos ad=95f pd=0.88u as=0 ps=0 w=0.5u l=5u
X306 xsc_vc1r_p.t0 sw_tgate_9.gb.t6 xsc_vc1r_p.t3 vss.t974 sg13_lv_nmos ad=0.19p pd=1.38u as=0 ps=0 w=1u l=1u
X307 vss.t701 dsm2_io_0.sg13cmos5l_inv_1_4.A quantizer2_lfsr_0.di_dith_amp[0].t0 vss.t467 sg13_lv_nmos ad=0.2516p pd=2.16u as=0.2516p ps=2.16u w=0.74u l=0.13u
X308 a_2461_10089# a_2034_11112# vdd.t1086 vdd.t507 sg13_lv_pmos ad=63f pd=0.72u as=0.1563p ps=1.22u w=0.42u l=0.13u
X309 vss.t924 di_btest_en dsm2_io_0.sg13cmos5l_inv_1_5.A vss.t923 sg13_hv_nmos ad=0.34p pd=2.68u as=0.34p ps=2.68u w=1u l=0.45u
X310 a_558_13478# quantizer2_lfsr_0.sg13cmos5l_dfrbpq_1_1.D.t2 vdd.t995 vdd.t504 sg13_lv_pmos ad=79.8f pd=0.8u as=0.1428p ps=1.52u w=0.42u l=0.13u
X311 vo_p.t10 sg13cmos5l_inv_1_3.Y.t3 xq_dith_v_bq.t4 vdd.t624 sg13_lv_pmos ad=0.665p pd=3.88u as=0.665p ps=3.88u w=3.5u l=0.13u
X312 a_11293_11104.t7 xq_vg_p_1_.t3 a_9357_11104.t16 vss.t405 sg13_lv_nmos ad=0.285p pd=1.88u as=0.285p ps=1.88u w=1.5u l=0.5u
X313 a_1600_11717# a_1324_11172# a_1745_11398# vss.t673 sg13_lv_nmos ad=0.1428p pd=1.52u as=37.8f ps=0.6u w=0.42u l=0.13u
X314 vdd.t600 a_22368_558# a_23391_985# vdd.t515 sg13_lv_pmos ad=0.1563p pd=1.22u as=63f ps=0.72u w=0.42u l=0.13u
X315 a_6249_9100.t14 d_amp_s_b[1].t2 a_11173_9488.t2 vdd.t659 sg13_lv_pmos ad=95f pd=0.88u as=0.17p ps=1.68u w=0.5u l=0.13u
X316 sg13cmos5l_inv_1_17.Y.t0 sg13cmos5l_inv_1_17.A.t4 vss.t1 vss.t0 sg13_lv_nmos ad=0.2516p pd=2.16u as=0.2516p ps=2.16u w=0.74u l=0.13u
X317 a_522_7538# a_522_7702# a_558_7666# vss.t880 sg13_lv_nmos ad=0.1428p pd=1.52u as=37.8f ps=0.6u w=0.42u l=0.13u
X318 vdd.t1038 d_qi.t8 sw_tgate_12.m.t7 vss.t1011 sg13_lv_nmos ad=0.34p pd=2.68u as=0.19p ps=1.38u w=1u l=1u
X319 vdd.t210 vss.t2347 vdd.t225 vdd.t88 sg13_lv_pmos ad=0.19p pd=1.38u as=0 ps=0 w=1u l=1u
X320 vdd.t967 sg13cmos5l_and2_2_1.X.t3 sg13cmos5l_inv_1_14.A.t4 vdd.t863 sg13_lv_pmos ad=0.285p pd=1.88u as=0.285p ps=1.88u w=1.5u l=0.5u
X321 vdd.t425 vss.t2163 vdd.t383 vdd.t308 sg13_lv_pmos ad=0.19p pd=1.38u as=0 ps=0 w=1u l=1u
X322 vss.t773 a_5176_30111# vss.t774 vss.t755 sg13_lv_nmos ad=95f pd=0.88u as=0 ps=0 w=0.5u l=3u
X323 vss.t325 vss.t323 vss.t324 vss.t262 sg13_hv_nmos ad=0.34p pd=2.68u as=0 ps=0 w=1u l=10u
X324 vdd.t511 a_1286_14615# a_1322_14546# vdd.t504 sg13_lv_pmos ad=1.21587p pd=7.58u as=0.3864p ps=2.93u w=1.12u l=0.13u
X325 vss.t496 a_12237_7164# a_11956_7466# vss.t2108 sg13_lv_nmos ad=79.8f pd=0.8u as=0.1428p ps=1.52u w=0.42u l=0.5u
X326 vdd.t212 vss.t2333 vdd.t211 vdd.t65 sg13_lv_pmos ad=0.19p pd=1.38u as=0 ps=0 w=1u l=1u
X327 xsc_vc1r_p.t1 sw_tgate_9.gb.t6 xsc_vvg_n.t1 vdd.t556 sg13_lv_pmos ad=0.38p pd=2.38u as=0.38p ps=2.38u w=2u l=1u
X328 vdd.t1405 vdd.t1403 vdd.t726 vdd.t1287 sg13_lv_pmos ad=0.17p pd=1.68u as=0 ps=0 w=0.5u l=5u
X329 vss.t1991 vdd.t1709 vss.t1989 vss.t1990 sg13_lv_nmos ad=79.8f pd=0.8u as=0 ps=0 w=0.42u l=1u
X330 vdd.t936 bias_gm_0.bias_trim_0.vz.t53 a_22252_11246# vdd.t570 sg13_lv_pmos ad=95f pd=0.88u as=95f ps=0.88u w=0.5u l=5u
X331 a_14433_7467# a_14548_7466# vss.t680 vss.t679 sg13_lv_nmos ad=0.1428p pd=1.52u as=0.1426p ps=1.16u w=0.42u l=0.5u
X332 vss.t169 vss.t435 vss.t437 vss.t436 sg13_hv_nmos ad=3.4p pd=20.68u as=0 ps=0 w=10u l=0.45u
X333 a_8661_8468# a_10757_8328# vss.t449 rhigh l=10.05u w=0.5u
X334 vdd.t1437 vdd.t1423 vdd.t1439 vdd.t1173 sg13_lv_pmos ad=95f pd=0.88u as=0 ps=0 w=0.5u l=5u
X335 a_22252_4074# bias_gm_0.bias_trim_0.vz.t32 vdd.t1188 vdd.t566 sg13_lv_pmos ad=95f pd=0.88u as=95f ps=0.88u w=0.5u l=5u
X336 vdd.t237 vss.t2337 vdd.t230 vdd.t65 sg13_lv_pmos ad=0.19p pd=1.38u as=0 ps=0 w=1u l=1u
X337 vdd.t630 a_10483_7459# d_qclk.t0 vdd.t308 sg13_lv_pmos ad=0.1918p pd=1.5u as=0.3808p ps=2.92u w=1.12u l=0.13u
X338 vdd.t1506 vdd.t1498 vdd.t1508 vdd.t573 sg13_lv_pmos ad=95f pd=0.88u as=0 ps=0 w=0.5u l=5u
X339 a_2070_9446# a_2045_11072# a_2079_9714# vdd.t507 sg13_lv_pmos ad=0.1428p pd=1.52u as=79.8f ps=0.8u w=0.42u l=0.13u
X340 a_24258_22964# a_20328_23820# vss.t49 rhigh l=10.975u w=0.5u
X341 a_1758_15442# d_dith_en.t36 vss.t1082 vss.t792 sg13_lv_nmos ad=37.8f pd=0.6u as=79.8f ps=0.8u w=0.42u l=0.13u
X342 d_phi2.t0 clk_noverlap_0.do_phi2_b vss.t474 vss.t473 sg13_lv_nmos ad=0.2516p pd=2.16u as=0.2516p ps=2.16u w=0.74u l=0.13u
X343 vdd.t148 vss.t2232 vdd.t150 vdd.t147 sg13_hv_pmos ad=0.285p pd=1.88u as=0 ps=0 w=1.5u l=0.45u
X344 vdd.t711 sg13cmos5l_nand2_1_5.A.t7 sg13cmos5l_inv_1_6.A.t0 vdd.t502 sg13_lv_pmos ad=0.3808p pd=2.92u as=0.2128p ps=1.5u w=1.12u l=0.13u
X345 vdd.t1684 vss.t2362 vdd.t1682 vdd.t764 sg13_hv_pmos ad=0.2375p pd=1.63u as=0 ps=0 w=1.25u l=4u
X346 vdd.t818 a_5176_31117# vdd.t816 vdd.t764 sg13_lv_pmos ad=0.19p pd=1.38u as=0 ps=0 w=1u l=2u
X347 vss.t781 a_5176_30111# vss.t783 vss.t751 sg13_lv_nmos ad=95f pd=0.88u as=0 ps=0 w=0.5u l=3u
X348 vss.t1005 d_qi.t9 sw_tgate_10.p.t7 vdd.t561 sg13_lv_pmos ad=0.38p pd=2.38u as=0.38p ps=2.38u w=2u l=1u
X349 a_16161_7467# a_16276_7466# vdd.t672 vdd.t308 sg13_lv_pmos ad=0.34p pd=2.68u as=0.2254p ps=1.53u w=1u l=0.5u
X350 vdd.t94 vss.t2340 vdd.t231 vdd.t65 sg13_lv_pmos ad=0.34p pd=2.68u as=0 ps=0 w=1u l=1u
X351 vcm_esd.t12 sw_tgate_cmfb2_1.gb.t3 xsc_xcmfb1_vsw_cm_n.t3 vdd.t560 sg13_lv_pmos ad=0.285p pd=1.88u as=0.285p ps=1.88u w=1.5u l=1u
X352 a_567_13746# a_537_14181# a_949_14121# vdd.t504 sg13_lv_pmos ad=79.8f pd=0.8u as=63f ps=0.72u w=0.42u l=0.13u
X353 vdd.t511 a_1407_4946# a_1443_4857# vdd.t504 sg13_lv_pmos ad=1.21587p pd=7.58u as=93.45f ps=0.865u w=0.42u l=0.13u
X354 sw_tgate_12.m.t1 d_phi2.t6 sw_tgate_12.m.t0 vdd.t561 sg13_lv_pmos ad=0.38p pd=2.38u as=0 ps=0 w=2u l=1u
X355 vss.t704 a_1284_10575# a_1284_10677# vss.t994 sg13_lv_nmos ad=0.1406p pd=1.12u as=0.2516p ps=2.16u w=0.74u l=0.13u
X356 a_522_12722# a_522_12886# a_558_12850# vss.t1289 sg13_lv_nmos ad=0.1428p pd=1.52u as=37.8f ps=0.6u w=0.42u l=0.13u
X357 vdd.t186 vss.t2295 vdd.t185 vdd.t184 sg13_lv_pmos ad=0.34p pd=2.68u as=0 ps=0 w=1u l=1u
X358 inv_en_0.di d_ena.t9 vdd.t1286 vdd.t753 sg13_hv_pmos ad=0.285p pd=1.88u as=0.51p ps=3.68u w=1.5u l=0.45u
X359 a_1600_1349# a_1324_804# a_1745_1030# vss.t500 sg13_lv_nmos ad=0.1428p pd=1.52u as=37.8f ps=0.6u w=0.42u l=0.13u
X360 a_19984_17824# bias_gm_0.bias_trim_0.vz.t51 vdd.t729 vdd.t287 sg13_lv_pmos ad=95f pd=0.88u as=95f ps=0.88u w=0.5u l=5u
X361 vdd.t1362 vdd.t1360 vdd.t1364 vdd.t384 sg13_lv_pmos ad=95f pd=0.88u as=0 ps=0 w=0.5u l=5u
X362 a_4362_8188.t10 sg13cmos5l_or2_1_0.X.t3 xq_dith_v_bq.t8 vss.t919 sg13_lv_nmos ad=0.665p pd=3.88u as=0.665p ps=3.88u w=3.5u l=0.13u
X363 vdd.t510 a_522_5110# a_522_5493# vdd.t504 sg13_lv_pmos ad=0.2128p pd=1.5u as=0.3864p ps=2.93u w=1.12u l=0.13u
X364 a_2070_6226# d_dith_en.t13 vss.t682 vss.t1118 sg13_lv_nmos ad=37.8f pd=0.6u as=79.8f ps=0.8u w=0.42u l=0.13u
X365 vdd.t84 vss.t2182 vdd.t83 vdd.t82 sg13_lv_pmos ad=0.19p pd=1.38u as=0 ps=0 w=1u l=1u
X366 a_24404_8546# dsm2_io_0.do_trim_b[1].t3 ibias_200n.t3 vdd.t572 sg13_lv_pmos ad=95f pd=0.88u as=95f ps=0.88u w=0.5u l=5u
X367 vdd.t279 vss.t2400 vdd.t267 vdd.t0 sg13_lv_pmos ad=0.19p pd=1.38u as=0 ps=0 w=1u l=1u
X368 a_22252_5274# bias_gm_0.bias_trim_0.vz.t33 vdd.t1178 vdd.t287 sg13_lv_pmos ad=95f pd=0.88u as=95f ps=0.88u w=0.5u l=5u
X369 a_12075_9628.t3 a_4362_8188.t7 vss.t609 rhigh l=4.08u w=0.5u
X370 vcm_esd.t1 d_phi2.t13 vcm_esd.t0 vdd.t558 sg13_lv_pmos ad=0.285p pd=1.88u as=0 ps=0 w=1.5u l=1u
X371 a_1600_1349# a_1322_1586# a_1288_778# vss.t148 sg13_lv_nmos ad=0.2373p pd=1.97u as=79.8f ps=0.8u w=0.42u l=0.13u
X372 do_q.t0 sg13cmos5l_inv_1_5.Y vdd.t1260 vdd.t502 sg13_lv_pmos ad=0.2128p pd=1.5u as=0.3808p ps=2.92u w=1.12u l=0.13u
X373 sg13cmos5l_nor2_2_2.A sg13cmos5l_inv_2_5.Y a_11865_14889# vss.t991 sg13_lv_nmos ad=0.1368p pd=1.1u as=0.1404p ps=1.11u w=0.72u l=0.13u
X374 vss.t961 d_ena.t14 vss.t1429 vss.t1430 sg13_hv_nmos ad=0.19p pd=1.38u as=0 ps=0 w=1u l=5u
X375 vdd.t801 a_5176_31117# a_9348_31505# vdd.t764 sg13_lv_pmos ad=0.34p pd=2.68u as=0.19p ps=1.38u w=1u l=2u
X376 vss.t1848 vdd.t1742 vss.t1850 vss.t1849 sg13_lv_nmos ad=79.8f pd=0.8u as=0 ps=0 w=0.42u l=1u
X377 vdd.t608 dsm2_io_0.do_btest_en.t2 a_22930_1332# vdd.t515 sg13_lv_pmos ad=0.2226p pd=1.535u as=0.1596p ps=1.22u w=0.84u l=0.13u
X378 a_558_10980# quantizer2_lfsr_0.sg13cmos5l_dfrbpq_1_7.D a_558_10886# vss.t1228 sg13_lv_nmos ad=60.89999f pd=0.71u as=0.1428p ps=1.52u w=0.42u l=0.13u
X379 a_1324_13764# a_1322_14546# a_1284_15759# vss.t804 sg13_lv_nmos ad=0.3473p pd=2.71u as=0.12665p ps=1.145u w=0.74u l=0.13u
X380 a_21554_2052.t3 dsm2_osc_0.dsm2_io_rx_0.di_b.t2 vss.t245 vss.t244 sg13_lv_nmos ad=0.17p pd=1.68u as=0.17p ps=1.68u w=0.5u l=0.5u
X381 vdd.t518 di_ena dsm2_io_0.dsm2_io_rx_9.di_b.t1 vdd.t25 sg13_hv_pmos ad=0.17p pd=1.68u as=0.17p ps=1.68u w=0.5u l=1u
X382 a_5401_7200# a_5131_7241# vss.t616 vss.t615 sg13_lv_nmos ad=0.1428p pd=1.52u as=79.8f ps=0.8u w=0.42u l=0.5u
X383 a_949_11529# a_522_12552# vdd.t1068 vdd.t504 sg13_lv_pmos ad=63f pd=0.72u as=0.1563p ps=1.22u w=0.42u l=0.13u
X384 vss.t1673 vdd.t1784 vss.t1672 vss.t1671 sg13_lv_nmos ad=0.1428p pd=1.52u as=0 ps=0 w=0.42u l=1u
X385 a_9533_11104.t1 vo_p.t24 a_9357_11104.t0 vss.t30 sg13_lv_nmos ad=0.76p pd=4.38u as=0.76p ps=4.38u w=4u l=0.5u
X386 vdd.t948 vss.t2394 vdd.t947 vdd.t0 sg13_lv_pmos ad=0.19p pd=1.38u as=0 ps=0 w=1u l=1u
X387 vss.t1741 vdd.t1767 vss.t1740 vss.t1731 sg13_lv_nmos ad=0.1428p pd=1.52u as=0 ps=0 w=0.42u l=1u
X388 sg13cmos5l_inv_1_13.A.t0 sg13cmos5l_nand2_1_5.A.t5 vdd.t985 vdd.t502 sg13_lv_pmos ad=0.2128p pd=1.5u as=0.3808p ps=2.92u w=1.12u l=0.13u
X389 a_522_4946# d_dith_en.t12 vdd.t511 vdd.t504 sg13_lv_pmos ad=79.8f pd=0.8u as=1.1847p ps=7.385u w=0.42u l=0.13u
X390 a_28746_15446# a_19964_18216# a_26670_15446# vdd.t1128 sg13_lv_pmos ad=0.17p pd=1.68u as=95f ps=0.88u w=0.5u l=10u
X391 a_14734_15077# a_14849_15078# vdd.t707 vdd.t502 sg13_lv_pmos ad=0.34p pd=2.68u as=0.2254p ps=1.53u w=1u l=0.5u
X392 vss.t3 d_dith_en.t21 a_558_8388# vss.t1104 sg13_lv_nmos ad=0.1626p pd=1.415u as=60.89999f ps=0.71u w=0.42u l=0.13u
X393 sw_tgate_12.m.t4 d_qi_b.t8 vdd.t1047 vdd.t561 sg13_lv_pmos ad=0.38p pd=2.38u as=0.68p ps=4.68u w=2u l=1u
X394 sg13cmos5l_inv_1_2.A.t0 vss.t366 vss.t378 vss.t382 sg13_lv_nmos ad=95f pd=0.88u as=95f ps=0.88u w=0.5u l=0.5u
X395 a_6638_31505# a_5176_31469# a_5176_31117# vdd.t764 sg13_lv_pmos ad=1.19p pd=7.68u as=1.19p ps=7.68u w=3.5u l=2u
X396 clk_noverlap_0.sg13cmos5l_dlygate4sd3_1_4.X a_8969_7224# vss.t887 vss.t886 sg13_lv_nmos ad=0.2516p pd=2.16u as=0.1426p ps=1.16u w=0.74u l=0.13u
X397 a_571_8806# d_dith_en.t21 vss.t1103 vss.t1102 sg13_lv_nmos ad=37.8f pd=0.6u as=0.1701p ps=1.65u w=0.42u l=0.13u
X398 clk_noverlap_0.sg13cmos5l_nor3_1_0.C a_9833_7224# vdd.t893 vdd.t308 sg13_lv_pmos ad=0.4256p pd=3u as=0.2254p ps=1.53u w=1.12u l=0.13u
X399 a_21252_3394# dsm2_osc_0.d_btest_or.t2 vdd.t1174 vdd.t1173 sg13_lv_pmos ad=0.17p pd=1.68u as=95f ps=0.88u w=0.5u l=5u
X400 a_26670_14846# a_19964_18216# a_24602_14546# vdd.t1127 sg13_lv_pmos ad=95f pd=0.88u as=0.17p ps=1.68u w=0.5u l=10u
X401 do_osc_oe.t1 dsm2_osc_0.dsm2_io_rx_1.di_b vss.t506 vss.t505 sg13_lv_nmos ad=0.2516p pd=2.16u as=0.2516p ps=2.16u w=0.74u l=0.13u
X402 bias_gm_0.bias_trim_0.iout vdd.t1607 bias_gm_0.bias_trim_0.iout vdd.t1287 sg13_lv_pmos ad=0.17p pd=1.68u as=3.045p ps=31.93u w=0.5u l=5u
X403 a_17421_7164# d_phi2.t3 vss.t205 vss.t204 sg13_lv_nmos ad=0.1428p pd=1.52u as=79.8f ps=0.8u w=0.42u l=0.13u
X404 a_567_786# a_537_1221# a_558_518# vss.t489 sg13_lv_nmos ad=79.8f pd=0.8u as=0.1296p ps=1.52u w=0.42u l=0.13u
X405 vss.t1594 vdd.t1803 vss.t1593 vss.t1583 sg13_lv_nmos ad=0.1428p pd=1.52u as=0 ps=0 w=0.42u l=1u
X406 vss.t1280 vss.t1281 vss.t39 rhigh l=2.75u w=0.5u
X407 vss.t1859 vdd.t1739 vss.t1860 vss.t1849 sg13_lv_nmos ad=79.8f pd=0.8u as=0 ps=0 w=0.42u l=1u
X408 vss.t8 a_4537_7200# a_4649_7224# vss.t7 sg13_lv_nmos ad=0.1426p pd=1.16u as=0.1428p ps=1.52u w=0.42u l=0.5u
X409 a_11115_8328# vss.t930 vss.t6 rhigh l=10.05u w=0.5u
X410 dsm2_osc_0.dsm2_io_rx_1.di_b di_clk_sel.t1 vdd.t1247 vdd.t1125 sg13_hv_pmos ad=0.17p pd=1.68u as=0.17p ps=1.68u w=0.5u l=1u
X411 a_22252_7946# bias_gm_0.bias_trim_0.vz.t48 vdd.t1010 vdd.t566 sg13_lv_pmos ad=95f pd=0.88u as=95f ps=0.88u w=0.5u l=5u
X412 vss.t1155 vss.t1156 vss.t531 rhigh l=2.75u w=0.5u
X413 dsm2_osc_0.sg13cmos5l_inv_1_2.A a_21681_1704# vdd.t545 vdd.t515 sg13_lv_pmos ad=0.3808p pd=2.92u as=0.1918p ps=1.5u w=1.12u l=0.13u
X414 a_9533_11104.t3 xq_vg_q_1_.t3 a_9357_11104.t9 vss.t31 sg13_lv_nmos ad=0.285p pd=1.88u as=0.285p ps=1.88u w=1.5u l=0.5u
X415 vdd.t1187 bias_gm_0.bias_trim_0.vz.t27 a_22252_5274# vdd.t570 sg13_lv_pmos ad=95f pd=0.88u as=95f ps=0.88u w=0.5u l=5u
X416 vss.t758 a_5176_30111# vss.t760 vss.t759 sg13_lv_nmos ad=95f pd=0.88u as=0 ps=0 w=0.5u l=3u
X417 quantizer2_lfsr_0.sg13cmos5l_dfrbpq_1_0.Q a_522_2901# vdd.t596 vdd.t504 sg13_lv_pmos ad=0.3808p pd=2.92u as=0.2128p ps=1.5u w=1.12u l=0.13u
X418 w_9407_29481.t10 a_5176_31469# a_7224_31505# vdd.t764 sg13_lv_pmos ad=0.665p pd=3.88u as=0.665p ps=3.88u w=3.5u l=2u
X419 vdd.t960 vdd.t1320 vdd.t1322 vdd.t863 sg13_lv_pmos ad=0.285p pd=1.88u as=0 ps=0 w=1.5u l=0.5u
X420 dsm2_osc_0.sg13cmos5l_buf_2_0.A a_20770_598# vdd.t548 vdd.t515 sg13_lv_pmos ad=0.6048p pd=3.32u as=0.2198p ps=1.52u w=1.12u l=0.13u
X421 vss.t1004 d_qi.t9 vss.t1003 vss.t1002 sg13_lv_nmos ad=0.34p pd=2.68u as=0 ps=0 w=1u l=1u
X422 vss.t557 dsm2_osc_0.sg13cmos5l_dfrbp_1_0.RESET_B.t3 a_22094_594# vss.t1180 sg13_lv_nmos ad=79.8f pd=0.8u as=37.8f ps=0.6u w=0.42u l=0.13u
X423 d_amp_s_b[2].t1 d_amp_s[2].t4 vss.t2066 vss.t664 sg13_lv_nmos ad=0.2516p pd=2.16u as=0.2516p ps=2.16u w=0.74u l=0.13u
X424 vdd.t418 vss.t2167 vdd.t417 vdd.t308 sg13_lv_pmos ad=0.19p pd=1.38u as=0 ps=0 w=1u l=1u
X425 vdd.t610 a_6265_7200# a_6377_7224# vdd.t308 sg13_lv_pmos ad=0.2254p pd=1.53u as=0.34p ps=2.68u w=1u l=0.5u
X426 a_2070_9540# quantizer2_lfsr_0.sg13cmos5l_dfrbpq_1_4.Q a_2070_9446# vss.t544 sg13_lv_nmos ad=60.89999f pd=0.71u as=0.1428p ps=1.52u w=0.42u l=0.13u
X427 xsc_vc1l_p.t4 d_phi2.t6 sw_tgate_12.m.t3 vss.t200 sg13_lv_nmos ad=0.19p pd=1.38u as=0.19p ps=1.38u w=1u l=1u
X428 d_dith[1].t0 a_2034_1082# vss.t526 vss.t525 sg13_lv_nmos ad=0.2886p pd=2.26u as=0.14875p ps=1.16u w=0.74u l=0.13u
X429 a_10483_7459# clk_noverlap_0.sg13cmos5l_inv_1_0.A a_10620_7548# vss.t132 sg13_lv_nmos ad=0.2176p pd=1.96u as=0.1216p ps=1.02u w=0.64u l=0.13u
X430 vdd.t172 vss.t2314 vdd.t171 vdd.t116 sg13_lv_pmos ad=0.19p pd=1.38u as=0 ps=0 w=1u l=1u
X431 a_522_7702# a_537_6405# a_522_7368# vdd.t504 sg13_lv_pmos ad=0.2048p pd=1.63u as=0.34p ps=2.68u w=1u l=0.13u
X432 xq_dith_v_bp.t0 sg13cmos5l_inv_1_9.Y.t2 a_4362_8188.t1 vdd.t623 sg13_lv_pmos ad=0.665p pd=3.88u as=0.665p ps=3.88u w=3.5u l=0.13u
X433 sg13cmos5l_inv_2_4.Y sg13cmos5l_inv_1_11.Y vss.t860 vss.t859 sg13_lv_nmos ad=0.1406p pd=1.12u as=0.2516p ps=2.16u w=0.74u l=0.13u
X434 bias_gm_0.bias_trim_0.iout vss.t2143 a_22252_4074# vdd.t384 sg13_lv_pmos ad=95f pd=0.88u as=95f ps=0.88u w=0.5u l=5u
X435 vss.t1392 sg13cmos5l_inv_1_5.Y do_q.t1 vss.t1391 sg13_lv_nmos ad=0.2516p pd=2.16u as=0.1406p ps=1.12u w=0.74u l=0.13u
X436 vdd.t1508 vdd.t1498 vdd.t1510 vdd.t287 sg13_lv_pmos ad=95f pd=0.88u as=0 ps=0 w=0.5u l=5u
X437 vdd.t170 vss.t2258 vdd.t97 vdd.t95 sg13_lv_pmos ad=0.19p pd=1.38u as=0 ps=0 w=1u l=1u
X438 a_6874_14892# sg13cmos5l_inv_1_15.Y vss.t793 vss.t0 sg13_lv_nmos ad=0.1406p pd=1.12u as=0.2516p ps=2.16u w=0.74u l=0.13u
X439 vdd.t950 bias_gm_0.bias_trim_0.vz.t47 a_22252_7946# vdd.t570 sg13_lv_pmos ad=95f pd=0.88u as=95f ps=0.88u w=0.5u l=5u
X440 bias_gm_0.bias_trim_0.vz.t10 bias_gm_0.bias_trim_0.vz.t9 vdd.t568 vdd.t572 sg13_lv_pmos ad=95f pd=0.88u as=95f ps=0.88u w=0.5u l=5u
X441 a_21452_2308.t3 a_22644_2344# a_23294_2344# vss.t685 sg13_lv_nmos ad=0.17p pd=1.68u as=95f ps=0.88u w=0.5u l=0.13u
X442 a_2034_8690# d_dith_en.t19 vdd.t507 vdd.t507 sg13_lv_pmos ad=79.8f pd=0.8u as=1.87952p ps=12.085u w=0.42u l=0.13u
X443 vss.t101 sw_tgate_cmfb2_1.p.t10 vss.t98 vss.t100 sg13_lv_nmos ad=95f pd=0.88u as=0 ps=0 w=0.5u l=3u
X444 vdd.t131 vss.t2346 vdd.t369 vdd.t88 sg13_lv_pmos ad=0.34p pd=2.68u as=0 ps=0 w=1u l=1u
X445 a_1286_9431# d_qclk.t12 vss.t1406 vss.t1405 sg13_lv_nmos ad=0.2516p pd=2.16u as=2.50852p ps=15.49u w=0.74u l=0.13u
X446 xsc_vc1l_n.t3 sw_tgate_9.gb.t2 xsc_vc1l_n.t2 vss.t2074 sg13_lv_nmos ad=0.19p pd=1.38u as=0 ps=0 w=1u l=1u
X447 vss.t2009 vdd.t1705 vss.t2008 vss.t2007 sg13_lv_nmos ad=0.1428p pd=1.52u as=0 ps=0 w=0.42u l=1u
X448 a_4362_8188.t0 sg13cmos5l_inv_1_9.Y.t2 xq_dith_v_bp.t2 vdd.t623 sg13_lv_pmos ad=0.665p pd=3.88u as=0.665p ps=3.88u w=3.5u l=0.13u
X449 a_2083_10020# a_2045_11072# a_2079_9714# vss.t797 sg13_lv_nmos ad=0.2373p pd=1.97u as=79.8f ps=0.8u w=0.42u l=0.13u
X450 a_2083_12612# a_2034_13704# a_2083_12550# vss.t949 sg13_lv_nmos ad=0.1428p pd=1.52u as=37.8f ps=0.6u w=0.42u l=0.13u
X451 vss.t1784 vdd.t1757 vss.t1786 vss.t1785 sg13_lv_nmos ad=79.8f pd=0.8u as=0 ps=0 w=0.42u l=1u
X452 a_558_5074# d_dith_en.t12 vss.t632 vss.t1119 sg13_lv_nmos ad=37.8f pd=0.6u as=79.8f ps=0.8u w=0.42u l=0.13u
X453 vss.t1585 vdd.t1805 vss.t1584 vss.t1583 sg13_lv_nmos ad=0.1428p pd=1.52u as=0 ps=0 w=0.42u l=1u
X454 vdd.t67 vss.t2332 vdd.t66 vdd.t65 sg13_lv_pmos ad=0.34p pd=2.68u as=0 ps=0 w=1u l=1u
X455 vdd.t404 vss.t2261 vdd.t403 vdd.t95 sg13_lv_pmos ad=0.34p pd=2.68u as=0 ps=0 w=1u l=1u
X456 vdd.t271 vss.t2222 vdd.t270 vdd.t159 sg13_lv_pmos ad=0.19p pd=1.38u as=0 ps=0 w=1u l=1u
X457 a_1367_3941# quantizer2_lfsr_0.sg13cmos5l_dfrbpq_1_11.Q.t3 vdd.t907 vdd.t504 sg13_lv_pmos ad=79.8f pd=0.8u as=0.1428p ps=1.52u w=0.42u l=0.13u
X458 vdd.t879 di_qout_en dsm2_io_0.sg13cmos5l_inv_1_1.A vdd.t25 sg13_hv_pmos ad=0.17p pd=1.68u as=0.17p ps=1.68u w=0.5u l=1u
X459 a_1443_7449# a_1322_6770# a_1284_7983# vdd.t504 sg13_lv_pmos ad=93.45f pd=0.865u as=0.2048p ps=1.63u w=0.42u l=0.13u
X460 a_6249_9100.t7 d_amp_s[1].t2 a_11173_9488.t3 vss.t667 sg13_lv_nmos ad=95f pd=0.88u as=0.17p ps=1.68u w=0.5u l=0.13u
X461 vdd.t820 a_5176_31117# vdd.t818 vdd.t764 sg13_lv_pmos ad=0.465p pd=1.93u as=0 ps=0 w=1u l=2u
X462 vdd.t322 vss.t2162 vdd.t321 vdd.t308 sg13_lv_pmos ad=0.34p pd=2.68u as=0 ps=0 w=1u l=1u
X463 a_537_14181# d_qclk.t20 vss.t143 vss.t1398 sg13_lv_nmos ad=0.2516p pd=2.16u as=3.67165p ps=23.42u w=0.74u l=0.13u
X464 a_1324_804# a_1288_778# vss.t555 vss.t554 sg13_lv_nmos ad=0.2516p pd=2.16u as=0.1626p ps=1.415u w=0.74u l=0.13u
X465 vss.t263 vss.t261 vss.t266 vss.t265 sg13_hv_nmos ad=0.19p pd=1.38u as=0 ps=0 w=1u l=10u
X466 a_20672_19620# a_24258_19480# vss.t207 rhigh l=17.5u w=0.5u
X467 vss.t109 sw_tgate_cmfb2_1.p.t10 vss.t107 vss.t108 sg13_lv_nmos ad=95f pd=0.88u as=0 ps=0 w=0.5u l=3u
X468 vss.t1917 vdd.t1725 vss.t1916 vss.t1915 sg13_lv_nmos ad=1.19p pd=7.68u as=0 ps=0 w=3.5u l=1u
X469 vss.t1359 a_20328_23820# vss.t280 vss.t262 sg13_hv_nmos ad=1.9p pd=10.38u as=0 ps=0 w=10u l=10u
X470 a_1407_15314# d_dith_en.t36 vdd.t511 vdd.t504 sg13_lv_pmos ad=79.8f pd=0.8u as=1.1847p ps=7.385u w=0.42u l=0.13u
X471 a_20672_21300# a_24258_21160# vss.t207 rhigh l=17.5u w=0.5u
X472 sw_tgate_10.p.t2 sw_tgate_9.gb.t4 xsc_vc1l_p.t1 vdd.t561 sg13_lv_pmos ad=0.38p pd=2.38u as=0.38p ps=2.38u w=2u l=1u
X473 a_571_11460# a_533_12512# a_567_11154# vss.t864 sg13_lv_nmos ad=0.2373p pd=1.97u as=79.8f ps=0.8u w=0.42u l=0.13u
X474 a_22252_4374# bias_gm_0.bias_trim_0.vz.t26 vdd.t1162 vdd.t572 sg13_lv_pmos ad=95f pd=0.88u as=95f ps=0.88u w=0.5u l=5u
X475 xq_dith_v_bp.t6 sg13cmos5l_inv_1_3.A.t2 vo_n.t10 vss.t717 sg13_lv_nmos ad=0.665p pd=3.88u as=0.665p ps=3.88u w=3.5u l=0.13u
X476 a_6249_9100.t15 sg13cmos5l_nand2_1_2.Y.t3 xq_vg_q_0_.t2 vdd.t580 sg13_lv_pmos ad=0.17p pd=1.68u as=95f ps=0.88u w=0.5u l=0.13u
X477 clk_noverlap_0.sg13cmos5l_dlygate4sd3_1_4.A a_8105_7224# vdd.t594 vdd.t308 sg13_lv_pmos ad=0.4256p pd=3u as=0.2254p ps=1.53u w=1.12u l=0.13u
X478 a_11293_11104.t9 xq_vg_p_2_.t3 a_9357_11104.t19 vss.t645 sg13_lv_nmos ad=0.285p pd=1.88u as=0.285p ps=1.88u w=1.5u l=0.5u
X479 vdd.t49 vss.t2382 vdd.t48 vdd.t10 sg13_lv_pmos ad=0.19p pd=1.38u as=0 ps=0 w=1u l=1u
X480 a_2083_2244# a_2045_3296# a_2079_1938# vss.t522 sg13_lv_nmos ad=0.2373p pd=1.97u as=79.8f ps=0.8u w=0.42u l=0.13u
X481 vss.t268 vss.t261 vss.t270 vss.t269 sg13_hv_nmos ad=0.19p pd=1.38u as=0 ps=0 w=1u l=10u
X482 vdd.t824 a_5176_31117# vdd.t822 vdd.t764 sg13_lv_pmos ad=0.19p pd=1.38u as=0 ps=0 w=1u l=2u
X483 a_15491_15614# d_rst_b.t2 vdd.t749 vdd.t502 sg13_lv_pmos ad=0.1596p pd=1.22u as=0.1918p ps=1.5u w=0.84u l=0.13u
X484 a_8107_14934# sg13cmos5l_and2_1_5.A.t4 a_8013_14934# vss.t94 sg13_lv_nmos ad=0.1216p pd=1.02u as=0.2176p ps=1.96u w=0.64u l=0.13u
X485 vss.t1363 a_20328_23820# vss.t1364 vss.t265 sg13_hv_nmos ad=1.9p pd=10.38u as=0 ps=0 w=10u l=10u
X486 a_522_15314# d_dith_en.t38 vdd.t511 vdd.t504 sg13_lv_pmos ad=79.8f pd=0.8u as=1.1847p ps=7.385u w=0.42u l=0.13u
X487 vss.t432 vss.t431 a_9357_11104.t5 vss.t407 sg13_lv_nmos ad=0.285p pd=1.88u as=0.285p ps=1.88u w=1.5u l=0.5u
X488 vss.t1497 vdd.t1824 vss.t1499 vss.t1498 sg13_lv_nmos ad=79.8f pd=0.8u as=0 ps=0 w=0.42u l=1u
X489 vss.t274 a_20328_23820# vss.t1354 vss.t262 sg13_hv_nmos ad=1.9p pd=10.38u as=0 ps=0 w=10u l=10u
X490 d_qi_b.t1 d_qi.t3 vss.t1022 vss.t1021 sg13_lv_nmos ad=0.1406p pd=1.12u as=0.2516p ps=2.16u w=0.74u l=0.13u
X491 vdd.t655 d_dith_en.t2 a_1367_1349# vdd.t504 sg13_lv_pmos ad=0.36237p pd=2.605u as=79.8f ps=0.8u w=0.42u l=0.13u
X492 vss.t175 vcm_esd.t25 vss.t177 vss.t176 sg13_hv_nmos ad=1.9p pd=10.38u as=0 ps=0 w=10u l=10u
X493 vss.t2049 vdd.t1697 vss.t2048 vss.t2047 sg13_lv_nmos ad=0.1428p pd=1.52u as=0 ps=0 w=0.42u l=1u
X494 vo_n.t9 sg13cmos5l_inv_1_3.A.t2 xq_dith_v_bp.t4 vss.t717 sg13_lv_nmos ad=0.665p pd=3.88u as=1.19p ps=7.68u w=3.5u l=0.13u
X495 a_15130_14856# sg13cmos5l_and2_1_5.A.t2 vss.t825 vss.t824 sg13_lv_nmos ad=0.1428p pd=1.52u as=79.8f ps=0.8u w=0.42u l=0.13u
X496 quantizer2_lfsr_0.sg13cmos5l_dfrbpq_1_13.Q a_1284_15861# vdd.t758 vdd.t504 sg13_lv_pmos ad=0.3808p pd=2.92u as=0.2128p ps=1.5u w=1.12u l=0.13u
X497 vdd.t374 vss.t2145 vdd.t373 vdd.t308 sg13_lv_pmos ad=0.19p pd=1.38u as=0 ps=0 w=1u l=1u
X498 vdd.t1332 vdd.t1313 vdd.t1314 vdd.t863 sg13_lv_pmos ad=0.285p pd=1.88u as=0 ps=0 w=1.5u l=0.5u
X499 a_1407_7538# a_1284_7983# a_1758_7666# vss.t130 sg13_lv_nmos ad=0.1428p pd=1.52u as=37.8f ps=0.6u w=0.42u l=0.13u
X500 xsc_xcmfb1_vsw_cm_p.t12 vdd.t1301 xsc_xcmfb1_vsw_cm_p.t7 vdd.t558 sg13_lv_pmos ad=0.51p pd=3.68u as=0 ps=0 w=1.5u l=1u
X501 sg13cmos5l_inv_2_5.Y sg13cmos5l_inv_2_5.A vdd.t1119 vdd.t502 sg13_lv_pmos ad=0.2128p pd=1.5u as=0.3808p ps=2.92u w=1.12u l=0.13u
X502 a_11284_15186# sg13cmos5l_nor2_2_2.A vdd.t1141 vdd.t502 sg13_lv_pmos ad=0.2128p pd=1.5u as=0.2128p ps=1.5u w=1.12u l=0.13u
X503 vss.t1664 vdd.t1787 vss.t1662 vss.t1663 sg13_lv_nmos ad=79.8f pd=0.8u as=0 ps=0 w=0.42u l=1u
X504 vdd.t1187 vdd.t1564 vdd.t1565 vdd.t1173 sg13_lv_pmos ad=95f pd=0.88u as=0 ps=0 w=0.5u l=5u
X505 vss.t1512 vdd.t1821 vss.t1514 vss.t1513 sg13_lv_nmos ad=79.8f pd=0.8u as=0 ps=0 w=0.42u l=1u
X506 vss.t1619 vdd.t1797 vss.t1618 vss.t1617 sg13_lv_nmos ad=0.1428p pd=1.52u as=0 ps=0 w=0.42u l=1u
X507 vss.t1365 a_20328_23820# vss.t290 vss.t269 sg13_hv_nmos ad=1.9p pd=10.38u as=0 ps=0 w=10u l=10u
X508 vcm_esd.t21 sw_tgate_11.gb.t6 xsc_vc1r_p.t7 vdd.t556 sg13_lv_pmos ad=0.68p pd=4.68u as=0.38p ps=2.38u w=2u l=1u
X509 vss.t1692 vdd.t1779 vss.t1693 vss.t1689 sg13_lv_nmos ad=79.8f pd=0.8u as=0 ps=0 w=0.42u l=1u
X510 vss.t624 a_11841_7467# clk_noverlap_0.sg13cmos5l_dlygate4sd3_1_0.A.t0 vss.t2109 sg13_lv_nmos ad=0.1426p pd=1.16u as=0.2516p ps=2.16u w=0.74u l=0.13u
X511 a_21977_22824# a_24258_22824# vss.t212 rhigh l=10.975u w=0.5u
X512 vdd.t417 vss.t2168 vdd.t479 vdd.t308 sg13_lv_pmos ad=0.34p pd=2.68u as=0 ps=0 w=1u l=1u
X513 a_2461_12681# a_2034_13704# vdd.t921 vdd.t507 sg13_lv_pmos ad=63f pd=0.72u as=0.1563p ps=1.22u w=0.42u l=0.13u
X514 vss.t1569 vdd.t1809 vss.t1568 vss.t1567 sg13_lv_nmos ad=0.1428p pd=1.52u as=0 ps=0 w=0.42u l=1u
X515 vdd.t1170 bias_gm_0.bias_trim_0.vz.t34 a_22252_4074# vdd.t573 sg13_lv_pmos ad=95f pd=0.88u as=95f ps=0.88u w=0.5u l=5u
X516 vss.t1032 d_qi_b.t9 sw_tgate_10.p.t8 vss.t1031 sg13_lv_nmos ad=0.34p pd=2.68u as=0.19p ps=1.38u w=1u l=1u
X517 a_10989_15998# d_qi.t5 vdd.t1034 vdd.t502 sg13_lv_pmos ad=0.1596p pd=1.22u as=0.2856p ps=2.36u w=0.84u l=0.13u
X518 vdd.t501 vss.t2392 vdd.t7 vdd.t0 sg13_lv_pmos ad=0.19p pd=1.38u as=0 ps=0 w=1u l=1u
X519 a_10757_9808# sg13cmos5l_inv_1_1.A vss.t710 rhigh l=20u w=0.5u
X520 vdd.t43 vss.t2378 vdd.t37 vdd.t10 sg13_lv_pmos ad=0.19p pd=1.38u as=0 ps=0 w=1u l=1u
X521 a_24540_19760# a_28126_19900# vss.t34 rhigh l=17.5u w=0.5u
X522 a_21478_2344# a_21452_2308.t6 a_21276_2052# vss.t2078 sg13_lv_nmos ad=95f pd=0.88u as=95f ps=0.88u w=0.5u l=0.13u
X523 vss.t2014 vdd.t1704 vss.t2013 vss.t2012 sg13_lv_nmos ad=0.1428p pd=1.52u as=0 ps=0 w=0.42u l=1u
X524 vdd.t1490 vdd.t1488 vdd.t1153 vdd.t1287 sg13_lv_pmos ad=0.17p pd=1.68u as=0 ps=0 w=0.5u l=5u
X525 vdd.t1669 vss.t2361 vdd.t1667 vdd.t764 sg13_hv_pmos ad=0.2375p pd=1.63u as=0 ps=0 w=1.25u l=4u
X526 a_2034_3336# a_2079_1938# vdd.t627 vdd.t507 sg13_lv_pmos ad=0.34p pd=2.68u as=0.36237p ps=2.605u w=1u l=0.13u
X527 vdd.t1671 vss.t2361 vdd.t1669 vdd.t764 sg13_hv_pmos ad=0.2375p pd=1.63u as=0 ps=0 w=1.25u l=4u
X528 vdd.t627 d_dith_en.t4 a_2070_1670# vdd.t507 sg13_lv_pmos ad=0.36237p pd=2.605u as=79.8f ps=0.8u w=0.42u l=0.13u
X529 a_522_2184# a_567_786# vdd.t1110 vdd.t504 sg13_lv_pmos ad=0.34p pd=2.68u as=0.36237p ps=2.605u w=1u l=0.13u
X530 xq_vg_p_2_.t2 sg13cmos5l_inv_1_19.Y.t4 vss.t878 vss.t840 sg13_lv_nmos ad=0.17p pd=1.68u as=0.17p ps=1.68u w=0.5u l=0.13u
X531 vdd.t1110 d_dith_en.t3 a_558_518# vdd.t504 sg13_lv_pmos ad=0.36237p pd=2.605u as=79.8f ps=0.8u w=0.42u l=0.13u
X532 vss.t177 vcm_esd.t25 vss.t179 vss.t178 sg13_hv_nmos ad=1.9p pd=10.38u as=0 ps=0 w=10u l=10u
X533 vss.t1346 vss.t1347 vss.t531 rhigh l=2.75u w=0.5u
X534 vss.t1173 vss.t1174 vss.t39 rhigh l=2.75u w=0.5u
X535 vdd.t584 bias_gm_0.bias_trim_0.vz.t12 bias_gm_0.bias_trim_0.vz.t13 vdd.t573 sg13_lv_pmos ad=95f pd=0.88u as=95f ps=0.88u w=0.5u l=5u
X536 a_19984_17824# bias_gm_0.bias_trim_0.vz.t0 vdd.t1256 vdd.t566 sg13_lv_pmos ad=95f pd=0.88u as=95f ps=0.88u w=0.5u l=5u
X537 a_522_12552# a_567_11154# vss.t708 vss.t707 sg13_lv_nmos ad=0.2516p pd=2.16u as=0.1626p ps=1.415u w=0.74u l=0.13u
X538 vss.t1081 d_dith_en.t28 a_2070_12132# vss.t1080 sg13_lv_nmos ad=0.1626p pd=1.415u as=60.89999f ps=0.71u w=0.42u l=0.13u
X539 vss.t1167 vss.t1168 vss.t531 rhigh l=2.75u w=0.5u
X540 vss.t119 sw_tgate_cmfb2_1.p.t7 vss.t117 vss.t70 sg13_lv_nmos ad=95f pd=0.88u as=0 ps=0 w=0.5u l=3u
X541 a_2070_12038# a_2045_13664# a_2079_12306# vdd.t507 sg13_lv_pmos ad=0.1428p pd=1.52u as=79.8f ps=0.8u w=0.42u l=0.13u
X542 vdd.t1359 vdd.t1357 vdd.t899 vdd.t897 sg13_lv_pmos ad=0.17p pd=1.68u as=0 ps=0 w=0.5u l=10u
X543 xsc_xcmfb1_vsw_cm_n.t6 vss.t302 xsc_xcmfb1_vsw_cm_n.t5 vss.t298 sg13_lv_nmos ad=95f pd=0.88u as=0 ps=0 w=0.5u l=1u
X544 vdd.t117 vss.t2313 vdd.t166 vdd.t116 sg13_lv_pmos ad=0.34p pd=2.68u as=0 ps=0 w=1u l=1u
X545 vdd.t444 vss.t2151 vdd.t362 vdd.t308 sg13_lv_pmos ad=0.19p pd=1.38u as=0 ps=0 w=1u l=1u
X546 a_1286_4247# d_qclk.t6 vdd.t511 vdd.t504 sg13_lv_pmos ad=0.4088p pd=2.97u as=1.1847p ps=7.385u w=1.12u l=0.13u
X547 sg13cmos5l_inv_1_15.Y d_dith[2].t3 vdd.t1623 vdd.t502 sg13_lv_pmos ad=0.3808p pd=2.92u as=0.3808p ps=2.92u w=1.12u l=0.13u
X548 a_6453_8400.t3 a_5994_8400.t1 vss.t4 rhigh l=4.08u w=0.5u
X549 vss.t33 di_ena dsm2_io_0.dsm2_io_rx_9.di_b.t0 vss.t32 sg13_hv_nmos ad=0.34p pd=2.68u as=0.34p ps=2.68u w=1u l=0.45u
X550 vss.t1832 vdd.t1746 vss.t1830 vss.t1819 sg13_lv_nmos ad=79.8f pd=0.8u as=0 ps=0 w=0.42u l=1u
X551 a_5994_8400.t2 d_amp_s_b[1].t3 a_5892_8400.t13 vdd.t658 sg13_lv_pmos ad=0.17p pd=1.68u as=95f ps=0.88u w=0.5u l=0.13u
X552 a_21830_2088# a_21276_2052# a_21736_2344# vss.t501 sg13_lv_nmos ad=95f pd=0.88u as=0.17p ps=1.68u w=0.5u l=0.13u
X553 a_12237_7164# clk_noverlap_0.sg13cmos5l_dlygate4sd3_1_8.X vdd.t632 vdd.t308 sg13_lv_pmos ad=0.1428p pd=1.52u as=0.1523p ps=1.38u w=0.42u l=0.13u
X554 vdd.t305 vss.t2420 vdd.t303 vdd.t0 sg13_lv_pmos ad=0.19p pd=1.38u as=0 ps=0 w=1u l=1u
X555 vdd.t782 a_5176_31117# vdd.t783 vdd.t764 sg13_lv_pmos ad=0.465p pd=1.93u as=0 ps=0 w=1u l=2u
X556 vdd.t1689 vss.t2359 vdd.t1664 vdd.t261 sg13_lv_pmos ad=0.19p pd=1.38u as=0 ps=0 w=1u l=1u
X557 a_1600_3941# a_1324_3396# a_1745_3622# vss.t16 sg13_lv_nmos ad=0.1428p pd=1.52u as=37.8f ps=0.6u w=0.42u l=0.13u
X558 vss.t607 d_dith_en.t20 a_1758_8388# vss.t1059 sg13_lv_nmos ad=0.1626p pd=1.415u as=60.89999f ps=0.71u w=0.42u l=0.13u
X559 vdd.t663 a_522_7702# a_522_8085# vdd.t504 sg13_lv_pmos ad=0.2128p pd=1.5u as=0.3864p ps=2.93u w=1.12u l=0.13u
X560 vdd.t866 sg13cmos5l_inv_1_2.A.t10 sg13cmos5l_inv_1_14.A.t7 vdd.t863 sg13_lv_pmos ad=0.285p pd=1.88u as=0.285p ps=1.88u w=1.5u l=0.5u
X561 vdd.t31 vss.t2367 vdd.t30 vdd.t22 sg13_lv_pmos ad=0.19p pd=1.38u as=0 ps=0 w=1u l=1u
X562 vdd.t1400 vdd.t1398 vdd.t567 vdd.t1287 sg13_lv_pmos ad=0.17p pd=1.68u as=0 ps=0 w=0.5u l=5u
X563 sg13cmos5l_inv_1_8.Y d_dith[1].t3 vdd.t605 vdd.t502 sg13_lv_pmos ad=0.3808p pd=2.92u as=0.3808p ps=2.92u w=1.12u l=0.13u
X564 vdd.t160 vss.t2221 vdd.t226 vdd.t159 sg13_lv_pmos ad=0.34p pd=2.68u as=0 ps=0 w=1u l=1u
X565 a_567_5970# a_537_6405# a_949_6345# vdd.t504 sg13_lv_pmos ad=79.8f pd=0.8u as=63f ps=0.72u w=0.42u l=0.13u
X566 vdd.t216 vss.t2293 vdd.t215 vdd.t102 sg13_lv_pmos ad=0.34p pd=2.68u as=0 ps=0 w=1u l=1u
X567 d_amp_s_b[1].t1 d_amp_s[1].t4 vss.t1328 vss.t457 sg13_lv_nmos ad=0.2516p pd=2.16u as=0.2516p ps=2.16u w=0.74u l=0.13u
X568 a_1600_3941# a_1322_4178# a_1288_3370# vss.t146 sg13_lv_nmos ad=0.2373p pd=1.97u as=79.8f ps=0.8u w=0.42u l=0.13u
X569 vdd.t1259 bias_gm_0.bias_trim_0.vz.t0 a_19984_17824# vdd.t570 sg13_lv_pmos ad=95f pd=0.88u as=95f ps=0.88u w=0.5u l=5u
X570 vdd.t636 d_dith[0].t2 sg13cmos5l_inv_1_13.A.t0 vdd.t502 sg13_lv_pmos ad=0.3808p pd=2.92u as=0.2128p ps=1.5u w=1.12u l=0.13u
X571 vdd.t76 vss.t2335 vdd.t75 vdd.t74 sg13_lv_pmos ad=0.19p pd=1.38u as=0 ps=0 w=1u l=1u
X572 a_1600_11717# a_1322_11954# a_1288_11146# vss.t560 sg13_lv_nmos ad=0.2373p pd=1.97u as=79.8f ps=0.8u w=0.42u l=0.13u
X573 a_1284_15759# a_1286_14615# a_1324_13764# vdd.t504 sg13_lv_pmos ad=0.2048p pd=1.63u as=0.34p ps=2.68u w=1u l=0.13u
X574 vdd.t992 bias_gm_0.bias_trim_0.vz.t36 a_22252_7946# vdd.t573 sg13_lv_pmos ad=95f pd=0.88u as=95f ps=0.88u w=0.5u l=5u
X575 xsc_xcmfb1_vsw_cm_n.t11 sw_tgate_cmfb2_1.gb.t3 vcm_esd.t13 vdd.t560 sg13_lv_pmos ad=0.285p pd=1.88u as=0.285p ps=1.88u w=1.5u l=1u
X576 a_571_1092# a_522_2184# a_571_1030# vss.t499 sg13_lv_nmos ad=0.1428p pd=1.52u as=37.8f ps=0.6u w=0.42u l=0.13u
X577 vdd.t511 a_1286_9431# a_1322_9362# vdd.t504 sg13_lv_pmos ad=1.21587p pd=7.58u as=0.3864p ps=2.93u w=1.12u l=0.13u
X578 vss.t456 quantizer2_lfsr_0.di_dith_amp[0].t4 d_amp_s[0].t1 vss.t455 sg13_lv_nmos ad=0.2516p pd=2.16u as=0.1406p ps=1.12u w=0.74u l=0.13u
X579 a_1324_8580# a_1288_8554# vss.t607 vss.t606 sg13_lv_nmos ad=0.2516p pd=2.16u as=0.1626p ps=1.415u w=0.74u l=0.13u
X580 vss.t256 a_10592_15909# sg13cmos5l_inv_1_12.A vss.t255 sg13_lv_nmos ad=0.1331p pd=1.12u as=0.2516p ps=2.16u w=0.74u l=0.13u
X581 vo_p.t15 sg13cmos5l_inv_1_3.A.t3 xq_dith_v_bq.t11 vss.t1235 sg13_lv_nmos ad=0.665p pd=3.88u as=0.665p ps=3.88u w=3.5u l=0.13u
X582 vdd.t313 vss.t2166 vdd.t312 vdd.t308 sg13_lv_pmos ad=0.34p pd=2.68u as=0 ps=0 w=1u l=1u
X583 xsc_xcmfb1_vsw_cm_n.t0 vss.t301 xsc_xcmfb1_vsw_cm_n.t4 vss.t296 sg13_lv_nmos ad=0.17p pd=1.68u as=0 ps=0 w=0.5u l=1u
X584 xsc_xcmfb1_vsw_cm_p.t3 sw_tgate_cmfb2_1.gb.t4 vcm_esd.t0 vdd.t558 sg13_lv_pmos ad=0.285p pd=1.88u as=0.285p ps=1.88u w=1.5u l=1u
X585 vss.t1720 vdd.t1772 vss.t1719 vss.t1718 sg13_lv_nmos ad=0.1428p pd=1.52u as=0 ps=0 w=0.42u l=1u
X586 vss.t1903 vdd.t1729 vss.t1901 vss.t1890 sg13_lv_nmos ad=79.8f pd=0.8u as=0 ps=0 w=0.42u l=1u
X587 a_20672_20740# a_24258_20880# vss.t207 rhigh l=17.5u w=0.5u
X588 a_22252_11246# bias_gm_0.bias_trim_0.vz.t9 vdd.t569 vdd.t287 sg13_lv_pmos ad=95f pd=0.88u as=95f ps=0.88u w=0.5u l=5u
X589 a_567_3378# a_537_3813# a_558_3110# vss.t144 sg13_lv_nmos ad=79.8f pd=0.8u as=0.1296p ps=1.52u w=0.42u l=0.13u
X590 a_22252_4074# bias_gm_0.bias_trim_0.vz.t34 vdd.t1170 vdd.t287 sg13_lv_pmos ad=95f pd=0.88u as=95f ps=0.88u w=0.5u l=5u
X591 a_22252_7946# bias_gm_0.bias_trim_0.vz.t45 vdd.t1013 vdd.t572 sg13_lv_pmos ad=95f pd=0.88u as=95f ps=0.88u w=0.5u l=5u
X592 vss.t1773 vdd.t1760 vss.t1771 vss.t1763 sg13_lv_nmos ad=79.8f pd=0.8u as=0 ps=0 w=0.42u l=1u
X593 a_22258_594# a_22000_594# vss.t557 vss.t556 sg13_lv_nmos ad=0.1428p pd=1.52u as=79.8f ps=0.8u w=0.42u l=0.13u
X594 a_24214_15746# a_20138_14766# a_22138_16046# vdd.t898 sg13_lv_pmos ad=0.17p pd=1.68u as=95f ps=0.88u w=0.5u l=10u
X595 vss.t951 a_522_12886# a_522_13269# vss.t1288 sg13_lv_nmos ad=0.1406p pd=1.12u as=0.2516p ps=2.16u w=0.74u l=0.13u
X596 vss.t2070 vss.t2071 vss.t207 rhigh l=17.5u w=0.5u
X597 vss.t65 sw_tgate_cmfb2_1.p.t12 vss.t64 vss.t61 sg13_lv_nmos ad=0.17p pd=1.68u as=0 ps=0 w=0.5u l=3u
X598 vss.t1094 d_dith_en.t33 a_558_13572# vss.t1093 sg13_lv_nmos ad=0.1626p pd=1.415u as=60.89999f ps=0.71u w=0.42u l=0.13u
X599 vss.t1607 vdd.t1800 vss.t1606 vss.t1605 sg13_lv_nmos ad=0.1428p pd=1.52u as=0 ps=0 w=0.42u l=1u
X600 vss.t518 a_21554_2052.t5 a_23294_2344# vss.t517 sg13_lv_nmos ad=95f pd=0.88u as=0.17p ps=1.68u w=0.5u l=0.5u
X601 a_28746_15446# a_19964_18216# a_26670_15746# vdd.t1128 sg13_lv_pmos ad=0.17p pd=1.68u as=95f ps=0.88u w=0.5u l=10u
X602 a_558_3110# quantizer2_lfsr_0.sg13cmos5l_dfrbpq_1_0.Q vdd.t1131 vdd.t504 sg13_lv_pmos ad=79.8f pd=0.8u as=0.1428p ps=1.52u w=0.42u l=0.13u
X603 a_6249_9100.t4 sg13cmos5l_inv_1_20.Y.t3 xq_vg_q_0_.t1 vss.t479 sg13_lv_nmos ad=0.17p pd=1.68u as=95f ps=0.88u w=0.5u l=0.13u
X604 vdd.t885 d_dith_en.t26 a_1367_11717# vdd.t504 sg13_lv_pmos ad=0.36237p pd=2.605u as=79.8f ps=0.8u w=0.42u l=0.13u
X605 vdd.t142 vss.t2305 vdd.t141 vdd.t110 sg13_lv_pmos ad=0.34p pd=2.68u as=0 ps=0 w=1u l=1u
X606 vss.t871 vss.t872 vss.t527 rhigh l=9.28u w=0.5u
X607 vdd.t414 vss.t2173 vdd.t413 vdd.t339 sg13_lv_pmos ad=0.34p pd=2.68u as=0 ps=0 w=1u l=1u
X608 vss.t1573 vdd.t1808 vss.t1572 vss.t1567 sg13_lv_nmos ad=0.1428p pd=1.52u as=0 ps=0 w=0.42u l=1u
X609 sg13cmos5l_inv_1_17.A.t1 sg13cmos5l_nand2_1_5.A.t2 a_6874_14892# vss.t0 sg13_lv_nmos ad=0.2516p pd=2.16u as=0.1406p ps=1.12u w=0.74u l=0.13u
X610 vdd.t310 vss.t2149 vdd.t309 vdd.t308 sg13_lv_pmos ad=0.19p pd=1.38u as=0 ps=0 w=1u l=1u
X611 vdd.t1676 vss.t2380 vdd.t34 vdd.t10 sg13_lv_pmos ad=0.19p pd=1.38u as=0 ps=0 w=1u l=1u
X612 vdd.t808 a_5176_31117# a_9348_31505# vdd.t764 sg13_lv_pmos ad=0.34p pd=2.68u as=0.34p ps=2.68u w=1u l=2u
X613 vss.t1532 vdd.t1817 vss.t1531 vss.t1530 sg13_lv_nmos ad=0.1428p pd=1.52u as=0 ps=0 w=0.42u l=1u
X614 a_9348_31505# a_5176_31469# vo_n.t18 vdd.t764 sg13_lv_pmos ad=0.665p pd=3.88u as=1.19p ps=7.68u w=3.5u l=2u
X615 vss.t854 di_qout_en dsm2_io_0.sg13cmos5l_inv_1_1.A vss.t853 sg13_hv_nmos ad=0.34p pd=2.68u as=0.34p ps=2.68u w=1u l=0.45u
X616 a_1758_5074# d_dith_en.t11 vss.t633 vss.t549 sg13_lv_nmos ad=37.8f pd=0.6u as=79.8f ps=0.8u w=0.42u l=0.13u
X617 vss.t756 a_5176_30111# vss.t758 vss.t757 sg13_lv_nmos ad=0.365p pd=1.96u as=0 ps=0 w=0.5u l=3u
X618 vdd.t507 a_2049_4965# a_2045_5888# vdd.t507 sg13_lv_pmos ad=1.99007p pd=12.8u as=0.3864p ps=2.93u w=1.12u l=0.13u
X619 a_522_10294# a_537_8997# a_522_9960# vdd.t504 sg13_lv_pmos ad=0.2048p pd=1.63u as=0.34p ps=2.68u w=1u l=0.13u
X620 vdd.t1592 vdd.t1590 vdd.t1591 vdd.t1287 sg13_lv_pmos ad=0.17p pd=1.68u as=0 ps=0 w=0.5u l=5u
X621 vss.t1413 a_1286_4247# a_1322_4178# vss.t1412 sg13_lv_nmos ad=2.71757p pd=16.785u as=0.2516p ps=2.16u w=0.74u l=0.13u
X622 vss.t1863 vdd.t1738 vss.t1862 vss.t1861 sg13_hv_nmos ad=0.34p pd=2.68u as=0 ps=0 w=1u l=0.45u
X623 vdd.t642 a_21554_2798# a_21478_2578# vdd.t514 sg13_lv_pmos ad=95f pd=0.88u as=0.17p ps=1.68u w=0.5u l=0.5u
X624 vdd.t511 a_1284_5391# a_1407_4946# vdd.t504 sg13_lv_pmos ad=1.21587p pd=7.58u as=79.8f ps=0.8u w=0.42u l=0.13u
X625 vss.t1517 vdd.t1820 vss.t1519 vss.t1518 sg13_lv_nmos ad=79.8f pd=0.8u as=0 ps=0 w=0.42u l=1u
X626 a_2034_3336# a_2079_1938# vss.t486 vss.t485 sg13_lv_nmos ad=0.2516p pd=2.16u as=0.1626p ps=1.415u w=0.74u l=0.13u
X627 vdd.t28 vss.t2373 vdd.t29 vdd.t25 sg13_hv_pmos ad=0.19p pd=1.38u as=0 ps=0 w=1u l=5u
X628 a_22252_8246# bias_gm_0.bias_trim_0.vz.t49 vdd.t679 vdd.t566 sg13_lv_pmos ad=95f pd=0.88u as=95f ps=0.88u w=0.5u l=5u
X629 vss.t1891 vdd.t1732 vss.t1889 vss.t1890 sg13_lv_nmos ad=79.8f pd=0.8u as=0 ps=0 w=0.42u l=1u
X630 a_8974_5832# dsm2_io_vcmg_0.di_vcm_ext.t2 a_8880_5832# vdd.t526 sg13_lv_pmos ad=0.1596p pd=1.22u as=0.2856p ps=2.36u w=0.84u l=0.13u
X631 a_12705_7467# a_12820_7466# vss.t466 vss.t895 sg13_lv_nmos ad=0.1428p pd=1.52u as=0.1426p ps=1.16u w=0.42u l=0.5u
X632 a_2083_12612# a_2045_13664# a_2079_12306# vss.t700 sg13_lv_nmos ad=0.2373p pd=1.97u as=79.8f ps=0.8u w=0.42u l=0.13u
X633 sw_tgate_10.p.t9 d_qi_b.t9 vss.t1003 vss.t1030 sg13_lv_nmos ad=0.19p pd=1.38u as=0.19p ps=1.38u w=1u l=1u
X634 sg13cmos5l_inv_1_8.Y d_dith[1].t3 vss.t252 vss.t251 sg13_lv_nmos ad=0.2516p pd=2.16u as=0.2516p ps=2.16u w=0.74u l=0.13u
X635 vss.t380 vss.t379 vss.t413 vss.t377 sg13_lv_nmos ad=0.76p pd=4.38u as=0 ps=0 w=4u l=0.5u
X636 vdd.t980 vdd.t1557 vdd.t1558 vdd.t570 sg13_lv_pmos ad=95f pd=0.88u as=0 ps=0 w=0.5u l=5u
X637 xsc_vc1l_p.t4 sw_tgate_9.gb.t3 xsc_vc1l_p.t5 vss.t1232 sg13_lv_nmos ad=0.19p pd=1.38u as=0 ps=0 w=1u l=1u
X638 vdd.t507 a_2034_6262# a_2034_6098# vdd.t507 sg13_lv_pmos ad=1.99007p pd=12.8u as=79.8f ps=0.8u w=0.42u l=0.13u
X639 vdd.t243 vss.t2178 vdd.t242 vdd.t82 sg13_lv_pmos ad=0.19p pd=1.38u as=0 ps=0 w=1u l=1u
X640 a_19964_18216# a_19984_17824# vss.t350 vss.t265 sg13_hv_nmos ad=95f pd=0.88u as=95f ps=0.88u w=0.5u l=10u
X641 vss.t362 vss.t360 vss.t361 vss.t262 sg13_lv_nmos ad=0.17p pd=1.68u as=0 ps=0 w=0.5u l=10u
X642 do_q_dec.t0 sg13cmos5l_inv_1_7.Y vss.t216 vss.t215 sg13_lv_nmos ad=0.1406p pd=1.12u as=0.2516p ps=2.16u w=0.74u l=0.13u
X643 vss.t836 sg13cmos5l_nand2_2_0.B.t2 a_11865_14889# vss.t835 sg13_lv_nmos ad=0.1368p pd=1.1u as=0.27p ps=2.19u w=0.72u l=0.13u
X644 vss.t1182 a_21554_2052.t2 a_21554_2052.t1 vss.t1215 sg13_lv_nmos ad=95f pd=0.88u as=95f ps=0.88u w=0.5u l=0.5u
X645 vss.t764 a_5176_30111# vss.t766 vss.t765 sg13_lv_nmos ad=95f pd=0.88u as=0 ps=0 w=0.5u l=3u
X646 a_15721_14934# d_dith_en.t34 vss.t1088 vss.t1087 sg13_lv_nmos ad=0.1216p pd=1.02u as=0.1331p ps=1.12u w=0.64u l=0.13u
X647 a_2038_15217# quantizer2_lfsr_0.sg13cmos5l_dfrbpq_1_5.Q vdd.t1208 vdd.t507 sg13_lv_pmos ad=0.1596p pd=1.22u as=0.4536p ps=2.76u w=0.84u l=0.13u
X648 vcm_esd.t11 sw_tgate_11.gb.t5 vcm_esd.t17 vss.t596 sg13_lv_nmos ad=0.34p pd=2.68u as=0 ps=0 w=1u l=1u
X649 vdd.t383 vss.t2164 vdd.t382 vdd.t308 sg13_lv_pmos ad=0.34p pd=2.68u as=0 ps=0 w=1u l=1u
X650 vdd.t531 clk_noverlap_0.sg13cmos5l_dlygate4sd3_1_3.X a_7723_7241# vdd.t308 sg13_lv_pmos ad=0.1523p pd=1.38u as=0.1428p ps=1.52u w=0.42u l=0.13u
X651 vi_esd.t2 sw_tgate_9.gb.t2 vi_esd.t10 vss.t2075 sg13_lv_nmos ad=0.19p pd=1.38u as=0 ps=0 w=1u l=1u
X652 vss.t770 a_5176_30111# vss.t772 vss.t751 sg13_lv_nmos ad=95f pd=0.88u as=0 ps=0 w=0.5u l=3u
X653 vss.t1684 vdd.t1781 vss.t1685 vss.t1674 sg13_lv_nmos ad=79.8f pd=0.8u as=0 ps=0 w=0.42u l=1u
X654 a_2385_3417# a_2045_3296# a_2034_3670# vdd.t507 sg13_lv_pmos ad=93.45f pd=0.865u as=0.2048p ps=1.63u w=0.42u l=0.13u
X655 a_22252_7946# bias_gm_0.bias_trim_0.vz.t36 vdd.t992 vdd.t287 sg13_lv_pmos ad=95f pd=0.88u as=95f ps=0.88u w=0.5u l=5u
X656 a_9348_31505# a_5176_31469# vo_n.t20 vdd.t764 sg13_lv_pmos ad=0.665p pd=3.88u as=1.19p ps=7.68u w=3.5u l=2u
X657 vdd.t684 bias_gm_0.bias_trim_0.vz.t49 a_22252_8246# vdd.t570 sg13_lv_pmos ad=95f pd=0.88u as=95f ps=0.88u w=0.5u l=5u
X658 bias_gm_0.bias_trim_0.vz.t7 bias_gm_0.bias_trim_0.vz.t6 vdd.t575 vdd.t572 sg13_lv_pmos ad=95f pd=0.88u as=95f ps=0.88u w=0.5u l=5u
X659 a_24540_20040# a_28126_19900# vss.t34 rhigh l=17.5u w=0.5u
X660 a_1600_14309# a_1324_13764# a_1745_13990# vss.t993 sg13_lv_nmos ad=0.1428p pd=1.52u as=37.8f ps=0.6u w=0.42u l=0.13u
X661 a_558_10258# d_dith_en.t24 vss.t1078 vss.t1077 sg13_lv_nmos ad=37.8f pd=0.6u as=79.8f ps=0.8u w=0.42u l=0.13u
X662 vdd.t334 vss.t2316 vdd.t333 vdd.t105 sg13_lv_pmos ad=0.19p pd=1.38u as=0 ps=0 w=1u l=1u
X663 vss.t848 ibias_200n.t8 vss.t847 vss.t269 sg13_hv_nmos ad=95f pd=0.88u as=0 ps=0 w=0.5u l=10u
X664 clk_noverlap_0.sg13cmos5l_dlygate4sd3_1_3.X a_7241_7224# vss.t575 vss.t231 sg13_lv_nmos ad=0.2516p pd=2.16u as=0.1426p ps=1.16u w=0.74u l=0.13u
X665 vss.t816 vss.t817 vss.t531 rhigh l=2.75u w=0.5u
X666 vdd.t777 a_5176_31117# vdd.t778 vdd.t764 sg13_lv_pmos ad=0.19p pd=1.38u as=0 ps=0 w=1u l=2u
X667 vdd.t263 vss.t2358 vdd.t262 vdd.t261 sg13_lv_pmos ad=0.34p pd=2.68u as=0 ps=0 w=1u l=1u
X668 vss.t731 vss.t732 vss.t39 rhigh l=2.75u w=0.5u
X669 vss.t1447 vdd.t1834 vss.t1449 vss.t1448 sg13_lv_nmos ad=79.8f pd=0.8u as=0 ps=0 w=0.42u l=1u
X670 vss.t852 a_19984_17824# a_22252_11246# vss.t267 sg13_hv_nmos ad=95f pd=0.88u as=95f ps=0.88u w=0.5u l=10u
X671 a_6249_9100.t9 sg13cmos5l_inv_1_17.A.t3 xq_vg_q_2_.t1 vdd.t580 sg13_lv_pmos ad=0.17p pd=1.68u as=95f ps=0.88u w=0.5u l=0.13u
X672 vdd.t248 vss.t2403 vdd.t247 vdd.t0 sg13_lv_pmos ad=0.34p pd=2.68u as=0 ps=0 w=1u l=1u
X673 vdd.t1517 vdd.t1515 vdd.t1516 vdd.t1287 sg13_lv_pmos ad=0.17p pd=1.68u as=0 ps=0 w=0.5u l=5u
X674 vss.t121 sw_tgate_cmfb2_1.p.t7 vss.t119 vss.t72 sg13_lv_nmos ad=95f pd=0.88u as=0 ps=0 w=0.5u l=3u
X675 vss.t1801 vdd.t1753 vss.t1800 vss.t1799 sg13_lv_nmos ad=0.1428p pd=1.52u as=0 ps=0 w=0.42u l=1u
X676 d_qi.t1 d_qi_b.t3 a_11284_15186# vdd.t502 sg13_lv_pmos ad=0.2128p pd=1.5u as=0.2128p ps=1.5u w=1.12u l=0.13u
X677 vdd.t178 vss.t2224 vdd.t177 vdd.t176 sg13_lv_pmos ad=0.19p pd=1.38u as=0 ps=0 w=1u l=1u
X678 vss.t904 clk_noverlap_0.sg13cmos5l_inv_1_11.Y clk_noverlap_0.sg13cmos5l_inv_1_10.A vss.t2114 sg13_lv_nmos ad=0.1463p pd=1.15u as=0.1694p ps=1.21u w=0.77u l=0.13u
X679 a_5994_8400.t3 d_amp_s[1].t3 a_5892_8400.t6 vss.t666 sg13_lv_nmos ad=0.17p pd=1.68u as=95f ps=0.88u w=0.5u l=0.13u
X680 vss.t1919 vdd.t1725 vss.t1917 vss.t1915 sg13_lv_nmos ad=0.665p pd=3.88u as=0 ps=0 w=3.5u l=1u
X681 vdd.t830 a_5176_31117# vdd.t828 vdd.t764 sg13_lv_pmos ad=0.465p pd=1.93u as=0 ps=0 w=1u l=2u
X682 xsc_vc1l_n.t8 d_phi1.t3 sw_tgate_8.m.t4 vss.t913 sg13_lv_nmos ad=0.19p pd=1.38u as=0.34p ps=2.68u w=1u l=1u
X683 a_6257_8400.t0 a_10757_9168# vss.t220 rhigh l=10.05u w=0.5u
X684 xsc_vc1r_p.t4 d_phi1.t11 vcm_esd.t6 vss.t897 sg13_lv_nmos ad=0.19p pd=1.38u as=0.34p ps=2.68u w=1u l=1u
X685 vss.t181 vcm_esd.t25 vss.t179 vss.t180 sg13_hv_nmos ad=1.9p pd=10.38u as=0 ps=0 w=10u l=10u
X686 vdd.t436 vss.t2147 vdd.t468 vdd.t308 sg13_lv_pmos ad=0.19p pd=1.38u as=0 ps=0 w=1u l=1u
X687 vdd.t1068 d_dith_en.t27 a_567_11154# vdd.t504 sg13_lv_pmos ad=0.1563p pd=1.22u as=0.147p ps=1.54u w=0.42u l=0.13u
X688 vdd.t997 bias_gm_0.bias_trim_0.vz.t15 a_22252_11246# vdd.t384 sg13_lv_pmos ad=95f pd=0.88u as=95f ps=0.88u w=0.5u l=5u
X689 xq_dith_v_bp.t9 sg13cmos5l_or2_1_0.X.t2 a_4362_8188.t12 vss.t717 sg13_lv_nmos ad=0.665p pd=3.88u as=0.665p ps=3.88u w=3.5u l=0.13u
X690 a_1443_10041# a_1322_9362# a_1284_10575# vdd.t504 sg13_lv_pmos ad=93.45f pd=0.865u as=0.2048p ps=1.63u w=0.42u l=0.13u
X691 vdd.t107 vss.t2311 vdd.t106 vdd.t105 sg13_lv_pmos ad=0.34p pd=2.68u as=0 ps=0 w=1u l=1u
X692 a_8768_15909# vss.t374 vdd.t660 vdd.t502 sg13_lv_pmos ad=0.1596p pd=1.22u as=0.1918p ps=1.5u w=0.84u l=0.13u
X693 vss.t1724 vdd.t1771 vss.t1723 vss.t1718 sg13_lv_nmos ad=0.1428p pd=1.52u as=0 ps=0 w=0.42u l=1u
X694 a_2034_13704# a_2079_12306# vss.t1081 vss.t1148 sg13_lv_nmos ad=0.2516p pd=2.16u as=0.1626p ps=1.415u w=0.74u l=0.13u
X695 vss.t1668 vdd.t1785 vss.t1667 vss.t1666 sg13_lv_nmos ad=0.1428p pd=1.52u as=0 ps=0 w=0.42u l=1u
X696 vss.t1737 vdd.t1768 vss.t1736 vss.t1726 sg13_lv_nmos ad=0.1428p pd=1.52u as=0 ps=0 w=0.42u l=1u
X697 vss.t1403 a_1286_12023# a_1322_11954# vss.t1402 sg13_lv_nmos ad=2.71757p pd=16.785u as=0.2516p ps=2.16u w=0.74u l=0.13u
X698 vss.t1223 vss.t1224 vss.t693 rhigh l=9.28u w=0.5u
X699 vdd.t1640 dsm2_osc_0.sg13cmos5l_inv_1_3.A a_23674_2344# vss.t2122 sg13_lv_nmos ad=0.17p pd=1.68u as=0.17p ps=1.68u w=0.5u l=0.5u
X700 vdd.t665 clk_noverlap_0.sg13cmos5l_dlygate4sd3_1_0.A.t2 a_4267_7241# vdd.t308 sg13_lv_pmos ad=0.1523p pd=1.38u as=0.1428p ps=1.52u w=0.42u l=0.13u
X701 a_11293_11104.t2 vo_n.t24 a_9357_11104.t12 vss.t644 sg13_lv_nmos ad=0.76p pd=4.38u as=0.76p ps=4.38u w=4u l=0.5u
X702 vdd.t511 a_1407_7538# a_1443_7449# vdd.t504 sg13_lv_pmos ad=1.21587p pd=7.58u as=93.45f ps=0.865u w=0.42u l=0.13u
X703 a_4362_8188.t11 sg13cmos5l_or2_1_0.X.t2 xq_dith_v_bp.t7 vss.t717 sg13_lv_nmos ad=0.665p pd=3.88u as=0.665p ps=3.88u w=3.5u l=0.13u
X704 a_1288_8554# a_1286_9431# a_1367_9125# vss.t2141 sg13_lv_nmos ad=79.8f pd=0.8u as=0.1296p ps=1.52u w=0.42u l=0.13u
X705 a_873_10041# a_533_9920# a_522_10294# vdd.t504 sg13_lv_pmos ad=93.45f pd=0.865u as=0.2048p ps=1.63u w=0.42u l=0.13u
X706 vss.t1283 a_1284_13167# a_1284_13269# vss.t2099 sg13_lv_nmos ad=0.1406p pd=1.12u as=0.2516p ps=2.16u w=0.74u l=0.13u
X707 a_522_15314# a_522_15478# a_558_15442# vss.t1210 sg13_lv_nmos ad=0.1428p pd=1.52u as=37.8f ps=0.6u w=0.42u l=0.13u
X708 vss.t1615 vdd.t1798 vss.t1614 vss.t1605 sg13_lv_nmos ad=0.1428p pd=1.52u as=0 ps=0 w=0.42u l=1u
X709 vss.t163 a_21617_558# dsm2_osc_0.sg13cmos5l_dfrbp_1_0.Q_N vss.t162 sg13_lv_nmos ad=0.2516p pd=2.16u as=0.2849p ps=2.25u w=0.74u l=0.13u
X710 vdd.t465 vss.t2153 vdd.t441 vdd.t308 sg13_lv_pmos ad=0.19p pd=1.38u as=0 ps=0 w=1u l=1u
X711 vss.t1636 vdd.t1793 vss.t1635 vss.t1634 sg13_lv_nmos ad=0.1428p pd=1.52u as=0 ps=0 w=0.42u l=1u
X712 xsc_vc1l_p.t11 d_phi1.t5 xsc_vc1l_p.t10 vdd.t561 sg13_lv_pmos ad=0.38p pd=2.38u as=0 ps=0 w=2u l=1u
X713 vdd.t1001 vdd.t1421 vdd.t1422 vdd.t1173 sg13_lv_pmos ad=95f pd=0.88u as=0 ps=0 w=0.5u l=5u
X714 a_558_13572# quantizer2_lfsr_0.sg13cmos5l_dfrbpq_1_1.D.t2 a_558_13478# vss.t985 sg13_lv_nmos ad=60.89999f pd=0.71u as=0.1428p ps=1.52u w=0.42u l=0.13u
X715 a_22252_5274# bias_gm_0.bias_trim_0.vz.t33 vdd.t1175 vdd.t566 sg13_lv_pmos ad=95f pd=0.88u as=95f ps=0.88u w=0.5u l=5u
X716 vss.t894 a_15297_7467# clk_noverlap_0.sg13cmos5l_dlygate4sd3_1_9.A vss.t893 sg13_lv_nmos ad=0.1426p pd=1.16u as=0.2516p ps=2.16u w=0.74u l=0.13u
X717 vss.t1571 vdd.t1809 vss.t1569 vss.t1570 sg13_lv_nmos ad=79.8f pd=0.8u as=0 ps=0 w=0.42u l=1u
X718 vdd.t838 a_5176_31117# vdd.t836 vdd.t764 sg13_lv_pmos ad=0.465p pd=1.93u as=0 ps=0 w=1u l=2u
X719 vdd.t1558 vdd.t1557 vdd.t1560 vdd.t1173 sg13_lv_pmos ad=95f pd=0.88u as=0 ps=0 w=0.5u l=5u
X720 vdd.t208 vss.t2284 vdd.t207 vdd.t153 sg13_lv_pmos ad=0.19p pd=1.38u as=0 ps=0 w=1u l=1u
X721 vss.t1262 vss.t1263 vss.t527 rhigh l=9.28u w=0.5u
X722 a_522_15144# a_567_13746# vss.t1094 vss.t1319 sg13_lv_nmos ad=0.2516p pd=2.16u as=0.1626p ps=1.415u w=0.74u l=0.13u
X723 vdd.t803 a_5176_31117# a_8762_31505# vdd.t764 sg13_lv_pmos ad=0.34p pd=2.68u as=0.19p ps=1.38u w=1u l=2u
X724 vo_n.t23 vdd.t1300 vo_n.t7 vdd.t678 sg13_lv_pmos ad=0.285p pd=1.88u as=0 ps=0 w=1.5u l=1u
X725 xsc_vc1l_n.t7 sw_tgate_11.gb.t3 sw_tgate_6.p.t0 vdd.t562 sg13_lv_pmos ad=0.38p pd=2.38u as=0.38p ps=2.38u w=2u l=1u
X726 vdd.t1242 bias_gm_0.bias_trim_0.vz.t35 a_22252_4374# vdd.t573 sg13_lv_pmos ad=95f pd=0.88u as=95f ps=0.88u w=0.5u l=5u
X727 sw_tgate_8.m.t6 d_qi_b.t6 sw_tgate_8.m.t7 vdd.t562 sg13_lv_pmos ad=0.38p pd=2.38u as=0 ps=0 w=2u l=1u
X728 vdd.t896 a_16557_7164# a_16276_7466# vdd.t308 sg13_lv_pmos ad=0.1523p pd=1.38u as=0.34p ps=2.68u w=1u l=0.5u
X729 a_1286_6839# d_qclk.t9 vdd.t511 vdd.t504 sg13_lv_pmos ad=0.4088p pd=2.97u as=1.1847p ps=7.385u w=1.12u l=0.13u
X730 vcm_esd.t10 d_phi1.t9 xsc_vc1r_n.t6 vss.t902 sg13_lv_nmos ad=0.34p pd=2.68u as=0.19p ps=1.38u w=1u l=1u
X731 sg13cmos5l_inv_1_19.Y.t0 d_dith_en.t35 vss.t1079 vss.t92 sg13_lv_nmos ad=0.2516p pd=2.16u as=0.2516p ps=2.16u w=0.74u l=0.13u
X732 vdd.t24 vss.t2366 vdd.t23 vdd.t22 sg13_lv_pmos ad=0.34p pd=2.68u as=0 ps=0 w=1u l=1u
X733 dsm2_osc_0.dsm2_io_rx_1.di_b di_clk_sel.t0 vss.t1351 vss.t1350 sg13_hv_nmos ad=0.34p pd=2.68u as=0.34p ps=2.68u w=1u l=0.45u
X734 a_19904_17646# d_ena.t5 vdd.t1291 vdd.t1290 sg13_lv_pmos ad=0.17p pd=1.68u as=0.17p ps=1.68u w=0.5u l=0.5u
X735 vss.t117 sw_tgate_cmfb2_1.p.t7 vss.t115 vss.t68 sg13_lv_nmos ad=95f pd=0.88u as=0 ps=0 w=0.5u l=3u
X736 vdd.t1485 vdd.t1483 vdd.t1004 vdd.t1287 sg13_lv_pmos ad=0.17p pd=1.68u as=0 ps=0 w=0.5u l=5u
X737 vss.t1976 vdd.t1712 vss.t1978 vss.t1977 sg13_lv_nmos ad=79.8f pd=0.8u as=0 ps=0 w=0.42u l=1u
X738 a_6452_29739.t6 xsc_vfb.t12 vss.t64 vss.t100 sg13_lv_nmos ad=95f pd=0.88u as=95f ps=0.88u w=0.5u l=3u
X739 a_12237_7164# clk_noverlap_0.sg13cmos5l_dlygate4sd3_1_8.X vss.t496 vss.t495 sg13_lv_nmos ad=0.1428p pd=1.52u as=79.8f ps=0.8u w=0.42u l=0.13u
X740 vdd.t871 sg13cmos5l_nand2_2_0.B.t3 sg13cmos5l_nor2_2_0.B.t2 vdd.t502 sg13_lv_pmos ad=0.2128p pd=1.5u as=0.2128p ps=1.5u w=1.12u l=0.13u
X741 sg13cmos5l_inv_1_2.A.t4 sg13cmos5l_and2_2_1.X.t4 vdd.t969 vdd.t863 sg13_lv_pmos ad=0.285p pd=1.88u as=0.285p ps=1.88u w=1.5u l=0.5u
X742 vss.t319 a_20328_23820# vss.t1372 vss.t262 sg13_hv_nmos ad=1.9p pd=10.38u as=0 ps=0 w=10u l=10u
X743 vss.t243 dsm2_osc_0.sg13cmos5l_dfrbp_1_0.RESET_B.t2 a_23546_607# vss.t242 sg13_lv_nmos ad=0.1701p pd=1.65u as=37.8f ps=0.6u w=0.42u l=0.13u
X744 w_9407_29481.t17 w_9407_29481.t15 w_9407_29481.t4 w_9407_29481.t0 sg13_lv_pmos ad=0.38p pd=2.38u as=0 ps=0 w=2u l=1u
X745 a_11017_14934# d_qclk.t18 vss.t1396 vss.t1395 sg13_lv_nmos ad=0.1216p pd=1.02u as=0.1331p ps=1.12u w=0.64u l=0.13u
X746 xsc_vc1r_n.t4 d_phi1.t9 xsc_vc1r_n.t5 vdd.t556 sg13_lv_pmos ad=0.38p pd=2.38u as=0 ps=0 w=2u l=1u
X747 vss.t590 sg13cmos5l_nor2_2_0.B.t4 sg13cmos5l_nor2_2_0.Y vss.t1198 sg13_lv_nmos ad=0.1406p pd=1.12u as=0.1406p ps=1.12u w=0.74u l=0.13u
X748 vdd.t276 vss.t2398 vdd.t275 vdd.t0 sg13_lv_pmos ad=0.19p pd=1.38u as=0 ps=0 w=1u l=1u
X749 vdd.t1680 vss.t2362 vdd.t1678 vdd.t764 sg13_hv_pmos ad=0.2375p pd=1.63u as=0 ps=0 w=1.25u l=4u
X750 vss.t1700 vdd.t1777 vss.t1699 vss.t1694 sg13_lv_nmos ad=0.1428p pd=1.52u as=0 ps=0 w=0.42u l=1u
X751 vdd.t633 d_dith_en.t3 a_567_786# vdd.t504 sg13_lv_pmos ad=0.1563p pd=1.22u as=0.147p ps=1.54u w=0.42u l=0.13u
X752 a_571_3684# a_522_4776# a_571_3622# vss.t233 sg13_lv_nmos ad=0.1428p pd=1.52u as=37.8f ps=0.6u w=0.42u l=0.13u
X753 a_22138_14846# a_20138_14766# a_20070_14846# vdd.t897 sg13_lv_pmos ad=95f pd=0.88u as=0.17p ps=1.68u w=0.5u l=10u
X754 vss.t1747 vdd.t1766 vss.t1744 vss.t1746 sg13_lv_nmos ad=79.8f pd=0.8u as=0 ps=0 w=0.42u l=1u
X755 vdd.t1036 d_qi.t7 sw_tgate_6.p.t9 vss.t1013 sg13_lv_nmos ad=0.19p pd=1.38u as=0.19p ps=1.38u w=1u l=1u
X756 vss.t723 sw_tgate_cmfb2_1.p.t11 vss.t722 vss.t108 sg13_lv_nmos ad=95f pd=0.88u as=0 ps=0 w=0.5u l=3u
X757 vss.t284 vss.t275 vss.t283 vss.t276 sg13_hv_nmos ad=1.9p pd=10.38u as=0 ps=0 w=10u l=1u
X758 a_26670_15146# a_19964_18216# a_24602_15146# vdd.t1127 sg13_lv_pmos ad=95f pd=0.88u as=0.17p ps=1.68u w=0.5u l=10u
X759 vo_n.t5 vdd.t1299 vo_n.t4 vdd.t678 sg13_lv_pmos ad=0.51p pd=3.68u as=0 ps=0 w=1.5u l=1u
X760 sw_tgate_8.m.t1 sw_tgate_11.gb.t2 sw_tgate_8.m.t0 vss.t605 sg13_lv_nmos ad=0.19p pd=1.38u as=0 ps=0 w=1u l=1u
X761 a_2368_16106# quantizer2_lfsr_0.sg13cmos5l_nor2_1_0.A vdd.t1204 vdd.t507 sg13_lv_pmos ad=0.1176p pd=1.33u as=0.4032p ps=2.96u w=1.12u l=0.13u
X762 vss.t1368 a_20328_23820# vss.t312 vss.t262 sg13_hv_nmos ad=1.9p pd=10.38u as=0 ps=0 w=10u l=10u
X763 vdd.t1250 do_osc_oe.t2 a_20447_636# vdd.t515 sg13_lv_pmos ad=0.253p pd=1.53u as=0.2856p ps=2.36u w=0.84u l=0.13u
X764 a_571_11398# d_dith_en.t27 vss.t1098 vss.t1097 sg13_lv_nmos ad=37.8f pd=0.6u as=0.1701p ps=1.65u w=0.42u l=0.13u
X765 sg13cmos5l_nand2_1_2.Y.t1 sg13cmos5l_nand2_1_5.A.t4 vdd.t978 vdd.t502 sg13_lv_pmos ad=0.2128p pd=1.5u as=0.3808p ps=2.92u w=1.12u l=0.13u
X766 sg13cmos5l_nor2_2_2.A sg13cmos5l_inv_2_5.Y vdd.t876 vdd.t502 sg13_lv_pmos ad=0.2128p pd=1.5u as=0.2184p ps=1.51u w=1.12u l=0.13u
X767 quantizer2_lfsr_0.sg13cmos5l_dfrbpq_1_5.Q a_2034_11829# vss.t697 vss.t1149 sg13_lv_nmos ad=0.2516p pd=2.16u as=0.1406p ps=1.12u w=0.74u l=0.13u
X768 xsc_vvg_n.t3 sw_tgate_9.gb.t6 xsc_vvg_n.t4 vss.t975 sg13_lv_nmos ad=0.19p pd=1.38u as=0 ps=0 w=1u l=1u
X769 vdd.t422 vss.t2144 vdd.t421 vdd.t308 sg13_lv_pmos ad=0.34p pd=2.68u as=0 ps=0 w=1u l=1u
X770 vss.t582 a_14829_7164# a_14548_7466# vss.t137 sg13_lv_nmos ad=79.8f pd=0.8u as=0.1428p ps=1.52u w=0.42u l=0.5u
X771 a_24540_19480# vss.t211 vss.t34 rhigh l=17.5u w=0.5u
X772 dsm2_osc_0.sg13cmos5l_inv_1_2.Y dsm2_osc_0.sg13cmos5l_inv_1_2.A vdd.t1282 vdd.t515 sg13_lv_pmos ad=0.3808p pd=2.92u as=0.3808p ps=2.92u w=1.12u l=0.13u
X773 vss.t1537 vdd.t1816 vss.t1536 vss.t1535 sg13_lv_nmos ad=0.1428p pd=1.52u as=0 ps=0 w=0.42u l=1u
X774 vss.t143 a_537_1221# a_533_2144# vss.t488 sg13_lv_nmos ad=4.19617p pd=26.765u as=0.2516p ps=2.16u w=0.74u l=0.13u
X775 a_9721_7200# a_9451_7241# vdd.t911 vdd.t308 sg13_lv_pmos ad=0.34p pd=2.68u as=0.1523p ps=1.38u w=1u l=0.5u
X776 vdd.t1500 vdd.t1498 vdd.t1502 vdd.t566 sg13_lv_pmos ad=95f pd=0.88u as=0 ps=0 w=0.5u l=5u
X777 vdd.t1395 vdd.t1393 vdd.t574 vdd.t1287 sg13_lv_pmos ad=0.17p pd=1.68u as=0 ps=0 w=0.5u l=5u
X778 vss.t1809 vdd.t1751 vss.t1808 vss.t1799 sg13_lv_nmos ad=0.1428p pd=1.52u as=0 ps=0 w=0.42u l=1u
X779 a_2070_11410# d_dith_en.t25 vss.t651 vss.t1101 sg13_lv_nmos ad=37.8f pd=0.6u as=79.8f ps=0.8u w=0.42u l=0.13u
X780 vdd.t40 vss.t2374 vdd.t20 vdd.t19 sg13_lv_pmos ad=0.19p pd=1.38u as=0 ps=0 w=1u l=1u
X781 vss.t278 vss.t275 vss.t277 vss.t276 sg13_hv_nmos ad=1.9p pd=10.38u as=0 ps=0 w=10u l=1u
X782 a_24540_21160# a_28126_21020# vss.t34 rhigh l=17.5u w=0.5u
X783 vss.t1209 a_522_15478# a_522_15861# vss.t1208 sg13_lv_nmos ad=0.1406p pd=1.12u as=0.2516p ps=2.16u w=0.74u l=0.13u
X784 vdd.t780 a_5176_31117# vdd.t781 vdd.t764 sg13_lv_pmos ad=0.465p pd=1.93u as=0 ps=0 w=1u l=2u
X785 sg13cmos5l_inv_1_14.A.t5 sg13cmos5l_inv_1_2.A.t10 a_11293_11104.t3 vss.t643 sg13_lv_nmos ad=95f pd=0.88u as=95f ps=0.88u w=0.5u l=0.5u
X786 vss.t93 sg13cmos5l_and2_1_5.B.t2 sg13cmos5l_nor2_1_0.Y vss.t92 sg13_lv_nmos ad=0.2516p pd=2.16u as=0.1406p ps=1.12u w=0.74u l=0.13u
X787 vcm_esd.t24 vdd.t553 dpantenna l=0.64u w=4.98u
X788 w_9407_29481.t6 xsc_vvg_n.t6 a_6452_29739.t3 w_9407_29481.t0 sg13_lv_pmos ad=0.38p pd=2.38u as=0.38p ps=2.38u w=2u l=1u
X789 vss.t105 sw_tgate_cmfb2_1.p.t10 vss.t103 vss.t104 sg13_lv_nmos ad=95f pd=0.88u as=0 ps=0 w=0.5u l=3u
X790 a_873_2265# a_533_2144# a_522_2518# vdd.t504 sg13_lv_pmos ad=93.45f pd=0.865u as=0.2048p ps=1.63u w=0.42u l=0.13u
X791 vdd.t448 vss.t2209 vdd.t462 vdd.t379 sg13_lv_pmos ad=0.34p pd=2.68u as=0 ps=0 w=1u l=1u
X792 a_21276_2052# a_21452_2308.t6 a_21478_2578# vdd.t514 sg13_lv_pmos ad=0.17p pd=1.68u as=95f ps=0.88u w=0.5u l=0.13u
X793 a_23195_985# dsm2_osc_0.sg13cmos5l_dfrbp_1_0.RESET_B.t2 vdd.t601 vdd.t515 sg13_lv_pmos ad=79.8f pd=0.8u as=0.36237p ps=2.605u w=0.42u l=0.13u
X794 xsc_xcmfb1_vsw_cm_p.t13 vdd.t1302 xsc_xcmfb1_vsw_cm_p.t2 vdd.t558 sg13_lv_pmos ad=0.285p pd=1.88u as=0 ps=0 w=1.5u l=1u
X795 xsc_vvg_n.t5 sw_tgate_9.gb.t6 xsc_vc1r_p.t2 vdd.t556 sg13_lv_pmos ad=0.68p pd=4.68u as=0.38p ps=2.38u w=2u l=1u
X796 vss.t1722 vdd.t1772 vss.t1720 vss.t1721 sg13_lv_nmos ad=79.8f pd=0.8u as=0 ps=0 w=0.42u l=1u
X797 vss.t674 quantizer2_lfsr_0.sg13cmos5l_nor2_1_1.B d_amp_s[3].t0 vss.t664 sg13_lv_nmos ad=0.2516p pd=2.16u as=0.1406p ps=1.12u w=0.74u l=0.13u
X798 a_8661_8748# a_10757_8888# vss.t129 rhigh l=10.05u w=0.5u
X799 vdd.t1060 d_dith_en.t32 a_1367_14309# vdd.t504 sg13_lv_pmos ad=0.36237p pd=2.605u as=79.8f ps=0.8u w=0.42u l=0.13u
X800 a_5892_8400.t14 sg13cmos5l_inv_1_4.A.t2 xq_vg_p_1_.t2 vdd.t763 sg13_lv_pmos ad=0.17p pd=1.68u as=95f ps=0.88u w=0.5u l=0.13u
X801 a_522_7368# a_567_5970# vss.t939 vss.t938 sg13_lv_nmos ad=0.2516p pd=2.16u as=0.1626p ps=1.415u w=0.74u l=0.13u
X802 a_20672_20460# a_24258_20600# vss.t207 rhigh l=17.5u w=0.5u
X803 vss.t1866 vdd.t1737 vss.t1865 vss.t1864 sg13_hv_nmos ad=0.34p pd=2.68u as=0 ps=0 w=1u l=0.45u
X804 vdd.t1176 bias_gm_0.bias_trim_0.vz.t33 a_22252_5274# vdd.t384 sg13_lv_pmos ad=95f pd=0.88u as=95f ps=0.88u w=0.5u l=5u
X805 a_6249_9100.t0 sg13cmos5l_inv_1_17.Y.t3 xq_vg_q_2_.t0 vss.t461 sg13_lv_nmos ad=0.17p pd=1.68u as=95f ps=0.88u w=0.5u l=0.13u
X806 xsc_xcmfb1_vsw_cm_p.t5 sw_tgate_cmfb2_1.gb.t4 xsc_xcmfb1_vsw_cm_p.t0 vss.t1221 sg13_lv_nmos ad=95f pd=0.88u as=0 ps=0 w=0.5u l=1u
X807 vss.t1074 d_dith_en.t37 a_7531_15998# vss.t1073 sg13_lv_nmos ad=0.1331p pd=1.12u as=0.1216p ps=1.02u w=0.64u l=0.13u
X808 sg13cmos5l_nor2_2_0.B.t1 sg13cmos5l_nand2_2_0.B.t3 vss.t831 vss.t832 sg13_lv_nmos ad=0.1406p pd=1.12u as=0.1406p ps=1.12u w=0.74u l=0.13u
X809 vdd.t27 vss.t2373 vdd.t26 vdd.t25 sg13_hv_pmos ad=0.34p pd=2.68u as=0 ps=0 w=1u l=5u
X810 vss.t1650 vdd.t1790 vss.t1649 vss.t1648 sg13_lv_nmos ad=0.1428p pd=1.52u as=0 ps=0 w=0.42u l=1u
X811 a_1288_11146# a_1286_12023# a_1367_11529# vdd.t504 sg13_lv_pmos ad=79.8f pd=0.8u as=63f ps=0.72u w=0.42u l=0.13u
X812 xsc_xcmfb1_vsw_cm_n.t10 sw_tgate_cmfb2_3.gb.t3 xsc_xcmfb1_vsw_cm_n.t9 vss.t594 sg13_lv_nmos ad=95f pd=0.88u as=0 ps=0 w=0.5u l=1u
X813 a_19984_17824# bias_gm_0.bias_trim_0.vz.t6 vdd.t577 vdd.t287 sg13_lv_pmos ad=95f pd=0.88u as=95f ps=0.88u w=0.5u l=5u
X814 vss.t1255 a_6817_30111# sw_tgate_cmfb2_1.p.t1 vss.t1254 sg13_lv_nmos ad=95f pd=0.88u as=95f ps=0.88u w=0.5u l=3u
X815 vdd.t218 vss.t2325 vdd.t144 vdd.t71 sg13_lv_pmos ad=0.19p pd=1.38u as=0 ps=0 w=1u l=1u
X816 vdd.t1202 a_13870_15077# sg13cmos5l_and2_1_5.A.t1 vdd.t502 sg13_lv_pmos ad=0.2254p pd=1.53u as=0.4256p ps=3u w=1.12u l=0.13u
X817 a_571_14052# a_533_15104# a_567_13746# vss.t649 sg13_lv_nmos ad=0.2373p pd=1.97u as=79.8f ps=0.8u w=0.42u l=0.13u
X818 a_22252_4374# bias_gm_0.bias_trim_0.vz.t35 vdd.t1242 vdd.t287 sg13_lv_pmos ad=95f pd=0.88u as=95f ps=0.88u w=0.5u l=5u
X819 vss.t83 a_1286_6839# a_1322_6770# vss.t82 sg13_lv_nmos ad=2.71757p pd=16.785u as=0.2516p ps=2.16u w=0.74u l=0.13u
X820 vdd.t511 a_1284_7983# a_1407_7538# vdd.t504 sg13_lv_pmos ad=1.21587p pd=7.58u as=79.8f ps=0.8u w=0.42u l=0.13u
X821 a_20138_14766# a_20138_14766# a_22138_16346# vdd.t898 sg13_lv_pmos ad=0.17p pd=1.68u as=95f ps=0.88u w=0.5u l=10u
X822 xsc_xcmfb1_vsw_cm_p.t8 d_phi1.t12 vo_p.t14 vss.t186 sg13_lv_nmos ad=95f pd=0.88u as=95f ps=0.88u w=0.5u l=1u
X823 quantizer2_lfsr_0.sg13cmos5l_dfrbpq_1_6.Q a_2034_14421# vdd.t1139 vdd.t507 sg13_lv_pmos ad=0.3808p pd=2.92u as=0.2128p ps=1.5u w=1.12u l=0.13u
X824 vdd.t634 d_dith_en.t2 a_1288_778# vdd.t504 sg13_lv_pmos ad=0.1563p pd=1.22u as=0.147p ps=1.54u w=0.42u l=0.13u
X825 a_16161_7467# a_16276_7466# vss.t584 vss.t583 sg13_lv_nmos ad=0.1428p pd=1.52u as=0.1426p ps=1.16u w=0.42u l=0.5u
X826 a_2083_4836# a_2045_5888# a_2079_4530# vss.t56 sg13_lv_nmos ad=0.2373p pd=1.97u as=79.8f ps=0.8u w=0.42u l=0.13u
X827 vss.t1573 vdd.t1808 vss.t1574 vss.t1570 sg13_lv_nmos ad=79.8f pd=0.8u as=0 ps=0 w=0.42u l=1u
X828 vss.t1869 vdd.t1736 vss.t1868 vss.t1867 sg13_lv_nmos ad=0.1428p pd=1.52u as=0 ps=0 w=0.42u l=1u
X829 vdd.t206 vss.t2328 vdd.t205 vdd.t71 sg13_lv_pmos ad=0.34p pd=2.68u as=0 ps=0 w=1u l=1u
X830 bias_gm_0.bias_trim_0.iout a_21252_3394# dsm2_osc_0.ibias_in.t4 vdd.t573 sg13_lv_pmos ad=95f pd=0.88u as=95f ps=0.88u w=0.5u l=5u
X831 a_526_16657# quantizer2_lfsr_0.sg13cmos5l_dfrbpq_1_1.D.t3 vdd.t1002 vdd.t504 sg13_lv_pmos ad=0.1596p pd=1.22u as=0.4536p ps=2.76u w=0.84u l=0.13u
X832 vss.t1429 d_ena.t14 vss.t1427 vss.t1428 sg13_hv_nmos ad=0.19p pd=1.38u as=0 ps=0 w=1u l=5u
X833 vss.t1162 sg13cmos5l_inv_1_10.Y a_14266_16020# vss.t1161 sg13_lv_nmos ad=0.2516p pd=2.16u as=0.1406p ps=1.12u w=0.74u l=0.13u
X834 sg13cmos5l_inv_2_0.Y sg13cmos5l_inv_1_2.Y vss.t1296 vss.t1295 sg13_lv_nmos ad=0.1406p pd=1.12u as=0.2516p ps=2.16u w=0.74u l=0.13u
X835 a_21736_2344# a_21276_2052# a_21830_2578# vdd.t514 sg13_lv_pmos ad=95f pd=0.88u as=95f ps=0.88u w=0.5u l=0.13u
X836 vdd.t1044 d_qi_b.t4 a_10592_15909# vdd.t502 sg13_lv_pmos ad=0.2856p pd=2.36u as=0.1596p ps=1.22u w=0.84u l=0.13u
X837 a_2034_11282# d_dith_en.t25 vdd.t507 vdd.t507 sg13_lv_pmos ad=79.8f pd=0.8u as=1.87952p ps=12.085u w=0.42u l=0.13u
X838 vss.t76 xsc_vfb.t11 a_7804_29739.t8 vss.t70 sg13_lv_nmos ad=95f pd=0.88u as=95f ps=0.88u w=0.5u l=3u
X839 vdd.t197 vss.t2283 vdd.t196 vdd.t153 sg13_lv_pmos ad=0.34p pd=2.68u as=0 ps=0 w=1u l=1u
X840 vdd.t373 vss.t2146 vdd.t428 vdd.t308 sg13_lv_pmos ad=0.34p pd=2.68u as=0 ps=0 w=1u l=1u
X841 a_7224_31505# a_5176_31469# w_9407_29481.t10 vdd.t764 sg13_lv_pmos ad=1.19p pd=7.68u as=0.665p ps=3.88u w=3.5u l=2u
X842 vss.t88 clk_noverlap_0.sg13cmos5l_dlygate4sd3_1_3.X a_7723_7241# vss.t87 sg13_lv_nmos ad=79.8f pd=0.8u as=0.1428p ps=1.52u w=0.42u l=0.13u
X843 xq_dith_v_bq.t2 sg13cmos5l_inv_1_9.Y.t3 a_4362_8188.t4 vdd.t624 sg13_lv_pmos ad=0.665p pd=3.88u as=0.665p ps=3.88u w=3.5u l=0.13u
X844 a_2385_6009# a_2045_5888# a_2034_6262# vdd.t507 sg13_lv_pmos ad=93.45f pd=0.865u as=0.2048p ps=1.63u w=0.42u l=0.13u
X845 vdd.t307 vss.t2190 vdd.t299 vdd.t173 sg13_lv_pmos ad=0.19p pd=1.38u as=0 ps=0 w=1u l=1u
X846 a_24404_4674# dsm2_io_0.do_trim_b[1].t2 bias_gm_0.bias_trim_0.iout vdd.t572 sg13_lv_pmos ad=95f pd=0.88u as=95f ps=0.88u w=0.5u l=5u
X847 d_amp_s_b[3].t1 d_amp_s[3].t4 vdd.t712 vdd.t507 sg13_lv_pmos ad=0.3808p pd=2.92u as=0.3808p ps=2.92u w=1.12u l=0.13u
X848 a_558_12850# d_dith_en.t30 vss.t1086 vss.t1085 sg13_lv_nmos ad=37.8f pd=0.6u as=79.8f ps=0.8u w=0.42u l=0.13u
X849 a_8762_31505# a_5176_31117# vdd.t805 vdd.t764 sg13_lv_pmos ad=0.19p pd=1.38u as=0.34p ps=2.68u w=1u l=2u
X850 quantizer2_lfsr_0.sg13cmos5l_dfrbpq_1_1.Q a_522_15861# vdd.t1144 vdd.t504 sg13_lv_pmos ad=0.3808p pd=2.92u as=0.2128p ps=1.5u w=1.12u l=0.13u
X851 a_1367_1161# a_1324_804# vdd.t634 vdd.t504 sg13_lv_pmos ad=63f pd=0.72u as=0.1563p ps=1.22u w=0.42u l=0.13u
X852 a_1745_1030# d_dith_en.t2 vss.t1062 vss.t1061 sg13_lv_nmos ad=37.8f pd=0.6u as=0.1701p ps=1.65u w=0.42u l=0.13u
X853 vdd.t1425 vdd.t1423 vdd.t1427 vdd.t566 sg13_lv_pmos ad=95f pd=0.88u as=0 ps=0 w=0.5u l=5u
X854 vss.t1758 vdd.t1763 vss.t1757 vss.t1748 sg13_lv_nmos ad=0.1428p pd=1.52u as=0 ps=0 w=0.42u l=1u
X855 vss.t1055 quantizer2_lfsr_0.sg13cmos5l_dfrbpq_1_5.Q a_2074_14933# vss.t664 sg13_lv_nmos ad=0.1898p pd=1.36u as=0.2516p ps=2.16u w=0.74u l=0.13u
X856 a_2461_2313# a_2034_3336# vdd.t1062 vdd.t507 sg13_lv_pmos ad=63f pd=0.72u as=0.1563p ps=1.22u w=0.42u l=0.13u
X857 a_2034_5928# a_2079_4530# vdd.t533 vdd.t507 sg13_lv_pmos ad=0.34p pd=2.68u as=0.36237p ps=2.605u w=1u l=0.13u
X858 a_4362_8188.t3 sg13cmos5l_inv_1_9.Y.t3 xq_dith_v_bq.t0 vdd.t624 sg13_lv_pmos ad=0.665p pd=3.88u as=1.19p ps=7.68u w=3.5u l=0.13u
X859 vdd.t420 vss.t2193 vdd.t419 vdd.t173 sg13_lv_pmos ad=0.34p pd=2.68u as=0 ps=0 w=1u l=1u
X860 vdd.t1150 bias_gm_0.bias_trim_0.vz.t31 a_22252_4074# vdd.t570 sg13_lv_pmos ad=95f pd=0.88u as=95f ps=0.88u w=0.5u l=5u
X861 a_11115_8608# a_13211_8748# vss.t6 rhigh l=10.05u w=0.5u
X862 vdd.t78 vss.t2353 vdd.t61 vdd.t53 sg13_lv_pmos ad=0.19p pd=1.38u as=0 ps=0 w=1u l=1u
X863 vdd.t362 vss.t2152 vdd.t361 vdd.t308 sg13_lv_pmos ad=0.34p pd=2.68u as=0 ps=0 w=1u l=1u
X864 vdd.t533 d_dith_en.t10 a_2070_4262# vdd.t507 sg13_lv_pmos ad=0.36237p pd=2.605u as=79.8f ps=0.8u w=0.42u l=0.13u
X865 vss.t532 vss.t533 vss.t531 rhigh l=2.75u w=0.5u
X866 a_22252_11246# a_19984_17824# vss.t347 vss.t265 sg13_hv_nmos ad=95f pd=0.88u as=95f ps=0.88u w=0.5u l=10u
X867 vdd.t677 sg13cmos5l_inv_2_4.Y a_8768_15909# vdd.t502 sg13_lv_pmos ad=0.2856p pd=2.36u as=0.1596p ps=1.22u w=0.84u l=0.13u
X868 a_16941_5500# d_phi2.t2 vdd.t563 vdd.t526 sg13_lv_pmos ad=0.1596p pd=1.22u as=0.2856p ps=2.36u w=0.84u l=0.13u
X869 vdd.t903 sg13cmos5l_inv_1_13.A.t4 sg13cmos5l_inv_1_13.Y.t1 vdd.t502 sg13_lv_pmos ad=0.3808p pd=2.92u as=0.3808p ps=2.92u w=1.12u l=0.13u
X870 vss.t55 a_2049_4965# a_2045_5888# vss.t54 sg13_lv_nmos ad=2.71757p pd=16.785u as=0.2516p ps=2.16u w=0.74u l=0.13u
X871 vdd.t1502 vdd.t1498 vdd.t1504 vdd.t384 sg13_lv_pmos ad=95f pd=0.88u as=0 ps=0 w=0.5u l=5u
X872 a_10132_15186# d_qi.t3 d_qi_b.t2 vdd.t502 sg13_lv_pmos ad=0.2128p pd=1.5u as=0.2128p ps=1.5u w=1.12u l=0.13u
X873 vdd.t1643 dsm2_osc_0.sg13cmos5l_dfrbp_1_0.Q_N a_23195_985# vdd.t515 sg13_lv_pmos ad=0.1428p pd=1.52u as=79.8f ps=0.8u w=0.42u l=0.13u
X874 vdd.t751 d_dith_en.t33 a_567_13746# vdd.t504 sg13_lv_pmos ad=0.1563p pd=1.22u as=0.147p ps=1.54u w=0.42u l=0.13u
X875 vdd.t285 vss.t2356 vdd.t284 vdd.t53 sg13_lv_pmos ad=0.34p pd=2.68u as=0 ps=0 w=1u l=1u
X876 sw_tgate_10.p.t5 sw_tgate_9.gb.t4 sw_tgate_10.p.t0 vss.t976 sg13_lv_nmos ad=0.34p pd=2.68u as=0 ps=0 w=1u l=1u
X877 a_1443_12633# a_1322_11954# a_1284_13167# vdd.t504 sg13_lv_pmos ad=93.45f pd=0.865u as=0.2048p ps=1.63u w=0.42u l=0.13u
X878 vss.t806 vss.t807 vss.t531 rhigh l=2.75u w=0.5u
X879 sw_tgate_12.m.t6 d_qi.t8 vdd.t1037 vss.t1010 sg13_lv_nmos ad=0.19p pd=1.38u as=0.19p ps=1.38u w=1u l=1u
X880 vdd.t195 vss.t2303 vdd.t111 vdd.t110 sg13_lv_pmos ad=0.34p pd=2.68u as=0 ps=0 w=1u l=1u
X881 vdd.t1435 vdd.t1423 vdd.t1437 vdd.t570 sg13_lv_pmos ad=95f pd=0.88u as=0 ps=0 w=0.5u l=5u
X882 sg13cmos5l_inv_1_2.A.t2 vss.t384 vss.t386 vss.t387 sg13_lv_nmos ad=95f pd=0.88u as=95f ps=0.88u w=0.5u l=0.5u
X883 vss.t846 ibias_200n.t9 vss.t845 vss.t269 sg13_hv_nmos ad=95f pd=0.88u as=0 ps=0 w=0.5u l=10u
X884 a_1367_1349# a_1322_1586# a_1288_778# vdd.t504 sg13_lv_pmos ad=0.1428p pd=1.52u as=79.8f ps=0.8u w=0.42u l=0.13u
X885 w_9407_29481.t11 a_5176_31469# a_7224_31505# vdd.t764 sg13_lv_pmos ad=0.665p pd=3.88u as=1.19p ps=7.68u w=3.5u l=2u
X886 vss.t987 quantizer2_lfsr_0.sg13cmos5l_dfrbpq_1_1.D.t3 a_562_16373# vss.t986 sg13_lv_nmos ad=0.1898p pd=1.36u as=0.2516p ps=2.16u w=0.74u l=0.13u
X887 quantizer2_lfsr_0.sg13cmos5l_dfrbpq_1_2.Q.t0 a_2034_4053# vss.t1145 vss.t1147 sg13_lv_nmos ad=0.2516p pd=2.16u as=0.1406p ps=1.12u w=0.74u l=0.13u
X888 vss.t393 vss.t384 vss.t390 vss.t391 sg13_lv_nmos ad=95f pd=0.88u as=0 ps=0 w=0.5u l=0.5u
X889 bias_gm_0.bias_trim_0.vz.t20 a_19964_18216# vss.t1170 vss.t1169 sg13_hv_nmos ad=1.36p pd=8.68u as=1.36p ps=8.68u w=4u l=0.5u
X890 vss.t450 a_6265_7200# a_6377_7224# vss.t2107 sg13_lv_nmos ad=0.1426p pd=1.16u as=0.1428p ps=1.52u w=0.42u l=0.5u
X891 sg13cmos5l_inv_1_5.Y sg13cmos5l_and2_1_2.X vdd.t752 vdd.t502 sg13_lv_pmos ad=0.3808p pd=2.92u as=0.3808p ps=2.92u w=1.12u l=0.13u
X892 vss.t47 a_1286_14615# a_1322_14546# vss.t46 sg13_lv_nmos ad=2.71757p pd=16.785u as=0.2516p ps=2.16u w=0.74u l=0.13u
X893 sw_tgate_6.p.t8 d_qi.t7 vdd.t1035 vss.t1012 sg13_lv_nmos ad=0.19p pd=1.38u as=0.34p ps=2.68u w=1u l=1u
X894 a_2070_1670# a_2045_3296# a_2079_1938# vdd.t507 sg13_lv_pmos ad=0.1428p pd=1.52u as=79.8f ps=0.8u w=0.42u l=0.13u
X895 vss.t574 clk_noverlap_0.sg13cmos5l_dlygate4sd3_1_0.A.t2 a_4267_7241# vss.t925 sg13_lv_nmos ad=79.8f pd=0.8u as=0.1428p ps=1.52u w=0.42u l=0.13u
X896 vss.t1954 vdd.t1717 vss.t1953 vss.t1952 sg13_lv_nmos ad=0.1428p pd=1.52u as=0 ps=0 w=0.42u l=1u
X897 xsc_xcmfb1_vsw_cm_p.t1 d_phi2.t13 vcm_esd.t2 vss.t187 sg13_lv_nmos ad=95f pd=0.88u as=95f ps=0.88u w=0.5u l=1u
X898 vss.t791 a_1284_15759# a_1284_15861# vss.t790 sg13_lv_nmos ad=0.1406p pd=1.12u as=0.2516p ps=2.16u w=0.74u l=0.13u
X899 a_23289_752# a_22347_812# a_23150_752# vss.t662 sg13_lv_nmos ad=79.8f pd=0.8u as=0.2373p ps=1.97u w=0.42u l=0.13u
X900 a_873_12633# a_533_12512# a_522_12886# vdd.t504 sg13_lv_pmos ad=93.45f pd=0.865u as=0.2048p ps=1.63u w=0.42u l=0.13u
X901 a_8762_31505# a_5176_31469# vo_p.t19 vdd.t764 sg13_lv_pmos ad=0.665p pd=3.88u as=1.19p ps=7.68u w=3.5u l=2u
X902 vss.t850 a_22252_11246# bias_gm_0.bias_trim_0.vz.t18 vss.t267 sg13_hv_nmos ad=95f pd=0.88u as=95f ps=0.88u w=0.5u l=10u
X903 xsc_vc1l_n.t9 sw_tgate_11.gb.t2 xsc_vc1l_n.t8 vss.t604 sg13_lv_nmos ad=0.19p pd=1.38u as=0 ps=0 w=1u l=1u
X904 vss.t239 quantizer2_lfsr_0.sg13cmos5l_dfrbpq_1_0.Q a_2034_1466# vss.t1179 sg13_lv_nmos ad=0.14875p pd=1.16u as=0.187p ps=1.78u w=0.55u l=0.13u
X905 vdd.t826 a_5176_31117# vdd.t824 vdd.t764 sg13_lv_pmos ad=0.19p pd=1.38u as=0 ps=0 w=1u l=2u
X906 vss.t1724 vdd.t1771 vss.t1725 vss.t1721 sg13_lv_nmos ad=79.8f pd=0.8u as=0 ps=0 w=0.42u l=1u
X907 a_1600_6533# a_1322_6770# a_1288_5962# vss.t2104 sg13_lv_nmos ad=0.2373p pd=1.97u as=79.8f ps=0.8u w=0.42u l=0.13u
X908 vdd.t18 vss.t2376 vdd.t17 vdd.t10 sg13_lv_pmos ad=0.19p pd=1.38u as=0 ps=0 w=1u l=1u
X909 vdd.t729 bias_gm_0.bias_trim_0.vz.t51 a_22252_11246# vdd.t573 sg13_lv_pmos ad=95f pd=0.88u as=95f ps=0.88u w=0.5u l=5u
X910 vdd.t1362 vdd.t1360 vdd.t1288 vdd.t566 sg13_lv_pmos ad=95f pd=0.88u as=0 ps=0 w=0.5u l=5u
X911 a_11293_11104.t5 sg13cmos5l_and2_2_1.X.t3 vdd.t960 vdd.t863 sg13_lv_pmos ad=0.285p pd=1.88u as=0.285p ps=1.88u w=1.5u l=0.5u
X912 vss.t1688 vdd.t1780 vss.t1687 vss.t1686 sg13_lv_nmos ad=0.1428p pd=1.52u as=0 ps=0 w=0.42u l=1u
X913 sg13cmos5l_inv_1_4.A.t1 sg13cmos5l_inv_1_8.Y vdd.t1199 vdd.t502 sg13_lv_pmos ad=0.2128p pd=1.5u as=0.3808p ps=2.92u w=1.12u l=0.13u
X914 a_1600_14309# a_1322_14546# a_1288_13738# vss.t805 sg13_lv_nmos ad=0.2373p pd=1.97u as=79.8f ps=0.8u w=0.42u l=0.13u
X915 a_9357_11104.t9 xq_vg_q_2_.t3 a_9533_11104.t7 vss.t30 sg13_lv_nmos ad=0.285p pd=1.88u as=0.285p ps=1.88u w=1.5u l=0.5u
X916 vdd.t594 a_7993_7200# a_8105_7224# vdd.t308 sg13_lv_pmos ad=0.2254p pd=1.53u as=0.34p ps=2.68u w=1u l=0.5u
X917 vdd.t926 bias_gm_0.bias_trim_0.vz.t50 a_19984_17824# vdd.t384 sg13_lv_pmos ad=95f pd=0.88u as=95f ps=0.88u w=0.5u l=5u
X918 vdd.t163 vss.t2234 vdd.t162 vdd.t85 sg13_lv_pmos ad=0.19p pd=1.38u as=0 ps=0 w=1u l=1u
X919 vss.t1960 vdd.t1716 vss.t1958 vss.t1945 sg13_lv_nmos ad=79.8f pd=0.8u as=0 ps=0 w=0.42u l=1u
X920 vss.t783 a_5176_30111# vss.t784 vss.t753 sg13_lv_nmos ad=95f pd=0.88u as=0 ps=0 w=0.5u l=3u
X921 a_24258_22280# a_28126_22140# vss.t34 rhigh l=17.5u w=0.5u
X922 dsm2_osc_0.ibias_in.t5 a_21252_3394# bias_gm_0.bias_trim_0.iout vdd.t287 sg13_lv_pmos ad=95f pd=0.88u as=95f ps=0.88u w=0.5u l=5u
X923 vss.t1602 vdd.t1801 vss.t1601 vss.t1600 sg13_lv_nmos ad=0.1428p pd=1.52u as=0 ps=0 w=0.42u l=1u
X924 vss.t1879 vdd.t1734 vss.t1878 vss.t1877 sg13_lv_nmos ad=0.1428p pd=1.52u as=0 ps=0 w=0.42u l=1u
X925 vss.t156 dsm2_osc_0.sg13cmos5l_inv_1_2.Y do_clk_osc.t0 vss.t155 sg13_lv_nmos ad=0.2516p pd=2.16u as=0.1406p ps=1.12u w=0.74u l=0.13u
X926 a_19984_17824# a_19984_17824# a_20260_17236# vss.t265 sg13_lv_nmos ad=95f pd=0.88u as=95f ps=0.88u w=0.5u l=10u
X927 dsm2_osc_0.d_btest_or.t0 a_22836_1332# vss.t258 vss.t257 sg13_lv_nmos ad=0.2516p pd=2.16u as=0.1469p ps=1.155u w=0.74u l=0.13u
X928 vdd.t492 vss.t2237 vdd.t164 vdd.t85 sg13_lv_pmos ad=0.34p pd=2.68u as=0 ps=0 w=1u l=1u
X929 vss.t1638 vdd.t1793 vss.t1636 vss.t1637 sg13_lv_nmos ad=79.8f pd=0.8u as=0 ps=0 w=0.42u l=1u
X930 vi_esd.t4 sw_tgate_11.gb.t4 xsc_vc1l_p.t11 vdd.t561 sg13_lv_pmos ad=0.38p pd=2.38u as=0.38p ps=2.38u w=2u l=1u
X931 a_20672_21580# a_24258_21720# vss.t207 rhigh l=17.5u w=0.5u
X932 dsm2_osc_0.sg13cmos5l_dfrbp_1_0.RESET_B.t0 dsm2_osc_0.dsm2_io_rx_0.di_b.t3 vss.t538 vss.t537 sg13_lv_nmos ad=0.2516p pd=2.16u as=0.2516p ps=2.16u w=0.74u l=0.13u
X933 a_2083_12550# d_dith_en.t28 vss.t1095 vss.t949 sg13_lv_nmos ad=37.8f pd=0.6u as=0.1701p ps=1.65u w=0.42u l=0.13u
X934 a_567_5970# a_537_6405# a_558_5702# vss.t572 sg13_lv_nmos ad=79.8f pd=0.8u as=0.1296p ps=1.52u w=0.42u l=0.13u
X935 a_5892_8400.t12 sg13cmos5l_inv_1_4.Y.t2 xq_vg_p_1_.t1 vss.t979 sg13_lv_nmos ad=0.17p pd=1.68u as=95f ps=0.88u w=0.5u l=0.13u
X936 vdd.t309 vss.t2150 vdd.t423 vdd.t308 sg13_lv_pmos ad=0.34p pd=2.68u as=0 ps=0 w=1u l=1u
X937 vdd.t1370 vdd.t1360 vdd.t1174 vdd.t570 sg13_lv_pmos ad=95f pd=0.88u as=0 ps=0 w=0.5u l=5u
X938 a_537_8997# d_qclk.t13 vss.t143 vss.t1404 sg13_lv_nmos ad=0.2516p pd=2.16u as=3.67165p ps=23.42u w=0.74u l=0.13u
X939 vss.t14 a_522_5110# a_522_5493# vss.t13 sg13_lv_nmos ad=0.1406p pd=1.12u as=0.2516p ps=2.16u w=0.74u l=0.13u
X940 vdd.t650 a_1284_5391# a_1284_5493# vdd.t504 sg13_lv_pmos ad=0.2128p pd=1.5u as=0.3864p ps=2.93u w=1.12u l=0.13u
X941 vdd.t930 vdd.t1416 vdd.t1417 vdd.t1173 sg13_lv_pmos ad=95f pd=0.88u as=0 ps=0 w=0.5u l=5u
X942 a_1324_11172# a_1288_11146# vss.t874 vss.t873 sg13_lv_nmos ad=0.2516p pd=2.16u as=0.1626p ps=1.415u w=0.74u l=0.13u
X943 a_20260_17236# vss.t345 a_20260_17236# vss.t269 sg13_lv_nmos ad=95f pd=0.88u as=2.14p ps=21.52u w=0.5u l=10u
X944 a_22252_4074# bias_gm_0.bias_trim_0.vz.t34 vdd.t1167 vdd.t566 sg13_lv_pmos ad=95f pd=0.88u as=95f ps=0.88u w=0.5u l=5u
X945 vss.t916 sg13cmos5l_inv_1_13.A.t4 sg13cmos5l_inv_1_13.Y.t0 vss.t915 sg13_lv_nmos ad=0.2516p pd=2.16u as=0.2516p ps=2.16u w=0.74u l=0.13u
X946 quantizer2_lfsr_0.sg13cmos5l_dfrbpq_1_0.D.t1 quantizer2_lfsr_0.sg13cmos5l_dfrbpq_1_6.Q a_2368_15027# vdd.t507 sg13_lv_pmos ad=0.2408p pd=1.55u as=0.1428p ps=1.375u w=1.12u l=0.13u
X947 a_11786_6736# clk_noverlap_0.sg13cmos5l_inv_1_11.Y a_11672_6736# vdd.t308 sg13_lv_pmos ad=0.2128p pd=1.5u as=0.2464p ps=1.56u w=1.12u l=0.13u
X948 vdd.t1156 bias_gm_0.bias_trim_0.vz.t37 a_22252_8246# vdd.t573 sg13_lv_pmos ad=95f pd=0.88u as=95f ps=0.88u w=0.5u l=5u
X949 a_2116_14747# quantizer2_lfsr_0.sg13cmos5l_dfrbpq_1_5.Q vss.t1284 vss.t1056 sg13_lv_nmos ad=78.39999f pd=0.885u as=0.2272p ps=1.99u w=0.64u l=0.13u
X950 vdd.t1150 vdd.t1550 vdd.t1551 vdd.t1173 sg13_lv_pmos ad=95f pd=0.88u as=0 ps=0 w=0.5u l=5u
X951 vdd.t848 a_5176_31117# vdd.t846 vdd.t764 sg13_lv_pmos ad=0.465p pd=1.93u as=0 ps=0 w=1u l=2u
X952 vo_p.t3 vss.t291 vo_p.t2 vss.t292 sg13_lv_nmos ad=0.17p pd=1.68u as=0 ps=0 w=0.5u l=1u
X953 a_6817_30111# d_ena.t12 vss.t1255 vss.t1431 sg13_lv_nmos ad=0.17p pd=1.68u as=95f ps=0.88u w=0.5u l=3u
X954 a_2049_2373# d_qclk.t5 vdd.t507 vdd.t507 sg13_lv_pmos ad=0.4088p pd=2.97u as=1.87952p ps=12.085u w=1.12u l=0.13u
X955 vdd.t168 vss.t2320 vdd.t72 vdd.t71 sg13_lv_pmos ad=0.19p pd=1.38u as=0 ps=0 w=1u l=1u
X956 vo_n.t17 sg13cmos5l_inv_1_3.Y.t2 xq_dith_v_bp.t13 vdd.t623 sg13_lv_pmos ad=0.665p pd=3.88u as=0.665p ps=3.88u w=3.5u l=0.13u
X957 vdd.t834 a_5176_31117# vdd.t832 vdd.t764 sg13_lv_pmos ad=0.465p pd=1.93u as=0 ps=0 w=1u l=2u
X958 vdd.t388 vss.t2308 vdd.t495 vdd.t386 sg13_lv_pmos ad=0.19p pd=1.38u as=0 ps=0 w=1u l=1u
X959 a_522_9960# a_533_9920# a_522_10294# vss.t843 sg13_lv_nmos ad=0.3473p pd=2.71u as=0.12665p ps=1.145u w=0.74u l=0.13u
X960 vdd.t739 a_1284_10575# a_1284_10677# vdd.t504 sg13_lv_pmos ad=0.2128p pd=1.5u as=0.3864p ps=2.93u w=1.12u l=0.13u
X961 a_14266_14856# sg13cmos5l_inv_1_0.Y vss.t811 vss.t810 sg13_lv_nmos ad=0.1428p pd=1.52u as=79.8f ps=0.8u w=0.42u l=0.13u
X962 vdd.t1480 vdd.t1478 vdd.t984 vdd.t1287 sg13_lv_pmos ad=0.17p pd=1.68u as=0 ps=0 w=0.5u l=5u
X963 a_1324_8580# a_1322_9362# a_1284_10575# vss.t602 sg13_lv_nmos ad=0.3473p pd=2.71u as=0.12665p ps=1.145u w=0.74u l=0.13u
X964 sw_tgate_10.p.t1 d_phi2.t7 xsc_vc1l_p.t7 vss.t199 sg13_lv_nmos ad=0.34p pd=2.68u as=0.19p ps=1.38u w=1u l=1u
X965 a_571_13990# d_dith_en.t33 vss.t1072 vss.t1071 sg13_lv_nmos ad=37.8f pd=0.6u as=0.1701p ps=1.65u w=0.42u l=0.13u
X966 vo_n.t19 a_5176_31469# a_9348_31505# vdd.t764 sg13_lv_pmos ad=1.19p pd=7.68u as=0.665p ps=3.88u w=3.5u l=2u
X967 sg13cmos5l_inv_1_5.Y sg13cmos5l_and2_1_2.X vss.t734 vss.t733 sg13_lv_nmos ad=0.2516p pd=2.16u as=0.2516p ps=2.16u w=0.74u l=0.13u
X968 a_1284_16630# quantizer2_lfsr_0.sg13cmos5l_dfrbpq_1_13.D.t3 vdd.t924 vdd.t504 sg13_lv_pmos ad=0.1596p pd=1.22u as=0.4536p ps=2.76u w=0.84u l=0.13u
X969 vdd.t662 sg13cmos5l_inv_1_12.Y do_q_b.t0 vdd.t502 sg13_lv_pmos ad=0.3808p pd=2.92u as=0.2128p ps=1.5u w=1.12u l=0.13u
X970 xq_dith_v_bp.t12 sg13cmos5l_inv_1_3.Y.t2 vo_n.t15 vdd.t623 sg13_lv_pmos ad=0.665p pd=3.88u as=0.665p ps=3.88u w=3.5u l=0.13u
X971 vcm_esd.t9 sw_tgate_11.gb.t5 xsc_vc1r_n.t5 vdd.t556 sg13_lv_pmos ad=0.38p pd=2.38u as=0.38p ps=2.38u w=2u l=1u
X972 vss.t1700 vdd.t1777 vss.t1701 vss.t1697 sg13_lv_nmos ad=79.8f pd=0.8u as=0 ps=0 w=0.42u l=1u
X973 a_6452_29739.t8 xsc_vfb.t11 vss.t76 vss.t72 sg13_lv_nmos ad=95f pd=0.88u as=95f ps=0.88u w=0.5u l=3u
X974 vss.t1630 vdd.t1795 vss.t1628 vss.t1620 sg13_lv_nmos ad=79.8f pd=0.8u as=0 ps=0 w=0.42u l=1u
X975 a_2070_14002# d_dith_en.t31 vss.t1090 vss.t1089 sg13_lv_nmos ad=37.8f pd=0.6u as=79.8f ps=0.8u w=0.42u l=0.13u
X976 vss.t1598 vdd.t1802 vss.t1599 vss.t1591 sg13_lv_nmos ad=79.8f pd=0.8u as=0 ps=0 w=0.42u l=1u
X977 xsc_vfb.t10 vdd.t1308 xsc_vfb.t5 vdd.t560 sg13_lv_pmos ad=0.285p pd=1.88u as=0 ps=0 w=1.5u l=1u
X978 vdd.t755 inv_en_0.di inv_en_0.di_b.t1 vdd.t753 sg13_hv_pmos ad=0.51p pd=3.68u as=0.285p ps=1.88u w=1.5u l=0.45u
X979 a_28746_16046# a_19964_18216# a_26670_16046# vdd.t1128 sg13_lv_pmos ad=0.17p pd=1.68u as=95f ps=0.88u w=0.5u l=10u
X980 vdd.t1248 a_1284_16630# quantizer2_lfsr_0.sg13cmos5l_dfrbpq_1_2.D.t0 vdd.t504 sg13_lv_pmos ad=0.3808p pd=2.92u as=0.2408p ps=1.55u w=1.12u l=0.13u
X981 vdd.t235 vss.t2291 vdd.t103 vdd.t102 sg13_lv_pmos ad=0.34p pd=2.68u as=0 ps=0 w=1u l=1u
X982 a_8013_14934# sg13cmos5l_and2_1_5.A.t4 vdd.t868 vdd.t502 sg13_lv_pmos ad=0.1596p pd=1.22u as=0.2856p ps=2.36u w=0.84u l=0.13u
X983 vdd.t330 vss.t2156 vdd.t329 vdd.t308 sg13_lv_pmos ad=0.34p pd=2.68u as=0 ps=0 w=1u l=1u
X984 quantizer2_lfsr_0.sg13cmos5l_dfrbpq_1_0.Q a_522_2901# vss.t235 vss.t234 sg13_lv_nmos ad=0.2516p pd=2.16u as=0.1406p ps=1.12u w=0.74u l=0.13u
X985 vss.t581 a_13569_7467# clk_noverlap_0.sg13cmos5l_dlygate4sd3_1_7.X vss.t580 sg13_lv_nmos ad=0.1426p pd=1.16u as=0.2516p ps=2.16u w=0.74u l=0.13u
X986 vdd.t1336 vdd.t1309 sg13cmos5l_inv_1_2.A.t9 vdd.t863 sg13_lv_pmos ad=0.285p pd=1.88u as=0.285p ps=1.88u w=1.5u l=0.5u
X987 quantizer2_lfsr_0.sg13cmos5l_dfrbpq_1_11.Q.t1 a_1284_2901# vdd.t598 vdd.t504 sg13_lv_pmos ad=0.3808p pd=2.92u as=0.2128p ps=1.5u w=1.12u l=0.13u
X988 a_26670_15446# a_19964_18216# a_24602_15146# vdd.t1127 sg13_lv_pmos ad=95f pd=0.88u as=0.17p ps=1.68u w=0.5u l=10u
X989 vo_p.t8 a_5176_30111# a_6452_29739.t1 vss.t745 sg13_lv_nmos ad=95f pd=0.88u as=95f ps=0.88u w=0.5u l=3u
X990 vss.t1796 vdd.t1754 vss.t1795 vss.t1794 sg13_lv_nmos ad=0.1428p pd=1.52u as=0 ps=0 w=0.42u l=1u
X991 vss.t877 sg13cmos5l_inv_1_19.Y.t5 xq_vg_q_2_.t2 vss.t462 sg13_lv_nmos ad=0.17p pd=1.68u as=0.17p ps=1.68u w=0.5u l=0.13u
X992 xsc_xcmfb1_vsw_cm_p.t10 sw_tgate_cmfb2_3.gb.t4 vo_p.t5 vdd.t900 sg13_lv_pmos ad=0.285p pd=1.88u as=0.285p ps=1.88u w=1.5u l=1u
X993 vss.t2088 vss.t2089 vss.t531 rhigh l=2.75u w=0.5u
X994 vss.t103 sw_tgate_cmfb2_1.p.t10 vss.t101 vss.t102 sg13_lv_nmos ad=95f pd=0.88u as=0 ps=0 w=0.5u l=3u
X995 vdd.t1587 vdd.t1585 vdd.t732 vdd.t1287 sg13_lv_pmos ad=0.17p pd=1.68u as=0 ps=0 w=0.5u l=5u
X996 a_15130_14856# sg13cmos5l_and2_1_5.A.t2 vdd.t862 vdd.t502 sg13_lv_pmos ad=0.1428p pd=1.52u as=0.1523p ps=1.38u w=0.42u l=0.13u
X997 vss.t1733 vdd.t1769 vss.t1732 vss.t1731 sg13_lv_nmos ad=0.1428p pd=1.52u as=0 ps=0 w=0.42u l=1u
X998 vi_esd.t8 vi vss.t1422 rppd l=2u w=1u
X999 vss.t2131 vss.t2132 vss.t39 rhigh l=2.75u w=0.5u
X1000 a_22252_7946# bias_gm_0.bias_trim_0.vz.t36 vdd.t989 vdd.t566 sg13_lv_pmos ad=95f pd=0.88u as=95f ps=0.88u w=0.5u l=5u
X1001 sg13cmos5l_inv_1_2.A.t3 sg13cmos5l_and2_2_1.X.t4 vdd.t968 vdd.t863 sg13_lv_pmos ad=0.285p pd=1.88u as=0.285p ps=1.88u w=1.5u l=0.5u
X1002 vss.t1425 d_ena.t14 vss.t1424 vss.t1423 sg13_hv_nmos ad=0.34p pd=2.68u as=0 ps=0 w=1u l=5u
X1003 vss.t2054 vdd.t1696 vss.t2053 vss.t2052 sg13_lv_nmos ad=0.1428p pd=1.52u as=0 ps=0 w=0.42u l=1u
X1004 vss.t2072 vss.t2073 vss.t39 rhigh l=2.75u w=0.5u
X1005 vdd.t1 vss.t2397 vdd.t1651 vdd.t0 sg13_lv_pmos ad=0.34p pd=2.68u as=0 ps=0 w=1u l=1u
X1006 d_amp_s_b[1].t0 d_amp_s[1].t4 vdd.t1235 vdd.t504 sg13_lv_pmos ad=0.3808p pd=2.92u as=0.3808p ps=2.92u w=1.12u l=0.13u
X1007 a_2083_7428# a_2045_8480# a_2079_7122# vss.t225 sg13_lv_nmos ad=0.2373p pd=1.97u as=79.8f ps=0.8u w=0.42u l=0.13u
X1008 a_8661_8468# a_10757_8608# vss.t2101 rhigh l=10.05u w=0.5u
X1009 a_20260_17236# vss.t358 a_20260_17236# vss.t262 sg13_lv_nmos ad=0.17p pd=1.68u as=0 ps=0 w=0.5u l=10u
X1010 xsc_vfb.t7 vdd.t1307 xsc_vfb.t9 vdd.t560 sg13_lv_pmos ad=0.51p pd=3.68u as=0 ps=0 w=1.5u l=1u
X1011 vdd.t884 sg13cmos5l_or2_1_0.X.t4 sg13cmos5l_inv_1_9.Y.t1 vdd.t502 sg13_lv_pmos ad=0.3808p pd=2.92u as=0.3808p ps=2.92u w=1.12u l=0.13u
X1012 vss.t1611 vdd.t1799 vss.t1610 vss.t1600 sg13_lv_nmos ad=0.1428p pd=1.52u as=0 ps=0 w=0.42u l=1u
X1013 vdd.t101 vss.t2242 vdd.t152 vdd.t85 sg13_lv_pmos ad=0.19p pd=1.38u as=0 ps=0 w=1u l=1u
X1014 vdd.t557 d_phi2.t14 sw_tgate_cmfb2_1.gb.t1 vdd.t556 sg13_lv_pmos ad=0.68p pd=4.68u as=0.68p ps=4.68u w=2u l=0.13u
X1015 vo_n.t6 sw_tgate_cmfb2_3.gb.t3 vo_n.t3 vss.t595 sg13_lv_nmos ad=95f pd=0.88u as=0 ps=0 w=0.5u l=1u
X1016 vss.t1054 a_2034_3506# a_2070_3438# vss.t1053 sg13_lv_nmos ad=79.8f pd=0.8u as=0.1428p ps=1.52u w=0.42u l=0.13u
X1017 vdd.t224 vss.t2219 vdd.t223 vdd.t222 sg13_lv_pmos ad=0.34p pd=2.68u as=0 ps=0 w=1u l=1u
X1018 vdd.t55 vss.t2351 vdd.t54 vdd.t53 sg13_lv_pmos ad=0.19p pd=1.38u as=0 ps=0 w=1u l=1u
X1019 vss.t1590 vdd.t1804 vss.t1592 vss.t1591 sg13_lv_nmos ad=79.8f pd=0.8u as=0 ps=0 w=0.42u l=1u
X1020 a_2034_13874# d_dith_en.t31 vdd.t507 vdd.t507 sg13_lv_pmos ad=79.8f pd=0.8u as=1.87952p ps=12.085u w=0.42u l=0.13u
X1021 vdd.t832 a_5176_31117# vdd.t830 vdd.t764 sg13_lv_pmos ad=0.19p pd=1.38u as=0 ps=0 w=1u l=2u
X1022 vss.t448 a_21452_2308.t4 vss.t1182 vss.t1181 sg13_lv_nmos ad=95f pd=0.88u as=0 ps=0 w=0.5u l=0.5u
X1023 vdd.t1168 bias_gm_0.bias_trim_0.vz.t34 a_22252_4074# vdd.t384 sg13_lv_pmos ad=95f pd=0.88u as=95f ps=0.88u w=0.5u l=5u
X1024 vdd.t616 a_12705_7467# clk_noverlap_0.sg13cmos5l_dlygate4sd3_1_8.X vdd.t308 sg13_lv_pmos ad=0.2254p pd=1.53u as=0.4256p ps=3u w=1.12u l=0.13u
X1025 vdd.t228 vss.t2226 vdd.t227 vdd.t159 sg13_lv_pmos ad=0.19p pd=1.38u as=0 ps=0 w=1u l=1u
X1026 a_22252_8246# bias_gm_0.bias_trim_0.vz.t37 vdd.t1156 vdd.t287 sg13_lv_pmos ad=95f pd=0.88u as=95f ps=0.88u w=0.5u l=5u
X1027 xsc_vc1r_n.t1 d_phi2.t9 xsc_vvg_p.t2 vss.t194 sg13_lv_nmos ad=0.19p pd=1.38u as=0.19p ps=1.38u w=1u l=1u
X1028 a_19984_17824# bias_gm_0.bias_trim_0.vz.t52 vdd.t1019 vdd.t572 sg13_lv_pmos ad=95f pd=0.88u as=95f ps=0.88u w=0.5u l=5u
X1029 vdd.t1686 vss.t2412 vdd.t1685 vdd.t0 sg13_lv_pmos ad=0.19p pd=1.38u as=0 ps=0 w=1u l=1u
X1030 xsc_xcmfb1_vsw_cm_p.t8 sw_tgate_cmfb2_3.gb.t4 xsc_xcmfb1_vsw_cm_p.t9 vss.t1222 sg13_lv_nmos ad=95f pd=0.88u as=0 ps=0 w=0.5u l=1u
X1031 a_21830_2578# a_21554_2798# vdd.t642 vdd.t514 sg13_lv_pmos ad=0.17p pd=1.68u as=95f ps=0.88u w=0.5u l=0.5u
X1032 vss.t158 a_20447_636# a_20884_598# vss.t157 sg13_lv_nmos ad=0.148p pd=1.14u as=0.3367p ps=1.65u w=0.74u l=0.13u
X1033 a_13965_7164# clk_noverlap_0.sg13cmos5l_dlygate4sd3_1_7.A vdd.t717 vdd.t308 sg13_lv_pmos ad=0.1428p pd=1.52u as=0.1523p ps=1.38u w=0.42u l=0.13u
X1034 a_7804_29739.t8 xsc_vfb.t11 vss.t75 vss.t68 sg13_lv_nmos ad=95f pd=0.88u as=95f ps=0.88u w=0.5u l=3u
X1035 sg13cmos5l_inv_1_15.Y d_dith[2].t3 vss.t2096 vss.t0 sg13_lv_nmos ad=0.2516p pd=2.16u as=0.2516p ps=2.16u w=0.74u l=0.13u
X1036 vss.t1871 vdd.t1736 vss.t1869 vss.t1870 sg13_lv_nmos ad=79.8f pd=0.8u as=0 ps=0 w=0.42u l=1u
X1037 a_522_2518# a_537_1221# a_558_2286# vss.t487 sg13_lv_nmos ad=0.12665p pd=1.145u as=0.1428p ps=1.52u w=0.42u l=0.13u
X1038 vdd.t281 vss.t2229 vdd.t280 vdd.t159 sg13_lv_pmos ad=0.34p pd=2.68u as=0 ps=0 w=1u l=1u
X1039 a_1367_3753# a_1324_3396# vdd.t512 vdd.t504 sg13_lv_pmos ad=63f pd=0.72u as=0.1563p ps=1.22u w=0.42u l=0.13u
X1040 sg13cmos5l_nor2_2_2.A sg13cmos5l_nand2_2_0.B.t2 vdd.t875 vdd.t502 sg13_lv_pmos ad=0.2128p pd=1.5u as=0.4032p ps=2.96u w=1.12u l=0.13u
X1041 sg13cmos5l_inv_2_5.Y sg13cmos5l_inv_2_5.A vss.t1151 vss.t1150 sg13_lv_nmos ad=0.1406p pd=1.12u as=0.2516p ps=2.16u w=0.74u l=0.13u
X1042 sg13cmos5l_inv_1_14.A.t1 vss.t384 vss.t404 vss.t405 sg13_lv_nmos ad=95f pd=0.88u as=95f ps=0.88u w=0.5u l=0.5u
X1043 vss.t1042 sg13cmos5l_nor2_2_2.A d_qi.t2 vss.t1207 sg13_lv_nmos ad=0.1406p pd=1.12u as=0.1406p ps=1.12u w=0.74u l=0.13u
X1044 a_2461_4905# a_2034_5928# vdd.t710 vdd.t507 sg13_lv_pmos ad=63f pd=0.72u as=0.1563p ps=1.22u w=0.42u l=0.13u
X1045 a_7993_7200# a_7723_7241# vdd.t531 vdd.t308 sg13_lv_pmos ad=0.34p pd=2.68u as=0.1523p ps=1.38u w=1u l=0.5u
X1046 vdd.t511 a_1284_10575# a_1407_10130# vdd.t504 sg13_lv_pmos ad=1.21587p pd=7.58u as=79.8f ps=0.8u w=0.42u l=0.13u
X1047 xsc_vc1r_n.t3 d_phi2.t9 xsc_vc1r_n.t2 vdd.t556 sg13_lv_pmos ad=0.38p pd=2.38u as=0 ps=0 w=2u l=1u
X1048 vss.t322 vss.t314 vss.t321 vss.t276 sg13_hv_nmos ad=1.9p pd=10.38u as=0 ps=0 w=10u l=1u
X1049 vdd.t1598 vdd.t1590 vdd.t1600 vdd.t573 sg13_lv_pmos ad=95f pd=0.88u as=0 ps=0 w=0.5u l=5u
X1050 a_558_5796# quantizer2_lfsr_0.sg13cmos5l_dfrbpq_1_9.D a_558_5702# vss.t659 sg13_lv_nmos ad=60.89999f pd=0.71u as=0.1428p ps=1.52u w=0.42u l=0.13u
X1051 xq_dith_v_bq.t5 sg13cmos5l_inv_1_3.Y.t3 vo_p.t10 vdd.t624 sg13_lv_pmos ad=0.665p pd=3.88u as=0.665p ps=3.88u w=3.5u l=0.13u
X1052 vdd.t1137 dsm2_io_vcmg_0.di_phi1_b d_phi1.t1 vdd.t308 sg13_lv_pmos ad=0.3808p pd=2.92u as=0.3808p ps=2.92u w=1.12u l=0.13u
X1053 vdd.t1351 vdd.t1346 vdd.t1353 vdd.t863 sg13_lv_pmos ad=0.285p pd=1.88u as=0 ps=0 w=1.5u l=0.5u
X1054 a_571_1030# d_dith_en.t3 vss.t1122 vss.t1121 sg13_lv_nmos ad=37.8f pd=0.6u as=0.1701p ps=1.65u w=0.42u l=0.13u
X1055 vdd.t1148 dsm2_io_0.sg13cmos5l_inv_1_3.A quantizer2_lfsr_0.di_dith_amp[1].t1 vdd.t617 sg13_lv_pmos ad=0.3808p pd=2.92u as=0.3808p ps=2.92u w=1.12u l=0.13u
X1056 vdd.t341 vss.t2171 vdd.t340 vdd.t339 sg13_lv_pmos ad=0.34p pd=2.68u as=0 ps=0 w=1u l=1u
X1057 quantizer2_lfsr_0.sg13cmos5l_nor2_1_0.A quantizer2_lfsr_0.di_dith_amp[1].t2 vss.t1241 vss.t664 sg13_lv_nmos ad=0.2516p pd=2.16u as=0.2516p ps=2.16u w=0.74u l=0.13u
X1058 vss.t1790 vdd.t1756 vss.t1788 vss.t1780 sg13_lv_nmos ad=79.8f pd=0.8u as=0 ps=0 w=0.42u l=1u
X1059 vdd.t119 vss.t2319 vdd.t151 vdd.t71 sg13_lv_pmos ad=0.34p pd=2.68u as=0 ps=0 w=1u l=1u
X1060 vdd.t1040 d_qi.t8 vdd.t1039 vdd.t561 sg13_lv_pmos ad=0.38p pd=2.38u as=0 ps=0 w=2u l=1u
X1061 a_23195_985# a_22499_864# a_23289_752# vss.t641 sg13_lv_nmos ad=0.1296p pd=1.52u as=79.8f ps=0.8u w=0.42u l=0.13u
X1062 vdd.t511 a_522_10294# a_522_10130# vdd.t504 sg13_lv_pmos ad=1.21587p pd=7.58u as=79.8f ps=0.8u w=0.42u l=0.13u
X1063 a_20672_20180# a_24258_20040# vss.t207 rhigh l=17.5u w=0.5u
X1064 vss.t316 vss.t314 vss.t315 vss.t276 sg13_hv_nmos ad=1.9p pd=10.38u as=0 ps=0 w=10u l=1u
X1065 bias_gm_0.bias_trim_0.iout dsm2_io_0.do_trim_b[0].t2 a_23328_5574# vdd.t572 sg13_lv_pmos ad=95f pd=0.88u as=95f ps=0.88u w=0.5u l=5u
X1066 vdd.t26 vss.t2373 vdd.t28 vdd.t25 sg13_hv_pmos ad=0.19p pd=1.38u as=0 ps=0 w=1u l=5u
X1067 a_1367_3941# a_1322_4178# a_1288_3370# vdd.t504 sg13_lv_pmos ad=0.1428p pd=1.52u as=79.8f ps=0.8u w=0.42u l=0.13u
X1068 quantizer2_lfsr_0.sg13cmos5l_dfrbpq_1_3.Q a_2034_6645# vss.t10 vss.t9 sg13_lv_nmos ad=0.2516p pd=2.16u as=0.1406p ps=1.12u w=0.74u l=0.13u
X1069 vdd.t880 sg13cmos5l_inv_1_0.A sg13cmos5l_inv_1_0.Y vdd.t502 sg13_lv_pmos ad=0.3808p pd=2.92u as=0.3808p ps=2.92u w=1.12u l=0.13u
X1070 vdd.t64 vss.t2301 vdd.t463 vdd.t62 sg13_lv_pmos ad=0.34p pd=2.68u as=0 ps=0 w=1u l=1u
X1071 vss.t1624 vdd.t1796 vss.t1626 vss.t1625 sg13_lv_nmos ad=79.8f pd=0.8u as=0 ps=0 w=0.42u l=1u
X1072 vo_p.t13 d_phi1.t12 vo_p.t12 vdd.t900 sg13_lv_pmos ad=0.285p pd=1.88u as=0 ps=0 w=1.5u l=1u
X1073 a_10483_7459# clk_noverlap_0.sg13cmos5l_inv_1_5.Y vdd.t630 vdd.t308 sg13_lv_pmos ad=0.1596p pd=1.22u as=0.1918p ps=1.5u w=0.84u l=0.13u
X1074 vdd.t945 sg13cmos5l_nand2_1_5.A.t6 sg13cmos5l_inv_1_4.A.t1 vdd.t502 sg13_lv_pmos ad=0.3808p pd=2.92u as=0.2128p ps=1.5u w=1.12u l=0.13u
X1075 vss.t266 vss.t261 vss.t268 vss.t267 sg13_hv_nmos ad=0.19p pd=1.38u as=0 ps=0 w=1u l=10u
X1076 a_7804_29739.t6 xsc_vfb.t12 vss.t1316 vss.t104 sg13_lv_nmos ad=95f pd=0.88u as=95f ps=0.88u w=0.5u l=3u
X1077 a_2034_6262# a_2049_4965# a_2070_6030# vss.t53 sg13_lv_nmos ad=0.12665p pd=1.145u as=0.1428p ps=1.52u w=0.42u l=0.13u
X1078 vdd.t990 bias_gm_0.bias_trim_0.vz.t36 a_22252_7946# vdd.t384 sg13_lv_pmos ad=95f pd=0.88u as=95f ps=0.88u w=0.5u l=5u
X1079 vdd.t511 a_537_11589# a_533_12512# vdd.t504 sg13_lv_pmos ad=1.21587p pd=7.58u as=0.3864p ps=2.93u w=1.12u l=0.13u
X1080 vss.t869 sg13cmos5l_or2_1_0.X.t4 sg13cmos5l_inv_1_9.Y.t0 vss.t868 sg13_lv_nmos ad=0.2516p pd=2.16u as=0.2516p ps=2.16u w=0.74u l=0.13u
X1081 vss.t1805 vdd.t1752 vss.t1804 vss.t1794 sg13_lv_nmos ad=0.1428p pd=1.52u as=0 ps=0 w=0.42u l=1u
X1082 vss.t1924 vdd.t1724 vss.t1922 vss.t1923 sg13_lv_nmos ad=79.8f pd=0.8u as=0 ps=0 w=0.42u l=1u
X1083 vdd.t332 vss.t2256 vdd.t129 vdd.t95 sg13_lv_pmos ad=0.19p pd=1.38u as=0 ps=0 w=1u l=1u
X1084 a_4537_7200# a_4267_7241# vdd.t665 vdd.t308 sg13_lv_pmos ad=0.34p pd=2.68u as=0.1523p ps=1.38u w=1u l=0.5u
X1085 vdd.t1523 vdd.t1515 vdd.t1525 vdd.t573 sg13_lv_pmos ad=95f pd=0.88u as=0 ps=0 w=0.5u l=5u
X1086 xq_dith_v_bq.t9 sg13cmos5l_or2_1_0.X.t3 a_4362_8188.t10 vss.t920 sg13_lv_nmos ad=0.665p pd=3.88u as=0.665p ps=3.88u w=3.5u l=0.13u
X1087 vdd.t1682 vss.t2362 vdd.t1680 vdd.t764 sg13_hv_pmos ad=0.2375p pd=1.63u as=0 ps=0 w=1.25u l=4u
X1088 vss.t762 a_5176_30111# vss.t764 vss.t763 sg13_lv_nmos ad=95f pd=0.88u as=0 ps=0 w=0.5u l=3u
X1089 vss.t1364 a_20328_23820# vss.t1365 vss.t267 sg13_hv_nmos ad=1.9p pd=10.38u as=0 ps=0 w=10u l=10u
X1090 a_949_1161# a_522_2184# vdd.t633 vdd.t504 sg13_lv_pmos ad=63f pd=0.72u as=0.1563p ps=1.22u w=0.42u l=0.13u
X1091 a_19904_17646# d_ena.t10 vss.t1432 vss.t1171 sg13_lv_nmos ad=0.17p pd=1.68u as=0.17p ps=1.68u w=0.5u l=1u
X1092 a_4362_8188.t8 sg13cmos5l_or2_1_0.X.t3 xq_dith_v_bq.t7 vss.t917 sg13_lv_nmos ad=0.665p pd=3.88u as=1.19p ps=7.68u w=3.5u l=0.13u
X1093 a_24540_20320# a_28126_20460# vss.t34 rhigh l=17.5u w=0.5u
X1094 vss.t1690 vdd.t1780 vss.t1688 vss.t1689 sg13_lv_nmos ad=79.8f pd=0.8u as=0 ps=0 w=0.42u l=1u
X1095 vss.t1645 vdd.t1791 vss.t1644 vss.t1643 sg13_lv_nmos ad=0.1428p pd=1.52u as=0 ps=0 w=0.42u l=1u
X1096 vss.t143 a_537_3813# a_533_4736# vss.t142 sg13_lv_nmos ad=4.19617p pd=26.765u as=0.2516p ps=2.16u w=0.74u l=0.13u
X1097 a_1284_7983# a_1286_6839# a_1324_5988# vdd.t504 sg13_lv_pmos ad=0.2048p pd=1.63u as=0.34p ps=2.68u w=1u l=0.13u
X1098 vss.t1556 vdd.t1812 vss.t1558 vss.t1557 sg13_lv_nmos ad=79.8f pd=0.8u as=0 ps=0 w=0.42u l=1u
X1099 vdd.t408 vss.t2184 vdd.t407 vdd.t82 sg13_lv_pmos ad=0.19p pd=1.38u as=0 ps=0 w=1u l=1u
X1100 vdd.t789 a_5176_31117# vdd.t790 vdd.t764 sg13_lv_pmos ad=0.19p pd=1.38u as=0 ps=0 w=1u l=2u
X1101 vss.t569 a_522_7702# a_522_8085# vss.t879 sg13_lv_nmos ad=0.1406p pd=1.12u as=0.2516p ps=2.16u w=0.74u l=0.13u
X1102 a_604_16187# quantizer2_lfsr_0.sg13cmos5l_dfrbpq_1_1.D.t3 vss.t989 vss.t988 sg13_lv_nmos ad=78.39999f pd=0.885u as=0.2272p ps=1.99u w=0.64u l=0.13u
X1103 vdd.t569 bias_gm_0.bias_trim_0.vz.t9 bias_gm_0.bias_trim_0.vz.t10 vdd.t573 sg13_lv_pmos ad=95f pd=0.88u as=95f ps=0.88u w=0.5u l=5u
X1104 vss.t1507 vdd.t1822 vss.t1506 vss.t1505 sg13_lv_nmos ad=0.1428p pd=1.52u as=0 ps=0 w=0.42u l=1u
X1105 a_24540_22000# a_28126_21860# vss.t34 rhigh l=17.5u w=0.5u
X1106 a_1324_13764# a_1288_13738# vss.t1070 vss.t1324 sg13_lv_nmos ad=0.2516p pd=2.16u as=0.1626p ps=1.415u w=0.74u l=0.13u
X1107 a_22000_594# a_21617_558# vdd.t551 vdd.t515 sg13_lv_pmos ad=79.8f pd=0.8u as=0.2639p ps=1.81u w=0.42u l=0.13u
X1108 vdd.t626 a_1284_7983# a_1284_8085# vdd.t504 sg13_lv_pmos ad=0.2128p pd=1.5u as=0.3864p ps=2.93u w=1.12u l=0.13u
X1109 a_6452_29739.t2 a_5176_30111# vo_p.t8 vss.t747 sg13_lv_nmos ad=0.17p pd=1.68u as=95f ps=0.88u w=0.5u l=3u
X1110 vss.t966 sg13cmos5l_and2_2_1.X.t2 a_9357_11104.t13 vss.t389 sg13_lv_nmos ad=0.76p pd=4.38u as=0.76p ps=4.38u w=4u l=0.5u
X1111 vdd.t581 bias_gm_0.bias_trim_0.vz.t12 a_19984_17824# vdd.t384 sg13_lv_pmos ad=95f pd=0.88u as=95f ps=0.88u w=0.5u l=5u
X1112 a_558_10886# a_533_12512# a_567_11154# vdd.t504 sg13_lv_pmos ad=0.1428p pd=1.52u as=79.8f ps=0.8u w=0.42u l=0.13u
X1113 vdd.t87 vss.t2241 vdd.t86 vdd.t85 sg13_lv_pmos ad=0.34p pd=2.68u as=0 ps=0 w=1u l=1u
X1114 vss.t766 a_5176_30111# vss.t767 vss.t110 sg13_lv_nmos ad=0.36625p pd=1.965u as=0 ps=0 w=0.5u l=3u
X1115 sw_tgate_8.m.t8 d_qi_b.t6 vss.t1039 vss.t1038 sg13_lv_nmos ad=0.19p pd=1.38u as=0.34p ps=2.68u w=1u l=1u
X1116 vdd.t282 vss.t2350 vdd.t437 vdd.t53 sg13_lv_pmos ad=0.34p pd=2.68u as=0 ps=0 w=1u l=1u
X1117 vdd.t1600 vdd.t1590 vdd.t1602 vdd.t287 sg13_lv_pmos ad=95f pd=0.88u as=0 ps=0 w=0.5u l=5u
X1118 a_22138_15146# a_20138_14766# a_20070_14846# vdd.t897 sg13_lv_pmos ad=95f pd=0.88u as=0.17p ps=1.68u w=0.5u l=10u
X1119 vss.t2137 vss.t2138 vss.t39 rhigh l=2.75u w=0.5u
X1120 sg13cmos5l_inv_1_2.A.t1 sg13cmos5l_inv_1_14.A.t10 a_9533_11104.t9 vss.t31 sg13_lv_nmos ad=95f pd=0.88u as=95f ps=0.88u w=0.5u l=0.5u
X1121 vdd.t675 sg13cmos5l_inv_2_0.Y a_9556_15186# vdd.t502 sg13_lv_pmos ad=0.2128p pd=1.5u as=0.2128p ps=1.5u w=1.12u l=0.13u
X1122 a_558_518# a_533_2144# a_567_786# vdd.t504 sg13_lv_pmos ad=0.1428p pd=1.52u as=79.8f ps=0.8u w=0.42u l=0.13u
X1123 vdd.t530 clk_noverlap_0.sg13cmos5l_dlygate4sd3_1_2.X a_6859_7241# vdd.t308 sg13_lv_pmos ad=0.1523p pd=1.38u as=0.1428p ps=1.52u w=0.42u l=0.13u
X1124 a_522_9960# a_567_8562# vss.t3 vss.t2 sg13_lv_nmos ad=0.2516p pd=2.16u as=0.1626p ps=1.415u w=0.74u l=0.13u
X1125 a_15584_15091# d_dith_en.t34 vdd.t1075 vdd.t502 sg13_lv_pmos ad=0.1596p pd=1.22u as=0.1918p ps=1.5u w=0.84u l=0.13u
X1126 vcm_esd.t7 d_phi1.t11 xsc_vc1r_p.t5 vss.t898 sg13_lv_nmos ad=0.19p pd=1.38u as=0.19p ps=1.38u w=1u l=1u
X1127 vdd.t1345 vdd.t1309 sg13cmos5l_inv_1_14.A.t9 vdd.t863 sg13_lv_pmos ad=0.285p pd=1.88u as=0.285p ps=1.88u w=1.5u l=0.5u
X1128 vss.t1467 vdd.t1830 vss.t1469 vss.t1468 sg13_lv_nmos ad=79.8f pd=0.8u as=0 ps=0 w=0.42u l=1u
X1129 vdd.t9 vss.t2389 vdd.t41 vdd.t0 sg13_lv_pmos ad=0.34p pd=2.68u as=0 ps=0 w=1u l=1u
X1130 a_22386_2578# a_21736_2344# a_22184_2052# vdd.t514 sg13_lv_pmos ad=95f pd=0.88u as=0.17p ps=1.68u w=0.5u l=0.13u
X1131 vdd.t475 vss.t2161 vdd.t322 vdd.t308 sg13_lv_pmos ad=0.19p pd=1.38u as=0 ps=0 w=1u l=1u
X1132 vdd.t1390 vdd.t1388 vdd.t1018 vdd.t1287 sg13_lv_pmos ad=0.17p pd=1.68u as=0 ps=0 w=0.5u l=5u
X1133 clk_noverlap_0.sg13cmos5l_dlygate4sd3_1_2.X a_6377_7224# vss.t450 vss.t229 sg13_lv_nmos ad=0.2516p pd=2.16u as=0.1426p ps=1.16u w=0.74u l=0.13u
X1134 vdd.t864 sg13cmos5l_inv_1_2.A.t10 sg13cmos5l_inv_1_14.A.t6 vdd.t863 sg13_lv_pmos ad=0.285p pd=1.88u as=0.285p ps=1.88u w=1.5u l=0.5u
X1135 vdd.t511 a_522_2518# a_522_2354# vdd.t504 sg13_lv_pmos ad=1.21587p pd=7.58u as=79.8f ps=0.8u w=0.42u l=0.13u
X1136 a_2083_10020# a_2034_11112# a_2083_9958# vss.t1075 sg13_lv_nmos ad=0.1428p pd=1.52u as=37.8f ps=0.6u w=0.42u l=0.13u
X1137 vss.t1827 vdd.t1747 vss.t1826 vss.t1811 sg13_lv_nmos ad=0.1428p pd=1.52u as=0 ps=0 w=0.42u l=1u
X1138 vss.t727 a_15491_15614# sg13cmos5l_nand2_2_0.B.t0 vss.t1306 sg13_lv_nmos ad=0.1331p pd=1.12u as=0.1406p ps=1.12u w=0.74u l=0.13u
X1139 a_21681_1704# dsm2_osc_0.sg13cmos5l_mux2_1_0.A1 vdd.t544 vdd.t515 sg13_lv_pmos ad=0.1596p pd=1.22u as=0.2856p ps=2.36u w=0.84u l=0.13u
X1140 a_9357_11104.t4 vss.t416 vss.t417 vss.t377 sg13_lv_nmos ad=0.285p pd=1.88u as=0.285p ps=1.88u w=1.5u l=0.5u
X1141 vss.t1820 vdd.t1749 vss.t1817 vss.t1819 sg13_lv_nmos ad=79.8f pd=0.8u as=0 ps=0 w=0.42u l=1u
X1142 vdd.t586 vdd.t1411 vdd.t1412 vdd.t1173 sg13_lv_pmos ad=95f pd=0.88u as=0 ps=0 w=0.5u l=5u
X1143 sw_tgate_10.p.t6 d_qi.t9 vss.t1006 vdd.t561 sg13_lv_pmos ad=0.38p pd=2.38u as=0.68p ps=4.68u w=2u l=1u
X1144 a_22252_4374# bias_gm_0.bias_trim_0.vz.t35 vdd.t1239 vdd.t566 sg13_lv_pmos ad=95f pd=0.88u as=95f ps=0.88u w=0.5u l=5u
X1145 sg13cmos5l_and2_1_5.X.t1 a_8013_14934# vdd.t534 vdd.t502 sg13_lv_pmos ad=0.3808p pd=2.92u as=0.1918p ps=1.5u w=1.12u l=0.13u
X1146 a_4362_8188.t2 sg13cmos5l_inv_1_9.Y.t2 xq_dith_v_bp.t0 vdd.t623 sg13_lv_pmos ad=0.665p pd=3.88u as=0.665p ps=3.88u w=3.5u l=0.13u
X1147 vss.t1754 vdd.t1764 vss.t1753 vss.t1743 sg13_lv_nmos ad=0.1428p pd=1.52u as=0 ps=0 w=0.42u l=1u
X1148 xsc_vc1l_p.t3 d_phi2.t6 xsc_vc1l_p.t2 vdd.t561 sg13_lv_pmos ad=0.38p pd=2.38u as=0 ps=0 w=2u l=1u
X1149 vdd.t1007 bias_gm_0.bias_trim_0.vz.t38 a_24404_8546# vdd.t573 sg13_lv_pmos ad=95f pd=0.88u as=95f ps=0.88u w=0.5u l=5u
X1150 vss.t671 vss.t672 vss.t49 rhigh l=10.975u w=0.5u
X1151 vdd.t250 vss.t2404 vdd.t249 vdd.t0 sg13_lv_pmos ad=0.19p pd=1.38u as=0 ps=0 w=1u l=1u
X1152 xq_dith_v_bp.t3 sg13cmos5l_inv_1_9.Y.t2 a_4362_8188.t0 vdd.t623 sg13_lv_pmos ad=0.665p pd=3.88u as=0.665p ps=3.88u w=3.5u l=0.13u
X1153 xsc_vc1l_n.t1 sw_tgate_9.gb.t2 vi_esd.t1 vdd.t562 sg13_lv_pmos ad=0.38p pd=2.38u as=0.38p ps=2.38u w=2u l=1u
X1154 vdd.t515 dsm2_osc_0.sg13cmos5l_dfrbp_1_0.RESET_B.t3 a_22000_594# vdd.t515 sg13_lv_pmos ad=1.93285p pd=12.62u as=79.8f ps=0.8u w=0.42u l=0.13u
X1155 vdd.t615 clk_noverlap_0.sg13cmos5l_dlygate4sd3_1_1.X a_5995_7241# vdd.t308 sg13_lv_pmos ad=0.1523p pd=1.38u as=0.1428p ps=1.52u w=0.42u l=0.13u
X1156 a_22252_11246# bias_gm_0.bias_trim_0.vz.t52 vdd.t1020 vdd.t287 sg13_lv_pmos ad=95f pd=0.88u as=95f ps=0.88u w=0.5u l=5u
X1157 vdd.t214 vss.t2323 vdd.t213 vdd.t135 sg13_lv_pmos ad=0.19p pd=1.38u as=0 ps=0 w=1u l=1u
X1158 vdd.t813 a_5176_31117# vdd.t814 vdd.t764 sg13_lv_pmos ad=0.19p pd=1.38u as=0 ps=0 w=1u l=2u
X1159 a_21452_2308.t0 dsm2_osc_0.dsm2_io_rx_0.di_b.t4 vss.t536 vss.t535 sg13_lv_nmos ad=95f pd=0.88u as=0.17p ps=1.68u w=0.5u l=0.13u
X1160 a_2385_8601# a_2045_8480# a_2034_8854# vdd.t507 sg13_lv_pmos ad=93.45f pd=0.865u as=0.2048p ps=1.63u w=0.42u l=0.13u
X1161 sg13cmos5l_and2_1_5.X.t0 a_8013_14934# vss.t95 vss.t208 sg13_lv_nmos ad=0.2516p pd=2.16u as=0.1331p ps=1.12u w=0.74u l=0.13u
X1162 vdd.t1525 vdd.t1515 vdd.t1527 vdd.t287 sg13_lv_pmos ad=95f pd=0.88u as=0 ps=0 w=0.5u l=5u
X1163 a_558_15442# d_dith_en.t38 vss.t1084 vss.t1083 sg13_lv_nmos ad=37.8f pd=0.6u as=79.8f ps=0.8u w=0.42u l=0.13u
X1164 a_22738_2578# a_22184_2052# a_22644_2344# vdd.t514 sg13_lv_pmos ad=95f pd=0.88u as=0.17p ps=1.68u w=0.5u l=0.13u
X1165 quantizer2_lfsr_0.sg13cmos5l_dfrbpq_1_0.D.t0 a_2038_15217# a_2074_14933# vss.t664 sg13_lv_nmos ad=0.2516p pd=2.16u as=0.1406p ps=1.12u w=0.74u l=0.13u
X1166 vss.t1898 vdd.t1730 vss.t1897 vss.t1882 sg13_lv_nmos ad=0.1428p pd=1.52u as=0 ps=0 w=0.42u l=1u
X1167 vdd.t1652 vss.t2417 vdd.t1660 vdd.t0 sg13_lv_pmos ad=0.34p pd=2.68u as=0 ps=0 w=1u l=1u
X1168 vss.t588 clk_noverlap_0.sg13cmos5l_inv_1_0.Y clk_noverlap_0.sg13cmos5l_inv_1_1.A vss.t587 sg13_lv_nmos ad=0.2618p pd=2.22u as=0.1694p ps=1.21u w=0.77u l=0.13u
X1169 a_2034_8520# a_2079_7122# vdd.t528 vdd.t507 sg13_lv_pmos ad=0.34p pd=2.68u as=0.36237p ps=2.605u w=1u l=0.13u
X1170 a_2049_2373# d_qclk.t5 vss.t521 vss.t1411 sg13_lv_nmos ad=0.2516p pd=2.16u as=2.50852p ps=15.49u w=0.74u l=0.13u
X1171 vss.t422 vss.t419 vss.t424 vss.t398 sg13_lv_nmos ad=0.76p pd=4.38u as=0 ps=0 w=4u l=0.5u
X1172 vss.t1047 vss.t1048 vss.t531 rhigh l=2.75u w=0.5u
X1173 vss.t115 sw_tgate_cmfb2_1.p.t7 vss.t114 vss.t113 sg13_lv_nmos ad=0.17p pd=1.68u as=0 ps=0 w=0.5u l=3u
X1174 vss.t627 a_17025_7467# clk_noverlap_0.sg13cmos5l_dlygate4sd3_1_12.A vss.t2111 sg13_lv_nmos ad=0.1426p pd=1.16u as=0.2516p ps=2.16u w=0.74u l=0.13u
X1175 vo_n.t22 a_5176_31469# a_9348_31505# vdd.t764 sg13_lv_pmos ad=1.19p pd=7.68u as=1.19p ps=7.68u w=3.5u l=2u
X1176 a_28746_16046# a_19964_18216# a_26670_16346# vdd.t1128 sg13_lv_pmos ad=0.17p pd=1.68u as=95f ps=0.88u w=0.5u l=10u
X1177 vdd.t528 d_dith_en.t16 a_2070_6854# vdd.t507 sg13_lv_pmos ad=0.36237p pd=2.605u as=79.8f ps=0.8u w=0.42u l=0.13u
X1178 vss.t1933 vdd.t1722 vss.t1931 vss.t1923 sg13_lv_nmos ad=79.8f pd=0.8u as=0 ps=0 w=0.42u l=1u
X1179 vss.t1708 vdd.t1775 vss.t1707 vss.t1702 sg13_lv_nmos ad=0.1428p pd=1.52u as=0 ps=0 w=0.42u l=1u
X1180 xq_vg_q_1_.t0 sg13cmos5l_inv_1_4.A.t3 a_6249_9100.t1 vdd.t580 sg13_lv_pmos ad=95f pd=0.88u as=0.17p ps=1.68u w=0.5u l=0.13u
X1181 vcm_esd.t14 d_phi2.t12 xsc_xcmfb1_vsw_cm_n.t0 vss.t188 sg13_lv_nmos ad=95f pd=0.88u as=95f ps=0.88u w=0.5u l=1u
X1182 vss.t819 vss.t820 vss.t531 rhigh l=2.75u w=0.5u
X1183 sg13cmos5l_inv_1_14.A.t2 sg13cmos5l_inv_1_2.A.t10 a_11293_11104.t4 vss.t645 sg13_lv_nmos ad=95f pd=0.88u as=95f ps=0.88u w=0.5u l=0.5u
X1184 vss.t772 a_5176_30111# vss.t773 vss.t753 sg13_lv_nmos ad=95f pd=0.88u as=0 ps=0 w=0.5u l=3u
X1185 xsc_xcmfb1_vsw_vbias.t10 sw_tgate_cmfb2_3.gb.t2 xsc_xcmfb1_vsw_vbias.t9 vss.t1219 sg13_lv_nmos ad=95f pd=0.88u as=0 ps=0 w=0.5u l=1u
X1186 do_clk_osc.t1 dsm2_osc_0.sg13cmos5l_inv_1_2.Y vdd.t546 vdd.t515 sg13_lv_pmos ad=0.2128p pd=1.5u as=0.3808p ps=2.92u w=1.12u l=0.13u
X1187 vdd.t12 vss.t2387 vdd.t11 vdd.t10 sg13_lv_pmos ad=0.34p pd=2.68u as=0 ps=0 w=1u l=1u
X1188 vdd.t99 vss.t2255 vdd.t98 vdd.t95 sg13_lv_pmos ad=0.34p pd=2.68u as=0 ps=0 w=1u l=1u
X1189 vo_n.t11 sg13cmos5l_inv_1_3.A.t2 xq_dith_v_bp.t6 vss.t717 sg13_lv_nmos ad=0.665p pd=3.88u as=0.665p ps=3.88u w=3.5u l=0.13u
X1190 a_26670_15746# a_19964_18216# a_24602_15746# vdd.t1127 sg13_lv_pmos ad=95f pd=0.88u as=0.17p ps=1.68u w=0.5u l=10u
X1191 a_1288_8554# a_1286_9431# a_1367_8937# vdd.t504 sg13_lv_pmos ad=79.8f pd=0.8u as=63f ps=0.72u w=0.42u l=0.13u
X1192 vss.t409 vss.t397 vss.t400 vss.t407 sg13_lv_nmos ad=95f pd=0.88u as=0 ps=0 w=0.5u l=0.5u
X1193 clk_noverlap_0.sg13cmos5l_inv_1_9.A clk_noverlap_0.sg13cmos5l_inv_1_10.A vdd.t612 vdd.t308 sg13_lv_pmos ad=0.3808p pd=2.92u as=0.3808p ps=2.92u w=1.12u l=0.13u
X1194 vdd.t1216 sg13cmos5l_inv_1_2.Y sg13cmos5l_inv_2_0.Y vdd.t502 sg13_lv_pmos ad=0.3808p pd=2.92u as=0.2128p ps=1.5u w=1.12u l=0.13u
X1195 vdd.t1578 vdd.t1576 vdd.t943 vdd.t1287 sg13_lv_pmos ad=0.17p pd=1.68u as=0 ps=0 w=0.5u l=5u
X1196 vdd.t672 a_16161_7467# clk_noverlap_0.sg13cmos5l_dlygate4sd3_1_10.A vdd.t308 sg13_lv_pmos ad=0.2254p pd=1.53u as=0.4256p ps=3u w=1.12u l=0.13u
X1197 sw_tgate_6.p.t3 d_phi1.t4 xsc_vc1l_n.t5 vss.t912 sg13_lv_nmos ad=0.19p pd=1.38u as=0.19p ps=1.38u w=1u l=1u
X1198 vdd.t364 vss.t2213 vdd.t363 vdd.t123 sg13_lv_pmos ad=0.34p pd=2.68u as=0 ps=0 w=1u l=1u
X1199 sw_tgate_cmfb2_1.p.t4 d_phi2.t8 xsc_xcmfb1_vsw_vbias.t0 vss.t196 sg13_lv_nmos ad=95f pd=0.88u as=95f ps=0.88u w=0.5u l=1u
X1200 vss.t1017 d_qi.t6 vss.t1016 vss.t1015 sg13_lv_nmos ad=0.19p pd=1.38u as=0 ps=0 w=1u l=1u
X1201 a_11173_9488.t0 a_12075_9488.t0 vss.t219 rhigh l=4.08u w=0.5u
X1202 a_22252_11246# bias_gm_0.bias_trim_0.vz.t15 vdd.t996 vdd.t566 sg13_lv_pmos ad=95f pd=0.88u as=95f ps=0.88u w=0.5u l=5u
X1203 a_9357_11104.t19 xq_vg_p_2_.t3 a_11293_11104.t8 vss.t644 sg13_lv_nmos ad=0.285p pd=1.88u as=0.285p ps=1.88u w=1.5u l=0.5u
X1204 quantizer2_lfsr_0.sg13cmos5l_dfrbpq_1_11.D.t0 a_526_16657# a_562_16373# vss.t668 sg13_lv_nmos ad=0.2516p pd=2.16u as=0.1406p ps=1.12u w=0.74u l=0.13u
X1205 a_13965_7164# clk_noverlap_0.sg13cmos5l_dlygate4sd3_1_7.A vss.t678 vss.t494 sg13_lv_nmos ad=0.1428p pd=1.52u as=79.8f ps=0.8u w=0.42u l=0.13u
X1206 d_qi.t0 d_qi_b.t3 vss.t1042 vss.t1041 sg13_lv_nmos ad=0.1406p pd=1.12u as=0.1406p ps=1.12u w=0.74u l=0.13u
X1207 clk_noverlap_0.di_clk.t0 a_19949_784# vss.t25 vss.t24 sg13_lv_nmos ad=0.1406p pd=1.12u as=0.2516p ps=2.16u w=0.74u l=0.13u
X1208 vdd.t548 a_20447_636# a_20947_892# vdd.t515 sg13_lv_pmos ad=0.2198p pd=1.52u as=0.2975p ps=1.595u w=1u l=0.13u
X1209 a_522_5110# a_537_3813# a_558_4878# vss.t141 sg13_lv_nmos ad=0.12665p pd=1.145u as=0.1428p ps=1.52u w=0.42u l=0.13u
X1210 a_1758_5796# quantizer2_lfsr_0.sg13cmos5l_dfrbpq_1_12.Q a_1367_6533# vss.t226 sg13_lv_nmos ad=60.89999f pd=0.71u as=0.1428p ps=1.52u w=0.42u l=0.13u
X1211 xq_dith_v_bp.t5 sg13cmos5l_inv_1_3.A.t2 vo_n.t9 vss.t717 sg13_lv_nmos ad=0.665p pd=3.88u as=0.665p ps=3.88u w=3.5u l=0.13u
X1212 vss.t123 sw_tgate_cmfb2_1.p.t7 vss.t121 vss.t73 sg13_lv_nmos ad=95f pd=0.88u as=0 ps=0 w=0.5u l=3u
X1213 a_2070_4262# a_2045_5888# a_2079_4530# vdd.t507 sg13_lv_pmos ad=0.1428p pd=1.52u as=79.8f ps=0.8u w=0.42u l=0.13u
X1214 d_amp_s_b[0].t0 d_amp_s[0].t4 vdd.t750 vdd.t504 sg13_lv_pmos ad=0.3808p pd=2.92u as=0.3808p ps=2.92u w=1.12u l=0.13u
X1215 vss.t1874 vdd.t1735 vss.t1873 vss.t1872 sg13_lv_nmos ad=0.1428p pd=1.52u as=0 ps=0 w=0.42u l=1u
X1216 vdd.t1180 bias_gm_0.bias_trim_0.vz.t33 a_22252_5274# vdd.t570 sg13_lv_pmos ad=95f pd=0.88u as=95f ps=0.88u w=0.5u l=5u
X1217 a_22347_812# a_22499_864# vss.t638 vss.t640 sg13_lv_nmos ad=0.2516p pd=2.16u as=3.63417p ps=24.185u w=0.74u l=0.13u
X1218 a_522_12552# a_567_11154# vdd.t741 vdd.t504 sg13_lv_pmos ad=0.34p pd=2.68u as=0.36237p ps=2.605u w=1u l=0.13u
X1219 a_11865_14889# sg13cmos5l_nand2_2_0.B.t2 vss.t836 vss.t837 sg13_lv_nmos ad=0.1404p pd=1.11u as=0.1368p ps=1.1u w=0.72u l=0.13u
X1220 vss.t825 a_15130_14856# a_14849_15078# vss.t1244 sg13_lv_nmos ad=79.8f pd=0.8u as=0.1428p ps=1.52u w=0.42u l=0.5u
X1221 vdd.t1332 vdd.t1313 vdd.t1331 vdd.t863 sg13_lv_pmos ad=0.51p pd=3.68u as=0 ps=0 w=1.5u l=0.5u
X1222 vdd.t511 a_1284_13167# a_1407_12722# vdd.t504 sg13_lv_pmos ad=1.21587p pd=7.58u as=79.8f ps=0.8u w=0.42u l=0.13u
X1223 vdd.t741 d_dith_en.t27 a_558_10886# vdd.t504 sg13_lv_pmos ad=0.36237p pd=2.605u as=79.8f ps=0.8u w=0.42u l=0.13u
X1224 vss.t1884 vdd.t1733 vss.t1883 vss.t1882 sg13_lv_nmos ad=0.1428p pd=1.52u as=0 ps=0 w=0.42u l=1u
X1225 sw_tgate_cmfb2_1.p.t2 sw_tgate_cmfb2_1.gb.t2 xsc_xcmfb1_vsw_vbias.t11 vdd.t558 sg13_lv_pmos ad=0.285p pd=1.88u as=0.285p ps=1.88u w=1.5u l=1u
X1226 xsc_vc1r_n.t1 sw_tgate_9.gb.t5 xsc_vc1r_n.t0 vss.t2077 sg13_lv_nmos ad=0.19p pd=1.38u as=0 ps=0 w=1u l=1u
X1227 a_24540_21440# a_28126_21580# vss.t34 rhigh l=17.5u w=0.5u
X1228 vdd.t507 a_2034_6098# a_2385_6009# vdd.t507 sg13_lv_pmos ad=1.99007p pd=12.8u as=93.45f ps=0.865u w=0.42u l=0.13u
X1229 vss.t1542 vdd.t1815 vss.t1541 vss.t1540 sg13_lv_nmos ad=0.1428p pd=1.52u as=0 ps=0 w=0.42u l=1u
X1230 vo_p.t1 vss.t293 vo_p.t0 vss.t294 sg13_lv_nmos ad=95f pd=0.88u as=0 ps=0 w=0.5u l=1u
X1231 a_1284_2799# a_1286_1655# a_1681_1969# vss.t2118 sg13_lv_nmos ad=0.12665p pd=1.145u as=0.1428p ps=1.52u w=0.42u l=0.13u
X1232 vdd.t1310 vdd.t1309 sg13cmos5l_inv_1_2.A.t8 vdd.t863 sg13_lv_pmos ad=0.285p pd=1.88u as=0.285p ps=1.88u w=1.5u l=0.5u
X1233 vss.t815 di_trim[3] dsm2_io_0.do_trim_b[3].t0 vss.t814 sg13_hv_nmos ad=0.34p pd=2.68u as=0.34p ps=2.68u w=1u l=0.45u
X1234 vss.t1026 d_qi_b.t9 vss.t1005 vdd.t561 sg13_lv_pmos ad=0.38p pd=2.38u as=0 ps=0 w=2u l=1u
X1235 vss.t1834 vdd.t1745 vss.t1833 vss.t1821 sg13_lv_nmos ad=0.1428p pd=1.52u as=0 ps=0 w=0.42u l=1u
X1236 vdd.t1240 bias_gm_0.bias_trim_0.vz.t35 a_22252_4374# vdd.t384 sg13_lv_pmos ad=95f pd=0.88u as=95f ps=0.88u w=0.5u l=5u
X1237 a_21276_2052# a_21452_2308.t6 a_21478_2344# vss.t2079 sg13_lv_nmos ad=0.17p pd=1.68u as=95f ps=0.88u w=0.5u l=0.13u
X1238 a_10787_14878# d_qclk.t18 vdd.t1269 vdd.t502 sg13_lv_pmos ad=0.1596p pd=1.22u as=0.1918p ps=1.5u w=0.84u l=0.13u
X1239 a_22252_8546# bias_gm_0.bias_trim_0.vz.t38 vdd.t1007 vdd.t287 sg13_lv_pmos ad=95f pd=0.88u as=95f ps=0.88u w=0.5u l=5u
X1240 vdd.t1189 sg13cmos5l_inv_1_14.A.t10 sg13cmos5l_inv_1_2.A.t6 vdd.t863 sg13_lv_pmos ad=0.285p pd=1.88u as=0.285p ps=1.88u w=1.5u l=0.5u
X1241 vdd.t140 vss.t2244 vdd.t139 vdd.t138 sg13_lv_pmos ad=0.19p pd=1.38u as=0 ps=0 w=1u l=1u
X1242 vss.t890 clk_noverlap_0.sg13cmos5l_inv_1_5.A clk_noverlap_0.sg13cmos5l_inv_1_5.Y vss.t889 sg13_lv_nmos ad=0.2516p pd=2.16u as=0.2516p ps=2.16u w=0.74u l=0.13u
X1243 vdd.t1001 bias_gm_0.bias_trim_0.vz.t15 a_22252_11246# vdd.t570 sg13_lv_pmos ad=95f pd=0.88u as=95f ps=0.88u w=0.5u l=5u
X1244 bias_gm_0.bias_trim_0.vz.t4 bias_gm_0.bias_trim_0.vz.t3 vdd.t1182 vdd.t572 sg13_lv_pmos ad=95f pd=0.88u as=95f ps=0.88u w=0.5u l=5u
X1245 vdd.t57 vss.t2369 vdd.t4 vdd.t3 sg13_lv_pmos ad=0.19p pd=1.38u as=0 ps=0 w=1u l=1u
X1246 vdd.t511 a_522_12886# a_522_12722# vdd.t504 sg13_lv_pmos ad=1.21587p pd=7.58u as=79.8f ps=0.8u w=0.42u l=0.13u
X1247 vss.t896 a_16557_7164# a_16276_7466# vss.t204 sg13_lv_nmos ad=79.8f pd=0.8u as=0.1428p ps=1.52u w=0.42u l=0.5u
X1248 vdd.t1667 vss.t2361 vdd.t1666 vdd.t764 sg13_hv_pmos ad=0.425p pd=3.18u as=0 ps=0 w=1.25u l=4u
X1249 dsm2_osc_0.ibias_in.t3 a_21252_3394# bias_gm_0.bias_trim_0.iout vdd.t566 sg13_lv_pmos ad=95f pd=0.88u as=95f ps=0.88u w=0.5u l=5u
X1250 xsc_vvg_p.t0 sw_tgate_9.gb.t5 xsc_vc1r_n.t3 vdd.t556 sg13_lv_pmos ad=0.38p pd=2.38u as=0.38p ps=2.38u w=2u l=1u
X1251 vdd.t846 a_5176_31117# vdd.t844 vdd.t764 sg13_lv_pmos ad=0.465p pd=1.93u as=0 ps=0 w=1u l=2u
X1252 a_7437_15998# sg13cmos5l_nor2_1_0.Y vdd.t1030 vdd.t502 sg13_lv_pmos ad=0.1596p pd=1.22u as=0.2856p ps=2.36u w=0.84u l=0.13u
X1253 vss.t848 a_19984_17824# a_19964_18216# vss.t267 sg13_hv_nmos ad=95f pd=0.88u as=95f ps=0.88u w=0.5u l=10u
X1254 vss.t1527 vdd.t1818 vss.t1526 vss.t1525 sg13_lv_nmos ad=0.1428p pd=1.52u as=0 ps=0 w=0.42u l=1u
X1255 vss.t1673 vdd.t1784 vss.t1675 vss.t1674 sg13_lv_nmos ad=79.8f pd=0.8u as=0 ps=0 w=0.42u l=1u
X1256 vss.t1427 d_ena.t14 vss.t1425 vss.t1426 sg13_hv_nmos ad=0.19p pd=1.38u as=0 ps=0 w=1u l=5u
X1257 vss.t1741 vdd.t1767 vss.t1742 vss.t1734 sg13_lv_nmos ad=79.8f pd=0.8u as=0 ps=0 w=0.42u l=1u
X1258 vdd.t1115 a_2034_3670# a_2034_4053# vdd.t507 sg13_lv_pmos ad=0.2128p pd=1.5u as=0.3864p ps=2.93u w=1.12u l=0.13u
X1259 vss.t483 vss.t484 vss.t482 rhigh l=10.05u w=0.5u
X1260 a_2070_8818# d_dith_en.t19 vss.t712 vss.t1063 sg13_lv_nmos ad=37.8f pd=0.6u as=79.8f ps=0.8u w=0.42u l=0.13u
X1261 vdd.t1655 vss.t2418 vdd.t1650 vdd.t0 sg13_lv_pmos ad=0.19p pd=1.38u as=0 ps=0 w=1u l=1u
X1262 vdd.t511 a_537_14181# a_533_15104# vdd.t504 sg13_lv_pmos ad=1.21587p pd=7.58u as=0.3864p ps=2.93u w=1.12u l=0.13u
X1263 a_1407_2354# d_dith_en.t5 vdd.t511 vdd.t504 sg13_lv_pmos ad=79.8f pd=0.8u as=1.1847p ps=7.385u w=0.42u l=0.13u
X1264 vss.t173 vcm_esd.t25 vss.t175 vss.t174 sg13_hv_nmos ad=1.9p pd=10.38u as=0 ps=0 w=10u l=10u
X1265 vss.t1307 vss.t1308 vss.t49 rhigh l=10.975u w=0.5u
X1266 a_21554_2798# a_21554_2798# vdd.t641 vdd.t514 sg13_lv_pmos ad=95f pd=0.88u as=0.17p ps=1.68u w=0.5u l=0.5u
X1267 a_21736_2344# a_21276_2052# a_21830_2088# vss.t502 sg13_lv_nmos ad=0.17p pd=1.68u as=95f ps=0.88u w=0.5u l=0.13u
X1268 a_23546_607# a_22368_558# a_23150_752# vss.t558 sg13_lv_nmos ad=37.8f pd=0.6u as=0.1428p ps=1.52u w=0.42u l=0.13u
X1269 vss.t1905 vdd.t1728 vss.t1904 vss.t1892 sg13_lv_nmos ad=0.1428p pd=1.52u as=0 ps=0 w=0.42u l=1u
X1270 vss.t1487 vdd.t1826 vss.t1489 vss.t1488 sg13_lv_nmos ad=79.8f pd=0.8u as=0 ps=0 w=0.42u l=1u
X1271 vss.t1316 xsc_vfb.t12 a_6452_29739.t6 vss.t102 sg13_lv_nmos ad=95f pd=0.88u as=95f ps=0.88u w=0.5u l=3u
X1272 sw_tgate_cmfb2_3.gb.t1 d_phi1.t10 vdd.t902 vdd.t556 sg13_lv_pmos ad=0.68p pd=4.68u as=0.68p ps=4.68u w=2u l=0.13u
X1273 d_dith[2].t1 a_2034_1466# vdd.t599 vdd.t507 sg13_lv_pmos ad=0.42p pd=2.99u as=0.2114p ps=1.54u w=1.12u l=0.13u
X1274 a_2049_4965# d_qclk.t8 vdd.t507 vdd.t507 sg13_lv_pmos ad=0.4088p pd=2.97u as=1.87952p ps=12.085u w=1.12u l=0.13u
X1275 vss.t970 sg13cmos5l_and2_2_1.X.t2 a_9357_11104.t15 vss.t403 sg13_lv_nmos ad=0.76p pd=4.38u as=0.76p ps=4.38u w=4u l=0.5u
X1276 vss.t193 d_phi2.t10 sw_tgate_9.gb.t0 vss.t192 sg13_lv_nmos ad=0.34p pd=2.68u as=0.34p ps=2.68u w=1u l=0.13u
X1277 a_2034_3506# d_dith_en.t7 vdd.t507 vdd.t507 sg13_lv_pmos ad=79.8f pd=0.8u as=1.87952p ps=12.085u w=0.42u l=0.13u
X1278 a_22252_4374# dsm2_io_0.do_trim_b[3].t2 bias_gm_0.bias_trim_0.iout vdd.t572 sg13_lv_pmos ad=95f pd=0.88u as=95f ps=0.88u w=0.5u l=5u
X1279 vdd.t324 vss.t2252 vdd.t323 vdd.t79 sg13_lv_pmos ad=0.19p pd=1.38u as=0 ps=0 w=1u l=1u
X1280 vss.t337 vss.t335 vss.t339 vss.t265 sg13_lv_nmos ad=95f pd=0.88u as=0 ps=0 w=0.5u l=10u
X1281 a_11293_11104.t1 vo_n.t24 a_9357_11104.t11 vss.t642 sg13_lv_nmos ad=0.76p pd=4.38u as=0.76p ps=4.38u w=4u l=0.5u
X1282 vdd.t1510 vdd.t1498 vdd.t1512 vdd.t570 sg13_lv_pmos ad=95f pd=0.88u as=0 ps=0 w=0.5u l=5u
X1283 vss.t1775 vdd.t1759 vss.t1774 vss.t1765 sg13_lv_nmos ad=0.1428p pd=1.52u as=0 ps=0 w=0.42u l=1u
X1284 vdd.t1206 a_1284_13167# a_1284_13269# vdd.t504 sg13_lv_pmos ad=0.2128p pd=1.5u as=0.3864p ps=2.93u w=1.12u l=0.13u
X1285 a_949_3753# a_522_4776# vdd.t595 vdd.t504 sg13_lv_pmos ad=63f pd=0.72u as=0.1563p ps=1.22u w=0.42u l=0.13u
X1286 vdd.t457 vss.t2307 vdd.t456 vdd.t386 sg13_lv_pmos ad=0.34p pd=2.68u as=0 ps=0 w=1u l=1u
X1287 d_amp_s[1].t1 quantizer2_lfsr_0.sg13cmos5l_nor2_1_1.B a_1320_16970# vdd.t504 sg13_lv_pmos ad=0.3808p pd=2.92u as=0.1176p ps=1.33u w=1.12u l=0.13u
X1288 sg13cmos5l_inv_2_4.Y sg13cmos5l_inv_1_11.Y vdd.t881 vdd.t502 sg13_lv_pmos ad=0.2128p pd=1.5u as=0.3864p ps=2.93u w=1.12u l=0.13u
X1289 a_11865_14889# sg13cmos5l_inv_2_5.Y sg13cmos5l_nor2_2_2.A vss.t992 sg13_lv_nmos ad=0.2448p pd=2.12u as=0.1368p ps=1.1u w=0.72u l=0.13u
X1290 a_9721_7200# a_9451_7241# vss.t936 vss.t2106 sg13_lv_nmos ad=0.1428p pd=1.52u as=79.8f ps=0.8u w=0.42u l=0.5u
X1291 sg13cmos5l_inv_1_3.Y.t1 sg13cmos5l_inv_1_3.A.t4 vdd.t747 vdd.t502 sg13_lv_pmos ad=0.3808p pd=2.92u as=0.3808p ps=2.92u w=1.12u l=0.13u
X1292 vdd.t1261 sg13cmos5l_inv_1_5.Y do_q.t0 vdd.t502 sg13_lv_pmos ad=0.3864p pd=2.93u as=0.2128p ps=1.5u w=1.12u l=0.13u
X1293 vdd.t353 vss.t2160 vdd.t352 vdd.t308 sg13_lv_pmos ad=0.34p pd=2.68u as=0 ps=0 w=1u l=1u
X1294 vss.t760 a_5176_30111# vss.t762 vss.t761 sg13_lv_nmos ad=95f pd=0.88u as=0 ps=0 w=0.5u l=3u
X1295 vdd.t511 a_537_1221# a_533_2144# vdd.t504 sg13_lv_pmos ad=1.21587p pd=7.58u as=0.3864p ps=2.93u w=1.12u l=0.13u
X1296 a_1284_10575# a_1286_9431# a_1324_8580# vdd.t504 sg13_lv_pmos ad=0.2048p pd=1.63u as=0.34p ps=2.68u w=1u l=0.13u
X1297 vss.t143 a_537_6405# a_533_7328# vss.t571 sg13_lv_nmos ad=4.19617p pd=26.765u as=0.2516p ps=2.16u w=0.74u l=0.13u
X1298 xq_dith_v_bq.t12 sg13cmos5l_inv_1_3.A.t3 vo_p.t15 vss.t1236 sg13_lv_nmos ad=0.665p pd=3.88u as=0.665p ps=3.88u w=3.5u l=0.13u
X1299 vss.t1457 vdd.t1832 vss.t1456 vss.t1455 sg13_lv_nmos ad=0.1428p pd=1.52u as=0 ps=0 w=0.42u l=1u
X1300 vss.t1728 vdd.t1770 vss.t1727 vss.t1726 sg13_lv_nmos ad=0.1428p pd=1.52u as=0 ps=0 w=0.42u l=1u
X1301 vss.t341 vss.t335 vss.t343 vss.t269 sg13_lv_nmos ad=95f pd=0.88u as=0 ps=0 w=0.5u l=10u
X1302 a_2034_3336# a_2045_3296# a_2034_3670# vss.t1159 sg13_lv_nmos ad=0.3473p pd=2.71u as=0.12665p ps=1.145u w=0.74u l=0.13u
X1303 vo_p.t20 a_5176_31469# a_8762_31505# vdd.t764 sg13_lv_pmos ad=1.19p pd=7.68u as=0.665p ps=3.88u w=3.5u l=2u
X1304 vdd.t559 d_phi2.t10 sw_tgate_9.gb.t1 vdd.t556 sg13_lv_pmos ad=0.68p pd=4.68u as=0.68p ps=4.68u w=2u l=0.13u
X1305 vdd.t858 a_14266_14856# a_13985_15078# vdd.t502 sg13_lv_pmos ad=0.1523p pd=1.38u as=0.34p ps=2.68u w=1u l=0.5u
X1306 vss.t547 a_1284_5391# a_1284_5493# vss.t548 sg13_lv_nmos ad=0.1406p pd=1.12u as=0.2516p ps=2.16u w=0.74u l=0.13u
X1307 vdd.t1236 a_522_10294# a_522_10677# vdd.t504 sg13_lv_pmos ad=0.2128p pd=1.5u as=0.3864p ps=2.93u w=1.12u l=0.13u
X1308 vdd.t1347 vdd.t1346 sg13cmos5l_inv_1_14.A.t8 vdd.t863 sg13_lv_pmos ad=0.285p pd=1.88u as=0.285p ps=1.88u w=1.5u l=0.5u
X1309 vdd.t1180 vdd.t1545 vdd.t1546 vdd.t1173 sg13_lv_pmos ad=95f pd=0.88u as=0 ps=0 w=0.5u l=5u
X1310 a_9556_15186# sg13cmos5l_inv_2_0.Y vdd.t675 vdd.t502 sg13_lv_pmos ad=0.4032p pd=2.96u as=0.2128p ps=1.5u w=1.12u l=0.13u
X1311 vss.t788 vss.t789 vss.t531 rhigh l=2.75u w=0.5u
X1312 vdd.t603 vdd.t1612 vdd.t1613 vdd.t514 sg13_lv_pmos ad=95f pd=0.88u as=0 ps=0 w=0.5u l=0.5u
X1313 vss.t1954 vdd.t1717 vss.t1956 vss.t1955 sg13_lv_nmos ad=79.8f pd=0.8u as=0 ps=0 w=0.42u l=1u
X1314 vdd.t892 clk_noverlap_0.sg13cmos5l_inv_1_5.A clk_noverlap_0.sg13cmos5l_inv_1_5.Y vdd.t308 sg13_lv_pmos ad=0.3808p pd=2.92u as=0.3808p ps=2.92u w=1.12u l=0.13u
X1315 vi_esd.t7 sw_tgate_11.gb.t4 vi_esd.t6 vss.t600 sg13_lv_nmos ad=0.34p pd=2.68u as=0 ps=0 w=1u l=1u
X1316 vdd.t132 vss.t2345 vdd.t131 vdd.t88 sg13_lv_pmos ad=0.19p pd=1.38u as=0 ps=0 w=1u l=1u
X1317 xsc_xcmfb1_vsw_vbias.t2 d_phi2.t8 xsc_xcmfb1_vsw_vbias.t1 vdd.t558 sg13_lv_pmos ad=0.285p pd=1.88u as=0 ps=0 w=1.5u l=1u
X1318 vdd.t315 vss.t2294 vdd.t185 vdd.t184 sg13_lv_pmos ad=0.19p pd=1.38u as=0 ps=0 w=1u l=1u
X1319 w_9407_29481.t2 xsc_vvg_p.t6 a_7804_29739.t0 w_9407_29481.t0 sg13_lv_pmos ad=0.38p pd=2.38u as=0.38p ps=2.38u w=2u l=1u
X1320 a_558_3110# a_533_4736# a_567_3378# vdd.t504 sg13_lv_pmos ad=0.1428p pd=1.52u as=79.8f ps=0.8u w=0.42u l=0.13u
X1321 xq_vg_p_2_.t1 sg13cmos5l_inv_1_17.A.t2 a_5892_8400.t7 vdd.t763 sg13_lv_pmos ad=95f pd=0.88u as=0.17p ps=1.68u w=0.5u l=0.13u
X1322 vdd.t784 a_5176_31117# vdd.t785 vdd.t764 sg13_lv_pmos ad=0.19p pd=1.38u as=0 ps=0 w=1u l=2u
X1323 vdd.t1471 vdd.t1469 vdd.t1470 vdd.t1287 sg13_lv_pmos ad=0.17p pd=1.68u as=0 ps=0 w=0.5u l=5u
X1324 vss.t86 clk_noverlap_0.sg13cmos5l_dlygate4sd3_1_2.X a_6859_7241# vss.t85 sg13_lv_nmos ad=79.8f pd=0.8u as=0.1428p ps=1.52u w=0.42u l=0.13u
X1325 vss.t1894 vdd.t1731 vss.t1893 vss.t1892 sg13_lv_nmos ad=0.1428p pd=1.52u as=0 ps=0 w=0.42u l=1u
X1326 vss.t1352 vss.t1353 vss.t531 rhigh l=2.75u w=0.5u
X1327 vdd.t1062 d_dith_en.t4 a_2079_1938# vdd.t507 sg13_lv_pmos ad=0.1563p pd=1.22u as=0.147p ps=1.54u w=0.42u l=0.13u
X1328 a_522_12552# a_533_12512# a_522_12886# vss.t863 sg13_lv_nmos ad=0.3473p pd=2.71u as=0.12665p ps=1.145u w=0.74u l=0.13u
X1329 vdd.t499 vss.t2331 vdd.t67 vdd.t65 sg13_lv_pmos ad=0.19p pd=1.38u as=0 ps=0 w=1u l=1u
X1330 a_2034_6262# a_2049_4965# a_2034_5928# vdd.t507 sg13_lv_pmos ad=0.2048p pd=1.63u as=0.34p ps=2.68u w=1u l=0.13u
X1331 xq_vg_q_1_.t2 sg13cmos5l_inv_1_4.Y.t3 a_6249_9100.t13 vss.t980 sg13_lv_nmos ad=95f pd=0.88u as=0.17p ps=1.68u w=0.5u l=0.13u
X1332 vss.t1165 vss.t1166 vss.t39 rhigh l=2.75u w=0.5u
X1333 vdd.t713 a_526_16657# quantizer2_lfsr_0.sg13cmos5l_dfrbpq_1_11.D.t1 vdd.t504 sg13_lv_pmos ad=0.3808p pd=2.92u as=0.2408p ps=1.55u w=1.12u l=0.13u
X1334 vdd.t128 vss.t2276 vdd.t201 vdd.t126 sg13_lv_pmos ad=0.19p pd=1.38u as=0 ps=0 w=1u l=1u
X1335 a_2079_9714# a_2049_10149# a_2461_10089# vdd.t507 sg13_lv_pmos ad=79.8f pd=0.8u as=63f ps=0.72u w=0.42u l=0.13u
X1336 vdd.t210 vss.t2348 vdd.t209 vdd.t88 sg13_lv_pmos ad=0.34p pd=2.68u as=0 ps=0 w=1u l=1u
X1337 xsc_vc1l_n.t4 d_phi1.t4 sw_tgate_6.p.t4 vss.t911 sg13_lv_nmos ad=0.19p pd=1.38u as=0.34p ps=2.68u w=1u l=1u
X1338 xsc_xcmfb1_vsw_vbias.t5 vss.t303 xsc_xcmfb1_vsw_vbias.t4 vss.t304 sg13_lv_nmos ad=0.17p pd=1.68u as=0 ps=0 w=0.5u l=1u
X1339 sw_tgate_8.m.t9 d_qi.t6 sw_tgate_8.m.t8 vss.t1014 sg13_lv_nmos ad=0.19p pd=1.38u as=0 ps=0 w=1u l=1u
X1340 a_10787_14878# inv_en_0.di_b.t2 a_11017_14934# vss.t981 sg13_lv_nmos ad=0.2176p pd=1.96u as=0.1216p ps=1.02u w=0.64u l=0.13u
X1341 bias_gm_0.bias_trim_0.iout a_21252_3394# dsm2_osc_0.ibias_in.t3 vdd.t384 sg13_lv_pmos ad=95f pd=0.88u as=95f ps=0.88u w=0.5u l=5u
X1342 a_22738_2578# a_21554_2798# vdd.t645 vdd.t514 sg13_lv_pmos ad=0.17p pd=1.68u as=95f ps=0.88u w=0.5u l=0.5u
X1343 vss.t1225 dsm2_io_0.sg13cmos5l_inv_1_3.A quantizer2_lfsr_0.di_dith_amp[1].t0 vss.t467 sg13_lv_nmos ad=0.2516p pd=2.16u as=0.2516p ps=2.16u w=0.74u l=0.13u
X1344 vdd.t577 bias_gm_0.bias_trim_0.vz.t6 bias_gm_0.bias_trim_0.vz.t7 vdd.t573 sg13_lv_pmos ad=95f pd=0.88u as=95f ps=0.88u w=0.5u l=5u
X1345 vdd.t459 vss.t2334 vdd.t211 vdd.t65 sg13_lv_pmos ad=0.34p pd=2.68u as=0 ps=0 w=1u l=1u
X1346 vdd.t1113 di_dith_amp[0] dsm2_io_0.sg13cmos5l_inv_1_4.A vdd.t25 sg13_hv_pmos ad=0.17p pd=1.68u as=0.17p ps=1.68u w=0.5u l=1u
X1347 a_24404_8546# bias_gm_0.bias_trim_0.vz.t46 vdd.t952 vdd.t572 sg13_lv_pmos ad=95f pd=0.88u as=95f ps=0.88u w=0.5u l=5u
X1348 d_amp_s[1].t0 quantizer2_lfsr_0.di_dith_amp[1].t3 vss.t458 vss.t457 sg13_lv_nmos ad=0.1406p pd=1.12u as=0.2516p ps=2.16u w=0.74u l=0.13u
X1349 a_22258_909# a_22000_594# vdd.t515 vdd.t515 sg13_lv_pmos ad=93.45f pd=0.865u as=1.93285p ps=12.62u w=0.42u l=0.13u
X1350 a_1320_16970# quantizer2_lfsr_0.di_dith_amp[1].t3 vdd.t613 vdd.t504 sg13_lv_pmos ad=0.1176p pd=1.33u as=0.4032p ps=2.96u w=1.12u l=0.13u
X1351 a_22138_15446# a_20138_14766# a_20070_15446# vdd.t897 sg13_lv_pmos ad=95f pd=0.88u as=0.17p ps=1.68u w=0.5u l=10u
X1352 vdd.t786 a_5176_31117# vdd.t787 vdd.t764 sg13_lv_pmos ad=0.465p pd=1.93u as=0 ps=0 w=1u l=2u
X1353 vss.t720 xsc_vfb.t12 a_7804_29739.t5 vss.t106 sg13_lv_nmos ad=95f pd=0.88u as=95f ps=0.88u w=0.5u l=3u
X1354 vdd.t1056 di_rst_b dsm2_io_0.sg13cmos5l_inv_1_6.A vdd.t25 sg13_hv_pmos ad=0.17p pd=1.68u as=0.17p ps=1.68u w=0.5u l=1u
X1355 vdd.t703 quantizer2_lfsr_0.sg13cmos5l_dfrbpq_1_2.Q.t2 a_2034_698# vdd.t507 sg13_lv_pmos ad=0.2114p pd=1.54u as=0.2856p ps=2.36u w=0.84u l=0.13u
X1356 vss.t376 a_8768_15909# sg13cmos5l_and2_1_4.X vss.t563 sg13_lv_nmos ad=0.1331p pd=1.12u as=0.2516p ps=2.16u w=0.74u l=0.13u
X1357 vss.t862 sg13cmos5l_inv_1_11.Y sg13cmos5l_inv_2_4.Y vss.t861 sg13_lv_nmos ad=0.2516p pd=2.16u as=0.1406p ps=1.12u w=0.74u l=0.13u
X1358 d_amp_s[2].t0 quantizer2_lfsr_0.sg13cmos5l_nor2_1_0.A vss.t1279 vss.t664 sg13_lv_nmos ad=0.1406p pd=1.12u as=0.2516p ps=2.16u w=0.74u l=0.13u
X1359 do_osc_oe.t0 dsm2_osc_0.dsm2_io_rx_1.di_b vdd.t635 vdd.t515 sg13_lv_pmos ad=0.3808p pd=2.92u as=0.3808p ps=2.92u w=1.12u l=0.13u
X1360 quantizer2_lfsr_0.sg13cmos5l_dfrbpq_1_11.Q.t0 a_1284_2901# vss.t237 vss.t634 sg13_lv_nmos ad=0.2516p pd=2.16u as=0.1406p ps=1.12u w=0.74u l=0.13u
X1361 quantizer2_lfsr_0.sg13cmos5l_dfrbpq_1_7.D a_522_10677# vss.t1332 vss.t1331 sg13_lv_nmos ad=0.2516p pd=2.16u as=0.1406p ps=1.12u w=0.74u l=0.13u
X1362 vss.t1827 vdd.t1747 vss.t1828 vss.t1814 sg13_lv_nmos ad=79.8f pd=0.8u as=0 ps=0 w=0.42u l=1u
X1363 vss.t23 a_22184_2052# vss.t22 vss.t21 sg13_lv_nmos ad=95f pd=0.88u as=0 ps=0 w=0.5u l=0.5u
X1364 vss.t232 a_7993_7200# a_8105_7224# vss.t888 sg13_lv_nmos ad=0.1426p pd=1.16u as=0.1428p ps=1.52u w=0.42u l=0.5u
X1365 vss.t464 clk_noverlap_0.sg13cmos5l_dlygate4sd3_1_1.X a_5995_7241# vss.t85 sg13_lv_nmos ad=79.8f pd=0.8u as=0.1428p ps=1.52u w=0.42u l=0.13u
X1366 vss.t1696 vdd.t1778 vss.t1695 vss.t1694 sg13_lv_nmos ad=0.1428p pd=1.52u as=0 ps=0 w=0.42u l=1u
X1367 sw_tgate_10.p.t7 d_qi_b.t9 sw_tgate_10.p.t6 vdd.t561 sg13_lv_pmos ad=0.38p pd=2.38u as=0 ps=0 w=2u l=1u
X1368 vdd.t836 a_5176_31117# vdd.t834 vdd.t764 sg13_lv_pmos ad=0.19p pd=1.38u as=0 ps=0 w=1u l=2u
X1369 a_22252_8246# bias_gm_0.bias_trim_0.vz.t37 vdd.t1153 vdd.t566 sg13_lv_pmos ad=95f pd=0.88u as=95f ps=0.88u w=0.5u l=5u
X1370 vdd.t1385 vdd.t1383 vdd.t1181 vdd.t1287 sg13_lv_pmos ad=0.17p pd=1.68u as=0 ps=0 w=0.5u l=5u
X1371 vdd.t328 vss.t2158 vdd.t327 vdd.t308 sg13_lv_pmos ad=0.34p pd=2.68u as=0 ps=0 w=1u l=1u
X1372 vss.t381 vss.t379 vss.t380 vss.t367 sg13_lv_nmos ad=1.36p pd=8.68u as=0 ps=0 w=4u l=0.5u
X1373 sw_tgate_12.m.t0 sw_tgate_9.gb.t3 xsc_vc1l_p.t3 vdd.t561 sg13_lv_pmos ad=0.38p pd=2.38u as=0.38p ps=2.38u w=2u l=1u
X1374 sg13cmos5l_inv_1_3.Y.t0 sg13cmos5l_inv_1_3.A.t4 vss.t719 vss.t718 sg13_lv_nmos ad=0.2516p pd=2.16u as=0.2516p ps=2.16u w=0.74u l=0.13u
X1375 a_1367_6345# a_1324_5988# vdd.t910 vdd.t504 sg13_lv_pmos ad=63f pd=0.72u as=0.1563p ps=1.22u w=0.42u l=0.13u
X1376 vdd.t1512 vdd.t1498 vdd.t1514 vdd.t1173 sg13_lv_pmos ad=95f pd=0.88u as=0 ps=0 w=0.5u l=5u
X1377 vss.t1764 vdd.t1762 vss.t1761 vss.t1763 sg13_lv_nmos ad=79.8f pd=0.8u as=0 ps=0 w=0.42u l=1u
X1378 vdd.t860 dsm2_io_0.sg13cmos5l_inv_1_5.A dsm2_io_0.do_btest_en.t1 vdd.t617 sg13_lv_pmos ad=0.3808p pd=2.92u as=0.3808p ps=2.92u w=1.12u l=0.13u
X1379 a_2034_11112# a_2079_9714# vdd.t1065 vdd.t507 sg13_lv_pmos ad=0.34p pd=2.68u as=0.36237p ps=2.605u w=1u l=0.13u
X1380 ibias_200n.t1 dsm2_io_0.do_trim_b[3].t3 a_22252_7946# vdd.t573 sg13_lv_pmos ad=95f pd=0.88u as=95f ps=0.88u w=0.5u l=5u
X1381 vss.t964 sg13cmos5l_and2_2_1.X.t2 a_9357_11104.t1 vss.t385 sg13_lv_nmos ad=0.76p pd=4.38u as=0.76p ps=4.38u w=4u l=0.5u
X1382 a_9533_11104.t0 vo_p.t24 a_9357_11104.t2 vss.t28 sg13_lv_nmos ad=0.76p pd=4.38u as=0.76p ps=4.38u w=4u l=0.5u
X1383 vi_esd.t9 sw_tgate_9.gb.t2 xsc_vc1l_n.t0 vdd.t562 sg13_lv_pmos ad=0.68p pd=4.68u as=0.38p ps=2.38u w=2u l=1u
X1384 a_6257_8400.t1 a_5798_8400.t1 vss.t676 rhigh l=4.08u w=0.5u
X1385 vdd.t1065 d_dith_en.t22 a_2070_9446# vdd.t507 sg13_lv_pmos ad=0.36237p pd=2.605u as=79.8f ps=0.8u w=0.42u l=0.13u
X1386 a_7224_31505# a_5176_31117# vdd.t809 vdd.t764 sg13_lv_pmos ad=0.19p pd=1.38u as=0.19p ps=1.38u w=1u l=2u
X1387 vo_n.t5 d_phi1.t8 vo_n.t8 vdd.t678 sg13_lv_pmos ad=0.285p pd=1.88u as=0 ps=0 w=1.5u l=1u
X1388 vss.t1051 vss.t1052 vss.t527 rhigh l=9.28u w=0.5u
X1389 vdd.t193 vss.t2180 vdd.t192 vdd.t82 sg13_lv_pmos ad=0.19p pd=1.38u as=0 ps=0 w=1u l=1u
X1390 a_558_8388# quantizer2_lfsr_0.sg13cmos5l_dfrbpq_1_8.D a_558_8294# vss.t702 sg13_lv_nmos ad=60.89999f pd=0.71u as=0.1428p ps=1.52u w=0.42u l=0.13u
X1391 vdd.t1083 d_dith_en.t28 a_2070_12038# vdd.t507 sg13_lv_pmos ad=0.36237p pd=2.605u as=79.8f ps=0.8u w=0.42u l=0.13u
X1392 vss.t27 a_19949_784# clk_noverlap_0.di_clk.t0 vss.t26 sg13_lv_nmos ad=0.1371p pd=1.12u as=0.1406p ps=1.12u w=0.74u l=0.13u
X1393 vss.t1264 vss.t1265 vss.t207 rhigh l=17.5u w=0.5u
X1394 vdd.t666 a_7129_7200# a_7241_7224# vdd.t308 sg13_lv_pmos ad=0.2254p pd=1.53u as=0.34p ps=2.68u w=1u l=0.5u
X1395 vss.t1966 vdd.t1714 vss.t1965 vss.t1964 sg13_lv_nmos ad=0.1428p pd=1.52u as=0 ps=0 w=0.42u l=1u
X1396 sg13cmos5l_inv_1_16.A.t1 d_dith[2].t2 vdd.t1624 vdd.t502 sg13_lv_pmos ad=0.2128p pd=1.5u as=0.3808p ps=2.92u w=1.12u l=0.13u
X1397 sg13cmos5l_inv_1_14.A.t3 sg13cmos5l_and2_2_1.X.t3 vdd.t962 vdd.t863 sg13_lv_pmos ad=0.285p pd=1.88u as=0.285p ps=1.88u w=1.5u l=0.5u
X1398 vss.t357 vss.t355 vss.t356 vss.t262 sg13_hv_nmos ad=0.17p pd=1.68u as=0 ps=0 w=0.5u l=10u
X1399 a_22252_11246# bias_gm_0.bias_trim_0.vz.t3 vdd.t1184 vdd.t287 sg13_lv_pmos ad=95f pd=0.88u as=95f ps=0.88u w=0.5u l=5u
X1400 a_20672_21020# a_24258_20880# vss.t207 rhigh l=17.5u w=0.5u
X1401 vdd.t80 vss.t2251 vdd.t200 vdd.t79 sg13_lv_pmos ad=0.34p pd=2.68u as=0 ps=0 w=1u l=1u
X1402 vss.t1898 vdd.t1730 vss.t1899 vss.t1885 sg13_lv_nmos ad=79.8f pd=0.8u as=0 ps=0 w=0.42u l=1u
X1403 vdd.t1338 vdd.t1309 vdd.t1341 vdd.t863 sg13_lv_pmos ad=0.285p pd=1.88u as=0 ps=0 w=1.5u l=0.5u
X1404 a_17035_5500# d_phi2.t2 a_16941_5500# vss.t206 sg13_lv_nmos ad=0.1216p pd=1.02u as=0.2176p ps=1.96u w=0.64u l=0.13u
X1405 vdd.t1295 d_ena.t8 a_15491_15614# vdd.t502 sg13_lv_pmos ad=0.2856p pd=2.36u as=0.1596p ps=1.22u w=0.84u l=0.13u
X1406 a_1367_6533# a_1322_6770# a_1288_5962# vdd.t504 sg13_lv_pmos ad=0.1428p pd=1.52u as=79.8f ps=0.8u w=0.42u l=0.13u
X1407 clk_noverlap_0.sg13cmos5l_inv_1_10.A d_phi1.t2 vss.t904 vss.t903 sg13_lv_nmos ad=0.2618p pd=2.22u as=0.1463p ps=1.15u w=0.77u l=0.13u
X1408 a_11841_7467# a_11956_7466# vdd.t695 vdd.t308 sg13_lv_pmos ad=0.34p pd=2.68u as=0.2254p ps=1.53u w=1u l=0.5u
X1409 quantizer2_lfsr_0.sg13cmos5l_dfrbpq_1_4.Q a_2034_9237# vss.t128 vss.t127 sg13_lv_nmos ad=0.2516p pd=2.16u as=0.1406p ps=1.12u w=0.74u l=0.13u
X1410 vss.t748 a_5176_30111# vss.t750 vss.t749 sg13_lv_nmos ad=0.365p pd=1.96u as=0 ps=0 w=0.5u l=3u
X1411 vss.t1708 vdd.t1775 vss.t1709 vss.t1705 sg13_lv_nmos ad=79.8f pd=0.8u as=0 ps=0 w=0.42u l=1u
X1412 vss.t95 sg13cmos5l_and2_1_5.B.t3 a_8107_14934# vss.t94 sg13_lv_nmos ad=0.1331p pd=1.12u as=0.1216p ps=1.02u w=0.64u l=0.13u
X1413 vss.t36 d_qi.t3 d_qi_b.t1 vss.t1023 sg13_lv_nmos ad=0.1406p pd=1.12u as=0.1406p ps=1.12u w=0.74u l=0.13u
X1414 xsc_xcmfb1_vsw_cm_n.t1 d_phi2.t12 vcm_esd.t15 vss.t189 sg13_lv_nmos ad=95f pd=0.88u as=95f ps=0.88u w=0.5u l=1u
X1415 vss.t247 a_21554_2052.t10 a_21478_2344# vss.t246 sg13_lv_nmos ad=95f pd=0.88u as=0.17p ps=1.68u w=0.5u l=0.5u
X1416 a_2070_6854# a_2045_8480# a_2079_7122# vdd.t507 sg13_lv_pmos ad=0.1428p pd=1.52u as=79.8f ps=0.8u w=0.42u l=0.13u
X1417 xsc_vfb.t6 sw_tgate_cmfb2_3.gb.t2 xsc_vfb.t3 vss.t1220 sg13_lv_nmos ad=95f pd=0.88u as=0 ps=0 w=0.5u l=1u
X1418 vdd.t439 vss.t2288 vdd.t350 vdd.t116 sg13_lv_pmos ad=0.19p pd=1.38u as=0 ps=0 w=1u l=1u
X1419 clk_noverlap_0.di_clk.t1 a_19949_784# vdd.t516 vdd.t515 sg13_lv_pmos ad=0.2128p pd=1.5u as=0.7336p ps=3.55u w=1.12u l=0.13u
X1420 a_4362_8188.t13 sg13cmos5l_or2_1_0.X.t2 xq_dith_v_bp.t9 vss.t717 sg13_lv_nmos ad=0.665p pd=3.88u as=0.665p ps=3.88u w=3.5u l=0.13u
X1421 vdd.t1226 a_12445_30191# a_5176_31117# vdd.t764 sg13_lv_pmos ad=0.34p pd=2.68u as=0.34p ps=2.68u w=1u l=2u
X1422 sw_tgate_8.m.t3 d_phi1.t3 sw_tgate_8.m.t5 vdd.t562 sg13_lv_pmos ad=0.68p pd=4.68u as=0 ps=0 w=2u l=1u
X1423 vdd.t735 bias_gm_0.bias_trim_0.vz.t22 a_22252_5274# vdd.t573 sg13_lv_pmos ad=95f pd=0.88u as=95f ps=0.88u w=0.5u l=5u
X1424 vss.t1973 vdd.t1713 vss.t1971 vss.t1972 sg13_lv_nmos ad=79.8f pd=0.8u as=0 ps=0 w=0.42u l=1u
X1425 vss.t738 a_5176_30111# vss.t737 vss.t61 sg13_lv_nmos ad=0.17p pd=1.68u as=0 ps=0 w=0.5u l=3u
X1426 a_522_15144# a_567_13746# vdd.t1071 vdd.t504 sg13_lv_pmos ad=0.34p pd=2.68u as=0.36237p ps=2.605u w=1u l=0.13u
X1427 vss.t638 dsm2_osc_0.sg13cmos5l_dfrbp_1_0.CLK a_22499_864# vss.t637 sg13_lv_nmos ad=3.63417p pd=24.185u as=0.2516p ps=2.16u w=0.74u l=0.13u
X1428 vdd.t1120 sg13cmos5l_inv_2_5.A sg13cmos5l_inv_2_5.Y vdd.t502 sg13_lv_pmos ad=0.3864p pd=2.93u as=0.2128p ps=1.5u w=1.12u l=0.13u
X1429 vdd.t1071 d_dith_en.t33 a_558_13478# vdd.t504 sg13_lv_pmos ad=0.36237p pd=2.605u as=79.8f ps=0.8u w=0.42u l=0.13u
X1430 a_2034_8854# a_2049_7557# a_2070_8622# vss.t222 sg13_lv_nmos ad=0.12665p pd=1.145u as=0.1428p ps=1.52u w=0.42u l=0.13u
X1431 vss.t961 dsm2_io_0.dsm2_io_rx_9.di_b.t3 a_1502_28364# vss.t960 sg13_hv_nmos ad=0.19p pd=1.38u as=0.19p ps=1.38u w=1u l=0.45u
X1432 vdd.t118 vss.t2312 vdd.t117 vdd.t116 sg13_lv_pmos ad=0.19p pd=1.38u as=0 ps=0 w=1u l=1u
X1433 sw_tgate_cmfb2_1.p.t4 sw_tgate_cmfb2_1.gb.t2 sw_tgate_cmfb2_1.p.t5 vss.t984 sg13_lv_nmos ad=95f pd=0.88u as=0 ps=0 w=0.5u l=1u
X1434 xq_dith_v_bp.t8 sg13cmos5l_or2_1_0.X.t2 a_4362_8188.t11 vss.t717 sg13_lv_nmos ad=0.665p pd=3.88u as=0.665p ps=3.88u w=3.5u l=0.13u
X1435 a_1284_5391# a_1286_4247# a_1681_4561# vss.t2115 sg13_lv_nmos ad=0.12665p pd=1.145u as=0.1428p ps=1.52u w=0.42u l=0.13u
X1436 a_2079_9714# a_2049_10149# a_2070_9446# vss.t797 sg13_lv_nmos ad=79.8f pd=0.8u as=0.1296p ps=1.52u w=0.42u l=0.13u
X1437 a_8762_31505# a_5176_31469# vo_p.t21 vdd.t764 sg13_lv_pmos ad=0.665p pd=3.88u as=1.19p ps=7.68u w=3.5u l=2u
X1438 a_5176_30111# a_5176_30111# sw_tgate_cmfb2_1.p.t6 vss.t780 sg13_lv_nmos ad=0.17p pd=1.68u as=0.17p ps=1.68u w=0.5u l=3u
X1439 a_949_14121# a_522_15144# vdd.t751 vdd.t504 sg13_lv_pmos ad=63f pd=0.72u as=0.1563p ps=1.22u w=0.42u l=0.13u
X1440 vdd.t1573 vdd.t1571 vdd.t937 vdd.t1287 sg13_lv_pmos ad=0.17p pd=1.68u as=0 ps=0 w=0.5u l=5u
X1441 vdd.t762 d_qout_en.t2 a_10989_15998# vdd.t502 sg13_lv_pmos ad=0.1918p pd=1.5u as=0.1596p ps=1.22u w=0.84u l=0.13u
X1442 vdd.t294 vss.t2423 vdd.t293 vdd.t0 sg13_lv_pmos ad=0.34p pd=2.68u as=0 ps=0 w=1u l=1u
X1443 vdd.t779 a_5176_31117# vdd.t780 vdd.t764 sg13_lv_pmos ad=0.19p pd=1.38u as=0 ps=0 w=1u l=2u
X1444 vss.t2059 vdd.t1695 vss.t2058 vss.t2057 sg13_lv_nmos ad=0.1428p pd=1.52u as=0 ps=0 w=0.42u l=1u
X1445 vdd.t172 vss.t2315 vdd.t354 vdd.t116 sg13_lv_pmos ad=0.34p pd=2.68u as=0 ps=0 w=1u l=1u
X1446 a_20673_598# do_osc_oe.t2 vss.t1382 vss.t1383 sg13_lv_nmos ad=0.13135p pd=1.095u as=0.18945p ps=1.27u w=0.74u l=0.13u
X1447 a_19984_17824# bias_gm_0.bias_trim_0.vz.t50 vdd.t925 vdd.t566 sg13_lv_pmos ad=95f pd=0.88u as=95f ps=0.88u w=0.5u l=5u
X1448 clk_noverlap_0.sg13cmos5l_dlygate4sd3_1_0.X a_4649_7224# vss.t8 vss.t614 sg13_lv_nmos ad=0.2516p pd=2.16u as=0.1426p ps=1.16u w=0.74u l=0.13u
X1449 a_24540_19480# a_28126_19620# vss.t34 rhigh l=17.5u w=0.5u
X1450 vdd.t161 vss.t2220 vdd.t160 vdd.t159 sg13_lv_pmos ad=0.19p pd=1.38u as=0 ps=0 w=1u l=1u
X1451 vss.t152 dsm2_osc_0.sg13cmos5l_dfrbp_1_0.RESET_B.t8 a_21775_1704# vss.t250 sg13_lv_nmos ad=0.1331p pd=1.12u as=0.1216p ps=1.02u w=0.64u l=0.13u
X1452 clk_noverlap_0.sg13cmos5l_dlygate4sd3_1_4.X a_8969_7224# vdd.t890 vdd.t308 sg13_lv_pmos ad=0.4256p pd=3u as=0.2254p ps=1.53u w=1.12u l=0.13u
X1453 a_2083_7366# d_dith_en.t16 vss.t1114 vss.t610 sg13_lv_nmos ad=37.8f pd=0.6u as=0.1701p ps=1.65u w=0.42u l=0.13u
X1454 vss.t1884 vdd.t1733 vss.t1886 vss.t1885 sg13_lv_nmos ad=79.8f pd=0.8u as=0 ps=0 w=0.42u l=1u
X1455 a_23674_2578# a_21452_2308.t5 vdd.t1617 vdd.t514 sg13_lv_pmos ad=95f pd=0.88u as=0.17p ps=1.68u w=0.5u l=0.5u
X1456 a_6452_29739.t1 a_5176_30111# vo_p.t7 vss.t743 sg13_lv_nmos ad=95f pd=0.88u as=95f ps=0.88u w=0.5u l=3u
X1457 vdd.t376 vss.t2275 vdd.t375 vdd.t126 sg13_lv_pmos ad=0.34p pd=2.68u as=0 ps=0 w=1u l=1u
X1458 vdd.t1172 bias_gm_0.bias_trim_0.vz.t34 a_22252_4074# vdd.t570 sg13_lv_pmos ad=95f pd=0.88u as=95f ps=0.88u w=0.5u l=5u
X1459 vss.t420 vss.t419 a_9357_11104.t3 vss.t410 sg13_lv_nmos ad=0.76p pd=4.38u as=0.76p ps=4.38u w=4u l=0.5u
X1460 vss.t74 sw_tgate_cmfb2_1.p.t8 vss.t111 vss.t110 sg13_lv_nmos ad=95f pd=0.88u as=0 ps=0 w=0.5u l=3u
X1461 a_24540_21160# a_28126_21300# vss.t34 rhigh l=17.5u w=0.5u
X1462 sg13cmos5l_and2_2_1.X.t1 a_10787_14878# vdd.t1615 vdd.t502 sg13_lv_pmos ad=0.2128p pd=1.5u as=0.4256p ps=3u w=1.12u l=0.13u
X1463 vss.t1344 vss.t1345 vss.t39 rhigh l=2.75u w=0.5u
X1464 clk_noverlap_0.sg13cmos5l_inv_1_8.A clk_noverlap_0.sg13cmos5l_inv_1_9.A vdd.t1253 vdd.t308 sg13_lv_pmos ad=0.3808p pd=2.92u as=0.3808p ps=2.92u w=1.12u l=0.13u
X1465 vdd.t674 clk_noverlap_0.sg13cmos5l_inv_1_0.Y a_10198_6736# vdd.t308 sg13_lv_pmos ad=0.3808p pd=2.92u as=0.2464p ps=1.56u w=1.12u l=0.13u
X1466 xsc_xcmfb1_vsw_cm_n.t13 vdd.t1304 xsc_xcmfb1_vsw_cm_n.t11 vdd.t560 sg13_lv_pmos ad=0.285p pd=1.88u as=0 ps=0 w=1.5u l=1u
X1467 vdd.t402 vss.t2223 vdd.t270 vdd.t159 sg13_lv_pmos ad=0.34p pd=2.68u as=0 ps=0 w=1u l=1u
X1468 vdd.t1154 bias_gm_0.bias_trim_0.vz.t37 a_22252_8246# vdd.t384 sg13_lv_pmos ad=95f pd=0.88u as=95f ps=0.88u w=0.5u l=5u
X1469 xq_vg_p_2_.t0 sg13cmos5l_inv_1_17.Y.t2 a_5892_8400.t8 vss.t838 sg13_lv_nmos ad=95f pd=0.88u as=0.17p ps=1.68u w=0.5u l=0.13u
X1470 vdd.t427 vss.t2188 vdd.t431 vdd.t290 sg13_lv_pmos ad=0.19p pd=1.38u as=0 ps=0 w=1u l=1u
X1471 a_537_8997# d_qclk.t13 vdd.t511 vdd.t504 sg13_lv_pmos ad=0.4088p pd=2.97u as=1.1847p ps=7.385u w=1.12u l=0.13u
X1472 vss.t646 vss.t647 vss.t39 rhigh l=2.75u w=0.5u
X1473 a_14266_14856# sg13cmos5l_inv_1_0.Y vdd.t858 vdd.t502 sg13_lv_pmos ad=0.1428p pd=1.52u as=0.1523p ps=1.38u w=0.42u l=0.13u
X1474 vdd.t640 quantizer2_lfsr_0.sg13cmos5l_dfrbpq_1_11.Q.t2 a_2034_1082# vdd.t507 sg13_lv_pmos ad=0.2114p pd=1.54u as=0.2856p ps=2.36u w=0.84u l=0.13u
X1475 a_11115_9168# a_13211_9028# vss.t6 rhigh l=10.05u w=0.5u
X1476 vdd.t450 vss.t2343 vdd.t316 vdd.t88 sg13_lv_pmos ad=0.19p pd=1.38u as=0 ps=0 w=1u l=1u
X1477 vss.t1750 vdd.t1765 vss.t1749 vss.t1748 sg13_lv_nmos ad=0.1428p pd=1.52u as=0 ps=0 w=0.42u l=1u
X1478 a_23294_2578# a_22644_2344# a_21452_2308.t1 vdd.t514 sg13_lv_pmos ad=95f pd=0.88u as=0.17p ps=1.68u w=0.5u l=0.13u
X1479 a_522_7538# d_dith_en.t18 vdd.t511 vdd.t504 sg13_lv_pmos ad=79.8f pd=0.8u as=1.1847p ps=7.385u w=0.42u l=0.13u
X1480 a_567_11154# a_537_11589# a_558_10886# vss.t1294 sg13_lv_nmos ad=79.8f pd=0.8u as=0.1296p ps=1.52u w=0.42u l=0.13u
X1481 a_558_13478# a_533_15104# a_567_13746# vdd.t504 sg13_lv_pmos ad=0.1428p pd=1.52u as=79.8f ps=0.8u w=0.42u l=0.13u
X1482 a_567_8562# a_537_8997# a_949_8937# vdd.t504 sg13_lv_pmos ad=79.8f pd=0.8u as=63f ps=0.72u w=0.42u l=0.13u
X1483 vdd.t781 a_5176_31117# vdd.t782 vdd.t764 sg13_lv_pmos ad=0.19p pd=1.38u as=0 ps=0 w=1u l=2u
X1484 vdd.t1456 vdd.t1454 vdd.t951 vdd.t1287 sg13_lv_pmos ad=0.17p pd=1.68u as=0 ps=0 w=0.5u l=5u
X1485 quantizer2_lfsr_0.sg13cmos5l_dfrbpq_1_14.D a_1284_10677# vss.t704 vss.t703 sg13_lv_nmos ad=0.2516p pd=2.16u as=0.1406p ps=1.12u w=0.74u l=0.13u
X1486 a_22252_8246# vss.t2174 ibias_200n.t1 vdd.t287 sg13_lv_pmos ad=95f pd=0.88u as=95f ps=0.88u w=0.5u l=5u
X1487 vdd.t724 a_2034_11446# a_2034_11829# vdd.t507 sg13_lv_pmos ad=0.2128p pd=1.5u as=0.3864p ps=2.93u w=1.12u l=0.13u
X1488 vss.t60 a_6817_30111# a_5176_30111# vss.t1253 sg13_lv_nmos ad=95f pd=0.88u as=0.17p ps=1.68u w=0.5u l=3u
X1489 vdd.t930 bias_gm_0.bias_trim_0.vz.t50 a_19984_17824# vdd.t570 sg13_lv_pmos ad=95f pd=0.88u as=95f ps=0.88u w=0.5u l=5u
X1490 a_19984_17824# bias_gm_0.bias_trim_0.vz.t53 vdd.t932 vdd.t572 sg13_lv_pmos ad=95f pd=0.88u as=95f ps=0.88u w=0.5u l=5u
X1491 a_16557_7164# clk_noverlap_0.sg13cmos5l_dlygate4sd3_1_12.A vdd.t896 vdd.t308 sg13_lv_pmos ad=0.1428p pd=1.52u as=0.1523p ps=1.38u w=0.42u l=0.13u
X1492 vss.t754 a_5176_30111# vss.t756 vss.t755 sg13_lv_nmos ad=95f pd=0.88u as=0 ps=0 w=0.5u l=3u
X1493 quantizer2_lfsr_0.sg13cmos5l_dfrbpq_1_9.D a_522_5493# vdd.t510 vdd.t504 sg13_lv_pmos ad=0.3808p pd=2.92u as=0.2128p ps=1.5u w=1.12u l=0.13u
X1494 sg13cmos5l_and2_2_1.X.t0 a_10787_14878# vss.t2068 vss.t2067 sg13_lv_nmos ad=0.1406p pd=1.12u as=0.2812p ps=2.24u w=0.74u l=0.13u
X1495 vss.t281 vss.t271 vss.t280 vss.t272 sg13_hv_nmos ad=3.4p pd=20.68u as=0 ps=0 w=10u l=1u
X1496 vdd.t1592 vdd.t1590 vdd.t1594 vdd.t566 sg13_lv_pmos ad=95f pd=0.88u as=0 ps=0 w=0.5u l=5u
X1497 vdd.t758 a_1284_15759# a_1284_15861# vdd.t504 sg13_lv_pmos ad=0.2128p pd=1.5u as=0.3864p ps=2.93u w=1.12u l=0.13u
X1498 vss.t845 a_19984_17824# a_22252_11246# vss.t267 sg13_hv_nmos ad=95f pd=0.88u as=95f ps=0.88u w=0.5u l=10u
X1499 vdd.t400 vss.t2211 vdd.t124 vdd.t123 sg13_lv_pmos ad=0.34p pd=2.68u as=0 ps=0 w=1u l=1u
X1500 vss.t1607 vdd.t1800 vss.t1609 vss.t1608 sg13_lv_nmos ad=79.8f pd=0.8u as=0 ps=0 w=0.42u l=1u
X1501 vss.t841 sg13cmos5l_inv_1_19.Y.t3 xq_vg_p_1_.t0 vss.t840 sg13_lv_nmos ad=95f pd=0.88u as=0.17p ps=1.68u w=0.5u l=0.13u
X1502 a_9533_11104.t5 sg13cmos5l_and2_2_1.X.t4 vdd.t973 vdd.t863 sg13_lv_pmos ad=0.285p pd=1.88u as=0.285p ps=1.88u w=1.5u l=0.5u
X1503 vdd.t92 vss.t2299 vdd.t91 vdd.t62 sg13_lv_pmos ad=0.34p pd=2.68u as=0 ps=0 w=1u l=1u
X1504 vss.t75 sw_tgate_cmfb2_1.p.t9 vss.t126 vss.t113 sg13_lv_nmos ad=0.17p pd=1.68u as=0 ps=0 w=0.5u l=3u
X1505 vdd.t842 a_5176_31117# vdd.t840 vdd.t764 sg13_lv_pmos ad=0.465p pd=1.93u as=0 ps=0 w=1u l=2u
X1506 xsc_xcmfb1_vsw_cm_n.t12 vdd.t1303 xsc_xcmfb1_vsw_cm_n.t2 vdd.t560 sg13_lv_pmos ad=0.51p pd=3.68u as=0 ps=0 w=1.5u l=1u
X1507 vdd.t1322 vdd.t1320 vdd.t975 vdd.t863 sg13_lv_pmos ad=0.285p pd=1.88u as=0 ps=0 w=1.5u l=0.5u
X1508 a_2034_5928# a_2045_5888# a_2034_6262# vss.t227 sg13_lv_nmos ad=0.3473p pd=2.71u as=0.12665p ps=1.145u w=0.74u l=0.13u
X1509 vdd.t1678 vss.t2362 vdd.t1677 vdd.t764 sg13_hv_pmos ad=0.425p pd=3.18u as=0 ps=0 w=1.25u l=4u
X1510 vss.t274 vss.t271 vss.t273 vss.t272 sg13_hv_nmos ad=3.4p pd=20.68u as=0 ps=0 w=10u l=1u
X1511 sw_tgate_6.p.t7 d_qi.t7 sw_tgate_6.p.t6 vdd.t562 sg13_lv_pmos ad=0.38p pd=2.38u as=0 ps=0 w=2u l=1u
X1512 a_22252_7946# bias_gm_0.bias_trim_0.vz.t46 vdd.t954 vdd.t287 sg13_lv_pmos ad=95f pd=0.88u as=95f ps=0.88u w=0.5u l=5u
X1513 vdd.t727 bias_gm_0.bias_trim_0.vz.t51 a_19984_17824# vdd.t384 sg13_lv_pmos ad=95f pd=0.88u as=95f ps=0.88u w=0.5u l=5u
X1514 vss.t481 a_1284_7983# a_1284_8085# vss.t480 sg13_lv_nmos ad=0.1406p pd=1.12u as=0.2516p ps=2.16u w=0.74u l=0.13u
X1515 vdd.t806 a_5176_31117# a_9348_31505# vdd.t764 sg13_lv_pmos ad=0.34p pd=2.68u as=0.19p ps=1.38u w=1u l=2u
X1516 sw_tgate_8.m.t2 sw_tgate_11.gb.t2 xsc_vc1l_n.t11 vdd.t562 sg13_lv_pmos ad=0.68p pd=4.68u as=0.38p ps=2.38u w=2u l=1u
X1517 a_10729_15998# d_qout_en.t3 vss.t256 vss.t1183 sg13_lv_nmos ad=0.1216p pd=1.02u as=0.1331p ps=1.12u w=0.64u l=0.13u
X1518 a_22252_4074# bias_gm_0.bias_trim_0.vz.t22 vdd.t735 vdd.t287 sg13_lv_pmos ad=95f pd=0.88u as=95f ps=0.88u w=0.5u l=5u
X1519 a_571_1092# a_533_2144# a_567_786# vss.t498 sg13_lv_nmos ad=0.2373p pd=1.97u as=79.8f ps=0.8u w=0.42u l=0.13u
X1520 vdd.t718 a_14433_7467# clk_noverlap_0.sg13cmos5l_dlygate4sd3_1_7.A vdd.t308 sg13_lv_pmos ad=0.2254p pd=1.53u as=0.4256p ps=3u w=1.12u l=0.13u
X1521 a_6249_9100.t10 sg13cmos5l_inv_1_13.A.t2 xq_vg_p_0_.t2 vdd.t763 sg13_lv_pmos ad=0.17p pd=1.68u as=95f ps=0.88u w=0.5u l=0.13u
X1522 vss.t1137 d_dith_en.t3 a_558_612# vss.t1136 sg13_lv_nmos ad=0.1626p pd=1.415u as=60.89999f ps=0.71u w=0.42u l=0.13u
X1523 vss.t1143 di_dith_amp[0] dsm2_io_0.sg13cmos5l_inv_1_4.A vss.t1142 sg13_hv_nmos ad=0.34p pd=2.68u as=0.34p ps=2.68u w=1u l=0.45u
X1524 a_6452_29739.t0 a_5176_30111# vo_p.t6 vss.t739 sg13_lv_nmos ad=95f pd=0.88u as=0.17p ps=1.68u w=0.5u l=3u
X1525 do_q_dec.t1 sg13cmos5l_inv_1_7.Y vdd.t587 vdd.t502 sg13_lv_pmos ad=0.2128p pd=1.5u as=0.3808p ps=2.92u w=1.12u l=0.13u
X1526 a_2070_1670# quantizer2_lfsr_0.sg13cmos5l_dfrbpq_1_2.D.t2 vdd.t1619 vdd.t507 sg13_lv_pmos ad=79.8f pd=0.8u as=0.1428p ps=1.52u w=0.42u l=0.13u
X1527 vdd.t994 bias_gm_0.bias_trim_0.vz.t36 a_22252_7946# vdd.t570 sg13_lv_pmos ad=95f pd=0.88u as=95f ps=0.88u w=0.5u l=5u
X1528 d_amp_s_b[0].t1 d_amp_s[0].t4 vss.t729 vss.t728 sg13_lv_nmos ad=0.2516p pd=2.16u as=0.2516p ps=2.16u w=0.74u l=0.13u
X1529 vdd.t710 d_dith_en.t10 a_2079_4530# vdd.t507 sg13_lv_pmos ad=0.1563p pd=1.22u as=0.147p ps=1.54u w=0.42u l=0.13u
X1530 a_1745_11398# d_dith_en.t26 vss.t1068 vss.t1067 sg13_lv_nmos ad=37.8f pd=0.6u as=0.1701p ps=1.65u w=0.42u l=0.13u
X1531 vss.t78 xsc_vfb.t11 a_6452_29739.t8 vss.t73 sg13_lv_nmos ad=95f pd=0.88u as=95f ps=0.88u w=0.5u l=3u
X1532 vdd.t216 vss.t2292 vdd.t295 vdd.t102 sg13_lv_pmos ad=0.19p pd=1.38u as=0 ps=0 w=1u l=1u
X1533 vdd.t430 vss.t2198 vdd.t429 vdd.t173 sg13_lv_pmos ad=0.19p pd=1.38u as=0 ps=0 w=1u l=1u
X1534 vdd.t1075 a_15584_15091# sg13cmos5l_nand2_1_5.A.t1 vdd.t502 sg13_lv_pmos ad=0.1918p pd=1.5u as=0.3808p ps=2.92u w=1.12u l=0.13u
X1535 a_558_7666# d_dith_en.t18 vss.t929 vss.t1113 sg13_lv_nmos ad=37.8f pd=0.6u as=79.8f ps=0.8u w=0.42u l=0.13u
X1536 vdd.t1289 d_ena.t13 a_6817_30111# vdd.t764 sg13_lv_pmos ad=0.34p pd=2.68u as=0.34p ps=2.68u w=1u l=2u
X1537 vdd.t338 vss.t2287 vdd.t337 vdd.t116 sg13_lv_pmos ad=0.34p pd=2.68u as=0 ps=0 w=1u l=1u
X1538 a_20672_22140# a_24258_22000# vss.t207 rhigh l=17.5u w=0.5u
X1539 a_1367_6533# quantizer2_lfsr_0.sg13cmos5l_dfrbpq_1_12.Q vdd.t591 vdd.t504 sg13_lv_pmos ad=79.8f pd=0.8u as=0.1428p ps=1.52u w=0.42u l=0.13u
X1540 vdd.t731 vdd.t1406 vdd.t1407 vdd.t1173 sg13_lv_pmos ad=95f pd=0.88u as=0 ps=0 w=0.5u l=5u
X1541 a_1286_12023# d_qclk.t15 vdd.t511 vdd.t504 sg13_lv_pmos ad=0.4088p pd=2.97u as=1.1847p ps=7.385u w=1.12u l=0.13u
X1542 vdd.t807 a_5176_31117# a_8762_31505# vdd.t764 sg13_lv_pmos ad=0.34p pd=2.68u as=0.19p ps=1.38u w=1u l=2u
X1543 sg13cmos5l_inv_1_18.Y.t1 d_ena.t6 vdd.t1285 vdd.t502 sg13_lv_pmos ad=0.3808p pd=2.92u as=0.3808p ps=2.92u w=1.12u l=0.13u
X1544 vss.t1258 vss.t1259 vss.t531 rhigh l=2.75u w=0.5u
X1545 vdd.t1517 vdd.t1515 vdd.t1519 vdd.t566 sg13_lv_pmos ad=95f pd=0.88u as=0 ps=0 w=0.5u l=5u
X1546 a_2049_4965# d_qclk.t8 vss.t55 vss.t1393 sg13_lv_nmos ad=0.2516p pd=2.16u as=2.50852p ps=15.49u w=0.74u l=0.13u
X1547 vdd.t1172 vdd.t1540 vdd.t1541 vdd.t1173 sg13_lv_pmos ad=95f pd=0.88u as=0 ps=0 w=0.5u l=5u
X1548 vdd.t673 clk_noverlap_0.sg13cmos5l_inv_1_3.Y dsm2_io_vcmg_0.di_phi1_b vdd.t308 sg13_lv_pmos ad=0.3808p pd=2.92u as=0.3808p ps=2.92u w=1.12u l=0.13u
X1549 a_5892_8400.t4 d_amp_s_b[2].t3 a_6257_8400.t2 vdd.t658 sg13_lv_pmos ad=95f pd=0.88u as=0.17p ps=1.68u w=0.5u l=0.13u
X1550 vss.t1492 vdd.t1825 vss.t1491 vss.t1490 sg13_lv_nmos ad=0.1428p pd=1.52u as=0 ps=0 w=0.42u l=1u
X1551 vss.t486 d_dith_en.t4 a_2070_1764# vss.t1135 sg13_lv_nmos ad=0.1626p pd=1.415u as=60.89999f ps=0.71u w=0.42u l=0.13u
X1552 vdd.t1292 d_ena.t11 vdd.t946 vdd.t25 sg13_hv_pmos ad=0.19p pd=1.38u as=0 ps=0 w=1u l=10u
X1553 a_20260_17236# a_19984_17824# a_19984_17824# vss.t267 sg13_lv_nmos ad=95f pd=0.88u as=95f ps=0.88u w=0.5u l=10u
X1554 vss.t968 sg13cmos5l_and2_2_1.X.t2 a_9357_11104.t14 vss.t394 sg13_lv_nmos ad=0.76p pd=4.38u as=0.76p ps=4.38u w=4u l=0.5u
X1555 a_6202_16020# d_dith[1].t2 vss.t254 vss.t253 sg13_lv_nmos ad=0.1406p pd=1.12u as=0.2516p ps=2.16u w=0.74u l=0.13u
X1556 vdd.t507 a_2034_8854# a_2034_8690# vdd.t507 sg13_lv_pmos ad=1.99007p pd=12.8u as=79.8f ps=0.8u w=0.42u l=0.13u
X1557 vdd.t878 dsm2_io_0.sg13cmos5l_inv_1_1.A d_qout_en.t0 vdd.t617 sg13_lv_pmos ad=0.3808p pd=2.92u as=0.3808p ps=2.92u w=1.12u l=0.13u
X1558 vss.t1088 a_15584_15091# sg13cmos5l_nand2_1_5.A.t0 vss.t1243 sg13_lv_nmos ad=0.1331p pd=1.12u as=0.2516p ps=2.16u w=0.74u l=0.13u
X1559 clk_noverlap_0.sg13cmos5l_nor3_1_0.C a_9833_7224# vss.t892 vss.t937 sg13_lv_nmos ad=0.2516p pd=2.16u as=0.1426p ps=1.16u w=0.74u l=0.13u
X1560 vdd.t524 sg13cmos5l_inv_1_12.A sg13cmos5l_inv_1_12.Y vdd.t502 sg13_lv_pmos ad=0.3808p pd=2.92u as=0.3808p ps=2.92u w=1.12u l=0.13u
X1561 vdd.t1466 vdd.t1464 vdd.t1159 vdd.t1287 sg13_lv_pmos ad=0.17p pd=1.68u as=0 ps=0 w=0.5u l=5u
X1562 vdd.t289 vss.t2357 vdd.t263 vdd.t261 sg13_lv_pmos ad=0.19p pd=1.38u as=0 ps=0 w=1u l=1u
X1563 vdd.t611 a_13101_7164# a_12820_7466# vdd.t308 sg13_lv_pmos ad=0.1523p pd=1.38u as=0.34p ps=2.68u w=1u l=0.5u
X1564 a_1288_11146# a_1286_12023# a_1367_11717# vss.t2135 sg13_lv_nmos ad=79.8f pd=0.8u as=0.1296p ps=1.52u w=0.42u l=0.13u
X1565 sw_tgate_11.gb.t0 d_phi1.t7 vss.t906 vss.t905 sg13_lv_nmos ad=0.34p pd=2.68u as=0.34p ps=2.68u w=1u l=0.13u
X1566 ibias_200n.t5 a_12445_30191# a_5176_30111# vss.t1325 sg13_lv_nmos ad=0.17p pd=1.68u as=0.17p ps=1.68u w=0.5u l=3u
X1567 vss.t1830 vdd.t1746 vss.t1829 vss.t1816 sg13_lv_nmos ad=0.1428p pd=1.52u as=0 ps=0 w=0.42u l=1u
X1568 a_1758_8388# quantizer2_lfsr_0.sg13cmos5l_dfrbpq_1_15.D a_1367_9125# vss.t221 sg13_lv_nmos ad=60.89999f pd=0.71u as=0.1428p ps=1.52u w=0.42u l=0.13u
X1569 vss.t1801 vdd.t1753 vss.t1803 vss.t1802 sg13_lv_nmos ad=79.8f pd=0.8u as=0 ps=0 w=0.42u l=1u
X1570 vss.t856 sg13cmos5l_inv_1_0.A sg13cmos5l_inv_1_0.Y vss.t855 sg13_lv_nmos ad=0.2516p pd=2.16u as=0.2516p ps=2.16u w=0.74u l=0.13u
X1571 vdd.t1594 vdd.t1590 vdd.t1596 vdd.t384 sg13_lv_pmos ad=95f pd=0.88u as=0 ps=0 w=0.5u l=5u
X1572 vdd.t1665 vss.t2360 vdd.t1664 vdd.t261 sg13_lv_pmos ad=0.34p pd=2.68u as=0 ps=0 w=1u l=1u
X1573 a_24540_20880# a_28126_20740# vss.t34 rhigh l=17.5u w=0.5u
X1574 vdd.t142 vss.t2304 vdd.t453 vdd.t110 sg13_lv_pmos ad=0.19p pd=1.38u as=0 ps=0 w=1u l=1u
X1575 vss.t218 sg13cmos5l_inv_1_7.Y do_q_dec.t0 vss.t217 sg13_lv_nmos ad=0.2516p pd=2.16u as=0.1406p ps=1.12u w=0.74u l=0.13u
X1576 vdd.t1011 vdd.t1448 vdd.t1449 vdd.t572 sg13_lv_pmos ad=95f pd=0.88u as=0 ps=0 w=0.5u l=5u
X1577 a_7993_7200# a_7723_7241# vss.t88 vss.t87 sg13_lv_nmos ad=0.1428p pd=1.52u as=79.8f ps=0.8u w=0.42u l=0.5u
X1578 a_15584_15091# sg13cmos5l_and2_1_5.X.t2 a_15721_14934# vss.t44 sg13_lv_nmos ad=0.2176p pd=1.96u as=0.1216p ps=1.02u w=0.64u l=0.13u
X1579 vdd.t511 a_1284_15759# a_1407_15314# vdd.t504 sg13_lv_pmos ad=1.21587p pd=7.58u as=79.8f ps=0.8u w=0.42u l=0.13u
X1580 a_22138_15746# a_20138_14766# a_20070_15446# vdd.t897 sg13_lv_pmos ad=95f pd=0.88u as=0.17p ps=1.68u w=0.5u l=10u
X1581 a_4362_8188.t5 sg13cmos5l_inv_1_9.Y.t3 xq_dith_v_bq.t2 vdd.t624 sg13_lv_pmos ad=0.665p pd=3.88u as=0.665p ps=3.88u w=3.5u l=0.13u
X1582 vdd.t90 vss.t2342 vdd.t89 vdd.t88 sg13_lv_pmos ad=0.34p pd=2.68u as=0 ps=0 w=1u l=1u
X1583 a_6265_7200# a_5995_7241# vdd.t615 vdd.t308 sg13_lv_pmos ad=0.34p pd=2.68u as=0.1523p ps=1.38u w=1u l=0.5u
X1584 a_2385_11193# a_2045_11072# a_2034_11446# vdd.t507 sg13_lv_pmos ad=93.45f pd=0.865u as=0.2048p ps=1.63u w=0.42u l=0.13u
X1585 sw_tgate_11.gb.t1 d_phi1.t7 vdd.t901 vdd.t556 sg13_lv_pmos ad=0.68p pd=4.68u as=0.68p ps=4.68u w=2u l=0.13u
X1586 vss.t1193 vss.t1194 vss.t34 rhigh l=17.5u w=0.5u
X1587 vss.t1581 vdd.t1806 vss.t1580 vss.t1575 sg13_lv_nmos ad=0.1428p pd=1.52u as=0 ps=0 w=0.42u l=1u
X1588 a_26670_16046# a_19964_18216# a_24602_15746# vdd.t1127 sg13_lv_pmos ad=95f pd=0.88u as=0.17p ps=1.68u w=0.5u l=10u
X1589 vss.t1698 vdd.t1778 vss.t1696 vss.t1697 sg13_lv_nmos ad=79.8f pd=0.8u as=0 ps=0 w=0.42u l=1u
X1590 vss.t1656 vdd.t1789 vss.t1654 vss.t1646 sg13_lv_nmos ad=79.8f pd=0.8u as=0 ps=0 w=0.42u l=1u
X1591 vdd.t517 a_19949_784# clk_noverlap_0.di_clk.t1 vdd.t515 sg13_lv_pmos ad=0.2086p pd=1.5u as=0.2128p ps=1.5u w=1.12u l=0.13u
X1592 vdd.t511 a_522_15478# a_522_15314# vdd.t504 sg13_lv_pmos ad=1.21587p pd=7.58u as=79.8f ps=0.8u w=0.42u l=0.13u
X1593 xq_dith_v_bq.t1 sg13cmos5l_inv_1_9.Y.t3 a_4362_8188.t3 vdd.t624 sg13_lv_pmos ad=0.665p pd=3.88u as=0.665p ps=3.88u w=3.5u l=0.13u
X1594 vss.t1615 vdd.t1798 vss.t1616 vss.t1608 sg13_lv_nmos ad=79.8f pd=0.8u as=0 ps=0 w=0.42u l=1u
X1595 clk_noverlap_0.sg13cmos5l_inv_1_10.A clk_noverlap_0.sg13cmos5l_inv_1_0.A vss.t134 vss.t133 sg13_lv_nmos ad=0.1694p pd=1.21u as=0.2618p ps=2.22u w=0.77u l=0.13u
X1596 a_22252_8546# bias_gm_0.bias_trim_0.vz.t38 vdd.t1004 vdd.t566 sg13_lv_pmos ad=95f pd=0.88u as=95f ps=0.88u w=0.5u l=5u
X1597 vdd.t1380 vdd.t1378 vdd.t931 vdd.t1287 sg13_lv_pmos ad=0.17p pd=1.68u as=0 ps=0 w=0.5u l=5u
X1598 vss.t1901 vdd.t1729 vss.t1900 vss.t1887 sg13_lv_nmos ad=0.1428p pd=1.52u as=0 ps=0 w=0.42u l=1u
X1599 vdd.t994 vdd.t1496 vdd.t1497 vdd.t1173 sg13_lv_pmos ad=95f pd=0.88u as=0 ps=0 w=0.5u l=5u
X1600 xsc_xcmfb1_vsw_cm_n.t7 d_phi1.t8 xsc_xcmfb1_vsw_cm_n.t8 vdd.t678 sg13_lv_pmos ad=0.285p pd=1.88u as=0 ps=0 w=1.5u l=1u
X1601 a_22386_2344# a_21736_2344# a_22184_2052# vss.t507 sg13_lv_nmos ad=95f pd=0.88u as=95f ps=0.88u w=0.5u l=0.13u
X1602 vdd.t1662 vss.t2364 vdd.t1687 vdd.t74 sg13_lv_pmos ad=0.34p pd=2.68u as=0 ps=0 w=1u l=1u
X1603 a_13870_15077# a_13985_15078# vdd.t1202 vdd.t502 sg13_lv_pmos ad=0.34p pd=2.68u as=0.2254p ps=1.53u w=1u l=0.5u
X1604 a_11284_15186# d_qi_b.t3 d_qi.t1 vdd.t502 sg13_lv_pmos ad=0.3808p pd=2.92u as=0.2128p ps=1.5u w=1.12u l=0.13u
X1605 vss.t1771 vdd.t1760 vss.t1770 vss.t1760 sg13_lv_nmos ad=0.1428p pd=1.52u as=0 ps=0 w=0.42u l=1u
X1606 vdd.t297 vss.t2272 vdd.t268 vdd.t126 sg13_lv_pmos ad=0.19p pd=1.38u as=0 ps=0 w=1u l=1u
X1607 xsc_vc1l_p.t0 sw_tgate_9.gb.t4 sw_tgate_10.p.t4 vdd.t561 sg13_lv_pmos ad=0.38p pd=2.38u as=0.68p ps=4.68u w=2u l=1u
X1608 vdd.t508 a_2034_6262# a_2034_6645# vdd.t507 sg13_lv_pmos ad=0.2128p pd=1.5u as=0.3864p ps=2.93u w=1.12u l=0.13u
X1609 sg13cmos5l_nand2_2_0.B.t1 a_15491_15614# vdd.t1218 vdd.t502 sg13_lv_pmos ad=0.2128p pd=1.5u as=0.4256p ps=3u w=1.12u l=0.13u
X1610 a_8661_9028# a_10757_8888# vss.t5 rhigh l=10.05u w=0.5u
X1611 sw_tgate_12.m.t5 d_qi.t8 sw_tgate_12.m.t4 vdd.t561 sg13_lv_pmos ad=0.38p pd=2.38u as=0 ps=0 w=2u l=1u
X1612 a_8208_15626# sg13cmos5l_inv_1_19.Y.t8 vss.t813 vss.t812 sg13_lv_nmos ad=0.1045p pd=0.93u as=0.187p ps=1.78u w=0.55u l=0.13u
X1613 sg13cmos5l_and2_1_2.X a_10989_15998# vdd.t762 vdd.t502 sg13_lv_pmos ad=0.3808p pd=2.92u as=0.1918p ps=1.5u w=1.12u l=0.13u
X1614 vdd.t1519 vdd.t1515 vdd.t1521 vdd.t384 sg13_lv_pmos ad=95f pd=0.88u as=0 ps=0 w=0.5u l=5u
X1615 a_22930_1332# dsm2_osc_0.sg13cmos5l_dfrbp_1_0.RESET_B.t6 a_22836_1332# vdd.t515 sg13_lv_pmos ad=0.1596p pd=1.22u as=0.2856p ps=2.36u w=0.84u l=0.13u
X1616 a_1407_4946# d_dith_en.t11 vdd.t511 vdd.t504 sg13_lv_pmos ad=79.8f pd=0.8u as=1.1847p ps=7.385u w=0.42u l=0.13u
X1617 vdd.t667 clk_noverlap_0.sg13cmos5l_dlygate4sd3_1_4.A a_8587_7241# vdd.t308 sg13_lv_pmos ad=0.1523p pd=1.38u as=0.1428p ps=1.52u w=0.42u l=0.13u
X1618 a_4537_7200# a_4267_7241# vss.t574 vss.t573 sg13_lv_nmos ad=0.1428p pd=1.52u as=79.8f ps=0.8u w=0.42u l=0.5u
X1619 vss.t1502 vdd.t1823 vss.t1504 vss.t1503 sg13_lv_nmos ad=79.8f pd=0.8u as=0 ps=0 w=0.42u l=1u
X1620 vss.t354 vss.t352 vss.t353 vss.t262 sg13_hv_nmos ad=0.17p pd=1.68u as=0 ps=0 w=0.5u l=10u
X1621 a_22252_11246# bias_gm_0.bias_trim_0.vz.t53 vdd.t934 vdd.t287 sg13_lv_pmos ad=95f pd=0.88u as=95f ps=0.88u w=0.5u l=5u
X1622 a_15297_7467# a_15412_7466# vdd.t894 vdd.t308 sg13_lv_pmos ad=0.34p pd=2.68u as=0.2254p ps=1.53u w=1u l=0.5u
X1623 a_7804_29739.t1 xsc_vvg_p.t6 w_9407_29481.t3 w_9407_29481.t0 sg13_lv_pmos ad=0.38p pd=2.38u as=0.38p ps=2.38u w=2u l=1u
X1624 vdd.t1042 d_qi.t7 vdd.t1041 vdd.t562 sg13_lv_pmos ad=0.68p pd=4.68u as=0 ps=0 w=2u l=1u
X1625 vss.t51 sg13cmos5l_inv_1_12.A sg13cmos5l_inv_1_12.Y vss.t50 sg13_lv_nmos ad=0.2516p pd=2.16u as=0.2516p ps=2.16u w=0.74u l=0.13u
X1626 a_558_612# quantizer2_lfsr_0.sg13cmos5l_dfrbpq_1_0.D.t2 a_558_518# vss.t1195 sg13_lv_nmos ad=60.89999f pd=0.71u as=0.1428p ps=1.52u w=0.42u l=0.13u
X1627 vdd.t507 a_2049_10149# a_2045_11072# vdd.t507 sg13_lv_pmos ad=1.99007p pd=12.8u as=0.3864p ps=2.93u w=1.12u l=0.13u
X1628 vdd.t34 vss.t2381 vdd.t33 vdd.t10 sg13_lv_pmos ad=0.34p pd=2.68u as=0 ps=0 w=1u l=1u
X1629 vdd.t539 clk_noverlap_0.sg13cmos5l_inv_1_0.A clk_noverlap_0.sg13cmos5l_inv_1_0.Y vdd.t308 sg13_lv_pmos ad=0.3808p pd=2.92u as=0.3808p ps=2.92u w=1.12u l=0.13u
X1630 xsc_vc1l_n.t10 sw_tgate_11.gb.t2 sw_tgate_8.m.t3 vdd.t562 sg13_lv_pmos ad=0.38p pd=2.38u as=0.38p ps=2.38u w=2u l=1u
X1631 a_9533_11104.t9 sg13cmos5l_inv_1_14.A.t10 sg13cmos5l_inv_1_2.A.t5 vss.t30 sg13_lv_nmos ad=95f pd=0.88u as=95f ps=0.88u w=0.5u l=0.5u
X1632 clk_noverlap_0.sg13cmos5l_dlygate4sd3_1_4.A a_8105_7224# vss.t232 vss.t231 sg13_lv_nmos ad=0.2516p pd=2.16u as=0.1426p ps=1.16u w=0.74u l=0.13u
X1633 vdd.t876 sg13cmos5l_nand2_2_0.B.t2 sg13cmos5l_nor2_2_2.A vdd.t502 sg13_lv_pmos ad=0.2184p pd=1.51u as=0.2128p ps=1.5u w=1.12u l=0.13u
X1634 a_949_6345# a_522_7368# vdd.t1093 vdd.t504 sg13_lv_pmos ad=63f pd=0.72u as=0.1563p ps=1.22u w=0.42u l=0.13u
X1635 vdd.t174 vss.t2197 vdd.t389 vdd.t173 sg13_lv_pmos ad=0.34p pd=2.68u as=0 ps=0 w=1u l=1u
X1636 a_20673_892# do_osc_oe.t2 vdd.t1250 vdd.t515 sg13_lv_pmos ad=0.3325p pd=1.665u as=0.253p ps=1.53u w=1u l=0.13u
X1637 a_2083_9958# d_dith_en.t22 vss.t1076 vss.t1075 sg13_lv_nmos ad=37.8f pd=0.6u as=0.1701p ps=1.65u w=0.42u l=0.13u
X1638 a_6249_9100.t2 sg13cmos5l_inv_1_13.Y.t2 xq_vg_p_0_.t0 vss.t476 sg13_lv_nmos ad=0.17p pd=1.68u as=95f ps=0.88u w=0.5u l=0.13u
X1639 xsc_vfb.t7 d_phi1.t6 xsc_vfb.t4 vdd.t560 sg13_lv_pmos ad=0.285p pd=1.88u as=0 ps=0 w=1.5u l=1u
X1640 xsc_xcmfb1_vsw_vbias.t3 vss.t305 xsc_xcmfb1_vsw_vbias.t6 vss.t306 sg13_lv_nmos ad=95f pd=0.88u as=0 ps=0 w=0.5u l=1u
X1641 vdd.t1580 vdd.t1579 vdd.t987 vdd.t573 sg13_lv_pmos ad=95f pd=0.88u as=0 ps=0 w=0.5u l=5u
X1642 a_22738_2088# a_22184_2052# a_22644_2344# vss.t19 sg13_lv_nmos ad=95f pd=0.88u as=0.17p ps=1.68u w=0.5u l=0.13u
X1643 vss.t636 quantizer2_lfsr_0.sg13cmos5l_dfrbpq_1_2.Q.t2 a_2034_698# vss.t990 sg13_lv_nmos ad=0.14875p pd=1.16u as=0.187p ps=1.78u w=0.55u l=0.13u
X1644 vss.t1889 vdd.t1732 vss.t1888 vss.t1887 sg13_lv_nmos ad=0.1428p pd=1.52u as=0 ps=0 w=0.42u l=1u
X1645 vdd.t511 a_537_3813# a_533_4736# vdd.t504 sg13_lv_pmos ad=1.21587p pd=7.58u as=0.3864p ps=2.93u w=1.12u l=0.13u
X1646 vdd.t45 vss.t2390 vdd.t44 vdd.t0 sg13_lv_pmos ad=0.19p pd=1.38u as=0 ps=0 w=1u l=1u
X1647 vdd.t446 vss.t2310 vdd.t106 vdd.t105 sg13_lv_pmos ad=0.19p pd=1.38u as=0 ps=0 w=1u l=1u
X1648 a_9357_11104.t7 vss.t427 a_9533_11104.t2 vss.t389 sg13_lv_nmos ad=0.285p pd=1.88u as=0.285p ps=1.88u w=1.5u l=0.5u
X1649 vo_p.t7 a_5176_30111# a_6452_29739.t0 vss.t741 sg13_lv_nmos ad=95f pd=0.88u as=95f ps=0.88u w=0.5u l=3u
X1650 vdd.t922 a_522_12886# a_522_13269# vdd.t504 sg13_lv_pmos ad=0.2128p pd=1.5u as=0.3864p ps=2.93u w=1.12u l=0.13u
X1651 a_2070_1764# quantizer2_lfsr_0.sg13cmos5l_dfrbpq_1_2.D.t2 a_2070_1670# vss.t2084 sg13_lv_nmos ad=60.89999f pd=0.71u as=0.1428p ps=1.52u w=0.42u l=0.13u
X1652 a_12445_30191# a_6817_30111# vdd.t1201 vdd.t764 sg13_lv_pmos ad=0.34p pd=2.68u as=0.34p ps=2.68u w=1u l=2u
X1653 vdd.t1568 vdd.t1566 vdd.t1161 vdd.t1287 sg13_lv_pmos ad=0.17p pd=1.68u as=0 ps=0 w=0.5u l=5u
X1654 a_11293_11104.t6 sg13cmos5l_and2_2_1.X.t3 vdd.t961 vdd.t863 sg13_lv_pmos ad=0.285p pd=1.88u as=0.285p ps=1.88u w=1.5u l=0.5u
X1655 vss.t561 vss.t562 vss.t531 rhigh l=2.75u w=0.5u
X1656 d_amp_s[0].t0 quantizer2_lfsr_0.di_dith_amp[0].t4 a_856_16970# vdd.t504 sg13_lv_pmos ad=0.3808p pd=2.92u as=0.1176p ps=1.33u w=1.12u l=0.13u
X1657 vdd.t535 sg13cmos5l_inv_1_2.A.t11 sg13cmos5l_inv_1_2.Y vdd.t502 sg13_lv_pmos ad=0.3808p pd=2.92u as=0.3808p ps=2.92u w=1.12u l=0.13u
X1658 a_24404_4674# bias_gm_0.bias_trim_0.vz.t33 vdd.t1176 vdd.t572 sg13_lv_pmos ad=95f pd=0.88u as=95f ps=0.88u w=0.5u l=5u
X1659 a_16557_7164# clk_noverlap_0.sg13cmos5l_dlygate4sd3_1_12.A vss.t896 vss.t204 sg13_lv_nmos ad=0.1428p pd=1.52u as=79.8f ps=0.8u w=0.42u l=0.13u
X1660 vss.t796 a_2049_10149# a_2045_11072# vss.t795 sg13_lv_nmos ad=2.71757p pd=16.785u as=0.2516p ps=2.16u w=0.74u l=0.13u
X1661 vi_esd.t2 d_phi2.t5 xsc_vc1l_n.t3 vss.t203 sg13_lv_nmos ad=0.19p pd=1.38u as=0.19p ps=1.38u w=1u l=1u
X1662 a_19984_17824# bias_gm_0.bias_trim_0.vz.t12 vdd.t582 vdd.t566 sg13_lv_pmos ad=95f pd=0.88u as=95f ps=0.88u w=0.5u l=5u
X1663 a_558_5702# a_533_7328# a_567_5970# vdd.t504 sg13_lv_pmos ad=0.1428p pd=1.52u as=79.8f ps=0.8u w=0.42u l=0.13u
X1664 vss.t1716 vdd.t1773 vss.t1715 vss.t1710 sg13_lv_nmos ad=0.1428p pd=1.52u as=0 ps=0 w=0.42u l=1u
X1665 vss.t1809 vdd.t1751 vss.t1810 vss.t1802 sg13_lv_nmos ad=79.8f pd=0.8u as=0 ps=0 w=0.42u l=1u
X1666 a_5892_8400.t5 d_amp_s[2].t3 a_6257_8400.t3 vss.t666 sg13_lv_nmos ad=95f pd=0.88u as=0.17p ps=1.68u w=0.5u l=0.13u
X1667 vdd.t255 vss.t2409 vdd.t257 vdd.t0 sg13_lv_pmos ad=0.34p pd=2.68u as=0 ps=0 w=1u l=1u
X1668 vss.t874 d_dith_en.t26 a_1758_10980# vss.t1100 sg13_lv_nmos ad=0.1626p pd=1.415u as=60.89999f ps=0.71u w=0.42u l=0.13u
X1669 a_522_15144# a_533_15104# a_522_15478# vss.t648 sg13_lv_nmos ad=0.3473p pd=2.71u as=0.12665p ps=1.145u w=0.74u l=0.13u
X1670 a_1286_1655# d_qclk.t3 vss.t1415 vss.t1414 sg13_lv_nmos ad=0.2516p pd=2.16u as=2.50852p ps=15.49u w=0.74u l=0.13u
X1671 vss.t818 dsm2_io_0.sg13cmos5l_inv_1_5.A dsm2_io_0.do_btest_en.t0 vss.t467 sg13_lv_nmos ad=0.2516p pd=2.16u as=0.2516p ps=2.16u w=0.74u l=0.13u
X1672 a_2034_8854# a_2049_7557# a_2034_8520# vdd.t507 sg13_lv_pmos ad=0.2048p pd=1.63u as=0.34p ps=2.68u w=1u l=0.13u
X1673 vss.t1632 vdd.t1794 vss.t1631 vss.t1622 sg13_lv_nmos ad=0.1428p pd=1.52u as=0 ps=0 w=0.42u l=1u
X1674 sg13cmos5l_nor2_2_0.B.t3 sg13cmos5l_nand2_2_0.B.t3 vdd.t871 vdd.t502 sg13_lv_pmos ad=0.2128p pd=1.5u as=0.2128p ps=1.5u w=1.12u l=0.13u
X1675 vdd.t1244 bias_gm_0.bias_trim_0.vz.t35 a_22252_4374# vdd.t570 sg13_lv_pmos ad=95f pd=0.88u as=95f ps=0.88u w=0.5u l=5u
X1676 clk_noverlap_0.sg13cmos5l_inv_1_10.A d_phi1.t2 a_11786_6736# vdd.t308 sg13_lv_pmos ad=0.3808p pd=2.92u as=0.2128p ps=1.5u w=1.12u l=0.13u
X1677 sg13cmos5l_inv_1_16.Y.t1 sg13cmos5l_inv_1_16.A.t4 vdd.t883 vdd.t502 sg13_lv_pmos ad=0.3808p pd=2.92u as=0.3808p ps=2.92u w=1.12u l=0.13u
X1678 vdd.t1005 bias_gm_0.bias_trim_0.vz.t38 a_22252_8546# vdd.t384 sg13_lv_pmos ad=95f pd=0.88u as=95f ps=0.88u w=0.5u l=5u
X1679 sg13cmos5l_nor2_2_0.Y sg13cmos5l_inv_2_0.Y vss.t590 vss.t589 sg13_lv_nmos ad=0.1406p pd=1.12u as=0.1406p ps=1.12u w=0.74u l=0.13u
X1680 xq_dith_v_bp.t2 sg13cmos5l_inv_1_3.Y.t2 vo_n.t17 vdd.t623 sg13_lv_pmos ad=0.665p pd=3.88u as=0.665p ps=3.88u w=3.5u l=0.13u
X1681 vdd.t603 dsm2_osc_0.sg13cmos5l_dfrbp_1_0.RESET_B.t11 a_21554_2798# vdd.t514 sg13_lv_pmos ad=95f pd=0.88u as=95f ps=0.88u w=0.5u l=0.5u
X1682 a_558_5702# quantizer2_lfsr_0.sg13cmos5l_dfrbpq_1_9.D vdd.t709 vdd.t504 sg13_lv_pmos ad=79.8f pd=0.8u as=0.1428p ps=1.52u w=0.42u l=0.13u
X1683 a_21554_2052.t4 dsm2_osc_0.sg13cmos5l_dfrbp_1_0.RESET_B.t7 dsm2_osc_0.ibias_in.t0 vss.t446 sg13_hv_nmos ad=0.34p pd=2.68u as=0.34p ps=2.68u w=1u l=0.45u
X1684 vss.t1650 vdd.t1790 vss.t1652 vss.t1651 sg13_lv_nmos ad=79.8f pd=0.8u as=0 ps=0 w=0.42u l=1u
X1685 vdd.t398 vss.t2297 vdd.t442 vdd.t184 sg13_lv_pmos ad=0.34p pd=2.68u as=0 ps=0 w=1u l=1u
X1686 vdd.t1447 vdd.t1445 vdd.t1010 vdd.t1287 sg13_lv_pmos ad=0.17p pd=1.68u as=0 ps=0 w=0.5u l=5u
X1687 a_22368_558# a_22499_864# a_21617_558# vdd.t515 sg13_lv_pmos ad=0.34p pd=2.68u as=0.2048p ps=1.63u w=1u l=0.13u
X1688 vss.t1192 dsm2_io_vcmg_0.di_phi1_b d_phi1.t0 vss.t1191 sg13_lv_nmos ad=0.2516p pd=2.16u as=0.2516p ps=2.16u w=0.74u l=0.13u
X1689 vdd.t586 bias_gm_0.bias_trim_0.vz.t12 a_19984_17824# vdd.t570 sg13_lv_pmos ad=95f pd=0.88u as=95f ps=0.88u w=0.5u l=5u
X1690 bias_gm_0.bias_trim_0.vz.t1 bias_gm_0.bias_trim_0.vz.t0 vdd.t1254 vdd.t572 sg13_lv_pmos ad=95f pd=0.88u as=95f ps=0.88u w=0.5u l=5u
X1691 a_1758_7666# d_dith_en.t17 vss.t131 vss.t130 sg13_lv_nmos ad=37.8f pd=0.6u as=79.8f ps=0.8u w=0.42u l=0.13u
X1692 vdd.t47 vss.t2365 vdd.t23 vdd.t22 sg13_lv_pmos ad=0.19p pd=1.38u as=0 ps=0 w=1u l=1u
X1693 a_571_3684# a_533_4736# a_567_3378# vss.t551 sg13_lv_nmos ad=0.2373p pd=1.97u as=79.8f ps=0.8u w=0.42u l=0.13u
X1694 sw_tgate_10.p.t3 d_phi2.t7 sw_tgate_10.p.t2 vdd.t561 sg13_lv_pmos ad=0.38p pd=2.38u as=0 ps=0 w=2u l=1u
X1695 vdd.t601 a_23289_752# a_22368_558# vdd.t515 sg13_lv_pmos ad=0.36237p pd=2.605u as=0.34p ps=2.68u w=1u l=0.13u
X1696 vdd.t507 a_2049_7557# a_2045_8480# vdd.t507 sg13_lv_pmos ad=1.99007p pd=12.8u as=0.3864p ps=2.93u w=1.12u l=0.13u
X1697 d_qclk.t2 a_10757_9808# vss.t545 rhigh l=20u w=0.5u
X1698 sg13cmos5l_inv_1_6.Y.t1 sg13cmos5l_inv_1_6.A.t4 vdd.t976 vdd.t502 sg13_lv_pmos ad=0.3808p pd=2.92u as=0.3808p ps=2.92u w=1.12u l=0.13u
X1699 vss.t2054 vdd.t1696 vss.t2056 vss.t2055 sg13_lv_nmos ad=79.8f pd=0.8u as=0 ps=0 w=0.42u l=1u
X1700 vdd.t1124 sg13cmos5l_inv_1_10.Y sg13cmos5l_nand2_1_2.Y.t1 vdd.t502 sg13_lv_pmos ad=0.3808p pd=2.92u as=0.2128p ps=1.5u w=1.12u l=0.13u
X1701 vo_n.t16 sg13cmos5l_inv_1_3.Y.t2 xq_dith_v_bp.t12 vdd.t623 sg13_lv_pmos ad=0.665p pd=3.88u as=0.665p ps=3.88u w=3.5u l=0.13u
X1702 vdd.t1026 sg13cmos5l_inv_2_5.Y sg13cmos5l_nor2_2_2.A vdd.t502 sg13_lv_pmos ad=0.392p pd=2.94u as=0.2128p ps=1.5u w=1.12u l=0.13u
X1703 vss.t169 vcm_esd.t25 vss.t168 vss.t167 sg13_hv_nmos ad=1.9p pd=10.38u as=0 ps=0 w=10u l=10u
X1704 vss.t670 a_1407_10130# a_1681_9745# vss.t669 sg13_lv_nmos ad=79.8f pd=0.8u as=0.1428p ps=1.52u w=0.42u l=0.13u
X1705 vss.t1909 vdd.t1727 vss.t1908 vss.t1907 sg13_lv_nmos ad=0.1428p pd=1.52u as=0 ps=0 w=0.42u l=1u
X1706 quantizer2_lfsr_0.sg13cmos5l_dfrbpq_1_1.D.t0 a_522_13269# vss.t951 vss.t950 sg13_lv_nmos ad=0.2516p pd=2.16u as=0.1406p ps=1.12u w=0.74u l=0.13u
X1707 vdd.t946 dsm2_io_0.dsm2_io_rx_9.di_b.t2 a_670_25288# vdd.t25 sg13_hv_pmos ad=0.19p pd=1.38u as=0.19p ps=1.38u w=1u l=0.45u
X1708 a_856_16970# quantizer2_lfsr_0.di_dith_amp[1].t4 vdd.t614 vdd.t504 sg13_lv_pmos ad=0.1176p pd=1.33u as=0.4032p ps=2.96u w=1.12u l=0.13u
X1709 a_1745_13990# d_dith_en.t32 vss.t1092 vss.t1091 sg13_lv_nmos ad=37.8f pd=0.6u as=0.1701p ps=1.65u w=0.42u l=0.13u
X1710 vss.t1946 vdd.t1719 vss.t1943 vss.t1945 sg13_lv_nmos ad=79.8f pd=0.8u as=0 ps=0 w=0.42u l=1u
X1711 vdd.t320 vss.t2248 vdd.t264 vdd.t79 sg13_lv_pmos ad=0.19p pd=1.38u as=0 ps=0 w=1u l=1u
X1712 vdd.t645 a_21554_2798# a_22386_2578# vdd.t514 sg13_lv_pmos ad=95f pd=0.88u as=0.17p ps=1.68u w=0.5u l=0.5u
X1713 vdd.t1020 bias_gm_0.bias_trim_0.vz.t52 a_19984_17824# vdd.t573 sg13_lv_pmos ad=95f pd=0.88u as=95f ps=0.88u w=0.5u l=5u
X1714 vss.t432 vss.t431 vss.t434 vss.t398 sg13_lv_nmos ad=0.285p pd=1.88u as=0 ps=0 w=1.5u l=0.5u
X1715 a_1286_14615# d_qclk.t19 vdd.t511 vdd.t504 sg13_lv_pmos ad=0.4088p pd=2.97u as=1.1847p ps=7.385u w=1.12u l=0.13u
X1716 vcm_esd.t1 sw_tgate_cmfb2_1.gb.t4 xsc_xcmfb1_vsw_cm_p.t7 vdd.t558 sg13_lv_pmos ad=0.285p pd=1.88u as=0.285p ps=1.88u w=1.5u l=1u
X1717 vdd.t722 di_trim[0] dsm2_io_0.do_trim_b[0].t1 vdd.t25 sg13_hv_pmos ad=0.17p pd=1.68u as=0.17p ps=1.68u w=0.5u l=1u
X1718 vdd.t146 vss.t2271 vdd.t145 vdd.t126 sg13_lv_pmos ad=0.34p pd=2.68u as=0 ps=0 w=1u l=1u
X1719 a_19984_17824# a_19904_17646# vss.t1337 vss.t1171 sg13_hv_nmos ad=0.17p pd=1.68u as=0.17p ps=1.68u w=0.5u l=1u
X1720 a_22252_7946# bias_gm_0.bias_trim_0.vz.t47 vdd.t949 vdd.t287 sg13_lv_pmos ad=95f pd=0.88u as=95f ps=0.88u w=0.5u l=5u
X1721 vdd.t568 bias_gm_0.bias_trim_0.vz.t9 a_22252_11246# vdd.t384 sg13_lv_pmos ad=95f pd=0.88u as=95f ps=0.88u w=0.5u l=5u
X1722 vdd.t326 vss.t2282 vdd.t197 vdd.t153 sg13_lv_pmos ad=0.19p pd=1.38u as=0 ps=0 w=1u l=1u
X1723 vdd.t1504 vdd.t1498 vdd.t1506 vdd.t572 sg13_lv_pmos ad=95f pd=0.88u as=0 ps=0 w=0.5u l=5u
X1724 a_22252_4374# bias_gm_0.bias_trim_0.vz.t23 vdd.t987 vdd.t287 sg13_lv_pmos ad=95f pd=0.88u as=95f ps=0.88u w=0.5u l=5u
X1725 vss.t834 sg13cmos5l_nand2_2_0.B.t3 sg13cmos5l_nor2_2_0.B.t1 vss.t833 sg13_lv_nmos ad=0.2516p pd=2.16u as=0.1406p ps=1.12u w=0.74u l=0.13u
X1726 vdd.t497 vss.t2186 vdd.t291 vdd.t290 sg13_lv_pmos ad=0.19p pd=1.38u as=0 ps=0 w=1u l=1u
X1727 sg13cmos5l_inv_1_2.A.t7 sg13cmos5l_inv_1_14.A.t10 vdd.t1189 vdd.t863 sg13_lv_pmos ad=0.285p pd=1.88u as=0.285p ps=1.88u w=1.5u l=0.5u
X1728 a_20672_20180# a_24258_20320# vss.t207 rhigh l=17.5u w=0.5u
X1729 sg13cmos5l_inv_1_3.A.t0 a_7437_15998# vss.t1074 vss.t1323 sg13_lv_nmos ad=0.2516p pd=2.16u as=0.1331p ps=1.12u w=0.74u l=0.13u
X1730 vdd.t208 vss.t2285 vdd.t219 vdd.t153 sg13_lv_pmos ad=0.34p pd=2.68u as=0 ps=0 w=1u l=1u
X1731 a_22258_594# a_22499_864# a_21617_558# vss.t639 sg13_lv_nmos ad=0.1428p pd=1.52u as=0.12665p ps=1.145u w=0.42u l=0.13u
X1732 vss.t1758 vdd.t1763 vss.t1759 vss.t1751 sg13_lv_nmos ad=79.8f pd=0.8u as=0 ps=0 w=0.42u l=1u
X1733 a_1324_11172# a_1288_11146# vdd.t885 vdd.t504 sg13_lv_pmos ad=0.34p pd=2.68u as=0.36237p ps=2.605u w=1u l=0.13u
X1734 vss.t1537 vdd.t1816 vss.t1539 vss.t1538 sg13_lv_nmos ad=79.8f pd=0.8u as=0 ps=0 w=0.42u l=1u
X1735 vss.t63 sw_tgate_cmfb2_1.p.t12 vss.t62 vss.t61 sg13_lv_nmos ad=0.17p pd=1.68u as=0 ps=0 w=0.5u l=3u
X1736 vss.t526 quantizer2_lfsr_0.sg13cmos5l_dfrbpq_1_11.Q.t2 a_2034_1082# vss.t875 sg13_lv_nmos ad=0.14875p pd=1.16u as=0.187p ps=1.78u w=0.55u l=0.13u
X1737 vdd.t183 vss.t2216 vdd.t182 vdd.t181 sg13_lv_pmos ad=0.19p pd=1.38u as=0 ps=0 w=1u l=1u
X1738 vdd.t455 vss.t2170 vdd.t341 vdd.t339 sg13_lv_pmos ad=0.19p pd=1.38u as=0 ps=0 w=1u l=1u
X1739 a_9533_11104.t4 sg13cmos5l_and2_2_1.X.t4 vdd.t971 vdd.t863 sg13_lv_pmos ad=0.285p pd=1.88u as=0.285p ps=1.88u w=1.5u l=0.5u
X1740 vdd.t571 vdd.t1401 vdd.t1402 vdd.t1173 sg13_lv_pmos ad=95f pd=0.88u as=0 ps=0 w=0.5u l=5u
X1741 vdd.t448 vss.t2208 vdd.t447 vdd.t379 sg13_lv_pmos ad=0.19p pd=1.38u as=0 ps=0 w=1u l=1u
X1742 a_1745_3622# d_dith_en.t8 vss.t1129 vss.t1128 sg13_lv_nmos ad=37.8f pd=0.6u as=0.1701p ps=1.65u w=0.42u l=0.13u
X1743 a_23328_9146# dsm2_io_0.do_trim_b[0].t3 ibias_200n.t2 vdd.t573 sg13_lv_pmos ad=95f pd=0.88u as=95f ps=0.88u w=0.5u l=5u
X1744 vdd.t1244 vdd.t1535 vdd.t1536 vdd.t1173 sg13_lv_pmos ad=95f pd=0.88u as=0 ps=0 w=0.5u l=5u
X1745 vss.t1298 sg13cmos5l_inv_1_2.Y sg13cmos5l_inv_2_0.Y vss.t1297 sg13_lv_nmos ad=0.2516p pd=2.16u as=0.1406p ps=1.12u w=0.74u l=0.13u
X1746 a_14734_15077# a_14849_15078# vss.t653 vss.t1322 sg13_lv_nmos ad=0.1428p pd=1.52u as=0.1426p ps=1.16u w=0.42u l=0.5u
X1747 vss.t319 vss.t311 vss.t318 vss.t272 sg13_hv_nmos ad=3.4p pd=20.68u as=0 ps=0 w=10u l=1u
X1748 vss.t1792 vdd.t1755 vss.t1791 vss.t1782 sg13_lv_nmos ad=0.1428p pd=1.52u as=0 ps=0 w=0.42u l=1u
X1749 vss.t736 inv_en_0.di inv_en_0.di_b.t0 vss.t735 sg13_hv_nmos ad=0.34p pd=2.68u as=0.34p ps=2.68u w=1u l=0.45u
X1750 vss.t1522 vdd.t1819 vss.t1524 vss.t1523 sg13_lv_nmos ad=79.8f pd=0.8u as=0 ps=0 w=0.42u l=1u
X1751 vss.t1813 vdd.t1750 vss.t1812 vss.t1811 sg13_lv_nmos ad=0.1428p pd=1.52u as=0 ps=0 w=0.42u l=1u
X1752 vss.t160 a_21498_769# dsm2_osc_0.sg13cmos5l_mux2_1_0.A1 vss.t159 sg13_lv_nmos ad=0.1406p pd=1.12u as=0.2516p ps=2.16u w=0.74u l=0.13u
X1753 a_2385_13785# a_2045_13664# a_2034_14038# vdd.t507 sg13_lv_pmos ad=93.45f pd=0.865u as=0.2048p ps=1.63u w=0.42u l=0.13u
X1754 vdd.t1233 a_5176_31469# vdd.t1234 vdd.t764 sg13_lv_pmos ad=0.665p pd=3.88u as=0 ps=0 w=3.5u l=2u
X1755 xsc_vc1r_n.t4 sw_tgate_11.gb.t5 vcm_esd.t18 vdd.t556 sg13_lv_pmos ad=0.38p pd=2.38u as=0.68p ps=4.68u w=2u l=1u
X1756 bias_gm_0.bias_trim_0.iout a_21252_3394# dsm2_osc_0.ibias_in.t5 vdd.t570 sg13_lv_pmos ad=95f pd=0.88u as=95f ps=0.88u w=0.5u l=5u
X1757 sg13cmos5l_inv_1_6.Y.t0 sg13cmos5l_inv_1_6.A.t4 vss.t973 vss.t972 sg13_lv_nmos ad=0.2516p pd=2.16u as=0.2516p ps=2.16u w=0.74u l=0.13u
X1758 vdd.t1461 vdd.t1459 vdd.t1012 vdd.t1287 sg13_lv_pmos ad=0.17p pd=1.68u as=0 ps=0 w=0.5u l=5u
X1759 vss.t1845 vdd.t1743 vss.t1843 vss.t1844 sg13_lv_nmos ad=79.8f pd=0.8u as=0 ps=0 w=0.42u l=1u
X1760 vss.t1745 vdd.t1766 vss.t1744 vss.t1743 sg13_lv_nmos ad=0.1428p pd=1.52u as=0 ps=0 w=0.42u l=1u
X1761 dsm2_osc_0.sg13cmos5l_dfrbp_1_0.CLK dsm2_osc_0.sg13cmos5l_inv_1_3.A vss.t2124 vss.t2123 sg13_lv_nmos ad=0.2516p pd=2.16u as=0.2516p ps=2.16u w=0.74u l=0.13u
X1762 vss.t313 vss.t311 vss.t312 vss.t272 sg13_hv_nmos ad=3.4p pd=20.68u as=0 ps=0 w=10u l=1u
X1763 a_24540_20600# a_28126_20460# vss.t34 rhigh l=17.5u w=0.5u
X1764 vdd.t698 clk_noverlap_0.sg13cmos5l_inv_1_1.Y clk_noverlap_0.sg13cmos5l_inv_1_3.Y vdd.t308 sg13_lv_pmos ad=0.3808p pd=2.92u as=0.3808p ps=2.92u w=1.12u l=0.13u
X1765 a_1600_6533# a_1324_5988# a_1745_6214# vss.t934 sg13_lv_nmos ad=0.1428p pd=1.52u as=37.8f ps=0.6u w=0.42u l=0.13u
X1766 vo_p.t11 sg13cmos5l_inv_1_3.Y.t3 xq_dith_v_bq.t5 vdd.t624 sg13_lv_pmos ad=0.665p pd=3.88u as=0.665p ps=3.88u w=3.5u l=0.13u
X1767 vss.t1477 vdd.t1828 vss.t1476 vss.t1475 sg13_lv_nmos ad=0.1428p pd=1.52u as=0 ps=0 w=0.42u l=1u
X1768 vdd.t789 a_5176_31117# vdd.t787 vdd.t764 sg13_lv_pmos ad=0.465p pd=1.93u as=0 ps=0 w=1u l=2u
X1769 vss.t1387 vss.t1388 vss.t39 rhigh l=2.75u w=0.5u
X1770 a_11115_8328# a_13211_8468# vss.t6 rhigh l=10.05u w=0.5u
X1771 vss.t1581 vdd.t1806 vss.t1582 vss.t1578 sg13_lv_nmos ad=79.8f pd=0.8u as=0 ps=0 w=0.42u l=1u
X1772 a_22252_8546# bias_gm_0.bias_trim_0.vz.t49 vdd.t680 vdd.t572 sg13_lv_pmos ad=95f pd=0.88u as=95f ps=0.88u w=0.5u l=5u
X1773 vdd.t252 vss.t2407 vdd.t254 vdd.t0 sg13_lv_pmos ad=0.34p pd=2.68u as=0 ps=0 w=1u l=1u
X1774 vdd.t519 sg13cmos5l_nor2_2_0.Y a_10132_15186# vdd.t502 sg13_lv_pmos ad=0.2128p pd=1.5u as=0.2128p ps=1.5u w=1.12u l=0.13u
X1775 vss.t1000 vss.t1001 vss.t531 rhigh l=2.75u w=0.5u
X1776 clk_noverlap_0.sg13cmos5l_inv_1_11.Y d_ena.t2 vdd.t1296 vdd.t308 sg13_lv_pmos ad=0.3808p pd=2.92u as=0.3808p ps=2.92u w=1.12u l=0.13u
X1777 vss.t1927 vdd.t1723 vss.t1926 vss.t1925 sg13_lv_nmos ad=0.1428p pd=1.52u as=0 ps=0 w=0.42u l=1u
X1778 vss.t750 a_5176_30111# vss.t752 vss.t751 sg13_lv_nmos ad=95f pd=0.88u as=0 ps=0 w=0.5u l=3u
X1779 a_1502_28364# vdd.t1786 a_1502_26288# vss.t1639 sg13_hv_nmos ad=0.19p pd=1.38u as=0.19p ps=1.38u w=1u l=10u
X1780 quantizer2_lfsr_0.sg13cmos5l_nor2_1_1.B quantizer2_lfsr_0.di_dith_amp[0].t2 vdd.t1621 vdd.t507 sg13_lv_pmos ad=0.3808p pd=2.92u as=0.3808p ps=2.92u w=1.12u l=0.13u
X1781 vss.t1857 vdd.t1740 vss.t1855 vss.t1844 sg13_lv_nmos ad=79.8f pd=0.8u as=0 ps=0 w=0.42u l=1u
X1782 a_26670_16346# a_19964_18216# a_20138_14766# vdd.t1127 sg13_lv_pmos ad=95f pd=0.88u as=0.17p ps=1.68u w=0.5u l=10u
X1783 vss.t1879 vdd.t1734 vss.t1881 vss.t1880 sg13_lv_nmos ad=79.8f pd=0.8u as=0 ps=0 w=0.42u l=1u
X1784 vdd.t511 a_1286_1655# a_1322_1586# vdd.t504 sg13_lv_pmos ad=1.21587p pd=7.58u as=0.3864p ps=2.93u w=1.12u l=0.13u
X1785 vdd.t427 vss.t2189 vdd.t426 vdd.t290 sg13_lv_pmos ad=0.34p pd=2.68u as=0 ps=0 w=1u l=1u
X1786 vcm_esd.t5 d_phi1.t11 vcm_esd.t4 vdd.t556 sg13_lv_pmos ad=0.68p pd=4.68u as=0 ps=0 w=2u l=1u
X1787 vdd.t204 vss.t2268 vdd.t241 vdd.t68 sg13_lv_pmos ad=0.19p pd=1.38u as=0 ps=0 w=1u l=1u
X1788 xvcm_vcf_t.t1 d_vcm_phi2 vcm_esd.t22 vss.t371 sg13_lv_nmos ad=1.36p pd=8.68u as=1.36p ps=8.68u w=4u l=0.5u
X1789 xsc_xcmfb1_vsw_cm_p.t3 d_phi2.t13 xsc_xcmfb1_vsw_cm_p.t2 vdd.t558 sg13_lv_pmos ad=0.285p pd=1.88u as=0 ps=0 w=1.5u l=1u
X1790 vss.t1913 vdd.t1726 vss.t1912 vss.t1907 sg13_lv_nmos ad=0.1428p pd=1.52u as=0 ps=0 w=0.42u l=1u
X1791 quantizer2_lfsr_0.sg13cmos5l_dfrbpq_1_13.D.t0 a_1284_13269# vss.t1283 vss.t1282 sg13_lv_nmos ad=0.2516p pd=2.16u as=0.1406p ps=1.12u w=0.74u l=0.13u
X1792 vdd.t1139 a_2034_14038# a_2034_14421# vdd.t507 sg13_lv_pmos ad=0.2128p pd=1.5u as=0.3864p ps=2.93u w=1.12u l=0.13u
X1793 a_9357_11104.t16 xq_vg_p_0_.t3 a_11293_11104.t0 vss.t403 sg13_lv_nmos ad=0.285p pd=1.88u as=0.285p ps=1.88u w=1.5u l=0.5u
X1794 vss.t576 clk_noverlap_0.sg13cmos5l_dlygate4sd3_1_4.A a_8587_7241# vss.t87 sg13_lv_nmos ad=79.8f pd=0.8u as=0.1428p ps=1.52u w=0.42u l=0.13u
X1795 vdd.t538 clk_noverlap_0.sg13cmos5l_inv_1_0.A a_10483_7459# vdd.t308 sg13_lv_pmos ad=0.2856p pd=2.36u as=0.1596p ps=1.22u w=0.84u l=0.13u
X1796 quantizer2_lfsr_0.sg13cmos5l_dfrbpq_1_8.D a_522_8085# vdd.t663 vdd.t504 sg13_lv_pmos ad=0.3808p pd=2.92u as=0.2128p ps=1.5u w=1.12u l=0.13u
X1797 a_2083_2244# a_2034_3336# a_2083_2182# vss.t1123 sg13_lv_nmos ad=0.1428p pd=1.52u as=37.8f ps=0.6u w=0.42u l=0.13u
X1798 a_9357_11104.t18 xq_vg_p_1_.t3 a_11293_11104.t7 vss.t642 sg13_lv_nmos ad=0.285p pd=1.88u as=0.285p ps=1.88u w=1.5u l=0.5u
X1799 vdd.t1375 vdd.t1373 vdd.t1256 vdd.t1287 sg13_lv_pmos ad=0.17p pd=1.68u as=0 ps=0 w=0.5u l=5u
X1800 vss.t264 vss.t261 vss.t263 vss.t262 sg13_hv_nmos ad=0.34p pd=2.68u as=0 ps=0 w=1u l=10u
X1801 a_22252_8246# bias_gm_0.bias_trim_0.vz.t40 vdd.t984 vdd.t566 sg13_lv_pmos ad=95f pd=0.88u as=95f ps=0.88u w=0.5u l=5u
X1802 sg13cmos5l_inv_1_14.A.t4 sg13cmos5l_and2_2_1.X.t3 vdd.t965 vdd.t863 sg13_lv_pmos ad=0.285p pd=1.88u as=0.285p ps=1.88u w=1.5u l=0.5u
X1803 vdd.t511 a_1407_10130# a_1443_10041# vdd.t504 sg13_lv_pmos ad=1.21587p pd=7.58u as=93.45f ps=0.865u w=0.42u l=0.13u
X1804 a_21830_2088# a_21554_2052.t9 vss.t247 vss.t539 sg13_lv_nmos ad=0.17p pd=1.68u as=95f ps=0.88u w=0.5u l=0.5u
X1805 vdd.t1327 vdd.t1325 vdd.t967 vdd.t863 sg13_lv_pmos ad=0.285p pd=1.88u as=0 ps=0 w=1.5u l=0.5u
X1806 vdd.t221 vss.t2247 vdd.t220 vdd.t79 sg13_lv_pmos ad=0.34p pd=2.68u as=0 ps=0 w=1u l=1u
X1807 vss.t1966 vdd.t1714 vss.t1968 vss.t1967 sg13_lv_nmos ad=79.8f pd=0.8u as=0 ps=0 w=0.42u l=1u
X1808 vdd.t856 a_5176_31117# vdd.t857 vdd.t764 sg13_lv_pmos ad=0.19p pd=1.38u as=0 ps=0 w=1u l=2u
X1809 a_4362_8188.t9 sg13cmos5l_or2_1_0.X.t3 xq_dith_v_bq.t9 vss.t921 sg13_lv_nmos ad=0.665p pd=3.88u as=0.665p ps=3.88u w=3.5u l=0.13u
X1810 vdd.t511 a_537_6405# a_533_7328# vdd.t504 sg13_lv_pmos ad=1.21587p pd=7.58u as=0.3864p ps=2.93u w=1.12u l=0.13u
X1811 a_567_8562# a_537_8997# a_558_8294# vss.t933 sg13_lv_nmos ad=79.8f pd=0.8u as=0.1296p ps=1.52u w=0.42u l=0.13u
X1812 vss.t839 dsm2_io_0.sg13cmos5l_inv_1_1.A d_qout_en.t1 vss.t467 sg13_lv_nmos ad=0.2516p pd=2.16u as=0.2516p ps=2.16u w=0.74u l=0.13u
X1813 xsc_vc1l_p.t6 d_phi2.t7 sw_tgate_10.p.t0 vss.t198 sg13_lv_nmos ad=0.19p pd=1.38u as=0.19p ps=1.38u w=1u l=1u
X1814 vdd.t511 a_522_10130# a_873_10041# vdd.t504 sg13_lv_pmos ad=1.21587p pd=7.58u as=93.45f ps=0.865u w=0.42u l=0.13u
X1815 vss.t287 a_20328_23820# vss.t1363 vss.t262 sg13_hv_nmos ad=1.9p pd=10.38u as=0 ps=0 w=10u l=10u
X1816 sw_tgate_12.m.t6 d_qi_b.t8 sw_tgate_12.m.t7 vss.t1034 sg13_lv_nmos ad=0.19p pd=1.38u as=0 ps=0 w=1u l=1u
X1817 vdd.t979 inv_en_0.di_b.t2 a_10787_14878# vdd.t502 sg13_lv_pmos ad=0.2856p pd=2.36u as=0.1596p ps=1.22u w=0.84u l=0.13u
X1818 vdd.t1144 a_522_15478# a_522_15861# vdd.t504 sg13_lv_pmos ad=0.2128p pd=1.5u as=0.3864p ps=2.93u w=1.12u l=0.13u
X1819 vss.t1532 vdd.t1817 vss.t1534 vss.t1533 sg13_lv_nmos ad=79.8f pd=0.8u as=0 ps=0 w=0.42u l=1u
X1820 vdd.t112 vss.t2302 vdd.t111 vdd.t110 sg13_lv_pmos ad=0.19p pd=1.38u as=0 ps=0 w=1u l=1u
X1821 vdd.t983 bias_gm_0.bias_trim_0.vz.t41 a_23328_9146# vdd.t287 sg13_lv_pmos ad=95f pd=0.88u as=95f ps=0.88u w=0.5u l=5u
X1822 vss.t1781 vdd.t1758 vss.t1778 vss.t1780 sg13_lv_nmos ad=79.8f pd=0.8u as=0 ps=0 w=0.42u l=1u
X1823 vss.t1547 vdd.t1814 vss.t1546 vss.t1545 sg13_lv_nmos ad=0.1428p pd=1.52u as=0 ps=0 w=0.42u l=1u
X1824 xq_dith_v_bq.t8 sg13cmos5l_or2_1_0.X.t3 a_4362_8188.t8 vss.t918 sg13_lv_nmos ad=0.665p pd=3.88u as=0.665p ps=3.88u w=3.5u l=0.13u
X1825 a_19984_17824# bias_gm_0.bias_trim_0.vz.t0 vdd.t1255 vdd.t287 sg13_lv_pmos ad=95f pd=0.88u as=95f ps=0.88u w=0.5u l=5u
X1826 a_6249_9100.t5 d_amp_s_b[3].t2 a_12075_9628.t1 vdd.t659 sg13_lv_pmos ad=95f pd=0.88u as=0.17p ps=1.68u w=0.5u l=0.13u
X1827 a_20672_19620# a_24258_19760# vss.t207 rhigh l=17.5u w=0.5u
X1828 inv_en_0.di d_ena.t7 vss.t1436 vss.t1435 sg13_hv_nmos ad=0.34p pd=2.68u as=0.34p ps=2.68u w=1u l=0.45u
X1829 vss.t58 dsm2_io_vcmg_0.di_phi1_b a_8880_5832# vss.t1190 sg13_lv_nmos ad=0.1469p pd=1.155u as=0.1045p ps=0.93u w=0.55u l=0.13u
X1830 vdd.t813 a_5176_31117# vdd.t812 vdd.t764 sg13_lv_pmos ad=0.34p pd=2.68u as=0 ps=0 w=1u l=2u
X1831 xsc_xcmfb1_vsw_vbias.t8 d_phi1.t6 xsc_xcmfb1_vsw_vbias.t7 vdd.t560 sg13_lv_pmos ad=0.285p pd=1.88u as=0 ps=0 w=1.5u l=1u
X1832 a_22252_4074# bias_gm_0.bias_trim_0.vz.t22 vdd.t732 vdd.t566 sg13_lv_pmos ad=95f pd=0.88u as=95f ps=0.88u w=0.5u l=5u
X1833 clk_noverlap_0.sg13cmos5l_inv_1_9.A clk_noverlap_0.sg13cmos5l_inv_1_10.A vss.t454 vss.t453 sg13_lv_nmos ad=0.2516p pd=2.16u as=0.2516p ps=2.16u w=0.74u l=0.13u
X1834 dsm2_osc_0.sg13cmos5l_inv_1_3.A a_21452_2308.t5 a_23674_2578# vdd.t514 sg13_lv_pmos ad=0.17p pd=1.68u as=95f ps=0.88u w=0.5u l=0.5u
X1835 a_2034_5928# a_2079_4530# vss.t91 vss.t90 sg13_lv_nmos ad=0.2516p pd=2.16u as=0.1626p ps=1.415u w=0.74u l=0.13u
X1836 vcm_esd.t9 d_phi1.t9 vcm_esd.t8 vdd.t556 sg13_lv_pmos ad=0.38p pd=2.38u as=0 ps=0 w=2u l=1u
X1837 bias_gm_0.bias_trim_0.iout vdd.t1608 bias_gm_0.bias_trim_0.iout vdd.t1173 sg13_lv_pmos ad=95f pd=0.88u as=0 ps=0 w=0.5u l=5u
X1838 a_11672_6736# clk_noverlap_0.sg13cmos5l_inv_1_0.A vdd.t540 vdd.t308 sg13_lv_pmos ad=0.2464p pd=1.56u as=0.3808p ps=2.92u w=1.12u l=0.13u
X1839 vss.t575 a_7129_7200# a_7241_7224# vss.t618 sg13_lv_nmos ad=0.1426p pd=1.16u as=0.1428p ps=1.52u w=0.42u l=0.5u
X1840 a_20672_21300# a_24258_21440# vss.t207 rhigh l=17.5u w=0.5u
X1841 vss.t168 vcm_esd.t25 vss.t171 vss.t170 sg13_hv_nmos ad=1.9p pd=10.38u as=0 ps=0 w=10u l=10u
X1842 vdd.t686 d_dith_en.t16 a_2079_7122# vdd.t507 sg13_lv_pmos ad=0.1563p pd=1.22u as=0.147p ps=1.54u w=0.42u l=0.13u
X1843 vss.t1823 vdd.t1748 vss.t1822 vss.t1821 sg13_lv_nmos ad=0.1428p pd=1.52u as=0 ps=0 w=0.42u l=1u
X1844 a_1668_16187# quantizer2_lfsr_0.sg13cmos5l_dfrbpq_1_13.D.t3 vss.t953 vss.t952 sg13_lv_nmos ad=78.39999f pd=0.885u as=0.2272p ps=1.99u w=0.64u l=0.13u
X1845 vss.t2092 sg13cmos5l_inv_1_1.A vss.t2091 vss.t2090 sg13_lv_nmos ad=1.19p pd=7.68u as=0 ps=0 w=3.5u l=1u
X1846 vdd.t434 vss.t2215 vdd.t433 vdd.t181 sg13_lv_pmos ad=0.34p pd=2.68u as=0 ps=0 w=1u l=1u
X1847 vss.t592 sg13cmos5l_inv_2_0.Y sg13cmos5l_nor2_2_0.Y vss.t591 sg13_lv_nmos ad=0.2516p pd=2.16u as=0.1406p ps=1.12u w=0.74u l=0.13u
X1848 vdd.t940 bias_gm_0.bias_trim_0.vz.t25 a_24404_4674# vdd.t573 sg13_lv_pmos ad=95f pd=0.88u as=95f ps=0.88u w=0.5u l=5u
X1849 a_1367_9125# quantizer2_lfsr_0.sg13cmos5l_dfrbpq_1_15.D vdd.t589 vdd.t504 sg13_lv_pmos ad=79.8f pd=0.8u as=0.1428p ps=1.52u w=0.42u l=0.13u
X1850 vss.t1008 d_qi_b.t6 vss.t1027 vdd.t562 sg13_lv_pmos ad=0.68p pd=4.68u as=0 ps=0 w=2u l=1u
X1851 a_873_4857# a_533_4736# a_522_5110# vdd.t504 sg13_lv_pmos ad=93.45f pd=0.865u as=0.2048p ps=1.63u w=0.42u l=0.13u
X1852 a_11841_7467# a_11956_7466# vss.t624 vss.t623 sg13_lv_nmos ad=0.1428p pd=1.52u as=0.1426p ps=1.16u w=0.42u l=0.5u
X1853 a_9357_11104.t0 vo_p.t24 a_9533_11104.t0 vss.t29 sg13_lv_nmos ad=0.76p pd=4.38u as=0.76p ps=4.38u w=4u l=0.5u
X1854 vss.t143 a_537_11589# a_533_12512# vss.t1293 sg13_lv_nmos ad=4.19617p pd=26.765u as=0.2516p ps=2.16u w=0.74u l=0.13u
X1855 vss.t91 d_dith_en.t10 a_2070_4356# vss.t1131 sg13_lv_nmos ad=0.1626p pd=1.415u as=60.89999f ps=0.71u w=0.42u l=0.13u
X1856 vdd.t890 a_8857_7200# a_8969_7224# vdd.t308 sg13_lv_pmos ad=0.2254p pd=1.53u as=0.34p ps=2.68u w=1u l=0.5u
X1857 vss.t1716 vdd.t1773 vss.t1717 vss.t1713 sg13_lv_nmos ad=79.8f pd=0.8u as=0 ps=0 w=0.42u l=1u
X1858 d_amp_s[3].t1 quantizer2_lfsr_0.sg13cmos5l_nor2_1_1.B a_2368_16778# vdd.t507 sg13_lv_pmos ad=0.3808p pd=2.92u as=0.1176p ps=1.33u w=1.12u l=0.13u
X1859 a_6452_29739.t5 xsc_vfb.t12 vss.t62 vss.t100 sg13_lv_nmos ad=95f pd=0.88u as=95f ps=0.88u w=0.5u l=3u
X1860 w_9407_29481.t1 w_9407_29481.t13 w_9407_29481.t14 w_9407_29481.t0 sg13_lv_pmos ad=0.68p pd=4.68u as=0 ps=0 w=2u l=1u
X1861 a_22184_2052# a_21736_2344# a_22386_2578# vdd.t514 sg13_lv_pmos ad=0.17p pd=1.68u as=95f ps=0.88u w=0.5u l=0.13u
X1862 vss.t368 vss.t366 vss.t378 vss.t377 sg13_lv_nmos ad=95f pd=0.88u as=0 ps=0 w=0.5u l=0.5u
X1863 a_8302_15626# sg13cmos5l_inv_1_19.Y.t8 a_8208_15626# vdd.t502 sg13_lv_pmos ad=0.1596p pd=1.22u as=0.2856p ps=2.36u w=0.84u l=0.13u
X1864 a_22252_4074# bias_gm_0.bias_trim_0.vz.t34 vdd.t1168 vdd.t572 sg13_lv_pmos ad=95f pd=0.88u as=95f ps=0.88u w=0.5u l=5u
X1865 vss.t1733 vdd.t1769 vss.t1735 vss.t1734 sg13_lv_nmos ad=79.8f pd=0.8u as=0 ps=0 w=0.42u l=1u
X1866 a_11173_9488.t1 a_12075_9628.t0 vss.t219 rhigh l=4.08u w=0.5u
X1867 vss.t690 di_trim[0] dsm2_io_0.do_trim_b[0].t0 vss.t689 sg13_hv_nmos ad=0.34p pd=2.68u as=0.34p ps=2.68u w=1u l=0.45u
X1868 d_amp_s_b[3].t0 d_amp_s[3].t4 vss.t665 vss.t664 sg13_lv_nmos ad=0.2516p pd=2.16u as=0.2516p ps=2.16u w=0.74u l=0.13u
X1869 vdd.t1158 bias_gm_0.bias_trim_0.vz.t37 a_22252_8246# vdd.t570 sg13_lv_pmos ad=95f pd=0.88u as=95f ps=0.88u w=0.5u l=5u
X1870 sg13cmos5l_inv_1_14.A.t9 vdd.t1309 vdd.t1338 vdd.t863 sg13_lv_pmos ad=0.285p pd=1.88u as=0.285p ps=1.88u w=1.5u l=0.5u
X1871 dsm2_osc_0.sg13cmos5l_dfrbp_1_0.RESET_B.t1 dsm2_osc_0.dsm2_io_rx_0.di_b.t3 vdd.t648 vdd.t515 sg13_lv_pmos ad=0.3808p pd=2.92u as=0.3808p ps=2.92u w=1.12u l=0.13u
X1872 a_21977_22824# a_24258_22964# vss.t212 rhigh l=10.975u w=0.5u
X1873 vss.t1025 a_1407_12722# a_1681_12337# vss.t1024 sg13_lv_nmos ad=79.8f pd=0.8u as=0.1428p ps=1.52u w=0.42u l=0.13u
X1874 a_522_2354# a_522_2518# a_558_2482# vss.t553 sg13_lv_nmos ad=0.1428p pd=1.52u as=37.8f ps=0.6u w=0.42u l=0.13u
X1875 a_13569_7467# a_13684_7466# vdd.t670 vdd.t308 sg13_lv_pmos ad=0.34p pd=2.68u as=0.2254p ps=1.53u w=1u l=0.5u
X1876 xq_dith_v_bp.t1 sg13cmos5l_inv_1_9.Y.t2 a_4362_8188.t2 vdd.t623 sg13_lv_pmos ad=1.19p pd=7.68u as=0.665p ps=3.88u w=3.5u l=0.13u
X1877 vdd.t2 vss.t2396 vdd.t1 vdd.t0 sg13_lv_pmos ad=0.19p pd=1.38u as=0 ps=0 w=1u l=1u
X1878 vss.t1201 vss.t1202 vss.t710 rhigh l=20u w=0.5u
X1879 vss.t171 vcm_esd.t25 vss.t173 vss.t172 sg13_hv_nmos ad=1.9p pd=10.38u as=0 ps=0 w=10u l=10u
X1880 a_10878_6484# clk_noverlap_0.di_clk.t2 a_10784_6484# vss.t926 sg13_lv_nmos ad=0.1216p pd=1.02u as=0.2176p ps=1.96u w=0.64u l=0.13u
X1881 a_1324_3396# a_1288_3370# vdd.t1053 vdd.t504 sg13_lv_pmos ad=0.34p pd=2.68u as=0.36237p ps=2.605u w=1u l=0.13u
X1882 vss.t418 vss.t416 vss.t417 vss.t367 sg13_lv_nmos ad=0.51p pd=3.68u as=0 ps=0 w=1.5u l=0.5u
X1883 vss.t165 vcm_esd.t23 dantenna l=3.1u w=0.64u
X1884 vss.t1935 vdd.t1721 vss.t1934 vss.t1925 sg13_lv_nmos ad=0.1428p pd=1.52u as=0 ps=0 w=0.42u l=1u
X1885 vdd.t303 vss.t2421 vdd.t302 vdd.t0 sg13_lv_pmos ad=0.34p pd=2.68u as=0 ps=0 w=1u l=1u
X1886 a_23674_2344# a_21452_2308.t5 vss.t2081 vss.t2080 sg13_lv_nmos ad=95f pd=0.88u as=0.17p ps=1.68u w=0.5u l=0.5u
X1887 ibias_200n.t0 vss.t2175 a_22252_8246# vdd.t384 sg13_lv_pmos ad=95f pd=0.88u as=95f ps=0.88u w=0.5u l=5u
X1888 vo_n.t3 vss.t297 vo_n.t2 vss.t298 sg13_lv_nmos ad=95f pd=0.88u as=0 ps=0 w=0.5u l=1u
X1889 vss.t721 sw_tgate_cmfb2_1.p.t11 vss.t720 vss.t108 sg13_lv_nmos ad=95f pd=0.88u as=0 ps=0 w=0.5u l=3u
X1890 do_q_b.t1 sg13cmos5l_inv_1_12.Y vss.t565 vss.t564 sg13_lv_nmos ad=0.1406p pd=1.12u as=0.2516p ps=2.16u w=0.74u l=0.13u
X1891 a_9357_11104.t10 xq_vg_q_1_.t3 a_9533_11104.t3 vss.t385 sg13_lv_nmos ad=0.285p pd=1.88u as=0.285p ps=1.88u w=1.5u l=0.5u
X1892 xsc_vc1r_p.t5 sw_tgate_11.gb.t6 xsc_vc1r_p.t4 vss.t958 sg13_lv_nmos ad=0.19p pd=1.38u as=0 ps=0 w=1u l=1u
X1893 a_24540_21720# a_28126_21580# vss.t34 rhigh l=17.5u w=0.5u
X1894 vdd.t534 sg13cmos5l_and2_1_5.B.t3 a_8013_14934# vdd.t502 sg13_lv_pmos ad=0.1918p pd=1.5u as=0.1596p ps=1.22u w=0.84u l=0.13u
X1895 vss.t1482 vdd.t1827 vss.t1481 vss.t1480 sg13_lv_nmos ad=0.1428p pd=1.52u as=0 ps=0 w=0.42u l=1u
X1896 a_9357_11104.t17 xq_vg_q_2_.t3 a_9533_11104.t6 vss.t28 sg13_lv_nmos ad=0.285p pd=1.88u as=0.285p ps=1.88u w=1.5u l=0.5u
X1897 vss.t339 vss.t335 vss.t341 vss.t267 sg13_lv_nmos ad=95f pd=0.88u as=0 ps=0 w=0.5u l=10u
X1898 vdd.t1442 vdd.t1440 vdd.t679 vdd.t1287 sg13_lv_pmos ad=0.17p pd=1.68u as=0 ps=0 w=0.5u l=5u
X1899 vss.t1909 vdd.t1727 vss.t1911 vss.t1910 sg13_lv_nmos ad=79.8f pd=0.8u as=0 ps=0 w=0.42u l=1u
X1900 vss.t1378 vss.t1379 vss.t39 rhigh l=2.75u w=0.5u
X1901 vdd.t133 vss.t2267 vdd.t377 vdd.t68 sg13_lv_pmos ad=0.34p pd=2.68u as=0 ps=0 w=1u l=1u
X1902 a_23294_2344# a_22644_2344# a_21452_2308.t0 vss.t684 sg13_lv_nmos ad=95f pd=0.88u as=95f ps=0.88u w=0.5u l=0.13u
X1903 a_22644_2344# a_22184_2052# a_22738_2578# vdd.t514 sg13_lv_pmos ad=95f pd=0.88u as=95f ps=0.88u w=0.5u l=0.13u
X1904 vdd.t511 a_522_2354# a_873_2265# vdd.t504 sg13_lv_pmos ad=1.21587p pd=7.58u as=93.45f ps=0.865u w=0.42u l=0.13u
X1905 a_1324_13764# a_1288_13738# vdd.t1060 vdd.t504 sg13_lv_pmos ad=0.34p pd=2.68u as=0.36237p ps=2.605u w=1u l=0.13u
X1906 a_1443_15225# a_1322_14546# a_1284_15759# vdd.t504 sg13_lv_pmos ad=93.45f pd=0.865u as=0.2048p ps=1.63u w=0.42u l=0.13u
X1907 vss.t653 a_14734_15077# sg13cmos5l_and2_1_5.B.t0 vss.t652 sg13_lv_nmos ad=0.1426p pd=1.16u as=0.2516p ps=2.16u w=0.74u l=0.13u
X1908 a_1284_13167# a_1286_12023# a_1681_12337# vss.t2133 sg13_lv_nmos ad=0.12665p pd=1.145u as=0.1428p ps=1.52u w=0.42u l=0.13u
X1909 a_5892_8400.t0 sg13cmos5l_inv_1_6.A.t3 xq_vg_q_1_.t0 vdd.t580 sg13_lv_pmos ad=0.17p pd=1.68u as=95f ps=0.88u w=0.5u l=0.13u
X1910 vdd.t733 bias_gm_0.bias_trim_0.vz.t22 a_22252_4074# vdd.t384 sg13_lv_pmos ad=95f pd=0.88u as=95f ps=0.88u w=0.5u l=5u
X1911 a_20770_598# dsm2_osc_0.sg13cmos5l_mux2_1_0.A1 a_20673_598# vss.t150 sg13_lv_nmos ad=0.1628p pd=1.18u as=0.13135p ps=1.095u w=0.74u l=0.13u
X1912 a_21498_769# a_21617_558# vss.t160 vss.t161 sg13_lv_nmos ad=0.2516p pd=2.16u as=0.1406p ps=1.12u w=0.74u l=0.13u
X1913 vdd.t547 dsm2_osc_0.sg13cmos5l_inv_1_2.Y do_clk_osc.t1 vdd.t515 sg13_lv_pmos ad=0.3864p pd=2.93u as=0.2128p ps=1.5u w=1.12u l=0.13u
X1914 vdd.t1184 bias_gm_0.bias_trim_0.vz.t3 bias_gm_0.bias_trim_0.vz.t4 vdd.t573 sg13_lv_pmos ad=95f pd=0.88u as=95f ps=0.88u w=0.5u l=5u
X1915 vdd.t507 a_2034_11446# a_2034_11282# vdd.t507 sg13_lv_pmos ad=1.99007p pd=12.8u as=79.8f ps=0.8u w=0.42u l=0.13u
X1916 xq_dith_v_bp.t7 sg13cmos5l_inv_1_3.A.t2 vo_n.t11 vss.t717 sg13_lv_nmos ad=0.665p pd=3.88u as=0.665p ps=3.88u w=3.5u l=0.13u
X1917 vdd.t104 vss.t2290 vdd.t103 vdd.t102 sg13_lv_pmos ad=0.19p pd=1.38u as=0 ps=0 w=1u l=1u
X1918 a_6884_8680# a_10757_8328# vss.t882 rhigh l=10.05u w=0.5u
X1919 a_22252_8246# bias_gm_0.bias_trim_0.vz.t49 vdd.t682 vdd.t287 sg13_lv_pmos ad=95f pd=0.88u as=95f ps=0.88u w=0.5u l=5u
X1920 vdd.t575 bias_gm_0.bias_trim_0.vz.t6 a_19984_17824# vdd.t384 sg13_lv_pmos ad=95f pd=0.88u as=95f ps=0.88u w=0.5u l=5u
X1921 vo_n.t1 vss.t295 vo_n.t0 vss.t296 sg13_lv_nmos ad=0.17p pd=1.68u as=0 ps=0 w=0.5u l=1u
X1922 a_6202_14892# d_dith[2].t2 vss.t2097 vss.t0 sg13_lv_nmos ad=0.1406p pd=1.12u as=0.2516p ps=2.16u w=0.74u l=0.13u
X1923 vss.t224 a_2049_7557# a_2045_8480# vss.t223 sg13_lv_nmos ad=2.71757p pd=16.785u as=0.2516p ps=2.16u w=0.74u l=0.13u
X1924 vdd.t366 vss.t2206 vdd.t365 vdd.t187 sg13_lv_pmos ad=0.19p pd=1.38u as=0 ps=0 w=1u l=1u
X1925 a_11293_11104.t4 sg13cmos5l_inv_1_2.A.t10 sg13cmos5l_inv_1_14.A.t5 vss.t644 sg13_lv_nmos ad=95f pd=0.88u as=95f ps=0.88u w=0.5u l=0.5u
X1926 a_873_15225# a_533_15104# a_522_15478# vdd.t504 sg13_lv_pmos ad=93.45f pd=0.865u as=0.2048p ps=1.63u w=0.42u l=0.13u
X1927 vss.t493 a_10483_7459# d_qclk.t1 vss.t492 sg13_lv_nmos ad=0.1331p pd=1.12u as=0.2516p ps=2.16u w=0.74u l=0.13u
X1928 a_22252_4374# bias_gm_0.bias_trim_0.vz.t25 vdd.t940 vdd.t287 sg13_lv_pmos ad=95f pd=0.88u as=95f ps=0.88u w=0.5u l=5u
X1929 a_22252_7946# bias_gm_0.bias_trim_0.vz.t36 vdd.t990 vdd.t572 sg13_lv_pmos ad=95f pd=0.88u as=95f ps=0.88u w=0.5u l=5u
X1930 a_22138_16046# a_20138_14766# a_20070_16046# vdd.t897 sg13_lv_pmos ad=95f pd=0.88u as=0.17p ps=1.68u w=0.5u l=10u
X1931 a_24258_22824# a_22252_11246# vss.t49 rhigh l=10.975u w=0.5u
X1932 vdd.t120 vss.t2318 vdd.t119 vdd.t71 sg13_lv_pmos ad=0.19p pd=1.38u as=0 ps=0 w=1u l=1u
X1933 vdd.t536 a_2034_8854# a_2034_9237# vdd.t507 sg13_lv_pmos ad=0.2128p pd=1.5u as=0.3864p ps=2.93u w=1.12u l=0.13u
X1934 xsc_vc1l_n.t7 d_phi1.t4 xsc_vc1l_n.t6 vdd.t562 sg13_lv_pmos ad=0.38p pd=2.38u as=0 ps=0 w=2u l=1u
X1935 vdd.t766 a_5176_31117# vdd.t765 vdd.t764 sg13_lv_pmos ad=0.34p pd=2.68u as=0 ps=0 w=1u l=2u
X1936 vss.t1007 d_qi.t6 sw_tgate_8.m.t7 vdd.t562 sg13_lv_pmos ad=0.68p pd=4.68u as=0.38p ps=2.38u w=2u l=1u
X1937 vo_n.t10 sg13cmos5l_inv_1_3.A.t2 xq_dith_v_bp.t5 vss.t717 sg13_lv_nmos ad=0.665p pd=3.88u as=0.665p ps=3.88u w=3.5u l=0.13u
X1938 vss.t680 a_14433_7467# clk_noverlap_0.sg13cmos5l_dlygate4sd3_1_7.A vss.t580 sg13_lv_nmos ad=0.1426p pd=1.16u as=0.2516p ps=2.16u w=0.74u l=0.13u
X1939 a_1600_9125# a_1322_9362# a_1288_8554# vss.t603 sg13_lv_nmos ad=0.2373p pd=1.97u as=79.8f ps=0.8u w=0.42u l=0.13u
X1940 a_1286_9431# d_qclk.t12 vdd.t511 vdd.t504 sg13_lv_pmos ad=0.4088p pd=2.97u as=1.1847p ps=7.385u w=1.12u l=0.13u
X1941 vss.t2029 vdd.t1701 vss.t2031 vss.t2030 sg13_lv_nmos ad=79.8f pd=0.8u as=0 ps=0 w=0.42u l=1u
X1942 vdd.t73 vss.t2321 vdd.t72 vdd.t71 sg13_lv_pmos ad=0.34p pd=2.68u as=0 ps=0 w=1u l=1u
X1943 vdd.t607 a_10592_15909# sg13cmos5l_inv_1_12.A vdd.t502 sg13_lv_pmos ad=0.1918p pd=1.5u as=0.3808p ps=2.92u w=1.12u l=0.13u
X1944 a_571_3622# d_dith_en.t9 vss.t1127 vss.t1126 sg13_lv_nmos ad=37.8f pd=0.6u as=0.1701p ps=1.65u w=0.42u l=0.13u
X1945 vdd.t507 a_2049_12741# a_2045_13664# vdd.t507 sg13_lv_pmos ad=1.99007p pd=12.8u as=0.3864p ps=2.93u w=1.12u l=0.13u
X1946 vss.t328 vss.t323 vss.t324 vss.t265 sg13_hv_nmos ad=0.19p pd=1.38u as=0 ps=0 w=1u l=10u
X1947 a_670_25288# vss.t2322 d_ena.t0 vdd.t25 sg13_hv_pmos ad=0.19p pd=1.38u as=0.34p ps=2.68u w=1u l=5u
X1948 vss.t1153 sg13cmos5l_inv_2_5.A sg13cmos5l_inv_2_5.Y vss.t1152 sg13_lv_nmos ad=0.2516p pd=2.16u as=0.1406p ps=1.12u w=0.74u l=0.13u
X1949 vdd.t551 a_21617_558# dsm2_osc_0.sg13cmos5l_dfrbp_1_0.Q_N vdd.t515 sg13_lv_pmos ad=0.2639p pd=1.81u as=0.4312p ps=3.01u w=1.12u l=0.13u
X1950 vdd.t1158 vdd.t1491 vdd.t1492 vdd.t1173 sg13_lv_pmos ad=95f pd=0.88u as=0 ps=0 w=0.5u l=5u
X1951 a_1600_9125# a_1324_8580# a_1745_8806# vss.t963 sg13_lv_nmos ad=0.1428p pd=1.52u as=37.8f ps=0.6u w=0.42u l=0.13u
X1952 vdd.t579 vdd.t1396 vdd.t1397 vdd.t1173 sg13_lv_pmos ad=95f pd=0.88u as=0 ps=0 w=0.5u l=5u
X1953 a_7224_31505# a_5176_31469# w_9407_29481.t11 vdd.t764 sg13_lv_pmos ad=0.665p pd=3.88u as=0.665p ps=3.88u w=3.5u l=2u
X1954 a_9357_11104.t5 xq_vg_p_2_.t3 a_11293_11104.t9 vss.t410 sg13_lv_nmos ad=0.285p pd=1.88u as=0.285p ps=1.88u w=1.5u l=0.5u
X1955 vss.t71 xsc_vfb.t11 a_7804_29739.t7 vss.t70 sg13_lv_nmos ad=95f pd=0.88u as=95f ps=0.88u w=0.5u l=3u
X1956 xvcm_vcf_b.t1 d_vcm_phi2 vss.t1212 vss.t371 sg13_hv_nmos ad=0.68p pd=4.68u as=0.68p ps=4.68u w=2u l=0.45u
X1957 vss.t1815 vdd.t1750 vss.t1813 vss.t1814 sg13_lv_nmos ad=79.8f pd=0.8u as=0 ps=0 w=0.42u l=1u
X1958 ibias_200n.t4 dsm2_io_0.do_trim_b[1].t3 a_24404_8546# vdd.t573 sg13_lv_pmos ad=95f pd=0.88u as=95f ps=0.88u w=0.5u l=5u
X1959 vdd.t233 vss.t2218 vdd.t223 vdd.t222 sg13_lv_pmos ad=0.19p pd=1.38u as=0 ps=0 w=1u l=1u
X1960 a_6249_9100.t6 d_amp_s[3].t2 a_12075_9628.t2 vss.t667 sg13_lv_nmos ad=95f pd=0.88u as=0.17p ps=1.68u w=0.5u l=0.13u
X1961 vss.t334 vss.t323 vss.t331 vss.t269 sg13_hv_nmos ad=0.19p pd=1.38u as=0 ps=0 w=1u l=10u
X1962 vss.t1628 vdd.t1795 vss.t1627 vss.t1617 sg13_lv_nmos ad=0.1428p pd=1.52u as=0 ps=0 w=0.42u l=1u
X1963 vss.t1704 vdd.t1776 vss.t1703 vss.t1702 sg13_lv_nmos ad=0.1428p pd=1.52u as=0 ps=0 w=0.42u l=1u
X1964 vdd.t748 di_trim[2] dsm2_io_0.do_trim_b[2].t1 vdd.t25 sg13_hv_pmos ad=0.17p pd=1.68u as=0.17p ps=1.68u w=0.5u l=1u
X1965 vdd.t1036 d_qi_b.t7 vdd.t1051 vss.t1036 sg13_lv_nmos ad=0.19p pd=1.38u as=0 ps=0 w=1u l=1u
X1966 vss.t524 a_522_2354# a_558_2286# vss.t523 sg13_lv_nmos ad=79.8f pd=0.8u as=0.1428p ps=1.52u w=0.42u l=0.13u
X1967 a_571_6276# a_522_7368# a_571_6214# vss.t2102 sg13_lv_nmos ad=0.1428p pd=1.52u as=37.8f ps=0.6u w=0.42u l=0.13u
X1968 sg13cmos5l_inv_1_2.A.t6 vdd.t1313 vdd.t1314 vdd.t863 sg13_lv_pmos ad=0.285p pd=1.88u as=0.285p ps=1.88u w=1.5u l=0.5u
X1969 vdd.t1602 vdd.t1590 vdd.t1604 vdd.t570 sg13_lv_pmos ad=95f pd=0.88u as=0 ps=0 w=0.5u l=5u
X1970 vss.t351 vss.t349 vss.t350 vss.t262 sg13_hv_nmos ad=0.17p pd=1.68u as=0 ps=0 w=0.5u l=10u
X1971 a_522_2518# a_537_1221# a_522_2184# vdd.t504 sg13_lv_pmos ad=0.2048p pd=1.63u as=0.34p ps=2.68u w=1u l=0.13u
X1972 quantizer2_lfsr_0.sg13cmos5l_dfrbpq_1_6.Q a_2034_14421# vss.t1200 vss.t1199 sg13_lv_nmos ad=0.2516p pd=2.16u as=0.1406p ps=1.12u w=0.74u l=0.13u
X1973 vss.t823 a_2049_12741# a_2045_13664# vss.t822 sg13_lv_nmos ad=2.71757p pd=16.785u as=0.2516p ps=2.16u w=0.74u l=0.13u
X1974 a_22347_812# a_22499_864# vdd.t515 vdd.t515 sg13_lv_pmos ad=0.3864p pd=2.93u as=1.93285p ps=12.62u w=1.12u l=0.13u
X1975 vss.t1958 vdd.t1716 vss.t1957 vss.t1942 sg13_lv_nmos ad=0.1428p pd=1.52u as=0 ps=0 w=0.42u l=1u
X1976 vdd.t1227 a_12445_30191# a_5176_31469# vdd.t764 sg13_lv_pmos ad=1.19p pd=7.68u as=1.19p ps=7.68u w=3.5u l=2u
X1977 vdd.t1620 sg13cmos5l_nand2_1_2.Y.t4 sg13cmos5l_inv_1_20.Y.t1 vdd.t502 sg13_lv_pmos ad=0.3808p pd=2.92u as=0.3808p ps=2.92u w=1.12u l=0.13u
X1978 a_19949_784# dsm2_osc_0.sg13cmos5l_buf_2_0.A vss.t27 vss.t688 sg13_lv_nmos ad=0.2176p pd=1.96u as=0.1371p ps=1.12u w=0.64u l=0.13u
X1979 a_14829_7164# clk_noverlap_0.sg13cmos5l_dlygate4sd3_1_9.A vdd.t671 vdd.t308 sg13_lv_pmos ad=0.1428p pd=1.52u as=0.1523p ps=1.38u w=0.42u l=0.13u
X1980 vss.t1552 vdd.t1813 vss.t1551 vss.t1550 sg13_lv_nmos ad=0.1428p pd=1.52u as=0 ps=0 w=0.42u l=1u
X1981 vdd.t785 a_5176_31117# vdd.t786 vdd.t764 sg13_lv_pmos ad=0.19p pd=1.38u as=0 ps=0 w=1u l=2u
X1982 clk_noverlap_0.sg13cmos5l_dlygate4sd3_1_1.X a_5513_7224# vdd.t593 vdd.t308 sg13_lv_pmos ad=0.4256p pd=3u as=0.2254p ps=1.53u w=1.12u l=0.13u
X1983 vdd.t511 a_1407_12722# a_1443_12633# vdd.t504 sg13_lv_pmos ad=1.21587p pd=7.58u as=93.45f ps=0.865u w=0.42u l=0.13u
X1984 a_1286_4247# d_qclk.t6 vss.t1413 vss.t1412 sg13_lv_nmos ad=0.2516p pd=2.16u as=2.50852p ps=15.49u w=0.74u l=0.13u
X1985 vss.t1507 vdd.t1822 vss.t1509 vss.t1508 sg13_lv_nmos ad=79.8f pd=0.8u as=0 ps=0 w=0.42u l=1u
X1986 vdd.t1429 vdd.t1423 vdd.t1431 vdd.t572 sg13_lv_pmos ad=95f pd=0.88u as=0 ps=0 w=0.5u l=5u
X1987 vdd.t792 a_5176_31117# vdd.t791 vdd.t764 sg13_lv_pmos ad=0.34p pd=2.68u as=0 ps=0 w=1u l=2u
X1988 vdd.t452 vss.t2240 vdd.t87 vdd.t85 sg13_lv_pmos ad=0.19p pd=1.38u as=0 ps=0 w=1u l=1u
X1989 a_8857_7200# a_8587_7241# vdd.t667 vdd.t308 sg13_lv_pmos ad=0.34p pd=2.68u as=0.1523p ps=1.38u w=1u l=0.5u
X1990 a_2034_11112# a_2045_11072# a_2034_11446# vss.t1291 sg13_lv_nmos ad=0.3473p pd=2.71u as=0.12665p ps=1.145u w=0.74u l=0.13u
X1991 vss.t1447 vdd.t1834 vss.t1446 vss.t1445 sg13_lv_nmos ad=0.1428p pd=1.52u as=0 ps=0 w=0.42u l=1u
X1992 vss.t1913 vdd.t1726 vss.t1914 vss.t1910 sg13_lv_nmos ad=79.8f pd=0.8u as=0 ps=0 w=0.42u l=1u
X1993 vdd.t283 vss.t2349 vdd.t282 vdd.t53 sg13_lv_pmos ad=0.19p pd=1.38u as=0 ps=0 w=1u l=1u
X1994 vdd.t740 a_2038_15217# quantizer2_lfsr_0.sg13cmos5l_dfrbpq_1_0.D.t1 vdd.t507 sg13_lv_pmos ad=0.3808p pd=2.92u as=0.2408p ps=1.55u w=1.12u l=0.13u
X1995 sg13cmos5l_inv_1_18.Y.t0 d_ena.t6 vss.t1437 vss.t92 sg13_lv_nmos ad=0.2516p pd=2.16u as=0.2516p ps=2.16u w=0.74u l=0.13u
X1996 a_1443_2265# a_1322_1586# a_1284_2799# vdd.t504 sg13_lv_pmos ad=93.45f pd=0.865u as=0.2048p ps=1.63u w=0.42u l=0.13u
X1997 sg13cmos5l_inv_1_7.Y d_qi.t4 vdd.t1033 vdd.t502 sg13_lv_pmos ad=0.3808p pd=2.92u as=0.3808p ps=2.92u w=1.12u l=0.13u
X1998 a_558_8294# quantizer2_lfsr_0.sg13cmos5l_dfrbpq_1_8.D vdd.t738 vdd.t504 sg13_lv_pmos ad=79.8f pd=0.8u as=0.1428p ps=1.52u w=0.42u l=0.13u
X1999 vdd.t542 clk_noverlap_0.sg13cmos5l_inv_1_1.A clk_noverlap_0.sg13cmos5l_inv_1_1.Y vdd.t308 sg13_lv_pmos ad=0.3808p pd=2.92u as=0.3808p ps=2.92u w=1.12u l=0.13u
X2000 vdd.t511 a_522_12722# a_873_12633# vdd.t504 sg13_lv_pmos ad=1.21587p pd=7.58u as=93.45f ps=0.865u w=0.42u l=0.13u
X2001 vdd.t1563 vdd.t1561 vdd.t1151 vdd.t1287 sg13_lv_pmos ad=0.17p pd=1.68u as=0 ps=0 w=0.5u l=5u
X2002 a_9357_11104.t15 sg13cmos5l_and2_2_1.X.t2 vss.t968 vss.t401 sg13_lv_nmos ad=0.76p pd=4.38u as=0.76p ps=4.38u w=4u l=0.5u
X2003 vdd.t101 vss.t2243 vdd.t100 vdd.t85 sg13_lv_pmos ad=0.34p pd=2.68u as=0 ps=0 w=1u l=1u
X2004 vdd.t59 vss.t2352 vdd.t54 vdd.t53 sg13_lv_pmos ad=0.34p pd=2.68u as=0 ps=0 w=1u l=1u
X2005 vdd.t155 vss.t2280 vdd.t154 vdd.t153 sg13_lv_pmos ad=0.19p pd=1.38u as=0 ps=0 w=1u l=1u
X2006 a_1288_13738# a_1286_14615# a_1367_14121# vdd.t504 sg13_lv_pmos ad=79.8f pd=0.8u as=63f ps=0.72u w=0.42u l=0.13u
X2007 a_571_6276# a_533_7328# a_567_5970# vss.t613 sg13_lv_nmos ad=0.2373p pd=1.97u as=79.8f ps=0.8u w=0.42u l=0.13u
X2008 vdd.t954 bias_gm_0.bias_trim_0.vz.t46 a_24404_8546# vdd.t573 sg13_lv_pmos ad=95f pd=0.88u as=95f ps=0.88u w=0.5u l=5u
X2009 a_19984_17824# bias_gm_0.bias_trim_0.vz.t51 vdd.t726 vdd.t566 sg13_lv_pmos ad=95f pd=0.88u as=95f ps=0.88u w=0.5u l=5u
X2010 vdd.t64 vss.t2300 vdd.t63 vdd.t62 sg13_lv_pmos ad=0.19p pd=1.38u as=0 ps=0 w=1u l=1u
X2011 vdd.t850 a_5176_31117# vdd.t848 vdd.t764 sg13_lv_pmos ad=0.19p pd=1.38u as=0 ps=0 w=1u l=2u
X2012 vss.t490 dsm2_osc_0.ibias_pad.t2 dantenna l=3.1u w=0.64u
X2013 xsc_vvg_p.t4 sw_tgate_9.gb.t5 xsc_vvg_p.t2 vss.t2076 sg13_lv_nmos ad=0.34p pd=2.68u as=0 ps=0 w=1u l=1u
X2014 quantizer2_lfsr_0.sg13cmos5l_dfrbpq_1_9.D a_522_5493# vss.t14 vss.t630 sg13_lv_nmos ad=0.2516p pd=2.16u as=0.1406p ps=1.12u w=0.74u l=0.13u
X2015 vo_p.t16 sg13cmos5l_inv_1_3.A.t3 xq_dith_v_bq.t12 vss.t1237 sg13_lv_nmos ad=0.665p pd=3.88u as=0.665p ps=3.88u w=3.5u l=0.13u
X2016 vss.t1406 a_1286_9431# a_1322_9362# vss.t1405 sg13_lv_nmos ad=2.71757p pd=16.785u as=0.2516p ps=2.16u w=0.74u l=0.13u
X2017 vdd.t1685 vss.t2413 vdd.t1690 vdd.t0 sg13_lv_pmos ad=0.34p pd=2.68u as=0 ps=0 w=1u l=1u
X2018 quantizer2_lfsr_0.sg13cmos5l_dfrbpq_1_12.Q a_1284_5493# vdd.t650 vdd.t504 sg13_lv_pmos ad=0.3808p pd=2.92u as=0.2128p ps=1.5u w=1.12u l=0.13u
X2019 vdd.t1527 vdd.t1515 vdd.t1529 vdd.t570 sg13_lv_pmos ad=95f pd=0.88u as=0 ps=0 w=0.5u l=5u
X2020 a_24540_20040# a_28126_20180# vss.t34 rhigh l=17.5u w=0.5u
X2021 a_526_16657# quantizer2_lfsr_0.sg13cmos5l_dfrbpq_1_1.Q a_604_16187# vss.t1277 sg13_lv_nmos ad=0.2176p pd=1.96u as=78.39999f ps=0.885u w=0.64u l=0.13u
X2022 vdd.t1086 d_dith_en.t22 a_2079_9714# vdd.t507 sg13_lv_pmos ad=0.1563p pd=1.22u as=0.147p ps=1.54u w=0.42u l=0.13u
X2023 a_1324_804# a_1288_778# vdd.t655 vdd.t504 sg13_lv_pmos ad=0.34p pd=2.68u as=0.36237p ps=2.605u w=1u l=0.13u
X2024 a_1367_11529# a_1324_11172# vdd.t715 vdd.t504 sg13_lv_pmos ad=63f pd=0.72u as=0.1563p ps=1.22u w=0.42u l=0.13u
X2025 vss.t1682 vdd.t1782 vss.t1680 vss.t1669 sg13_lv_nmos ad=79.8f pd=0.8u as=0 ps=0 w=0.42u l=1u
X2026 vss.t258 dsm2_io_0.do_btest_en.t2 a_22836_1332# vss.t2098 sg13_lv_nmos ad=0.1469p pd=1.155u as=0.1045p ps=0.93u w=0.55u l=0.13u
X2027 vdd.t406 vss.t2205 vdd.t405 vdd.t187 sg13_lv_pmos ad=0.34p pd=2.68u as=0 ps=0 w=1u l=1u
X2028 a_4362_8188.t6 a_6453_8400.t1 vss.t608 rhigh l=4.08u w=0.5u
X2029 xsc_vc1r_n.t2 sw_tgate_9.gb.t5 xsc_vvg_p.t5 vdd.t556 sg13_lv_pmos ad=0.38p pd=2.38u as=0.68p ps=4.68u w=2u l=1u
X2030 xsc_vc1l_p.t10 sw_tgate_11.gb.t4 vi_esd.t5 vdd.t561 sg13_lv_pmos ad=0.38p pd=2.38u as=0.68p ps=4.68u w=2u l=1u
X2031 a_6249_9100.t8 sg13cmos5l_inv_1_16.A.t2 xq_vg_p_2_.t1 vdd.t763 sg13_lv_pmos ad=0.17p pd=1.68u as=95f ps=0.88u w=0.5u l=0.13u
X2032 quantizer2_lfsr_0.sg13cmos5l_dfrbpq_1_14.D a_1284_10677# vdd.t739 vdd.t504 sg13_lv_pmos ad=0.3808p pd=2.92u as=0.2128p ps=1.5u w=1.12u l=0.13u
X2033 a_1407_2354# a_1284_2799# a_1758_2482# vss.t17 sg13_lv_nmos ad=0.1428p pd=1.52u as=37.8f ps=0.6u w=0.42u l=0.13u
X2034 a_22252_8546# dsm2_io_0.do_trim_b[2].t4 ibias_200n.t4 vdd.t287 sg13_lv_pmos ad=95f pd=0.88u as=95f ps=0.88u w=0.5u l=5u
X2035 vss.t143 a_537_14181# a_533_15104# vss.t1176 sg13_lv_nmos ad=4.19617p pd=26.765u as=0.2516p ps=2.16u w=0.74u l=0.13u
X2036 vdd.t854 a_5176_31117# vdd.t852 vdd.t764 sg13_lv_pmos ad=0.465p pd=1.93u as=0 ps=0 w=1u l=2u
X2037 vdd.t731 bias_gm_0.bias_trim_0.vz.t51 a_19984_17824# vdd.t570 sg13_lv_pmos ad=95f pd=0.88u as=95f ps=0.88u w=0.5u l=5u
X2038 vdd.t1364 vdd.t1360 vdd.t1366 vdd.t572 sg13_lv_pmos ad=95f pd=0.88u as=0 ps=0 w=0.5u l=5u
X2039 a_5892_8400.t11 sg13cmos5l_inv_1_6.Y.t3 xq_vg_q_1_.t2 vss.t957 sg13_lv_nmos ad=0.17p pd=1.68u as=95f ps=0.88u w=0.5u l=0.13u
X2040 a_2034_11446# a_2049_10149# a_2034_11112# vdd.t507 sg13_lv_pmos ad=0.2048p pd=1.63u as=0.34p ps=2.68u w=1u l=0.13u
X2041 vdd.t522 sg13cmos5l_and2_1_5.X.t2 a_15584_15091# vdd.t502 sg13_lv_pmos ad=0.2856p pd=2.36u as=0.1596p ps=1.22u w=0.84u l=0.13u
X2042 a_12075_9488.t3 d_amp_s_b[0].t2 a_6249_9100.t14 vdd.t659 sg13_lv_pmos ad=0.17p pd=1.68u as=95f ps=0.88u w=0.5u l=0.13u
X2043 a_9357_11104.t6 vss.t427 a_9357_11104.t8 vss.t394 sg13_lv_nmos ad=0.285p pd=1.88u as=0 ps=0 w=1.5u l=0.5u
X2044 vdd.t137 vss.t2330 vdd.t136 vdd.t135 sg13_lv_pmos ad=0.34p pd=2.68u as=0 ps=0 w=1u l=1u
X2045 d_dith[1].t1 a_2034_1082# vdd.t640 vdd.t507 sg13_lv_pmos ad=0.42p pd=2.99u as=0.2114p ps=1.54u w=1.12u l=0.13u
X2046 vdd.t811 a_5176_31117# a_7224_31505# vdd.t764 sg13_lv_pmos ad=0.34p pd=2.68u as=0.19p ps=1.38u w=1u l=2u
X2047 vss.t1788 vdd.t1756 vss.t1787 vss.t1777 sg13_lv_nmos ad=0.1428p pd=1.52u as=0 ps=0 w=0.42u l=1u
X2048 vss.t2062 vdd.t1694 vss.t2061 vss.t2060 sg13_hv_nmos ad=1.36p pd=8.68u as=0 ps=0 w=4u l=10u
X2049 a_22252_4374# bias_gm_0.bias_trim_0.vz.t24 vdd.t943 vdd.t566 sg13_lv_pmos ad=95f pd=0.88u as=95f ps=0.88u w=0.5u l=5u
X2050 vss.t682 a_2034_6098# a_2070_6030# vss.t681 sg13_lv_nmos ad=79.8f pd=0.8u as=0.1428p ps=1.52u w=0.42u l=0.13u
X2051 vdd.t292 vss.t2187 vdd.t291 vdd.t290 sg13_lv_pmos ad=0.34p pd=2.68u as=0 ps=0 w=1u l=1u
X2052 xsc_vc1r_p.t3 d_phi2.t11 xsc_vvg_n.t2 vss.t190 sg13_lv_nmos ad=0.19p pd=1.38u as=0.34p ps=2.68u w=1u l=1u
X2053 sw_tgate_6.p.t0 d_phi1.t4 sw_tgate_6.p.t5 vdd.t562 sg13_lv_pmos ad=0.68p pd=4.68u as=0 ps=0 w=2u l=1u
X2054 vss.t2086 sg13cmos5l_nand2_1_2.Y.t4 sg13cmos5l_inv_1_20.Y.t0 vss.t2085 sg13_lv_nmos ad=0.2516p pd=2.16u as=0.2516p ps=2.16u w=0.74u l=0.13u
X2055 vdd.t1604 vdd.t1590 vdd.t1606 vdd.t1173 sg13_lv_pmos ad=95f pd=0.88u as=0 ps=0 w=0.5u l=5u
X2056 vss.t1767 vdd.t1761 vss.t1766 vss.t1765 sg13_lv_nmos ad=0.1428p pd=1.52u as=0 ps=0 w=0.42u l=1u
X2057 a_2368_16778# quantizer2_lfsr_0.sg13cmos5l_nor2_1_0.A vdd.t1205 vdd.t507 sg13_lv_pmos ad=0.1176p pd=1.33u as=0.4032p ps=2.96u w=1.12u l=0.13u
X2058 sw_tgate_8.m.t6 d_qi.t6 vss.t1008 vdd.t562 sg13_lv_pmos ad=0.38p pd=2.38u as=0.38p ps=2.38u w=2u l=1u
X2059 vss.t452 a_13101_7164# a_12820_7466# vss.t451 sg13_lv_nmos ad=79.8f pd=0.8u as=0.1428p ps=1.52u w=0.42u l=0.5u
X2060 a_15721_15998# d_rst_b.t2 vss.t727 vss.t726 sg13_lv_nmos ad=0.1216p pd=1.02u as=0.1331p ps=1.12u w=0.64u l=0.13u
X2061 vss.t2019 vdd.t1703 vss.t2021 vss.t2020 sg13_lv_nmos ad=79.8f pd=0.8u as=0 ps=0 w=0.42u l=1u
X2062 vss.t694 vss.t695 vss.t693 rhigh l=9.28u w=0.5u
X2063 a_1286_12023# d_qclk.t15 vss.t1403 vss.t1402 sg13_lv_nmos ad=0.2516p pd=2.16u as=2.50852p ps=15.49u w=0.74u l=0.13u
X2064 vdd.t1164 bias_gm_0.bias_trim_0.vz.t26 a_22252_4374# vdd.t573 sg13_lv_pmos ad=95f pd=0.88u as=95f ps=0.88u w=0.5u l=5u
X2065 a_15297_7467# a_15412_7466# vss.t894 vss.t2112 sg13_lv_nmos ad=0.1428p pd=1.52u as=0.1426p ps=1.16u w=0.42u l=0.5u
X2066 vo_n.t21 a_5176_31469# a_9348_31505# vdd.t764 sg13_lv_pmos ad=1.19p pd=7.68u as=0.665p ps=3.88u w=3.5u l=2u
X2067 a_1324_5988# a_1288_5962# vdd.t669 vdd.t504 sg13_lv_pmos ad=0.34p pd=2.68u as=0.36237p ps=2.605u w=1u l=0.13u
X2068 vdd.t1673 vss.t2361 vdd.t1671 vdd.t764 sg13_hv_pmos ad=0.2375p pd=1.63u as=0 ps=0 w=1.25u l=4u
X2069 vdd.t346 vss.t2254 vdd.t99 vdd.t95 sg13_lv_pmos ad=0.19p pd=1.38u as=0 ps=0 w=1u l=1u
X2070 a_1745_6214# d_dith_en.t14 vss.t1112 vss.t1111 sg13_lv_nmos ad=37.8f pd=0.6u as=0.1701p ps=1.65u w=0.42u l=0.13u
X2071 xsc_vvg_n.t1 d_phi2.t11 xsc_vvg_n.t0 vdd.t556 sg13_lv_pmos ad=0.68p pd=4.68u as=0 ps=0 w=2u l=1u
X2072 clk_noverlap_0.sg13cmos5l_inv_1_8.A clk_noverlap_0.sg13cmos5l_inv_1_9.A vss.t1386 vss.t1385 sg13_lv_nmos ad=0.2516p pd=2.16u as=0.2516p ps=2.16u w=0.74u l=0.13u
X2073 a_522_12886# a_537_11589# a_522_12552# vdd.t504 sg13_lv_pmos ad=0.2048p pd=1.63u as=0.34p ps=2.68u w=1u l=0.13u
X2074 sg13cmos5l_inv_1_7.Y d_qi.t4 vss.t1020 vss.t1019 sg13_lv_nmos ad=0.2516p pd=2.16u as=0.2516p ps=2.16u w=0.74u l=0.13u
X2075 vss.t1359 a_20328_23820# vss.t1360 vss.t265 sg13_hv_nmos ad=1.9p pd=10.38u as=0 ps=0 w=10u l=10u
X2076 vdd.t381 vss.t2195 vdd.t380 vdd.t379 sg13_lv_pmos ad=0.34p pd=2.68u as=0 ps=0 w=1u l=1u
X2077 a_6265_7200# a_5995_7241# vss.t464 vss.t85 sg13_lv_nmos ad=0.1428p pd=1.52u as=79.8f ps=0.8u w=0.42u l=0.5u
X2078 vdd.t1003 quantizer2_lfsr_0.sg13cmos5l_dfrbpq_1_1.Q a_526_16657# vdd.t504 sg13_lv_pmos ad=0.2891p pd=1.695u as=0.1596p ps=1.22u w=0.84u l=0.13u
X2079 a_22252_4374# bias_gm_0.bias_trim_0.vz.t35 vdd.t1240 vdd.t572 sg13_lv_pmos ad=95f pd=0.88u as=95f ps=0.88u w=0.5u l=5u
X2080 a_17025_7467# a_17140_7466# vdd.t697 vdd.t308 sg13_lv_pmos ad=0.34p pd=2.68u as=0.2254p ps=1.53u w=1u l=0.5u
X2081 a_2034_13704# a_2079_12306# vdd.t1083 vdd.t507 sg13_lv_pmos ad=0.34p pd=2.68u as=0.36237p ps=2.605u w=1u l=0.13u
X2082 vdd.t130 vss.t2257 vdd.t129 vdd.t95 sg13_lv_pmos ad=0.34p pd=2.68u as=0 ps=0 w=1u l=1u
X2083 a_11083_15998# d_qi.t5 a_10989_15998# vss.t1018 sg13_lv_nmos ad=0.1216p pd=1.02u as=0.2176p ps=1.96u w=0.64u l=0.13u
X2084 vdd.t1009 bias_gm_0.bias_trim_0.vz.t38 a_22252_8546# vdd.t570 sg13_lv_pmos ad=95f pd=0.88u as=95f ps=0.88u w=0.5u l=5u
X2085 vss.t1922 vdd.t1724 vss.t1921 vss.t1920 sg13_lv_nmos ad=0.1428p pd=1.52u as=0 ps=0 w=0.42u l=1u
X2086 sw_tgate_6.p.t9 d_qi_b.t7 sw_tgate_6.p.t8 vss.t1035 sg13_lv_nmos ad=0.19p pd=1.38u as=0 ps=0 w=1u l=1u
X2087 a_6452_29739.t7 xsc_vfb.t11 vss.t71 vss.t72 sg13_lv_nmos ad=95f pd=0.88u as=95f ps=0.88u w=0.5u l=3u
X2088 vo_p.t22 a_5176_31469# a_8762_31505# vdd.t764 sg13_lv_pmos ad=1.19p pd=7.68u as=0.665p ps=3.88u w=3.5u l=2u
X2089 vdd.t511 a_522_4946# a_873_4857# vdd.t504 sg13_lv_pmos ad=1.21587p pd=7.58u as=93.45f ps=0.865u w=0.42u l=0.13u
X2090 vdd.t14 vss.t2372 vdd.t13 vdd.t3 sg13_lv_pmos ad=0.34p pd=2.68u as=0 ps=0 w=1u l=1u
X2091 sw_tgate_8.m.t1 d_phi1.t3 xsc_vc1l_n.t9 vss.t914 sg13_lv_nmos ad=0.19p pd=1.38u as=0.19p ps=1.38u w=1u l=1u
X2092 vdd.t15 vss.t2385 vdd.t32 vdd.t10 sg13_lv_pmos ad=0.34p pd=2.68u as=0 ps=0 w=1u l=1u
X2093 vss.t1361 a_20328_23820# vss.t284 vss.t269 sg13_hv_nmos ad=1.9p pd=10.38u as=0 ps=0 w=10u l=10u
X2094 vss.t1354 a_20328_23820# vss.t1355 vss.t265 sg13_hv_nmos ad=1.9p pd=10.38u as=0 ps=0 w=10u l=10u
X2095 a_567_11154# a_537_11589# a_949_11529# vdd.t504 sg13_lv_pmos ad=79.8f pd=0.8u as=63f ps=0.72u w=0.42u l=0.13u
X2096 xsc_xcmfb1_vsw_cm_n.t3 d_phi2.t12 xsc_xcmfb1_vsw_cm_n.t2 vdd.t560 sg13_lv_pmos ad=0.285p pd=1.88u as=0 ps=0 w=1.5u l=1u
X2097 vss.t40 vss.t41 vss.t39 rhigh l=2.75u w=0.5u
X2098 a_2070_3634# d_dith_en.t7 vss.t1054 vss.t1134 sg13_lv_nmos ad=37.8f pd=0.6u as=79.8f ps=0.8u w=0.42u l=0.13u
X2099 vdd.t596 a_522_2518# a_522_2901# vdd.t504 sg13_lv_pmos ad=0.2128p pd=1.5u as=0.3864p ps=2.93u w=1.12u l=0.13u
X2100 xsc_vvg_p.t3 d_phi2.t9 xsc_vc1r_n.t0 vss.t195 sg13_lv_nmos ad=0.34p pd=2.68u as=0.19p ps=1.38u w=1u l=1u
X2101 vss.t691 vss.t692 vss.t531 rhigh l=2.75u w=0.5u
X2102 vdd.t149 vss.t2232 vdd.t148 vdd.t147 sg13_hv_pmos ad=0.51p pd=3.68u as=0 ps=0 w=1.5u l=0.45u
X2103 vdd.t1529 vdd.t1515 vdd.t1531 vdd.t1173 sg13_lv_pmos ad=95f pd=0.88u as=0 ps=0 w=0.5u l=5u
X2104 a_11115_9168# a_13211_9308.t0 vss.t6 rhigh l=10.05u w=0.5u
X2105 a_9357_11104.t2 vss.t379 vss.t413 vss.t382 sg13_lv_nmos ad=0.76p pd=4.38u as=0.76p ps=4.38u w=4u l=0.5u
X2106 vss.t744 a_5176_30111# vss.t746 vss.t745 sg13_lv_nmos ad=95f pd=0.88u as=0 ps=0 w=0.5u l=3u
X2107 vss.t1834 vdd.t1745 vss.t1835 vss.t1824 sg13_lv_nmos ad=79.8f pd=0.8u as=0 ps=0 w=0.42u l=1u
X2108 vss.t655 vss.t656 vss.t531 rhigh l=2.75u w=0.5u
X2109 a_22738_2088# a_21554_2052.t7 vss.t1217 vss.t1218 sg13_lv_nmos ad=0.17p pd=1.68u as=95f ps=0.88u w=0.5u l=0.5u
X2110 vdd.t1425 vdd.t1423 vdd.t1424 vdd.t1287 sg13_lv_pmos ad=0.17p pd=1.68u as=0 ps=0 w=0.5u l=5u
X2111 vss.t290 vss.t275 vss.t289 vss.t276 sg13_hv_nmos ad=1.9p pd=10.38u as=0 ps=0 w=10u l=1u
X2112 vss.t1356 a_20328_23820# vss.t278 vss.t269 sg13_hv_nmos ad=1.9p pd=10.38u as=0 ps=0 w=10u l=10u
X2113 dsm2_osc_0.di_clk_ext a_19105_884# vss.t2126 vss.t2125 sg13_lv_nmos ad=0.1406p pd=1.12u as=0.2516p ps=2.16u w=0.74u l=0.13u
X2114 dsm2_osc_0.ibias_pad.t0 dsm2_osc_0.sg13cmos5l_dfrbp_1_0.RESET_B.t5 dsm2_osc_0.ibias_in.t1 vdd.t515 sg13_lv_pmos ad=0.19p pd=1.38u as=0.34p ps=2.68u w=1u l=0.5u
X2115 a_1324_3396# a_1288_3370# vss.t1050 vss.t1049 sg13_lv_nmos ad=0.2516p pd=2.16u as=0.1626p ps=1.415u w=0.74u l=0.13u
X2116 vdd.t511 a_1286_4247# a_1322_4178# vdd.t504 sg13_lv_pmos ad=1.21587p pd=7.58u as=0.3864p ps=2.93u w=1.12u l=0.13u
X2117 vss.t1452 vdd.t1833 vss.t1454 vss.t1453 sg13_lv_nmos ad=79.8f pd=0.8u as=0 ps=0 w=0.42u l=1u
X2118 vdd.t179 vss.t2279 vdd.t274 vdd.t153 sg13_lv_pmos ad=0.34p pd=2.68u as=0 ps=0 w=1u l=1u
X2119 vdd.t947 vss.t2395 vdd.t958 vdd.t0 sg13_lv_pmos ad=0.34p pd=2.68u as=0 ps=0 w=1u l=1u
X2120 xsc_vvg_p.t1 d_phi2.t9 xsc_vvg_p.t0 vdd.t556 sg13_lv_pmos ad=0.38p pd=2.38u as=0 ps=0 w=2u l=1u
X2121 a_1690_16373# quantizer2_lfsr_0.sg13cmos5l_dfrbpq_1_13.Q vss.t954 vss.t457 sg13_lv_nmos ad=0.1406p pd=1.12u as=0.1898p ps=1.36u w=0.74u l=0.13u
X2122 vss.t942 clk_noverlap_0.sg13cmos5l_nor3_1_0.C clk_noverlap_0.sg13cmos5l_inv_1_1.A vss.t941 sg13_lv_nmos ad=0.1463p pd=1.15u as=0.2618p ps=2.22u w=0.77u l=0.13u
X2123 vdd.t840 a_5176_31117# vdd.t838 vdd.t764 sg13_lv_pmos ad=0.19p pd=1.38u as=0 ps=0 w=1u l=2u
X2124 vss.t725 di_trim[2] dsm2_io_0.do_trim_b[2].t0 vss.t724 sg13_hv_nmos ad=0.34p pd=2.68u as=0.34p ps=2.68u w=1u l=0.45u
X2125 vss.t97 sg13cmos5l_inv_1_2.A.t11 sg13cmos5l_inv_1_2.Y vss.t96 sg13_lv_nmos ad=0.2516p pd=2.16u as=0.2516p ps=2.16u w=0.74u l=0.13u
X2126 vss.t1044 d_qi_b.t3 d_qi.t0 vss.t1043 sg13_lv_nmos ad=0.2516p pd=2.16u as=0.1406p ps=1.12u w=0.74u l=0.13u
X2127 xq_dith_v_bp.t10 sg13cmos5l_or2_1_0.X.t2 a_4362_8188.t13 vss.t717 sg13_lv_nmos ad=1.19p pd=7.68u as=0.665p ps=3.88u w=3.5u l=0.13u
X2128 xq_vg_q_2_.t1 sg13cmos5l_inv_1_16.A.t3 a_5892_8400.t3 vdd.t580 sg13_lv_pmos ad=95f pd=0.88u as=0.17p ps=1.68u w=0.5u l=0.13u
X2129 vss.t18 a_1407_2354# a_1681_1969# vss.t17 sg13_lv_nmos ad=79.8f pd=0.8u as=0.1428p ps=1.52u w=0.42u l=0.13u
X2130 vdd.t944 bias_gm_0.bias_trim_0.vz.t24 a_22252_4374# vdd.t384 sg13_lv_pmos ad=95f pd=0.88u as=95f ps=0.88u w=0.5u l=5u
X2131 a_23195_985# dsm2_osc_0.sg13cmos5l_dfrbp_1_0.Q_N a_23942_594# vss.t2128 sg13_lv_nmos ad=0.1428p pd=1.52u as=60.89999f ps=0.71u w=0.42u l=0.13u
X2132 sg13cmos5l_or2_1_0.X.t0 a_8208_15626# vss.t43 vss.t530 sg13_lv_nmos ad=0.2516p pd=2.16u as=0.1469p ps=1.155u w=0.74u l=0.13u
X2133 vi_esd.t11 d_phi1.t5 xsc_vc1l_p.t8 vss.t910 sg13_lv_nmos ad=0.34p pd=2.68u as=0.19p ps=1.38u w=1u l=1u
X2134 vdd.t934 bias_gm_0.bias_trim_0.vz.t53 a_19984_17824# vdd.t573 sg13_lv_pmos ad=95f pd=0.88u as=95f ps=0.88u w=0.5u l=5u
X2135 a_537_1221# d_qclk.t4 vss.t143 vss.t1410 sg13_lv_nmos ad=0.2516p pd=2.16u as=3.67165p ps=23.42u w=0.74u l=0.13u
X2136 vdd.t391 vss.t2239 vdd.t245 vdd.t138 sg13_lv_pmos ad=0.34p pd=2.68u as=0 ps=0 w=1u l=1u
X2137 vdd.t1433 vdd.t1423 vdd.t1435 vdd.t287 sg13_lv_pmos ad=95f pd=0.88u as=0 ps=0 w=0.5u l=5u
X2138 vdd.t259 vss.t2410 vdd.t258 vdd.t0 sg13_lv_pmos ad=0.19p pd=1.38u as=0 ps=0 w=1u l=1u
X2139 vo_p.t14 sw_tgate_cmfb2_3.gb.t4 vo_p.t2 vss.t1221 sg13_lv_nmos ad=95f pd=0.88u as=0 ps=0 w=0.5u l=1u
X2140 a_22252_4074# bias_gm_0.bias_trim_0.vz.t26 vdd.t1164 vdd.t287 sg13_lv_pmos ad=95f pd=0.88u as=95f ps=0.88u w=0.5u l=5u
X2141 a_22138_16346# a_20138_14766# a_20070_16046# vdd.t897 sg13_lv_pmos ad=95f pd=0.88u as=0.17p ps=1.68u w=0.5u l=10u
X2142 a_1502_26288# vdd.t1786 d_ena.t1 vss.t1665 sg13_hv_nmos ad=0.19p pd=1.38u as=0.34p ps=2.68u w=1u l=10u
X2143 vss.t1818 vdd.t1749 vss.t1817 vss.t1816 sg13_lv_nmos ad=0.1428p pd=1.52u as=0 ps=0 w=0.42u l=1u
X2144 sg13cmos5l_inv_1_16.Y.t0 sg13cmos5l_inv_1_16.A.t4 vss.t865 vss.t0 sg13_lv_nmos ad=0.2516p pd=2.16u as=0.2516p ps=2.16u w=0.74u l=0.13u
X2145 a_24214_14546# a_20138_14766# vdd.t899 vdd.t898 sg13_lv_pmos ad=0.17p pd=1.68u as=95f ps=0.88u w=0.5u l=10u
X2146 vss.t1905 vdd.t1728 vss.t1906 vss.t1895 sg13_lv_nmos ad=79.8f pd=0.8u as=0 ps=0 w=0.42u l=1u
X2147 vdd.t364 vss.t2212 vdd.t478 vdd.t123 sg13_lv_pmos ad=0.19p pd=1.38u as=0 ps=0 w=1u l=1u
X2148 a_7804_29739.t7 xsc_vfb.t11 vss.t69 vss.t68 sg13_lv_nmos ad=95f pd=0.88u as=95f ps=0.88u w=0.5u l=3u
X2149 vss.t632 a_522_4946# a_558_4878# vss.t631 sg13_lv_nmos ad=79.8f pd=0.8u as=0.1428p ps=1.52u w=0.42u l=0.13u
X2150 vss.t586 clk_noverlap_0.sg13cmos5l_inv_1_3.Y dsm2_io_vcmg_0.di_phi1_b vss.t585 sg13_lv_nmos ad=0.2516p pd=2.16u as=0.2516p ps=2.16u w=0.74u l=0.13u
X2151 vdd.t844 a_5176_31117# vdd.t842 vdd.t764 sg13_lv_pmos ad=0.19p pd=1.38u as=0 ps=0 w=1u l=2u
X2152 a_571_8868# a_522_9960# a_571_8806# vss.t709 sg13_lv_nmos ad=0.1428p pd=1.52u as=37.8f ps=0.6u w=0.42u l=0.13u
X2153 dsm2_osc_0.sg13cmos5l_inv_1_2.A a_21681_1704# vss.t152 vss.t151 sg13_lv_nmos ad=0.2516p pd=2.16u as=0.1331p ps=1.12u w=0.74u l=0.13u
X2154 vss.t1775 vdd.t1759 vss.t1776 vss.t1768 sg13_lv_nmos ad=79.8f pd=0.8u as=0 ps=0 w=0.42u l=1u
X2155 a_5176_31469# a_6817_30111# a_5176_31117# vdd.t764 sg13_lv_pmos ad=0.17p pd=1.68u as=0.17p ps=1.68u w=0.5u l=10u
X2156 a_20672_20740# a_24258_20600# vss.t207 rhigh l=17.5u w=0.5u
X2157 a_522_5110# a_537_3813# a_522_4776# vdd.t504 sg13_lv_pmos ad=0.2048p pd=1.63u as=0.34p ps=2.68u w=1u l=0.13u
X2158 vss.t2039 vdd.t1699 vss.t2038 vss.t2037 sg13_lv_nmos ad=0.1428p pd=1.52u as=0 ps=0 w=0.42u l=1u
X2159 sw_tgate_12.m.t9 sw_tgate_9.gb.t3 sw_tgate_12.m.t3 vss.t1231 sg13_lv_nmos ad=0.34p pd=2.68u as=0 ps=0 w=1u l=1u
X2160 vdd.t1470 vdd.t1469 vdd.t982 vdd.t566 sg13_lv_pmos ad=95f pd=0.88u as=0 ps=0 w=0.5u l=5u
X2161 vdd.t1288 d_ena.t4 bias_gm_0.bias_trim_0.vz.t21 vdd.t1287 sg13_lv_pmos ad=95f pd=0.88u as=0.17p ps=1.68u w=0.5u l=5u
X2162 vdd.t1078 d_dith_en.t37 a_7437_15998# vdd.t502 sg13_lv_pmos ad=0.1918p pd=1.5u as=0.1596p ps=1.22u w=0.84u l=0.13u
X2163 vdd.t515 dsm2_osc_0.sg13cmos5l_dfrbp_1_0.CLK a_22499_864# vdd.t515 sg13_lv_pmos ad=1.93285p pd=12.62u as=0.4088p ps=2.97u w=1.12u l=0.13u
X2164 vdd.t1009 vdd.t1486 vdd.t1487 vdd.t1173 sg13_lv_pmos ad=95f pd=0.88u as=0 ps=0 w=0.5u l=5u
X2165 a_14829_7164# clk_noverlap_0.sg13cmos5l_dlygate4sd3_1_9.A vss.t582 vss.t137 sg13_lv_nmos ad=0.1428p pd=1.52u as=79.8f ps=0.8u w=0.42u l=0.13u
X2166 a_2034_8520# a_2079_7122# vss.t80 vss.t79 sg13_lv_nmos ad=0.2516p pd=2.16u as=0.1626p ps=1.415u w=0.74u l=0.13u
X2167 a_6249_9100.t3 sg13cmos5l_inv_1_16.Y.t2 xq_vg_p_2_.t0 vss.t478 sg13_lv_nmos ad=0.17p pd=1.68u as=95f ps=0.88u w=0.5u l=0.13u
X2168 vss.t1641 vdd.t1792 vss.t1640 vss.t1634 sg13_lv_nmos ad=0.1428p pd=1.52u as=0 ps=0 w=0.42u l=1u
X2169 vdd.t372 vss.t2169 vdd.t371 vdd.t308 sg13_lv_pmos ad=0.34p pd=2.68u as=0 ps=0 w=1u l=1u
X2170 vss.t1706 vdd.t1776 vss.t1704 vss.t1705 sg13_lv_nmos ad=79.8f pd=0.8u as=0 ps=0 w=0.42u l=1u
X2171 a_1286_6839# d_qclk.t9 vss.t83 vss.t82 sg13_lv_nmos ad=0.2516p pd=2.16u as=2.50852p ps=15.49u w=0.74u l=0.13u
X2172 a_12075_9488.t2 d_amp_s[0].t2 a_6249_9100.t7 vss.t667 sg13_lv_nmos ad=0.17p pd=1.68u as=95f ps=0.88u w=0.5u l=0.13u
X2173 vdd.t1014 bias_gm_0.bias_trim_0.vz.t45 a_22252_7946# vdd.t573 sg13_lv_pmos ad=95f pd=0.88u as=95f ps=0.88u w=0.5u l=5u
X2174 dsm2_osc_0.ibias_in.t4 a_21252_3394# bias_gm_0.bias_trim_0.iout vdd.t572 sg13_lv_pmos ad=95f pd=0.88u as=95f ps=0.88u w=0.5u l=5u
X2175 a_2034_13704# a_2045_13664# a_2034_14038# vss.t699 sg13_lv_nmos ad=0.3473p pd=2.71u as=0.12665p ps=1.145u w=0.74u l=0.13u
X2176 a_873_7449# a_533_7328# a_522_7702# vdd.t504 sg13_lv_pmos ad=93.45f pd=0.865u as=0.2048p ps=1.63u w=0.42u l=0.13u
X2177 a_19949_784# dsm2_osc_0.sg13cmos5l_buf_2_0.A vdd.t517 vdd.t515 sg13_lv_pmos ad=0.34p pd=2.68u as=0.2086p ps=1.5u w=1u l=0.13u
X2178 vss.t1931 vdd.t1722 vss.t1930 vss.t1920 sg13_lv_nmos ad=0.1428p pd=1.52u as=0 ps=0 w=0.42u l=1u
X2179 vss.t80 d_dith_en.t16 a_2070_6948# vss.t1109 sg13_lv_nmos ad=0.1626p pd=1.415u as=60.89999f ps=0.71u w=0.42u l=0.13u
X2180 vdd.t408 vss.t2185 vdd.t432 vdd.t82 sg13_lv_pmos ad=0.34p pd=2.68u as=0 ps=0 w=1u l=1u
X2181 vdd.t368 vss.t2202 vdd.t188 vdd.t187 sg13_lv_pmos ad=0.19p pd=1.38u as=0 ps=0 w=1u l=1u
X2182 vss.t1894 vdd.t1731 vss.t1896 vss.t1895 sg13_lv_nmos ad=79.8f pd=0.8u as=0 ps=0 w=0.42u l=1u
X2183 vss.t348 vss.t346 vss.t347 vss.t262 sg13_hv_nmos ad=0.17p pd=1.68u as=0 ps=0 w=0.5u l=10u
X2184 vdd.t1368 vdd.t1360 vdd.t1370 vdd.t287 sg13_lv_pmos ad=95f pd=0.88u as=0 ps=0 w=0.5u l=5u
X2185 vdd.t487 vss.t2264 vdd.t343 vdd.t68 sg13_lv_pmos ad=0.19p pd=1.38u as=0 ps=0 w=1u l=1u
X2186 vdd.t882 sg13cmos5l_inv_1_11.Y sg13cmos5l_inv_2_4.Y vdd.t502 sg13_lv_pmos ad=0.3808p pd=2.92u as=0.2128p ps=1.5u w=1.12u l=0.13u
X2187 vss.t1082 a_1407_15314# a_1681_14929# vss.t792 sg13_lv_nmos ad=79.8f pd=0.8u as=0.1428p ps=1.52u w=0.42u l=0.13u
X2188 a_7804_29739.t5 xsc_vfb.t12 vss.t1313 vss.t104 sg13_lv_nmos ad=95f pd=0.88u as=95f ps=0.88u w=0.5u l=3u
X2189 vdd.t512 d_dith_en.t8 a_1288_3370# vdd.t504 sg13_lv_pmos ad=0.1563p pd=1.22u as=0.147p ps=1.54u w=0.42u l=0.13u
X2190 vss.t2024 vdd.t1702 vss.t2023 vss.t2022 sg13_lv_nmos ad=0.1428p pd=1.52u as=0 ps=0 w=0.42u l=1u
X2191 vdd.t971 sg13cmos5l_and2_2_1.X.t4 sg13cmos5l_inv_1_2.A.t4 vdd.t863 sg13_lv_pmos ad=0.285p pd=1.88u as=0.285p ps=1.88u w=1.5u l=0.5u
X2192 a_10784_6484# clk_noverlap_0.di_clk.t2 vdd.t906 vdd.t308 sg13_lv_pmos ad=0.1596p pd=1.22u as=0.2856p ps=2.36u w=0.84u l=0.13u
X2193 a_11115_8888# a_13211_8748# vss.t6 rhigh l=10.05u w=0.5u
X2194 vdd.t923 quantizer2_lfsr_0.sg13cmos5l_dfrbpq_1_13.Q a_1284_16630# vdd.t504 sg13_lv_pmos ad=0.2891p pd=1.695u as=0.1596p ps=1.22u w=0.84u l=0.13u
X2195 vdd.t1126 di_osc_en.t1 dsm2_osc_0.dsm2_io_rx_0.di_b.t1 vdd.t1125 sg13_hv_pmos ad=0.17p pd=1.68u as=0.17p ps=1.68u w=0.5u l=1u
X2196 vss.t466 a_12705_7467# clk_noverlap_0.sg13cmos5l_dlygate4sd3_1_8.X vss.t465 sg13_lv_nmos ad=0.1426p pd=1.16u as=0.2516p ps=2.16u w=0.74u l=0.13u
X2197 vdd.t1554 vdd.t1552 vdd.t1553 vdd.t1287 sg13_lv_pmos ad=0.17p pd=1.68u as=0 ps=0 w=0.5u l=5u
X2198 a_1288_778# a_1286_1655# a_1367_1349# vss.t2120 sg13_lv_nmos ad=79.8f pd=0.8u as=0.1296p ps=1.52u w=0.42u l=0.13u
X2199 vss.t463 sg13cmos5l_inv_1_19.Y.t7 xq_vg_q_0_.t0 vss.t462 sg13_lv_nmos ad=95f pd=0.88u as=0.17p ps=1.68u w=0.5u l=0.13u
X2200 vo_p.t1 d_phi1.t12 xsc_xcmfb1_vsw_cm_p.t9 vss.t187 sg13_lv_nmos ad=95f pd=0.88u as=95f ps=0.88u w=0.5u l=1u
X2201 a_2034_14038# a_2049_12741# a_2034_13704# vdd.t507 sg13_lv_pmos ad=0.2048p pd=1.63u as=0.34p ps=2.68u w=1u l=0.13u
X2202 vdd.t1449 vdd.t1448 vdd.t949 vdd.t573 sg13_lv_pmos ad=95f pd=0.88u as=0 ps=0 w=0.5u l=5u
X2203 a_22252_11246# bias_gm_0.bias_trim_0.vz.t9 vdd.t567 vdd.t566 sg13_lv_pmos ad=95f pd=0.88u as=95f ps=0.88u w=0.5u l=5u
X2204 a_7804_29739.t3 a_5176_30111# vo_n.t12 vss.t759 sg13_lv_nmos ad=95f pd=0.88u as=95f ps=0.88u w=0.5u l=3u
X2205 vss.t1058 di_rst_b dsm2_io_0.sg13cmos5l_inv_1_6.A vss.t1057 sg13_hv_nmos ad=0.34p pd=2.68u as=0.34p ps=2.68u w=1u l=0.45u
X2206 vss.t1512 vdd.t1821 vss.t1511 vss.t1510 sg13_lv_nmos ad=0.1428p pd=1.52u as=0 ps=0 w=0.42u l=1u
X2207 vss.t705 vss.t706 vss.t531 rhigh l=2.75u w=0.5u
X2208 vdd.t473 vss.t2306 vdd.t456 vdd.t386 sg13_lv_pmos ad=0.19p pd=1.38u as=0 ps=0 w=1u l=1u
X2209 vdd.t717 a_13965_7164# a_13684_7466# vdd.t308 sg13_lv_pmos ad=0.1523p pd=1.38u as=0.34p ps=2.68u w=1u l=0.5u
X2210 vdd.t695 a_11841_7467# clk_noverlap_0.sg13cmos5l_dlygate4sd3_1_0.A.t1 vdd.t308 sg13_lv_pmos ad=0.2254p pd=1.53u as=0.4256p ps=3u w=1.12u l=0.13u
X2211 xsc_vc1r_p.t7 d_phi1.t11 xsc_vc1r_p.t6 vdd.t556 sg13_lv_pmos ad=0.38p pd=2.38u as=0 ps=0 w=2u l=1u
X2212 vss.t1157 vss.t1158 vss.t39 rhigh l=2.75u w=0.5u
X2213 vss.t136 clk_noverlap_0.sg13cmos5l_inv_1_0.A clk_noverlap_0.sg13cmos5l_inv_1_0.Y vss.t135 sg13_lv_nmos ad=0.2516p pd=2.16u as=0.2516p ps=2.16u w=0.74u l=0.13u
X2214 sg13cmos5l_nor2_2_0.Y sg13cmos5l_nor2_2_0.B.t4 a_9556_15186# vdd.t502 sg13_lv_pmos ad=0.2128p pd=1.5u as=0.3808p ps=2.92u w=1.12u l=0.13u
X2215 a_6453_8400.t0 d_amp_s_b[3].t3 a_5892_8400.t4 vdd.t658 sg13_lv_pmos ad=0.17p pd=1.68u as=95f ps=0.88u w=0.5u l=0.13u
X2216 vss.t746 a_5176_30111# vss.t748 vss.t747 sg13_lv_nmos ad=95f pd=0.88u as=0 ps=0 w=0.5u l=3u
X2217 sg13cmos5l_nor2_2_0.B.t0 sg13cmos5l_nand2_2_0.B.t3 vss.t829 vss.t828 sg13_lv_nmos ad=0.1406p pd=1.12u as=0.2516p ps=2.16u w=0.74u l=0.13u
X2218 a_13101_7164# clk_noverlap_0.sg13cmos5l_dlygate4sd3_1_7.X vdd.t611 vdd.t308 sg13_lv_pmos ad=0.1428p pd=1.52u as=0.1523p ps=1.38u w=0.42u l=0.13u
X2219 a_20260_17236# vss.t344 a_20260_17236# vss.t262 sg13_lv_nmos ad=0.17p pd=1.68u as=0 ps=0 w=0.5u l=10u
X2220 a_1286_14615# d_qclk.t19 vss.t47 vss.t46 sg13_lv_nmos ad=0.2516p pd=2.16u as=2.50852p ps=15.49u w=0.74u l=0.13u
X2221 a_2461_7497# a_2034_8520# vdd.t686 vdd.t507 sg13_lv_pmos ad=63f pd=0.72u as=0.1563p ps=1.22u w=0.42u l=0.13u
X2222 a_23328_9146# bias_gm_0.bias_trim_0.vz.t42 vdd.t982 vdd.t384 sg13_lv_pmos ad=95f pd=0.88u as=95f ps=0.88u w=0.5u l=5u
X2223 a_21252_3394# dsm2_osc_0.d_btest_or.t3 vss.t361 vss.t265 sg13_lv_nmos ad=95f pd=0.88u as=95f ps=0.88u w=0.5u l=10u
X2224 vdd.t507 a_2034_14038# a_2034_13874# vdd.t507 sg13_lv_pmos ad=1.99007p pd=12.8u as=79.8f ps=0.8u w=0.42u l=0.13u
X2225 xq_vg_q_2_.t0 sg13cmos5l_inv_1_16.Y.t3 a_5892_8400.t2 vss.t477 sg13_lv_nmos ad=95f pd=0.88u as=0.17p ps=1.68u w=0.5u l=0.13u
X2226 a_522_12886# a_537_11589# a_558_12654# vss.t1292 sg13_lv_nmos ad=0.12665p pd=1.145u as=0.1428p ps=1.52u w=0.42u l=0.13u
X2227 vdd.t199 vss.t2231 vdd.t198 vdd.t176 sg13_lv_pmos ad=0.34p pd=2.68u as=0 ps=0 w=1u l=1u
X2228 vss.t1472 vdd.t1829 vss.t1474 vss.t1473 sg13_lv_nmos ad=79.8f pd=0.8u as=0 ps=0 w=0.42u l=1u
X2229 a_8905_15998# vss.t374 vss.t376 vss.t375 sg13_lv_nmos ad=0.1216p pd=1.02u as=0.1331p ps=1.12u w=0.64u l=0.13u
X2230 a_22252_8246# bias_gm_0.bias_trim_0.vz.t45 vdd.t1014 vdd.t287 sg13_lv_pmos ad=95f pd=0.88u as=95f ps=0.88u w=0.5u l=5u
X2231 vdd.t571 bias_gm_0.bias_trim_0.vz.t9 a_22252_11246# vdd.t570 sg13_lv_pmos ad=95f pd=0.88u as=95f ps=0.88u w=0.5u l=5u
X2232 vss.t1658 vdd.t1788 vss.t1657 vss.t1648 sg13_lv_nmos ad=0.1428p pd=1.52u as=0 ps=0 w=0.42u l=1u
X2233 vdd.t81 vss.t2250 vdd.t80 vdd.t79 sg13_lv_pmos ad=0.19p pd=1.38u as=0 ps=0 w=1u l=1u
X2234 vss.t365 vss.t363 vss.t364 vss.t269 sg13_lv_nmos ad=95f pd=0.88u as=0 ps=0 w=0.5u l=10u
X2235 a_22252_4374# bias_gm_0.bias_trim_0.vz.t25 vdd.t937 vdd.t566 sg13_lv_pmos ad=95f pd=0.88u as=95f ps=0.88u w=0.5u l=5u
X2236 a_2049_10149# d_qclk.t14 vdd.t507 vdd.t507 sg13_lv_pmos ad=0.4088p pd=2.97u as=1.87952p ps=12.085u w=1.12u l=0.13u
X2237 a_8618_15186# sg13cmos5l_and2_1_5.A.t3 vdd.t869 vdd.t502 sg13_lv_pmos ad=0.1176p pd=1.33u as=0.4032p ps=2.96u w=1.12u l=0.13u
X2238 a_571_6214# d_dith_en.t15 vss.t1117 vss.t1116 sg13_lv_nmos ad=37.8f pd=0.6u as=0.1701p ps=1.65u w=0.42u l=0.13u
X2239 vdd.t324 vss.t2253 vdd.t385 vdd.t79 sg13_lv_pmos ad=0.34p pd=2.68u as=0 ps=0 w=1u l=1u
X2240 xsc_vfb.t3 vss.t309 xsc_vfb.t2 vss.t310 sg13_lv_nmos ad=95f pd=0.88u as=0 ps=0 w=0.5u l=1u
X2241 d_amp_s[0].t1 quantizer2_lfsr_0.di_dith_amp[1].t4 vss.t460 vss.t459 sg13_lv_nmos ad=0.1406p pd=1.12u as=0.2516p ps=2.16u w=0.74u l=0.13u
X2242 vss.t1442 vdd.t1835 vss.t1441 vss.t1440 sg13_lv_nmos ad=0.1428p pd=1.52u as=0 ps=0 w=0.42u l=1u
X2243 dsm2_osc_0.sg13cmos5l_inv_1_3.A a_21452_2308.t5 a_23674_2344# vss.t2082 sg13_lv_nmos ad=0.17p pd=1.68u as=95f ps=0.88u w=0.5u l=0.5u
X2244 xq_dith_v_bq.t3 sg13cmos5l_inv_1_9.Y.t3 a_4362_8188.t5 vdd.t624 sg13_lv_pmos ad=0.665p pd=3.88u as=0.665p ps=3.88u w=3.5u l=0.13u
X2245 vss.t1349 a_19105_884# dsm2_osc_0.di_clk_ext vss.t2127 sg13_lv_nmos ad=0.1371p pd=1.12u as=0.1406p ps=1.12u w=0.74u l=0.13u
X2246 a_20672_21860# a_24258_21720# vss.t207 rhigh l=17.5u w=0.5u
X2247 vdd.t1019 bias_gm_0.bias_trim_0.vz.t52 a_22252_11246# vdd.t384 sg13_lv_pmos ad=95f pd=0.88u as=95f ps=0.88u w=0.5u l=5u
X2248 a_8880_5832# dsm2_io_vcmg_0.di_vcm_ext.t2 vss.t1240 vss.t1190 sg13_lv_nmos ad=0.1045p pd=0.93u as=0.187p ps=1.78u w=0.55u l=0.13u
X2249 a_22252_8246# bias_gm_0.bias_trim_0.vz.t37 vdd.t1154 vdd.t572 sg13_lv_pmos ad=95f pd=0.88u as=95f ps=0.88u w=0.5u l=5u
X2250 vdd.t507 a_2034_8690# a_2385_8601# vdd.t507 sg13_lv_pmos ad=1.99007p pd=12.8u as=93.45f ps=0.865u w=0.42u l=0.13u
X2251 vss.t1939 vdd.t1720 vss.t1938 vss.t1937 sg13_lv_nmos ad=0.1428p pd=1.52u as=0 ps=0 w=0.42u l=1u
X2252 d_vcm_phi2 a_16941_5500# vdd.t619 vdd.t526 sg13_lv_pmos ad=0.3808p pd=2.92u as=0.1918p ps=1.5u w=1.12u l=0.13u
X2253 a_1407_10130# a_1284_10575# a_1758_10258# vss.t669 sg13_lv_nmos ad=0.1428p pd=1.52u as=37.8f ps=0.6u w=0.42u l=0.13u
X2254 vdd.t977 sg13cmos5l_nand2_1_5.A.t3 sg13cmos5l_inv_1_16.A.t1 vdd.t502 sg13_lv_pmos ad=0.3808p pd=2.92u as=0.2128p ps=1.5u w=1.12u l=0.13u
X2255 vdd.t393 vss.t2201 vdd.t392 vdd.t187 sg13_lv_pmos ad=0.34p pd=2.68u as=0 ps=0 w=1u l=1u
X2256 vdd.t618 dsm2_io_vcmg_0.di_vcm_ext_b.t3 dsm2_io_vcmg_0.di_vcm_ext.t1 vdd.t617 sg13_lv_pmos ad=0.3808p pd=2.92u as=0.3808p ps=2.92u w=1.12u l=0.13u
X2257 clk_noverlap_0.sg13cmos5l_inv_1_0.A a_10784_6484# vdd.t509 vdd.t308 sg13_lv_pmos ad=0.3808p pd=2.92u as=0.1918p ps=1.5u w=1.12u l=0.13u
X2258 vdd.t986 bias_gm_0.bias_trim_0.vz.t39 a_22252_8246# vdd.t570 sg13_lv_pmos ad=95f pd=0.88u as=95f ps=0.88u w=0.5u l=5u
X2259 a_2049_10149# d_qclk.t14 vss.t796 vss.t1397 sg13_lv_nmos ad=0.2516p pd=2.16u as=2.50852p ps=15.49u w=0.74u l=0.13u
X2260 vdd.t94 vss.t2339 vdd.t93 vdd.t65 sg13_lv_pmos ad=0.19p pd=1.38u as=0 ps=0 w=1u l=1u
X2261 vcm_esd.t13 d_phi2.t12 vcm_esd.t12 vdd.t560 sg13_lv_pmos ad=0.285p pd=1.88u as=0 ps=0 w=1.5u l=1u
X2262 dsm2_osc_0.di_clk_ext a_19105_884# vdd.t1641 vdd.t1245 sg13_lv_pmos ad=0.2128p pd=1.5u as=0.7336p ps=3.55u w=1.12u l=0.13u
X2263 vdd.t511 a_1286_6839# a_1322_6770# vdd.t504 sg13_lv_pmos ad=1.21587p pd=7.58u as=0.3864p ps=2.93u w=1.12u l=0.13u
X2264 vss.t2011 vdd.t1705 vss.t2009 vss.t2010 sg13_lv_nmos ad=79.8f pd=0.8u as=0 ps=0 w=0.42u l=1u
X2265 a_522_2184# a_533_2144# a_522_2518# vss.t497 sg13_lv_nmos ad=0.3473p pd=2.71u as=0.12665p ps=1.145u w=0.74u l=0.13u
X2266 a_22184_2052# a_21736_2344# a_22386_2344# vss.t508 sg13_lv_nmos ad=0.17p pd=1.68u as=95f ps=0.88u w=0.5u l=0.13u
X2267 vdd.t69 vss.t2263 vdd.t202 vdd.t68 sg13_lv_pmos ad=0.34p pd=2.68u as=0 ps=0 w=1u l=1u
X2268 a_1324_804# a_1322_1586# a_1284_2799# vss.t147 sg13_lv_nmos ad=0.3473p pd=2.71u as=0.12665p ps=1.145u w=0.74u l=0.13u
X2269 vss.t373 vss.t370 vss.t372 vss.t371 sg13_hv_nmos ad=0.51p pd=3.68u as=0 ps=0 w=1.5u l=0.45u
X2270 a_1367_11717# quantizer2_lfsr_0.sg13cmos5l_dfrbpq_1_14.D vdd.t708 vdd.t504 sg13_lv_pmos ad=79.8f pd=0.8u as=0.1428p ps=1.52u w=0.42u l=0.13u
X2271 vdd.t477 vss.t2274 vdd.t376 vdd.t126 sg13_lv_pmos ad=0.19p pd=1.38u as=0 ps=0 w=1u l=1u
X2272 vss.t887 a_8857_7200# a_8969_7224# vss.t940 sg13_lv_nmos ad=0.1426p pd=1.16u as=0.1428p ps=1.52u w=0.42u l=0.5u
X2273 d_qi_b.t0 sg13cmos5l_nor2_2_0.Y vss.t36 vss.t35 sg13_lv_nmos ad=0.1406p pd=1.12u as=0.1406p ps=1.12u w=0.74u l=0.13u
X2274 xsc_vfb.t1 vss.t307 xsc_vfb.t0 vss.t308 sg13_lv_nmos ad=0.17p pd=1.68u as=0 ps=0 w=0.5u l=1u
X2275 vdd.t1023 vdd.t1391 vdd.t1392 vdd.t1173 sg13_lv_pmos ad=95f pd=0.88u as=0 ps=0 w=0.5u l=5u
X2276 vss.t633 a_1407_4946# a_1681_4561# vss.t549 sg13_lv_nmos ad=79.8f pd=0.8u as=0.1428p ps=1.52u w=0.42u l=0.13u
X2277 vdd.t511 a_1407_15314# a_1443_15225# vdd.t504 sg13_lv_pmos ad=1.21587p pd=7.58u as=93.45f ps=0.865u w=0.42u l=0.13u
X2278 vss.t752 a_5176_30111# vss.t754 vss.t753 sg13_lv_nmos ad=95f pd=0.88u as=0 ps=0 w=0.5u l=3u
X2279 vss.t1750 vdd.t1765 vss.t1752 vss.t1751 sg13_lv_nmos ad=79.8f pd=0.8u as=0 ps=0 w=0.42u l=1u
X2280 vdd.t128 vss.t2277 vdd.t127 vdd.t126 sg13_lv_pmos ad=0.34p pd=2.68u as=0 ps=0 w=1u l=1u
X2281 a_13569_7467# a_13684_7466# vss.t581 vss.t625 sg13_lv_nmos ad=0.1428p pd=1.52u as=0.1426p ps=1.16u w=0.42u l=0.5u
X2282 vdd.t715 d_dith_en.t26 a_1288_11146# vdd.t504 sg13_lv_pmos ad=0.1563p pd=1.22u as=0.147p ps=1.54u w=0.42u l=0.13u
X2283 a_21617_558# a_22347_812# a_22258_909# vdd.t515 sg13_lv_pmos ad=0.2048p pd=1.63u as=93.45f ps=0.865u w=0.42u l=0.13u
X2284 vdd.t1622 sg13cmos5l_inv_1_1.A sg13cmos5l_inv_1_0.A vdd.t502 sg13_lv_pmos ad=0.3808p pd=2.92u as=0.3808p ps=2.92u w=1.12u l=0.13u
X2285 vss.t1981 vdd.t1711 vss.t1980 vss.t1979 sg13_lv_nmos ad=0.1428p pd=1.52u as=0 ps=0 w=0.42u l=1u
X2286 vdd.t1052 di_vcm_ext dsm2_io_vcmg_0.di_vcm_ext_b.t1 vdd.t25 sg13_hv_pmos ad=0.17p pd=1.68u as=0.17p ps=1.68u w=0.5u l=1u
X2287 a_2079_1938# a_2049_2373# a_2070_1670# vss.t522 sg13_lv_nmos ad=79.8f pd=0.8u as=0.1296p ps=1.52u w=0.42u l=0.13u
X2288 vdd.t737 bias_gm_0.bias_trim_0.vz.t22 a_22252_4074# vdd.t570 sg13_lv_pmos ad=95f pd=0.88u as=95f ps=0.88u w=0.5u l=5u
X2289 vdd.t511 a_522_15314# a_873_15225# vdd.t504 sg13_lv_pmos ad=1.21587p pd=7.58u as=93.45f ps=0.865u w=0.42u l=0.13u
X2290 vcm_esd.t20 sw_tgate_11.gb.t6 vcm_esd.t7 vss.t959 sg13_lv_nmos ad=0.19p pd=1.38u as=0 ps=0 w=1u l=1u
X2291 a_1367_1349# quantizer2_lfsr_0.sg13cmos5l_dfrbpq_1_11.D.t2 vdd.t621 vdd.t504 sg13_lv_pmos ad=79.8f pd=0.8u as=0.1428p ps=1.52u w=0.42u l=0.13u
X2292 vdd.t1123 dsm2_io_0.sg13cmos5l_inv_1_6.A d_rst_b.t1 vdd.t617 sg13_lv_pmos ad=0.3808p pd=2.92u as=0.3808p ps=2.92u w=1.12u l=0.13u
X2293 d_amp_s_b[2].t0 d_amp_s[2].t4 vdd.t1614 vdd.t507 sg13_lv_pmos ad=0.3808p pd=2.92u as=0.3808p ps=2.92u w=1.12u l=0.13u
X2294 a_22644_2344# a_22184_2052# a_22738_2088# vss.t20 sg13_lv_nmos ad=0.17p pd=1.68u as=95f ps=0.88u w=0.5u l=0.13u
X2295 a_20770_598# dsm2_osc_0.di_clk_ext a_20673_892# vdd.t515 sg13_lv_pmos ad=0.2225p pd=1.445u as=0.3325p ps=1.665u w=1u l=0.13u
X2296 vdd.t619 dsm2_io_vcmg_0.di_vcm_ext_b.t2 a_16941_5500# vdd.t526 sg13_lv_pmos ad=0.1918p pd=1.5u as=0.1596p ps=1.22u w=0.84u l=0.13u
X2297 vdd.t9 vss.t2388 vdd.t8 vdd.t0 sg13_lv_pmos ad=0.19p pd=1.38u as=0 ps=0 w=1u l=1u
X2298 vss.t390 vss.t384 sg13cmos5l_inv_1_2.A.t2 vss.t389 sg13_lv_nmos ad=95f pd=0.88u as=95f ps=0.88u w=0.5u l=0.5u
X2299 vss.t1596 vdd.t1803 vss.t1594 vss.t1586 sg13_lv_nmos ad=79.8f pd=0.8u as=0 ps=0 w=0.42u l=1u
X2300 vdd.t637 d_dith[0].t3 sg13cmos5l_inv_1_10.Y vdd.t502 sg13_lv_pmos ad=0.3808p pd=2.92u as=0.3808p ps=2.92u w=1.12u l=0.13u
X2301 vss.t1376 vss.t1377 vss.t34 rhigh l=17.5u w=0.5u
X2302 quantizer2_lfsr_0.sg13cmos5l_dfrbpq_1_8.D a_522_8085# vss.t569 vss.t568 sg13_lv_nmos ad=0.2516p pd=2.16u as=0.1406p ps=1.12u w=0.74u l=0.13u
X2303 vdd.t1269 a_10787_14878# sg13cmos5l_and2_2_1.X.t1 vdd.t502 sg13_lv_pmos ad=0.1918p pd=1.5u as=0.2128p ps=1.5u w=1.12u l=0.13u
X2304 vdd.t938 bias_gm_0.bias_trim_0.vz.t25 a_22252_4374# vdd.t384 sg13_lv_pmos ad=95f pd=0.88u as=95f ps=0.88u w=0.5u l=5u
X2305 vdd.t511 a_522_5110# a_522_4946# vdd.t504 sg13_lv_pmos ad=1.21587p pd=7.58u as=79.8f ps=0.8u w=0.42u l=0.13u
X2306 vss.t2051 vdd.t1697 vss.t2049 vss.t2050 sg13_lv_nmos ad=79.8f pd=0.8u as=0 ps=0 w=0.42u l=1u
X2307 vss.t1372 a_20328_23820# vss.t1373 vss.t265 sg13_hv_nmos ad=1.9p pd=10.38u as=0 ps=0 w=10u l=10u
X2308 vss.t1838 vdd.t1744 vss.t1837 vss.t1836 sg13_lv_nmos ad=0.1428p pd=1.52u as=0 ps=0 w=0.42u l=1u
X2309 vdd.t1255 bias_gm_0.bias_trim_0.vz.t0 bias_gm_0.bias_trim_0.vz.t1 vdd.t573 sg13_lv_pmos ad=95f pd=0.88u as=95f ps=0.88u w=0.5u l=5u
X2310 quantizer2_lfsr_0.sg13cmos5l_dfrbpq_1_15.D a_1284_8085# vdd.t626 vdd.t504 sg13_lv_pmos ad=0.3808p pd=2.92u as=0.2128p ps=1.5u w=1.12u l=0.13u
X2311 a_2034_11112# a_2079_9714# vss.t1066 vss.t1310 sg13_lv_nmos ad=0.2516p pd=2.16u as=0.1626p ps=1.415u w=0.74u l=0.13u
X2312 vss.t1996 vdd.t1708 vss.t1994 vss.t1995 sg13_lv_nmos ad=79.8f pd=0.8u as=0 ps=0 w=0.42u l=1u
X2313 sg13cmos5l_inv_1_14.A.t7 sg13cmos5l_inv_1_2.A.t10 vdd.t864 vdd.t863 sg13_lv_pmos ad=0.285p pd=1.88u as=0.285p ps=1.88u w=1.5u l=0.5u
X2314 a_24540_20880# a_28126_21020# vss.t34 rhigh l=17.5u w=0.5u
X2315 vss.t1268 vss.t1269 vss.t39 rhigh l=2.75u w=0.5u
X2316 vdd.t511 a_1284_2799# a_1407_2354# vdd.t504 sg13_lv_pmos ad=1.21587p pd=7.58u as=79.8f ps=0.8u w=0.42u l=0.13u
X2317 bias_gm_0.bias_trim_0.vz.t16 bias_gm_0.bias_trim_0.vz.t15 vdd.t997 vdd.t572 sg13_lv_pmos ad=95f pd=0.88u as=95f ps=0.88u w=0.5u l=5u
X2318 vss.t1517 vdd.t1820 vss.t1516 vss.t1515 sg13_lv_nmos ad=0.1428p pd=1.52u as=0 ps=0 w=0.42u l=1u
X2319 vss.t1762 vdd.t1762 vss.t1761 vss.t1760 sg13_lv_nmos ad=0.1428p pd=1.52u as=0 ps=0 w=0.42u l=1u
X2320 vss.t998 vi_esd.t13 dantenna l=3.1u w=0.64u
X2321 vdd.t267 vss.t2401 vdd.t266 vdd.t0 sg13_lv_pmos ad=0.34p pd=2.68u as=0 ps=0 w=1u l=1u
X2322 vss.t1329 vss.t1330 vss.t39 rhigh l=2.75u w=0.5u
X2323 a_24214_14546# a_20138_14766# a_22138_14846# vdd.t898 sg13_lv_pmos ad=0.17p pd=1.68u as=95f ps=0.88u w=0.5u l=10u
X2324 vss.t241 a_23289_752# a_22368_558# vss.t1420 sg13_lv_nmos ad=0.1626p pd=1.415u as=0.2516p ps=2.16u w=0.74u l=0.13u
X2325 a_9533_11104.t7 xq_vg_q_2_.t3 a_9357_11104.t17 vss.t29 sg13_lv_nmos ad=0.285p pd=1.88u as=0.285p ps=1.88u w=1.5u l=0.5u
X2326 a_23294_2578# a_21554_2798# vdd.t644 vdd.t514 sg13_lv_pmos ad=0.17p pd=1.68u as=0.17p ps=1.68u w=0.5u l=0.5u
X2327 a_8661_8748# a_10757_8608# vss.t881 rhigh l=10.05u w=0.5u
X2328 vss.t1374 a_20328_23820# vss.t322 vss.t269 sg13_hv_nmos ad=1.9p pd=10.38u as=0 ps=0 w=10u l=10u
X2329 a_6453_8400.t2 d_amp_s[3].t3 a_5892_8400.t5 vss.t666 sg13_lv_nmos ad=0.17p pd=1.68u as=95f ps=0.88u w=0.5u l=0.13u
X2330 quantizer2_lfsr_0.sg13cmos5l_dfrbpq_1_13.D.t1 a_1284_13269# vdd.t1206 vdd.t504 sg13_lv_pmos ad=0.3808p pd=2.92u as=0.2128p ps=1.5u w=1.12u l=0.13u
X2331 vdd.t301 vss.t2422 vdd.t294 vdd.t0 sg13_lv_pmos ad=0.19p pd=1.38u as=0 ps=0 w=1u l=1u
X2332 vss.t2019 vdd.t1703 vss.t2018 vss.t2017 sg13_lv_nmos ad=0.1428p pd=1.52u as=0 ps=0 w=0.42u l=1u
X2333 vss.t1368 a_20328_23820# vss.t1369 vss.t265 sg13_hv_nmos ad=1.9p pd=10.38u as=0 ps=0 w=10u l=10u
X2334 xsc_vc1l_n.t1 d_phi2.t5 xsc_vc1l_n.t0 vdd.t562 sg13_lv_pmos ad=0.38p pd=2.38u as=0 ps=0 w=2u l=1u
X2335 vss.t1396 a_10787_14878# sg13cmos5l_and2_2_1.X.t0 vss.t2069 sg13_lv_nmos ad=0.1331p pd=1.12u as=0.1406p ps=1.12u w=0.74u l=0.13u
X2336 a_558_518# quantizer2_lfsr_0.sg13cmos5l_dfrbpq_1_0.D.t2 vdd.t1138 vdd.t504 sg13_lv_pmos ad=79.8f pd=0.8u as=0.1428p ps=1.52u w=0.42u l=0.13u
X2337 vss.t1641 vdd.t1792 vss.t1642 vss.t1637 sg13_lv_nmos ad=79.8f pd=0.8u as=0 ps=0 w=0.42u l=1u
X2338 vss.t1477 vdd.t1828 vss.t1479 vss.t1478 sg13_lv_nmos ad=79.8f pd=0.8u as=0 ps=0 w=0.42u l=1u
X2339 vss.t1852 vdd.t1741 vss.t1851 vss.t1836 sg13_lv_nmos ad=0.1428p pd=1.52u as=0 ps=0 w=0.42u l=1u
X2340 a_23289_752# a_22347_812# a_23195_985# vdd.t515 sg13_lv_pmos ad=79.8f pd=0.8u as=0.1428p ps=1.52u w=0.42u l=0.13u
X2341 a_20884_598# dsm2_osc_0.di_clk_ext a_20770_598# vss.t1419 sg13_lv_nmos ad=0.3367p pd=1.65u as=0.1628p ps=1.18u w=0.74u l=0.13u
X2342 a_22252_8546# bias_gm_0.bias_trim_0.vz.t44 vdd.t1159 vdd.t566 sg13_lv_pmos ad=95f pd=0.88u as=95f ps=0.88u w=0.5u l=5u
X2343 vss.t1949 vdd.t1718 vss.t1948 vss.t1947 sg13_lv_nmos ad=0.1428p pd=1.52u as=0 ps=0 w=0.42u l=1u
X2344 a_10096_6736# clk_noverlap_0.sg13cmos5l_nor3_1_0.C clk_noverlap_0.sg13cmos5l_inv_1_1.A vdd.t308 sg13_lv_pmos ad=0.2128p pd=1.5u as=0.3808p ps=2.92u w=1.12u l=0.13u
X2345 vdd.t770 a_5176_31117# vdd.t771 vdd.t764 sg13_lv_pmos ad=0.465p pd=1.93u as=0 ps=0 w=1u l=2u
X2346 vdd.t1653 vss.t2416 vdd.t1652 vdd.t0 sg13_lv_pmos ad=0.19p pd=1.38u as=0 ps=0 w=1u l=1u
X2347 vdd.t471 vss.t2286 vdd.t338 vdd.t116 sg13_lv_pmos ad=0.19p pd=1.38u as=0 ps=0 w=1u l=1u
X2348 sg13cmos5l_inv_1_6.A.t0 d_dith[1].t2 vdd.t606 vdd.t502 sg13_lv_pmos ad=0.2128p pd=1.5u as=0.3808p ps=2.92u w=1.12u l=0.13u
X2349 vdd.t986 vdd.t1481 vdd.t1482 vdd.t1173 sg13_lv_pmos ad=95f pd=0.88u as=0 ps=0 w=0.5u l=5u
X2350 quantizer2_lfsr_0.sg13cmos5l_dfrbpq_1_12.Q a_1284_5493# vss.t547 vss.t546 sg13_lv_nmos ad=0.2516p pd=2.16u as=0.1406p ps=1.12u w=0.74u l=0.13u
X2351 a_2079_12306# a_2049_12741# a_2461_12681# vdd.t507 sg13_lv_pmos ad=79.8f pd=0.8u as=63f ps=0.72u w=0.42u l=0.13u
X2352 quantizer2_lfsr_0.sg13cmos5l_dfrbpq_1_7.D a_522_10677# vdd.t1236 vdd.t504 sg13_lv_pmos ad=0.3808p pd=2.92u as=0.2128p ps=1.5u w=1.12u l=0.13u
X2353 vss.t1587 vdd.t1805 vss.t1585 vss.t1586 sg13_lv_nmos ad=79.8f pd=0.8u as=0 ps=0 w=0.42u l=1u
X2354 vss.t1370 a_20328_23820# vss.t316 vss.t269 sg13_hv_nmos ad=1.9p pd=10.38u as=0 ps=0 w=10u l=10u
X2355 vdd.t404 vss.t2260 vdd.t412 vdd.t95 sg13_lv_pmos ad=0.19p pd=1.38u as=0 ps=0 w=1u l=1u
X2356 vdd.t689 clk_noverlap_0.sg13cmos5l_dlygate4sd3_1_0.X a_5131_7241# vdd.t308 sg13_lv_pmos ad=0.1523p pd=1.38u as=0.1428p ps=1.52u w=0.42u l=0.13u
X2357 vss.t629 clk_noverlap_0.sg13cmos5l_inv_1_1.Y clk_noverlap_0.sg13cmos5l_inv_1_3.Y vss.t628 sg13_lv_nmos ad=0.2516p pd=2.16u as=0.2516p ps=2.16u w=0.74u l=0.13u
X2358 vdd.t1596 vdd.t1590 vdd.t1598 vdd.t572 sg13_lv_pmos ad=95f pd=0.88u as=0 ps=0 w=0.5u l=5u
X2359 a_6452_29739.t4 xsc_vvg_n.t6 w_9407_29481.t6 w_9407_29481.t0 sg13_lv_pmos ad=0.38p pd=2.38u as=0.38p ps=2.38u w=2u l=1u
X2360 a_1324_8580# a_1288_8554# vdd.t685 vdd.t504 sg13_lv_pmos ad=0.34p pd=2.68u as=0.36237p ps=2.605u w=1u l=0.13u
X2361 vcm_esd.t15 sw_tgate_cmfb2_1.gb.t3 vcm_esd.t14 vss.t594 sg13_lv_nmos ad=95f pd=0.88u as=0 ps=0 w=0.5u l=1u
X2362 vdd.t351 vss.t2289 vdd.t350 vdd.t116 sg13_lv_pmos ad=0.34p pd=2.68u as=0 ps=0 w=1u l=1u
X2363 vss.t1313 xsc_vfb.t12 a_6452_29739.t5 vss.t102 sg13_lv_nmos ad=95f pd=0.88u as=95f ps=0.88u w=0.5u l=3u
X2364 a_10592_15909# d_qi_b.t4 a_10729_15998# vss.t1040 sg13_lv_nmos ad=0.2176p pd=1.96u as=0.1216p ps=1.02u w=0.64u l=0.13u
X2365 vdd.t1233 a_5176_31469# vdd.t1232 vdd.t764 sg13_lv_pmos ad=1.19p pd=7.68u as=0 ps=0 w=3.5u l=2u
X2366 a_522_15478# a_537_14181# a_522_15144# vdd.t504 sg13_lv_pmos ad=0.2048p pd=1.63u as=0.34p ps=2.68u w=1u l=0.13u
X2367 clk_noverlap_0.sg13cmos5l_inv_1_11.Y d_ena.t2 vss.t1439 vss.t1438 sg13_lv_nmos ad=0.2516p pd=2.16u as=0.2516p ps=2.16u w=0.74u l=0.13u
X2368 sw_tgate_6.p.t3 sw_tgate_11.gb.t3 sw_tgate_6.p.t2 vss.t599 sg13_lv_nmos ad=0.19p pd=1.38u as=0 ps=0 w=1u l=1u
X2369 vss.t584 a_16161_7467# clk_noverlap_0.sg13cmos5l_dlygate4sd3_1_10.A vss.t893 sg13_lv_nmos ad=0.1426p pd=1.16u as=0.2516p ps=2.16u w=0.74u l=0.13u
X2370 vcm_esd.t3 d_phi2.t13 xsc_xcmfb1_vsw_cm_p.t0 vss.t186 sg13_lv_nmos ad=95f pd=0.88u as=95f ps=0.88u w=0.5u l=1u
X2371 a_21617_558# a_22347_812# a_22368_558# vss.t661 sg13_lv_nmos ad=0.12665p pd=1.145u as=0.3473p ps=2.71u w=0.74u l=0.13u
X2372 vdd.t593 a_5401_7200# a_5513_7224# vdd.t308 sg13_lv_pmos ad=0.2254p pd=1.53u as=0.34p ps=2.68u w=1u l=0.5u
X2373 vdd.t588 sg13cmos5l_inv_1_7.Y do_q_dec.t1 vdd.t502 sg13_lv_pmos ad=0.3864p pd=2.93u as=0.2128p ps=1.5u w=1.12u l=0.13u
X2374 a_1288_3370# a_1286_4247# a_1367_3941# vss.t2117 sg13_lv_nmos ad=79.8f pd=0.8u as=0.1296p ps=1.52u w=0.42u l=0.13u
X2375 vss.t448 vss.t445 vss.t447 vss.t446 sg13_lv_nmos ad=95f pd=0.88u as=0 ps=0 w=0.5u l=0.5u
X2376 vss.t400 vss.t397 vss.t399 vss.t398 sg13_lv_nmos ad=95f pd=0.88u as=0 ps=0 w=0.5u l=0.5u
X2377 xvcm_vcf_b.t0 d_vcm_phi1_b.t3 vcm_esd.t19 vdd.t756 sg13_lv_pmos ad=1.36p pd=8.68u as=1.36p ps=8.68u w=4u l=0.5u
X2378 vdd.t230 vss.t2338 vdd.t229 vdd.t65 sg13_lv_pmos ad=0.34p pd=2.68u as=0 ps=0 w=1u l=1u
X2379 vdd.t1053 d_dith_en.t8 a_1367_3941# vdd.t504 sg13_lv_pmos ad=0.36237p pd=2.605u as=79.8f ps=0.8u w=0.42u l=0.13u
X2380 vdd.t125 vss.t2210 vdd.t124 vdd.t123 sg13_lv_pmos ad=0.19p pd=1.38u as=0 ps=0 w=1u l=1u
X2381 vss.t811 a_14266_14856# a_13985_15078# vss.t810 sg13_lv_nmos ad=79.8f pd=0.8u as=0.1428p ps=1.52u w=0.42u l=0.5u
X2382 vdd.t737 vdd.t1588 vdd.t1589 vdd.t1173 sg13_lv_pmos ad=95f pd=0.88u as=0 ps=0 w=0.5u l=5u
X2383 vss.t512 d_dith[0].t3 sg13cmos5l_inv_1_10.Y vss.t511 sg13_lv_nmos ad=0.2516p pd=2.16u as=0.2516p ps=2.16u w=0.74u l=0.13u
X2384 clk_noverlap_0.do_phi2_b clk_noverlap_0.sg13cmos5l_inv_1_8.A vdd.t746 vdd.t308 sg13_lv_pmos ad=0.3808p pd=2.92u as=0.3808p ps=2.92u w=1.12u l=0.13u
X2385 a_522_7702# a_537_6405# a_558_7470# vss.t570 sg13_lv_nmos ad=0.12665p pd=1.145u as=0.1428p ps=1.52u w=0.42u l=0.13u
X2386 vss.t1712 vdd.t1774 vss.t1711 vss.t1710 sg13_lv_nmos ad=0.1428p pd=1.52u as=0 ps=0 w=0.42u l=1u
X2387 a_21554_2798# a_21554_2052.t6 vss.t516 vss.t515 sg13_lv_nmos ad=0.17p pd=1.68u as=95f ps=0.88u w=0.5u l=0.5u
X2388 vdd.t511 a_522_7538# a_873_7449# vdd.t504 sg13_lv_pmos ad=1.21587p pd=7.58u as=93.45f ps=0.865u w=0.42u l=0.13u
X2389 bias_gm_0.bias_trim_0.iout dsm2_io_0.do_trim_b[1].t2 a_24404_4674# vdd.t573 sg13_lv_pmos ad=95f pd=0.88u as=95f ps=0.88u w=0.5u l=5u
X2390 vss.t2001 vdd.t1707 vss.t1999 vss.t2000 sg13_lv_nmos ad=79.8f pd=0.8u as=0 ps=0 w=0.42u l=1u
X2391 vdd.t239 vss.t2298 vdd.t91 vdd.t62 sg13_lv_pmos ad=0.19p pd=1.38u as=0 ps=0 w=1u l=1u
X2392 a_1367_8937# a_1324_8580# vdd.t959 vdd.t504 sg13_lv_pmos ad=63f pd=0.72u as=0.1563p ps=1.22u w=0.42u l=0.13u
X2393 a_11115_8608# a_13211_8468# vss.t6 rhigh l=10.05u w=0.5u
X2394 vo_n.t12 a_5176_30111# a_7804_29739.t2 vss.t775 sg13_lv_nmos ad=95f pd=0.88u as=0.17p ps=1.68u w=0.5u l=3u
X2395 a_13101_7164# clk_noverlap_0.sg13cmos5l_dlygate4sd3_1_7.X vss.t452 vss.t494 sg13_lv_nmos ad=0.1428p pd=1.52u as=79.8f ps=0.8u w=0.42u l=0.13u
X2396 vdd.t122 vss.t2341 vdd.t90 vdd.t88 sg13_lv_pmos ad=0.19p pd=1.38u as=0 ps=0 w=1u l=1u
X2397 vss.t1299 vss.t1300 vss.t531 rhigh l=2.75u w=0.5u
X2398 a_8768_15909# sg13cmos5l_inv_2_4.Y a_8905_15998# vss.t593 sg13_lv_nmos ad=0.2176p pd=1.96u as=0.1216p ps=1.02u w=0.64u l=0.13u
X2399 xsc_vc1l_n.t2 d_phi2.t5 vi_esd.t3 vss.t202 sg13_lv_nmos ad=0.19p pd=1.38u as=0.34p ps=2.68u w=1u l=1u
X2400 a_1367_9125# a_1322_9362# a_1288_8554# vdd.t504 sg13_lv_pmos ad=0.1428p pd=1.52u as=79.8f ps=0.8u w=0.42u l=0.13u
X2401 vss.t1242 quantizer2_lfsr_0.di_dith_amp[0].t3 d_amp_s[2].t0 vss.t664 sg13_lv_nmos ad=0.2516p pd=2.16u as=0.1406p ps=1.12u w=0.74u l=0.13u
X2402 vss.t1556 vdd.t1812 vss.t1555 vss.t1554 sg13_lv_nmos ad=0.1428p pd=1.52u as=0 ps=0 w=0.42u l=1u
X2403 sg13cmos5l_inv_2_5.A sg13cmos5l_inv_1_14.A.t11 vdd.t1140 vdd.t502 sg13_lv_pmos ad=0.3808p pd=2.92u as=0.3808p ps=2.92u w=1.12u l=0.13u
X2404 sg13cmos5l_inv_1_6.A.t1 sg13cmos5l_nand2_1_5.A.t7 a_6202_16020# vss.t663 sg13_lv_nmos ad=0.2516p pd=2.16u as=0.1406p ps=1.12u w=0.74u l=0.13u
X2405 vdd.t1549 vdd.t1547 vdd.t1188 vdd.t1287 sg13_lv_pmos ad=0.17p pd=1.68u as=0 ps=0 w=0.5u l=5u
X2406 vdd.t1611 vdd.t1609 vdd.t1610 vdd.t514 sg13_lv_pmos ad=0.17p pd=1.68u as=0 ps=0 w=0.5u l=0.5u
X2407 vss.t1621 vdd.t1797 vss.t1619 vss.t1620 sg13_lv_nmos ad=79.8f pd=0.8u as=0 ps=0 w=0.42u l=1u
X2408 d_dith[0].t0 a_2034_698# vdd.t703 vdd.t507 sg13_lv_pmos ad=0.42p pd=2.99u as=0.2114p ps=1.54u w=1.12u l=0.13u
X2409 a_537_11589# d_qclk.t16 vdd.t511 vdd.t504 sg13_lv_pmos ad=0.4088p pd=2.97u as=1.1847p ps=7.385u w=1.12u l=0.13u
X2410 vss.t1848 vdd.t1742 vss.t1847 vss.t1846 sg13_lv_nmos ad=0.1428p pd=1.52u as=0 ps=0 w=0.42u l=1u
X2411 vi_esd.t14 vdd.t553 dpantenna l=0.64u w=4.98u
X2412 sg13cmos5l_inv_1_2.A.t9 vdd.t1309 vdd.t1310 vdd.t863 sg13_lv_pmos ad=0.285p pd=1.88u as=0.285p ps=1.88u w=1.5u l=0.5u
X2413 a_7224_31505# a_5176_31117# vdd.t796 vdd.t764 sg13_lv_pmos ad=0.19p pd=1.38u as=0.34p ps=2.68u w=1u l=2u
X2414 vdd.t317 vss.t2344 vdd.t316 vdd.t88 sg13_lv_pmos ad=0.34p pd=2.68u as=0 ps=0 w=1u l=1u
X2415 vdd.t1521 vdd.t1515 vdd.t1523 vdd.t572 sg13_lv_pmos ad=95f pd=0.88u as=0 ps=0 w=0.5u l=5u
X2416 vdd.t894 a_15297_7467# clk_noverlap_0.sg13cmos5l_dlygate4sd3_1_9.A vdd.t308 sg13_lv_pmos ad=0.2254p pd=1.53u as=0.4256p ps=3u w=1.12u l=0.13u
X2417 a_19964_18216# a_19904_17646# vss.t1336 vss.t1169 sg13_lv_nmos ad=0.17p pd=1.68u as=0.17p ps=1.68u w=0.5u l=1u
X2418 vdd.t564 a_17421_7164# a_17140_7466# vdd.t308 sg13_lv_pmos ad=0.1523p pd=1.38u as=0.34p ps=2.68u w=1u l=0.5u
X2419 vdd.t682 bias_gm_0.bias_trim_0.vz.t49 a_22252_8546# vdd.t573 sg13_lv_pmos ad=95f pd=0.88u as=95f ps=0.88u w=0.5u l=5u
X2420 a_19984_17824# bias_gm_0.bias_trim_0.vz.t6 vdd.t574 vdd.t566 sg13_lv_pmos ad=95f pd=0.88u as=95f ps=0.88u w=0.5u l=5u
X2421 vdd.t1341 vdd.t1309 vdd.t1336 vdd.t863 sg13_lv_pmos ad=0.285p pd=1.88u as=0 ps=0 w=1.5u l=0.5u
X2422 a_19105_884# di_clk vdd.t1246 vdd.t1245 sg13_lv_pmos ad=0.34p pd=2.68u as=0.2086p ps=1.5u w=1u l=0.13u
X2423 vdd.t483 vss.t2181 vdd.t192 vdd.t82 sg13_lv_pmos ad=0.34p pd=2.68u as=0 ps=0 w=1u l=1u
X2424 vo_n.t14 a_5176_30111# a_7804_29739.t4 vss.t765 sg13_lv_nmos ad=0.17p pd=1.68u as=95f ps=0.88u w=0.5u l=3u
X2425 vdd.t595 d_dith_en.t9 a_567_3378# vdd.t504 sg13_lv_pmos ad=0.1563p pd=1.22u as=0.147p ps=1.54u w=0.42u l=0.13u
X2426 clk_noverlap_0.sg13cmos5l_dlygate4sd3_1_3.X a_7241_7224# vdd.t666 vdd.t308 sg13_lv_pmos ad=0.4256p pd=3u as=0.2254p ps=1.53u w=1.12u l=0.13u
X2427 do_q.t1 sg13cmos5l_inv_1_5.Y vss.t1390 vss.t1389 sg13_lv_nmos ad=0.1406p pd=1.12u as=0.2516p ps=2.16u w=0.74u l=0.13u
X2428 vdd.t968 vdd.t1315 vdd.t1316 vdd.t863 sg13_lv_pmos ad=0.285p pd=1.88u as=0 ps=0 w=1.5u l=0.5u
X2429 ibias_200n.t3 dsm2_io_0.do_trim_b[2].t5 a_22252_8546# vdd.t384 sg13_lv_pmos ad=95f pd=0.88u as=95f ps=0.88u w=0.5u l=5u
X2430 vdd.t856 a_5176_31117# vdd.t854 vdd.t764 sg13_lv_pmos ad=0.465p pd=1.93u as=0 ps=0 w=1u l=2u
X2431 a_13594_16020# sg13cmos5l_nand2_1_5.A.t5 sg13cmos5l_inv_1_13.A.t1 vss.t982 sg13_lv_nmos ad=0.1406p pd=1.12u as=0.2516p ps=2.16u w=0.74u l=0.13u
X2432 vdd.t461 vss.t2172 vdd.t413 vdd.t339 sg13_lv_pmos ad=0.19p pd=1.38u as=0 ps=0 w=1u l=1u
X2433 vss.t1859 vdd.t1739 vss.t1858 vss.t1846 sg13_lv_nmos ad=0.1428p pd=1.52u as=0 ps=0 w=0.42u l=1u
X2434 vss.t1217 a_21554_2052.t8 a_22386_2344# vss.t1216 sg13_lv_nmos ad=95f pd=0.88u as=0.17p ps=1.68u w=0.5u l=0.5u
X2435 a_537_3813# d_qclk.t7 vss.t143 vss.t1409 sg13_lv_nmos ad=0.2516p pd=2.16u as=3.67165p ps=23.42u w=0.74u l=0.13u
X2436 vss.t1172 a_19964_18216# bias_gm_0.bias_trim_0.vz.t19 vss.t1171 sg13_hv_nmos ad=1.36p pd=8.68u as=1.36p ps=8.68u w=4u l=0.5u
X2437 vdd.t1246 a_19105_884# dsm2_osc_0.di_clk_ext vdd.t1245 sg13_lv_pmos ad=0.2086p pd=1.5u as=0.2128p ps=1.5u w=1.12u l=0.13u
X2438 vdd.t1420 vdd.t1418 vdd.t996 vdd.t1287 sg13_lv_pmos ad=0.17p pd=1.68u as=0 ps=0 w=0.5u l=5u
X2439 vss.t621 clk_noverlap_0.sg13cmos5l_inv_1_6.A clk_noverlap_0.sg13cmos5l_inv_1_5.A vss.t620 sg13_lv_nmos ad=0.2516p pd=2.16u as=0.2516p ps=2.16u w=0.74u l=0.13u
X2440 vss.t708 d_dith_en.t27 a_558_10980# vss.t1099 sg13_lv_nmos ad=0.1626p pd=1.415u as=60.89999f ps=0.71u w=0.42u l=0.13u
X2441 dsm2_osc_0.d_btest_or.t1 a_22836_1332# vdd.t608 vdd.t515 sg13_lv_pmos ad=0.3976p pd=2.95u as=0.2226p ps=1.535u w=1.12u l=0.13u
X2442 vdd.t579 bias_gm_0.bias_trim_0.vz.t6 a_19984_17824# vdd.t570 sg13_lv_pmos ad=95f pd=0.88u as=95f ps=0.88u w=0.5u l=5u
X2443 a_24540_22000# a_28126_22140# vss.t34 rhigh l=17.5u w=0.5u
X2444 vss.t1497 vdd.t1824 vss.t1496 vss.t1495 sg13_lv_nmos ad=0.1428p pd=1.52u as=0 ps=0 w=0.42u l=1u
X2445 a_2079_12306# a_2049_12741# a_2070_12038# vss.t700 sg13_lv_nmos ad=79.8f pd=0.8u as=0.1296p ps=1.52u w=0.42u l=0.13u
X2446 vss.t1971 vdd.t1713 vss.t1970 vss.t1969 sg13_lv_nmos ad=0.1428p pd=1.52u as=0 ps=0 w=0.42u l=1u
X2447 a_1407_12722# a_1284_13167# a_1758_12850# vss.t1024 sg13_lv_nmos ad=0.1428p pd=1.52u as=37.8f ps=0.6u w=0.42u l=0.13u
X2448 vss.t929 a_522_7538# a_558_7470# vss.t928 sg13_lv_nmos ad=79.8f pd=0.8u as=0.1428p ps=1.52u w=0.42u l=0.13u
X2449 a_2049_7557# d_qclk.t11 vdd.t507 vdd.t507 sg13_lv_pmos ad=0.4088p pd=2.97u as=1.87952p ps=12.085u w=1.12u l=0.13u
X2450 a_22252_4074# bias_gm_0.bias_trim_0.vz.t26 vdd.t1161 vdd.t566 sg13_lv_pmos ad=95f pd=0.88u as=95f ps=0.88u w=0.5u l=5u
X2451 vss.t1442 vdd.t1835 vss.t1444 vss.t1443 sg13_lv_nmos ad=79.8f pd=0.8u as=0 ps=0 w=0.42u l=1u
X2452 a_2034_6098# d_dith_en.t13 vdd.t507 vdd.t507 sg13_lv_pmos ad=79.8f pd=0.8u as=1.87952p ps=12.085u w=0.42u l=0.13u
X2453 xq_dith_v_bq.t6 sg13cmos5l_inv_1_3.Y.t3 vo_p.t11 vdd.t624 sg13_lv_pmos ad=1.19p pd=7.68u as=0.665p ps=3.88u w=3.5u l=0.13u
X2454 vss.t1320 vss.t1321 vss.t39 rhigh l=2.75u w=0.5u
X2455 a_20672_19900# a_24258_19760# vss.t207 rhigh l=17.5u w=0.5u
X2456 vss.t1962 vdd.t1715 vss.t1961 vss.t1947 sg13_lv_nmos ad=0.1428p pd=1.52u as=0 ps=0 w=0.42u l=1u
X2457 vdd.t275 vss.t2399 vdd.t277 vdd.t0 sg13_lv_pmos ad=0.34p pd=2.68u as=0 ps=0 w=1u l=1u
X2458 vdd.t175 vss.t2196 vdd.t174 vdd.t173 sg13_lv_pmos ad=0.19p pd=1.38u as=0 ps=0 w=1u l=1u
X2459 vdd.t773 a_5176_31117# vdd.t774 vdd.t764 sg13_lv_pmos ad=0.465p pd=1.93u as=0 ps=0 w=1u l=2u
X2460 a_522_4776# a_533_4736# a_522_5110# vss.t550 sg13_lv_nmos ad=0.3473p pd=2.71u as=0.12665p ps=1.145u w=0.74u l=0.13u
X2461 vss.t1046 di_vcm_ext dsm2_io_vcmg_0.di_vcm_ext_b.t0 vss.t1045 sg13_hv_nmos ad=0.34p pd=2.68u as=0.34p ps=2.68u w=1u l=0.45u
X2462 a_9357_11104.t12 vo_n.t24 a_11293_11104.t1 vss.t643 sg13_lv_nmos ad=0.76p pd=4.38u as=0.76p ps=4.38u w=4u l=0.5u
X2463 a_1758_10980# quantizer2_lfsr_0.sg13cmos5l_dfrbpq_1_14.D a_1367_11717# vss.t654 sg13_lv_nmos ad=60.89999f pd=0.71u as=0.1428p ps=1.52u w=0.42u l=0.13u
X2464 a_1324_3396# a_1322_4178# a_1284_5391# vss.t145 sg13_lv_nmos ad=0.3473p pd=2.71u as=0.12665p ps=1.145u w=0.74u l=0.13u
X2465 quantizer2_lfsr_0.sg13cmos5l_dfrbpq_1_2.Q.t1 a_2034_4053# vdd.t1115 vdd.t507 sg13_lv_pmos ad=0.3808p pd=2.92u as=0.2128p ps=1.5u w=1.12u l=0.13u
X2466 vss.t1941 vdd.t1720 vss.t1939 vss.t1940 sg13_lv_nmos ad=79.8f pd=0.8u as=0 ps=0 w=0.42u l=1u
X2467 a_2034_3506# a_2034_3670# a_2070_3634# vss.t1146 sg13_lv_nmos ad=0.1428p pd=1.52u as=37.8f ps=0.6u w=0.42u l=0.13u
X2468 vss.t1457 vdd.t1832 vss.t1459 vss.t1458 sg13_lv_nmos ad=79.8f pd=0.8u as=0 ps=0 w=0.42u l=1u
X2469 vdd.t97 vss.t2259 vdd.t96 vdd.t95 sg13_lv_pmos ad=0.34p pd=2.68u as=0 ps=0 w=1u l=1u
X2470 a_5176_31469# a_5176_30111# a_13189_30111# vss.t785 sg13_lv_nmos ad=0.17p pd=1.68u as=95f ps=0.88u w=0.5u l=3u
X2471 vss.t143 a_537_8997# a_533_9920# vss.t932 sg13_lv_nmos ad=4.19617p pd=26.765u as=0.2516p ps=2.16u w=0.74u l=0.13u
X2472 vdd.t430 vss.t2199 vdd.t469 vdd.t173 sg13_lv_pmos ad=0.34p pd=2.68u as=0 ps=0 w=1u l=1u
X2473 vdd.t7 vss.t2393 vdd.t6 vdd.t0 sg13_lv_pmos ad=0.34p pd=2.68u as=0 ps=0 w=1u l=1u
X2474 vss.t404 vss.t384 sg13cmos5l_inv_1_14.A.t0 vss.t403 sg13_lv_nmos ad=95f pd=0.88u as=95f ps=0.88u w=0.5u l=0.5u
X2475 xsc_vvg_n.t3 d_phi2.t11 xsc_vc1r_p.t0 vss.t191 sg13_lv_nmos ad=0.19p pd=1.38u as=0.19p ps=1.38u w=1u l=1u
X2476 a_22252_11246# bias_gm_0.bias_trim_0.vz.t15 vdd.t999 vdd.t287 sg13_lv_pmos ad=95f pd=0.88u as=95f ps=0.88u w=0.5u l=5u
X2477 vdd.t1182 bias_gm_0.bias_trim_0.vz.t3 a_22252_11246# vdd.t384 sg13_lv_pmos ad=95f pd=0.88u as=95f ps=0.88u w=0.5u l=5u
X2478 vdd.t37 vss.t2379 vdd.t36 vdd.t10 sg13_lv_pmos ad=0.34p pd=2.68u as=0 ps=0 w=1u l=1u
X2479 vss.t1078 a_522_10130# a_558_10062# vss.t1309 sg13_lv_nmos ad=79.8f pd=0.8u as=0.1428p ps=1.52u w=0.42u l=0.13u
X2480 a_24404_8546# bias_gm_0.bias_trim_0.vz.t38 vdd.t1005 vdd.t572 sg13_lv_pmos ad=95f pd=0.88u as=95f ps=0.88u w=0.5u l=5u
X2481 a_11293_11104.t3 sg13cmos5l_inv_1_2.A.t10 sg13cmos5l_inv_1_14.A.t1 vss.t642 sg13_lv_nmos ad=95f pd=0.88u as=95f ps=0.88u w=0.5u l=0.5u
X2482 vdd.t1692 vss.t2414 vdd.t1648 vdd.t0 sg13_lv_pmos ad=0.19p pd=1.38u as=0 ps=0 w=1u l=1u
X2483 vdd.t749 a_15491_15614# sg13cmos5l_nand2_2_0.B.t1 vdd.t502 sg13_lv_pmos ad=0.1918p pd=1.5u as=0.2128p ps=1.5u w=1.12u l=0.13u
X2484 a_22252_5274# dsm2_io_0.do_trim_b[2].t2 bias_gm_0.bias_trim_0.iout vdd.t287 sg13_lv_pmos ad=95f pd=0.88u as=95f ps=0.88u w=0.5u l=5u
X2485 vss.t43 sg13cmos5l_and2_1_5.X.t3 a_8208_15626# vss.t42 sg13_lv_nmos ad=0.1469p pd=1.155u as=0.1045p ps=0.93u w=0.55u l=0.13u
X2486 vdd.t1027 d_dith_en.t32 a_1288_13738# vdd.t504 sg13_lv_pmos ad=0.1563p pd=1.22u as=0.147p ps=1.54u w=0.42u l=0.13u
X2487 a_8857_7200# a_8587_7241# vss.t576 vss.t617 sg13_lv_nmos ad=0.1428p pd=1.52u as=79.8f ps=0.8u w=0.42u l=0.5u
X2488 vss.t1784 vdd.t1757 vss.t1783 vss.t1782 sg13_lv_nmos ad=0.1428p pd=1.52u as=0 ps=0 w=0.42u l=1u
X2489 dsm2_osc_0.ibias_in.t2 dsm2_osc_0.sg13cmos5l_dfrbp_1_0.RESET_B.t4 dsm2_osc_0.ibias_pad.t0 vdd.t515 sg13_lv_pmos ad=0.34p pd=2.68u as=0.19p ps=1.38u w=1u l=0.5u
X2490 vdd.t507 a_2049_2373# a_2045_3296# vdd.t507 sg13_lv_pmos ad=1.99007p pd=12.8u as=0.3864p ps=2.93u w=1.12u l=0.13u
X2491 a_7129_7200# a_6859_7241# vdd.t530 vdd.t308 sg13_lv_pmos ad=0.34p pd=2.68u as=0.1523p ps=1.38u w=1u l=0.5u
X2492 a_2079_4530# a_2049_4965# a_2070_4262# vss.t56 sg13_lv_nmos ad=79.8f pd=0.8u as=0.1296p ps=1.52u w=0.42u l=0.13u
X2493 a_6452_29739.t3 xsc_vvg_n.t6 w_9407_29481.t2 w_9407_29481.t0 sg13_lv_pmos ad=0.38p pd=2.38u as=0.38p ps=2.38u w=2u l=1u
X2494 a_11293_11104.t0 vss.t427 a_9357_11104.t6 vss.t401 sg13_lv_nmos ad=0.285p pd=1.88u as=0.285p ps=1.88u w=1.5u l=0.5u
X2495 a_571_11460# a_522_12552# a_571_11398# vss.t2083 sg13_lv_nmos ad=0.1428p pd=1.52u as=37.8f ps=0.6u w=0.42u l=0.13u
X2496 vdd.t256 vss.t2408 vdd.t255 vdd.t0 sg13_lv_pmos ad=0.19p pd=1.38u as=0 ps=0 w=1u l=1u
X2497 xsc_vc1r_p.t2 d_phi2.t11 xsc_vc1r_p.t1 vdd.t556 sg13_lv_pmos ad=0.38p pd=2.38u as=0 ps=0 w=2u l=1u
X2498 a_19964_18216# a_19964_18216# a_19964_18216# vdd.t1128 sg13_lv_pmos ad=95f pd=0.88u as=6.9529p ps=59.89u w=0.5u l=10u
X2499 vdd.t1141 sg13cmos5l_nor2_2_2.A a_11284_15186# vdd.t502 sg13_lv_pmos ad=0.2128p pd=1.5u as=0.4032p ps=2.96u w=1.12u l=0.13u
X2500 vdd.t965 sg13cmos5l_and2_2_1.X.t3 sg13cmos5l_inv_1_14.A.t3 vdd.t863 sg13_lv_pmos ad=0.285p pd=1.88u as=0.285p ps=1.88u w=1.5u l=0.5u
X2501 vss.t1632 vdd.t1794 vss.t1633 vss.t1625 sg13_lv_nmos ad=79.8f pd=0.8u as=0 ps=0 w=0.42u l=1u
X2502 xq_dith_v_bq.t10 sg13cmos5l_or2_1_0.X.t3 a_4362_8188.t9 vss.t922 sg13_lv_nmos ad=0.665p pd=3.88u as=0.665p ps=3.88u w=3.5u l=0.13u
X2503 vdd.t1662 vss.t2363 vdd.t1661 vdd.t74 sg13_lv_pmos ad=0.19p pd=1.38u as=0 ps=0 w=1u l=1u
X2504 xsc_xcmfb1_vsw_cm_p.t5 vss.t299 xsc_xcmfb1_vsw_cm_p.t4 vss.t292 sg13_lv_nmos ad=0.17p pd=1.68u as=0 ps=0 w=0.5u l=1u
X2505 vdd.t1186 vdd.t1386 vdd.t1387 vdd.t1173 sg13_lv_pmos ad=95f pd=0.88u as=0 ps=0 w=0.5u l=5u
X2506 a_17025_7467# a_17140_7466# vss.t627 vss.t626 sg13_lv_nmos ad=0.1428p pd=1.52u as=0.1426p ps=1.16u w=0.42u l=0.5u
X2507 xsc_xcmfb1_vsw_vbias.t0 sw_tgate_cmfb2_1.gb.t2 xsc_xcmfb1_vsw_vbias.t4 vss.t983 sg13_lv_nmos ad=95f pd=0.88u as=0 ps=0 w=0.5u l=1u
X2508 xsc_xcmfb1_vsw_cm_n.t9 d_phi1.t8 vo_n.t0 vss.t188 sg13_lv_nmos ad=95f pd=0.88u as=95f ps=0.88u w=0.5u l=1u
X2509 vdd.t910 d_dith_en.t14 a_1288_5962# vdd.t504 sg13_lv_pmos ad=0.1563p pd=1.22u as=0.147p ps=1.54u w=0.42u l=0.13u
X2510 vdd.t511 a_522_7702# a_522_7538# vdd.t504 sg13_lv_pmos ad=1.21587p pd=7.58u as=79.8f ps=0.8u w=0.42u l=0.13u
X2511 a_2034_11282# a_2034_11446# a_2070_11410# vss.t698 sg13_lv_nmos ad=0.1428p pd=1.52u as=37.8f ps=0.6u w=0.42u l=0.13u
X2512 xsc_vc1l_p.t1 d_phi2.t7 xsc_vc1l_p.t0 vdd.t561 sg13_lv_pmos ad=0.38p pd=2.38u as=0 ps=0 w=2u l=1u
X2513 xq_dith_v_bq.t4 sg13cmos5l_inv_1_3.Y.t3 vo_p.t9 vdd.t624 sg13_lv_pmos ad=0.665p pd=3.88u as=0.665p ps=3.88u w=3.5u l=0.13u
X2514 vdd.t602 dsm2_osc_0.sg13cmos5l_dfrbp_1_0.RESET_B.t10 a_21736_2344# vdd.t514 sg13_lv_pmos ad=0.17p pd=1.68u as=95f ps=0.88u w=0.5u l=0.13u
X2515 vdd.t1039 d_qi_b.t8 sw_tgate_12.m.t5 vdd.t561 sg13_lv_pmos ad=0.38p pd=2.38u as=0.38p ps=2.38u w=2u l=1u
X2516 quantizer2_lfsr_0.sg13cmos5l_dfrbpq_1_5.Q a_2034_11829# vdd.t724 vdd.t507 sg13_lv_pmos ad=0.3808p pd=2.92u as=0.2128p ps=1.5u w=1.12u l=0.13u
X2517 vdd.t48 vss.t2383 vdd.t50 vdd.t10 sg13_lv_pmos ad=0.34p pd=2.68u as=0 ps=0 w=1u l=1u
X2518 vdd.t693 clk_noverlap_0.sg13cmos5l_inv_1_6.A clk_noverlap_0.sg13cmos5l_inv_1_5.A vdd.t308 sg13_lv_pmos ad=0.3808p pd=2.92u as=0.3808p ps=2.92u w=1.12u l=0.13u
X2519 a_23391_985# a_22499_864# a_23289_752# vdd.t515 sg13_lv_pmos ad=63f pd=0.72u as=79.8f ps=0.8u w=0.42u l=0.13u
X2520 a_13211_9308.t2 d_amp_s_b[2].t2 a_6249_9100.t5 vdd.t659 sg13_lv_pmos ad=0.17p pd=1.68u as=95f ps=0.88u w=0.5u l=0.13u
X2521 vdd.t31 vss.t2368 vdd.t1674 vdd.t22 sg13_lv_pmos ad=0.34p pd=2.68u as=0 ps=0 w=1u l=1u
X2522 vss.t1274 vss.t1275 vss.t531 rhigh l=2.75u w=0.5u
X2523 vdd.t707 a_14734_15077# sg13cmos5l_and2_1_5.B.t1 vdd.t502 sg13_lv_pmos ad=0.2254p pd=1.53u as=0.4256p ps=3u w=1.12u l=0.13u
X2524 a_8762_31505# a_5176_31117# vdd.t798 vdd.t764 sg13_lv_pmos ad=0.34p pd=2.68u as=0.34p ps=2.68u w=1u l=2u
X2525 a_2038_15217# quantizer2_lfsr_0.sg13cmos5l_dfrbpq_1_6.Q a_2116_14747# vss.t1056 sg13_lv_nmos ad=0.2176p pd=1.96u as=78.39999f ps=0.885u w=0.64u l=0.13u
X2526 vdd.t988 bias_gm_0.bias_trim_0.vz.t23 a_22252_4374# vdd.t570 sg13_lv_pmos ad=95f pd=0.88u as=95f ps=0.88u w=0.5u l=5u
X2527 vss.t331 vss.t323 vss.t328 vss.t267 sg13_hv_nmos ad=0.19p pd=1.38u as=0 ps=0 w=1u l=10u
X2528 vdd.t1294 d_ena.t9 inv_en_0.di vdd.t753 sg13_hv_pmos ad=0.51p pd=3.68u as=0.285p ps=1.88u w=1.5u l=0.45u
X2529 vdd.t109 vss.t2336 vdd.t75 vdd.t74 sg13_lv_pmos ad=0.34p pd=2.68u as=0 ps=0 w=1u l=1u
X2530 vss.t802 vss.t803 vss.t531 rhigh l=2.75u w=0.5u
X2531 vdd.t911 clk_noverlap_0.sg13cmos5l_dlygate4sd3_1_4.X a_9451_7241# vdd.t308 sg13_lv_pmos ad=0.1523p pd=1.38u as=0.1428p ps=1.52u w=0.42u l=0.13u
X2532 vss.t742 a_5176_30111# vss.t744 vss.t743 sg13_lv_nmos ad=95f pd=0.88u as=0 ps=0 w=0.5u l=3u
X2533 vss.t1838 vdd.t1744 vss.t1840 vss.t1839 sg13_lv_nmos ad=79.8f pd=0.8u as=0 ps=0 w=0.42u l=1u
X2534 vss.t1257 a_13189_30111# vss.t67 vss.t2136 sg13_lv_nmos ad=95f pd=0.88u as=0 ps=0 w=0.5u l=3u
X2535 a_522_4776# a_567_3378# vdd.t1031 vdd.t504 sg13_lv_pmos ad=0.34p pd=2.68u as=0.36237p ps=2.605u w=1u l=0.13u
X2536 vdd.t1229 a_5176_31469# vdd.t1228 vdd.t764 sg13_lv_pmos ad=1.19p pd=7.68u as=0 ps=0 w=3.5u l=2u
X2537 vss.t1654 vdd.t1789 vss.t1653 vss.t1643 sg13_lv_nmos ad=0.1428p pd=1.52u as=0 ps=0 w=0.42u l=1u
X2538 vdd.t874 sg13cmos5l_nand2_2_0.B.t3 sg13cmos5l_nor2_2_0.B.t3 vdd.t502 sg13_lv_pmos ad=0.3808p pd=2.92u as=0.2128p ps=1.5u w=1.12u l=0.13u
X2539 vdd.t1162 bias_gm_0.bias_trim_0.vz.t26 a_22252_4074# vdd.t384 sg13_lv_pmos ad=95f pd=0.88u as=95f ps=0.88u w=0.5u l=5u
X2540 vss.t675 quantizer2_lfsr_0.sg13cmos5l_nor2_1_1.B d_amp_s[1].t0 vss.t457 sg13_lv_nmos ad=0.2516p pd=2.16u as=0.1406p ps=1.12u w=0.74u l=0.13u
X2541 vdd.t1031 d_dith_en.t9 a_558_3110# vdd.t504 sg13_lv_pmos ad=0.36237p pd=2.605u as=79.8f ps=0.8u w=0.42u l=0.13u
X2542 a_22252_11246# bias_gm_0.bias_trim_0.vz.t50 vdd.t926 vdd.t572 sg13_lv_pmos ad=95f pd=0.88u as=95f ps=0.88u w=0.5u l=5u
X2543 sw_tgate_10.p.t9 d_qi.t9 sw_tgate_10.p.t8 vss.t1009 sg13_lv_nmos ad=0.19p pd=1.38u as=0 ps=0 w=1u l=1u
X2544 vss.t2004 vdd.t1706 vss.t2003 vss.t2002 sg13_lv_nmos ad=0.1428p pd=1.52u as=0 ps=0 w=0.42u l=1u
X2545 vdd.t191 vss.t2270 vdd.t146 vdd.t126 sg13_lv_pmos ad=0.19p pd=1.38u as=0 ps=0 w=1u l=1u
X2546 vss.t616 clk_noverlap_0.sg13cmos5l_dlygate4sd3_1_0.X a_5131_7241# vss.t885 sg13_lv_nmos ad=79.8f pd=0.8u as=0.1428p ps=1.52u w=0.42u l=0.13u
X2547 sw_tgate_12.m.t2 d_phi2.t6 xsc_vc1l_p.t5 vss.t201 sg13_lv_nmos ad=0.34p pd=2.68u as=0.19p ps=1.38u w=1u l=1u
X2548 vdd.t893 a_9721_7200# a_9833_7224# vdd.t308 sg13_lv_pmos ad=0.2254p pd=1.53u as=0.34p ps=2.68u w=1u l=0.5u
X2549 vss.t1145 a_2034_3670# a_2034_4053# vss.t1144 sg13_lv_nmos ad=0.1406p pd=1.12u as=0.2516p ps=2.16u w=0.74u l=0.13u
X2550 xsc_xcmfb1_vsw_cm_n.t7 sw_tgate_cmfb2_3.gb.t3 vo_n.t8 vdd.t678 sg13_lv_pmos ad=0.285p pd=1.88u as=0.285p ps=1.88u w=1.5u l=1u
X2551 a_9357_11104.t13 sg13cmos5l_and2_2_1.X.t2 vss.t964 vss.t387 sg13_lv_nmos ad=0.76p pd=4.38u as=0.76p ps=4.38u w=4u l=0.5u
X2552 vss.t468 dsm2_io_vcmg_0.di_vcm_ext_b.t3 dsm2_io_vcmg_0.di_vcm_ext.t0 vss.t467 sg13_lv_nmos ad=0.2516p pd=2.16u as=0.2516p ps=2.16u w=0.74u l=0.13u
X2553 xsc_vc1r_n.t7 d_phi1.t9 vcm_esd.t11 vss.t901 sg13_lv_nmos ad=0.19p pd=1.38u as=0.19p ps=1.38u w=1u l=1u
X2554 vdd.t269 vss.t2273 vdd.t268 vdd.t126 sg13_lv_pmos ad=0.34p pd=2.68u as=0 ps=0 w=1u l=1u
X2555 vss.t1852 vdd.t1741 vss.t1853 vss.t1839 sg13_lv_nmos ad=79.8f pd=0.8u as=0 ps=0 w=0.42u l=1u
X2556 a_9357_11104.t14 sg13cmos5l_and2_2_1.X.t2 vss.t966 vss.t391 sg13_lv_nmos ad=0.76p pd=4.38u as=0.76p ps=4.38u w=4u l=0.5u
X2557 vss.t369 vss.t366 vss.t368 vss.t367 sg13_lv_nmos ad=0.17p pd=1.68u as=0 ps=0 w=0.5u l=0.5u
X2558 xsc_xcmfb1_vsw_cm_p.t11 d_phi1.t12 xsc_xcmfb1_vsw_cm_p.t10 vdd.t900 sg13_lv_pmos ad=0.285p pd=1.88u as=0 ps=0 w=1.5u l=1u
X2559 d_dith[2].t0 a_2034_1466# vss.t239 vss.t238 sg13_lv_nmos ad=0.2886p pd=2.26u as=0.14875p ps=1.16u w=0.74u l=0.13u
X2560 vss.t12 d_ena.t3 a_10878_6484# vss.t1434 sg13_lv_nmos ad=0.1331p pd=1.12u as=0.1216p ps=1.02u w=0.64u l=0.13u
X2561 vss.t1989 vdd.t1709 vss.t1988 vss.t1987 sg13_lv_nmos ad=0.1428p pd=1.52u as=0 ps=0 w=0.42u l=1u
X2562 vss.t386 vss.t384 sg13cmos5l_inv_1_2.A.t1 vss.t385 sg13_lv_nmos ad=95f pd=0.88u as=95f ps=0.88u w=0.5u l=0.5u
X2563 a_22252_8246# bias_gm_0.bias_trim_0.vz.t45 vdd.t1012 vdd.t566 sg13_lv_pmos ad=95f pd=0.88u as=95f ps=0.88u w=0.5u l=5u
X2564 vdd.t952 bias_gm_0.bias_trim_0.vz.t46 a_22252_7946# vdd.t384 sg13_lv_pmos ad=95f pd=0.88u as=95f ps=0.88u w=0.5u l=5u
X2565 a_2049_12741# d_qclk.t17 vdd.t507 vdd.t507 sg13_lv_pmos ad=0.4088p pd=2.97u as=1.87952p ps=12.085u w=1.12u l=0.13u
X2566 vdd.t768 a_5176_31117# vdd.t766 vdd.t764 sg13_lv_pmos ad=0.19p pd=1.38u as=0 ps=0 w=1u l=2u
X2567 vdd.t669 d_dith_en.t14 a_1367_6533# vdd.t504 sg13_lv_pmos ad=0.36237p pd=2.605u as=79.8f ps=0.8u w=0.42u l=0.13u
X2568 a_9533_11104.t8 sg13cmos5l_inv_1_14.A.t10 sg13cmos5l_inv_1_2.A.t0 vss.t28 sg13_lv_nmos ad=95f pd=0.88u as=95f ps=0.88u w=0.5u l=0.5u
X2569 vss.t1502 vdd.t1823 vss.t1501 vss.t1500 sg13_lv_nmos ad=0.1428p pd=1.52u as=0 ps=0 w=0.42u l=1u
X2570 w_9407_29481.t3 xsc_vvg_n.t6 a_6452_29739.t4 w_9407_29481.t0 sg13_lv_pmos ad=0.38p pd=2.38u as=0.38p ps=2.38u w=2u l=1u
X2571 vss.t69 sw_tgate_cmfb2_1.p.t9 vss.t125 vss.t113 sg13_lv_nmos ad=0.17p pd=1.68u as=0 ps=0 w=0.5u l=3u
X2572 xsc_xcmfb1_vsw_cm_n.t1 sw_tgate_cmfb2_1.gb.t3 xsc_xcmfb1_vsw_cm_n.t5 vss.t595 sg13_lv_nmos ad=95f pd=0.88u as=0 ps=0 w=0.5u l=1u
X2573 vdd.t1050 d_qi_b.t8 vdd.t1037 vss.t1033 sg13_lv_nmos ad=0.34p pd=2.68u as=0 ps=0 w=1u l=1u
X2574 a_522_10294# a_537_8997# a_558_10062# vss.t931 sg13_lv_nmos ad=0.12665p pd=1.145u as=0.1428p ps=1.52u w=0.42u l=0.13u
X2575 vdd.t1055 quantizer2_lfsr_0.sg13cmos5l_dfrbpq_1_6.Q a_2038_15217# vdd.t507 sg13_lv_pmos ad=0.2891p pd=1.695u as=0.1596p ps=1.22u w=0.84u l=0.13u
X2576 sg13cmos5l_inv_1_14.A.t6 vdd.t1309 vdd.t1345 vdd.t863 sg13_lv_pmos ad=0.285p pd=1.88u as=0.285p ps=1.88u w=1.5u l=0.5u
X2577 vss.t337 vss.t335 vss.t336 vss.t262 sg13_lv_nmos ad=0.17p pd=1.68u as=0 ps=0 w=0.5u l=10u
X2578 vss.t1792 vdd.t1755 vss.t1793 vss.t1785 sg13_lv_nmos ad=79.8f pd=0.8u as=0 ps=0 w=0.42u l=1u
X2579 a_19984_17824# a_19984_17824# a_20260_17236# vss.t265 sg13_lv_nmos ad=95f pd=0.88u as=95f ps=0.88u w=0.5u l=10u
X2580 vcm_esd.t3 sw_tgate_cmfb2_1.gb.t4 vcm_esd.t2 vss.t1222 sg13_lv_nmos ad=95f pd=0.88u as=0 ps=0 w=0.5u l=1u
X2581 vdd.t398 vss.t2296 vdd.t397 vdd.t184 sg13_lv_pmos ad=0.19p pd=1.38u as=0 ps=0 w=1u l=1u
X2582 vdd.t1133 dsm2_osc_0.sg13cmos5l_dfrbp_1_0.RESET_B.t9 a_22644_2344# vdd.t514 sg13_lv_pmos ad=0.17p pd=1.68u as=95f ps=0.88u w=0.5u l=0.13u
X2583 a_9533_11104.t6 xq_vg_q_2_.t3 a_9357_11104.t4 vss.t382 sg13_lv_nmos ad=0.285p pd=1.88u as=0.285p ps=1.88u w=1.5u l=0.5u
X2584 vss.t697 a_2034_11446# a_2034_11829# vss.t696 sg13_lv_nmos ad=0.1406p pd=1.12u as=0.2516p ps=2.16u w=0.74u l=0.13u
X2585 xsc_xcmfb1_vsw_vbias.t3 d_phi2.t8 sw_tgate_cmfb2_1.p.t5 vss.t197 sg13_lv_nmos ad=95f pd=0.88u as=95f ps=0.88u w=0.5u l=1u
X2586 w_9407_29481.t12 a_5176_31469# a_7224_31505# vdd.t764 sg13_lv_pmos ad=1.19p pd=7.68u as=0.665p ps=3.88u w=3.5u l=2u
X2587 vss.t737 a_5176_30111# vss.t740 vss.t739 sg13_lv_nmos ad=0.36625p pd=1.965u as=0 ps=0 w=0.5u l=3u
X2588 vss.t1462 vdd.t1831 vss.t1464 vss.t1463 sg13_lv_nmos ad=79.8f pd=0.8u as=0 ps=0 w=0.42u l=1u
X2589 vss.t1160 dsm2_io_0.sg13cmos5l_inv_1_6.A d_rst_b.t0 vss.t467 sg13_lv_nmos ad=0.2516p pd=2.16u as=0.2516p ps=2.16u w=0.74u l=0.13u
X2590 xvcm_vcf_t.t0 d_vcm_phi1_b.t2 vdd.t757 vdd.t756 sg13_hv_pmos ad=1.36p pd=8.68u as=1.36p ps=8.68u w=4u l=0.45u
X2591 a_1284_7983# a_1286_6839# a_1681_7153# vss.t81 sg13_lv_nmos ad=0.12665p pd=1.145u as=0.1428p ps=1.52u w=0.42u l=0.13u
X2592 vss.t1677 vdd.t1783 vss.t1676 vss.t1660 sg13_lv_nmos ad=0.1428p pd=1.52u as=0 ps=0 w=0.42u l=1u
X2593 d_amp_s[2].t1 quantizer2_lfsr_0.di_dith_amp[0].t3 a_2368_16106# vdd.t507 sg13_lv_pmos ad=0.3808p pd=2.92u as=0.1176p ps=1.33u w=1.12u l=0.13u
X2594 vdd.t545 dsm2_osc_0.sg13cmos5l_dfrbp_1_0.RESET_B.t8 a_21681_1704# vdd.t515 sg13_lv_pmos ad=0.1918p pd=1.5u as=0.1596p ps=1.22u w=0.84u l=0.13u
X2595 vdd.t83 vss.t2183 vdd.t370 vdd.t82 sg13_lv_pmos ad=0.34p pd=2.68u as=0 ps=0 w=1u l=1u
X2596 vdd.t816 a_5176_31117# vdd.t815 vdd.t764 sg13_lv_pmos ad=0.34p pd=2.68u as=0 ps=0 w=1u l=2u
X2597 vss.t1714 vdd.t1774 vss.t1712 vss.t1713 sg13_lv_nmos ad=79.8f pd=0.8u as=0 ps=0 w=0.42u l=1u
X2598 a_20672_19900# a_24258_20040# vss.t207 rhigh l=17.5u w=0.5u
X2599 a_537_14181# d_qclk.t20 vdd.t511 vdd.t504 sg13_lv_pmos ad=0.4088p pd=2.97u as=1.1847p ps=7.385u w=1.12u l=0.13u
X2600 vdd.t956 vdd.t1457 vdd.t1458 vdd.t1173 sg13_lv_pmos ad=95f pd=0.88u as=0 ps=0 w=0.5u l=5u
X2601 vss.t74 xsc_vfb.t11 a_6452_29739.t7 vss.t73 sg13_lv_nmos ad=95f pd=0.88u as=95f ps=0.88u w=0.5u l=3u
X2602 a_20260_17236# vss.t359 a_20260_17236# vss.t269 sg13_lv_nmos ad=95f pd=0.88u as=0 ps=0 w=0.5u l=10u
X2603 vss.t651 a_2034_11282# a_2070_11214# vss.t650 sg13_lv_nmos ad=79.8f pd=0.8u as=0.1428p ps=1.52u w=0.42u l=0.13u
X2604 vdd.t1648 vss.t2415 vdd.t1647 vdd.t0 sg13_lv_pmos ad=0.34p pd=2.68u as=0 ps=0 w=1u l=1u
X2605 vss.t140 clk_noverlap_0.sg13cmos5l_inv_1_1.A clk_noverlap_0.sg13cmos5l_inv_1_1.Y vss.t139 sg13_lv_nmos ad=0.2516p pd=2.16u as=0.2516p ps=2.16u w=0.74u l=0.13u
X2606 vss.t1670 vdd.t1785 vss.t1668 vss.t1669 sg13_lv_nmos ad=79.8f pd=0.8u as=0 ps=0 w=0.42u l=1u
X2607 a_2049_12741# d_qclk.t17 vss.t823 vss.t1400 sg13_lv_nmos ad=0.2516p pd=2.16u as=2.50852p ps=15.49u w=0.74u l=0.13u
X2608 vss.t1739 vdd.t1768 vss.t1737 vss.t1729 sg13_lv_nmos ad=79.8f pd=0.8u as=0 ps=0 w=0.42u l=1u
X2609 vdd.t988 vdd.t1583 vdd.t1584 vdd.t1173 sg13_lv_pmos ad=95f pd=0.88u as=0 ps=0 w=0.5u l=5u
X2610 d_amp_s[3].t0 quantizer2_lfsr_0.sg13cmos5l_nor2_1_0.A vss.t1278 vss.t664 sg13_lv_nmos ad=0.1406p pd=1.12u as=0.2516p ps=2.16u w=0.74u l=0.13u
X2611 vss.t787 a_5176_30111# vss.t786 vss.t110 sg13_lv_nmos ad=0.17p pd=1.68u as=0 ps=0 w=0.5u l=3u
X2612 a_1367_14309# quantizer2_lfsr_0.sg13cmos5l_dfrbpq_1_13.D.t2 vdd.t1193 vdd.t504 sg13_lv_pmos ad=79.8f pd=0.8u as=0.1428p ps=1.52u w=0.42u l=0.13u
X2613 vss.t514 d_dith[0].t2 a_13594_16020# vss.t513 sg13_lv_nmos ad=0.2516p pd=2.16u as=0.1406p ps=1.12u w=0.74u l=0.13u
X2614 a_23328_5574# dsm2_io_0.do_trim_b[0].t2 bias_gm_0.bias_trim_0.iout vdd.t573 sg13_lv_pmos ad=95f pd=0.88u as=95f ps=0.88u w=0.5u l=5u
X2615 a_10620_7548# clk_noverlap_0.sg13cmos5l_inv_1_5.Y vss.t493 vss.t619 sg13_lv_nmos ad=0.1216p pd=1.02u as=0.1331p ps=1.12u w=0.64u l=0.13u
X2616 a_4362_8188.t1 sg13cmos5l_inv_1_9.Y.t2 xq_dith_v_bp.t3 vdd.t623 sg13_lv_pmos ad=0.665p pd=3.88u as=0.665p ps=3.88u w=3.5u l=0.13u
X2617 vss.t1927 vdd.t1723 vss.t1929 vss.t1928 sg13_lv_nmos ad=79.8f pd=0.8u as=0 ps=0 w=0.42u l=1u
X2618 vdd.t334 vss.t2317 vdd.t490 vdd.t105 sg13_lv_pmos ad=0.34p pd=2.68u as=0 ps=0 w=1u l=1u
X2619 vss.t131 a_1407_7538# a_1681_7153# vss.t130 sg13_lv_nmos ad=79.8f pd=0.8u as=0.1428p ps=1.52u w=0.42u l=0.13u
X2620 a_1284_2799# a_1286_1655# a_1324_804# vdd.t504 sg13_lv_pmos ad=0.2048p pd=1.63u as=0.34p ps=2.68u w=1u l=0.13u
X2621 vss.t2044 vdd.t1698 vss.t2046 vss.t2045 sg13_lv_nmos ad=79.8f pd=0.8u as=0 ps=0 w=0.42u l=1u
X2622 vdd.t1112 di_dith_amp[1] dsm2_io_0.sg13cmos5l_inv_1_3.A vdd.t25 sg13_hv_pmos ad=0.17p pd=1.68u as=0.17p ps=1.68u w=0.5u l=1u
X2623 vss.t1164 di_osc_en.t0 dsm2_osc_0.dsm2_io_rx_0.di_b.t0 vss.t1163 sg13_hv_nmos ad=0.34p pd=2.68u as=0.34p ps=2.68u w=1u l=0.45u
X2624 a_12075_9488.t1 a_13211_9308.t1 vss.t609 rhigh l=4.08u w=0.5u
X2625 a_537_1221# d_qclk.t4 vdd.t511 vdd.t504 sg13_lv_pmos ad=0.4088p pd=2.97u as=1.1847p ps=7.385u w=1.12u l=0.13u
X2626 a_537_6405# d_qclk.t10 vss.t143 vss.t1407 sg13_lv_nmos ad=0.2516p pd=2.16u as=3.67165p ps=23.42u w=0.74u l=0.13u
X2627 a_567_13746# a_537_14181# a_558_13478# vss.t1177 sg13_lv_nmos ad=79.8f pd=0.8u as=0.1296p ps=1.52u w=0.42u l=0.13u
X2628 vss.t235 a_522_2518# a_522_2901# vss.t552 sg13_lv_nmos ad=0.1406p pd=1.12u as=0.2516p ps=2.16u w=0.74u l=0.13u
X2629 a_1407_7538# d_dith_en.t17 vdd.t511 vdd.t504 sg13_lv_pmos ad=79.8f pd=0.8u as=1.1847p ps=7.385u w=0.42u l=0.13u
X2630 vdd.t598 a_1284_2799# a_1284_2901# vdd.t504 sg13_lv_pmos ad=0.2128p pd=1.5u as=0.3864p ps=2.93u w=1.12u l=0.13u
X2631 d_phi2.t1 clk_noverlap_0.do_phi2_b vdd.t622 vdd.t308 sg13_lv_pmos ad=0.3808p pd=2.92u as=0.3808p ps=2.92u w=1.12u l=0.13u
X2632 vdd.t794 a_5176_31117# vdd.t792 vdd.t764 sg13_lv_pmos ad=0.19p pd=1.38u as=0 ps=0 w=1u l=2u
X2633 vss.t409 vss.t397 sg13cmos5l_inv_1_14.A.t2 vss.t410 sg13_lv_nmos ad=95f pd=0.88u as=95f ps=0.88u w=0.5u l=0.5u
X2634 vdd.t983 vdd.t1474 vdd.t1475 vdd.t570 sg13_lv_pmos ad=95f pd=0.88u as=0 ps=0 w=0.5u l=5u
X2635 vdd.t1431 vdd.t1423 vdd.t1433 vdd.t573 sg13_lv_pmos ad=95f pd=0.88u as=0 ps=0 w=0.5u l=5u
X2636 vdd.t489 vss.t2225 vdd.t177 vdd.t176 sg13_lv_pmos ad=0.34p pd=2.68u as=0 ps=0 w=1u l=1u
X2637 vss.t1994 vdd.t1708 vss.t1993 vss.t1992 sg13_lv_nmos ad=0.1428p pd=1.52u as=0 ps=0 w=0.42u l=1u
X2638 sg13cmos5l_or2_1_0.X.t1 a_8208_15626# vdd.t521 vdd.t502 sg13_lv_pmos ad=0.3976p pd=2.95u as=0.2226p ps=1.535u w=1.12u l=0.13u
X2639 a_522_4776# a_567_3378# vss.t997 vss.t996 sg13_lv_nmos ad=0.2516p pd=2.16u as=0.1626p ps=1.415u w=0.74u l=0.13u
X2640 vss.t1226 vss.t1227 vss.t212 rhigh l=10.975u w=0.5u
X2641 vdd.t360 vss.t2246 vdd.t221 vdd.t79 sg13_lv_pmos ad=0.19p pd=1.38u as=0 ps=0 w=1u l=1u
X2642 a_15693_7164# clk_noverlap_0.sg13cmos5l_dlygate4sd3_1_10.A vdd.t541 vdd.t308 sg13_lv_pmos ad=0.1428p pd=1.52u as=0.1523p ps=1.38u w=0.42u l=0.13u
X2643 vdd.t507 a_2034_11282# a_2385_11193# vdd.t507 sg13_lv_pmos ad=1.99007p pd=12.8u as=93.45f ps=0.865u w=0.42u l=0.13u
X2644 a_24540_20320# a_28126_20180# vss.t34 rhigh l=17.5u w=0.5u
X2645 a_13211_9308.t3 d_amp_s[2].t2 a_6249_9100.t6 vss.t667 sg13_lv_nmos ad=0.17p pd=1.68u as=95f ps=0.88u w=0.5u l=0.13u
X2646 a_949_8937# a_522_9960# vdd.t742 vdd.t504 sg13_lv_pmos ad=63f pd=0.72u as=0.1563p ps=1.22u w=0.42u l=0.13u
X2647 vcm_esd.t16 vcm vss.t260 rppd l=2u w=1u
X2648 quantizer2_lfsr_0.sg13cmos5l_dfrbpq_1_3.Q a_2034_6645# vdd.t508 vdd.t507 sg13_lv_pmos ad=0.3808p pd=2.92u as=0.2128p ps=1.5u w=1.12u l=0.13u
X2649 vdd.t1013 bias_gm_0.bias_trim_0.vz.t45 a_22252_8246# vdd.t384 sg13_lv_pmos ad=95f pd=0.88u as=95f ps=0.88u w=0.5u l=5u
X2650 vdd.t852 a_5176_31117# vdd.t850 vdd.t764 sg13_lv_pmos ad=0.19p pd=1.38u as=0 ps=0 w=1u l=2u
X2651 vss.t1360 a_20328_23820# vss.t1361 vss.t267 sg13_hv_nmos ad=1.9p pd=10.38u as=0 ps=0 w=10u l=10u
X2652 vss.t1326 vss.t1327 vss.t39 rhigh l=2.75u w=0.5u
X2653 xsc_vc1l_p.t6 sw_tgate_9.gb.t4 xsc_vc1l_p.t7 vss.t977 sg13_lv_nmos ad=0.19p pd=1.38u as=0 ps=0 w=1u l=1u
X2654 vss.t883 vss.t884 vss.t6 rhigh l=10.05u w=0.5u
X2655 a_558_8294# a_533_9920# a_567_8562# vdd.t504 sg13_lv_pmos ad=0.1428p pd=1.52u as=79.8f ps=0.8u w=0.42u l=0.13u
X2656 vdd.t265 vss.t2249 vdd.t264 vdd.t79 sg13_lv_pmos ad=0.34p pd=2.68u as=0 ps=0 w=1u l=1u
X2657 a_10132_15186# sg13cmos5l_nor2_2_0.Y vdd.t519 vdd.t502 sg13_lv_pmos ad=0.4032p pd=2.96u as=0.2128p ps=1.5u w=1.12u l=0.13u
X2658 vss.t1944 vdd.t1719 vss.t1943 vss.t1942 sg13_lv_nmos ad=0.1428p pd=1.52u as=0 ps=0 w=0.42u l=1u
X2659 vdd.t1049 d_qi_b.t7 sw_tgate_6.p.t6 vdd.t562 sg13_lv_pmos ad=0.68p pd=4.68u as=0.38p ps=2.38u w=2u l=1u
X2660 a_2034_8520# a_2045_8480# a_2034_8854# vss.t2100 sg13_lv_nmos ad=0.3473p pd=2.71u as=0.12665p ps=1.145u w=0.74u l=0.13u
X2661 vss.t1086 a_522_12722# a_558_12654# vss.t1248 sg13_lv_nmos ad=79.8f pd=0.8u as=0.1428p ps=1.52u w=0.42u l=0.13u
X2662 vdd.t1415 vdd.t1413 vdd.t925 vdd.t1287 sg13_lv_pmos ad=0.17p pd=1.68u as=0 ps=0 w=0.5u l=5u
X2663 xq_vg_q_0_.t2 sg13cmos5l_inv_1_13.A.t3 a_5892_8400.t10 vdd.t580 sg13_lv_pmos ad=95f pd=0.88u as=0.17p ps=1.68u w=0.5u l=0.13u
X2664 vdd.t770 a_5176_31117# vdd.t768 vdd.t764 sg13_lv_pmos ad=0.465p pd=1.93u as=0 ps=0 w=1u l=2u
X2665 a_13189_30111# sw_tgate_cmfb2_1.p.t13 vss.t67 vss.t66 sg13_lv_nmos ad=95f pd=0.88u as=95f ps=0.88u w=0.5u l=3u
X2666 vss.t1272 vss.t1273 vss.t39 rhigh l=2.75u w=0.5u
X2667 sg13cmos5l_inv_1_2.A.t8 sg13cmos5l_inv_1_14.A.t10 vdd.t1190 vdd.t863 sg13_lv_pmos ad=0.285p pd=1.88u as=0.285p ps=1.88u w=1.5u l=0.5u
X2668 vss.t1355 a_20328_23820# vss.t1356 vss.t267 sg13_hv_nmos ad=1.9p pd=10.38u as=0 ps=0 w=10u l=10u
X2669 a_2070_4262# quantizer2_lfsr_0.sg13cmos5l_dfrbpq_1_2.Q.t3 vdd.t957 vdd.t507 sg13_lv_pmos ad=79.8f pd=0.8u as=0.1428p ps=1.52u w=0.42u l=0.13u
X2670 dsm2_osc_0.sg13cmos5l_dfrbp_1_0.CLK dsm2_osc_0.sg13cmos5l_inv_1_3.A vdd.t1639 vdd.t515 sg13_lv_pmos ad=0.3808p pd=2.92u as=0.3808p ps=2.92u w=1.12u l=0.13u
X2671 vdd.t660 a_8768_15909# sg13cmos5l_and2_1_4.X vdd.t502 sg13_lv_pmos ad=0.1918p pd=1.5u as=0.3808p ps=2.92u w=1.12u l=0.13u
X2672 vdd.t670 a_13569_7467# clk_noverlap_0.sg13cmos5l_dlygate4sd3_1_7.X vdd.t308 sg13_lv_pmos ad=0.2254p pd=1.53u as=0.4256p ps=3u w=1.12u l=0.13u
X2673 vss.t1823 vdd.t1748 vss.t1825 vss.t1824 sg13_lv_nmos ad=79.8f pd=0.8u as=0 ps=0 w=0.42u l=1u
X2674 vss.t1070 d_dith_en.t32 a_1758_13572# vss.t1069 sg13_lv_nmos ad=0.1626p pd=1.415u as=60.89999f ps=0.71u w=0.42u l=0.13u
X2675 vdd.t541 a_15693_7164# a_15412_7466# vdd.t308 sg13_lv_pmos ad=0.1523p pd=1.38u as=0.34p ps=2.68u w=1u l=0.5u
X2676 vdd.t494 vss.t2214 vdd.t434 vdd.t181 sg13_lv_pmos ad=0.19p pd=1.38u as=0 ps=0 w=1u l=1u
X2677 vss.t183 d_phi2.t4 clk_noverlap_0.sg13cmos5l_inv_1_6.A vss.t182 sg13_lv_nmos ad=0.2516p pd=2.16u as=0.2516p ps=2.16u w=0.74u l=0.13u
X2678 vo_p.t5 vdd.t1297 vo_p.t4 vdd.t900 sg13_lv_pmos ad=0.51p pd=3.68u as=0 ps=0 w=1.5u l=1u
X2679 inv_en_0.di_b.t1 inv_en_0.di vdd.t754 vdd.t753 sg13_hv_pmos ad=0.285p pd=1.88u as=0.51p ps=3.68u w=1.5u l=0.45u
X2680 vdd.t1366 vdd.t1360 vdd.t1368 vdd.t573 sg13_lv_pmos ad=95f pd=0.88u as=0 ps=0 w=0.5u l=5u
X2681 vss.t1684 vdd.t1781 vss.t1683 vss.t1671 sg13_lv_nmos ad=0.1428p pd=1.52u as=0 ps=0 w=0.42u l=1u
X2682 quantizer2_lfsr_0.sg13cmos5l_dfrbpq_1_15.D a_1284_8085# vss.t481 vss.t611 sg13_lv_nmos ad=0.2516p pd=2.16u as=0.1406p ps=1.12u w=0.74u l=0.13u
X2683 quantizer2_lfsr_0.sg13cmos5l_dfrbpq_1_1.D.t1 a_522_13269# vdd.t922 vdd.t504 sg13_lv_pmos ad=0.3808p pd=2.92u as=0.2128p ps=1.5u w=1.12u l=0.13u
X2684 vdd.t771 a_5176_31117# vdd.t772 vdd.t764 sg13_lv_pmos ad=0.19p pd=1.38u as=0 ps=0 w=1u l=2u
X2685 a_19984_17824# bias_gm_0.bias_trim_0.vz.t50 vdd.t928 vdd.t287 sg13_lv_pmos ad=95f pd=0.88u as=95f ps=0.88u w=0.5u l=5u
X2686 vdd.t932 bias_gm_0.bias_trim_0.vz.t53 a_22252_11246# vdd.t384 sg13_lv_pmos ad=95f pd=0.88u as=95f ps=0.88u w=0.5u l=5u
X2687 vdd.t959 d_dith_en.t20 a_1288_8554# vdd.t504 sg13_lv_pmos ad=0.1563p pd=1.22u as=0.147p ps=1.54u w=0.42u l=0.13u
X2688 a_1288_778# a_1286_1655# a_1367_1161# vdd.t504 sg13_lv_pmos ad=79.8f pd=0.8u as=63f ps=0.72u w=0.42u l=0.13u
X2689 vdd.t481 vss.t2217 vdd.t182 vdd.t181 sg13_lv_pmos ad=0.34p pd=2.68u as=0 ps=0 w=1u l=1u
X2690 vdd.t980 bias_gm_0.bias_trim_0.vz.t29 a_23328_5574# vdd.t287 sg13_lv_pmos ad=95f pd=0.88u as=95f ps=0.88u w=0.5u l=5u
X2691 a_22252_7946# dsm2_io_0.do_trim_b[3].t3 ibias_200n.t0 vdd.t572 sg13_lv_pmos ad=95f pd=0.88u as=95f ps=0.88u w=0.5u l=5u
X2692 a_2049_7557# d_qclk.t11 vss.t224 vss.t1394 sg13_lv_nmos ad=0.2516p pd=2.16u as=2.50852p ps=15.49u w=0.74u l=0.13u
X2693 vss.t2065 vdd.t1693 vss.t2064 vss.t2063 sg13_hv_nmos ad=1.36p pd=8.68u as=0 ps=0 w=4u l=10u
X2694 a_24214_15146# a_20138_14766# a_22138_15146# vdd.t898 sg13_lv_pmos ad=0.17p pd=1.68u as=95f ps=0.88u w=0.5u l=10u
X2695 a_2079_1938# a_2049_2373# a_2461_2313# vdd.t507 sg13_lv_pmos ad=79.8f pd=0.8u as=63f ps=0.72u w=0.42u l=0.13u
X2696 a_21276_2052# dsm2_osc_0.dsm2_io_rx_0.di_b.t6 vss.t543 vss.t542 sg13_lv_nmos ad=95f pd=0.88u as=0.17p ps=1.68u w=0.5u l=0.13u
X2697 xq_dith_v_bq.t13 sg13cmos5l_inv_1_3.A.t3 vo_p.t16 vss.t1238 sg13_lv_nmos ad=1.19p pd=7.68u as=0.665p ps=3.88u w=3.5u l=0.13u
X2698 vss.t1999 vdd.t1707 vss.t1998 vss.t1997 sg13_lv_nmos ad=0.1428p pd=1.52u as=0 ps=0 w=0.42u l=1u
X2699 do_q_b.t0 sg13cmos5l_inv_1_12.Y vdd.t661 vdd.t502 sg13_lv_pmos ad=0.2128p pd=1.5u as=0.3864p ps=2.93u w=1.12u l=0.13u
X2700 vss.t528 vss.t529 vss.t527 rhigh l=9.28u w=0.5u
X2701 a_28746_14846# a_19964_18216# a_26670_14846# vdd.t1128 sg13_lv_pmos ad=0.17p pd=1.68u as=95f ps=0.88u w=0.5u l=10u
X2702 vo_n.t6 d_phi1.t8 xsc_xcmfb1_vsw_cm_n.t10 vss.t189 sg13_lv_nmos ad=95f pd=0.88u as=95f ps=0.88u w=0.5u l=1u
X2703 a_1288_5962# a_1286_6839# a_1367_6533# vss.t84 sg13_lv_nmos ad=79.8f pd=0.8u as=0.1296p ps=1.52u w=0.42u l=0.13u
X2704 a_20260_17236# a_24258_19480# vss.t207 rhigh l=17.5u w=0.5u
X2705 quantizer2_lfsr_0.sg13cmos5l_dfrbpq_1_1.Q a_522_15861# vss.t1209 vss.t1380 sg13_lv_nmos ad=0.2516p pd=2.16u as=0.1406p ps=1.12u w=0.74u l=0.13u
X2706 vss.t936 clk_noverlap_0.sg13cmos5l_dlygate4sd3_1_4.X a_9451_7241# vss.t935 sg13_lv_nmos ad=79.8f pd=0.8u as=0.1428p ps=1.52u w=0.42u l=0.13u
X2707 vss.t1462 vdd.t1831 vss.t1461 vss.t1460 sg13_lv_nmos ad=0.1428p pd=1.52u as=0 ps=0 w=0.42u l=1u
X2708 a_1288_13738# a_1286_14615# a_1367_14309# vss.t48 sg13_lv_nmos ad=79.8f pd=0.8u as=0.1296p ps=1.52u w=0.42u l=0.13u
X2709 a_9357_11104.t11 sg13cmos5l_and2_2_1.X.t2 vss.t970 vss.t405 sg13_lv_nmos ad=0.76p pd=4.38u as=0.76p ps=4.38u w=4u l=0.5u
X2710 a_1284_16630# quantizer2_lfsr_0.sg13cmos5l_dfrbpq_1_13.Q a_1668_16187# vss.t952 sg13_lv_nmos ad=0.2176p pd=1.96u as=78.39999f ps=0.885u w=0.64u l=0.13u
X2711 vdd.t1475 vdd.t1474 vdd.t1477 vdd.t1173 sg13_lv_pmos ad=95f pd=0.88u as=0 ps=0 w=0.5u l=5u
X2712 vss.t1843 vdd.t1743 vss.t1842 vss.t1841 sg13_lv_nmos ad=0.1428p pd=1.52u as=0 ps=0 w=0.42u l=1u
X2713 a_522_7368# a_567_5970# vdd.t913 vdd.t504 sg13_lv_pmos ad=0.34p pd=2.68u as=0.36237p ps=2.605u w=1u l=0.13u
X2714 vss.t1935 vdd.t1721 vss.t1936 vss.t1928 sg13_lv_nmos ad=79.8f pd=0.8u as=0 ps=0 w=0.42u l=1u
X2715 a_20672_21020# a_24258_21160# vss.t207 rhigh l=17.5u w=0.5u
X2716 vss.t1981 vdd.t1711 vss.t1983 vss.t1982 sg13_lv_nmos ad=79.8f pd=0.8u as=0 ps=0 w=0.42u l=1u
X2717 vdd.t936 vdd.t1381 vdd.t1382 vdd.t1173 sg13_lv_pmos ad=95f pd=0.88u as=0 ps=0 w=0.5u l=5u
X2718 vss.t678 a_13965_7164# a_13684_7466# vss.t494 sg13_lv_nmos ad=79.8f pd=0.8u as=0.1428p ps=1.52u w=0.42u l=0.5u
X2719 vdd.t913 d_dith_en.t15 a_558_5702# vdd.t504 sg13_lv_pmos ad=0.36237p pd=2.605u as=79.8f ps=0.8u w=0.42u l=0.13u
X2720 vss.t396 vss.t384 vss.t393 vss.t394 sg13_lv_nmos ad=95f pd=0.88u as=0 ps=0 w=0.5u l=0.5u
X2721 a_6638_31505# a_5176_31117# vdd.t795 vdd.t764 sg13_lv_pmos ad=0.34p pd=2.68u as=0.34p ps=2.68u w=1u l=2u
X2722 vss.t740 a_5176_30111# vss.t742 vss.t741 sg13_lv_nmos ad=95f pd=0.88u as=0 ps=0 w=0.5u l=3u
X2723 a_22252_5274# bias_gm_0.bias_trim_0.vz.t22 vdd.t733 vdd.t572 sg13_lv_pmos ad=95f pd=0.88u as=95f ps=0.88u w=0.5u l=5u
X2724 vss.t521 a_2049_2373# a_2045_3296# vss.t520 sg13_lv_nmos ad=2.71757p pd=16.785u as=0.2516p ps=2.16u w=0.74u l=0.13u
X2725 vdd.t632 a_12237_7164# a_11956_7466# vdd.t308 sg13_lv_pmos ad=0.1523p pd=1.38u as=0.34p ps=2.68u w=1u l=0.5u
X2726 dsm2_osc_0.sg13cmos5l_inv_1_2.Y dsm2_osc_0.sg13cmos5l_inv_1_2.A vss.t1418 vss.t1417 sg13_lv_nmos ad=0.2516p pd=2.16u as=0.2516p ps=2.16u w=0.74u l=0.13u
X2727 vdd.t206 vss.t2327 vdd.t311 vdd.t71 sg13_lv_pmos ad=0.19p pd=1.38u as=0 ps=0 w=1u l=1u
X2728 a_1367_11717# a_1322_11954# a_1288_11146# vdd.t504 sg13_lv_pmos ad=0.1428p pd=1.52u as=79.8f ps=0.8u w=0.42u l=0.13u
X2729 a_5892_8400.t13 d_amp_s_b[0].t3 a_5798_8400.t3 vdd.t658 sg13_lv_pmos ad=95f pd=0.88u as=0.17p ps=1.68u w=0.5u l=0.13u
X2730 sg13cmos5l_inv_1_14.A.t8 sg13cmos5l_inv_1_2.A.t10 vdd.t866 vdd.t863 sg13_lv_pmos ad=0.285p pd=1.88u as=0.285p ps=1.88u w=1.5u l=0.5u
X2731 vdd.t134 vss.t2266 vdd.t133 vdd.t68 sg13_lv_pmos ad=0.19p pd=1.38u as=0 ps=0 w=1u l=1u
X2732 vss.t2034 vdd.t1700 vss.t2036 vss.t2035 sg13_lv_nmos ad=79.8f pd=0.8u as=0 ps=0 w=0.42u l=1u
X2733 vdd.t1347 vdd.t1346 vdd.t1351 vdd.t863 sg13_lv_pmos ad=0.285p pd=1.88u as=0 ps=0 w=1.5u l=0.5u
X2734 vdd.t942 bias_gm_0.bias_trim_0.vz.t25 a_22252_4374# vdd.t570 sg13_lv_pmos ad=95f pd=0.88u as=95f ps=0.88u w=0.5u l=5u
X2735 a_1758_10258# d_dith_en.t23 vss.t670 vss.t669 sg13_lv_nmos ad=37.8f pd=0.6u as=79.8f ps=0.8u w=0.42u l=0.13u
X2736 vdd.t21 vss.t2375 vdd.t20 vdd.t19 sg13_lv_pmos ad=0.34p pd=2.68u as=0 ps=0 w=1u l=1u
X2737 vdd.t521 sg13cmos5l_and2_1_5.X.t3 a_8302_15626# vdd.t502 sg13_lv_pmos ad=0.2226p pd=1.535u as=0.1596p ps=1.22u w=0.84u l=0.13u
X2738 vdd.t1046 d_qi_b.t5 sg13cmos5l_inv_1_11.Y vdd.t502 sg13_lv_pmos ad=0.3808p pd=2.92u as=0.3808p ps=2.92u w=1.12u l=0.13u
X2739 sg13cmos5l_nor2_2_0.Y sg13cmos5l_nor2_2_0.B.t4 vss.t1197 vss.t1196 sg13_lv_nmos ad=0.1406p pd=1.12u as=0.2516p ps=2.16u w=0.74u l=0.13u
X2740 vss.t1855 vdd.t1740 vss.t1854 vss.t1841 sg13_lv_nmos ad=0.1428p pd=1.52u as=0 ps=0 w=0.42u l=1u
X2741 vdd.t204 vss.t2269 vdd.t203 vdd.t68 sg13_lv_pmos ad=0.34p pd=2.68u as=0 ps=0 w=1u l=1u
X2742 a_2034_11446# a_2049_10149# a_2070_11214# vss.t794 sg13_lv_nmos ad=0.12665p pd=1.145u as=0.1428p ps=1.52u w=0.42u l=0.13u
X2743 sg13cmos5l_inv_1_17.Y.t1 sg13cmos5l_inv_1_17.A.t4 vdd.t503 vdd.t502 sg13_lv_pmos ad=0.3808p pd=2.92u as=0.3808p ps=2.92u w=1.12u l=0.13u
X2744 vdd.t797 a_5176_31117# a_7224_31505# vdd.t764 sg13_lv_pmos ad=0.19p pd=1.38u as=0.19p ps=1.38u w=1u l=2u
X2745 vss.t213 vss.t214 vss.t212 rhigh l=10.975u w=0.5u
X2746 vdd.t555 d_phi2.t4 clk_noverlap_0.sg13cmos5l_inv_1_6.A vdd.t308 sg13_lv_pmos ad=0.3808p pd=2.92u as=0.3808p ps=2.92u w=1.12u l=0.13u
X2747 vo_n.t7 sw_tgate_cmfb2_3.gb.t3 xsc_xcmfb1_vsw_cm_n.t8 vdd.t678 sg13_lv_pmos ad=0.285p pd=1.88u as=0.285p ps=1.88u w=1.5u l=1u
X2748 vdd.t1093 d_dith_en.t15 a_567_5970# vdd.t504 sg13_lv_pmos ad=0.1563p pd=1.22u as=0.147p ps=1.54u w=0.42u l=0.13u
X2749 bias_gm_0.bias_trim_0.vz.t13 bias_gm_0.bias_trim_0.vz.t12 vdd.t581 vdd.t572 sg13_lv_pmos ad=95f pd=0.88u as=95f ps=0.88u w=0.5u l=5u
X2750 xq_dith_v_bq.t11 sg13cmos5l_inv_1_3.A.t3 vo_p.t17 vss.t1234 sg13_lv_nmos ad=0.665p pd=3.88u as=0.665p ps=3.88u w=3.5u l=0.13u
X2751 vdd.t1657 vss.t2192 vdd.t419 vdd.t173 sg13_lv_pmos ad=0.19p pd=1.38u as=0 ps=0 w=1u l=1u
X2752 a_24540_19760# a_28126_19620# vss.t34 rhigh l=17.5u w=0.5u
X2753 xsc_vc1r_n.t7 sw_tgate_11.gb.t5 xsc_vc1r_n.t6 vss.t597 sg13_lv_nmos ad=0.19p pd=1.38u as=0 ps=0 w=1u l=1u
X2754 d_vcm_phi1_b.t1 a_8880_5832# vdd.t527 vdd.t526 sg13_lv_pmos ad=0.3976p pd=2.95u as=0.2226p ps=1.535u w=1.12u l=0.13u
X2755 sg13cmos5l_inv_1_4.Y.t1 sg13cmos5l_inv_1_4.A.t4 vdd.t620 vdd.t502 sg13_lv_pmos ad=0.3808p pd=2.92u as=0.3808p ps=2.92u w=1.12u l=0.13u
X2756 vdd.t1217 dsm2_io_0.sg13cmos5l_inv_1_0.A d_dith_en.t1 vdd.t617 sg13_lv_pmos ad=0.3808p pd=2.92u as=0.3808p ps=2.92u w=1.12u l=0.13u
X2757 quantizer2_lfsr_0.sg13cmos5l_nor2_1_1.B quantizer2_lfsr_0.di_dith_amp[0].t2 vss.t2087 vss.t664 sg13_lv_nmos ad=0.2516p pd=2.16u as=0.2516p ps=2.16u w=0.74u l=0.13u
X2758 vo_p.t12 sw_tgate_cmfb2_3.gb.t4 xsc_xcmfb1_vsw_cm_p.t11 vdd.t900 sg13_lv_pmos ad=0.285p pd=1.88u as=0.285p ps=1.88u w=1.5u l=1u
X2759 a_24540_21440# a_28126_21300# vss.t34 rhigh l=17.5u w=0.5u
X2760 a_1284_15759# a_1286_14615# a_1681_14929# vss.t45 sg13_lv_nmos ad=0.12665p pd=1.145u as=0.1428p ps=1.52u w=0.42u l=0.13u
X2761 vdd.t395 vss.t2176 vdd.t114 vdd.t113 sg13_lv_pmos ad=0.19p pd=1.38u as=0 ps=0 w=1u l=1u
X2762 a_5401_7200# a_5131_7241# vdd.t689 vdd.t308 sg13_lv_pmos ad=0.34p pd=2.68u as=0.1523p ps=1.38u w=1u l=0.5u
X2763 vdd.t1544 vdd.t1542 vdd.t1175 vdd.t1287 sg13_lv_pmos ad=0.17p pd=1.68u as=0 ps=0 w=0.5u l=5u
X2764 vss.t997 d_dith_en.t9 a_558_3204# vss.t1133 sg13_lv_nmos ad=0.1626p pd=1.415u as=60.89999f ps=0.71u w=0.42u l=0.13u
X2765 vdd.t285 vss.t2355 vdd.t286 vdd.t53 sg13_lv_pmos ad=0.19p pd=1.38u as=0 ps=0 w=1u l=1u
X2766 vss.t1260 vss.t1261 vss.t39 rhigh l=2.75u w=0.5u
X2767 sg13cmos5l_nor2_1_0.Y sg13cmos5l_and2_1_5.A.t3 vss.t826 vss.t92 sg13_lv_nmos ad=0.1406p pd=1.12u as=0.2516p ps=2.16u w=0.74u l=0.13u
X2768 w_9407_29481.t4 xsc_vvg_p.t6 a_7804_29739.t1 w_9407_29481.t0 sg13_lv_pmos ad=0.38p pd=2.38u as=0.38p ps=2.38u w=2u l=1u
X2769 vss.t287 vss.t271 vss.t286 vss.t272 sg13_hv_nmos ad=3.4p pd=20.68u as=0 ps=0 w=10u l=1u
X2770 sw_tgate_6.p.t7 d_qi_b.t7 vdd.t1042 vdd.t562 sg13_lv_pmos ad=0.38p pd=2.38u as=0.38p ps=2.38u w=2u l=1u
X2771 a_22252_11246# bias_gm_0.bias_trim_0.vz.t52 vdd.t1018 vdd.t566 sg13_lv_pmos ad=95f pd=0.88u as=95f ps=0.88u w=0.5u l=5u
X2772 a_1284_10575# a_1286_9431# a_1681_9745# vss.t2139 sg13_lv_nmos ad=0.12665p pd=1.145u as=0.1428p ps=1.52u w=0.42u l=0.13u
X2773 vss.t1141 di_dith_amp[1] dsm2_io_0.sg13cmos5l_inv_1_3.A vss.t1140 sg13_hv_nmos ad=0.34p pd=2.68u as=0.34p ps=2.68u w=1u l=0.45u
X2774 a_1407_15314# a_1284_15759# a_1758_15442# vss.t792 sg13_lv_nmos ad=0.1428p pd=1.52u as=37.8f ps=0.6u w=0.42u l=0.13u
X2775 vss.t2093 sg13cmos5l_inv_1_1.A sg13cmos5l_inv_1_0.A vss.t855 sg13_lv_nmos ad=0.2516p pd=2.16u as=0.2516p ps=2.16u w=0.74u l=0.13u
X2776 xsc_vc1l_n.t11 d_phi1.t3 xsc_vc1l_n.t10 vdd.t562 sg13_lv_pmos ad=0.38p pd=2.38u as=0 ps=0 w=2u l=1u
X2777 vss.t1090 a_2034_13874# a_2070_13806# vss.t1290 sg13_lv_nmos ad=79.8f pd=0.8u as=0.1428p ps=1.52u w=0.42u l=0.13u
X2778 vdd.t1011 bias_gm_0.bias_trim_0.vz.t48 a_22252_7946# vdd.t384 sg13_lv_pmos ad=95f pd=0.88u as=95f ps=0.88u w=0.5u l=5u
X2779 vss.t1779 vdd.t1758 vss.t1778 vss.t1777 sg13_lv_nmos ad=0.1428p pd=1.52u as=0 ps=0 w=0.42u l=1u
X2780 vss.t831 sg13cmos5l_nand2_2_0.B.t3 sg13cmos5l_nor2_2_0.B.t0 vss.t830 sg13_lv_nmos ad=0.1406p pd=1.12u as=0.1406p ps=1.12u w=0.74u l=0.13u
X2781 xq_vg_q_0_.t1 sg13cmos5l_inv_1_13.Y.t3 a_5892_8400.t1 vss.t475 sg13_lv_nmos ad=95f pd=0.88u as=0.17p ps=1.68u w=0.5u l=0.13u
X2782 a_5798_8400.t0 a_5994_8400.t0 vss.t4 rhigh l=4.08u w=0.5u
X2783 a_7531_15998# sg13cmos5l_nor2_1_0.Y a_7437_15998# vss.t995 sg13_lv_nmos ad=0.1216p pd=1.02u as=0.2176p ps=1.96u w=0.64u l=0.13u
X2784 xsc_xcmfb1_vsw_cm_p.t6 vss.t300 xsc_xcmfb1_vsw_cm_p.t1 vss.t294 sg13_lv_nmos ad=95f pd=0.88u as=0 ps=0 w=0.5u l=1u
X2785 vss.t1986 vdd.t1710 vss.t1985 vss.t1984 sg13_lv_nmos ad=0.1428p pd=1.52u as=0 ps=0 w=0.42u l=1u
X2786 a_14433_7467# a_14548_7466# vdd.t718 vdd.t308 sg13_lv_pmos ad=0.34p pd=2.68u as=0.2254p ps=1.53u w=1u l=0.5u
X2787 a_522_7368# a_533_7328# a_522_7702# vss.t612 sg13_lv_nmos ad=0.3473p pd=2.71u as=0.12665p ps=1.145u w=0.74u l=0.13u
X2788 a_1758_13572# quantizer2_lfsr_0.sg13cmos5l_dfrbpq_1_13.D.t2 a_1367_14309# vss.t1239 sg13_lv_nmos ad=60.89999f pd=0.71u as=0.1428p ps=1.52u w=0.42u l=0.13u
X2789 xsc_xcmfb1_vsw_vbias.t8 sw_tgate_cmfb2_3.gb.t2 xsc_vfb.t4 vdd.t560 sg13_lv_pmos ad=0.285p pd=1.88u as=0.285p ps=1.88u w=1.5u l=1u
X2790 a_1324_5988# a_1322_6770# a_1284_7983# vss.t2103 sg13_lv_nmos ad=0.3473p pd=2.71u as=0.12665p ps=1.145u w=0.74u l=0.13u
X2791 a_2034_6098# a_2034_6262# a_2070_6226# vss.t948 sg13_lv_nmos ad=0.1428p pd=1.52u as=37.8f ps=0.6u w=0.42u l=0.13u
X2792 vdd.t336 vss.t2155 vdd.t330 vdd.t308 sg13_lv_pmos ad=0.19p pd=1.38u as=0 ps=0 w=1u l=1u
X2793 vss.t1677 vdd.t1783 vss.t1678 vss.t1663 sg13_lv_nmos ad=79.8f pd=0.8u as=0 ps=0 w=0.42u l=1u
X2794 sg13cmos5l_inv_1_17.A.t0 sg13cmos5l_inv_1_15.Y vdd.t760 vdd.t502 sg13_lv_pmos ad=0.2128p pd=1.5u as=0.3808p ps=2.92u w=1.12u l=0.13u
X2795 sg13cmos5l_inv_1_16.A.t0 sg13cmos5l_nand2_1_5.A.t3 a_6202_14892# vss.t0 sg13_lv_nmos ad=0.2516p pd=2.16u as=0.1406p ps=1.12u w=0.74u l=0.13u
X2796 a_1284_5391# a_1286_4247# a_1324_3396# vdd.t504 sg13_lv_pmos ad=0.2048p pd=1.63u as=0.34p ps=2.68u w=1u l=0.13u
X2797 a_9357_11104.t1 vo_p.t24 a_9533_11104.t1 vss.t31 sg13_lv_nmos ad=0.76p pd=4.38u as=0.76p ps=4.38u w=4u l=0.5u
X2798 vss.t1542 vdd.t1815 vss.t1544 vss.t1543 sg13_lv_nmos ad=79.8f pd=0.8u as=0 ps=0 w=0.42u l=1u
X2799 sw_tgate_cmfb2_1.p.t3 d_phi2.t8 sw_tgate_cmfb2_1.p.t2 vdd.t558 sg13_lv_pmos ad=0.285p pd=1.88u as=0 ps=0 w=1.5u l=1u
X2800 vss.t2039 vdd.t1699 vss.t2041 vss.t2040 sg13_lv_nmos ad=79.8f pd=0.8u as=0 ps=0 w=0.42u l=1u
X2801 a_2070_4356# quantizer2_lfsr_0.sg13cmos5l_dfrbpq_1_2.Q.t3 a_2070_4262# vss.t962 sg13_lv_nmos ad=60.89999f pd=0.71u as=0.1428p ps=1.52u w=0.42u l=0.13u
X2802 vdd.t1023 bias_gm_0.bias_trim_0.vz.t52 a_22252_11246# vdd.t570 sg13_lv_pmos ad=95f pd=0.88u as=95f ps=0.88u w=0.5u l=5u
X2803 vss.t185 d_phi2.t14 sw_tgate_cmfb2_1.gb.t0 vss.t184 sg13_lv_nmos ad=0.34p pd=2.68u as=0.34p ps=2.68u w=1u l=0.13u
X2804 vss.t444 vss.t441 vss.t443 vss.t442 sg13_lv_nmos ad=0.17p pd=1.68u as=0 ps=0 w=0.5u l=0.5u
X2805 clk_noverlap_0.sg13cmos5l_inv_1_1.A clk_noverlap_0.sg13cmos5l_inv_1_11.Y vss.t942 vss.t2113 sg13_lv_nmos ad=0.1694p pd=1.21u as=0.1463p ps=1.15u w=0.77u l=0.13u
X2806 quantizer2_lfsr_0.sg13cmos5l_dfrbpq_1_2.D.t0 quantizer2_lfsr_0.sg13cmos5l_dfrbpq_1_13.Q a_1320_16467# vdd.t504 sg13_lv_pmos ad=0.2408p pd=1.55u as=0.1428p ps=1.375u w=1.12u l=0.13u
X2807 vdd.t950 vdd.t1452 vdd.t1453 vdd.t1173 sg13_lv_pmos ad=95f pd=0.88u as=0 ps=0 w=0.5u l=5u
X2808 vss.t1604 vdd.t1801 vss.t1602 vss.t1603 sg13_lv_nmos ad=79.8f pd=0.8u as=0 ps=0 w=0.42u l=1u
X2809 quantizer2_lfsr_0.sg13cmos5l_dfrbpq_1_13.Q a_1284_15861# vss.t791 vss.t790 sg13_lv_nmos ad=0.2516p pd=2.16u as=0.1406p ps=1.12u w=0.74u l=0.13u
X2810 vss.t1029 d_qi_b.t5 sg13cmos5l_inv_1_11.Y vss.t1028 sg13_lv_nmos ad=0.2516p pd=2.16u as=0.2516p ps=2.16u w=0.74u l=0.13u
X2811 a_14266_16020# sg13cmos5l_nand2_1_5.A.t4 sg13cmos5l_nand2_1_2.Y.t0 vss.t978 sg13_lv_nmos ad=0.1406p pd=1.12u as=0.2516p ps=2.16u w=0.74u l=0.13u
X2812 a_22252_5274# bias_gm_0.bias_trim_0.vz.t28 vdd.t1151 vdd.t566 sg13_lv_pmos ad=95f pd=0.88u as=95f ps=0.88u w=0.5u l=5u
X2813 a_2079_7122# a_2049_7557# a_2070_6854# vss.t225 sg13_lv_nmos ad=79.8f pd=0.8u as=0.1296p ps=1.52u w=0.42u l=0.13u
X2814 a_10592_15909# d_qout_en.t3 vdd.t607 vdd.t502 sg13_lv_pmos ad=0.1596p pd=1.22u as=0.1918p ps=1.5u w=0.84u l=0.13u
X2815 a_571_14052# a_522_15144# a_571_13990# vss.t730 sg13_lv_nmos ad=0.1428p pd=1.52u as=37.8f ps=0.6u w=0.42u l=0.13u
X2816 vdd.t942 vdd.t1574 vdd.t1575 vdd.t1173 sg13_lv_pmos ad=95f pd=0.88u as=0 ps=0 w=0.5u l=5u
X2817 vdd.t273 vss.t2402 vdd.t248 vdd.t0 sg13_lv_pmos ad=0.19p pd=1.38u as=0 ps=0 w=1u l=1u
X2818 vdd.t165 vss.t2236 vdd.t164 vdd.t85 sg13_lv_pmos ad=0.19p pd=1.38u as=0 ps=0 w=1u l=1u
X2819 a_2083_4836# a_2034_5928# a_2083_4774# vss.t660 sg13_lv_nmos ad=0.1428p pd=1.52u as=37.8f ps=0.6u w=0.42u l=0.13u
X2820 vss.t365 dsm2_osc_0.d_btest_or.t3 a_21252_3394# vss.t267 sg13_lv_nmos ad=95f pd=0.88u as=95f ps=0.88u w=0.5u l=10u
X2821 vi_esd.t12 d_phi1.t5 vi_esd.t4 vdd.t561 sg13_lv_pmos ad=0.38p pd=2.38u as=0 ps=0 w=2u l=1u
X2822 vss.t230 a_5401_7200# a_5513_7224# vss.t677 sg13_lv_nmos ad=0.1426p pd=1.16u as=0.1428p ps=1.52u w=0.42u l=0.5u
X2823 bias_gm_0.bias_trim_0.iout dsm2_io_0.do_trim_b[3].t2 a_22252_4374# vdd.t573 sg13_lv_pmos ad=95f pd=0.88u as=95f ps=0.88u w=0.5u l=5u
X2824 vss.t1185 vss.t1186 vss.t693 rhigh l=9.28u w=0.5u
X2825 a_15693_7164# clk_noverlap_0.sg13cmos5l_dlygate4sd3_1_10.A vss.t138 vss.t137 sg13_lv_nmos ad=0.1428p pd=1.52u as=79.8f ps=0.8u w=0.42u l=0.13u
X2826 vdd.t507 a_2034_13874# a_2385_13785# vdd.t507 sg13_lv_pmos ad=1.99007p pd=12.8u as=93.45f ps=0.865u w=0.42u l=0.13u
X2827 vss.t107 sw_tgate_cmfb2_1.p.t10 vss.t105 vss.t106 sg13_lv_nmos ad=95f pd=0.88u as=0 ps=0 w=0.5u l=3u
X2828 vss.t2024 vdd.t1702 vss.t2026 vss.t2025 sg13_lv_nmos ad=79.8f pd=0.8u as=0 ps=0 w=0.42u l=1u
X2829 vdd.t1500 vdd.t1498 vdd.t1499 vdd.t1287 sg13_lv_pmos ad=0.17p pd=1.68u as=0 ps=0 w=0.5u l=5u
X2830 vss.t1467 vdd.t1830 vss.t1466 vss.t1465 sg13_lv_nmos ad=0.1428p pd=1.52u as=0 ps=0 w=0.42u l=1u
X2831 a_2034_13874# a_2034_14038# a_2070_14002# vss.t1214 sg13_lv_nmos ad=0.1428p pd=1.52u as=37.8f ps=0.6u w=0.42u l=0.13u
X2832 sg13cmos5l_inv_1_4.Y.t0 sg13cmos5l_inv_1_4.A.t4 vss.t471 vss.t470 sg13_lv_nmos ad=0.2516p pd=2.16u as=0.2516p ps=2.16u w=0.74u l=0.13u
X2833 vdd.t144 vss.t2326 vdd.t143 vdd.t71 sg13_lv_pmos ad=0.34p pd=2.68u as=0 ps=0 w=1u l=1u
X2834 vss.t954 quantizer2_lfsr_0.sg13cmos5l_dfrbpq_1_13.D.t3 a_1690_16373# vss.t457 sg13_lv_nmos ad=0.1898p pd=1.36u as=0.2516p ps=2.16u w=0.74u l=0.13u
X2835 vss.t469 dsm2_io_vcmg_0.di_vcm_ext_b.t2 a_17035_5500# vss.t206 sg13_lv_nmos ad=0.1331p pd=1.12u as=0.1216p ps=1.02u w=0.64u l=0.13u
X2836 vdd.t1644 di_trim[1] dsm2_io_0.do_trim_b[1].t1 vdd.t25 sg13_hv_pmos ad=0.17p pd=1.68u as=0.17p ps=1.68u w=0.5u l=1u
X2837 a_20672_22140# a_24258_22280# vss.t207 rhigh l=17.5u w=0.5u
X2838 vss.t1302 vss.t1303 vss.t531 rhigh l=2.75u w=0.5u
X2839 a_1320_16467# quantizer2_lfsr_0.sg13cmos5l_dfrbpq_1_13.D.t3 vdd.t923 vdd.t504 sg13_lv_pmos ad=0.1428p pd=1.375u as=0.2891p ps=1.695u w=1.12u l=0.13u
X2840 a_19105_884# di_clk vss.t1349 vss.t1348 sg13_lv_nmos ad=0.2176p pd=1.96u as=0.1371p ps=1.12u w=0.64u l=0.13u
X2841 a_2070_12132# quantizer2_lfsr_0.sg13cmos5l_dfrbpq_1_5.Q a_2070_12038# vss.t1286 sg13_lv_nmos ad=60.89999f pd=0.71u as=0.1428p ps=1.52u w=0.42u l=0.13u
X2842 vdd.t1160 bias_gm_0.bias_trim_0.vz.t43 a_22252_8546# vdd.t570 sg13_lv_pmos ad=95f pd=0.88u as=95f ps=0.88u w=0.5u l=5u
X2843 xsc_vc1l_p.t2 sw_tgate_9.gb.t3 sw_tgate_12.m.t8 vdd.t561 sg13_lv_pmos ad=0.38p pd=2.38u as=0.68p ps=4.68u w=2u l=1u
X2844 d_qi_b.t2 d_qi.t3 a_10132_15186# vdd.t502 sg13_lv_pmos ad=0.2128p pd=1.5u as=0.3808p ps=2.92u w=1.12u l=0.13u
X2845 a_1407_10130# d_dith_en.t23 vdd.t511 vdd.t504 sg13_lv_pmos ad=79.8f pd=0.8u as=1.1847p ps=7.385u w=0.42u l=0.13u
X2846 a_21775_1704# dsm2_osc_0.sg13cmos5l_mux2_1_0.A1 a_21681_1704# vss.t149 sg13_lv_nmos ad=0.1216p pd=1.02u as=0.2176p ps=1.96u w=0.64u l=0.13u
X2847 vdd.t506 a_4537_7200# a_4649_7224# vdd.t308 sg13_lv_pmos ad=0.2254p pd=1.53u as=0.34p ps=2.68u w=1u l=0.5u
X2848 a_2070_6854# quantizer2_lfsr_0.sg13cmos5l_dfrbpq_1_3.Q vdd.t668 vdd.t507 sg13_lv_pmos ad=79.8f pd=0.8u as=0.1428p ps=1.52u w=0.42u l=0.13u
X2849 vdd.t249 vss.t2405 vdd.t251 vdd.t0 sg13_lv_pmos ad=0.34p pd=2.68u as=0 ps=0 w=1u l=1u
X2850 a_5892_8400.t6 d_amp_s[0].t3 a_5798_8400.t2 vss.t666 sg13_lv_nmos ad=95f pd=0.88u as=0.17p ps=1.68u w=0.5u l=0.13u
X2851 vdd.t242 vss.t2179 vdd.t342 vdd.t82 sg13_lv_pmos ad=0.34p pd=2.68u as=0 ps=0 w=1u l=1u
X2852 vss.t440 vss.t438 vss.t181 vss.t439 sg13_hv_nmos ad=1.9p pd=10.38u as=0 ps=0 w=10u l=0.45u
X2853 a_4362_8188.t12 sg13cmos5l_or2_1_0.X.t2 xq_dith_v_bp.t8 vss.t717 sg13_lv_nmos ad=0.665p pd=3.88u as=0.665p ps=3.88u w=3.5u l=0.13u
X2854 a_9357_11104.t3 vo_n.t24 a_11293_11104.t2 vss.t645 sg13_lv_nmos ad=0.76p pd=4.38u as=0.76p ps=4.38u w=4u l=0.5u
X2855 vdd.t299 vss.t2191 vdd.t298 vdd.t173 sg13_lv_pmos ad=0.34p pd=2.68u as=0 ps=0 w=1u l=1u
X2856 a_522_10130# d_dith_en.t24 vdd.t511 vdd.t504 sg13_lv_pmos ad=79.8f pd=0.8u as=1.1847p ps=7.385u w=0.42u l=0.13u
X2857 vdd.t467 vss.t2204 vdd.t406 vdd.t187 sg13_lv_pmos ad=0.19p pd=1.38u as=0 ps=0 w=1u l=1u
X2858 vss.t420 vss.t419 vss.t422 vss.t407 sg13_lv_nmos ad=0.76p pd=4.38u as=0 ps=0 w=4u l=0.5u
X2859 a_7804_29739.t4 a_5176_30111# vo_n.t13 vss.t763 sg13_lv_nmos ad=95f pd=0.88u as=95f ps=0.88u w=0.5u l=3u
X2860 a_1288_3370# a_1286_4247# a_1367_3753# vdd.t504 sg13_lv_pmos ad=79.8f pd=0.8u as=63f ps=0.72u w=0.42u l=0.13u
X2861 vdd.t1410 vdd.t1408 vdd.t582 vdd.t1287 sg13_lv_pmos ad=0.17p pd=1.68u as=0 ps=0 w=0.5u l=5u
X2862 vss.t10 a_2034_6262# a_2034_6645# vss.t947 sg13_lv_nmos ad=0.1406p pd=1.12u as=0.2516p ps=2.16u w=0.74u l=0.13u
X2863 vdd.t774 a_5176_31117# vdd.t775 vdd.t764 sg13_lv_pmos ad=0.465p pd=1.93u as=0 ps=0 w=1u l=2u
X2864 a_2079_4530# a_2049_4965# a_2461_4905# vdd.t507 sg13_lv_pmos ad=79.8f pd=0.8u as=63f ps=0.72u w=0.42u l=0.13u
X2865 vdd.t366 vss.t2207 vdd.t396 vdd.t187 sg13_lv_pmos ad=0.34p pd=2.68u as=0 ps=0 w=1u l=1u
X2866 vdd.t697 a_17025_7467# clk_noverlap_0.sg13cmos5l_dlygate4sd3_1_12.A vdd.t308 sg13_lv_pmos ad=0.2254p pd=1.53u as=0.4256p ps=3u w=1.12u l=0.13u
X2867 vss.t782 a_5176_30111# vss.t781 vss.t749 sg13_lv_nmos ad=0.17p pd=1.68u as=0 ps=0 w=0.5u l=3u
X2868 vdd.t61 vss.t2354 vdd.t60 vdd.t53 sg13_lv_pmos ad=0.34p pd=2.68u as=0 ps=0 w=1u l=1u
X2869 xsc_vc1l_p.t9 d_phi1.t5 vi_esd.t6 vss.t909 sg13_lv_nmos ad=0.19p pd=1.38u as=0.19p ps=1.38u w=1u l=1u
X2870 sg13cmos5l_inv_2_5.A sg13cmos5l_inv_1_14.A.t11 vss.t1204 vss.t1203 sg13_lv_nmos ad=0.2516p pd=2.16u as=0.2516p ps=2.16u w=0.74u l=0.13u
X2871 a_558_3204# quantizer2_lfsr_0.sg13cmos5l_dfrbpq_1_0.Q a_558_3110# vss.t1178 sg13_lv_nmos ad=60.89999f pd=0.71u as=0.1428p ps=1.52u w=0.42u l=0.13u
X2872 vss.t1798 vdd.t1754 vss.t1795 vss.t1797 sg13_lv_nmos ad=79.8f pd=0.8u as=0 ps=0 w=0.42u l=1u
X2873 vss.t1767 vdd.t1761 vss.t1769 vss.t1768 sg13_lv_nmos ad=79.8f pd=0.8u as=0 ps=0 w=0.42u l=1u
X2874 vss.t1552 vdd.t1813 vss.t1553 vss.t1550 sg13_lv_nmos ad=79.8f pd=0.8u as=0 ps=0 w=0.42u l=1u
X2875 vss.t779 a_5176_30111# vss.t778 vss.t61 sg13_lv_nmos ad=0.17p pd=1.68u as=0 ps=0 w=0.5u l=3u
X2876 a_558_10886# quantizer2_lfsr_0.sg13cmos5l_dfrbpq_1_7.D vdd.t1149 vdd.t504 sg13_lv_pmos ad=79.8f pd=0.8u as=0.1428p ps=1.52u w=0.42u l=0.13u
X2877 xsc_xcmfb1_vsw_vbias.t9 d_phi1.t6 xsc_vfb.t0 vss.t907 sg13_lv_nmos ad=95f pd=0.88u as=95f ps=0.88u w=0.5u l=1u
X2878 a_21452_2308.t2 a_22644_2344# a_23294_2578# vdd.t514 sg13_lv_pmos ad=0.17p pd=1.68u as=95f ps=0.88u w=0.5u l=0.13u
X2879 vss.t777 a_5176_30111# vss.t776 vss.t110 sg13_lv_nmos ad=0.17p pd=1.68u as=0 ps=0 w=0.5u l=3u
X2880 bias_gm_0.bias_trim_0.iout dsm2_io_0.do_trim_b[2].t3 a_22252_5274# vdd.t384 sg13_lv_pmos ad=95f pd=0.88u as=95f ps=0.88u w=0.5u l=5u
X2881 vdd.t1356 vdd.t1354 vdd.t1355 vdd.t659 sg13_lv_pmos ad=0.34p pd=2.68u as=0 ps=0 w=1u l=0.5u
X2882 dsm2_osc_0.ibias_pad.t1 ibias_test vss.t1421 rppd l=2u w=1u
X2883 vdd.t685 d_dith_en.t20 a_1367_9125# vdd.t504 sg13_lv_pmos ad=0.36237p pd=2.605u as=79.8f ps=0.8u w=0.42u l=0.13u
X2884 xsc_vc1l_n.t5 sw_tgate_11.gb.t3 xsc_vc1l_n.t4 vss.t598 sg13_lv_nmos ad=0.19p pd=1.38u as=0 ps=0 w=1u l=1u
X2885 a_13870_15077# a_13985_15078# vss.t1271 vss.t1270 sg13_lv_nmos ad=0.1428p pd=1.52u as=0.1426p ps=1.16u w=0.42u l=0.5u
X2886 vdd.t509 d_ena.t3 a_10784_6484# vdd.t308 sg13_lv_pmos ad=0.1918p pd=1.5u as=0.1596p ps=1.22u w=0.84u l=0.13u
X2887 vdd.t436 vss.t2148 vdd.t435 vdd.t308 sg13_lv_pmos ad=0.34p pd=2.68u as=0 ps=0 w=1u l=1u
X2888 vdd.t388 vss.t2309 vdd.t387 vdd.t386 sg13_lv_pmos ad=0.34p pd=2.68u as=0 ps=0 w=1u l=1u
X2889 vss.t1017 d_qi_b.t6 sw_tgate_8.m.t9 vss.t1037 sg13_lv_nmos ad=0.19p pd=1.38u as=0.19p ps=1.38u w=1u l=1u
X2890 a_19984_17824# bias_gm_0.bias_trim_0.vz.t12 vdd.t584 vdd.t287 sg13_lv_pmos ad=95f pd=0.88u as=95f ps=0.88u w=0.5u l=5u
X2891 vdd.t1254 bias_gm_0.bias_trim_0.vz.t0 a_19984_17824# vdd.t384 sg13_lv_pmos ad=95f pd=0.88u as=95f ps=0.88u w=0.5u l=5u
X2892 clk_noverlap_0.sg13cmos5l_dlygate4sd3_1_2.X a_6377_7224# vdd.t610 vdd.t308 sg13_lv_pmos ad=0.4256p pd=3u as=0.2254p ps=1.53u w=1.12u l=0.13u
X2893 vss.t1565 vdd.t1810 vss.t1564 vss.t1559 sg13_lv_nmos ad=0.1428p pd=1.52u as=0 ps=0 w=0.42u l=1u
X2894 a_22252_4074# vss.t2142 bias_gm_0.bias_trim_0.iout vdd.t287 sg13_lv_pmos ad=95f pd=0.88u as=95f ps=0.88u w=0.5u l=5u
X2895 vss.t555 d_dith_en.t2 a_1758_612# vss.t1108 sg13_lv_nmos ad=0.1626p pd=1.415u as=60.89999f ps=0.71u w=0.42u l=0.13u
X2896 xq_vg_q_1_.t1 sg13cmos5l_inv_1_19.Y.t6 vss.t463 vss.t462 sg13_lv_nmos ad=0.17p pd=1.68u as=95f ps=0.88u w=0.5u l=0.13u
X2897 xq_vg_p_0_.t2 sg13cmos5l_nand2_1_2.Y.t2 a_5892_8400.t15 vdd.t763 sg13_lv_pmos ad=95f pd=0.88u as=0.17p ps=1.68u w=0.5u l=0.13u
X2898 a_24214_15146# a_20138_14766# a_22138_15446# vdd.t898 sg13_lv_pmos ad=0.17p pd=1.68u as=95f ps=0.88u w=0.5u l=10u
X2899 vdd.t975 sg13cmos5l_and2_2_1.X.t4 a_9533_11104.t5 vdd.t863 sg13_lv_pmos ad=0.285p pd=1.88u as=0.285p ps=1.88u w=1.5u l=0.5u
C0 quantizer2_lfsr_0.sg13cmos5l_dfrbpq_1_5.Q a_2079_12306# 0.02576f
C1 sw_tgate_11.gb vcm_esd 1.06002f
C2 sg13cmos5l_inv_1_9.Y sg13cmos5l_inv_1_16.Y 0.02233f
C3 inv_en_0.di_b sg13cmos5l_nor2_2_0.Y 0.04972f
C4 vo_n d_amp_s_b[1] 0.06455f
C5 a_522_4776# d_dith_en 0.33079f
C6 sg13cmos5l_inv_1_10.Y sg13cmos5l_inv_1_9.Y 0.02731f
C7 a_20138_14766# a_22138_16346# 0.05762f
C8 sg13cmos5l_inv_1_9.Y d_amp_s_b[0] 0.01512f
C9 dsm2_osc_0.sg13cmos5l_mux2_1_0.A1 vcm_esd 0.02331f
C10 sg13cmos5l_and2_1_5.A sg13cmos5l_inv_1_1.A 0.02897f
C11 sg13cmos5l_inv_1_16.Y sg13cmos5l_and2_2_1.X 0.03481f
C12 a_2049_7557# d_dith_en 0.04075f
C13 a_15130_14856# vdd 0.25781f
C14 a_4649_7224# vdd 0.15893f
C15 sg13cmos5l_inv_1_16.Y sg13cmos5l_inv_1_2.Y 0.01083f
C16 a_10592_15909# d_qi 0.01101f
C17 a_6757_9808# a_9883_9628# 0.14662f
C18 a_13088_15020# vdd 0.0778f
C19 a_28334_21160# a_28334_21020# 0.1335f
C20 a_22252_11246# a_24626_19480# 0.0162f
C21 clk_noverlap_0.sg13cmos5l_dlygate4sd3_1_12.A d_phi2 0.08481f
C22 a_21554_2798# a_23674_2578# 0.0196f
C23 quantizer2_lfsr_0.sg13cmos5l_dfrbpq_1_2.D di_osc_en 0.03411f
C24 a_2070_1670# d_dith_en 0.08434f
C25 a_9352_5586# d_vcm_phi1_b 0.0739f
C26 d_dith_en d_amp_s[0] 0.02579f
C27 a_522_10677# vdd 0.27678f
C28 xsc_vc1l_n d_phi1 0.99568f
C29 sw_tgate_10.p d_phi2 0.66449f
C30 m2_10908_16655# do_clk_osc 0.03001f
C31 a_22063_22964# a_24258_22964# 0.0182f
C32 a_13965_7164# vdd 0.2556f
C33 sw_tgate_11.gb d_phi2 0.61412f
C34 sg13cmos5l_and2_1_2.X sg13cmos5l_and2_1_5.A 0.02713f
C35 dsm2_io_vcmg_0.di_vcm_ext quantizer2_lfsr_0.sg13cmos5l_nor2_1_1.B 0.23756f
C37 a_8747_9308# vdd 0.01388f
C38 a_571_3684# a_558_3110# 0.18486f
C39 a_558_12654# a_537_11589# 0.01058f
C40 sg13cmos5l_inv_1_19.Y sg13cmos5l_and2_1_5.B 0.07383f
C41 a_2079_4530# d_dith_en 0.18315f
C42 a_20770_598# do_osc_oe 0.12024f
C43 a_558_5702# vdd 0.52277f
C44 a_1286_14615# a_1367_14309# 0.02431f
C45 a_20138_14766# a_20070_15446# 0.06835f
C46 a_7224_31505# vo_n 0.22165f
C47 a_24626_20040# dsm2_osc_0.d_btest_or 0.01657f
C48 sg13cmos5l_or2_1_0.X d_ena 0.11907f
C49 dsm2_osc_0.d_btest_or a_21498_769# 0.01278f
C50 a_8587_7241# a_8857_7200# 0.18796f
C51 a_1367_3941# d_qclk 0.01088f
C52 a_22184_2052# a_22386_2344# 0.0976f
C53 a_11201_9808# a_12395_9628# 0.14662f
C54 sg13cmos5l_and2_1_5.A sg13cmos5l_and2_1_5.B 2.70247f
C55 dsm2_osc_0.sg13cmos5l_dfrbp_1_0.RESET_B a_23674_2344# 0.02549f
C56 dsm2_io_0.sg13cmos5l_inv_1_6.A vdd 0.26978f
C57 sg13cmos5l_inv_1_8.Y vdd 0.43515f
C58 d_ena di_clk_sel 6.87072f
C59 xq_vg_p_0_ vdd 0.3721f
C60 dsm2_io_0.do_trim_b[1] bias_gm_0.bias_trim_0.vz 1.55826f
C61 sg13cmos5l_inv_1_16.Y a_8747_9308# 0.01218f
C62 a_20328_23820# a_24626_22964# 0.04998f
C63 a_2368_16778# d_amp_s[3] 0.01474f
C64 a_571_8868# d_dith_en 0.01369f
C65 sg13cmos5l_nor2_1_0.Y inv_en_0.di_b 0.02144f
C66 dsm2_io_vcmg_0.di_vcm_ext_b a_10888_5586# 0.01736f
C67 sg13cmos5l_inv_1_4.Y d_dith_en 0.27847f
C68 a_9352_5586# m2_10908_16863# 0.02099f
C69 xsc_vc1r_n sw_tgate_9.gb 0.40882f
C70 a_20260_17236# bias_gm_0.bias_trim_0.vz 0.33613f
C71 a_1286_4247# d_dith_en 0.04693f
C72 xsc_vc1r_n vdd 1f
C73 a_7129_7200# vdd 0.20436f
C74 sg13cmos5l_inv_1_6.Y xq_vg_p_1_ 0.07675f
C75 sg13cmos5l_inv_1_3.A xq_vg_q_2_ 0.08081f
C76 sg13cmos5l_inv_1_4.Y xq_vg_q_0_ 0.02196f
C77 a_24626_19900# dsm2_osc_0.d_btest_or 0.01657f
C78 dsm2_io_0.do_trim_b[1] a_24404_8546# 0.14521f
C79 d_qout_en d_dith[2] 1.17889f
C80 a_2034_13874# vdd 0.13471f
C81 dsm2_io_vcmg_0.di_vcm_ext a_2034_6262# 0.01087f
C82 clk_noverlap_0.sg13cmos5l_nor3_1_0.C clk_noverlap_0.sg13cmos5l_inv_1_1.A 0.17632f
C83 a_20000_20880# a_20000_20740# 0.1335f
C84 a_24540_20880# a_24540_20600# 0.04477f
C85 sg13cmos5l_inv_1_16.Y xq_vg_p_0_ 0.03569f
C86 sg13cmos5l_inv_1_17.A xq_vg_q_0_ 0.04547f
C87 di_osc_en di_clk_sel 9.49132f
C88 clk_noverlap_0.sg13cmos5l_dlygate4sd3_1_4.A a_8587_7241# 0.30507f
C89 quantizer2_lfsr_0.di_dith_amp[1] quantizer2_lfsr_0.sg13cmos5l_nor2_1_1.B 0.32967f
C90 a_19964_18216# a_28746_14846# 0.0725f
C91 a_5176_31469# m2_6409_30900# 0.03202f
C92 a_6817_30111# xsc_vfb 0.3731f
C93 a_10757_8888# a_10757_8608# 0.04477f
C94 a_2208_20141# vdd 0.15133f
C95 sg13cmos5l_inv_1_6.A sg13cmos5l_nand2_1_2.Y 0.21809f
C96 a_8208_15626# sg13cmos5l_or2_1_0.X 0.11073f
C97 sg13cmos5l_inv_1_4.A sg13cmos5l_inv_1_13.A 2.37801f
C98 xsc_vc1l_n d_phi2 0.85036f
C99 a_24626_22824# a_22252_11246# 0.14029f
C100 d_ena ibias_200n 0.01639f
C101 dsm2_io_0.do_trim_b[0] a_2208_23021# 0.08223f
C102 a_2208_32237# a_2208_31469# 0.05462f
C103 a_1288_8554# d_dith_en 0.2069f
C104 sg13cmos5l_inv_1_19.Y sg13cmos5l_and2_1_5.X 0.33291f
C105 dsm2_io_vcmg_0.di_vcm_ext_b a_16264_5586# 0.01469f
C106 a_533_15104# d_qclk 0.03767f
C107 dsm2_io_0.do_btest_en m2_10908_16863# 0.13695f
C108 xsc_vc1l_p d_ena 0.01752f
C109 a_2070_8622# vdd 0.01767f
C110 a_537_11589# a_1286_12023# 0.01571f
C111 a_14728_5586# m2_10908_16863# 0.02098f
C112 sg13cmos5l_inv_1_3.A sg13cmos5l_inv_1_1.A 0.01206f
C113 d_amp_s_b[3] d_dith[0] 2.89134f
C114 a_2208_27629# a_2208_26861# 0.05462f
C115 sg13cmos5l_and2_1_5.X sg13cmos5l_and2_1_5.A 0.255f
C116 sg13cmos5l_nor2_2_0.Y a_10132_15186# 0.11128f
C117 sg13cmos5l_inv_1_13.A sg13cmos5l_inv_1_9.Y 0.30312f
C118 a_2045_13664# vdd 0.20448f
C119 a_7723_7241# vdd 0.2556f
C120 a_24626_20880# a_24626_20740# 0.84953f
C121 sg13cmos5l_nand2_2_0.B d_qi 0.07025f
C122 a_22368_558# vdd 0.08301f
C123 sg13cmos5l_or2_1_0.X sg13cmos5l_inv_1_13.Y 0.69851f
C124 xsc_vfb sw_tgate_cmfb2_3.gb 0.52228f
C125 dsm2_osc_0.sg13cmos5l_dfrbp_1_0.RESET_B dsm2_osc_0.sg13cmos5l_inv_1_2.Y 0.08399f
C126 vcm_esd d_vcm_phi2 0.09941f
C127 dsm2_io_0.sg13cmos5l_inv_1_5.A a_2208_21189# 0.02343f
C128 a_2070_9446# vdd 0.52304f
C129 a_5176_30111# a_13189_30111# 0.50186f
C130 dsm2_osc_0.ibias_pad vdd 1.59993f
C131 quantizer2_lfsr_0.sg13cmos5l_nor2_1_1.B quantizer2_lfsr_0.sg13cmos5l_dfrbpq_1_13.Q 0.01923f
C132 sg13cmos5l_nor2_2_0.B sg13cmos5l_nor2_2_0.Y 0.26633f
C133 a_27029_22824# a_27029_22684# 0.4505f
C134 a_10120_5586# a_10888_5586# 0.05462f
C135 a_1324_13764# a_1286_14615# 0.28324f
C136 a_17025_7467# vdd 0.1605f
C137 sw_tgate_6.p d_phi1 0.62834f
C138 quantizer2_lfsr_0.sg13cmos5l_dfrbpq_1_2.Q quantizer2_lfsr_0.sg13cmos5l_dfrbpq_1_11.Q 1.02785f
C139 a_1322_11954# a_1367_11717# 0.07916f
C140 sg13cmos5l_nand2_1_5.A a_8768_15909# 0.02116f
C141 a_537_14181# vdd 0.23809f
C142 sw_tgate_10.p xsc_vc1l_p 0.54536f
C143 dsm2_osc_0.sg13cmos5l_dfrbp_1_0.RESET_B vi_esd 0.10733f
C144 sw_tgate_11.gb xsc_vc1l_p 0.40873f
C145 dsm2_osc_0.sg13cmos5l_dfrbp_1_0.RESET_B dsm2_osc_0.sg13cmos5l_dfrbp_1_0.Q_N 0.5545f
C146 a_28126_20740# a_28126_20460# 0.04477f
C147 clk_noverlap_0.sg13cmos5l_nor3_1_0.C clk_noverlap_0.sg13cmos5l_inv_1_11.Y 0.1401f
C148 a_1284_15759# quantizer2_lfsr_0.sg13cmos5l_dfrbpq_1_0.D 0.03841f
C149 a_19984_17824# a_20138_14766# 0.21752f
C150 a_2208_18213# vdd 0.08346f
C151 d_phi2 d_vcm_phi2 0.05507f
C152 a_2208_29165# a_2208_28397# 0.05462f
C153 sg13cmos5l_inv_1_2.A d_qclk 0.04975f
C154 a_522_5110# a_522_4776# 0.01412f
C155 sg13cmos5l_inv_1_6.A vdd 0.68921f
C156 a_27029_22684# a_24626_22420# 0.12754f
C157 a_6817_30111# a_7224_31505# 0.19495f
C158 a_5176_31117# a_6638_31505# 0.25355f
C159 a_5176_31469# a_12445_30191# 1.43084f
C160 dsm2_osc_0.ibias_in a_19105_884# 0.0231f
C161 a_15412_7466# vdd 0.21057f
C162 do_q_b do_osc_oe 0.0348f
C163 a_22252_11246# a_22252_8246# 0.01663f
C164 a_1407_15314# d_dith_en 0.10139f
C165 a_2034_1466# d_dith[2] 0.16299f
C166 a_537_8997# a_567_8562# 0.02241f
C167 clk_noverlap_0.di_clk di_clk 0.12857f
C168 sg13cmos5l_inv_1_4.A inv_en_0.di_b 0.02754f
C169 sg13cmos5l_inv_1_20.Y d_qclk 0.01089f
C170 a_558_15246# a_522_15144# 0.25046f
C171 sg13cmos5l_inv_1_3.Y xq_vg_q_2_ 2.98401f
C172 a_2070_6854# d_dith_en 0.08503f
C173 dsm2_io_vcmg_0.di_vcm_ext_b vdd 1.41983f
C174 sg13cmos5l_nor2_2_0.Y d_dith_en 0.03882f
C175 a_2034_8854# a_2070_8622# 0.16704f
C176 a_20672_20460# a_20758_20600# 0.01899f
C177 dsm2_osc_0.ibias_in do_q_b 0.03496f
C178 xq_dith_v_bq d_dith[2] 0.0687f
C179 sg13cmos5l_nor2_1_0.Y a_8618_15186# 0.01411f
C180 sg13cmos5l_inv_1_12.A vdd 0.3327f
C181 dsm2_osc_0.sg13cmos5l_inv_1_3.A a_22836_1332# 0.01904f
C182 quantizer2_lfsr_0.sg13cmos5l_dfrbpq_1_11.Q d_dith[1] 0.01851f
C183 a_21252_3394# dsm2_osc_0.ibias_pad 0.02185f
C184 sg13cmos5l_inv_1_6.A sg13cmos5l_inv_1_16.Y 0.25474f
C185 quantizer2_lfsr_0.di_dith_amp[0] vcm_esd 0.01027f
C186 a_2045_11072# a_2049_10149# 0.36374f
C187 dsm2_io_vcmg_0.di_vcm_ext a_1324_5988# 0.02087f
C188 a_15496_5586# a_16264_5586# 0.05462f
C189 sg13cmos5l_inv_1_3.A d_amp_s[1] 0.0256f
C190 a_7224_31505# a_9348_31505# 0.08591f
C191 a_5176_31117# sw_tgate_cmfb2_1.p 0.01883f
C192 a_28746_16046# vdd 0.19413f
C193 vcm_esd do_q_b 0.03308f
C194 sw_tgate_6.p d_phi2 0.36823f
C195 a_1367_11717# a_1288_11146# 0.45119f
C196 sg13cmos5l_inv_1_13.A xq_vg_p_0_ 0.44226f
C197 a_1286_9431# a_1600_9125# 0.01562f
C198 sg13cmos5l_inv_1_3.A sg13cmos5l_and2_1_5.X 0.019f
C199 inv_en_0.di_b sg13cmos5l_and2_2_1.X 0.07963f
C200 m2_10908_16655# do_osc_oe 0.03741f
C201 a_533_15104# quantizer2_lfsr_0.sg13cmos5l_dfrbpq_1_0.D 0.03244f
C202 sg13cmos5l_inv_1_3.Y sg13cmos5l_inv_1_1.A 0.01074f
C203 sw_tgate_10.p d_ena 0.0587f
C204 a_522_4946# vdd 0.13554f
C205 xsc_vc1l_p xsc_vc1l_n 1.30895f
C206 clk_noverlap_0.sg13cmos5l_inv_1_0.A vdd 0.62442f
C207 xsc_vfb d_phi1 0.86192f
C208 d_amp_s_b[3] do_q_dec 0.11649f
C209 sw_tgate_11.gb d_ena 0.1917f
C210 sg13cmos5l_inv_1_7.Y do_q 0.01139f
C211 sg13cmos5l_inv_1_16.A d_qout_en 0.08779f
C212 sg13cmos5l_inv_1_19.Y sg13cmos5l_and2_1_5.A 0.1145f
C213 bias_gm_0.bias_trim_0.vz a_22252_4374# 10.4237f
C214 sg13cmos5l_inv_1_3.Y a_11201_9028# 0.01574f
C215 dsm2_io_vcmg_0.di_vcm_ext_b d_amp_s_b[0] 0.19782f
C216 a_2045_11072# d_dith_en 0.29282f
C217 quantizer2_lfsr_0.sg13cmos5l_dfrbpq_1_2.D a_1322_9362# 0.03009f
C218 a_2208_29165# dsm2_io_0.do_trim_b[0] 0.01268f
C219 dsm2_osc_0.dsm2_io_rx_0.di_b dsm2_osc_0.sg13cmos5l_inv_1_2.Y 0.08867f
C220 dsm2_osc_0.ibias_in m2_10908_16655# 0.06379f
C221 clk_noverlap_0.sg13cmos5l_dlygate4sd3_1_1.X vdd 0.2309f
C222 inv_en_0.di d_dith[2] 0.06861f
C223 a_2208_32237# vdd 0.60311f
C224 quantizer2_lfsr_0.di_dith_amp[0] quantizer2_lfsr_0.sg13cmos5l_dfrbpq_1_2.D 0.05379f
C225 a_11956_7466# d_phi2 0.0467f
C226 a_20000_22280# a_20000_22140# 0.1335f
C227 a_24258_22280# a_24626_22280# 0.0182f
C228 a_1286_6839# a_1367_6533# 0.02431f
C229 a_5176_30111# sw_tgate_cmfb2_1.p 1.57566f
C230 a_26670_15746# vdd 0.0169f
C231 xq_vg_q_1_ d_qclk 0.03394f
C232 a_2034_11446# a_2034_11282# 0.23043f
C233 sg13cmos5l_nor2_2_0.B sg13cmos5l_inv_2_0.Y 0.17163f
C234 a_11201_9948# a_11201_9808# 0.97089f
C235 d_phi2 do_q_b 0.07584f
C236 sw_tgate_12.m d_phi1 0.12944f
C237 a_22252_8246# a_22252_8546# 1.11904f
C238 clk_noverlap_0.sg13cmos5l_dlygate4sd3_1_9.A vdd 0.22923f
C239 m2_10908_16655# vcm_esd 0.02574f
C240 a_10120_5586# vdd 0.50905f
C241 sg13cmos5l_nand2_1_5.A sg13cmos5l_or2_1_0.X 0.38968f
C242 dsm2_osc_0.dsm2_io_rx_0.di_b vi_esd 0.05038f
C243 xsc_vfb vcm_esd 3.02974f
C244 d_amp_s_b[3] d_qclk 0.06323f
C245 a_558_3110# d_dith_en 0.12527f
C246 sg13cmos5l_nor2_1_0.Y d_dith_en 0.21207f
C247 a_24258_20320# a_24540_20320# 0.04564f
C248 m2_6409_30900# vo_p 0.17925f
C249 a_2208_28397# dsm2_io_0.do_trim_b[0] 0.0168f
C250 d_amp_s[1] d_dith[1] 0.07365f
C251 d_amp_s_b[3] d_amp_s[2] 0.24139f
C252 d_amp_s[3] d_amp_s_b[2] 0.13041f
C253 sw_tgate_11.gb sw_tgate_10.p 0.03292f
C254 a_2034_14038# d_qclk 0.01678f
C255 quantizer2_lfsr_0.di_dith_amp[0] a_522_15478# 0.03646f
C256 a_1407_15314# a_1322_14546# 0.03546f
C257 a_9451_7241# a_9721_7200# 0.18796f
C258 a_558_2286# a_522_2184# 0.25046f
C259 a_20758_20180# d_ena 0.01376f
C260 clk_noverlap_0.sg13cmos5l_inv_1_3.Y vdd 0.2896f
C261 quantizer2_lfsr_0.sg13cmos5l_dfrbpq_1_11.D quantizer2_lfsr_0.sg13cmos5l_dfrbpq_1_2.Q 0.01477f
C262 a_5176_31469# vdd 19.8272f
C263 clk_noverlap_0.sg13cmos5l_dlygate4sd3_1_0.A clk_noverlap_0.sg13cmos5l_nor3_1_0.C 0.17865f
C264 a_22138_15146# vdd 0.01717f
C265 a_2208_22253# a_2208_21485# 0.05462f
C266 a_2045_8480# di_clk_sel 0.01398f
C267 clk_noverlap_0.di_clk dsm2_osc_0.di_clk_ext 0.2417f
C268 a_2045_5888# di_osc_en 0.01243f
C269 quantizer2_lfsr_0.sg13cmos5l_dfrbpq_1_11.D a_1367_1349# 0.17977f
C270 a_15496_5586# vdd 0.52911f
C271 bias_gm_0.bias_trim_0.vz a_19984_17824# 6.32984f
C272 xsc_vc1l_n d_ena 0.01502f
C273 a_1367_11717# vdd 0.52277f
C274 sg13cmos5l_nor2_1_0.Y d_rst_b 0.04106f
C275 sg13cmos5l_inv_1_8.Y inv_en_0.di_b 0.05607f
C276 m2_10908_16655# d_phi2 0.13589f
C277 a_24540_20320# a_24626_20320# 0.01899f
C278 xsc_vfb d_phi2 0.03732f
C279 sg13cmos5l_inv_2_0.Y d_dith_en 0.07674f
C280 sw_tgate_9.gb d_qi 0.30624f
C281 a_22252_5274# vdd 3.2199f
C282 a_2045_11072# a_2083_10020# 0.07823f
C283 a_2034_11112# a_2070_9446# 0.26205f
C284 dsm2_io_0.do_trim_b[0] a_23328_9146# 0.97393f
C285 vdd d_qi 4.93945f
C286 sg13cmos5l_inv_1_12.Y vdd 0.36963f
C287 a_20758_20040# d_ena 0.01376f
C288 sg13cmos5l_or2_1_0.X do_q_b 0.02639f
C289 a_522_15144# a_571_14052# 0.24435f
C290 a_24540_22000# a_24626_22140# 0.01899f
C291 sg13cmos5l_inv_1_3.Y d_amp_s[1] 0.31435f
C292 a_22252_8246# vdd 4.44448f
C293 a_8969_7224# clk_noverlap_0.sg13cmos5l_dlygate4sd3_1_4.X 0.12324f
C294 d_qout_en d_amp_s[0] 3.77863f
C295 d_dith_en d_amp_s_b[2] 0.45455f
C296 sg13cmos5l_inv_1_6.Y sg13cmos5l_nand2_1_2.Y 0.07259f
C297 quantizer2_lfsr_0.sg13cmos5l_dfrbpq_1_11.D a_562_16373# 0.02504f
C298 a_522_8085# a_522_7702# 0.09257f
C299 sg13cmos5l_inv_1_6.A sg13cmos5l_inv_1_13.A 0.16934f
C300 sw_tgate_12.m d_phi2 0.8431f
C301 do_q_b di_clk_sel 0.01185f
C302 quantizer2_lfsr_0.sg13cmos5l_dfrbpq_1_2.D a_1324_11172# 0.02703f
C303 vo_n d_qclk 0.01335f
C304 a_2038_15217# d_qclk 0.01134f
C305 sg13cmos5l_inv_1_3.A sg13cmos5l_inv_1_19.Y 0.08705f
C306 sg13cmos5l_or2_1_0.X sg13cmos5l_inv_2_5.A 0.09345f
C307 a_19949_784# dsm2_osc_0.sg13cmos5l_buf_2_0.A 0.22724f
C308 clk_noverlap_0.di_clk do_clk_osc 0.01761f
C309 a_24626_20320# a_28126_20180# 0.01899f
C310 quantizer2_lfsr_0.di_dith_amp[1] a_1284_15759# 0.01574f
C311 quantizer2_lfsr_0.sg13cmos5l_dfrbpq_1_9.D a_522_5493# 0.11703f
C312 sw_tgate_11.gb xsc_vc1l_n 0.74133f
C313 sg13cmos5l_inv_1_9.Y sg13cmos5l_nor2_2_0.B 0.01979f
C314 bias_gm_0.bias_trim_0.vz dsm2_osc_0.ibias_in 0.03023f
C315 sg13cmos5l_inv_1_9.Y d_amp_s[3] 0.01349f
C316 sg13cmos5l_inv_1_5.Y do_q 0.1622f
C317 sg13cmos5l_inv_1_3.A sg13cmos5l_and2_1_5.A 0.01891f
C318 a_12445_30191# vo_p 0.03505f
C319 a_8969_7224# vdd 0.1602f
C320 a_2083_4836# a_2070_4262# 0.18486f
C321 a_533_4736# a_537_3813# 0.36374f
C322 a_1324_8580# d_qclk 0.07676f
C323 d_rst_b d_amp_s_b[2] 0.08669f
C324 sg13cmos5l_inv_1_9.Y a_14849_15078# 0.01869f
C325 a_5176_30111# xsc_vvg_n 0.06796f
C326 sg13cmos5l_nor2_2_0.B sg13cmos5l_and2_2_1.X 0.04453f
C327 sg13cmos5l_nor2_2_0.B sg13cmos5l_inv_1_2.Y 0.03214f
C328 dsm2_io_0.do_trim_b[0] dsm2_osc_0.d_btest_or 0.67349f
C329 sg13cmos5l_inv_1_4.Y d_qout_en 0.01876f
C330 a_1284_7983# vdd 0.17139f
C331 dsm2_io_vcmg_0.di_vcm_ext_b a_2034_11112# 0.01144f
C332 a_28126_20180# a_24626_20180# 0.01899f
C333 a_20672_20180# a_20672_19900# 0.04477f
C334 quantizer2_lfsr_0.sg13cmos5l_dfrbpq_1_11.D quantizer2_lfsr_0.sg13cmos5l_dfrbpq_1_9.D 0.02634f
C335 a_1286_14615# vdd 0.24646f
C336 m2_10908_16655# di_clk_sel 0.01205f
C337 quantizer2_lfsr_0.sg13cmos5l_nor2_1_1.B vdd 0.33911f
C338 sg13cmos5l_nand2_1_2.Y vo_p 0.05565f
C339 dsm2_osc_0.sg13cmos5l_mux2_1_0.A1 a_20770_598# 0.32253f
C340 quantizer2_lfsr_0.sg13cmos5l_dfrbpq_1_2.D a_1284_2901# 0.01324f
C341 a_2208_26861# vdd 0.55868f
C342 a_21252_3394# a_22252_5274# 0.12181f
C343 a_1322_1586# a_1286_1655# 0.36396f
C344 sg13cmos5l_inv_1_4.A d_dith_en 0.13459f
C345 a_1324_804# vdd 0.08795f
C346 dsm2_io_0.do_trim_b[0] a_23328_5574# 0.97393f
C347 dsm2_io_0.dsm2_io_rx_9.di_b a_670_25288# 0.02023f
C348 a_12395_9628# a_12395_9488# 0.19806f
C349 sg13cmos5l_inv_1_4.A xq_vg_q_0_ 0.30733f
C350 dsm2_io_0.do_trim_b[3] a_22252_8246# 0.03484f
C351 a_21252_3394# a_22252_8246# 0.04261f
C352 a_20758_22000# a_20758_21860# 0.84953f
C353 a_1284_15759# a_1324_13764# 0.01412f
C354 quantizer2_lfsr_0.sg13cmos5l_dfrbpq_1_4.Q d_qclk 0.01535f
C355 quantizer2_lfsr_0.di_dith_amp[0] quantizer2_lfsr_0.sg13cmos5l_dfrbpq_1_13.D 0.04386f
C356 clk_noverlap_0.sg13cmos5l_dlygate4sd3_1_0.A clk_noverlap_0.sg13cmos5l_inv_1_5.Y 0.0326f
C357 clk_noverlap_0.sg13cmos5l_inv_1_11.Y clk_noverlap_0.sg13cmos5l_inv_1_10.A 0.15818f
C358 sg13cmos5l_or2_1_0.X d_amp_s_b[1] 0.01787f
C359 m2_10908_16863# d_qi_b 0.07254f
C360 sg13cmos5l_inv_1_20.Y sg13cmos5l_inv_1_0.Y 0.04917f
C361 sg13cmos5l_inv_1_6.Y vdd 0.4875f
C362 a_16832_5586# d_phi2 0.03045f
C363 a_2070_6030# d_dith_en 0.01045f
C364 sg13cmos5l_nand2_1_5.A d_ena 0.14341f
C365 d_vcm_phi2 di_osc_en 0.03249f
C366 sg13cmos5l_inv_1_9.Y d_dith_en 0.04519f
C367 sg13cmos5l_inv_1_9.Y xq_vg_q_0_ 0.06441f
C368 sg13cmos5l_inv_1_1.A xq_dith_v_bp 0.84828f
C369 a_20758_20180# a_20758_20040# 0.84953f
C370 a_14849_15078# a_15130_14856# 0.18796f
C371 a_8747_8468# d_amp_s[0] 0.02047f
C372 sg13cmos5l_inv_1_0.Y a_14734_15077# 0.01686f
C373 sw_tgate_6.p d_ena 0.05851f
C374 a_2070_12038# d_qclk 0.02632f
C375 sg13cmos5l_inv_1_6.A inv_en_0.di_b 0.11909f
C376 xsc_vc1r_p vo_n 0.0311f
C377 a_1322_1586# a_1600_1349# 0.07823f
C378 a_567_786# vdd 0.09499f
C379 sg13cmos5l_and2_2_1.X d_dith_en 0.02787f
C381 xsc_vfb ibias_200n 0.0395f
C382 sg13cmos5l_inv_1_2.Y d_dith_en 0.01627f
C383 a_22252_11246# a_24626_21160# 0.01579f
C384 a_28334_22000# a_28334_21860# 0.1335f
C385 a_1324_3396# a_1286_4247# 0.28324f
C386 sg13cmos5l_and2_2_1.X xq_vg_q_0_ 0.0203f
C387 sg13cmos5l_inv_1_6.Y sg13cmos5l_inv_1_16.Y 5.57653f
C388 a_27029_22964# ibias_200n 0.01045f
C389 a_5131_7241# d_qclk 0.01132f
C390 sg13cmos5l_inv_1_11.Y vdd 0.37025f
C391 a_2034_6262# vdd 0.1679f
C392 a_11115_8608# a_11201_8748# 0.01899f
C393 a_8747_8748# a_8747_8608# 0.48787f
C394 a_13211_8748# a_13211_8468# 0.04477f
C395 xq_dith_v_bq d_amp_s[0] 0.09669f
C396 clk_noverlap_0.sg13cmos5l_inv_1_1.A clk_noverlap_0.sg13cmos5l_inv_1_11.Y 0.1425f
C397 sg13cmos5l_inv_1_1.A do_q 0.03075f
C398 sg13cmos5l_inv_1_13.Y sg13cmos5l_inv_1_14.A 0.02271f
C399 sg13cmos5l_inv_1_20.Y xq_vg_p_1_ 0.03667f
C400 a_11841_7467# d_phi2 0.06311f
C401 a_28334_20180# a_28334_20040# 0.1335f
C402 a_24258_20040# a_24258_19760# 0.04477f
C403 sg13cmos5l_inv_1_19.Y sg13cmos5l_inv_1_3.Y 0.10536f
C404 xq_vg_q_0_ a_9883_9488# 0.01506f
C405 sw_tgate_8.m d_phi1 0.56035f
C406 a_11201_8188# d_amp_s[0] 0.07965f
C407 d_phi1 d_dith[0] 0.02604f
C408 quantizer2_lfsr_0.sg13cmos5l_dfrbpq_1_0.D a_2038_15217# 0.15474f
C409 a_2208_22253# vdd 0.54184f
C410 a_24626_21720# dsm2_osc_0.d_btest_or 0.01657f
C411 vdd vo_p 16.275f
C412 sg13cmos5l_or2_1_0.X sg13cmos5l_inv_2_5.Y 0.03419f
C413 d_ena do_q_b 0.08326f
C414 a_1286_1655# a_1288_778# 0.02241f
C415 xsc_vc1l_p sw_tgate_12.m 1.46425f
C416 sg13cmos5l_nand2_1_5.A a_8208_15626# 0.01175f
C417 sg13cmos5l_inv_1_1.A a_13870_15077# 0.02643f
C418 sg13cmos5l_or2_1_0.X sg13cmos5l_inv_1_18.Y 0.01419f
C419 sg13cmos5l_inv_1_3.Y sg13cmos5l_and2_1_5.A 0.02854f
C420 a_12395_9488# a_11201_9308# 0.14662f
C421 sw_tgate_11.gb sw_tgate_6.p 0.49497f
C422 a_22252_11246# a_24626_21020# 0.01575f
C423 di_btest_en di_dith_amp[0] 0.11625f
C424 a_522_10677# d_dith_en 0.01918f
C425 a_571_6276# a_558_5702# 0.18486f
C426 a_2034_9237# vdd 0.27895f
C427 a_522_7702# a_558_7470# 0.16704f
C428 a_1284_7983# a_1407_7538# 0.23043f
C429 a_8661_8468# a_8747_8468# 0.01899f
C430 a_11115_8608# a_11115_8328# 0.04477f
C431 quantizer2_lfsr_0.di_dith_amp[0] quantizer2_lfsr_0.sg13cmos5l_dfrbpq_1_1.Q 0.04418f
C432 quantizer2_lfsr_0.di_dith_amp[0] di_osc_en 0.52935f
C433 dsm2_io_vcmg_0.di_phi1_b clk_noverlap_0.di_clk 0.13346f
C434 a_20138_14766# d_ena 0.72865f
C435 a_558_5702# d_dith_en 0.12517f
C436 dsm2_osc_0.d_btest_or a_22386_2578# 0.01498f
C437 vcm_esd d_dith[0] 0.93787f
C438 sg13cmos5l_inv_1_16.Y vo_p 0.03489f
C439 a_1600_9125# a_1367_9125# 0.18486f
C440 sg13cmos5l_and2_1_5.B do_q 0.01661f
C441 do_q_b di_osc_en 0.01851f
C442 a_21617_558# dsm2_osc_0.sg13cmos5l_dfrbp_1_0.Q_N 0.10828f
C443 quantizer2_lfsr_0.sg13cmos5l_dfrbpq_1_2.D a_1286_1655# 0.04569f
C444 a_24626_21580# dsm2_osc_0.d_btest_or 0.01657f
C445 a_10757_8328# d_amp_s_b[0] 0.0218f
C446 dsm2_osc_0.sg13cmos5l_dfrbp_1_0.RESET_B vdd 2.51163f
C447 sg13cmos5l_nor2_2_0.Y d_qout_en 0.01166f
C448 a_10757_9168# a_8747_9168# 0.01899f
C449 sg13cmos5l_inv_1_0.A sg13cmos5l_inv_1_0.Y 0.15499f
C450 a_20000_21720# a_20000_21580# 0.1335f
C451 a_24540_21720# a_24540_21440# 0.04477f
C452 vo_p d_amp_s_b[0] 0.84237f
C453 sg13cmos5l_inv_1_8.Y d_dith_en 0.09888f
C454 m2_10908_16655# d_ena 0.02936f
C455 dsm2_io_vcmg_0.di_vcm_ext d_amp_s_b[3] 0.02207f
C456 dsm2_io_0.sg13cmos5l_inv_1_0.A a_2208_19085# 0.01958f
C457 dsm2_io_0.do_btest_en sg13cmos5l_nor2_1_0.Y 0.05541f
C458 a_10757_8328# a_11115_8328# 0.03425f
C459 xq_vg_q_0_ xq_vg_p_0_ 0.01744f
C460 a_522_10294# a_1284_10575# 0.01202f
C461 a_9352_5586# xvcm_vcf_b 0.01281f
C462 sg13cmos5l_inv_1_3.A d_dith[1] 0.01979f
C463 quantizer2_lfsr_0.sg13cmos5l_dfrbpq_1_2.Q d_dith[1] 0.29316f
C464 dsm2_osc_0.d_btest_or a_22644_2344# 0.03717f
C465 a_20000_19900# a_20000_19760# 0.1335f
C466 dsm2_io_0.do_trim_b[2] a_2208_21485# 0.05448f
C467 dsm2_io_0.do_trim_b[3] vo_p 0.03114f
C468 sw_tgate_8.m d_phi2 0.20891f
C469 dsm2_osc_0.sg13cmos5l_dfrbp_1_0.CLK vi_esd 0.0357f
C470 a_2034_13874# d_dith_en 0.10448f
C471 bias_gm_0.bias_trim_0.vz ibias_200n 1.41162f
C472 a_8880_5832# d_vcm_phi1_b 0.11488f
C473 a_2034_698# d_dith[0] 0.16125f
C474 sw_tgate_12.m d_ena 0.05851f
C475 dsm2_osc_0.sg13cmos5l_dfrbp_1_0.CLK dsm2_osc_0.sg13cmos5l_dfrbp_1_0.Q_N 0.05636f
C476 sw_tgate_6.p xsc_vc1l_n 1.46453f
C477 clk_noverlap_0.di_clk do_osc_oe 0.16086f
C478 m2_10908_16655# di_osc_en 0.01862f
C479 a_11201_9168# a_13211_9028# 0.01899f
C480 a_8747_9168# a_8747_9028# 0.48787f
C481 dsm2_io_0.sg13cmos5l_inv_1_6.A d_rst_b 0.06298f
C482 a_24626_21720# a_24626_21580# 0.84953f
C483 clk_noverlap_0.di_clk d_phi1 0.64898f
C484 a_522_2184# d_qclk 0.08085f
C485 sg13cmos5l_inv_1_13.Y do_q_b 1.66417f
C486 d_ena d_amp_s_b[1] 0.35442f
C487 sg13cmos5l_inv_1_1.A xq_vg_p_2_ 0.30538f
C488 a_24404_8546# ibias_200n 0.60782f
C489 a_522_10294# a_533_9920# 0.17382f
C490 a_2049_10149# a_2070_9446# 0.02431f
C491 a_8747_8328# a_8747_8188# 0.48787f
C492 a_14728_5586# xvcm_vcf_b 0.02352f
C493 dsm2_io_0.sg13cmos5l_inv_1_3.A quantizer2_lfsr_0.di_dith_amp[1] 0.07039f
C494 a_2208_29933# d_ena 0.03761f
C495 sg13cmos5l_and2_1_5.X do_q 0.0232f
C496 clk_noverlap_0.di_clk dsm2_osc_0.ibias_in 0.2086f
C497 xsc_vfb sw_tgate_11.gb 0.67039f
C498 sg13cmos5l_inv_1_13.Y a_11201_9948# 0.03851f
C499 a_1324_5988# vdd 0.07233f
C500 dsm2_io_0.sg13cmos5l_inv_1_5.A di_osc_en 0.01596f
C501 a_24626_19900# a_24626_19760# 0.84953f
C502 a_2034_9237# a_2034_8854# 0.09257f
C503 a_6817_30111# xsc_vvg_p 0.11883f
C504 inv_en_0.di_b d_qi 0.04807f
C505 inv_en_0.di_b sg13cmos5l_inv_1_12.Y 0.1017f
C506 sg13cmos5l_inv_1_6.Y sg13cmos5l_inv_1_13.A 0.06784f
C507 a_21252_3394# dsm2_osc_0.sg13cmos5l_dfrbp_1_0.RESET_B 0.02525f
C508 a_21554_2798# a_21478_2578# 0.0464f
C509 a_2045_13664# d_dith_en 0.28871f
C510 dsm2_osc_0.sg13cmos5l_dfrbp_1_0.Q_N a_22347_812# 0.03634f
C511 quantizer2_lfsr_0.di_dith_amp[1] d_amp_s_b[3] 0.02955f
C512 sg13cmos5l_inv_1_3.A sg13cmos5l_inv_1_3.Y 0.86584f
C513 dsm2_osc_0.sg13cmos5l_mux2_1_0.A1 m2_10908_16655# 0.02589f
C514 d_phi1 do_q_dec 0.0152f
C515 sg13cmos5l_nor2_1_0.Y d_qout_en 0.01768f
C516 clk_noverlap_0.di_clk vcm_esd 0.18192f
C517 clk_noverlap_0.do_phi2_b d_phi2 0.0951f
C518 dsm2_io_vcmg_0.di_vcm_ext quantizer2_lfsr_0.sg13cmos5l_dfrbpq_1_15.D 0.03059f
C519 a_28126_21580# a_28126_21300# 0.04477f
C520 sg13cmos5l_or2_1_0.X sg13cmos5l_nor2_2_2.A 0.05882f
C521 a_2045_5888# a_2049_4965# 0.36374f
C522 a_1322_1586# d_qclk 0.04061f
C523 a_2208_26861# a_2208_26093# 0.05462f
C524 sg13cmos5l_inv_1_3.Y a_11201_8608# 0.01043f
C525 a_670_25288# vdd 0.07773f
C526 a_2070_9446# d_dith_en 0.08507f
C527 sw_tgate_11.gb sw_tgate_12.m 0.03673f
C528 sg13cmos5l_nand2_2_0.B sg13cmos5l_inv_1_20.Y 0.02522f
C529 dsm2_io_vcmg_0.di_vcm_ext_b d_amp_s[3] 0.05351f
C530 a_8880_5832# m2_10908_16863# 0.01107f
C531 a_4537_7200# vdd 0.22273f
C532 a_1322_14546# a_1600_14309# 0.07823f
C533 a_7224_31505# d_ena 0.10588f
C534 sg13cmos5l_or2_1_0.X d_dith[0] 0.31587f
C535 sw_tgate_cmfb2_3.gb xsc_vc1r_p 0.06246f
C536 dsm2_io_0.sg13cmos5l_inv_1_4.A a_2208_20141# 0.01952f
C537 xsc_vvg_p sw_tgate_cmfb2_3.gb 0.11788f
C538 a_537_14181# d_dith_en 0.04439f
C539 a_20672_19620# a_20758_19620# 0.01899f
C540 xq_vg_p_1_ vo_n 1.17378f
C541 dsm2_io_vcmg_0.di_vcm_ext a_1324_8580# 0.02128f
C542 a_537_3813# d_qclk 0.21605f
C543 a_22738_2578# a_22184_2052# 0.03463f
C544 dsm2_osc_0.sg13cmos5l_dfrbp_1_0.RESET_B a_21276_2052# 0.14446f
C545 a_21554_2798# a_21736_2344# 0.24826f
C546 a_2045_3296# quantizer2_lfsr_0.sg13cmos5l_dfrbpq_1_11.Q 0.02747f
C547 a_21617_558# a_22258_594# 0.16704f
C548 vcm_esd do_q_dec 0.32389f
C549 sg13cmos5l_inv_1_18.Y d_ena 0.06727f
C550 d_dith[0] di_clk_sel 0.02773f
C551 d_phi1 d_qclk 0.35182f
C552 dsm2_osc_0.dsm2_io_rx_0.di_b vdd 0.67854f
C553 dsm2_io_vcmg_0.di_vcm_ext_b a_2049_10149# 0.01292f
C554 sg13cmos5l_nand2_1_5.A a_10989_15998# 0.04692f
C555 a_20672_21300# a_20758_21440# 0.01899f
C556 bias_gm_0.bias_trim_0.vz d_ena 0.2561f
C557 a_8880_5832# a_8392_5586# 0.01631f
C558 a_10787_14878# d_qi_b 0.01553f
C559 sg13cmos5l_inv_1_3.Y a_11201_8328# 0.01616f
C560 sg13cmos5l_inv_1_13.A vo_p 0.06801f
C561 a_522_15861# a_522_15478# 0.09257f
C562 sg13cmos5l_inv_1_6.A d_dith_en 0.07217f
C563 a_10784_6484# d_ena 0.21807f
C564 xq_vg_q_2_ a_6757_9948# 0.07705f
C565 quantizer2_lfsr_0.sg13cmos5l_dfrbpq_1_5.Q a_2034_14421# 0.02785f
C566 a_1284_10575# a_1681_9745# 0.16704f
C567 a_558_7470# a_522_7368# 0.25046f
C568 a_537_3813# a_567_3378# 0.02241f
C569 sg13cmos5l_inv_1_13.Y d_amp_s_b[1] 0.1087f
C570 sg13cmos5l_inv_1_6.A xq_vg_q_0_ 0.03238f
C571 quantizer2_lfsr_0.sg13cmos5l_dfrbpq_1_11.Q d_dith[2] 0.01193f
C572 dsm2_io_0.do_trim_b[2] a_22252_8546# 0.09512f
C573 dsm2_osc_0.sg13cmos5l_inv_1_2.Y do_clk_osc 0.16278f
C574 a_1284_15759# vdd 0.17359f
C575 d_qout_en d_amp_s_b[2] 0.04038f
C576 a_20758_19620# a_24258_19480# 0.01899f
C577 a_2070_13806# a_2049_12741# 0.01058f
C578 a_2034_13704# a_2045_13664# 0.20759f
C579 a_1367_3941# vdd 0.52277f
C580 dsm2_io_vcmg_0.di_vcm_ext_b d_dith_en 0.41045f
C581 sg13cmos5l_inv_1_14.A do_q_b 0.02927f
C582 vcm_esd d_qclk 0.17225f
C583 a_22499_864# a_23195_985# 0.02431f
C584 clk_noverlap_0.sg13cmos5l_dlygate4sd3_1_0.A clk_noverlap_0.sg13cmos5l_inv_1_11.Y 0.13682f
C585 clk_noverlap_0.sg13cmos5l_dlygate4sd3_1_0.A a_5995_7241# 0.03228f
C586 clk_noverlap_0.sg13cmos5l_dlygate4sd3_1_0.X a_5131_7241# 0.30507f
C587 sg13cmos5l_nor2_1_0.Y sg13cmos5l_and2_1_4.X 0.01134f
C588 sg13cmos5l_inv_1_6.Y inv_en_0.di_b 0.16863f
C589 a_2208_23789# d_ena 0.06128f
C590 clk_noverlap_0.do_phi2_b di_clk_sel 0.03996f
C591 vi_esd do_clk_osc 0.02215f
C592 a_2083_10020# a_2070_9446# 0.18486f
C593 quantizer2_lfsr_0.sg13cmos5l_dfrbpq_1_0.D a_522_2184# 0.01816f
C594 a_1286_4247# a_1600_3941# 0.01562f
C595 dsm2_osc_0.sg13cmos5l_dfrbp_1_0.Q_N do_clk_osc 0.25475f
C596 sg13cmos5l_inv_2_5.A sg13cmos5l_inv_1_14.A 0.1373f
C597 dsm2_io_0.do_btest_en dsm2_osc_0.sg13cmos5l_buf_2_0.A 0.07812f
C598 quantizer2_lfsr_0.sg13cmos5l_dfrbpq_1_2.D a_1286_6839# 0.01608f
C599 a_24258_19480# a_20758_19480# 0.01899f
C600 a_522_4946# d_dith_en 0.1175f
C601 quantizer2_lfsr_0.sg13cmos5l_dfrbpq_1_0.Q a_1322_1586# 0.03529f
C602 a_2034_3506# vdd 0.13465f
C603 a_22368_558# a_23150_752# 0.24435f
C604 sg13cmos5l_nand2_1_5.A do_q_b 0.09704f
C605 inv_en_0.di_b sg13cmos5l_inv_1_11.Y 0.13952f
C606 a_13101_7164# d_phi2 0.05817f
C607 sg13cmos5l_nand2_2_0.B sg13cmos5l_inv_1_0.A 0.01432f
C608 clk_noverlap_0.sg13cmos5l_dlygate4sd3_1_7.A a_14433_7467# 0.12324f
C609 quantizer2_lfsr_0.sg13cmos5l_dfrbpq_1_2.D d_qclk 0.74359f
C610 a_24258_21160# a_24540_21160# 0.04564f
C611 sg13cmos5l_and2_1_5.A do_q 0.01921f
C612 a_10132_15186# d_qi 0.03572f
C613 a_10757_8608# d_amp_s_b[2] 0.02312f
C614 sg13cmos5l_inv_1_13.Y sg13cmos5l_inv_1_18.Y 0.30759f
C615 dsm2_io_0.do_trim_b[2] vdd 6.5861f
C616 sg13cmos5l_inv_1_4.A d_qout_en 0.02918f
C617 xsc_vc1r_p d_phi1 0.44128f
C618 clk_noverlap_0.di_clk di_clk_sel 0.10556f
C619 dsm2_io_0.sg13cmos5l_inv_1_6.A di_rst_b 0.18482f
C620 a_533_15104# vdd 0.20451f
C621 quantizer2_lfsr_0.sg13cmos5l_dfrbpq_1_2.Q a_2034_4053# 0.11213f
C622 a_20758_21860# d_ena 0.01376f
C623 d_amp_s[1] d_dith[2] 0.21306f
C624 xsc_vvg_p d_phi1 0.14184f
C625 xvcm_vcf_t vcm_esd 1.12623f
C626 sg13cmos5l_nand2_1_2.Y sg13cmos5l_inv_1_20.Y 0.79258f
C627 sg13cmos5l_and2_1_5.A a_13870_15077# 0.12387f
C628 sg13cmos5l_nor2_2_0.B d_qi 0.31461f
C629 a_20000_19480# a_20000_19340# 0.1335f
C630 sg13cmos5l_or2_1_0.X do_q_dec 1.42342f
C631 a_1284_13269# a_1284_13167# 0.09257f
C632 a_522_12886# a_522_12722# 0.23043f
C633 a_20758_20180# bias_gm_0.bias_trim_0.vz 0.01087f
C634 a_522_7368# d_qclk 0.04936f
C635 a_21276_2052# dsm2_osc_0.dsm2_io_rx_0.di_b 0.38971f
C636 a_19105_884# do_q_b 0.01346f
C637 sg13cmos5l_inv_1_16.A xq_vg_q_2_ 0.04256f
C638 quantizer2_lfsr_0.sg13cmos5l_dfrbpq_1_0.D a_537_3813# 0.01125f
C639 a_24540_21160# a_24626_21160# 0.01899f
C640 do_q_dec di_clk_sel 0.04962f
C641 a_11865_14889# d_qi 0.01101f
C642 xsc_vc1r_p vcm_esd 0.47293f
C643 sw_tgate_8.m d_ena 0.0585f
C644 d_ena d_dith[0] 0.32982f
C645 a_1324_8580# a_1286_9431# 0.28324f
C646 a_1322_6770# a_1286_6839# 0.36396f
C647 xsc_vvg_p vcm_esd 0.08188f
C648 sg13cmos5l_nor2_2_0.Y d_qi_b 0.20751f
C649 a_20758_21720# d_ena 0.01376f
C650 a_28334_19480# a_28334_19340# 0.1335f
C651 sg13cmos5l_or2_1_0.X d_qclk 0.01851f
C652 a_1284_13167# a_1407_12722# 0.23043f
C653 a_522_12886# a_522_12552# 0.01412f
C654 a_2049_12741# a_2083_12612# 0.01562f
C655 a_20758_20040# bias_gm_0.bias_trim_0.vz 0.01252f
C656 quantizer2_lfsr_0.sg13cmos5l_dfrbpq_1_0.Q a_1288_778# 0.01995f
C657 xq_dith_v_bq d_amp_s_b[2] 0.11911f
C658 sg13cmos5l_or2_1_0.X d_amp_s[2] 0.03679f
C659 a_1367_11717# d_dith_en 0.11326f
C660 sg13cmos5l_inv_1_16.A sg13cmos5l_inv_1_1.A 0.03211f
C661 a_1322_6770# d_qclk 0.04448f
C662 di_ena di_clk_sel 0.02985f
C663 sg13cmos5l_inv_1_17.Y xq_vg_q_2_ 0.19881f
C664 a_19576_826# vdd 0.0712f
C665 a_9556_15186# vdd 0.30385f
C666 a_24626_21160# a_28126_21020# 0.01899f
C667 sg13cmos5l_inv_2_5.A do_q_b 0.01548f
C668 a_21681_1704# vdd 0.28746f
C669 sg13cmos5l_inv_1_3.A xq_dith_v_bp 0.33638f
C670 d_qclk di_clk_sel 0.21697f
C671 dsm2_io_0.do_trim_b[2] dsm2_io_0.do_trim_b[3] 15.5605f
C672 dsm2_io_0.do_trim_b[2] a_21252_3394# 0.18037f
C673 sg13cmos5l_inv_1_2.A vdd 2.669f
C674 d_dith[0] di_osc_en 0.02991f
C675 d_dith_en d_qi 0.13379f
C676 sg13cmos5l_nand2_1_2.Y xq_vg_q_1_ 0.2954f
C677 dsm2_osc_0.d_btest_or do_q 0.0364f
C678 dsm2_osc_0.ibias_in a_23674_2344# 0.02843f
C679 xsc_vc1r_p d_phi2 0.46387f
C680 a_22258_594# do_clk_osc 0.03008f
C681 quantizer2_lfsr_0.sg13cmos5l_nor2_1_1.B d_amp_s[3] 0.2888f
C682 a_19999_23104# a_19999_22964# 0.4505f
C683 xsc_vvg_p d_phi2 0.60205f
C684 clk_noverlap_0.do_phi2_b d_ena 0.06432f
C685 sg13cmos5l_inv_1_19.Y xq_vg_p_2_ 0.20545f
C686 sg13cmos5l_inv_1_20.Y vdd 0.34716f
C687 sw_tgate_11.gb sw_tgate_8.m 0.48578f
C688 a_9451_7241# d_qclk 0.01106f
C689 m2_10908_16655# do_q_b 0.04397f
C690 quantizer2_lfsr_0.sg13cmos5l_dfrbpq_1_2.D quantizer2_lfsr_0.sg13cmos5l_dfrbpq_1_0.Q 0.43902f
C691 di_trim[3] di_btest_en 0.11257f
C692 sg13cmos5l_inv_2_5.Y sg13cmos5l_inv_1_14.A 0.03695f
C693 a_558_4878# d_dith_en 0.01118f
C694 sg13cmos5l_inv_1_17.Y sg13cmos5l_inv_1_1.A 0.06179f
C695 dsm2_io_vcmg_0.di_vcm_ext dsm2_io_vcmg_0.di_phi1_b 0.31116f
C696 a_14734_15077# vdd 0.16048f
C697 sg13cmos5l_inv_1_16.Y sg13cmos5l_inv_1_2.A 0.04055f
C698 sg13cmos5l_inv_1_6.Y sg13cmos5l_nor2_2_0.B 0.01103f
C699 a_6757_9808# a_8747_9628# 0.14662f
C700 a_526_16657# quantizer2_lfsr_0.sg13cmos5l_dfrbpq_1_1.Q 0.27391f
C701 a_22252_11246# a_20260_17236# 0.08823f
C702 a_28126_21020# a_24626_21020# 0.01899f
C703 a_20672_21020# a_20672_20740# 0.04477f
C704 a_16161_7467# d_phi2 0.04955f
C705 sg13cmos5l_inv_1_16.A sg13cmos5l_and2_1_5.B 0.02199f
C706 a_2034_5928# quantizer2_lfsr_0.sg13cmos5l_dfrbpq_1_2.Q 0.01091f
C707 d_rst_b d_qi 0.04892f
C708 sg13cmos5l_inv_1_19.Y a_8302_15626# 0.01326f
C709 sg13cmos5l_inv_1_13.Y sg13cmos5l_nor2_2_2.A 0.0155f
C710 a_19964_18216# a_28746_16046# 0.06888f
C711 quantizer2_lfsr_0.sg13cmos5l_dfrbpq_1_2.D quantizer2_lfsr_0.sg13cmos5l_dfrbpq_1_0.D 0.02595f
C712 sg13cmos5l_inv_1_20.Y sg13cmos5l_inv_1_16.Y 0.01167f
C713 quantizer2_lfsr_0.di_dith_amp[0] d_amp_s_b[1] 0.02247f
C714 sg13cmos5l_inv_1_16.Y a_8747_9488# 0.0122f
C715 a_21977_22824# a_22063_22964# 0.01899f
C716 a_10483_7459# clk_noverlap_0.sg13cmos5l_inv_1_5.Y 0.2392f
C717 sg13cmos5l_inv_1_13.Y d_dith[0] 0.01893f
C718 clk_noverlap_0.di_clk d_ena 2.88887f
C719 sg13cmos5l_inv_1_10.Y sg13cmos5l_inv_1_20.Y 0.02404f
C720 dsm2_osc_0.ibias_pad ibias_test 0.1925f
C721 xvcm_vcf_t di_clk_sel 0.01611f
C722 a_12445_30191# vo_n 0.3664f
C723 clk_noverlap_0.sg13cmos5l_dlygate4sd3_1_0.X d_phi1 0.01287f
C724 a_2034_6098# a_2045_5888# 0.03546f
C725 quantizer2_lfsr_0.sg13cmos5l_dfrbpq_1_1.Q a_522_15861# 0.07905f
C726 a_1284_7983# d_dith_en 0.11034f
C727 a_1286_14615# d_dith_en 0.04014f
C728 clk_noverlap_0.sg13cmos5l_nor3_1_0.C clk_noverlap_0.sg13cmos5l_inv_1_1.Y 0.01395f
C729 sg13cmos5l_inv_1_9.Y xq_dith_v_bq 0.17528f
C730 quantizer2_lfsr_0.sg13cmos5l_nor2_1_1.B d_dith_en 0.028f
C731 a_21736_2344# a_21830_2088# 0.08402f
C732 a_522_15478# quantizer2_lfsr_0.sg13cmos5l_dfrbpq_1_0.D 0.01794f
C733 a_21617_558# vdd 0.26719f
C734 a_11201_9808# a_11259_9628# 0.14662f
C735 a_20758_21020# a_20758_20880# 0.84953f
C736 a_21554_2798# a_23294_2344# 0.03969f
C737 dsm2_osc_0.sg13cmos5l_dfrbp_1_0.RESET_B a_22738_2088# 0.01573f
C738 a_1324_804# d_dith_en 0.31245f
C739 quantizer2_lfsr_0.sg13cmos5l_dfrbpq_1_13.D d_qclk 0.05436f
C740 a_19964_18216# a_26670_15746# 0.05953f
C741 dsm2_io_0.sg13cmos5l_inv_1_3.A vdd 0.26753f
C742 xq_vg_q_1_ vdd 0.11216f
C743 quantizer2_lfsr_0.sg13cmos5l_dfrbpq_1_13.D d_amp_s[2] 0.01168f
C744 vdd di_clk 0.11693f
C745 a_10757_8328# d_amp_s[3] 0.02334f
C746 a_1284_5493# a_1284_5391# 0.09257f
C747 a_522_5110# a_522_4946# 0.23043f
C748 dsm2_io_vcmg_0.di_vcm_ext d_phi1 0.39905f
C749 xsc_vc1l_n sw_tgate_8.m 0.54536f
C750 quantizer2_lfsr_0.sg13cmos5l_dfrbpq_1_11.D a_533_12512# 0.0171f
C751 d_ena do_q_dec 2.16469f
C752 dsm2_io_vcmg_0.di_vcm_ext_b a_9352_5586# 0.01737f
C753 sg13cmos5l_inv_2_0.Y d_qi_b 0.08698f
C754 clk_noverlap_0.di_clk di_osc_en 4.20493f
C755 vo_p d_amp_s[3] 0.04024f
C756 sg13cmos5l_inv_1_6.Y d_dith_en 0.07261f
C757 sg13cmos5l_nand2_1_2.Y vo_n 0.05569f
C758 d_phi1 vi_esd 0.93211f
C759 dsm2_io_0.do_trim_b[1] a_24404_4674# 0.14521f
C760 a_1367_6533# vdd 0.52279f
C761 sg13cmos5l_inv_1_4.Y xq_vg_q_2_ 0.07129f
C762 sg13cmos5l_inv_1_6.Y xq_vg_q_0_ 0.02601f
C763 vdd d_amp_s_b[3] 0.95746f
C764 a_20138_14766# a_24214_15146# 0.06938f
C765 dsm2_io_0.do_trim_b[1] a_22252_8546# 0.01183f
C766 a_2034_14038# vdd 0.17043f
C767 a_2034_3670# d_qclk 0.01346f
C768 dsm2_osc_0.sg13cmos5l_inv_1_3.A a_23674_2344# 0.23763f
C769 quantizer2_lfsr_0.sg13cmos5l_dfrbpq_1_11.Q a_2070_1670# 0.01268f
C770 a_28334_21020# a_28334_20880# 0.1335f
C771 a_24258_20880# a_24258_20600# 0.04477f
C772 dsm2_osc_0.ibias_in vi_esd 0.02392f
C773 dsm2_osc_0.sg13cmos5l_dfrbp_1_0.RESET_B dsm2_osc_0.sg13cmos5l_inv_1_2.A 0.14718f
C774 sg13cmos5l_inv_1_16.Y xq_vg_q_1_ 0.02224f
C775 sg13cmos5l_inv_1_17.A xq_vg_q_2_ 0.07554f
C776 a_567_786# d_dith_en 0.20883f
C777 sg13cmos5l_inv_1_3.Y xq_dith_v_bp 0.25583f
C778 a_6817_30111# m2_6409_30900# 1.54612f
C779 dsm2_osc_0.sg13cmos5l_dfrbp_1_0.CLK vdd 0.37167f
C780 dsm2_osc_0.ibias_in dsm2_osc_0.sg13cmos5l_dfrbp_1_0.Q_N 0.02274f
C781 d_ena di_ena 0.06404f
C782 sg13cmos5l_inv_1_0.A vdd 0.35896f
C783 sg13cmos5l_inv_2_5.Y do_q_b 0.01348f
C784 quantizer2_lfsr_0.sg13cmos5l_dfrbpq_1_0.D di_clk_sel 0.02513f
C785 a_8661_8748# a_8747_8888# 0.01899f
C786 a_11201_9028# a_11201_8888# 0.48787f
C787 a_5513_7224# clk_noverlap_0.sg13cmos5l_dlygate4sd3_1_1.X 0.12324f
C788 do_q_dec di_osc_en 0.02852f
C789 clk_noverlap_0.sg13cmos5l_dlygate4sd3_1_0.A a_7241_7224# 0.02784f
C790 dsm2_io_vcmg_0.di_vcm_ext vcm_esd 0.04543f
C791 sg13cmos5l_inv_1_16.Y a_8747_9168# 0.01227f
C792 a_24258_22824# a_24626_22824# 0.0182f
C793 a_2034_6262# d_dith_en 0.1475f
C794 a_27856_874# ibias_test 0.05732f
C795 d_ena d_qclk 0.33529f
C796 sg13cmos5l_inv_1_6.Y d_rst_b 0.14954f
C797 dsm2_io_vcmg_0.di_vcm_ext_b a_14728_5586# 0.01736f
C798 sg13cmos5l_inv_1_16.Y d_amp_s_b[3] 0.029f
C799 vcm_esd vi_esd 0.39086f
C800 a_1367_3941# a_1288_3370# 0.45119f
C801 a_1681_12337# a_1286_12023# 0.01058f
C802 clk_noverlap_0.sg13cmos5l_inv_1_0.A clk_noverlap_0.sg13cmos5l_inv_1_5.A 0.01974f
C803 d_ena d_amp_s[2] 0.09614f
C804 a_13192_5586# m2_10908_16863# 0.02098f
C805 a_20758_19340# bias_gm_0.bias_trim_0.vz 0.01036f
C806 sg13cmos5l_inv_1_4.Y sg13cmos5l_inv_1_1.A 0.03177f
C807 sg13cmos5l_inv_1_3.A xq_vg_p_2_ 0.06906f
C809 a_20138_14766# a_22138_14846# 0.06025f
C810 a_24626_19760# dsm2_osc_0.d_btest_or 0.01657f
C811 sg13cmos5l_inv_2_5.Y sg13cmos5l_inv_2_5.A 0.2809f
C812 d_amp_s_b[0] d_amp_s_b[3] 0.09845f
C813 a_22347_812# vdd 0.22001f
C814 sg13cmos5l_or2_1_0.X a_12800_15736# 0.02324f
C815 vo_p d_dith_en 0.01239f
C816 di_ena di_osc_en 0.08756f
C817 quantizer2_lfsr_0.sg13cmos5l_dfrbpq_1_2.D a_1284_10677# 0.01329f
C818 xq_vg_q_0_ vo_p 0.13536f
C819 bias_gm_0.bias_trim_0.vz a_20138_14766# 0.04747f
C820 dsm2_io_0.sg13cmos5l_inv_1_1.A vdd 0.32054f
C821 quantizer2_lfsr_0.sg13cmos5l_dfrbpq_1_1.D a_537_14181# 0.01529f
C822 clk_noverlap_0.sg13cmos5l_dlygate4sd3_1_7.A d_phi2 0.06905f
C823 a_14829_7164# clk_noverlap_0.sg13cmos5l_dlygate4sd3_1_9.A 0.30507f
C824 a_11841_7467# a_11956_7466# 0.3854f
C825 d_qclk di_osc_en 0.07263f
C826 a_9352_5586# a_10120_5586# 0.05462f
C827 a_22252_11246# a_24626_22684# 0.02499f
C828 a_1322_14546# a_1286_14615# 0.36396f
C829 quantizer2_lfsr_0.sg13cmos5l_dfrbpq_1_11.D a_558_10886# 0.02059f
C830 a_2034_9237# d_dith_en 0.0198f
C831 dsm2_io_vcmg_0.di_vcm_ext quantizer2_lfsr_0.sg13cmos5l_dfrbpq_1_2.D 0.40599f
C832 sg13cmos5l_or2_1_0.X a_11284_15186# 0.01777f
C833 a_2208_18213# d_qout_en 0.01204f
C834 quantizer2_lfsr_0.sg13cmos5l_dfrbpq_1_2.Q a_2045_3296# 0.0244f
C835 quantizer2_lfsr_0.sg13cmos5l_dfrbpq_1_15.D vdd 0.40951f
C836 vdd vo_n 16.3693f
C837 dsm2_io_0.do_trim_b[1] vdd 6.69701f
C838 sg13cmos5l_inv_1_6.A d_qout_en 0.01982f
C839 a_533_9920# a_571_8868# 0.07823f
C840 a_522_9960# a_558_8294# 0.26205f
C841 a_2038_15217# vdd 0.18365f
C842 d_phi2 vi_esd 1.10696f
C843 a_24626_19620# dsm2_osc_0.d_btest_or 0.01657f
C844 quantizer2_lfsr_0.sg13cmos5l_dfrbpq_1_2.D a_1367_14309# 0.02091f
C845 sg13cmos5l_inv_1_13.A sg13cmos5l_inv_1_20.Y 0.39492f
C846 a_20260_17236# vdd 0.45989f
C847 a_522_12886# vdd 0.17136f
C848 a_20000_20740# a_20000_20600# 0.1335f
C849 d_amp_s[0] d_amp_s[1] 5.79162f
C850 sg13cmos5l_inv_1_3.A d_dith[2] 0.14233f
C851 dsm2_io_vcmg_0.di_vcm_ext_b d_qout_en 3.96595f
C852 sw_tgate_cmfb2_1.p m3_9560_28731# 0.0121f
C853 sg13cmos5l_inv_1_17.A sg13cmos5l_and2_1_5.B 0.07893f
C854 quantizer2_lfsr_0.sg13cmos5l_dfrbpq_1_2.Q d_dith[2] 0.03023f
C855 a_1324_8580# vdd 0.09953f
C856 dsm2_osc_0.di_clk_ext vdd 0.41238f
C857 dsm2_io_0.do_trim_b[0] di_trim[1] 0.0379f
C858 sg13cmos5l_nand2_1_5.A d_dith[0] 1.11183f
C859 sg13cmos5l_inv_1_12.A d_qout_en 0.15478f
C860 quantizer2_lfsr_0.sg13cmos5l_dfrbpq_1_13.D quantizer2_lfsr_0.sg13cmos5l_dfrbpq_1_0.D 0.02576f
C861 a_1284_5391# a_1407_4946# 0.23043f
C862 a_522_5110# a_558_4878# 0.16704f
C863 sg13cmos5l_inv_1_16.Y vo_n 0.0349f
C864 a_522_7368# a_567_5970# 0.24169f
C865 a_533_7328# a_558_5702# 0.07916f
C866 a_6817_30111# a_12445_30191# 2.5228f
C867 a_5176_31117# a_5176_31469# 9.72216f
C868 a_13684_7466# vdd 0.20727f
C869 sg13cmos5l_and2_2_1.X d_qi_b 0.09714f
C870 a_1286_12023# a_1367_11717# 0.02431f
C871 a_537_8997# a_571_8868# 0.01562f
C872 a_2045_5888# d_qclk 0.03655f
C873 dsm2_io_0.sg13cmos5l_inv_1_6.A di_qout_en 0.0379f
C874 sg13cmos5l_nor2_1_0.Y sg13cmos5l_inv_2_4.Y 0.03243f
C875 dsm2_osc_0.sg13cmos5l_inv_1_3.A vi_esd 0.01118f
C876 sg13cmos5l_inv_1_13.Y d_qclk 0.17811f
C877 vo_n d_amp_s_b[0] 0.16648f
C878 sg13cmos5l_inv_1_6.A a_6202_16020# 0.01489f
C879 dsm2_osc_0.ibias_pad vcm 0.10619f
C880 a_1367_9125# quantizer2_lfsr_0.sg13cmos5l_dfrbpq_1_15.D 0.18638f
C881 a_24626_20740# a_24626_20600# 0.84953f
C882 xvcm_vcf_t di_osc_en 0.15224f
C883 sg13cmos5l_inv_1_19.Y sg13cmos5l_inv_1_16.A 0.29997f
C884 dsm2_osc_0.dsm2_io_rx_0.di_b dsm2_osc_0.sg13cmos5l_inv_1_2.A 0.04313f
C885 quantizer2_lfsr_0.di_dith_amp[1] quantizer2_lfsr_0.sg13cmos5l_dfrbpq_1_2.D 0.06058f
C886 quantizer2_lfsr_0.sg13cmos5l_dfrbpq_1_4.Q vdd 0.3521f
C887 a_19999_22964# vdd 0.01432f
C888 a_522_2901# a_522_2518# 0.09257f
C889 sg13cmos5l_inv_1_16.A sg13cmos5l_and2_1_5.A 0.0303f
C890 a_14728_5586# a_15496_5586# 0.05462f
C891 a_537_6405# a_558_5702# 0.02431f
C892 a_4267_7241# a_4537_7200# 0.18796f
C893 sg13cmos5l_nor2_2_2.A do_q_b 0.0413f
C894 a_5176_31469# a_5176_30111# 0.51242f
C895 a_12445_30191# a_9348_31505# 0.03188f
C896 a_22138_16346# vdd 0.02771f
C897 dsm2_io_0.do_trim_b[1] a_21252_3394# 0.10275f
C898 dsm2_io_0.do_trim_b[1] dsm2_io_0.do_trim_b[3] 2.1654f
C899 vdd do_clk_osc 0.40588f
C900 a_1600_11717# a_1367_11717# 0.18486f
C901 dsm2_io_vcmg_0.di_vcm_ext di_clk_sel 0.12591f
C902 a_1324_8580# a_1367_9125# 0.26205f
C903 sg13cmos5l_inv_1_13.A xq_vg_q_1_ 0.05191f
C904 sg13cmos5l_or2_1_0.X xq_vg_p_1_ 0.04371f
C905 sg13cmos5l_inv_1_3.Y xq_vg_p_2_ 0.16761f
C906 do_q_b d_dith[0] 0.02216f
C907 vi_esd di_clk_sel 0.01147f
C908 d_dith[1] d_dith[2] 3.68113f
C909 clk_noverlap_0.di_clk d_vcm_phi2 0.02629f
C910 a_1324_5988# d_dith_en 0.30867f
C911 a_20260_17236# a_21252_3394# 0.01759f
C912 a_1284_5493# vdd 0.27771f
C913 dsm2_io_0.do_btest_en d_qi 0.22027f
C914 quantizer2_lfsr_0.sg13cmos5l_dfrbpq_1_11.D d_amp_s[0] 0.0137f
C915 dsm2_osc_0.d_btest_or m2_10908_16863# 0.12207f
C916 a_2070_12038# vdd 0.52277f
C917 a_2034_8690# a_2045_8480# 0.03546f
C918 a_20672_20460# a_20758_20460# 0.01899f
C919 sg13cmos5l_inv_1_19.Y sg13cmos5l_inv_1_17.Y 0.19004f
C920 sg13cmos5l_and2_1_5.X sg13cmos5l_inv_1_17.A 0.02237f
C921 sw_tgate_11.gb xsc_vc1r_p 0.43638f
C922 a_22252_11246# a_19984_17824# 6.75965f
C923 a_2208_30701# dsm2_io_0.do_trim_b[0] 0.01812f
C924 xsc_vvg_p sw_tgate_11.gb 0.04692f
C925 inv_en_0.di_b sg13cmos5l_inv_1_20.Y 0.04127f
C926 a_5131_7241# vdd 0.25895f
C927 a_22252_4374# a_24404_4674# 0.12299f
C928 a_22252_4074# a_22252_5274# 1.11904f
C929 quantizer2_lfsr_0.di_dith_amp[0] a_526_16657# 0.01496f
C930 a_17421_7164# d_phi2 0.31285f
C931 quantizer2_lfsr_0.sg13cmos5l_dfrbpq_1_2.D quantizer2_lfsr_0.sg13cmos5l_dfrbpq_1_13.Q 0.29111f
C932 a_28334_22420# a_28334_22280# 0.1335f
C933 a_20758_22280# a_24258_22280# 0.0182f
C934 a_1324_5988# a_1288_5962# 0.24169f
C935 a_20070_15446# vdd 0.1867f
C936 quantizer2_lfsr_0.sg13cmos5l_dfrbpq_1_2.D a_1324_13764# 0.01264f
C937 quantizer2_lfsr_0.sg13cmos5l_dfrbpq_1_0.D di_osc_en 0.02519f
C938 sg13cmos5l_inv_1_13.A sg13cmos5l_inv_1_0.A 0.01521f
C939 a_14433_7467# vdd 0.16109f
C940 a_16941_5500# vdd 0.29071f
C941 a_20758_20460# a_24258_20320# 0.01899f
C942 dsm2_osc_0.sg13cmos5l_dfrbp_1_0.RESET_B a_23150_752# 0.01238f
C943 quantizer2_lfsr_0.di_dith_amp[0] a_522_15861# 0.0193f
C944 a_27029_22824# dsm2_osc_0.d_btest_or 0.01264f
C945 xsc_vc1l_p vi_esd 3.7075f
C946 quantizer2_lfsr_0.sg13cmos5l_dfrbpq_1_2.D a_1286_9431# 0.01576f
C947 bias_gm_0.bias_trim_0.vz a_24404_8546# 0.84333f
C948 xsc_vvg_n m3_9560_28731# 0.04573f
C949 a_6817_30111# vdd 4.07091f
C950 a_16276_7466# d_phi2 0.05934f
C951 a_24258_22280# a_24258_22000# 0.0452f
C952 clk_noverlap_0.sg13cmos5l_dlygate4sd3_1_0.A a_8857_7200# 0.03553f
C953 sg13cmos5l_inv_1_14.A d_qclk 0.04822f
C954 a_26670_15446# vdd 0.01681f
C955 vdd di_dith_amp[1] 0.49475f
C956 d_qout_en d_qi 0.36799f
C957 sg13cmos5l_nand2_1_5.A do_q_dec 0.12346f
C958 sg13cmos5l_inv_1_12.Y d_qout_en 0.04388f
C959 a_10888_5586# d_phi1 0.02214f
C960 clk_noverlap_0.di_clk a_19105_884# 0.0132f
C961 dsm2_io_vcmg_0.di_vcm_ext quantizer2_lfsr_0.sg13cmos5l_dfrbpq_1_13.D 0.21791f
C962 a_22252_7946# a_23328_9146# 0.20579f
C963 a_2208_21189# vdd 0.06907f
C964 a_8747_8608# d_amp_s_b[1] 0.0127f
C965 a_13960_5586# vdd 0.52888f
C966 a_1284_15759# d_dith_en 0.11145f
C967 quantizer2_lfsr_0.sg13cmos5l_dfrbpq_1_13.D a_1367_14309# 0.20447f
C968 a_1367_3941# d_dith_en 0.10952f
C969 sg13cmos5l_inv_1_13.A vo_n 0.06869f
C970 a_24258_20320# a_20758_20320# 0.01899f
C971 sg13cmos5l_or2_1_0.X a_17421_7164# 0.01172f
C972 d_amp_s_b[1] d_dith[0] 0.03993f
C973 dsm2_io_0.do_trim_b[0] bias_gm_0.bias_trim_0.iout 0.21375f
C974 xsc_vvg_p xsc_vc1l_n 0.02958f
C975 xq_dith_v_bp do_q 0.06602f
C976 clk_noverlap_0.di_clk do_q_b 0.66757f
C977 di_trim[2] di_trim[3] 0.11625f
C978 sw_tgate_cmfb2_3.gb vdd 3.14425f
C979 a_1284_2799# a_1324_804# 0.01412f
C980 a_1407_2354# a_1322_1586# 0.03546f
C981 a_522_2354# vdd 0.13554f
C982 clk_noverlap_0.sg13cmos5l_inv_1_0.A clk_noverlap_0.sg13cmos5l_inv_1_0.Y 0.10216f
C983 sg13cmos5l_inv_1_3.A sg13cmos5l_inv_1_16.A 0.05779f
C984 a_22252_4374# vdd 9.91012f
C985 dsm2_io_0.do_trim_b[0] a_22252_7946# 0.9272f
C986 a_19984_17824# a_22252_8546# 0.01249f
C987 a_9348_31505# vdd 0.51351f
C988 a_24258_22000# a_24540_22000# 0.04564f
C989 a_24602_14546# vdd 0.08846f
C990 a_522_9960# d_qclk 0.04946f
C991 dsm2_io_0.do_trim_b[0] di_trim[0] 0.18638f
C992 clk_noverlap_0.sg13cmos5l_inv_1_1.Y clk_noverlap_0.sg13cmos5l_inv_1_1.A 0.08534f
C993 quantizer2_lfsr_0.sg13cmos5l_dfrbpq_1_2.D a_1284_5391# 0.01526f
C994 clk_noverlap_0.sg13cmos5l_dlygate4sd3_1_0.A clk_noverlap_0.sg13cmos5l_dlygate4sd3_1_4.A 0.03803f
C995 xq_vg_q_2_ d_amp_s_b[2] 0.03987f
C996 a_2045_8480# d_qclk 0.03262f
C997 a_1407_4946# vdd 0.13586f
C998 quantizer2_lfsr_0.sg13cmos5l_dfrbpq_1_2.D a_1322_11954# 0.03009f
C999 a_2208_24557# dsm2_io_0.do_trim_b[0] 0.01855f
C1000 a_2034_11282# vdd 0.13513f
C1001 sg13cmos5l_inv_1_4.Y sg13cmos5l_inv_1_19.Y 0.08755f
C1002 a_2034_3506# d_dith_en 0.13135f
C1003 do_q_b do_q_dec 0.01575f
C1004 dsm2_osc_0.d_btest_or bias_gm_0.bias_trim_0.iout 0.01185f
C1005 a_9556_15186# a_10132_15186# 0.0245f
C1006 d_ena vi_esd 0.18121f
C1007 a_522_2184# vdd 0.07415f
C1008 a_21681_1704# dsm2_osc_0.sg13cmos5l_inv_1_2.A 0.09901f
C1009 sg13cmos5l_inv_1_4.Y sg13cmos5l_and2_1_5.A 0.12289f
C1010 sg13cmos5l_inv_1_3.A sg13cmos5l_inv_1_17.Y 0.05554f
C1011 sg13cmos5l_inv_1_19.Y sg13cmos5l_inv_1_17.A 0.76949f
C1012 sg13cmos5l_nor2_2_2.A sg13cmos5l_inv_2_5.Y 0.23474f
C1013 xvcm_vcf_t d_vcm_phi2 0.13551f
C1014 a_5176_31117# vo_p 0.23683f
C1015 a_20758_19900# d_ena 0.01376f
C1016 sg13cmos5l_nor2_1_0.Y sg13cmos5l_and2_1_5.B 0.17595f
C1017 quantizer2_lfsr_0.di_dith_amp[1] quantizer2_lfsr_0.sg13cmos5l_dfrbpq_1_13.D 0.03093f
C1018 quantizer2_lfsr_0.sg13cmos5l_dfrbpq_1_0.D a_558_13478# 0.01068f
C1019 a_24540_22000# a_24626_22000# 0.01899f
C1020 clk_noverlap_0.di_clk m2_10908_16655# 0.05882f
C1021 dsm2_io_vcmg_0.di_phi1_b vdd 0.68754f
C1022 a_1322_9362# d_qclk 0.04405f
C1023 bias_gm_0.bias_trim_0.iout a_23328_5574# 0.28931f
C1024 a_533_15104# d_dith_en 0.28793f
C1025 sg13cmos5l_inv_1_9.Y a_14266_14856# 0.02354f
C1026 sg13cmos5l_inv_1_17.A sg13cmos5l_and2_1_5.A 0.30033f
C1027 sg13cmos5l_nor2_2_0.B a_9556_15186# 0.02932f
C1028 a_12705_7467# a_12820_7466# 0.3854f
C1029 dsm2_io_0.do_btest_en vo_p 0.0661f
C1030 quantizer2_lfsr_0.di_dith_amp[0] d_amp_s[2] 0.23793f
C1031 a_2034_3670# a_2034_3336# 0.01412f
C1032 quantizer2_lfsr_0.sg13cmos5l_dfrbpq_1_6.Q d_qclk 0.08273f
C1033 sg13cmos5l_inv_1_6.Y d_qout_en 0.02148f
C1034 dsm2_io_vcmg_0.di_vcm_ext di_osc_en 0.02664f
C1035 a_522_7702# vdd 0.17136f
C1036 xsc_xcmfb1_vsw_cm_n vo_n 2.18322f
C1037 do_q_b d_qclk 0.01182f
C1038 a_6884_8680# d_amp_s[0] 0.02303f
C1039 a_19984_17824# vdd 5.77483f
C1040 dsm2_io_0.dsm2_io_rx_9.di_b di_clk_sel 0.01364f
C1041 clk_noverlap_0.sg13cmos5l_dlygate4sd3_1_8.X vdd 0.22894f
C1042 vi_esd di_osc_en 0.01848f
C1043 dsm2_io_0.do_trim_b[3] a_22252_4374# 0.1779f
C1044 sg13cmos5l_inv_1_20.Y sg13cmos5l_nor2_2_0.B 0.04467f
C1045 a_21252_3394# a_22252_4374# 0.18766f
C1046 a_1322_1586# vdd 0.20965f
C1047 a_5176_30111# vo_p 1.59021f
C1048 a_20758_19760# d_ena 0.01376f
C1049 sw_tgate_10.p vi_esd 0.49599f
C1050 sg13cmos5l_inv_1_4.A xq_vg_q_2_ 0.18645f
C1051 a_24626_22000# a_28126_21860# 0.01899f
C1052 a_1284_15759# a_1322_14546# 0.17382f
C1053 sw_tgate_11.gb vi_esd 0.64415f
C1054 quantizer2_lfsr_0.sg13cmos5l_dfrbpq_1_13.Q quantizer2_lfsr_0.sg13cmos5l_dfrbpq_1_13.D 0.35771f
C1055 sg13cmos5l_nand2_1_2.Y a_11201_9808# 0.01501f
C1056 clk_noverlap_0.sg13cmos5l_dlygate4sd3_1_0.A a_10483_7459# 0.0148f
C1057 sg13cmos5l_inv_1_13.Y sg13cmos5l_inv_1_0.Y 0.0199f
C1058 a_8747_8888# a_8747_8748# 0.48787f
C1059 quantizer2_lfsr_0.sg13cmos5l_dfrbpq_1_13.D a_1324_13764# 0.03965f
C1060 a_16264_5586# d_phi2 0.01717f
C1061 dsm2_io_0.do_btest_en dsm2_osc_0.sg13cmos5l_dfrbp_1_0.RESET_B 1.11463f
C1062 sg13cmos5l_inv_1_3.A d_amp_s[0] 0.08484f
C1063 a_537_3813# vdd 0.23809f
C1064 quantizer2_lfsr_0.sg13cmos5l_dfrbpq_1_2.Q a_2070_1670# 0.0205f
C1065 quantizer2_lfsr_0.sg13cmos5l_dfrbpq_1_2.D a_1288_11146# 0.01575f
C1066 clk_noverlap_0.sg13cmos5l_inv_1_6.A d_phi2 0.08622f
C1067 sg13cmos5l_inv_1_9.Y xq_vg_q_2_ 0.07925f
C1068 vdd do_osc_oe 0.44413f
C1069 a_24540_20040# a_24626_20180# 0.01899f
C1070 dsm2_osc_0.sg13cmos5l_mux2_1_0.A1 vi_esd 0.01392f
C1071 a_14734_15077# a_14849_15078# 0.3854f
C1073 xq_vg_q_0_ a_9883_9628# 0.0212f
C1074 sw_tgate_9.gb d_phi1 8.33537f
C1075 vdd d_phi1 10.743f
C1076 a_2049_4965# d_qclk 0.2273f
C1077 a_10291_7286# d_qclk 0.01889f
C1078 sg13cmos5l_inv_1_0.Y a_13985_15078# 0.06524f
C1079 quantizer2_lfsr_0.sg13cmos5l_dfrbpq_1_2.D a_1407_2354# 0.0111f
C1080 sg13cmos5l_nor2_1_0.Y sg13cmos5l_and2_1_5.X 0.08453f
C1081 dsm2_osc_0.sg13cmos5l_mux2_1_0.A1 dsm2_osc_0.sg13cmos5l_dfrbp_1_0.Q_N 0.02075f
C1082 a_537_1221# a_567_786# 0.02241f
C1083 a_2208_27629# d_ena 0.0205f
C1084 d_amp_s_b[1] do_q_dec 0.04295f
C1085 sg13cmos5l_inv_1_3.Y sg13cmos5l_inv_1_16.A 0.02349f
C1086 sg13cmos5l_inv_1_4.A sg13cmos5l_inv_1_1.A 0.02175f
C1087 a_28126_21860# a_24626_21860# 0.01899f
C1088 a_1322_4178# a_1286_4247# 0.36396f
C1089 a_20672_21860# a_20672_21580# 0.04477f
C1090 dsm2_osc_0.ibias_in vdd 3.38991f
C1091 sg13cmos5l_inv_1_3.A sg13cmos5l_inv_1_15.Y 0.34808f
C1092 a_8768_15909# vdd 0.29534f
C1093 quantizer2_lfsr_0.di_dith_amp[1] quantizer2_lfsr_0.sg13cmos5l_dfrbpq_1_1.Q 0.09908f
C1094 quantizer2_lfsr_0.di_dith_amp[1] di_osc_en 0.06308f
C1095 a_6884_8680# a_8661_8468# 0.04523f
C1096 a_10757_8608# a_11115_8608# 0.03425f
C1097 sg13cmos5l_inv_1_16.Y a_8747_8748# 0.02092f
C1098 sg13cmos5l_inv_1_20.Y d_dith_en 0.01918f
C1099 a_5131_7241# a_5401_7200# 0.18796f
C1100 xq_vg_p_2_ do_q 0.10606f
C1101 sg13cmos5l_inv_1_9.Y sg13cmos5l_inv_1_1.A 0.27905f
C1102 sg13cmos5l_inv_1_13.Y xq_vg_p_1_ 0.05814f
C1103 sg13cmos5l_inv_1_20.Y xq_vg_q_0_ 0.03469f
C1104 sw_tgate_9.gb vcm_esd 0.01607f
C1105 a_19984_17824# a_21252_3394# 0.83295f
C1106 vdd vcm_esd 4.63734f
C1107 a_11201_8328# d_amp_s[0] 0.04411f
C1108 a_522_15144# a_537_14181# 0.28324f
C1109 sg13cmos5l_inv_1_4.Y sg13cmos5l_inv_1_3.A 0.33583f
C1110 a_1324_11172# d_qclk 0.07731f
C1111 a_8747_8748# d_amp_s_b[0] 0.01086f
C1112 a_1288_778# vdd 0.10298f
C1113 a_1286_1655# a_1600_1349# 0.01562f
C1114 a_558_518# a_567_786# 0.45119f
C1115 d_phi1 d_amp_s_b[0] 0.01281f
C1116 d_amp_s_b[1] d_qclk 0.01866f
C1117 a_1367_6533# quantizer2_lfsr_0.sg13cmos5l_dfrbpq_1_12.Q 0.18867f
C1118 sg13cmos5l_inv_1_3.Y sg13cmos5l_inv_1_17.Y 0.02958f
C1119 a_11259_9488# a_11201_9308# 0.14662f
C1120 a_20758_21860# a_20758_21720# 0.84953f
C1121 xsc_vc1l_n vi_esd 3.94047f
C1122 dsm2_io_0.sg13cmos5l_inv_1_0.A dsm2_io_0.sg13cmos5l_inv_1_6.A 0.10131f
C1123 d_amp_s_b[1] d_amp_s[2] 0.35743f
C1124 d_amp_s[0] d_dith[1] 0.36141f
C1125 d_amp_s_b[3] d_amp_s[3] 0.32231f
C1126 d_amp_s[1] d_amp_s_b[2] 0.02065f
C1127 sg13cmos5l_inv_1_3.A sg13cmos5l_inv_1_17.A 0.13668f
C1128 a_22252_11246# ibias_200n 0.17698f
C1129 a_11201_9808# vdd 0.02977f
C1130 quantizer2_lfsr_0.sg13cmos5l_dfrbpq_1_11.D a_558_3110# 0.02086f
C1131 clk_noverlap_0.di_clk a_10784_6484# 0.07709f
C1132 a_6377_7224# vdd 0.15875f
C1133 a_10757_8608# a_10757_8328# 0.04477f
C1134 sg13cmos5l_or2_1_0.X sg13cmos5l_nand2_1_2.Y 0.09188f
C1135 quantizer2_lfsr_0.sg13cmos5l_dfrbpq_1_1.Q quantizer2_lfsr_0.sg13cmos5l_dfrbpq_1_13.Q 0.0878f
C1136 quantizer2_lfsr_0.di_dith_amp[0] quantizer2_lfsr_0.sg13cmos5l_nor2_1_0.A 0.36125f
C1137 a_2034_6645# a_2034_6262# 0.09257f
C1138 quantizer2_lfsr_0.di_dith_amp[0] quantizer2_lfsr_0.sg13cmos5l_dfrbpq_1_0.D 0.18676f
C1139 a_8747_8188# vdd 0.01407f
C1140 dsm2_osc_0.d_btest_or a_21478_2578# 0.02695f
C1141 a_20758_20040# a_20758_19900# 0.84953f
C1142 sw_tgate_9.gb d_phi2 7.9345f
C1143 quantizer2_lfsr_0.sg13cmos5l_dfrbpq_1_0.D quantizer2_lfsr_0.sg13cmos5l_dfrbpq_1_6.Q 0.0578f
C1144 sg13cmos5l_inv_1_9.Y sg13cmos5l_and2_1_5.B 0.02441f
C1145 vdd d_phi2 13.3054f
C1146 quantizer2_lfsr_0.sg13cmos5l_dfrbpq_1_2.D vdd 1.22608f
C1147 a_15693_7164# vdd 0.26116f
C1148 a_22738_2578# vdd 0.1075f
C1149 a_2034_698# vdd 0.17653f
C1150 a_21252_3394# dsm2_osc_0.ibias_in 3.47615f
C1151 sg13cmos5l_inv_1_1.A a_13088_15020# 0.01803f
C1152 a_22252_11246# a_24626_20880# 0.01575f
C1153 a_28334_21860# a_28334_21720# 0.1335f
C1154 a_24258_21720# a_24258_21440# 0.04477f
C1155 sg13cmos5l_inv_1_16.Y a_11201_9808# 0.01659f
C1156 m2_6409_30900# d_ena 0.0503f
C1157 dsm2_io_0.dsm2_io_rx_9.di_b d_ena 0.54822f
C1158 a_11672_6736# vdd 0.01379f
C1159 a_12445_30191# ibias_200n 0.05969f
C1160 quantizer2_lfsr_0.di_dith_amp[1] a_2208_19661# 0.02786f
C1161 xq_vg_q_1_ xq_vg_q_0_ 0.26374f
C1162 a_8747_8468# a_10757_8328# 0.01899f
C1163 a_11201_8608# a_11201_8468# 0.48787f
C1164 sg13cmos5l_and2_1_5.B sg13cmos5l_inv_1_2.Y 0.02227f
C1165 dsm2_io_0.do_btest_en dsm2_osc_0.dsm2_io_rx_0.di_b 0.26317f
C1166 xsc_vfb xsc_vvg_p 1.05764f
C1167 sg13cmos5l_inv_1_3.Y d_amp_s[0] 0.19593f
C1168 dsm2_io_0.do_trim_b[3] vcm_esd 0.2952f
C1169 a_21252_3394# vcm_esd 0.03206f
C1170 clk_noverlap_0.sg13cmos5l_inv_1_1.A a_10198_6736# 0.02331f
C1171 d_qi_b d_qi 10.7775f
C1172 a_522_15478# vdd 0.17136f
C1173 sg13cmos5l_inv_1_12.Y d_qi_b 0.02729f
C1174 a_522_7368# vdd 0.0721f
C1175 a_1367_6533# d_dith_en 0.11121f
C1176 d_dith_en d_amp_s_b[3] 0.24539f
C1177 dsm2_osc_0.d_btest_or a_21736_2344# 0.04319f
C1178 a_28334_20040# a_28334_19900# 0.1335f
C1179 sg13cmos5l_inv_1_18.Y d_qclk 0.01771f
C1180 a_2034_11446# d_qclk 0.01638f
C1181 xq_vg_q_0_ d_amp_s_b[3] 0.18508f
C1182 a_24626_21440# dsm2_osc_0.d_btest_or 0.01657f
C1183 dsm2_osc_0.sg13cmos5l_inv_1_3.A vdd 0.34193f
C1184 a_2034_14038# d_dith_en 0.11174f
C1185 a_2034_1082# d_dith[0] 0.07045f
C1186 dsm2_osc_0.di_clk_ext a_19949_784# 0.05346f
C1187 dsm2_io_0.dsm2_io_rx_9.di_b di_osc_en 0.01951f
C1188 sg13cmos5l_nor2_1_0.Y sg13cmos5l_inv_1_19.Y 0.02748f
C1189 a_22252_11246# a_24626_20740# 0.01575f
C1190 sg13cmos5l_nand2_1_5.A a_15584_15091# 0.07689f
C1191 sg13cmos5l_inv_1_3.Y a_11201_8888# 0.01573f
C1192 quantizer2_lfsr_0.sg13cmos5l_dfrbpq_1_2.D a_1367_9125# 0.02278f
C1193 a_1367_6533# a_1288_5962# 0.45119f
C1194 xq_dith_v_bq vo_p 3.62841f
C1195 sw_tgate_cmfb2_3.gb xsc_xcmfb1_vsw_cm_n 0.46602f
C1196 sg13cmos5l_inv_1_1.A xq_vg_p_0_ 0.26933f
C1197 a_22252_8546# ibias_200n 0.46502f
C1198 a_11201_8468# a_11201_8328# 0.48787f
C1199 a_13192_5586# xvcm_vcf_b 0.022f
C1200 a_12424_5586# xvcm_vcf_t 0.013f
C1201 sg13cmos5l_nor2_1_0.Y sg13cmos5l_and2_1_5.A 0.07275f
C1202 a_22252_11246# d_ena 0.02024f
C1203 sg13cmos5l_or2_1_0.X vdd 2.22425f
C1204 a_2208_31469# d_ena 0.01757f
C1205 dsm2_io_0.sg13cmos5l_inv_1_4.A dsm2_io_0.sg13cmos5l_inv_1_3.A 0.10237f
C1206 dsm2_io_vcmg_0.di_vcm_ext_b di_vcm_ext 0.19271f
C1207 clk_noverlap_0.sg13cmos5l_dlygate4sd3_1_4.X a_9451_7241# 0.30507f
C1208 d_rst_b d_amp_s_b[3] 0.16234f
C1209 sg13cmos5l_and2_1_5.X sg13cmos5l_inv_1_9.Y 0.04663f
C1210 a_1322_6770# vdd 0.20468f
C1211 a_2034_14421# a_2034_13874# 0.07015f
C1212 a_533_4736# d_qclk 0.03875f
C1213 clk_noverlap_0.sg13cmos5l_dlygate4sd3_1_0.A d_amp_s[0] 0.05294f
C1214 a_24626_21300# dsm2_osc_0.d_btest_or 0.01657f
C1215 dsm2_osc_0.sg13cmos5l_dfrbp_1_0.Q_N a_22499_864# 0.03816f
C1216 a_20770_598# a_20673_598# 0.01637f
C1217 sg13cmos5l_inv_1_4.Y sg13cmos5l_inv_1_3.Y 0.14184f
C1218 vdd di_clk_sel 1.83177f
C1219 a_13211_9028# a_11201_9028# 0.01899f
C1220 a_20000_21580# a_20000_21440# 0.1335f
C1221 sg13cmos5l_or2_1_0.X sg13cmos5l_inv_1_16.Y 0.05296f
C1222 sg13cmos5l_inv_1_3.Y sg13cmos5l_inv_1_17.A 0.07956f
C1223 dsm2_io_0.sg13cmos5l_inv_1_6.A a_2208_18597# 0.01819f
C1224 sg13cmos5l_nand2_2_0.B sg13cmos5l_inv_1_13.Y 0.01929f
C1225 a_19949_784# do_clk_osc 0.01029f
C1226 m2_10908_16863# do_q 3.75274f
C1227 sw_tgate_6.p vi_esd 0.37204f
C1228 a_9451_7241# vdd 0.26113f
C1229 a_537_14181# a_567_13746# 0.02241f
C1230 dsm2_osc_0.sg13cmos5l_inv_1_2.A do_clk_osc 0.01544f
C1231 quantizer2_lfsr_0.sg13cmos5l_dfrbpq_1_15.D d_dith_en 0.06347f
C1232 quantizer2_lfsr_0.sg13cmos5l_dfrbpq_1_2.D a_1407_7538# 0.01101f
C1233 sg13cmos5l_inv_1_7.Y d_qi 0.15826f
C1234 sg13cmos5l_or2_1_0.X sg13cmos5l_inv_1_10.Y 0.01409f
C1235 a_10592_15909# a_10989_15998# 0.05368f
C1236 sg13cmos5l_inv_1_0.Y do_q_b 0.02129f
C1237 a_20000_19760# a_20000_19620# 0.1335f
C1238 sg13cmos5l_inv_1_19.Y d_amp_s_b[2] 0.01396f
C1239 a_24540_19760# a_24540_19480# 0.04477f
C1240 sg13cmos5l_or2_1_0.X d_amp_s_b[0] 0.16365f
C1241 a_2034_14038# a_2034_13704# 0.01412f
C1242 a_13569_7467# a_13684_7466# 0.3854f
C1243 a_22386_2578# a_21736_2344# 0.03452f
C1244 a_522_12886# d_dith_en 0.13348f
C1245 dsm2_osc_0.sg13cmos5l_dfrbp_1_0.Q_N a_23195_985# 0.19847f
C1246 a_21554_2798# dsm2_osc_0.sg13cmos5l_dfrbp_1_0.RESET_B 0.21954f
C1247 quantizer2_lfsr_0.di_dith_amp[0] dsm2_io_vcmg_0.di_vcm_ext 0.25816f
C1248 sg13cmos5l_inv_1_6.Y d_qi_b 0.05618f
C1249 sg13cmos5l_nand2_1_5.A a_10592_15909# 0.04987f
C1250 quantizer2_lfsr_0.sg13cmos5l_dfrbpq_1_0.D a_567_11154# 0.01415f
C1251 a_24626_21580# a_24626_21440# 0.84953f
C1252 vdd ibias_200n 2.82066f
C1253 dsm2_io_0.sg13cmos5l_inv_1_1.A d_rst_b 0.01342f
C1254 quantizer2_lfsr_0.sg13cmos5l_dfrbpq_1_12.Q a_1284_5493# 0.11592f
C1255 a_1286_1655# d_qclk 0.23287f
C1256 dsm2_io_vcmg_0.di_vcm_ext quantizer2_lfsr_0.sg13cmos5l_dfrbpq_1_6.Q 0.01065f
C1257 do_q_dec d_dith[0] 2.94281f
C1258 a_1324_8580# d_dith_en 0.30991f
C1259 sw_tgate_9.gb xsc_vc1l_p 0.75602f
C1260 xsc_vc1l_p vdd 2.98105f
C1261 dsm2_io_0.do_trim_b[2] a_22252_4074# 0.07275f
C1262 a_558_10062# a_522_9960# 0.25046f
C1263 a_537_3813# a_571_3684# 0.01562f
C1264 vi_esd do_q_b 0.02923f
C1265 di_trim[1] di_trim[2] 0.11257f
C1266 sg13cmos5l_inv_1_6.A xq_vg_q_2_ 0.511f
C1267 a_24626_19760# a_24626_19620# 0.84953f
C1268 sg13cmos5l_inv_1_13.A a_11201_9808# 0.02914f
C1269 sg13cmos5l_nor2_2_2.A d_qclk 0.01124f
C1270 sg13cmos5l_inv_1_11.Y d_qi_b 0.16777f
C1271 dsm2_osc_0.sg13cmos5l_dfrbp_1_0.Q_N a_24164_726# 0.04251f
C1272 xq_vg_p_1_ do_q_b 0.02941f
C1273 quantizer2_lfsr_0.sg13cmos5l_dfrbpq_1_13.D vdd 0.50772f
C1274 a_20672_21300# a_20758_21300# 0.01899f
C1275 a_1284_15861# a_1407_15314# 0.07015f
C1276 a_2208_25325# d_ena 0.02559f
C1277 xsc_xcmfb1_vsw_cm_n d_phi1 0.34596f
C1278 d_dith[0] d_qclk 0.24421f
C1279 quantizer2_lfsr_0.sg13cmos5l_dfrbpq_1_4.Q d_dith_en 0.23574f
C1280 sg13cmos5l_nor2_1_0.Y sg13cmos5l_inv_1_3.A 0.05824f
C1281 sg13cmos5l_inv_1_4.A sg13cmos5l_inv_1_19.Y 0.1301f
C1282 d_amp_s[2] d_dith[0] 0.01565f
C1283 xq_vg_p_1_ a_11201_9948# 0.01351f
C1284 a_1407_7538# a_1322_6770# 0.03546f
C1285 a_1324_3396# a_1367_3941# 0.26205f
C1286 sg13cmos5l_inv_1_6.A sg13cmos5l_inv_1_1.A 0.19608f
C1287 dsm2_io_0.sg13cmos5l_inv_1_3.A di_dith_en 0.0379f
C1288 a_6757_9808# d_qclk 0.20826f
C1289 sg13cmos5l_inv_1_4.A sg13cmos5l_and2_1_5.A 0.02864f
C1290 quantizer2_lfsr_0.di_dith_amp[0] quantizer2_lfsr_0.di_dith_amp[1] 2.17484f
C1291 sg13cmos5l_inv_1_16.A a_6202_14892# 0.01494f
C1292 a_20758_19620# a_20260_17236# 0.01172f
C1293 m2_10908_16655# vi_esd 14.9174f
C1294 a_2034_3670# vdd 0.16929f
C1295 sg13cmos5l_inv_1_19.Y sg13cmos5l_inv_1_9.Y 1.32474f
C1296 a_5995_7241# a_6265_7200# 0.18796f
C1297 a_2070_12038# d_dith_en 0.08217f
C1298 dsm2_osc_0.d_btest_or dsm2_osc_0.dsm2_io_rx_1.di_b 0.03474f
C1299 a_22368_558# a_23289_752# 0.24169f
C1300 a_22499_864# a_22258_594# 0.01058f
C1301 a_22347_812# a_23150_752# 0.07823f
C1302 quantizer2_lfsr_0.sg13cmos5l_dfrbpq_1_0.D a_533_4736# 0.01367f
C1303 inv_en_0.di_b a_8768_15909# 0.04853f
C1304 quantizer2_lfsr_0.sg13cmos5l_dfrbpq_1_1.D a_533_15104# 0.01345f
C1305 a_21252_3394# ibias_200n 0.17683f
C1306 dsm2_io_0.do_trim_b[3] ibias_200n 1.01967f
C1307 xsc_xcmfb1_vsw_cm_n vcm_esd 2.2793f
C1308 a_20758_21300# a_24258_21160# 0.01899f
C1309 sg13cmos5l_inv_1_9.Y sg13cmos5l_and2_1_5.A 0.31165f
C1310 dsm2_io_vcmg_0.di_vcm_ext a_8768_5586# 0.03107f
C1311 sw_tgate_9.gb d_ena 0.1761f
C1312 sg13cmos5l_inv_1_19.Y sg13cmos5l_and2_2_1.X 0.02881f
C1313 vdd d_ena 20.6652f
C1314 quantizer2_lfsr_0.sg13cmos5l_dfrbpq_1_11.D a_558_5702# 0.02078f
C1315 quantizer2_lfsr_0.sg13cmos5l_dfrbpq_1_5.Q a_2049_12741# 0.02067f
C1316 dsm2_io_vcmg_0.di_vcm_ext a_1324_11172# 0.02128f
C1317 sg13cmos5l_nand2_1_2.Y sg13cmos5l_inv_1_13.Y 0.47749f
C1318 sw_tgate_12.m vi_esd 0.36798f
C1319 dsm2_io_vcmg_0.di_vcm_ext d_amp_s_b[1] 0.03276f
C1320 a_28334_19620# a_28334_19480# 0.1335f
C1321 a_20260_17236# a_20758_19480# 0.04073f
C1322 a_522_13269# a_522_12722# 0.07015f
C1323 a_2049_12741# a_1284_13167# 0.02017f
C1324 clk_noverlap_0.sg13cmos5l_dlygate4sd3_1_3.X vdd 0.23244f
C1325 xq_dith_v_bp d_amp_s[0] 0.01877f
C1326 quantizer2_lfsr_0.sg13cmos5l_dfrbpq_1_0.Q a_1286_1655# 0.01297f
C1327 sg13cmos5l_inv_1_5.Y d_qi 0.02709f
C1328 sg13cmos5l_or2_1_0.X sg13cmos5l_inv_1_13.A 0.67556f
C1329 sg13cmos5l_inv_1_3.A d_amp_s_b[2] 0.13569f
C1330 a_21554_2798# dsm2_osc_0.dsm2_io_rx_0.di_b 0.07847f
C1331 a_24258_21160# a_20758_21160# 0.01899f
C1332 a_2074_14933# quantizer2_lfsr_0.sg13cmos5l_dfrbpq_1_5.Q 0.01336f
C1333 sg13cmos5l_inv_1_16.Y d_ena 0.0234f
C1334 sg13cmos5l_nand2_1_5.A sg13cmos5l_nand2_2_0.B 0.33382f
C1335 a_11201_8608# d_amp_s_b[2] 0.03784f
C1336 quantizer2_lfsr_0.sg13cmos5l_dfrbpq_1_1.Q vdd 0.50314f
C1337 clk_noverlap_0.sg13cmos5l_dlygate4sd3_1_12.A vdd 0.2308f
C1338 xsc_xcmfb1_vsw_cm_n d_phi2 0.37385f
C1339 vdd di_osc_en 5.48266f
C1340 a_1322_9362# a_1286_9431# 0.36396f
C1341 sw_tgate_9.gb sw_tgate_10.p 0.5024f
C1342 sg13cmos5l_inv_1_10.Y d_ena 0.02808f
C1343 clk_noverlap_0.sg13cmos5l_nor3_1_0.C clk_noverlap_0.sg13cmos5l_inv_1_0.A 0.03105f
C1344 sw_tgate_10.p vdd 0.31393f
C1345 clk_noverlap_0.di_clk d_qclk 0.0194f
C1346 d_ena d_amp_s_b[0] 0.0472f
C1347 sg13cmos5l_and2_1_5.A a_15130_14856# 0.29964f
C1348 sw_tgate_11.gb sw_tgate_9.gb 8.73602f
C1349 sw_tgate_11.gb vdd 3.17051f
C1350 a_24626_19480# a_24626_19340# 0.84953f
C1351 a_20260_17236# a_19964_18216# 0.27327f
C1352 a_522_12886# a_558_12654# 0.16704f
C1353 a_2045_13664# a_2083_12612# 0.07823f
C1354 a_2034_13704# a_2070_12038# 0.26205f
C1355 quantizer2_lfsr_0.sg13cmos5l_dfrbpq_1_2.D a_1288_3370# 0.01509f
C1356 quantizer2_lfsr_0.sg13cmos5l_dfrbpq_1_0.Q a_1600_1349# 0.02312f
C1357 a_8208_15626# vdd 0.1681f
C1358 sg13cmos5l_inv_1_16.A xq_vg_p_2_ 0.03458f
C1359 a_2034_5928# a_2079_4530# 0.24169f
C1360 a_2045_5888# a_2070_4262# 0.07916f
C1361 dsm2_osc_0.sg13cmos5l_mux2_1_0.A1 vdd 0.46007f
C1362 a_2070_6854# quantizer2_lfsr_0.sg13cmos5l_dfrbpq_1_3.Q 0.19381f
C1363 a_522_2354# d_dith_en 0.11752f
C1364 dsm2_io_0.do_trim_b[3] d_ena 4.66009f
C1365 quantizer2_lfsr_0.di_dith_amp[1] d_amp_s_b[1] 0.02852f
C1366 sg13cmos5l_nor2_1_0.Y sg13cmos5l_inv_1_3.Y 0.02436f
C1367 sg13cmos5l_inv_1_6.Y sg13cmos5l_inv_2_4.Y 0.04139f
C1368 do_q_dec d_qclk 0.02853f
C1369 a_20758_21580# d_ena 0.01376f
C1370 m2_10908_16863# d_vcm_phi1_b 0.12119f
C1371 sg13cmos5l_inv_1_4.A sg13cmos5l_inv_1_3.A 0.16445f
C1372 d_amp_s[2] do_q_dec 0.11191f
C1373 a_2045_5888# vdd 0.20285f
C1374 sg13cmos5l_inv_1_19.Y xq_vg_p_0_ 0.06341f
C1375 d_amp_s_b[2] d_dith[1] 3.00107f
C1376 sg13cmos5l_nand2_2_0.B do_q_b 0.44663f
C1377 sg13cmos5l_inv_1_13.Y vdd 0.35547f
C1378 a_28334_19340# a_19964_18216# 0.0104f
C1379 a_19949_784# do_osc_oe 0.03752f
C1380 dsm2_io_vcmg_0.di_vcm_ext_b d_amp_s[1] 0.04753f
C1381 a_20758_19900# bias_gm_0.bias_trim_0.vz 0.01446f
C1382 a_1407_4946# d_dith_en 0.10091f
C1383 dsm2_io_0.sg13cmos5l_inv_1_4.A di_dith_amp[1] 0.0379f
C1384 quantizer2_lfsr_0.sg13cmos5l_dfrbpq_1_0.Q a_2034_1082# 0.02127f
C1385 dsm2_osc_0.sg13cmos5l_inv_1_2.A do_osc_oe 0.01026f
C1386 a_1286_6839# d_qclk 0.23537f
C1387 a_2034_11282# d_dith_en 0.13059f
C1388 sg13cmos5l_inv_1_19.Y a_13211_9028# 0.0135f
C1389 sg13cmos5l_inv_1_17.Y xq_vg_p_2_ 0.18289f
C1390 sg13cmos5l_inv_1_4.Y do_q 0.03211f
C1391 a_13985_15078# vdd 0.20819f
C1392 dsm2_io_0.sg13cmos5l_inv_1_5.A a_2208_20717# 0.01968f
C1393 sg13cmos5l_inv_1_3.A sg13cmos5l_inv_1_9.Y 4.08316f
C1394 clk_noverlap_0.sg13cmos5l_dlygate4sd3_1_0.A a_6265_7200# 0.03553f
C1395 a_522_2184# d_dith_en 0.3502f
C1396 a_2208_19661# vdd 0.12684f
C1397 clk_noverlap_0.di_clk xvcm_vcf_t 0.02697f
C1398 inv_en_0.di_b sg13cmos5l_or2_1_0.X 1.06265f
C1399 sg13cmos5l_inv_2_4.Y sg13cmos5l_inv_1_11.Y 0.14408f
C1400 a_8392_5586# d_vcm_phi1_b 0.01382f
C1401 sg13cmos5l_nand2_2_0.B sg13cmos5l_inv_2_5.A 0.13473f
C1402 sg13cmos5l_inv_1_16.A d_dith[2] 0.07171f
C1403 sg13cmos5l_inv_1_13.Y sg13cmos5l_inv_1_16.Y 0.01144f
C1404 a_20758_21440# d_ena 0.01376f
C1405 d_amp_s[2] d_qclk 0.15334f
C1406 sw_tgate_9.gb xsc_vc1l_n 0.41862f
C1407 xsc_vc1l_n vdd 2.923f
C1408 sg13cmos5l_nor2_2_2.A a_11284_15186# 0.0646f
C1409 a_20758_19760# bias_gm_0.bias_trim_0.vz 0.01673f
C1410 sg13cmos5l_inv_1_10.Y sg13cmos5l_inv_1_13.Y 0.01529f
C1411 a_5176_31117# vo_n 0.23069f
C1412 a_20138_14766# a_22138_16046# 0.06025f
C1413 sg13cmos5l_inv_1_13.Y d_amp_s_b[0] 0.22131f
C1414 a_522_7702# d_dith_en 0.13096f
C1415 sg13cmos5l_inv_1_3.Y d_amp_s_b[2] 0.10639f
C1416 a_558_13478# vdd 0.52277f
C1417 d_qout_en d_amp_s_b[3] 0.18835f
C1418 sg13cmos5l_and2_1_2.X d_qi 0.05426f
C1419 a_21276_2052# a_21478_2344# 0.08168f
C1420 a_20770_598# vdd 0.1113f
C1421 a_24540_20880# a_24626_21020# 0.01899f
C1422 a_14433_7467# a_14548_7466# 0.3854f
C1423 dsm2_osc_0.sg13cmos5l_dfrbp_1_0.RESET_B a_21830_2088# 0.01627f
C1424 a_21554_2798# a_22386_2344# 0.01286f
C1425 a_1322_1586# d_dith_en 0.29f
C1426 sg13cmos5l_nand2_1_5.A sg13cmos5l_nand2_1_2.Y 0.17795f
C1427 sg13cmos5l_inv_1_16.Y a_12395_9488# 0.0122f
C1428 a_21977_22824# a_22063_22824# 0.01899f
C1429 a_522_5493# a_522_4946# 0.07015f
C1430 a_24626_23104# a_22252_11246# 0.01122f
C1431 a_2049_4965# a_1284_5391# 0.02017f
C1432 xsc_xcmfb1_vsw_cm_n ibias_200n 0.01176f
C1433 sg13cmos5l_and2_1_5.B d_qi 0.04464f
C1434 sg13cmos5l_inv_1_12.Y sg13cmos5l_and2_1_5.B 0.02006f
C1435 clk_noverlap_0.sg13cmos5l_inv_1_0.A clk_noverlap_0.sg13cmos5l_inv_1_5.Y 0.14106f
C1436 a_22252_11246# a_20138_14766# 0.03139f
C1437 a_11201_9308# vdd 0.01388f
C1438 a_2070_12038# a_2079_12306# 0.45119f
C1439 a_533_12512# a_537_11589# 0.36374f
C1440 a_8392_5586# m2_10908_16863# 0.01028f
C1441 a_537_3813# d_dith_en 0.05907f
C1442 dsm2_io_0.do_trim_b[1] a_22252_4074# 0.03535f
C1443 sg13cmos5l_inv_1_6.Y xq_vg_q_2_ 0.3583f
C1444 a_5176_30111# vo_n 1.33367f
C1445 dsm2_io_0.do_btest_en dsm2_osc_0.di_clk_ext 0.28883f
C1446 d_phi1 d_dith_en 0.04969f
C1447 sw_tgate_cmfb2_1.p xsc_xcmfb1_vsw_cm_p 0.26206f
C1448 a_22644_2344# a_23294_2344# 0.03431f
C1449 a_2045_3296# a_2070_1670# 0.07916f
C1450 a_2034_3336# a_2079_1938# 0.24169f
C1451 a_571_1092# d_dith_en 0.01839f
C1452 a_19964_18216# a_26670_15446# 0.05959f
C1453 a_22836_1332# vdd 0.20355f
C1454 sg13cmos5l_inv_1_14.A vdd 2.67563f
C1455 a_522_10130# vdd 0.13554f
C1456 quantizer2_lfsr_0.sg13cmos5l_dfrbpq_1_5.Q a_2034_11829# 0.10359f
C1457 a_8747_8188# d_amp_s[3] 0.01017f
C1458 a_2034_8520# a_2049_7557# 0.28324f
C1459 quantizer2_lfsr_0.sg13cmos5l_dfrbpq_1_2.D quantizer2_lfsr_0.sg13cmos5l_dfrbpq_1_12.Q 0.08238f
C1460 sg13cmos5l_inv_1_16.Y a_11201_9308# 0.01218f
C1461 a_22063_22824# a_24258_22824# 0.0182f
C1462 vdd d_vcm_phi2 0.94646f
C1463 dsm2_io_0.sg13cmos5l_inv_1_1.A d_qout_en 0.10868f
C1464 sg13cmos5l_inv_1_4.A sg13cmos5l_inv_1_3.Y 0.14818f
C1465 dsm2_io_vcmg_0.di_vcm_ext_b a_13192_5586# 0.01736f
C1466 a_2208_26093# d_ena 0.01844f
C1467 quantizer2_lfsr_0.sg13cmos5l_dfrbpq_1_0.D do_q_dec 0.03999f
C1468 a_1600_3941# a_1367_3941# 0.18486f
C1469 a_522_12552# a_567_11154# 0.24169f
C1470 a_533_12512# a_558_10886# 0.07916f
C1471 a_1322_11954# a_1324_11172# 0.20759f
C1472 a_11656_5586# m2_10908_16863# 0.02098f
C1473 dsm2_io_vcmg_0.di_vcm_ext d_dith[0] 0.02368f
C1474 sg13cmos5l_inv_1_6.A sg13cmos5l_inv_1_19.Y 3.64455f
C1475 a_2070_1670# d_dith[2] 0.02842f
C1476 sg13cmos5l_inv_1_6.Y sg13cmos5l_inv_1_1.A 0.04202f
C1477 di_dith_amp[1] di_dith_en 0.11625f
C1478 a_9721_7200# vdd 0.20754f
C1479 sg13cmos5l_inv_1_3.A xq_vg_p_0_ 0.74249f
C1480 sg13cmos5l_inv_1_4.Y xq_vg_p_2_ 0.06899f
C1481 d_amp_s[0] d_dith[2] 0.03044f
C1482 sg13cmos5l_nand2_1_2.Y do_q_b 0.02607f
C1483 sw_tgate_8.m vi_esd 0.4924f
C1484 sg13cmos5l_inv_1_17.Y a_6757_9948# 0.02387f
C1485 d_phi1 d_rst_b 0.23406f
C1486 vcm_esd d_dith_en 0.11074f
C1487 a_6859_7241# d_qclk 0.01065f
C1488 a_10989_15998# vdd 0.28639f
C1489 quantizer2_lfsr_0.sg13cmos5l_dfrbpq_1_0.Q d_qclk 0.09171f
C1490 a_20758_20880# a_20758_20740# 0.84953f
C1491 sg13cmos5l_inv_1_16.Y sg13cmos5l_inv_1_14.A 0.02296f
C1492 dsm2_io_0.dsm2_io_rx_9.di_b a_1502_28364# 0.01943f
C1493 sg13cmos5l_inv_1_3.Y sg13cmos5l_inv_1_9.Y 0.92518f
C1494 a_22499_864# vdd 0.24949f
C1495 sg13cmos5l_inv_1_17.A xq_vg_p_2_ 0.06975f
C1496 a_1288_778# d_dith_en 0.20586f
C1497 dsm2_io_0.do_btest_en do_clk_osc 0.07185f
C1498 a_19964_18216# a_24602_14546# 0.07427f
C1499 sg13cmos5l_nand2_1_2.Y a_11201_9948# 0.02314f
C1500 xq_vg_q_2_ vo_p 0.39282f
C1501 a_12445_30191# xsc_vfb 0.26831f
C1502 a_2208_18981# vdd 0.06975f
C1503 a_522_9960# vdd 0.0721f
C1504 a_13569_7467# d_phi2 0.04668f
C1505 sg13cmos5l_nand2_1_5.A vdd 1.4207f
C1506 sg13cmos5l_and2_1_5.X d_qi 0.04807f
C1507 sg13cmos5l_and2_1_5.X sg13cmos5l_inv_1_12.Y 0.01252f
C1508 sg13cmos5l_nand2_2_0.B sg13cmos5l_inv_2_5.Y 0.17883f
C1509 sg13cmos5l_inv_1_15.Y d_dith[2] 0.2329f
C1510 quantizer2_lfsr_0.sg13cmos5l_nor2_1_0.A d_amp_s[2] 0.20649f
C1511 quantizer2_lfsr_0.sg13cmos5l_dfrbpq_1_0.D d_qclk 0.2803f
C1512 a_2045_8480# vdd 0.23723f
C1513 a_537_11589# a_558_10886# 0.02431f
C1515 sw_tgate_9.gb sw_tgate_6.p 0.04452f
C1516 sw_tgate_6.p vdd 0.98469f
C1517 a_20260_17236# a_19904_17646# 0.219f
C1518 vcm_esd d_rst_b 0.01927f
C1519 sg13cmos5l_inv_1_13.A sg13cmos5l_inv_1_13.Y 0.93737f
C1520 sg13cmos5l_inv_1_6.Y sg13cmos5l_and2_1_5.B 0.01683f
C1521 a_522_13269# vdd 0.27678f
C1522 di_trim[0] di_trim[1] 0.11625f
C1523 inv_en_0.di_b d_ena 0.06761f
C1524 quantizer2_lfsr_0.sg13cmos5l_dfrbpq_1_2.D d_dith_en 0.44655f
C1525 a_28334_20880# a_28334_20740# 0.1335f
C1526 a_23195_985# vdd 0.5369f
C1527 a_522_15314# a_533_15104# 0.03546f
C1528 sg13cmos5l_or2_1_0.X sg13cmos5l_nor2_2_0.B 0.06677f
C1529 sg13cmos5l_or2_1_0.X d_amp_s[3] 0.01878f
C1530 dsm2_osc_0.dsm2_io_rx_0.di_b a_21830_2088# 0.01078f
C1531 xq_dith_v_bq d_amp_s_b[3] 0.22347f
C1532 sg13cmos5l_nand2_1_5.A sg13cmos5l_inv_1_16.Y 0.07704f
C1533 quantizer2_lfsr_0.sg13cmos5l_dfrbpq_1_0.D a_567_3378# 0.01375f
C1534 sw_tgate_cmfb2_1.p a_13189_30111# 0.18593f
C1535 a_1322_9362# vdd 0.20468f
C1536 a_19105_884# vdd 0.40535f
C1537 sg13cmos5l_inv_1_8.Y d_dith[1] 0.16179f
C1538 a_19999_22684# a_20758_22420# 0.12754f
C1539 a_522_7368# a_571_6276# 0.24435f
C1540 quantizer2_lfsr_0.di_dith_amp[0] vdd 0.99563f
C1541 a_6817_30111# a_5176_31117# 0.82488f
C1542 a_11956_7466# vdd 0.20754f
C1543 sg13cmos5l_nand2_1_5.A sg13cmos5l_inv_1_10.Y 0.14036f
C1544 a_9556_15186# d_qi_b 0.02981f
C1545 quantizer2_lfsr_0.sg13cmos5l_dfrbpq_1_2.D a_1288_5962# 0.01523f
C1546 a_1324_11172# a_1288_11146# 0.24169f
C1547 quantizer2_lfsr_0.sg13cmos5l_dfrbpq_1_6.Q vdd 0.42654f
C1548 a_15491_15614# d_ena 0.08657f
C1549 sg13cmos5l_inv_1_11.Y sg13cmos5l_and2_1_5.B 0.01665f
C1550 a_24626_19480# dsm2_osc_0.d_btest_or 0.01657f
C1551 a_19964_18216# a_19984_17824# 1.72357f
C1552 quantizer2_lfsr_0.sg13cmos5l_nor2_1_1.B d_amp_s[1] 0.36142f
C1553 a_522_15478# d_dith_en 0.11514f
C1554 vdd do_q_b 1.69319f
C1555 a_522_7368# d_dith_en 0.33047f
C1556 xsc_xcmfb1_vsw_cm_p sw_tgate_cmfb2_1.gb 0.48025f
C1557 a_558_5702# quantizer2_lfsr_0.sg13cmos5l_dfrbpq_1_9.D 0.19055f
C1558 clk_noverlap_0.sg13cmos5l_inv_1_0.A clk_noverlap_0.sg13cmos5l_inv_1_10.A 0.04602f
C1559 dsm2_io_vcmg_0.di_vcm_ext clk_noverlap_0.di_clk 0.03545f
C1560 a_24164_726# vdd 0.06987f
C1561 a_22252_11246# bias_gm_0.bias_trim_0.vz 5.03939f
C1562 xsc_vvg_n xsc_xcmfb1_vsw_cm_p 0.13662f
C1563 xsc_vvg_p xsc_vc1r_p 0.16912f
C1564 quantizer2_lfsr_0.sg13cmos5l_dfrbpq_1_2.D a_1407_10130# 0.01101f
C1565 clk_noverlap_0.di_clk vi_esd 0.0664f
C1566 quantizer2_lfsr_0.di_dith_amp[1] a_526_16657# 0.03544f
C1567 sg13cmos5l_inv_1_16.A sg13cmos5l_inv_1_17.Y 5.18106f
C1568 a_13960_5586# a_14728_5586# 0.05462f
C1569 a_2049_4965# a_2070_4262# 0.02431f
C1570 a_20000_22420# a_20000_22280# 0.1335f
C1571 sg13cmos5l_inv_2_5.A vdd 0.43363f
C1572 a_12445_30191# a_7224_31505# 0.06978f
C1573 a_5176_31469# a_8762_31505# 1.17273f
C1574 a_6817_30111# a_5176_30111# 2.34369f
C1575 a_5176_31117# a_9348_31505# 0.51908f
C1576 a_20138_14766# vdd 21.8361f
C1577 a_2208_23021# a_2208_22253# 0.05462f
C1578 a_8208_15626# inv_en_0.di_b 0.01057f
C1579 sg13cmos5l_or2_1_0.X d_dith_en 0.24721f
C1580 a_1322_9362# a_1367_9125# 0.07916f
C1581 clk_noverlap_0.sg13cmos5l_dlygate4sd3_1_0.A a_4649_7224# 0.0315f
C1582 quantizer2_lfsr_0.di_dith_amp[0] d_amp_s_b[0] 0.01295f
C1583 sg13cmos5l_inv_1_6.Y sg13cmos5l_and2_1_5.X 0.02128f
C1584 a_522_15144# a_533_15104# 0.20759f
C1585 sg13cmos5l_or2_1_0.X xq_vg_q_0_ 0.10823f
C1586 sg13cmos5l_inv_1_3.Y xq_vg_p_0_ 0.75789f
C1587 a_2049_4965# vdd 0.23798f
C1588 a_1322_6770# d_dith_en 0.29031f
C1589 dsm2_io_vcmg_0.di_vcm_ext do_q_dec 0.04795f
C1590 a_10291_7286# vdd 0.07831f
C1591 sg13cmos5l_inv_1_6.A sg13cmos5l_inv_1_3.A 0.13278f
C1592 a_2034_8854# a_2045_8480# 0.17382f
C1593 a_20000_20600# a_20000_20460# 0.1335f
C1594 quantizer2_lfsr_0.di_dith_amp[1] a_522_15861# 0.03381f
C1595 a_24540_20600# a_24540_20320# 0.04477f
C1596 dsm2_osc_0.sg13cmos5l_dfrbp_1_0.RESET_B a_22000_594# 0.09804f
C1597 m2_10908_16655# vdd 0.67373f
C1598 d_dith_en di_clk_sel 0.08444f
C1599 xsc_vfb vdd 1.22113f
C1600 clk_noverlap_0.sg13cmos5l_dlygate4sd3_1_0.X d_qclk 0.01047f
C1601 quantizer2_lfsr_0.sg13cmos5l_dfrbpq_1_0.D quantizer2_lfsr_0.sg13cmos5l_dfrbpq_1_0.Q 0.0303f
C1602 a_2208_32237# dsm2_io_0.do_trim_b[0] 0.01268f
C1603 inv_en_0.di_b sg13cmos5l_inv_1_13.Y 0.06158f
C1604 a_1284_2901# a_1407_2354# 0.07015f
C1605 a_22252_4374# a_22252_4074# 1.04634f
C1606 a_1284_5391# a_1681_4561# 0.16704f
C1607 a_20672_22140# a_20758_22280# 0.01899f
C1608 a_16941_5500# a_17416_5586# 0.01392f
C1609 a_1324_5988# a_1600_6533# 0.24435f
C1610 a_24602_15746# vdd 0.12373f
C1611 sg13cmos5l_and2_1_5.X sg13cmos5l_inv_1_11.Y 0.01244f
C1612 quantizer2_lfsr_0.sg13cmos5l_dfrbpq_1_2.D a_1322_14546# 0.02483f
C1613 sg13cmos5l_nand2_2_0.B sg13cmos5l_nor2_2_2.A 0.21377f
C1614 dsm2_io_0.sg13cmos5l_inv_1_5.A vdd 0.26636f
C1615 sg13cmos5l_nand2_1_2.Y sg13cmos5l_inv_1_18.Y 0.02099f
C1616 quantizer2_lfsr_0.sg13cmos5l_dfrbpq_1_11.D a_1324_804# 0.01476f
C1617 dsm2_io_0.sg13cmos5l_inv_1_1.A di_qout_en 0.19123f
C1618 a_26284_874# vcm_esd 0.05265f
C1619 a_8768_5586# vdd 0.06396f
C1620 dsm2_io_vcmg_0.di_vcm_ext d_qclk 4.51124f
C1621 sw_tgate_9.gb sw_tgate_12.m 0.5121f
C1622 sg13cmos5l_and2_1_5.A d_qi 0.04718f
C1623 vo_p d_amp_s[1] 0.18945f
C1624 a_1324_11172# vdd 0.07233f
C1625 sw_tgate_12.m vdd 0.98525f
C1626 quantizer2_lfsr_0.sg13cmos5l_dfrbpq_1_8.D quantizer2_lfsr_0.sg13cmos5l_dfrbpq_1_15.D 0.01273f
C1627 a_24626_20600# a_24626_20460# 0.84953f
C1628 dsm2_osc_0.sg13cmos5l_dfrbp_1_0.RESET_B a_23289_752# 0.22087f
C1629 bias_gm_0.bias_trim_0.vz a_24404_4674# 0.84205f
C1630 vdd d_amp_s_b[1] 0.8763f
C1631 a_522_2354# a_533_2144# 0.03546f
C1632 bias_gm_0.bias_trim_0.vz a_22252_8546# 2.32522f
C1633 a_2049_2373# a_2079_1938# 0.02241f
C1634 a_2034_8520# a_2070_6854# 0.26205f
C1635 a_2045_8480# a_2083_7428# 0.07823f
C1636 a_2208_29933# vdd 0.54527f
C1637 a_14548_7466# d_phi2 0.05183f
C1638 a_15297_7467# a_15412_7466# 0.3854f
C1639 a_20758_22280# a_20758_22140# 0.84953f
C1640 clk_noverlap_0.sg13cmos5l_dlygate4sd3_1_0.A a_7129_7200# 0.03553f
C1641 a_24214_15146# vdd 0.12369f
C1642 sg13cmos5l_inv_1_6.A d_dith[1] 0.06765f
C1643 sg13cmos5l_inv_1_15.Y sg13cmos5l_inv_1_16.A 0.16198f
C1644 a_9352_5586# d_phi1 0.02214f
C1645 sg13cmos5l_nand2_1_5.A sg13cmos5l_inv_1_13.A 0.26707f
C1646 a_12424_5586# vdd 0.50996f
C1647 sg13cmos5l_inv_1_16.Y d_amp_s_b[1] 0.0256f
C1648 a_567_11154# vdd 0.09469f
C1649 d_ena d_amp_s[3] 0.12314f
C1650 a_28126_20460# a_28126_20180# 0.04477f
C1651 dsm2_io_vcmg_0.di_vcm_ext_b d_dith[1] 0.26549f
C1652 quantizer2_lfsr_0.sg13cmos5l_dfrbpq_1_13.D d_dith_en 0.13463f
C1653 a_1502_28364# vdd 0.04402f
C1654 a_522_2184# a_533_2144# 0.20759f
C1655 a_1284_2799# a_1322_1586# 0.17382f
C1656 a_2034_3336# d_qclk 0.11103f
C1657 clk_noverlap_0.sg13cmos5l_inv_1_0.A clk_noverlap_0.sg13cmos5l_inv_1_11.Y 0.84082f
C1658 sg13cmos5l_inv_1_9.Y xq_dith_v_bp 1.36472f
C1659 sg13cmos5l_inv_1_4.Y sg13cmos5l_inv_1_16.A 0.22923f
C1660 a_1284_2901# vdd 0.27771f
C1661 dsm2_io_0.do_trim_b[0] a_22252_8246# 0.08938f
C1662 a_19904_17646# a_24602_14546# 0.06967f
C1663 d_amp_s_b[0] d_amp_s_b[1] 5.43227f
C1664 a_7224_31505# vdd 1.41667f
C1665 a_20758_22140# a_24258_22000# 0.01899f
C1666 dsm2_io_0.do_btest_en do_osc_oe 0.05017f
C1667 a_22138_14846# vdd 0.02171f
C1668 dsm2_io_0.do_btest_en d_phi1 0.23708f
C1669 dsm2_io_0.do_trim_b[3] dsm2_io_0.sg13cmos5l_inv_1_5.A 0.09855f
C1670 sg13cmos5l_inv_1_16.A sg13cmos5l_inv_1_17.A 6.17118f
C1671 sg13cmos5l_inv_2_5.Y vdd 0.4601f
C1672 clk_noverlap_0.sg13cmos5l_dlygate4sd3_1_1.X a_5995_7241# 0.30507f
C1673 clk_noverlap_0.sg13cmos5l_dlygate4sd3_1_0.A a_7723_7241# 0.03228f
C1674 quantizer2_lfsr_0.sg13cmos5l_dfrbpq_1_12.Q di_osc_en 0.01015f
C1675 sg13cmos5l_inv_1_18.Y vdd 0.54953f
C1676 a_16832_5586# vdd 0.06615f
C1677 dsm2_osc_0.ibias_in ibias_test 0.06492f
C1678 a_2034_11446# vdd 0.16967f
C1679 sg13cmos5l_inv_1_6.A sg13cmos5l_inv_1_3.Y 0.18769f
C1680 sg13cmos5l_inv_1_6.Y sg13cmos5l_inv_1_19.Y 0.22852f
C1681 a_2034_3670# d_dith_en 0.14777f
C1682 dsm2_io_0.do_btest_en dsm2_osc_0.ibias_in 0.05422f
C1683 bias_gm_0.bias_trim_0.vz vdd 247.51f
C1684 a_20672_20180# a_20758_20320# 0.01899f
C1685 a_2070_6030# a_2034_5928# 0.25046f
C1687 sg13cmos5l_inv_1_9.Y do_q 0.20614f
C1688 sg13cmos5l_inv_1_13.A do_q_b 0.01721f
C1689 a_522_2184# a_537_1221# 0.28324f
C1690 a_10784_6484# vdd 0.29673f
C1691 sg13cmos5l_inv_1_4.Y sg13cmos5l_inv_1_17.Y 0.02435f
C1692 sg13cmos5l_inv_1_6.Y sg13cmos5l_and2_1_5.A 0.01573f
C1693 a_24258_22000# a_20758_22000# 0.01899f
C1694 a_24404_8546# vdd 0.98753f
C1695 d_ena d_dith_en 0.19343f
C1696 dsm2_io_0.do_btest_en vcm_esd 0.24305f
C1697 sg13cmos5l_and2_2_1.X do_q 0.01212f
C1698 sg13cmos5l_inv_1_17.A sg13cmos5l_inv_1_17.Y 0.81662f
C1699 sg13cmos5l_inv_1_9.Y a_13870_15077# 0.01138f
C1700 sg13cmos5l_inv_1_16.Y sg13cmos5l_inv_1_18.Y 0.08701f
C1701 sg13cmos5l_inv_1_13.A a_11201_9948# 0.02621f
C1702 a_14829_7164# d_phi2 0.05782f
C1703 a_522_7702# a_522_7538# 0.23043f
C1704 a_1284_8085# a_1284_7983# 0.09257f
C1705 clk_noverlap_0.sg13cmos5l_dlygate4sd3_1_9.A a_15297_7467# 0.12324f
C1706 xq_vg_p_2_ d_amp_s_b[2] 0.04435f
C1707 a_533_4736# vdd 0.20451f
C1708 quantizer2_lfsr_0.sg13cmos5l_dfrbpq_1_2.D a_1286_12023# 0.01545f
C1709 a_2034_3670# a_2070_3438# 0.16704f
C1710 a_1367_3941# quantizer2_lfsr_0.sg13cmos5l_dfrbpq_1_11.Q 0.20282f
C1711 a_1324_13764# d_qclk 0.07679f
C1712 dsm2_io_vcmg_0.di_vcm_ext quantizer2_lfsr_0.sg13cmos5l_nor2_1_0.A 0.14348f
C1713 a_19984_17824# a_19904_17646# 0.73899f
C1714 a_522_8085# vdd 0.28033f
C1715 a_2208_26861# dsm2_io_0.do_trim_b[0] 0.02092f
C1716 sg13cmos5l_inv_1_18.Y d_amp_s_b[0] 0.04293f
C1717 a_2208_23789# vdd 0.52931f
C1718 a_11841_7467# vdd 0.15912f
C1719 dsm2_io_vcmg_0.di_vcm_ext quantizer2_lfsr_0.sg13cmos5l_dfrbpq_1_0.D 0.03343f
C1720 sg13cmos5l_nand2_1_5.A inv_en_0.di_b 0.15266f
C1721 sg13cmos5l_inv_1_11.Y sg13cmos5l_and2_1_5.A 0.0211f
C1722 a_856_16970# d_amp_s[0] 0.01463f
C1723 quantizer2_lfsr_0.sg13cmos5l_dfrbpq_1_0.D a_567_5970# 0.01387f
C1724 sg13cmos5l_inv_1_13.Y sg13cmos5l_nor2_2_0.B 0.04273f
C1725 a_2079_1938# vdd 0.09389f
C1726 a_533_2144# a_571_1092# 0.07823f
C1727 a_522_2184# a_558_518# 0.26205f
C1728 a_1681_1969# a_1324_804# 0.25046f
C1729 d_phi1 d_qout_en 0.02783f
C1730 a_8762_31505# vo_p 2.70219f
C1731 a_11259_9628# a_11259_9488# 0.19806f
C1732 quantizer2_lfsr_0.sg13cmos5l_dfrbpq_1_1.Q d_dith_en 0.03733f
C1733 d_dith_en di_osc_en 1.95909f
C1734 di_dith_en di_clk_sel 0.02982f
C1735 d_ena d_rst_b 3.50461f
C1736 sg13cmos5l_inv_1_19.Y vo_p 0.07564f
C1737 sw_tgate_cmfb2_1.p sw_tgate_cmfb2_1.gb 0.62607f
C1738 a_1286_9431# d_qclk 0.23475f
C1739 a_7241_7224# a_7129_7200# 0.3854f
C1740 sg13cmos5l_nand2_1_2.Y a_6757_9808# 0.01105f
C1741 sg13cmos5l_inv_1_20.Y a_14266_14856# 0.01899f
C1742 sw_tgate_cmfb2_1.p xsc_vvg_n 0.97076f
C1743 dsm2_io_0.do_btest_en d_phi2 0.12812f
C1744 quantizer2_lfsr_0.sg13cmos5l_dfrbpq_1_13.D a_1322_14546# 0.01791f
C1745 sg13cmos5l_nand2_1_5.A a_15491_15614# 0.01285f
C1746 dsm2_io_0.do_trim_b[3] bias_gm_0.bias_trim_0.vz 1.17947f
C1747 bias_gm_0.bias_trim_0.vz a_21252_3394# 1.4206f
C1748 a_24258_20040# a_24540_20040# 0.04564f
C1750 xq_vg_q_0_ a_8747_9628# 0.01203f
C1751 dsm2_io_0.dsm2_io_rx_9.di_b di_ena 0.2455f
C1752 dsm2_osc_0.sg13cmos5l_buf_2_0.A a_20447_636# 0.12403f
C1753 a_19964_18216# ibias_200n 0.42282f
C1754 quantizer2_lfsr_0.sg13cmos5l_dfrbpq_1_2.D a_1284_2799# 0.01536f
C1755 clk_noverlap_0.sg13cmos5l_inv_1_9.A d_phi1 0.01247f
C1756 a_522_12552# d_qclk 0.04963f
C1757 d_amp_s_b[2] d_dith[2] 0.02822f
C1758 vcm_esd d_qout_en 0.01945f
C1759 a_537_1221# a_571_1092# 0.01562f
C1760 a_1286_1655# vdd 0.25131f
C1761 di_rst_b di_clk_sel 0.02983f
C1762 a_20758_19620# d_ena 0.01376f
C1763 dsm2_io_0.do_trim_b[3] a_24404_8546# 0.34711f
C1764 a_21252_3394# a_24404_8546# 0.06556f
C1765 sg13cmos5l_inv_1_4.A xq_vg_p_2_ 0.18242f
C1766 sg13cmos5l_inv_1_6.Y a_6884_8680# 0.01925f
C1767 dsm2_io_vcmg_0.di_vcm_ext_b quantizer2_lfsr_0.sg13cmos5l_dfrbpq_1_3.Q 0.05843f
C1768 xvcm_vcf_b d_vcm_phi1_b 0.86562f
C1769 inv_en_0.di_b do_q_b 0.31354f
C1770 quantizer2_lfsr_0.di_dith_amp[1] quantizer2_lfsr_0.sg13cmos5l_nor2_1_0.A 0.13537f
C1771 a_558_8294# vdd 0.52623f
C1772 clk_noverlap_0.sg13cmos5l_dlygate4sd3_1_0.A clk_noverlap_0.sg13cmos5l_inv_1_0.A 0.03951f
C1773 dsm2_io_0.do_btest_en dsm2_osc_0.sg13cmos5l_inv_1_3.A 0.01687f
C1774 a_7437_15998# vdd 0.28613f
C1775 a_13211_8748# a_11201_8748# 0.01899f
C1776 a_8747_8748# a_10757_8608# 0.01899f
C1777 a_2045_5888# d_dith_en 0.29304f
C1778 sg13cmos5l_inv_1_13.Y d_dith_en 0.01503f
C1779 sg13cmos5l_inv_1_15.Y sg13cmos5l_inv_1_17.A 0.07731f
C1780 sg13cmos5l_nor2_2_2.A vdd 0.5097f
C1781 sg13cmos5l_inv_1_20.Y xq_vg_q_2_ 0.02732f
C1782 sg13cmos5l_inv_1_13.Y xq_vg_q_0_ 0.13779f
C1783 sg13cmos5l_inv_1_9.Y xq_vg_p_2_ 0.12379f
C1784 dsm2_io_0.do_trim_b[0] a_2208_22253# 0.0149f
C1785 a_24540_20040# a_24626_20040# 0.01899f
C1786 clk_noverlap_0.sg13cmos5l_dlygate4sd3_1_0.A clk_noverlap_0.sg13cmos5l_dlygate4sd3_1_1.X 0.0383f
C1787 a_1284_5391# d_qclk 0.01536f
C1788 a_11201_8468# d_amp_s[0] 0.01851f
C1789 a_558_15246# a_537_14181# 0.01058f
C1790 a_1322_11954# d_qclk 0.04365f
C1791 sg13cmos5l_inv_1_6.Y sg13cmos5l_inv_1_3.A 0.03649f
C1792 sw_tgate_9.gb sw_tgate_8.m 0.04087f
C1793 sw_tgate_8.m vdd 0.31406f
C1794 a_571_1092# a_558_518# 0.18486f
C1795 a_1324_804# a_1367_1349# 0.26205f
C1796 vdd d_dith[0] 1.3208f
C1797 a_20758_19480# d_ena 0.01184f
C1798 a_24540_21720# a_24626_21860# 0.01899f
C1799 a_2208_19661# a_2208_19557# 0.05762f
C1800 sg13cmos5l_inv_1_4.Y sg13cmos5l_inv_1_17.A 0.25639f
C1801 dsm2_io_0.sg13cmos5l_inv_1_3.A dsm2_io_0.sg13cmos5l_inv_1_0.A 0.10378f
C1802 a_20328_23820# ibias_200n 1.06471f
C1803 xsc_vfb xsc_xcmfb1_vsw_cm_n 0.77364f
C1804 a_2034_6098# vdd 0.1348f
C1805 a_6757_9808# vdd 0.02351f
C1806 a_522_10677# a_522_10294# 0.09257f
C1807 a_11115_8608# a_11201_8608# 0.01899f
C1808 dsm2_io_0.do_btest_en di_clk_sel 0.02519f
C1809 a_8768_15909# sg13cmos5l_and2_1_4.X 0.0733f
C1810 sg13cmos5l_inv_1_20.Y sg13cmos5l_inv_1_1.A 0.19514f
C1811 xvcm_vcf_b m2_10908_16863# 0.06037f
C1812 a_24626_20040# a_28126_19900# 0.01899f
C1813 xq_vg_p_1_ a_11259_9488# 0.01185f
C1814 a_21498_769# a_21617_558# 0.09076f
C1815 a_20447_636# a_20947_892# 0.03336f
C1816 quantizer2_lfsr_0.sg13cmos5l_dfrbpq_1_0.D a_1324_13764# 0.02485f
C1817 a_20770_598# a_20673_892# 0.02925f
C1818 dsm2_io_0.sg13cmos5l_inv_1_1.A di_vcm_ext 0.0379f
C1819 a_526_16657# vdd 0.18248f
C1820 a_21830_2578# vdd 0.1075f
C1821 dsm2_osc_0.ibias_in vcm 0.04839f
C1822 a_558_13478# d_dith_en 0.11434f
C1823 dsm2_osc_0.dsm2_io_rx_1.di_b m2_10908_16863# 0.018f
C1824 sg13cmos5l_inv_1_13.A sg13cmos5l_inv_1_18.Y 0.19841f
C1825 a_8747_8608# d_amp_s_b[0] 0.02394f
C1826 a_2034_1082# vdd 0.18851f
C1827 a_19964_18216# d_ena 0.06381f
C1828 sg13cmos5l_inv_1_10.Y d_dith[0] 0.26847f
C1829 sg13cmos5l_inv_1_16.Y a_6757_9808# 0.01032f
C1830 xq_dith_v_bq d_phi1 0.17071f
C1831 d_amp_s_b[0] d_dith[0] 0.02916f
C1832 clk_noverlap_0.do_phi2_b vdd 0.39285f
C1833 a_2049_2373# d_qclk 0.22104f
C1834 quantizer2_lfsr_0.sg13cmos5l_dfrbpq_1_1.D a_522_15478# 0.0168f
C1835 a_5176_31117# ibias_200n 0.08515f
C1836 xsc_vvg_n sw_tgate_cmfb2_1.gb 0.08851f
C1837 a_2034_8690# vdd 0.14124f
C1838 sg13cmos5l_inv_1_3.A vo_p 0.31081f
C1839 xq_vg_q_2_ xq_vg_q_1_ 0.34358f
C1840 a_2049_7557# a_2070_6854# 0.02431f
C1841 a_522_7702# a_533_7328# 0.17382f
C1842 vcm_esd vcm 0.15629f
C1843 quantizer2_lfsr_0.sg13cmos5l_dfrbpq_1_2.D a_1324_3396# 0.02703f
C1844 sg13cmos5l_and2_1_5.B sg13cmos5l_inv_1_2.A 0.02865f
C1845 quantizer2_lfsr_0.sg13cmos5l_nor2_1_1.B a_1284_15861# 0.01198f
C1846 a_16161_7467# a_16276_7466# 0.3854f
C1847 a_522_15861# vdd 0.27726f
C1848 a_2034_11446# a_2034_11112# 0.01412f
C1849 a_1367_11717# quantizer2_lfsr_0.sg13cmos5l_dfrbpq_1_14.D 0.19027f
C1850 a_20672_19900# a_20672_19620# 0.04477f
C1851 a_28126_19900# a_24626_19900# 0.01899f
C1852 sg13cmos5l_or2_1_0.X d_qout_en 0.09706f
C1853 sg13cmos5l_nand2_1_5.A sg13cmos5l_nor2_2_0.B 0.04721f
C1854 dsm2_osc_0.d_btest_or dsm2_osc_0.sg13cmos5l_dfrbp_1_0.RESET_B 0.49741f
C1855 sg13cmos5l_inv_1_20.Y sg13cmos5l_and2_1_5.B 0.05413f
C1856 a_22184_2052# vdd 0.17922f
C1857 a_11201_9308# a_11201_9168# 0.48787f
C1858 a_8661_9028# a_8747_9168# 0.01899f
C1859 sg13cmos5l_inv_1_4.A a_6757_9948# 0.12519f
C1860 a_20758_21720# a_20758_21580# 0.84953f
C1861 sg13cmos5l_nand2_1_2.Y d_qclk 0.10631f
C1862 dsm2_osc_0.ibias_in a_21554_2798# 0.04631f
C1863 a_1407_2354# d_qclk 0.01087f
C1864 dsm2_io_vcmg_0.di_vcm_ext_b a_2208_17741# 0.03887f
C1865 a_522_10130# d_dith_en 0.1175f
C1866 sg13cmos5l_and2_1_5.B a_14734_15077# 0.10864f
C1867 a_5176_30111# ibias_200n 0.27664f
C1868 a_1600_6533# a_1367_6533# 0.18486f
C1869 sw_tgate_cmfb2_1.p xsc_xcmfb1_vsw_vbias 0.41334f
C1870 clk_noverlap_0.di_clk vdd 0.87696f
C1871 clk_noverlap_0.sg13cmos5l_inv_1_8.A clk_noverlap_0.do_phi2_b 0.1059f
C1872 xq_vg_p_0_ xq_vg_p_2_ 0.14734f
C1873 di_dith_en di_osc_en 0.04687f
C1874 a_1284_7983# a_1681_7153# 0.16704f
C1875 a_11656_5586# xvcm_vcf_b 0.01282f
C1876 a_10888_5586# xvcm_vcf_t 0.01422f
C1877 a_20328_23820# d_ena 1.53982f
C1878 sg13cmos5l_inv_1_16.A sg13cmos5l_inv_2_0.Y 0.07727f
C1879 a_2079_7122# vdd 0.09553f
C1880 a_21554_2798# vcm_esd 0.01445f
C1881 a_20758_19900# a_20758_19760# 0.84953f
C1882 a_2034_14421# a_2034_14038# 0.09257f
C1883 clk_noverlap_0.sg13cmos5l_dlygate4sd3_1_0.A a_8969_7224# 0.02784f
C1884 a_6377_7224# clk_noverlap_0.sg13cmos5l_dlygate4sd3_1_2.X 0.12324f
C1885 quantizer2_lfsr_0.di_dith_amp[1] dsm2_io_vcmg_0.di_vcm_ext 0.26551f
C1886 quantizer2_lfsr_0.sg13cmos5l_dfrbpq_1_2.D a_2034_1466# 0.0211f
C1887 a_21617_558# a_22000_594# 0.21135f
C1888 quantizer2_lfsr_0.di_dith_amp[0] d_amp_s[3] 0.24513f
C1889 quantizer2_lfsr_0.sg13cmos5l_dfrbpq_1_11.D a_533_15104# 0.01686f
C1890 vo_p d_dith[1] 0.01969f
C1891 a_8661_9028# a_8661_8748# 0.04477f
C1892 a_28334_21720# a_28334_21580# 0.1335f
C1893 a_22252_11246# a_24626_20600# 0.01575f
C1894 a_2083_2244# d_qclk 0.01429f
C1895 vdd do_q_dec 2.15874f
C1896 sg13cmos5l_nor2_2_0.B do_q_b 0.05091f
C1897 a_522_9960# d_dith_en 0.33029f
C1898 sg13cmos5l_nand2_1_5.A d_dith_en 0.24946f
C1899 sg13cmos5l_inv_1_1.A sg13cmos5l_inv_1_0.A 0.20302f
C1900 clk_noverlap_0.sg13cmos5l_nor3_1_0.C d_amp_s_b[3] 0.0158f
C1901 clk_noverlap_0.sg13cmos5l_dlygate4sd3_1_4.X d_qclk 0.01014f
C1902 di_rst_b di_osc_en 0.04774f
C1903 a_533_4736# a_571_3684# 0.07823f
C1904 a_522_4776# a_558_3110# 0.26205f
C1905 sg13cmos5l_nor2_2_0.Y a_10787_14878# 0.01631f
C1906 a_537_14181# a_571_14052# 0.01562f
C1907 a_5176_31117# d_ena 0.39194f
C1908 a_2045_8480# d_dith_en 0.29201f
C1909 a_1286_6839# vdd 0.24938f
C1910 a_24258_19760# a_24258_19480# 0.04477f
C1911 a_28334_19900# a_28334_19760# 0.1335f
C1912 a_2034_14038# a_2070_13806# 0.16704f
C1913 a_2034_8854# a_2034_8690# 0.23043f
C1914 clk_noverlap_0.sg13cmos5l_dlygate4sd3_1_10.A d_phi2 0.0714f
C1915 a_2070_4262# d_qclk 0.0341f
C1916 a_15693_7164# clk_noverlap_0.sg13cmos5l_dlygate4sd3_1_10.A 0.30507f
C1917 a_21830_2578# a_21276_2052# 0.03442f
C1918 sg13cmos5l_or2_1_0.X sg13cmos5l_and2_1_4.X 0.16563f
C1919 a_24626_21160# dsm2_osc_0.d_btest_or 0.01657f
C1920 a_21554_2798# a_22738_2578# 0.06146f
C1921 dsm2_io_0.do_btest_en d_ena 4.52952f
C1922 a_522_13269# d_dith_en 0.01921f
C1923 vdd di_ena 0.51296f
C1924 a_19904_17646# ibias_200n 0.05986f
C1925 dsm2_osc_0.sg13cmos5l_inv_1_2.A m2_10908_16655# 0.01345f
C1926 a_22252_11246# a_24626_20460# 0.01575f
C1927 a_13101_7164# vdd 0.26215f
C1928 dsm2_io_vcmg_0.di_vcm_ext a_1324_13764# 0.01649f
C1929 vdd d_qclk 3.37582f
C1930 sg13cmos5l_nand2_1_5.A d_rst_b 0.82016f
C1931 a_1322_9362# d_dith_en 0.29047f
C1932 vdd d_amp_s[2] 0.59755f
C1933 sg13cmos5l_inv_1_13.A d_dith[0] 0.18763f
C1934 d_phi1 d_qi_b 0.43557f
C1935 d_amp_s_b[0] do_q_dec 0.302f
C1936 quantizer2_lfsr_0.di_dith_amp[0] d_dith_en 1.10739f
C1937 sg13cmos5l_inv_1_3.Y vo_p 0.23338f
C1938 a_20758_22280# d_ena 0.01376f
C1939 a_1324_13764# a_1367_14309# 0.26205f
C1940 a_5176_30111# d_ena 0.32154f
C1941 a_8105_7224# a_7993_7200# 0.3854f
C1942 quantizer2_lfsr_0.sg13cmos5l_dfrbpq_1_1.D quantizer2_lfsr_0.sg13cmos5l_dfrbpq_1_13.D 0.02769f
C1943 sg13cmos5l_inv_1_4.A sg13cmos5l_inv_1_16.A 0.08057f
C1944 sg13cmos5l_inv_1_13.A a_6757_9808# 0.01898f
C1945 d_dith_en do_q_b 0.06864f
C1946 dsm2_io_0.do_btest_en di_osc_en 0.08721f
C1947 a_567_3378# vdd 0.09469f
C1948 sg13cmos5l_nand2_2_0.B sg13cmos5l_inv_1_0.Y 0.03938f
C1949 dsm2_osc_0.d_btest_or dsm2_osc_0.dsm2_io_rx_0.di_b 0.17165f
C1950 dsm2_osc_0.sg13cmos5l_dfrbp_1_0.RESET_B a_22644_2344# 0.44681f
C1951 a_24626_21020# dsm2_osc_0.d_btest_or 0.01657f
C1952 sg13cmos5l_or2_1_0.X xq_dith_v_bq 3.34299f
C1953 dsm2_osc_0.sg13cmos5l_dfrbp_1_0.Q_N a_22258_594# 0.02081f
C1954 a_22000_594# a_22347_812# 0.03578f
C1955 sg13cmos5l_inv_1_16.Y d_qclk 0.06316f
C1956 a_2070_8622# a_2034_8520# 0.25046f
C1957 a_20000_21440# a_20000_21300# 0.1335f
C1958 a_24540_21440# a_24540_21160# 0.04477f
C1959 dsm2_osc_0.sg13cmos5l_dfrbp_1_0.CLK a_23289_752# 0.05557f
C1960 dsm2_osc_0.ibias_in vi 0.62134f
C1961 sg13cmos5l_inv_1_9.Y sg13cmos5l_inv_1_16.A 0.03535f
C1962 sg13cmos5l_nor2_1_0.Y sg13cmos5l_inv_1_4.Y 0.03255f
C1963 sw_tgate_cmfb2_1.gb xsc_xcmfb1_vsw_vbias 0.4859f
C1964 quantizer2_lfsr_0.di_dith_amp[0] d_rst_b 0.71888f
C1965 a_2208_18597# dsm2_io_0.sg13cmos5l_inv_1_1.A 0.02308f
C1966 quantizer2_lfsr_0.sg13cmos5l_dfrbpq_1_5.Q a_2034_13874# 0.01265f
C1967 a_1407_10130# a_1322_9362# 0.03546f
C1968 d_amp_s_b[0] d_qclk 0.05081f
C1969 a_522_7368# a_533_7328# 0.20759f
C1970 a_1284_10575# a_1324_8580# 0.01412f
C1971 a_1322_4178# a_1367_3941# 0.07916f
C1972 sg13cmos5l_inv_2_5.A d_dith_en 0.03698f
C1973 a_21498_769# do_clk_osc 0.0229f
C1974 xsc_vvg_n xsc_xcmfb1_vsw_vbias 0.1232f
C1975 sg13cmos5l_inv_1_6.A xq_vg_p_2_ 0.28175f
C1976 d_amp_s_b[1] d_amp_s[3] 5.77843f
C1977 d_amp_s[0] d_amp_s_b[2] 0.0216f
C1978 d_amp_s[1] d_amp_s_b[3] 0.29174f
C1979 d_amp_s_b[0] d_amp_s[2] 0.0429f
C1980 d_ena d_qout_en 1.01445f
C1981 sg13cmos5l_inv_1_4.A sg13cmos5l_inv_1_17.Y 0.19151f
C1982 sg13cmos5l_nor2_1_0.Y sg13cmos5l_inv_1_17.A 0.02959f
C1983 quantizer2_lfsr_0.di_dith_amp[1] quantizer2_lfsr_0.sg13cmos5l_dfrbpq_1_13.Q 0.06934f
C1984 sg13cmos5l_inv_1_16.A sg13cmos5l_and2_2_1.X 0.02806f
C1985 dsm2_io_0.do_btest_en dsm2_osc_0.sg13cmos5l_mux2_1_0.A1 0.02391f
C1986 vcm_esd vi 0.0191f
C1987 a_20000_19620# a_20000_19480# 0.1335f
C1988 a_2045_13664# a_2049_12741# 0.36374f
C1989 dsm2_io_0.sg13cmos5l_inv_1_4.A quantizer2_lfsr_0.di_dith_amp[0] 0.06446f
C1990 a_2049_4965# d_dith_en 0.04225f
C1991 xvcm_vcf_t vdd 7.40013f
C1992 sg13cmos5l_inv_1_16.A sg13cmos5l_inv_1_2.Y 0.02739f
C1993 a_22499_864# a_23150_752# 0.01562f
C1994 quantizer2_lfsr_0.sg13cmos5l_dfrbpq_1_0.D quantizer2_lfsr_0.sg13cmos5l_dfrbpq_1_7.D 0.02817f
C1995 dsm2_io_0.do_trim_b[0] dsm2_io_0.do_trim_b[2] 3.12962f
C1996 a_2208_23021# dsm2_io_0.do_trim_b[1] 0.01602f
C1997 a_24626_21440# a_24626_21300# 0.84953f
C1998 inv_en_0.di sg13cmos5l_or2_1_0.X 0.08899f
C1999 a_19904_17646# d_ena 0.5842f
C2000 a_11201_8888# d_amp_s_b[2] 0.01183f
C2001 sg13cmos5l_inv_1_9.Y sg13cmos5l_inv_1_17.Y 0.04142f
C2002 quantizer2_lfsr_0.sg13cmos5l_dfrbpq_1_8.D di_clk_sel 0.01053f
C2003 inv_en_0.di_b sg13cmos5l_nor2_2_2.A 0.02093f
C2004 quantizer2_lfsr_0.sg13cmos5l_dfrbpq_1_5.Q a_2045_13664# 0.02689f
C2005 a_522_7368# a_537_6405# 0.28324f
C2006 d_phi2 d_qi_b 0.60952f
C2007 di_qout_en di_clk_sel 0.02985f
C2008 xsc_vc1r_p sw_tgate_9.gb 0.36324f
C2009 xsc_vc1r_p vdd 1.01898f
C2010 a_2034_8854# d_qclk 0.01248f
C2011 d_qi do_q 0.47563f
C2012 xsc_vvg_p sw_tgate_9.gb 0.53772f
C2013 xsc_vvg_p vdd 1.23587f
C2014 sg13cmos5l_inv_1_17.Y sg13cmos5l_and2_2_1.X 0.03541f
C2015 inv_en_0.di_b d_dith[0] 0.82521f
C2016 a_24626_19620# a_24626_19480# 0.84953f
C2017 a_6859_7241# vdd 0.26095f
C2018 a_24626_20320# bias_gm_0.bias_trim_0.vz 0.01018f
C2019 quantizer2_lfsr_0.sg13cmos5l_dfrbpq_1_0.Q vdd 0.69921f
C2020 quantizer2_lfsr_0.sg13cmos5l_dfrbpq_1_1.Q quantizer2_lfsr_0.sg13cmos5l_dfrbpq_1_1.D 0.33806f
C2021 sg13cmos5l_inv_1_17.A sg13cmos5l_inv_2_0.Y 0.05341f
C2022 sg13cmos5l_inv_1_19.Y sg13cmos5l_inv_1_20.Y 0.01526f
C2023 a_1324_11172# d_dith_en 0.31056f
C2024 a_23195_985# a_23150_752# 0.18486f
C2025 d_dith_en d_amp_s_b[1] 0.04939f
C2026 a_28126_21300# a_28126_21020# 0.04477f
C2027 sg13cmos5l_inv_1_20.Y sg13cmos5l_and2_1_5.A 0.14859f
C2028 quantizer2_lfsr_0.sg13cmos5l_nor2_1_0.A vdd 0.42822f
C2029 a_16161_7467# vdd 0.16331f
C2030 xq_vg_q_0_ d_amp_s_b[1] 0.01149f
C2031 dsm2_io_vcmg_0.di_vcm_ext_b a_2034_8520# 0.01148f
C2032 a_1681_7153# a_1324_5988# 0.25046f
C2033 quantizer2_lfsr_0.sg13cmos5l_dfrbpq_1_2.Q a_2034_3506# 0.01079f
C2034 quantizer2_lfsr_0.sg13cmos5l_dfrbpq_1_0.D vdd 0.55176f
C2035 dsm2_io_vcmg_0.di_vcm_ext_b d_dith[2] 0.04119f
C2036 a_22000_594# do_clk_osc 0.01909f
C2037 sg13cmos5l_inv_2_5.Y a_11865_14889# 0.02596f
C2038 sg13cmos5l_and2_1_5.A a_14734_15077# 0.04752f
C2039 a_20758_19480# a_20758_19340# 0.84953f
C2040 a_24626_20180# bias_gm_0.bias_trim_0.vz 0.01168f
C2041 dsm2_io_vcmg_0.di_phi1_b a_8880_5832# 0.17818f
C2042 a_17025_7467# a_17140_7466# 0.3854f
C2043 a_567_11154# d_dith_en 0.21537f
C2044 a_2083_7428# d_qclk 0.01286f
C2045 a_22644_2344# dsm2_osc_0.dsm2_io_rx_0.di_b 0.24928f
C2046 dsm2_io_0.sg13cmos5l_inv_1_5.A dsm2_io_0.sg13cmos5l_inv_1_4.A 0.10453f
C2047 d_rst_b d_amp_s_b[1] 0.24332f
C2048 sg13cmos5l_nand2_1_2.Y sg13cmos5l_inv_1_0.Y 0.13749f
C2049 sg13cmos5l_or2_1_0.X d_qi_b 0.05955f
C2050 a_20672_21020# a_20758_21160# 0.01899f
C2051 a_2034_5928# a_2083_4836# 0.24435f
C2052 a_23674_2344# vdd 0.02122f
C2053 dsm2_io_vcmg_0.di_vcm_ext_b d_vcm_phi1_b 0.1937f
C2054 dsm2_io_vcmg_0.di_vcm_ext_b quantizer2_lfsr_0.sg13cmos5l_dfrbpq_1_5.Q 0.57325f
C2055 a_522_15478# a_522_15314# 0.23043f
C2056 a_1284_15861# a_1284_15759# 0.09257f
C2057 sg13cmos5l_inv_1_4.A sg13cmos5l_inv_1_4.Y 0.53865f
C2058 sg13cmos5l_inv_1_13.A d_qclk 0.24557f
C2059 sg13cmos5l_inv_1_19.Y xq_vg_q_1_ 0.15154f
C2060 a_12800_15736# vdd 0.08139f
C2061 clk_noverlap_0.sg13cmos5l_inv_1_0.Y d_ena 0.04082f
C2062 xq_dith_v_bq d_ena 0.04157f
C2063 sg13cmos5l_inv_1_18.Y d_dith_en 0.05579f
C2064 dsm2_io_0.do_btest_en a_22836_1332# 0.15777f
C2065 sg13cmos5l_inv_1_4.A sg13cmos5l_inv_1_17.A 0.92914f
C2066 a_2034_11446# d_dith_en 0.14666f
C2067 sg13cmos5l_inv_1_18.Y xq_vg_q_0_ 0.01504f
C2068 sg13cmos5l_inv_1_17.Y xq_vg_p_0_ 0.36508f
C2069 sg13cmos5l_inv_1_6.Y do_q 0.05212f
C2070 sg13cmos5l_inv_1_4.Y sg13cmos5l_inv_1_9.Y 0.34663f
C2071 a_11284_15186# vdd 0.32972f
C2072 clk_noverlap_0.sg13cmos5l_dlygate4sd3_1_0.A a_4537_7200# 0.04524f
C2073 a_2034_3336# a_2049_2373# 0.28324f
C2074 a_558_2286# d_dith_en 0.0112f
C2075 a_2034_11112# d_qclk 0.10952f
C2076 sg13cmos5l_inv_2_4.Y a_8768_15909# 0.10569f
C2077 a_19964_18216# a_20138_14766# 0.09747f
C2078 sg13cmos5l_nand2_1_2.Y xq_vg_p_1_ 0.2954f
C2079 sg13cmos5l_inv_1_9.Y sg13cmos5l_inv_1_17.A 0.02457f
C2080 a_22063_23104# a_22063_22964# 0.53278f
C2081 sg13cmos5l_inv_1_4.Y sg13cmos5l_and2_2_1.X 0.02659f
C2082 quantizer2_lfsr_0.sg13cmos5l_dfrbpq_1_1.D a_558_13478# 0.20402f
C2083 a_5401_7200# d_qclk 0.01038f
C2084 a_1284_13167# a_1681_12337# 0.16704f
C2085 a_10787_14878# sg13cmos5l_and2_2_1.X 0.16151f
C2086 a_533_4736# d_dith_en 0.30415f
C2087 dsm2_io_vcmg_0.di_vcm_ext_b m2_10908_16863# 2.87328f
C2088 a_2034_6262# a_2034_5928# 0.01412f
C2089 xsc_vc1l_p d_qi_b 0.04332f
C2090 sg13cmos5l_inv_2_0.Y sg13cmos5l_nor2_2_0.Y 0.10398f
C2091 sg13cmos5l_and2_1_5.A sg13cmos5l_inv_1_0.A 0.03747f
C2092 sg13cmos5l_inv_1_17.A sg13cmos5l_and2_2_1.X 0.16836f
C2093 inv_en_0.di_b do_q_dec 0.10741f
C2094 a_522_8085# d_dith_en 0.01722f
C2095 a_15584_15091# vdd 0.2891f
C2096 inv_en_0.di d_ena 0.46564f
C2097 clk_noverlap_0.sg13cmos5l_dlygate4sd3_1_0.X vdd 0.22829f
C2098 sg13cmos5l_inv_1_17.A sg13cmos5l_inv_1_2.Y 0.04995f
C2099 a_522_15478# a_522_15144# 0.01412f
C2100 sg13cmos5l_or2_1_0.X sg13cmos5l_inv_1_7.Y 0.04414f
C2101 sg13cmos5l_inv_1_3.A sg13cmos5l_inv_1_20.Y 0.08528f
C2102 a_24258_20880# a_24540_20880# 0.04564f
C2103 sg13cmos5l_inv_1_0.Y vdd 0.3331f
C2104 dsm2_osc_0.sg13cmos5l_dfrbp_1_0.RESET_B a_23674_2578# 0.07824f
C2105 a_2079_1938# d_dith_en 0.17932f
C2106 dsm2_osc_0.sg13cmos5l_inv_1_2.Y vdd 0.36322f
C2107 a_10120_5586# d_vcm_phi1_b 0.01269f
C2108 a_19964_18216# a_24602_15746# 0.07158f
C2109 a_1284_10677# vdd 0.27782f
C2110 a_20758_21300# d_ena 0.01376f
C2111 clk_noverlap_0.sg13cmos5l_dlygate4sd3_1_7.A vdd 0.23304f
C2112 a_19999_22964# a_19999_22824# 0.4505f
C2113 a_20328_23820# a_24626_23104# 0.01024f
C2114 dsm2_io_vcmg_0.di_vcm_ext_b a_8392_5586# 0.01669f
C2115 clk_noverlap_0.sg13cmos5l_inv_1_0.A a_10483_7459# 0.09601f
C2116 d_amp_s[3] d_dith[0] 0.02385f
C2117 a_2083_12612# a_2070_12038# 0.18486f
C2118 dsm2_io_vcmg_0.di_vcm_ext vdd 1.22926f
C2119 sg13cmos5l_nor2_2_2.A a_11865_14889# 0.15217f
C2120 di_qout_en di_osc_en 0.04772f
C2121 a_20758_19620# bias_gm_0.bias_trim_0.vz 0.01933f
C2122 a_567_5970# vdd 0.09469f
C2123 a_1286_14615# a_1288_13738# 0.02241f
C2124 a_8762_31505# vo_n 0.43723f
C2125 a_20138_14766# a_22138_15746# 0.06025f
C2126 sw_tgate_9.gb vi_esd 0.60268f
C2127 vdd vi_esd 3.51713f
C2128 dsm2_osc_0.d_btest_or a_21617_558# 0.01516f
C2129 inv_en_0.di_b d_qclk 0.18137f
C2130 a_8969_7224# a_8857_7200# 0.3854f
C2131 sg13cmos5l_inv_1_19.Y vo_n 0.07558f
C2132 sg13cmos5l_inv_1_13.Y xq_dith_v_bq 0.81348f
C2133 a_1367_14309# vdd 0.52277f
C2134 a_22184_2052# a_22738_2088# 0.03507f
C2135 sg13cmos5l_inv_1_6.A sg13cmos5l_inv_1_16.A 0.81271f
C2136 dsm2_osc_0.sg13cmos5l_dfrbp_1_0.Q_N vdd 0.29363f
C2137 dsm2_io_0.do_btest_en quantizer2_lfsr_0.di_dith_amp[0] 0.22551f
C2138 a_24540_20880# a_24626_20880# 0.01899f
C2139 a_2034_3336# a_2083_2244# 0.24435f
C2140 a_17416_5586# d_vcm_phi2 0.05619f
C2141 a_1286_1655# d_dith_en 0.04763f
C2142 a_10989_15998# d_qout_en 0.19177f
C2143 xq_vg_p_1_ vdd 0.10408f
C2144 a_8747_8328# d_amp_s[3] 0.0733f
C2145 a_2070_8622# a_2049_7557# 0.01058f
C2146 a_8747_9028# a_8747_8888# 0.48787f
C2147 dsm2_io_0.do_btest_en do_q_b 0.04106f
C2148 a_20758_21160# d_ena 0.01376f
C2149 bias_gm_0.bias_trim_0.iout dsm2_osc_0.ibias_pad 0.02026f
C2150 a_24626_22964# a_24626_22824# 0.53278f
C2151 a_20328_23820# a_27029_22964# 0.01269f
C2152 a_6884_8680# d_amp_s_b[3] 0.03798f
C2153 a_558_8294# d_dith_en 0.12614f
C2154 dsm2_io_vcmg_0.di_vcm_ext_b a_11656_5586# 0.01736f
C2155 a_7437_15998# d_dith_en 0.21532f
C2156 sg13cmos5l_nand2_1_5.A d_qout_en 0.31238f
C2157 a_522_12552# a_571_11460# 0.24435f
C2158 a_10120_5586# m2_10908_16863# 0.02098f
C2159 a_20758_19480# bias_gm_0.bias_trim_0.vz 0.02131f
C2160 a_7993_7200# vdd 0.20687f
C2161 sg13cmos5l_inv_1_3.A xq_vg_q_1_ 0.16198f
C2162 sg13cmos5l_inv_1_4.Y xq_vg_p_0_ 0.02196f
C2163 sg13cmos5l_inv_1_6.Y xq_vg_p_2_ 0.35697f
C2164 a_20138_14766# a_20070_14846# 0.06835f
C2165 sg13cmos5l_nor2_2_2.A d_dith_en 0.01312f
C2166 d_ena d_qi_b 0.63442f
C2167 dsm2_io_vcmg_0.di_vcm_ext d_amp_s_b[0] 0.04876f
C2168 dsm2_io_0.do_trim_b[1] a_23328_9146# 0.34124f
C2169 a_10592_15909# vdd 0.28639f
C2170 sg13cmos5l_inv_1_6.A sg13cmos5l_inv_1_17.Y 0.50616f
C2171 a_24626_20880# a_28126_20740# 0.01899f
C2172 a_2034_3336# vdd 0.07271f
C2173 dsm2_osc_0.d_btest_or dsm2_osc_0.sg13cmos5l_dfrbp_1_0.CLK 0.10834f
C2174 sg13cmos5l_inv_1_16.Y xq_vg_p_1_ 0.02224f
C2175 sg13cmos5l_inv_1_17.A xq_vg_p_0_ 0.04815f
C2176 d_dith_en d_dith[0] 0.04303f
C2177 sg13cmos5l_inv_1_3.A d_amp_s_b[3] 0.27808f
C2178 clk_noverlap_0.di_clk a_19949_784# 0.36666f
C2179 quantizer2_lfsr_0.sg13cmos5l_dfrbpq_1_15.D a_1284_8085# 0.10541f
C2180 quantizer2_lfsr_0.di_dith_amp[1] vdd 1.38722f
C2181 sg13cmos5l_inv_1_16.Y a_8747_9028# 0.0123f
C2182 a_22063_22824# a_22063_22684# 0.53278f
C2183 a_2034_6098# d_dith_en 0.13083f
C2184 dsm2_io_0.do_trim_b[0] dsm2_io_0.do_trim_b[1] 16.1614f
C2185 quantizer2_lfsr_0.sg13cmos5l_dfrbpq_1_1.D a_522_13269# 0.11175f
C2186 dsm2_io_0.do_btest_en m2_10908_16655# 6.18019f
C2187 a_1324_11172# a_1286_12023# 0.28324f
C2188 a_15496_5586# m2_10908_16863# 0.02098f
C2189 xq_vg_q_0_ a_6757_9808# 0.06268f
C2190 a_19964_18216# bias_gm_0.bias_trim_0.vz 1.46892f
C2191 quantizer2_lfsr_0.di_dith_amp[0] d_qout_en 0.05232f
C2192 a_21252_3394# vi_esd 0.0273f
C2193 di_vcm_ext di_clk_sel 0.03539f
C2194 sw_tgate_cmfb2_1.gb xsc_vc1r_n 0.09099f
C2195 a_2208_27629# vdd 0.56877f
C2196 sg13cmos5l_nor2_2_0.Y sg13cmos5l_and2_2_1.X 0.01738f
C2197 dsm2_osc_0.d_btest_or a_22347_812# 0.02428f
C2198 sg13cmos5l_nand2_1_2.Y sg13cmos5l_nand2_2_0.B 0.05234f
C2199 xsc_vvg_p xsc_xcmfb1_vsw_cm_n 0.1685f
C2200 xsc_vvg_n xsc_vc1r_n 0.14824f
C2201 sw_tgate_10.p d_qi_b 0.51402f
C2202 a_28126_20740# a_24626_20740# 0.01899f
C2203 a_20672_20740# a_20672_20460# 0.04477f
C2204 a_8105_7224# vdd 0.1584f
C2205 sg13cmos5l_inv_1_2.Y sg13cmos5l_nor2_2_0.Y 0.0247f
C2206 d_rst_b d_dith[0] 0.74409f
C2207 d_qout_en do_q_b 0.01558f
C2208 sg13cmos5l_inv_1_3.Y sg13cmos5l_inv_1_20.Y 0.5576f
C2209 quantizer2_lfsr_0.di_dith_amp[0] quantizer2_lfsr_0.sg13cmos5l_dfrbpq_1_1.D 0.56057f
C2210 a_2034_1082# d_dith_en 0.03039f
C2211 sw_tgate_11.gb d_qi_b 0.23629f
C2212 sg13cmos5l_or2_1_0.X sg13cmos5l_inv_1_5.Y 0.04225f
C2213 dsm2_io_0.sg13cmos5l_inv_1_5.A dsm2_io_0.do_btest_en 0.06703f
C2214 a_5176_30111# xsc_vfb 0.74351f
C2215 a_2079_9714# vdd 0.09548f
C2216 dsm2_osc_0.d_btest_or vo_n 0.05496f
C2217 dsm2_io_0.do_trim_b[1] dsm2_osc_0.d_btest_or 3.57913f
C2218 a_2208_20717# vdd 0.12629f
C2219 quantizer2_lfsr_0.sg13cmos5l_dfrbpq_1_13.Q vdd 0.48322f
C2220 a_17421_7164# vdd 0.30979f
C2221 a_2034_8690# d_dith_en 0.13047f
C2222 quantizer2_lfsr_0.di_dith_amp[1] d_amp_s_b[0] 0.03046f
C2223 a_2034_4053# a_2034_3506# 0.07015f
C2224 a_1324_11172# a_1600_11717# 0.24435f
C2225 sg13cmos5l_inv_1_1.A a_11201_9808# 0.09347f
C2226 a_522_12552# quantizer2_lfsr_0.sg13cmos5l_dfrbpq_1_7.D 0.01146f
C2227 dsm2_io_vcmg_0.di_vcm_ext_b a_2049_7557# 0.01253f
C2228 sg13cmos5l_nand2_1_5.A sg13cmos5l_and2_1_4.X 0.02585f
C2229 a_1324_13764# vdd 0.07232f
C2230 sg13cmos5l_nor2_2_0.B do_q_dec 0.85325f
C2231 a_20260_17236# dsm2_osc_0.d_btest_or 0.09021f
C2232 d_amp_s[3] do_q_dec 0.17669f
C2233 a_558_7470# d_dith_en 0.01118f
C2234 dsm2_io_0.do_trim_b[1] a_23328_5574# 0.34124f
C2235 sg13cmos5l_inv_1_4.A sg13cmos5l_nor2_1_0.Y 0.01997f
C2236 d_amp_s_b[3] d_dith[1] 0.01928f
C2237 a_522_12722# vdd 0.13554f
C2238 dsm2_io_vcmg_0.di_vcm_ext_b d_amp_s[0] 0.24989f
C2239 a_20758_20740# a_20758_20600# 0.84953f
C2240 sg13cmos5l_inv_1_3.A vo_n 0.36331f
C2241 sg13cmos5l_inv_1_13.Y d_qi_b 0.02261f
C2242 quantizer2_lfsr_0.sg13cmos5l_dfrbpq_1_2.D a_1284_10575# 0.01526f
C2243 sg13cmos5l_inv_1_6.A sg13cmos5l_inv_1_15.Y 0.03142f
C2244 dsm2_io_0.do_trim_b[2] di_trim[3] 0.0379f
C2245 a_1286_9431# vdd 0.24568f
C2246 a_19904_17646# a_20138_14766# 0.5665f
C2247 sg13cmos5l_inv_1_13.A sg13cmos5l_inv_1_0.Y 0.0259f
C2248 a_27029_22684# a_28334_22420# 0.06394f
C2249 a_522_5110# a_533_4736# 0.17382f
C2250 a_13192_5586# a_13960_5586# 0.05462f
C2251 a_22252_11246# a_24626_22280# 0.01718f
C2252 a_5176_31469# a_6638_31505# 0.25584f
C2253 a_5176_31117# a_7224_31505# 3.52074f
C2254 a_16276_7466# vdd 0.20312f
C2255 vo_p d_dith[2] 0.06839f
C2256 a_7531_15998# d_dith_en 0.0107f
C2257 quantizer2_lfsr_0.sg13cmos5l_dfrbpq_1_12.Q d_qclk 0.04207f
C2258 sg13cmos5l_nor2_2_0.B d_qclk 0.03949f
C2259 d_phi1 d_amp_s[1] 0.01377f
C2260 quantizer2_lfsr_0.sg13cmos5l_dfrbpq_1_11.D a_522_2184# 0.01003f
C2261 sg13cmos5l_or2_1_0.X xq_vg_q_2_ 0.04972f
C2262 sg13cmos5l_inv_1_3.Y xq_vg_q_1_ 0.4876f
C2263 xsc_xcmfb1_vsw_cm_p vo_p 2.18322f
C2264 d_amp_s[3] d_qclk 0.04526f
C2265 a_2079_7122# d_dith_en 0.1832f
C2266 sg13cmos5l_inv_1_6.A sg13cmos5l_inv_1_4.Y 0.56949f
C2267 quantizer2_lfsr_0.sg13cmos5l_dfrbpq_1_2.D quantizer2_lfsr_0.sg13cmos5l_dfrbpq_1_11.Q 0.07925f
C2268 a_522_12552# vdd 0.0721f
C2269 d_amp_s[3] d_amp_s[2] 4.72469f
C2270 sg13cmos5l_nand2_2_0.B vdd 0.87375f
C2271 a_24258_20600# a_24258_20320# 0.04477f
C2272 quantizer2_lfsr_0.sg13cmos5l_dfrbpq_1_11.Q a_2034_698# 0.01801f
C2273 a_28334_20740# a_28334_20600# 0.1335f
C2274 sg13cmos5l_nor2_1_0.Y sg13cmos5l_inv_1_2.Y 0.10152f
C2275 m2_6409_30900# vdd 0.46226f
C2276 dsm2_io_0.dsm2_io_rx_9.di_b vdd 1.06411f
C2277 xsc_vc1l_n d_qi_b 0.04836f
C2278 sg13cmos5l_inv_1_6.A sg13cmos5l_inv_1_17.A 0.05954f
C2279 sg13cmos5l_inv_1_3.Y d_amp_s_b[3] 0.93559f
C2280 a_522_2518# a_522_2354# 0.23043f
C2281 a_1284_2901# a_1284_2799# 0.09257f
C2282 d_dith_en do_q_dec 0.07147f
C2283 d_qout_en d_amp_s_b[1] 0.18106f
C2284 a_22252_11246# a_24626_22140# 0.0168f
C2285 dsm2_osc_0.d_btest_or do_clk_osc 0.03363f
C2286 a_1322_6770# a_1600_6533# 0.07823f
C2287 a_8762_31505# a_9348_31505# 2.10158f
C2288 a_5176_31469# sw_tgate_cmfb2_1.p 0.02199f
C2289 a_22138_16046# vdd 0.01731f
C2290 a_2049_10149# d_qclk 0.2263f
C2291 clk_noverlap_0.sg13cmos5l_inv_1_3.Y clk_noverlap_0.sg13cmos5l_inv_1_1.Y 0.08516f
C2292 sg13cmos5l_inv_1_13.A xq_vg_p_1_ 0.05191f
C2293 a_522_9960# quantizer2_lfsr_0.sg13cmos5l_dfrbpq_1_8.D 0.01115f
C2294 a_1286_9431# a_1367_9125# 0.02431f
C2295 dsm2_io_vcmg_0.di_vcm_ext a_2034_11112# 0.01362f
C2296 a_2208_21485# vdd 0.53377f
C2297 sg13cmos5l_or2_1_0.X sg13cmos5l_inv_1_1.A 0.01466f
C2298 a_1284_5391# vdd 0.17136f
C2299 a_1286_6839# d_dith_en 0.04695f
C2300 quantizer2_lfsr_0.sg13cmos5l_dfrbpq_1_2.D a_1284_13269# 0.01329f
C2301 a_1322_11954# vdd 0.20468f
C2302 di_dith_amp[0] di_dith_amp[1] 0.11257f
C2303 sg13cmos5l_inv_1_9.Y d_amp_s_b[2] 0.01356f
C2304 bias_gm_0.bias_trim_0.vz a_22252_4074# 4.41389f
C2305 sg13cmos5l_inv_1_2.Y sg13cmos5l_inv_2_0.Y 0.27802f
C2306 d_rst_b do_q_dec 0.01356f
C2307 dsm2_osc_0.sg13cmos5l_dfrbp_1_0.RESET_B a_22930_1332# 0.01774f
C2308 a_2049_2373# a_2083_2244# 0.01562f
C2309 a_522_2518# a_522_2184# 0.01412f
C2310 a_22252_11246# vdd 4.3822f
C2311 d_dith_en d_qclk 2.17234f
C2312 a_2208_31469# vdd 0.5623f
C2313 a_12820_7466# d_phi2 0.04776f
C2314 a_22252_5274# bias_gm_0.bias_trim_0.iout 0.14131f
C2315 sg13cmos5l_or2_1_0.X sg13cmos5l_and2_1_2.X 0.0374f
C2316 a_1286_6839# a_1288_5962# 0.02241f
C2317 clk_noverlap_0.sg13cmos5l_dlygate4sd3_1_0.A d_amp_s_b[3] 0.16037f
C2318 d_dith_en d_amp_s[2] 0.09871f
C2319 a_28746_15446# vdd 0.18473f
C2320 xq_vg_q_0_ d_qclk 1.3458f
C2321 a_8747_8188# d_amp_s[1] 0.04117f
C2322 a_22252_8246# a_22252_7946# 1.04634f
C2323 a_10888_5586# vdd 0.50983f
C2324 quantizer2_lfsr_0.sg13cmos5l_dfrbpq_1_2.D a_1407_12722# 0.01101f
C2325 quantizer2_lfsr_0.sg13cmos5l_dfrbpq_1_2.D d_amp_s[1] 0.01593f
C2326 xsc_vc1r_n xsc_xcmfb1_vsw_vbias 0.03211f
C2327 a_567_3378# d_dith_en 0.2122f
C2328 sg13cmos5l_or2_1_0.X sg13cmos5l_and2_1_5.B 0.06252f
C2329 a_20000_20460# a_20000_20320# 0.1335f
C2330 di_vcm_ext di_osc_en 0.0533f
C2331 dsm2_io_0.do_trim_b[0] a_22252_4374# 0.9272f
C2332 sg13cmos5l_inv_1_3.Y vo_n 0.26891f
C2333 a_9833_7224# a_9721_7200# 0.3854f
C2334 sg13cmos5l_inv_1_6.Y sg13cmos5l_inv_1_16.A 1.99359f
C2335 a_2049_2373# vdd 0.23817f
C2336 a_12445_30191# vdd 2.57343f
C2337 a_24626_22280# a_24626_22140# 0.84953f
C2338 a_20672_22140# a_20672_21860# 0.04477f
C2339 a_558_4878# a_522_4776# 0.25046f
C2340 a_26670_15146# vdd 0.0168f
C2341 dsm2_io_0.do_trim_b[3] a_2208_21485# 0.07975f
C2342 sg13cmos5l_inv_1_4.A sg13cmos5l_inv_1_9.Y 0.08871f
C2343 a_16264_5586# vdd 0.25153f
C2344 a_8747_8468# d_amp_s_b[1] 0.03184f
C2345 bias_gm_0.bias_trim_0.vz a_19904_17646# 0.07067f
C2346 quantizer2_lfsr_0.sg13cmos5l_nor2_1_0.A d_amp_s[3] 0.08321f
C2347 a_1288_11146# vdd 0.09469f
C2348 sg13cmos5l_nand2_1_5.A d_qi_b 0.23993f
C2349 a_24626_20460# a_24626_20320# 0.84953f
C2350 clk_noverlap_0.sg13cmos5l_inv_1_6.A vdd 0.28753f
C2351 dsm2_osc_0.sg13cmos5l_dfrbp_1_0.RESET_B m2_10908_16863# 0.06923f
C2352 a_2034_13704# d_qclk 0.10855f
C2353 sg13cmos5l_nand2_1_2.Y vdd 0.76368f
C2354 a_22252_11246# a_21252_3394# 0.28665f
C2355 a_558_2286# a_537_1221# 0.01058f
C2356 a_1407_2354# vdd 0.13586f
C2357 sg13cmos5l_inv_1_6.Y sg13cmos5l_inv_1_17.Y 0.04191f
C2358 sw_tgate_6.p d_qi_b 0.35967f
C2359 a_24404_4674# vdd 0.98769f
C2360 a_2045_11072# a_2070_9446# 0.07916f
C2361 a_2034_11112# a_2079_9714# 0.24169f
C2362 a_533_15104# a_571_14052# 0.07823f
C2363 a_522_15144# a_558_13478# 0.26205f
C2364 a_28126_22140# a_28126_21860# 0.04477f
C2365 a_1407_4946# a_1322_4178# 0.03546f
C2366 sg13cmos5l_or2_1_0.X d_amp_s[1] 0.03531f
C2367 a_2083_10020# d_qclk 0.0128f
C2368 a_22252_8546# vdd 2.99884f
C2369 xq_dith_v_bq d_amp_s_b[1] 0.17522f
C2370 dsm2_io_0.do_trim_b[2] di_trim[2] 0.18626f
C2371 a_22252_4374# a_23328_5574# 0.20579f
C2372 dsm2_io_vcmg_0.di_vcm_ext_b a_2070_6854# 0.02379f
C2373 quantizer2_lfsr_0.sg13cmos5l_dfrbpq_1_11.D quantizer2_lfsr_0.sg13cmos5l_dfrbpq_1_2.D 0.95474f
C2374 a_2049_7557# a_1284_7983# 0.02017f
C2375 a_522_8085# a_522_7538# 0.07015f
C2376 sg13cmos5l_inv_1_16.A vo_p 0.01707f
C2377 sg13cmos5l_and2_1_5.X sg13cmos5l_or2_1_0.X 0.07345f
C2378 a_1322_14546# d_qclk 0.04249f
C2379 a_12237_7164# clk_noverlap_0.sg13cmos5l_dlygate4sd3_1_8.X 0.30507f
C2380 quantizer2_lfsr_0.sg13cmos5l_dfrbpq_1_7.D vdd 0.32192f
C2381 a_10787_14878# d_qi 0.02678f
C2382 sg13cmos5l_nand2_1_2.Y sg13cmos5l_inv_1_16.Y 0.09055f
C2383 quantizer2_lfsr_0.sg13cmos5l_dfrbpq_1_0.Q d_dith_en 0.33265f
C2384 a_20672_20180# a_20758_20180# 0.01899f
C2385 a_2208_25325# vdd 0.58444f
C2386 clk_noverlap_0.sg13cmos5l_inv_1_10.A d_phi1 0.1958f
C2387 sg13cmos5l_inv_1_20.Y do_q 0.41069f
C2388 sg13cmos5l_inv_1_13.A sg13cmos5l_nand2_2_0.B 0.0169f
C2389 sg13cmos5l_inv_1_10.Y sg13cmos5l_nand2_1_2.Y 0.18017f
C2390 clk_noverlap_0.sg13cmos5l_dlygate4sd3_1_4.X vdd 0.22894f
C2391 quantizer2_lfsr_0.sg13cmos5l_nor2_1_0.A d_dith_en 0.03144f
C2392 d_qi_b do_q_b 0.27496f
C2393 a_20672_21860# a_20758_22000# 0.01899f
C2394 quantizer2_lfsr_0.sg13cmos5l_dfrbpq_1_0.D d_dith_en 6.1053f
C2395 sg13cmos5l_inv_1_9.Y a_15130_14856# 0.02704f
C2396 sg13cmos5l_inv_1_17.Y vo_p 0.01726f
C2397 a_2070_4262# vdd 0.52277f
C2398 sg13cmos5l_inv_1_19.Y a_11201_9808# 0.01249f
C2399 a_2034_3506# a_2045_3296# 0.03546f
C2400 a_2034_3670# quantizer2_lfsr_0.sg13cmos5l_dfrbpq_1_11.Q 0.01117f
C2401 a_19984_17824# dsm2_osc_0.d_btest_or 0.82997f
C2402 sg13cmos5l_nand2_1_5.A sg13cmos5l_inv_1_7.Y 0.15515f
C2403 quantizer2_lfsr_0.sg13cmos5l_dfrbpq_1_13.D a_1284_13269# 0.11247f
C2404 dsm2_io_vcmg_0.di_vcm_ext_b a_2045_11072# 0.0172f
C2405 a_20758_20180# a_24258_20040# 0.01899f
C2406 a_13985_15078# a_14266_14856# 0.18796f
C2407 clk_noverlap_0.sg13cmos5l_nor3_1_0.C d_ena 0.11847f
C2408 dsm2_osc_0.sg13cmos5l_mux2_1_0.A1 a_21498_769# 0.13034f
C2409 a_21252_3394# a_24404_4674# 0.06622f
C2410 sw_tgate_9.gb vdd 3.1158f
C2411 dsm2_io_0.do_trim_b[3] a_24404_4674# 0.34711f
C2412 sg13cmos5l_inv_1_18.Y xq_dith_v_bq 0.82958f
C2413 a_537_1221# a_1286_1655# 0.01571f
C2414 quantizer2_lfsr_0.di_dith_amp[0] a_522_15314# 0.04922f
C2415 sg13cmos5l_inv_1_8.Y sg13cmos5l_inv_1_4.A 0.06938f
C2416 sw_tgate_cmfb2_1.p vo_p 1.96573f
C2417 dsm2_osc_0.sg13cmos5l_inv_1_2.A dsm2_osc_0.sg13cmos5l_inv_1_2.Y 0.13036f
C2418 a_9833_7224# a_10291_7286# 0.01604f
C2419 sg13cmos5l_inv_1_4.A xq_vg_p_0_ 0.58726f
C2420 a_21252_3394# a_22252_8546# 0.05206f
C2421 a_1681_4561# a_1324_3396# 0.25046f
C2422 d_qout_en d_dith[0] 2.192f
C2423 clk_noverlap_0.sg13cmos5l_inv_1_0.Y a_10784_6484# 0.01401f
C2424 m2_10908_16655# d_qi_b 0.0576f
C2425 sg13cmos5l_inv_1_16.Y a_8747_8888# 0.01232f
C2426 quantizer2_lfsr_0.sg13cmos5l_dfrbpq_1_11.D di_clk_sel 0.02938f
C2427 dsm2_osc_0.d_btest_or do_osc_oe 0.0861f
C2428 do_q di_clk 0.12179f
C2429 sg13cmos5l_inv_1_13.Y xq_vg_q_2_ 0.11962f
C2430 sg13cmos5l_inv_1_9.Y xq_vg_p_0_ 0.06529f
C2431 a_24258_20040# a_20758_20040# 0.01899f
C2432 dsm2_osc_0.sg13cmos5l_inv_1_2.A vi_esd 0.01282f
C2433 sg13cmos5l_inv_1_16.Y vdd 1.0505f
C2434 clk_noverlap_0.sg13cmos5l_dlygate4sd3_1_0.A a_5131_7241# 0.03351f
C2435 a_2208_23021# d_ena 0.01157f
C2436 dsm2_osc_0.dsm2_io_rx_0.di_b m2_10908_16863# 0.06758f
C2437 sg13cmos5l_inv_1_6.Y sg13cmos5l_inv_1_4.Y 5.94501f
C2438 dsm2_io_0.do_btest_en clk_noverlap_0.di_clk 0.13694f
C2439 a_1322_1586# a_1367_1349# 0.07916f
C2440 vo_p d_amp_s[0] 0.02822f
C2441 dsm2_osc_0.d_btest_or dsm2_osc_0.ibias_in 1.60182f
C2442 a_9883_9488# a_8747_9308# 0.14662f
C2443 dsm2_io_vcmg_0.di_vcm_ext d_amp_s[3] 0.0901f
C2444 sg13cmos5l_inv_1_10.Y vdd 0.29497f
C2445 a_24258_21720# a_24540_21720# 0.04564f
C2446 clk_noverlap_0.sg13cmos5l_inv_1_8.A vdd 0.28904f
C2447 dsm2_osc_0.sg13cmos5l_mux2_1_0.A1 a_21775_1704# 0.01079f
C2448 sg13cmos5l_and2_2_1.X xq_vg_p_0_ 0.0203f
C2449 vdd d_amp_s_b[0] 2.64478f
C2450 sg13cmos5l_inv_1_6.Y sg13cmos5l_inv_1_17.A 0.27269f
C2451 sw_tgate_12.m d_qi_b 0.35997f
C2452 clk_noverlap_0.sg13cmos5l_inv_1_10.A a_11672_6736# 0.02331f
C2453 a_4251_6570# vdd 0.15875f
C2454 a_1367_9125# vdd 0.57954f
C2455 a_10757_8608# a_8747_8608# 0.01899f
C2456 a_526_16657# quantizer2_lfsr_0.sg13cmos5l_dfrbpq_1_1.D 0.11232f
C2457 a_1284_16630# a_1690_16373# 0.19075f
C2458 sg13cmos5l_inv_1_16.Y a_11201_8748# 0.02056f
C2459 dsm2_io_vcmg_0.di_vcm_ext_b xvcm_vcf_b 0.04207f
C2460 dsm2_osc_0.d_btest_or vcm_esd 0.13179f
C2461 quantizer2_lfsr_0.sg13cmos5l_dfrbpq_1_2.D a_1284_8085# 0.01207f
C2462 sg13cmos5l_inv_1_13.Y sg13cmos5l_inv_1_1.A 0.50929f
C2463 sg13cmos5l_inv_1_20.Y xq_vg_p_2_ 0.03482f
C2464 a_12237_7164# d_phi2 0.05114f
C2465 a_558_13478# a_567_13746# 0.45119f
C2466 sg13cmos5l_inv_1_19.Y sg13cmos5l_or2_1_0.X 0.19854f
C2467 sg13cmos5l_inv_1_7.Y sg13cmos5l_inv_2_5.A 0.01186f
C2468 a_20770_598# a_21498_769# 0.01597f
C2469 quantizer2_lfsr_0.sg13cmos5l_dfrbpq_1_0.D a_1322_14546# 0.0273f
C2470 dsm2_io_0.do_trim_b[3] vdd 12.76f
C2471 a_21252_3394# vdd 11.9027f
C2472 a_1286_12023# d_qclk 0.23442f
C2473 a_15584_15091# d_dith_en 0.19272f
C2474 a_11201_8748# d_amp_s_b[0] 0.01028f
C2475 sg13cmos5l_nor2_2_0.Y d_qi 0.22423f
C2476 sg13cmos5l_inv_1_16.Y d_amp_s_b[0] 0.99524f
C2477 sg13cmos5l_nand2_1_5.A sg13cmos5l_inv_2_4.Y 0.17214f
C2478 sg13cmos5l_inv_1_0.A a_13870_15077# 0.02166f
C2479 sg13cmos5l_or2_1_0.X sg13cmos5l_and2_1_5.A 0.09093f
C2480 d_ena d_amp_s[1] 0.26845f
C2481 quantizer2_lfsr_0.sg13cmos5l_dfrbpq_1_8.D a_522_8085# 0.10516f
C2482 xq_dith_v_bp vo_n 3.66612f
C2483 clk_noverlap_0.sg13cmos5l_inv_1_11.Y d_phi1 0.13462f
C2484 a_24540_21720# a_24626_21720# 0.01899f
C2485 sg13cmos5l_nand2_2_0.B a_15491_15614# 0.14999f
C2486 dsm2_io_vcmg_0.di_vcm_ext_b d_amp_s_b[2] 0.02823f
C2487 quantizer2_lfsr_0.sg13cmos5l_dfrbpq_1_1.D a_522_15861# 0.02354f
C2488 sg13cmos5l_inv_1_13.A sg13cmos5l_nand2_1_2.Y 3.17752f
C2489 a_2034_8854# vdd 0.19618f
C2490 sg13cmos5l_inv_1_4.Y vo_p 0.01512f
C2491 sg13cmos5l_and2_1_5.X d_ena 0.11032f
C2492 a_11201_8608# a_13211_8468# 0.01899f
C2493 a_8747_8608# a_8747_8468# 0.48787f
C2494 quantizer2_lfsr_0.sg13cmos5l_dfrbpq_1_2.D a_1322_4178# 0.03009f
C2495 dsm2_io_vcmg_0.di_vcm_ext d_dith_en 0.33413f
C2496 a_2034_6645# a_2034_6098# 0.07015f
C2497 a_1407_7538# vdd 0.13586f
C2498 a_567_5970# d_dith_en 0.21335f
C2499 dsm2_osc_0.d_btest_or a_22738_2578# 0.01742f
C2500 a_2034_11446# a_2070_11214# 0.16704f
C2501 sg13cmos5l_inv_1_17.A vo_p 0.05909f
C2502 quantizer2_lfsr_0.di_dith_amp[1] d_amp_s[3] 0.02779f
C2503 sg13cmos5l_inv_1_13.Y sg13cmos5l_and2_1_5.B 0.01495f
C2504 sg13cmos5l_nand2_1_5.A sg13cmos5l_inv_1_5.Y 0.22557f
C2505 a_21276_2052# vdd 0.24825f
C2506 a_1367_14309# d_dith_en 0.10666f
C2507 a_11115_8328# d_amp_s_b[0] 0.02294f
C2508 d_phi1 d_dith[1] 0.55782f
C2509 a_1367_1349# a_1288_778# 0.45119f
C2510 sw_tgate_cmfb2_1.gb vo_p 0.02366f
C2511 a_24626_21720# a_28126_21580# 0.01899f
C2512 a_1284_2799# d_qclk 0.02054f
C2514 a_17595_6570# vdd 0.16068f
C2515 sg13cmos5l_inv_1_6.A sg13cmos5l_inv_1_4.A 2.32242f
C2516 sg13cmos5l_inv_1_3.A d_phi2 0.02118f
C2517 quantizer2_lfsr_0.sg13cmos5l_nor2_1_1.B a_1407_15314# 0.0258f
C2518 a_1284_10677# a_1407_10130# 0.07015f
C2519 d_qout_en do_q_dec 4.66979f
C2520 a_8747_8468# a_8747_8328# 0.48787f
C2521 di_dith_amp[0] di_clk_sel 0.02982f
C2522 a_10120_5586# xvcm_vcf_b 0.01281f
C2523 a_9352_5586# xvcm_vcf_t 0.01295f
C2524 a_19999_22824# d_ena 0.01082f
C2525 dsm2_io_vcmg_0.di_vcm_ext d_rst_b 0.15093f
C2526 quantizer2_lfsr_0.sg13cmos5l_dfrbpq_1_2.Q a_2034_698# 0.20515f
C2527 dsm2_osc_0.di_clk_ext do_q 0.3443f
C2528 a_1284_8085# di_clk_sel 0.01067f
C2529 dsm2_osc_0.d_btest_or dsm2_osc_0.sg13cmos5l_inv_1_3.A 0.03372f
C2530 a_24540_19760# a_24626_19900# 0.01899f
C2531 a_558_8294# quantizer2_lfsr_0.sg13cmos5l_dfrbpq_1_8.D 0.19133f
C2532 a_10757_9808# a_11201_9808# 0.0182f
C2533 dsm2_io_0.do_trim_b[3] a_21252_3394# 0.14038f
C2534 sg13cmos5l_inv_1_6.A sg13cmos5l_inv_1_9.Y 1.66982f
C2535 clk_noverlap_0.sg13cmos5l_dlygate4sd3_1_0.A dsm2_io_vcmg_0.di_phi1_b 0.01704f
C2536 sg13cmos5l_and2_1_5.X a_8208_15626# 0.15361f
C2537 a_2034_3336# d_dith_en 0.28562f
C2538 a_2208_26093# a_2208_25325# 0.05462f
C2539 a_20672_21580# a_20672_21300# 0.04477f
C2540 a_28126_21580# a_24626_21580# 0.01899f
C2541 a_533_2144# d_qclk 0.05118f
C2542 sg13cmos5l_inv_1_3.Y a_8747_8748# 0.01228f
C2543 a_558_10062# d_dith_en 0.01118f
C2544 sg13cmos5l_inv_1_6.Y sg13cmos5l_nor2_2_0.Y 0.0129f
C2545 quantizer2_lfsr_0.di_dith_amp[1] d_dith_en 0.15629f
C2546 a_8587_7241# d_qclk 0.01067f
C2547 sg13cmos5l_inv_1_14.A sg13cmos5l_inv_1_1.A 0.02059f
C2548 sg13cmos5l_inv_1_13.A vdd 0.57767f
C2549 a_23328_9146# ibias_200n 0.28931f
C2550 a_2049_10149# a_2079_9714# 0.02241f
C2551 a_15496_5586# xvcm_vcf_b 0.02052f
C2552 dsm2_io_vcmg_0.di_vcm_ext a_2034_13704# 0.01362f
C2553 sg13cmos5l_nand2_1_5.A xq_vg_q_2_ 0.02675f
C2554 a_2208_29165# d_ena 0.0435f
C2555 d_qout_en d_amp_s[2] 0.08418f
C2556 a_22644_2344# vcm_esd 0.01106f
C2557 inv_en_0.di d_dith[0] 0.10662f
C2558 dsm2_io_0.do_trim_b[1] di_trim[2] 0.0379f
C2559 a_15297_7467# d_phi2 0.04668f
C2560 quantizer2_lfsr_0.sg13cmos5l_dfrbpq_1_11.D quantizer2_lfsr_0.sg13cmos5l_dfrbpq_1_1.Q 0.28524f
C2561 quantizer2_lfsr_0.sg13cmos5l_dfrbpq_1_1.D d_qclk 0.01941f
C2562 dsm2_osc_0.d_btest_or di_clk_sel 1.17931f
C2563 quantizer2_lfsr_0.sg13cmos5l_dfrbpq_1_11.D di_osc_en 0.03154f
C2564 a_21554_2798# a_21830_2578# 0.05875f
C2565 do_q do_clk_osc 0.05042f
C2566 a_2070_3438# a_2034_3336# 0.25046f
C2567 sg13cmos5l_inv_1_3.A sg13cmos5l_or2_1_0.X 5.39218f
C2568 dsm2_io_0.do_trim_b[0] ibias_200n 0.2444f
C2569 a_2034_11112# vdd 0.07281f
C2570 a_11115_8888# a_11201_9028# 0.01899f
C2571 sg13cmos5l_inv_2_0.Y d_qi 0.0303f
C2572 a_20758_21580# a_20758_21440# 0.84953f
C2573 dsm2_osc_0.di_clk_ext a_20447_636# 0.0537f
C2574 sg13cmos5l_inv_1_13.A sg13cmos5l_inv_1_16.Y 0.05211f
C2575 a_537_1221# d_qclk 0.24203f
C2576 quantizer2_lfsr_0.di_dith_amp[1] d_rst_b 0.15473f
C2577 a_2208_26093# vdd 0.59064f
C2578 a_2079_9714# d_dith_en 0.18426f
C2579 d_amp_s_b[3] d_dith[2] 0.02611f
C2580 a_9721_7200# clk_noverlap_0.sg13cmos5l_nor3_1_0.C 0.03461f
C2581 a_2208_28397# d_ena 0.02271f
C2582 sg13cmos5l_nand2_2_0.B sg13cmos5l_nor2_2_0.B 0.39972f
C2583 a_522_10130# a_533_9920# 0.03546f
C2584 quantizer2_lfsr_0.sg13cmos5l_dfrbpq_1_13.Q d_dith_en 0.03446f
C2585 a_5401_7200# vdd 0.20197f
C2586 a_1322_14546# a_1367_14309# 0.07916f
C2587 a_8762_31505# d_ena 0.04478f
C2588 clk_noverlap_0.sg13cmos5l_dlygate4sd3_1_0.A d_phi1 0.05112f
C2589 sg13cmos5l_inv_1_13.A sg13cmos5l_inv_1_10.Y 0.07492f
C2590 a_1324_13764# d_dith_en 0.27329f
C2591 a_10989_15998# sg13cmos5l_and2_1_2.X 0.1021f
C2592 clk_noverlap_0.sg13cmos5l_inv_1_0.Y clk_noverlap_0.di_clk 0.01506f
C2593 a_20758_19760# a_20758_19620# 0.84953f
C2594 a_2034_13874# a_2045_13664# 0.03546f
C2595 xq_vg_p_2_ vo_n 0.39685f
C2596 a_1324_3396# d_qclk 0.09459f
C2597 sg13cmos5l_nand2_2_0.B a_14849_15078# 0.01671f
C2598 a_5176_30111# xsc_vvg_p 0.59439f
C2599 a_22738_2578# a_22644_2344# 0.09305f
C2600 sg13cmos5l_nand2_2_0.B a_11865_14889# 0.07693f
C2601 dsm2_osc_0.sg13cmos5l_dfrbp_1_0.RESET_B a_21736_2344# 0.191f
C2602 a_21554_2798# a_22184_2052# 0.21861f
C2603 a_522_12722# d_dith_en 0.1175f
C2604 dsm2_osc_0.sg13cmos5l_dfrbp_1_0.Q_N a_23150_752# 0.03244f
C2605 dsm2_osc_0.d_btest_or ibias_200n 4.48986f
C2606 sg13cmos5l_nand2_1_5.A sg13cmos5l_and2_1_2.X 0.18963f
C2607 a_28334_21580# a_28334_21440# 0.1335f
C2608 a_24258_21440# a_24258_21160# 0.04477f
C2609 a_22252_11246# a_24626_20320# 0.01575f
C2610 a_8880_5832# a_8768_5586# 0.01147f
C2611 sg13cmos5l_nor2_2_2.A d_qi_b 0.13013f
C2612 sg13cmos5l_inv_1_3.Y a_8747_8188# 0.01315f
C2613 a_1286_9431# d_dith_en 0.04703f
C2614 sg13cmos5l_nor2_1_0.Y sg13cmos5l_inv_1_6.Y 0.03315f
C2615 dsm2_io_0.do_trim_b[2] bias_gm_0.bias_trim_0.iout 0.08618f
C2616 xsc_xcmfb1_vsw_cm_n vdd 3.19697f
C2617 sg13cmos5l_inv_1_3.Y d_phi2 0.04526f
C2618 clk_noverlap_0.sg13cmos5l_inv_1_10.A d_ena 0.01274f
C2619 quantizer2_lfsr_0.sg13cmos5l_dfrbpq_1_5.Q a_2034_14038# 0.01701f
C2620 a_1284_10575# a_1322_9362# 0.17382f
C2621 a_522_9960# a_533_9920# 0.20759f
C2622 xq_vg_q_1_ a_6757_9948# 0.01351f
C2623 sg13cmos5l_inv_1_6.A sg13cmos5l_inv_1_8.Y 0.24334f
C2624 quantizer2_lfsr_0.sg13cmos5l_dfrbpq_1_6.Q a_2034_14421# 0.09143f
C2625 sw_tgate_8.m d_qi_b 0.51402f
C2626 sg13cmos5l_inv_1_6.A xq_vg_p_0_ 0.03238f
C2627 dsm2_io_0.do_trim_b[2] a_22252_7946# 0.8942f
C2628 d_qi_b d_dith[0] 0.0373f
C2629 xq_dith_v_bq do_q_dec 0.06821f
C2630 sg13cmos5l_or2_1_0.X d_dith[1] 0.01995f
C2631 sg13cmos5l_nand2_1_5.A sg13cmos5l_and2_1_5.B 0.59621f
C2632 inv_en_0.di_b vdd 0.92921f
C2633 a_28334_19760# a_28334_19620# 0.1335f
C2634 a_1288_3370# vdd 0.09469f
C2635 sg13cmos5l_inv_1_16.A sg13cmos5l_inv_1_2.A 0.38581f
C2636 a_24626_20880# dsm2_osc_0.d_btest_or 0.01657f
C2637 a_522_12552# d_dith_en 0.33005f
C2638 sg13cmos5l_inv_1_1.A do_q_b 0.02837f
C2639 a_522_7368# quantizer2_lfsr_0.sg13cmos5l_dfrbpq_1_9.D 0.0109f
C2640 sg13cmos5l_nand2_2_0.B d_dith_en 1.35862f
C2641 a_22499_864# a_23289_752# 0.02241f
C2642 d_dith[1] di_clk_sel 0.02553f
C2643 clk_noverlap_0.sg13cmos5l_dlygate4sd3_1_0.A a_6377_7224# 0.02784f
C2644 a_22252_11246# a_24626_20180# 0.01582f
C2645 sg13cmos5l_inv_1_19.Y a_8208_15626# 0.1073f
C2646 dsm2_io_0.do_trim_b[0] d_ena 6.19286f
C2647 xsc_xcmfb1_vsw_vbias vo_p 6.13678f
C2648 sg13cmos5l_inv_1_20.Y sg13cmos5l_inv_1_16.A 0.05366f
C2649 sg13cmos5l_inv_1_1.A a_11201_9948# 0.05577f
C2650 a_522_9960# a_537_8997# 0.28324f
C2651 a_558_7470# a_537_6405# 0.01058f
C2652 quantizer2_lfsr_0.sg13cmos5l_dfrbpq_1_0.D a_533_2144# 0.0139f
C2653 a_1286_4247# a_1367_3941# 0.02431f
C2654 a_15491_15614# vdd 0.37512f
C2655 inv_en_0.di_b sg13cmos5l_inv_1_16.Y 0.17215f
C2656 sg13cmos5l_inv_1_6.Y sg13cmos5l_inv_2_0.Y 0.03622f
C2657 clk_noverlap_0.sg13cmos5l_dlygate4sd3_1_0.A d_phi2 0.10372f
C2658 quantizer2_lfsr_0.sg13cmos5l_dfrbpq_1_11.D a_558_13478# 0.02028f
C2659 clk_noverlap_0.sg13cmos5l_inv_1_1.A d_ena 0.06494f
C2660 di_btest_en di_clk_sel 0.02982f
C2661 di_dith_amp[0] di_osc_en 0.04771f
C2662 xq_dith_v_bq d_amp_s[2] 0.12406f
C2663 a_1284_5391# d_dith_en 0.11119f
C2664 sg13cmos5l_inv_1_17.Y sg13cmos5l_inv_1_2.A 0.03649f
C2665 sg13cmos5l_nand2_2_0.B d_rst_b 0.1471f
C2666 inv_en_0.di do_q_dec 0.23736f
C2667 a_24626_20740# dsm2_osc_0.d_btest_or 0.01657f
C2668 sg13cmos5l_inv_1_19.Y sg13cmos5l_inv_1_13.Y 0.01796f
C2669 a_1322_11954# d_dith_en 0.29055f
C2670 quantizer2_lfsr_0.sg13cmos5l_dfrbpq_1_2.D quantizer2_lfsr_0.sg13cmos5l_dfrbpq_1_14.D 0.08133f
C2671 a_23195_985# a_23289_752# 0.45119f
C2672 quantizer2_lfsr_0.sg13cmos5l_dfrbpq_1_1.D quantizer2_lfsr_0.sg13cmos5l_dfrbpq_1_0.D 0.24906f
C2673 sg13cmos5l_inv_1_3.Y sg13cmos5l_or2_1_0.X 0.22058f
C2674 clk_noverlap_0.sg13cmos5l_dlygate4sd3_1_7.X d_phi2 0.06915f
C2675 quantizer2_lfsr_0.sg13cmos5l_nor2_1_1.B a_1284_16630# 0.02188f
C2676 dsm2_io_0.do_trim_b[0] di_osc_en 0.01596f
C2677 sg13cmos5l_and2_1_5.B do_q_b 0.0211f
C2678 a_20000_21300# a_20000_21160# 0.1335f
C2679 dsm2_osc_0.sg13cmos5l_dfrbp_1_0.CLK m2_10908_16863# 0.0289f
C2680 a_2038_15217# quantizer2_lfsr_0.sg13cmos5l_dfrbpq_1_5.Q 0.09456f
C2681 dsm2_osc_0.d_btest_or d_ena 0.77371f
C2682 sg13cmos5l_and2_2_1.X d_qi 0.21124f
C2683 a_1681_14929# a_1286_14615# 0.01058f
C2684 a_1322_14546# a_1324_13764# 0.20759f
C2685 a_2038_15217# a_2074_14933# 0.19075f
C2686 sg13cmos5l_inv_1_13.Y sg13cmos5l_and2_1_5.A 0.08542f
C2687 a_11115_8608# d_amp_s_b[2] 0.02359f
C2688 a_1681_9745# a_1324_8580# 0.25046f
C2689 quantizer2_lfsr_0.sg13cmos5l_dfrbpq_1_0.D a_537_1221# 0.01147f
C2690 quantizer2_lfsr_0.sg13cmos5l_dfrbpq_1_2.Q a_2034_3670# 0.01753f
C2691 a_19105_884# a_19000_826# 0.02842f
C2692 clk_noverlap_0.sg13cmos5l_nor3_1_0.C a_10291_7286# 0.01341f
C2693 sg13cmos5l_nand2_1_5.A sg13cmos5l_and2_1_5.X 1.13783f
C2694 sg13cmos5l_inv_1_7.Y d_dith[0] 0.02591f
C2695 sg13cmos5l_nand2_1_2.Y sg13cmos5l_nor2_2_0.B 0.06336f
C2696 sg13cmos5l_and2_1_5.A a_13985_15078# 0.0368f
C2697 a_522_12886# a_1284_13167# 0.01202f
C2698 sg13cmos5l_inv_1_3.A d_ena 0.03505f
C2699 a_571_11460# d_dith_en 0.01369f
C2700 a_533_7328# d_qclk 0.0385f
C2701 a_21736_2344# dsm2_osc_0.dsm2_io_rx_0.di_b 0.26338f
C2702 dsm2_io_0.do_trim_b[1] di_trim[1] 0.18628f
C2703 dsm2_io_vcmg_0.di_vcm_ext_b a_2070_9446# 0.02369f
C2704 dsm2_osc_0.d_btest_or di_osc_en 0.03042f
C2705 a_24626_21300# a_24626_21160# 0.84953f
C2706 dsm2_osc_0.ibias_pad a_27856_874# 0.05242f
C2707 a_2049_2373# d_dith_en 0.04167f
C2708 quantizer2_lfsr_0.di_dith_amp[0] d_amp_s[1] 0.30771f
C2709 dsm2_osc_0.ibias_in a_23674_2578# 0.03448f
C2710 a_522_15861# a_522_15314# 0.07015f
C2711 quantizer2_lfsr_0.sg13cmos5l_dfrbpq_1_0.D a_558_518# 0.17617f
C2712 a_537_6405# a_1286_6839# 0.01571f
C2713 vo_p d_amp_s_b[2] 0.11163f
C2714 dsm2_io_0.do_btest_en vi_esd 0.09272f
C2715 sg13cmos5l_inv_1_4.A sg13cmos5l_inv_1_6.Y 0.3271f
C2716 a_13189_30111# vo_n 0.15549f
C2717 clk_noverlap_0.sg13cmos5l_inv_1_11.Y d_ena 0.15166f
C2718 quantizer2_lfsr_0.sg13cmos5l_dfrbpq_1_13.D a_1284_15861# 0.02376f
C2719 a_2049_12741# a_2070_12038# 0.02431f
C2720 a_522_12886# a_533_12512# 0.17382f
C2721 d_qi_b do_q_dec 0.03687f
C2722 a_24626_20040# bias_gm_0.bias_trim_0.vz 0.01346f
C2723 quantizer2_lfsr_0.sg13cmos5l_dfrbpq_1_0.Q a_2034_1466# 0.20699f
C2724 a_1288_11146# d_dith_en 0.20791f
C2725 a_537_6405# d_qclk 0.21599f
C2726 sg13cmos5l_and2_1_5.X do_q_b 0.05242f
C2727 sg13cmos5l_inv_1_18.Y xq_vg_q_2_ 1.12561f
C2728 sg13cmos5l_inv_1_17.Y xq_vg_q_1_ 0.01503f
C2729 dsm2_osc_0.d_btest_or dsm2_osc_0.sg13cmos5l_mux2_1_0.A1 0.33204f
C2730 a_19949_784# vdd 0.38513f
C2731 dsm2_osc_0.sg13cmos5l_dfrbp_1_0.RESET_B dsm2_osc_0.dsm2_io_rx_1.di_b 0.0967f
C2732 sg13cmos5l_inv_1_6.Y sg13cmos5l_inv_1_9.Y 0.02651f
C2733 a_10132_15186# vdd 0.31333f
C2734 a_2208_18213# dsm2_io_vcmg_0.di_vcm_ext_b 0.02348f
C2735 a_20672_21020# a_20758_21020# 0.01899f
C2736 sg13cmos5l_nand2_1_2.Y d_dith_en 0.01659f
C2737 dsm2_osc_0.sg13cmos5l_inv_1_2.A vdd 0.31835f
C2738 clk_noverlap_0.sg13cmos5l_dlygate4sd3_1_2.X a_6859_7241# 0.30507f
C2739 clk_noverlap_0.sg13cmos5l_dlygate4sd3_1_0.A a_9451_7241# 0.03228f
C2740 a_2070_3438# a_2049_2373# 0.01058f
C2741 a_1407_2354# d_dith_en 0.10049f
C2742 a_2070_11214# d_qclk 0.01467f
C2743 a_1284_15759# a_1407_15314# 0.23043f
C2744 do_q do_osc_oe 0.42894f
C2745 sg13cmos5l_nand2_1_2.Y xq_vg_q_0_ 0.05175f
C2746 quantizer2_lfsr_0.sg13cmos5l_dfrbpq_1_5.Q a_2070_12038# 0.21111f
C2747 d_ena d_dith[1] 0.2368f
C2748 quantizer2_lfsr_0.sg13cmos5l_dfrbpq_1_12.Q vdd 0.32669f
C2749 sg13cmos5l_inv_1_6.Y sg13cmos5l_and2_2_1.X 0.03378f
C2750 sg13cmos5l_nor2_2_0.B vdd 0.76535f
C2751 vdd d_amp_s[3] 0.62016f
C2752 sg13cmos5l_inv_1_4.Y sg13cmos5l_inv_1_2.A 0.01751f
C2753 sg13cmos5l_inv_1_6.Y sg13cmos5l_inv_1_2.Y 0.13549f
C2754 a_558_12654# a_522_12552# 0.25046f
C2755 dsm2_osc_0.ibias_in do_q 0.02225f
C2756 d_qi_b d_qclk 0.01047f
C2757 a_24626_19900# bias_gm_0.bias_trim_0.vz 0.01558f
C2758 a_20138_14766# a_20070_16046# 0.06835f
C2759 a_2034_6262# a_2070_6030# 0.16704f
C2760 quantizer2_lfsr_0.sg13cmos5l_dfrbpq_1_7.D d_dith_en 0.32145f
C2761 sg13cmos5l_inv_2_4.Y d_dith[0] 0.01223f
C2762 dsm2_io_vcmg_0.di_vcm_ext d_qout_en 0.40495f
C2763 sg13cmos5l_inv_1_4.A vo_p 0.93075f
C2764 a_14849_15078# vdd 0.2069f
C2765 a_4267_7241# vdd 0.3075f
C2766 sg13cmos5l_inv_1_17.A sg13cmos5l_inv_1_2.A 0.27669f
C2767 sg13cmos5l_inv_1_3.A sg13cmos5l_inv_1_13.Y 0.04097f
C2768 sg13cmos5l_inv_1_4.Y sg13cmos5l_inv_1_20.Y 8.64579f
C2769 a_522_15478# a_558_15246# 0.16704f
C2770 a_11865_14889# vdd 0.02347f
C2771 quantizer2_lfsr_0.di_dith_amp[0] quantizer2_lfsr_0.sg13cmos5l_dfrbpq_1_11.D 0.11439f
C2772 a_20758_21020# a_24258_20880# 0.01899f
C2773 a_16557_7164# d_phi2 0.06888f
C2774 clk_noverlap_0.sg13cmos5l_dlygate4sd3_1_10.A a_16161_7467# 0.12324f
C2775 quantizer2_lfsr_0.sg13cmos5l_dfrbpq_1_11.Q a_1284_2901# 0.11269f
C2776 vcm_esd do_q 0.02218f
C2777 sg13cmos5l_inv_1_16.A vo_n 0.01707f
C2778 a_2049_10149# vdd 0.23935f
C2779 d_dith[1] di_osc_en 0.02902f
C2780 sg13cmos5l_nor2_2_0.B sg13cmos5l_inv_1_16.Y 0.03036f
C2781 sg13cmos5l_inv_1_20.Y sg13cmos5l_inv_1_17.A 0.01855f
C2782 a_13569_7467# vdd 0.1584f
C2783 a_27029_23104# a_27029_22964# 0.4505f
C2784 sg13cmos5l_inv_1_11.Y sg13cmos5l_inv_1_2.Y 0.0112f
C2785 sg13cmos5l_inv_1_9.Y vo_p 0.04302f
C2786 xq_dith_v_bp d_phi2 0.28458f
C2787 sg13cmos5l_inv_1_7.Y do_q_dec 0.19793f
C2788 sg13cmos5l_inv_1_5.Y d_dith[0] 0.02632f
C2789 a_2070_4262# d_dith_en 0.0866f
C2790 a_20447_636# do_osc_oe 0.14786f
C2791 quantizer2_lfsr_0.sg13cmos5l_dfrbpq_1_0.D quantizer2_lfsr_0.sg13cmos5l_dfrbpq_1_8.D 0.0248f
C2792 a_1286_14615# a_1600_14309# 0.01562f
C2793 sg13cmos5l_inv_1_3.Y d_ena 0.1007f
C2794 d_amp_s[0] d_amp_s_b[3] 4.38417f
C2795 d_amp_s_b[0] d_amp_s[3] 0.79911f
C2796 d_amp_s_b[1] d_amp_s[1] 0.27052f
C2797 sw_tgate_cmfb2_3.gb xsc_xcmfb1_vsw_cm_p 0.38502f
C2798 di_trim[3] di_clk_sel 0.02982f
C2799 di_btest_en di_osc_en 0.04773f
C2800 sg13cmos5l_nand2_1_5.A sg13cmos5l_and2_1_5.A 0.07291f
C2801 xsc_vfb m3_9560_28731# 0.02141f
C2802 a_21736_2344# a_22386_2344# 0.03435f
C2803 sg13cmos5l_and2_2_1.X vo_p 0.04021f
C2804 dsm2_osc_0.sg13cmos5l_inv_1_3.A a_23674_2578# 0.19738f
C2805 dsm2_io_0.do_btest_en a_2208_20717# 0.02786f
C2806 a_22252_11246# a_19964_18216# 1.49913f
C2807 a_24258_20880# a_20758_20880# 0.01899f
C2808 quantizer2_lfsr_0.sg13cmos5l_dfrbpq_1_0.D a_533_7328# 0.01367f
C2809 dsm2_osc_0.sg13cmos5l_dfrbp_1_0.RESET_B a_23294_2344# 0.01228f
C2810 vdd d_dith_en 18.8336f
C2811 a_10592_15909# d_qout_en 0.20878f
C2812 a_2208_19557# vdd 0.06933f
C2813 a_19964_18216# a_28746_15446# 0.06859f
C2814 sg13cmos5l_inv_1_17.Y vo_n 0.01726f
C2815 xq_vg_q_0_ vdd 0.36542f
C2816 a_11115_8328# d_amp_s[3] 0.02367f
C2817 d_phi2 do_q 0.02351f
C2818 a_522_5110# a_1284_5391# 0.01202f
C2819 a_24258_22964# a_24258_22824# 0.18154f
C2820 dsm2_io_vcmg_0.di_vcm_ext_b a_10120_5586# 0.01736f
C2821 quantizer2_lfsr_0.di_dith_amp[1] d_qout_en 0.0976f
C2822 a_16941_5500# m2_10908_16863# 0.01012f
C2823 sg13cmos5l_inv_1_8.Y sg13cmos5l_inv_1_6.Y 0.11996f
C2824 dsm2_io_0.do_trim_b[1] bias_gm_0.bias_trim_0.iout 1.34118f
C2825 a_1288_5962# vdd 0.09469f
C2826 sg13cmos5l_inv_1_4.Y xq_vg_q_1_ 0.1858f
C2827 sg13cmos5l_inv_1_6.Y xq_vg_p_0_ 0.02601f
C2828 sw_tgate_cmfb2_1.p vo_n 1.90698f
C2829 dsm2_io_0.do_trim_b[1] a_22252_7946# 0.19473f
C2830 quantizer2_lfsr_0.di_dith_amp[1] quantizer2_lfsr_0.sg13cmos5l_dfrbpq_1_1.D 0.02047f
C2831 clk_noverlap_0.sg13cmos5l_dlygate4sd3_1_0.A d_ena 0.41879f
C2832 quantizer2_lfsr_0.sg13cmos5l_dfrbpq_1_11.Q a_2079_1938# 0.01803f
C2833 vdd d_rst_b 1.14235f
C2834 quantizer2_lfsr_0.sg13cmos5l_dfrbpq_1_0.D a_537_6405# 0.01117f
C2835 dsm2_osc_0.d_btest_or a_22836_1332# 0.10238f
C2836 dsm2_osc_0.dsm2_io_rx_0.di_b dsm2_osc_0.dsm2_io_rx_1.di_b 0.3907f
C2837 sg13cmos5l_inv_1_17.A xq_vg_q_1_ 0.02704f
C2838 sg13cmos5l_inv_1_16.Y xq_vg_q_0_ 0.03301f
C2839 sg13cmos5l_or2_1_0.X xq_dith_v_bp 1.65571f
C2840 a_19964_18216# a_26670_15146# 0.05976f
C2841 a_5176_31117# m2_6409_30900# 0.16267f
C2842 sg13cmos5l_inv_1_4.Y d_amp_s_b[3] 0.08146f
C2843 a_6817_30111# a_13189_30111# 0.07198f
C2844 a_1407_10130# vdd 0.13586f
C2845 d_dith_en d_amp_s_b[0] 0.09508f
C2846 a_20758_21020# d_ena 0.01376f
C2847 a_8208_15626# sg13cmos5l_inv_1_3.Y 0.0863f
C2848 clk_noverlap_0.sg13cmos5l_dlygate4sd3_1_0.A clk_noverlap_0.sg13cmos5l_dlygate4sd3_1_3.X 0.03803f
C2849 sg13cmos5l_and2_1_5.A do_q_b 0.03986f
C2850 sg13cmos5l_inv_1_16.Y a_11201_9168# 0.01227f
C2851 dsm2_io_0.sg13cmos5l_inv_1_4.A vdd 0.32082f
C2852 a_24258_22824# a_22252_11246# 0.01887f
C2853 a_19999_22824# a_19999_22684# 0.4505f
C2854 a_20328_23820# a_22252_11246# 0.12621f
C2855 a_2208_23789# a_2208_23021# 0.05462f
C2856 dsm2_io_0.do_btest_en sg13cmos5l_nand2_2_0.B 0.01844f
C2857 a_1367_9125# d_dith_en 0.10648f
C2858 dsm2_io_vcmg_0.di_vcm_ext_b a_15496_5586# 0.02462f
C2859 a_522_15144# d_qclk 0.04979f
C2860 a_1322_11954# a_1286_12023# 0.36396f
C2861 a_13960_5586# m2_10908_16863# 0.02098f
C2862 xq_vg_q_2_ a_6757_9808# 0.02522f
C2863 a_24626_19340# bias_gm_0.bias_trim_0.vz 0.0115f
C2864 a_20138_14766# a_24214_14546# 0.06876f
C2865 dsm2_io_vcmg_0.di_phi1_b d_vcm_phi1_b 0.09125f
C2866 sg13cmos5l_nor2_2_0.Y a_9556_15186# 0.24776f
C2867 dsm2_osc_0.d_btest_or a_22499_864# 0.01266f
C2868 a_2034_13704# vdd 0.07269f
C2869 sg13cmos5l_or2_1_0.X do_q 0.02891f
C2870 sg13cmos5l_inv_1_3.Y sg13cmos5l_inv_1_13.Y 1.07581f
C2871 a_5176_30111# m2_6409_30900# 0.17964f
C2872 sg13cmos5l_inv_1_12.A d_qi 0.03822f
C2873 sg13cmos5l_inv_1_10.Y d_rst_b 0.05516f
C2874 sg13cmos5l_inv_1_12.Y sg13cmos5l_inv_1_12.A 0.13475f
C2875 a_2208_21293# a_2208_21189# 0.05762f
C2876 d_rst_b d_amp_s_b[0] 0.14509f
C2877 a_8661_8748# a_8661_8468# 0.04477f
C2878 a_20758_20880# d_ena 0.01376f
C2879 a_12237_7164# a_11956_7466# 0.18796f
C2880 do_q di_clk_sel 0.01076f
C2881 a_537_14181# a_1286_14615# 0.01571f
C2882 d_phi1 d_dith[2] 0.01041f
C2883 a_2208_29933# a_2208_29165# 0.05462f
C2884 a_2034_8854# d_dith_en 0.14554f
C2885 a_2034_4053# a_2034_3670# 0.09257f
C2886 a_1322_11954# a_1600_11717# 0.07823f
C2887 a_533_9920# a_558_8294# 0.07916f
C2888 xq_vg_p_2_ a_11201_9808# 0.03241f
C2889 a_522_9960# a_567_8562# 0.24169f
C2890 xsc_xcmfb1_vsw_cm_p d_phi1 0.31695f
C2891 xsc_vc1r_n vo_p 0.02938f
C2892 a_1322_14546# vdd 0.20499f
C2893 sg13cmos5l_nand2_1_5.A sg13cmos5l_inv_1_3.A 0.0451f
C2894 a_1407_7538# d_dith_en 0.10049f
C2895 quantizer2_lfsr_0.sg13cmos5l_dfrbpq_1_2.D a_1288_13738# 0.01464f
C2896 sg13cmos5l_and2_1_2.X d_dith[0] 0.02835f
C2897 sg13cmos5l_inv_1_13.A sg13cmos5l_nor2_2_0.B 0.02126f
C2898 a_24540_20600# a_24626_20740# 0.01899f
C2899 quantizer2_lfsr_0.sg13cmos5l_dfrbpq_1_11.Q d_dith[0] 0.02501f
C2900 a_1284_15759# a_1681_14929# 0.16704f
C2901 sg13cmos5l_inv_1_4.Y vo_n 0.01512f
C2902 dsm2_io_vcmg_0.di_phi1_b m2_10908_16863# 0.0289f
C2903 d_phi1 d_vcm_phi1_b 0.01435f
C2904 sg13cmos5l_inv_1_17.A vo_n 0.05977f
C2905 a_12424_5586# a_13192_5586# 0.05462f
C2906 a_24626_22684# a_24626_22420# 0.2552f
C2907 sg13cmos5l_and2_1_5.B d_dith[0] 1.99913f
C2908 a_5176_31117# a_12445_30191# 0.94968f
C2909 a_14548_7466# vdd 0.2045f
C2910 xsc_xcmfb1_vsw_cm_p vcm_esd 2.27968f
C2911 a_11284_15186# d_qi_b 0.03351f
C2912 a_1286_12023# a_1288_11146# 0.02241f
C2913 dsm2_osc_0.d_btest_or do_q_b 0.03747f
C2914 a_537_8997# a_558_8294# 0.02431f
C2915 clk_noverlap_0.sg13cmos5l_inv_1_5.A clk_noverlap_0.sg13cmos5l_inv_1_6.A 0.08516f
C2916 sw_tgate_cmfb2_1.gb vo_n 0.02013f
C2917 a_1320_16970# d_amp_s[1] 0.01422f
C2918 sg13cmos5l_inv_1_6.A sg13cmos5l_inv_1_6.Y 0.5144f
C2919 xsc_vvg_n vo_n 0.04609f
C2920 a_19964_18216# vdd 21.9227f
C2921 quantizer2_lfsr_0.sg13cmos5l_dfrbpq_1_11.Q a_2034_1082# 0.18529f
C2922 dsm2_io_vcmg_0.di_phi1_b a_8392_5586# 0.01814f
C2923 sg13cmos5l_inv_1_3.Y a_11201_9308# 0.01376f
C2924 dsm2_io_0.sg13cmos5l_inv_1_5.A di_dith_amp[0] 0.0379f
C2925 di_trim[2] di_clk_sel 0.02982f
C2926 di_trim[3] di_osc_en 0.04695f
C2927 a_2049_2373# a_1284_2799# 0.02017f
C2928 a_522_2901# a_522_2354# 0.07015f
C2929 a_2034_11112# a_2049_10149# 0.28324f
C2930 dsm2_osc_0.d_btest_or a_20138_14766# 0.224f
C2931 vcm_esd d_vcm_phi1_b 0.12281f
C2932 quantizer2_lfsr_0.sg13cmos5l_dfrbpq_1_11.D a_533_4736# 0.0171f
C2933 vdd di_dith_en 0.51916f
C2934 a_20758_22420# a_20758_22280# 0.84953f
C2935 a_4649_7224# a_4537_7200# 0.3854f
C2936 a_537_6405# a_567_5970# 0.02241f
C2937 a_7241_7224# clk_noverlap_0.sg13cmos5l_dlygate4sd3_1_3.X 0.12324f
C2938 a_6817_30111# sw_tgate_cmfb2_1.p 0.33716f
C2939 a_12445_30191# a_5176_30111# 0.71722f
C2940 a_7224_31505# a_8762_31505# 0.08591f
C2941 sg13cmos5l_inv_1_13.A d_dith_en 0.01319f
C2942 sg13cmos5l_nand2_1_5.A d_dith[1] 0.06811f
C2943 a_26670_16346# vdd 0.02764f
C2944 quantizer2_lfsr_0.sg13cmos5l_dfrbpq_1_2.D d_dith[2] 0.04408f
C2945 sg13cmos5l_inv_1_13.A xq_vg_q_0_ 0.41895f
C2946 a_1324_8580# a_1288_8554# 0.24169f
C2947 dsm2_io_0.do_btest_en sg13cmos5l_nand2_1_2.Y 0.01434f
C2948 xsc_xcmfb1_vsw_cm_p d_phi2 0.38463f
C2949 a_522_15144# quantizer2_lfsr_0.sg13cmos5l_dfrbpq_1_0.D 0.0169f
C2950 sg13cmos5l_or2_1_0.X xq_vg_p_2_ 0.04949f
C2951 a_522_5110# vdd 0.17136f
C2952 m2_10908_16863# d_phi1 0.03351f
C2953 dsm2_osc_0.d_btest_or m2_10908_16655# 0.1746f
C2954 a_2079_12306# vdd 0.09472f
C2955 d_amp_s[1] d_dith[0] 0.01672f
C2956 xq_dith_v_bp d_ena 0.94016f
C2957 a_20758_20600# a_20758_20460# 0.84953f
C2958 sg13cmos5l_inv_1_19.Y sg13cmos5l_inv_1_18.Y 0.06721f
C2959 dsm2_osc_0.sg13cmos5l_dfrbp_1_0.RESET_B a_22368_558# 0.3172f
C2960 sg13cmos5l_inv_2_0.Y a_9556_15186# 0.06811f
C2961 sg13cmos5l_inv_1_7.Y a_12800_15736# 0.01676f
C2962 a_27029_22964# dsm2_osc_0.d_btest_or 0.01264f
C2963 a_2034_11112# d_dith_en 0.28298f
C2964 a_22252_11246# a_19904_17646# 0.13012f
C2965 a_2208_29933# dsm2_io_0.do_trim_b[0] 0.02092f
C2966 a_1284_2799# a_1407_2354# 0.23043f
C2967 sg13cmos5l_inv_1_2.A sg13cmos5l_inv_2_0.Y 0.02988f
C2968 sg13cmos5l_and2_1_5.X d_dith[0] 1.99518f
C2969 dsm2_osc_0.ibias_in m2_10908_16863# 0.02492f
C2970 dsm2_osc_0.sg13cmos5l_dfrbp_1_0.RESET_B dsm2_osc_0.ibias_pad 0.14447f
C2971 inv_en_0.di_b sg13cmos5l_nor2_2_0.B 0.33757f
C2972 a_5513_7224# vdd 0.16331f
C2973 a_522_2518# a_558_2286# 0.16704f
C2974 vdd di_rst_b 0.49471f
C2975 sw_tgate_cmfb2_1.p sw_tgate_cmfb2_3.gb 0.35708f
C2976 a_20328_23820# vdd 1.39642f
C2977 a_22252_4374# bias_gm_0.bias_trim_0.iout 1.51216f
C2978 a_22252_4074# a_24404_4674# 0.01925f
C2979 sg13cmos5l_inv_1_6.A vo_p 0.05541f
C2980 a_16557_7164# clk_noverlap_0.sg13cmos5l_dlygate4sd3_1_12.A 0.30507f
C2981 d_qi_b vi_esd 0.30036f
C2982 a_1284_5391# a_1324_3396# 0.01412f
C2983 a_22252_11246# a_24626_22000# 0.01655f
C2984 a_1286_6839# a_1600_6533# 0.01562f
C2985 a_22138_15746# vdd 0.01704f
C2986 xq_vg_q_2_ d_qclk 0.08126f
C2987 a_2034_11829# a_2034_11282# 0.07015f
C2988 a_14829_7164# vdd 0.26098f
C2989 m2_10908_16863# vcm_esd 23.1545f
C2990 vi_esd vi 0.04515f
C2991 quantizer2_lfsr_0.sg13cmos5l_dfrbpq_1_2.D a_1284_13167# 0.01526f
C2992 a_19964_18216# a_21252_3394# 2.35522f
C2993 a_9352_5586# vdd 0.51999f
C2994 a_6884_8680# d_amp_s_b[1] 0.02596f
C2995 d_ena do_q 0.04999f
C2996 a_1286_12023# vdd 0.24602f
C2997 clk_noverlap_0.sg13cmos5l_inv_1_5.A vdd 0.28717f
C2998 a_571_3684# d_dith_en 0.01368f
C2999 a_28334_20600# a_28334_20460# 0.1335f
C3000 sg13cmos5l_inv_1_20.Y d_amp_s_b[2] 0.06848f
C3001 a_2034_14421# d_qclk 0.01155f
C3002 quantizer2_lfsr_0.sg13cmos5l_dfrbpq_1_11.D a_558_8294# 0.0207f
C3003 sg13cmos5l_or2_1_0.X d_dith[2] 0.06541f
C3004 bias_gm_0.bias_trim_0.vz a_23328_9146# 0.08137f
C3005 a_5176_31117# vdd 41.2138f
C3006 a_17140_7466# d_phi2 0.09059f
C3007 a_24258_22280# a_24540_22000# 0.0452f
C3008 a_22252_11246# a_24626_21860# 0.01638f
C3009 clk_noverlap_0.sg13cmos5l_dlygate4sd3_1_0.A a_9721_7200# 0.02852f
C3010 a_20070_14846# vdd 0.19058f
C3011 a_10592_15909# d_qi_b 0.09044f
C3012 sg13cmos5l_inv_1_3.A d_amp_s_b[1] 0.08622f
C3013 a_2034_8520# di_clk_sel 0.01151f
C3014 a_11656_5586# d_phi1 0.01519f
C3015 vdd ibias_test 0.17637f
C3016 d_dith[2] di_clk_sel 0.107f
C3017 sg13cmos5l_and2_1_5.B do_q_dec 0.03439f
C3018 a_24404_8546# a_23328_9146# 0.03582f
C3019 do_q di_osc_en 0.01763f
C3020 a_2034_5928# di_osc_en 0.01207f
C3021 dsm2_io_0.do_btest_en vdd 1.89098f
C3022 dsm2_io_0.do_trim_b[0] bias_gm_0.bias_trim_0.vz 0.89079f
C3023 a_14728_5586# vdd 0.529f
C3024 a_11201_8608# d_amp_s_b[1] 0.02534f
C3025 inv_en_0.di_b d_dith_en 0.0414f
C3026 clk_noverlap_0.sg13cmos5l_nor3_1_0.C d_qclk 0.11923f
C3027 m2_10908_16863# d_phi2 0.12341f
C3028 quantizer2_lfsr_0.sg13cmos5l_dfrbpq_1_13.D a_1288_13738# 0.01541f
C3029 a_1288_3370# d_dith_en 0.20465f
C3030 a_2070_13806# d_qclk 0.01505f
C3031 a_1284_2799# vdd 0.17136f
C3032 quantizer2_lfsr_0.sg13cmos5l_dfrbpq_1_11.Q d_qclk 0.29887f
C3033 a_20328_23820# dsm2_io_0.do_trim_b[3] 0.26468f
C3034 sg13cmos5l_inv_1_13.Y xq_dith_v_bp 0.81352f
C3035 a_22252_4074# vdd 4.45755f
C3036 dsm2_io_0.do_trim_b[0] a_24404_8546# 0.05752f
C3037 a_2034_11112# a_2083_10020# 0.24435f
C3038 a_5176_30111# vdd 0.52919f
C3039 a_20000_22140# a_20000_22000# 0.1335f
C3040 a_26670_14846# vdd 0.01692f
C3041 a_533_9920# d_qclk 0.03827f
C3042 sg13cmos5l_inv_1_18.Y a_6884_8680# 0.07765f
C3043 sg13cmos5l_inv_1_4.A sg13cmos5l_inv_1_20.Y 0.27184f
C3044 quantizer2_lfsr_0.sg13cmos5l_dfrbpq_1_11.D a_526_16657# 0.1315f
C3045 sg13cmos5l_inv_1_6.Y d_qi 0.01139f
C3046 bias_gm_0.bias_trim_0.vz dsm2_osc_0.d_btest_or 0.42337f
C3047 a_11201_8328# d_amp_s_b[1] 0.01523f
C3048 a_2208_23789# dsm2_io_0.do_trim_b[0] 0.02402f
C3049 xsc_xcmfb1_vsw_vbias vo_n 6.12584f
C3050 dsm2_io_0.do_btest_en sg13cmos5l_inv_1_10.Y 0.13421f
C3051 dsm2_osc_0.sg13cmos5l_inv_1_3.A m2_10908_16863# 0.03241f
C3052 dsm2_io_0.do_btest_en d_amp_s_b[0] 0.12994f
C3053 a_24540_20320# a_24540_20040# 0.04477f
C3054 a_20000_20320# a_20000_20180# 0.1335f
C3055 sg13cmos5l_or2_1_0.X a_17140_7466# 0.01107f
C3056 a_2034_5928# a_2045_5888# 0.20759f
C3057 sg13cmos5l_inv_1_13.Y do_q 0.03333f
C3058 sw_tgate_cmfb2_1.p d_phi1 0.42945f
C3059 d_amp_s[1] do_q_dec 0.02614f
C3060 sg13cmos5l_inv_1_9.Y sg13cmos5l_inv_1_20.Y 0.32739f
C3061 sg13cmos5l_inv_1_16.A a_11201_9808# 0.0107f
C3062 bias_gm_0.bias_trim_0.vz a_23328_5574# 0.08137f
C3063 a_533_2144# vdd 0.20451f
C3064 d_amp_s_b[3] d_amp_s_b[2] 0.82151f
C3065 d_amp_s_b[1] d_dith[1] 0.0169f
C3066 sg13cmos5l_inv_1_3.A sg13cmos5l_inv_1_18.Y 0.07637f
C3067 sg13cmos5l_inv_1_2.A sg13cmos5l_and2_2_1.X 0.29994f
C3068 a_5176_31469# vo_p 1.46353f
C3069 sw_tgate_cmfb2_3.gb sw_tgate_cmfb2_1.gb 1.63038f
C3070 a_9883_9628# a_9883_9488# 0.19806f
C3071 a_8587_7241# vdd 0.26213f
C3072 quantizer2_lfsr_0.sg13cmos5l_dfrbpq_1_0.D a_567_13746# 0.01567f
C3073 a_24626_22140# a_24626_22000# 0.84953f
C3074 a_522_4776# a_537_3813# 0.28324f
C3075 dsm2_io_0.sg13cmos5l_inv_1_5.A di_btest_en 0.18485f
C3076 sg13cmos5l_inv_1_2.A sg13cmos5l_inv_1_2.Y 0.10231f
C3077 vdd d_qout_en 2.42055f
C3078 di_trim[2] di_osc_en 0.04773f
C3079 di_trim[1] di_clk_sel 0.02982f
C3080 xsc_vvg_n sw_tgate_cmfb2_3.gb 0.03479f
C3081 a_15491_15614# d_rst_b 0.20783f
C3082 sg13cmos5l_and2_1_5.X do_q_dec 0.0268f
C3083 a_537_8997# d_qclk 0.21593f
C3084 bias_gm_0.bias_trim_0.iout dsm2_osc_0.ibias_in 3.01083f
C3085 sg13cmos5l_inv_1_9.Y a_14734_15077# 0.01833f
C3086 dsm2_io_0.do_trim_b[3] dsm2_io_0.do_btest_en 0.03848f
C3087 sg13cmos5l_inv_1_20.Y sg13cmos5l_and2_2_1.X 0.02657f
C3088 a_13101_7164# a_12820_7466# 0.18796f
C3089 sg13cmos5l_and2_1_5.A d_dith[0] 0.01224f
C3090 a_17416_5586# vdd 0.28554f
C3091 quantizer2_lfsr_0.sg13cmos5l_dfrbpq_1_1.D vdd 0.47694f
C3092 sg13cmos5l_inv_1_19.Y a_6757_9808# 0.01088f
C3093 a_2034_3670# a_2045_3296# 0.17382f
C3094 a_522_7538# vdd 0.13554f
C3095 a_24626_20320# a_24626_20180# 0.84953f
C3096 a_13870_15077# a_13985_15078# 0.3854f
C3097 m2_10908_16863# di_clk_sel 0.28252f
C3098 a_19904_17646# vdd 1.22735f
C3099 sw_tgate_cmfb2_1.p vcm_esd 0.12124f
C3100 d_phi1 d_amp_s[0] 0.02302f
C3101 d_amp_s[1] d_qclk 0.02494f
C3102 dsm2_osc_0.sg13cmos5l_mux2_1_0.A1 a_20447_636# 0.09855f
C3103 dsm2_io_0.do_trim_b[3] a_22252_4074# 0.03484f
C3104 sg13cmos5l_inv_1_17.Y a_11201_9808# 0.01143f
C3105 a_21252_3394# a_22252_4074# 0.04485f
C3106 a_1681_1969# a_1286_1655# 0.01058f
C3107 a_537_1221# vdd 0.23809f
C3108 d_amp_s[1] d_amp_s[2] 8.15431f
C3109 clk_noverlap_0.sg13cmos5l_inv_1_9.A vdd 0.29017f
C3110 sg13cmos5l_inv_1_4.A xq_vg_q_1_ 0.0346f
C3111 a_20672_21860# a_20758_21860# 0.01899f
C3112 sg13cmos5l_nand2_2_0.B d_qi_b 0.02329f
C3113 clk_noverlap_0.sg13cmos5l_inv_1_11.Y a_10784_6484# 0.02383f
C3114 sg13cmos5l_inv_1_3.Y d_amp_s_b[1] 0.18053f
C3115 d_qout_en d_amp_s_b[0] 0.38041f
C3116 a_16648_5586# d_phi2 0.01133f
C3117 a_1324_3396# vdd 0.07232f
C3118 quantizer2_lfsr_0.sg13cmos5l_dfrbpq_1_0.Q quantizer2_lfsr_0.sg13cmos5l_dfrbpq_1_11.Q 0.07152f
C3119 sg13cmos5l_inv_1_9.Y xq_vg_q_1_ 0.17429f
C3120 quantizer2_lfsr_0.sg13cmos5l_dfrbpq_1_11.D do_q_dec 0.03897f
C3121 a_28126_20180# a_28126_19900# 0.04477f
C3122 d_ena d_dith[2] 0.4655f
C3123 sg13cmos5l_inv_1_0.Y a_14266_14856# 0.30066f
C3124 clk_noverlap_0.sg13cmos5l_inv_1_5.Y d_qclk 0.1093f
C3125 a_2083_12612# d_qclk 0.01273f
C3126 a_558_518# vdd 0.5259f
C3127 dsm2_io_vcmg_0.di_vcm_ext a_8880_5832# 0.11327f
C3128 sw_tgate_cmfb2_1.p d_phi2 0.6091f
C3129 sg13cmos5l_or2_1_0.X sg13cmos5l_inv_1_16.A 0.04141f
C3130 a_8747_9488# a_8747_9308# 0.14662f
C3131 a_20758_21860# a_24258_21720# 0.01899f
C3132 a_537_3813# a_1286_4247# 0.01571f
C3133 sg13cmos5l_inv_1_9.Y d_amp_s_b[3] 0.07726f
C3134 sg13cmos5l_and2_2_1.X xq_vg_q_1_ 0.01729f
C3135 clk_noverlap_0.sg13cmos5l_inv_1_9.A clk_noverlap_0.sg13cmos5l_inv_1_8.A 0.08516f
C3136 sg13cmos5l_and2_1_4.X vdd 0.12415f
C3137 a_2034_6645# vdd 0.27624f
C3138 quantizer2_lfsr_0.sg13cmos5l_dfrbpq_1_12.Q d_dith_en 0.09132f
C3139 quantizer2_lfsr_0.sg13cmos5l_dfrbpq_1_0.D a_533_9920# 0.01367f
C3140 sg13cmos5l_nor2_2_0.B d_dith_en 1.81899f
C3141 a_5513_7224# a_5401_7200# 0.3854f
C3142 sg13cmos5l_inv_1_14.A do_q 0.06189f
C3143 d_dith_en d_amp_s[3] 0.1023f
C3144 sg13cmos5l_inv_1_9.Y sg13cmos5l_inv_1_0.A 0.04569f
C3145 sg13cmos5l_inv_1_20.Y xq_vg_p_0_ 0.03469f
C3146 sg13cmos5l_inv_1_13.Y xq_vg_p_2_ 0.11963f
C3147 vdd vcm 0.37961f
C3148 d_dith[2] di_osc_en 0.02395f
C3149 a_19904_17646# a_21252_3394# 0.07157f
C3150 quantizer2_lfsr_0.sg13cmos5l_dfrbpq_1_5.Q d_ena 0.01296f
C3151 quantizer2_lfsr_0.sg13cmos5l_dfrbpq_1_11.D d_qclk 0.18879f
C3152 a_20672_19900# a_20758_20040# 0.01899f
C3153 sg13cmos5l_inv_1_6.Y sg13cmos5l_inv_1_11.Y 0.16717f
C3154 a_571_14052# a_558_13478# 0.18486f
C3155 a_558_8294# a_567_8562# 0.45119f
C3156 xq_vg_q_1_ a_9883_9488# 0.01134f
C3157 a_8747_8188# d_amp_s[0] 0.08001f
C3158 a_20447_636# a_20770_598# 0.28837f
C3159 a_533_15104# a_537_14181# 0.36374f
C3160 quantizer2_lfsr_0.sg13cmos5l_dfrbpq_1_2.D a_2070_1670# 0.17096f
C3161 a_7437_15998# sg13cmos5l_inv_1_3.A 0.09473f
C3162 sw_tgate_cmfb2_1.gb d_phi1 1.44518f
C3163 d_phi2 d_amp_s[0] 0.02849f
C3164 quantizer2_lfsr_0.di_dith_amp[1] di_vcm_ext 0.01072f
C3165 a_2034_1466# vdd 0.18295f
C3166 a_1286_1655# a_1367_1349# 0.02431f
C3167 xsc_vvg_n d_phi1 0.20273f
C3168 sg13cmos5l_inv_1_3.Y sg13cmos5l_inv_1_18.Y 0.12061f
C3169 sg13cmos5l_or2_1_0.X sg13cmos5l_inv_1_17.Y 1.32452f
C3170 a_24258_21720# a_20758_21720# 0.01899f
C3171 a_27029_22824# ibias_200n 0.01045f
C3172 a_2049_10149# d_dith_en 0.04198f
C3173 clk_noverlap_0.sg13cmos5l_inv_1_0.Y vdd 0.28095f
C3174 xq_dith_v_bq vdd 0.65825f
C3175 sg13cmos5l_inv_1_6.Y vo_p 0.01464f
C3176 clk_noverlap_0.sg13cmos5l_dlygate4sd3_1_2.X vdd 0.22914f
C3177 a_6884_8680# a_8747_8328# 0.0286f
C3178 sg13cmos5l_inv_1_3.A d_dith[0] 0.02826f
C3179 sg13cmos5l_nor2_2_0.B d_rst_b 0.01293f
C3180 sg13cmos5l_inv_1_19.Y do_q_dec 0.01705f
C3181 quantizer2_lfsr_0.sg13cmos5l_dfrbpq_1_0.D a_537_8997# 0.01109f
C3182 sg13cmos5l_inv_1_4.A vo_n 0.93219f
C3183 d_rst_b d_amp_s[3] 0.07447f
C3184 quantizer2_lfsr_0.sg13cmos5l_dfrbpq_1_2.Q d_dith[0] 0.08925f
C3185 d_vcm_phi1_b di_osc_en 0.06389f
C3186 sg13cmos5l_nand2_1_5.A do_q 0.08439f
C3187 a_11201_8188# vdd 0.01438f
C3188 a_571_6276# d_dith_en 0.01368f
C3189 dsm2_osc_0.d_btest_or a_21830_2578# 0.01646f
C3190 sg13cmos5l_and2_1_5.A do_q_dec 1.82896f
C3191 sw_tgate_cmfb2_1.gb vcm_esd 0.66962f
C3192 a_21498_769# dsm2_osc_0.sg13cmos5l_dfrbp_1_0.Q_N 0.13672f
C3193 clk_noverlap_0.sg13cmos5l_dlygate4sd3_1_10.A vdd 0.23111f
C3194 a_23294_2578# vdd 0.09733f
C3195 a_8747_8468# d_amp_s_b[0] 0.02562f
C3196 a_1600_1349# a_1367_1349# 0.18486f
C3197 a_21554_2798# vdd 1.30356f
C3198 xsc_vvg_n vcm_esd 0.08232f
C3199 dsm2_osc_0.sg13cmos5l_mux2_1_0.A1 a_20884_598# 0.01932f
C3200 sg13cmos5l_inv_1_9.Y vo_n 0.07407f
C3201 a_8747_9308# a_8747_9168# 0.48787f
C3202 a_11115_9168# a_11201_9308# 0.01899f
C3203 sg13cmos5l_inv_1_0.A a_13088_15020# 0.01201f
C3204 sg13cmos5l_inv_1_1.A sg13cmos5l_inv_1_0.Y 0.13743f
C3205 sg13cmos5l_inv_1_17.A a_11201_9808# 0.01509f
C3206 m2_10908_16863# d_ena 1.59291f
C3207 sw_tgate_cmfb2_3.gb xsc_xcmfb1_vsw_vbias 0.33016f
C3208 a_522_2518# d_qclk 0.01218f
C3209 xq_dith_v_bp do_q_b 0.04053f
C3210 quantizer2_lfsr_0.di_dith_amp[1] dsm2_io_0.sg13cmos5l_inv_1_0.A 0.01021f
C3211 quantizer2_lfsr_0.sg13cmos5l_dfrbpq_1_8.D vdd 0.31537f
C3212 a_522_10294# a_522_10130# 0.23043f
C3213 a_1284_10677# a_1284_10575# 0.09257f
C3214 a_13211_8468# a_11201_8468# 0.01899f
C3215 sg13cmos5l_inv_1_19.Y d_qclk 0.06499f
C3216 quantizer2_lfsr_0.sg13cmos5l_dfrbpq_1_2.D a_1286_4247# 0.01639f
C3217 vdd di_qout_en 0.50891f
C3218 di_trim[1] di_osc_en 0.04772f
C3219 di_trim[0] di_clk_sel 0.02983f
C3220 sg13cmos5l_and2_2_1.X vo_n 0.04021f
C3221 sg13cmos5l_or2_1_0.X d_amp_s[0] 0.18498f
C3222 xq_dith_v_bq d_amp_s_b[0] 0.09319f
C3223 a_19105_884# do_q 0.01461f
C3224 clk_noverlap_0.sg13cmos5l_inv_1_1.A clk_noverlap_0.di_clk 0.02895f
C3225 inv_en_0.di vdd 0.68352f
C3226 a_533_7328# vdd 0.20451f
C3227 a_1288_5962# d_dith_en 0.20581f
C3228 a_2034_11282# a_2045_11072# 0.03546f
C3229 dsm2_osc_0.d_btest_or a_22184_2052# 0.0131f
C3230 a_24258_19760# a_24540_19760# 0.04564f
C3231 a_6757_9808# a_10757_9808# 0.0182f
C3232 sw_tgate_cmfb2_1.gb d_phi2 1.40388f
C3233 a_2070_3438# d_dith_en 0.01033f
C3234 d_dith_en d_rst_b 0.71876f
C3235 d_amp_s[0] di_clk_sel 0.44121f
C3236 dsm2_osc_0.di_clk_ext dsm2_osc_0.sg13cmos5l_buf_2_0.A 0.29452f
C3237 m2_10908_16863# di_osc_en 0.44779f
C3238 a_8661_9028# a_8747_9028# 0.01899f
C3239 a_11115_9168# a_11115_8888# 0.04477f
C3240 d_dith[1] d_dith[0] 0.20508f
C3241 xsc_vvg_n d_phi2 0.52174f
C3242 do_q_b do_q 10.1314f
C3243 dsm2_osc_0.d_btest_or clk_noverlap_0.di_clk 0.11633f
C3244 a_1407_10130# d_dith_en 0.10089f
C3245 quantizer2_lfsr_0.sg13cmos5l_dfrbpq_1_2.D a_1288_8554# 0.01547f
C3246 sw_tgate_cmfb2_1.p ibias_200n 0.0987f
C3247 sg13cmos5l_or2_1_0.X sg13cmos5l_inv_1_15.Y 0.02316f
C3248 sg13cmos5l_and2_1_5.B sg13cmos5l_inv_1_0.Y 0.03316f
C3249 quantizer2_lfsr_0.sg13cmos5l_dfrbpq_1_11.D quantizer2_lfsr_0.sg13cmos5l_dfrbpq_1_0.Q 0.23062f
C3250 a_22252_7946# ibias_200n 1.51201f
C3251 a_2049_10149# a_2083_10020# 0.01562f
C3252 a_522_10294# a_522_9960# 0.01412f
C3253 a_1284_7983# a_1324_5988# 0.01412f
C3254 a_13960_5586# xvcm_vcf_b 0.02361f
C3255 dsm2_io_0.sg13cmos5l_inv_1_3.A a_2208_20141# 0.02709f
C3256 a_2208_30701# d_ena 0.01007f
C3257 clk_noverlap_0.sg13cmos5l_dlygate4sd3_1_0.A a_11841_7467# 0.10667f
C3258 sg13cmos5l_inv_1_13.Y a_6757_9948# 0.03851f
C3259 a_537_6405# vdd 0.23809f
C3260 a_24540_19760# a_24626_19760# 0.01899f
C3261 a_2034_14038# a_2034_13874# 0.23043f
C3262 sg13cmos5l_inv_2_5.A do_q 0.02085f
C3263 a_526_16657# a_562_16373# 0.19075f
C3264 sg13cmos5l_inv_1_6.A sg13cmos5l_inv_1_20.Y 0.07032f
C3265 a_21252_3394# a_21554_2798# 0.07792f
C3266 a_2034_13704# d_dith_en 0.27252f
C3267 a_20770_598# a_20884_598# 0.03097f
C3268 dsm2_osc_0.sg13cmos5l_dfrbp_1_0.Q_N a_22000_594# 0.11748f
C3269 a_21617_558# a_22368_558# 0.01412f
C3270 sg13cmos5l_inv_1_16.A d_ena 0.39124f
C3271 sg13cmos5l_inv_1_4.Y sg13cmos5l_or2_1_0.X 0.05772f
C3272 quantizer2_lfsr_0.sg13cmos5l_dfrbpq_1_11.D quantizer2_lfsr_0.sg13cmos5l_dfrbpq_1_0.D 6.58537f
C3273 dsm2_osc_0.sg13cmos5l_mux2_1_0.A1 m2_10908_16863# 0.01383f
C3274 clk_noverlap_0.sg13cmos5l_dlygate4sd3_1_8.X a_12705_7467# 0.12324f
C3275 a_10757_8888# a_11115_8888# 0.03425f
C3276 a_2034_1082# d_dith[1] 0.16319f
C3277 a_24540_21440# a_24626_21580# 0.01899f
C3278 a_2034_5928# a_2049_4965# 0.28324f
C3279 a_1681_1969# d_qclk 0.01055f
C3280 sg13cmos5l_inv_1_3.Y a_8747_8608# 0.01465f
C3281 a_1502_26288# vdd 0.11161f
C3282 sg13cmos5l_or2_1_0.X sg13cmos5l_inv_1_17.A 0.04557f
C3283 dsm2_io_0.sg13cmos5l_inv_1_6.A dsm2_io_0.sg13cmos5l_inv_1_1.A 0.10872f
C3284 dsm2_osc_0.sg13cmos5l_buf_2_0.A do_clk_osc 0.01813f
C3285 m2_10908_16655# do_q 0.06662f
C3286 a_9833_7224# vdd 0.15798f
C3287 sw_tgate_9.gb d_qi_b 0.22626f
C3288 vdd d_qi_b 4.53266f
C3289 sg13cmos5l_inv_1_3.A do_q_dec 0.01559f
C3290 a_1322_14546# d_dith_en 0.28445f
C3291 a_24626_19760# a_28126_19620# 0.01899f
C3292 a_2034_14038# a_2045_13664# 0.17382f
C3293 xq_vg_p_0_ vo_n 0.14561f
C3294 a_1322_4178# d_qclk 0.05213f
C3295 quantizer2_lfsr_0.sg13cmos5l_dfrbpq_1_2.Q do_q_dec 0.05039f
C3296 a_13965_7164# a_13684_7466# 0.18796f
C3297 a_22386_2578# a_22184_2052# 0.09015f
C3298 a_21554_2798# a_21276_2052# 0.05577f
C3299 a_2034_3336# quantizer2_lfsr_0.sg13cmos5l_dfrbpq_1_11.Q 0.05778f
C3300 inv_en_0.di_b d_qout_en 0.10021f
C3301 sg13cmos5l_inv_1_17.Y d_ena 0.21449f
C3302 vdd vi 0.18317f
C3303 xsc_xcmfb1_vsw_vbias d_phi1 0.33894f
C3304 sg13cmos5l_and2_1_5.X a_15584_15091# 0.09665f
C3305 dsm2_osc_0.sg13cmos5l_dfrbp_1_0.CLK a_22368_558# 0.06041f
C3306 xsc_vc1r_n vo_n 0.05103f
C3307 sg13cmos5l_inv_1_3.Y a_8747_8328# 0.01831f
C3308 dsm2_io_0.do_trim_b[2] a_22252_5274# 0.09512f
C3309 a_2208_19085# a_2208_18981# 0.05762f
C3310 a_537_3813# a_558_3110# 0.02431f
C3311 dsm2_io_vcmg_0.di_vcm_ext d_amp_s[1] 0.0688f
C3312 sw_tgate_cmfb2_1.p d_ena 0.12832f
C3313 quantizer2_lfsr_0.sg13cmos5l_nor2_1_1.B a_1284_15759# 0.01299f
C3314 sg13cmos5l_inv_1_6.A xq_vg_q_1_ 0.0443f
C3315 clk_noverlap_0.sg13cmos5l_inv_1_1.Y d_ena 0.07462f
C3316 dsm2_io_0.do_trim_b[2] a_22252_8246# 0.07275f
C3317 a_522_15314# vdd 0.13554f
C3318 a_28126_19620# a_24626_19620# 0.01899f
C3319 a_20672_19620# a_20260_17236# 0.05497f
C3320 a_24712_874# vi_esd 0.05289f
C3321 quantizer2_lfsr_0.sg13cmos5l_dfrbpq_1_2.Q d_qclk 0.07518f
C3322 sg13cmos5l_inv_1_3.A d_amp_s[2] 0.05042f
C3323 a_22184_2052# a_22644_2344# 0.28092f
C3324 sg13cmos5l_nand2_1_5.A d_dith[2] 0.06842f
C3325 a_558_12654# d_dith_en 0.01118f
C3326 xq_vg_p_2_ do_q_b 0.05881f
C3327 xsc_xcmfb1_vsw_vbias vcm_esd 2.19647f
C3328 a_22347_812# a_22368_558# 0.20754f
C3329 a_2034_8520# a_2045_8480# 0.20759f
C3330 a_20758_21440# a_20758_21300# 0.84953f
C3331 sg13cmos5l_nor2_1_0.Y a_8768_15909# 0.01189f
C3332 a_2208_24557# d_ena 0.03806f
C3333 sg13cmos5l_inv_1_13.Y sg13cmos5l_inv_1_16.A 0.2108f
C3334 d_dith[1] do_q_dec 0.13111f
C3335 a_558_10062# a_537_8997# 0.01058f
C3336 xq_vg_p_2_ a_11201_9948# 0.07705f
C3337 a_1324_3396# a_1288_3370# 0.24169f
C3338 d_ena d_amp_s[0] 0.52051f
C3339 dsm2_io_vcmg_0.di_vcm_ext_b d_amp_s_b[3] 0.02396f
C3340 sg13cmos5l_inv_1_7.Y vdd 0.3755f
C3341 a_10757_9808# d_qclk 0.03073f
C3342 xsc_vvg_n xsc_vc1l_p 0.02958f
C3343 a_5995_7241# d_qclk 0.01092f
C3344 xvcm_vcf_b d_phi1 0.05684f
C3345 a_20758_19620# a_20758_19480# 0.84953f
C3346 di_trim[0] di_osc_en 0.04776f
C3347 a_522_5110# d_dith_en 0.13349f
C3348 dsm2_osc_0.dsm2_io_rx_1.di_b do_osc_oe 0.07518f
C3349 a_6377_7224# a_6265_7200# 0.3854f
C3350 a_2079_12306# d_dith_en 0.18054f
C3351 sg13cmos5l_inv_2_5.Y do_q 0.01877f
C3352 inv_en_0.di_b sg13cmos5l_and2_1_4.X 0.03293f
C3353 a_12705_7467# d_phi2 0.04296f
C3354 xsc_xcmfb1_vsw_vbias d_phi2 0.3335f
C3355 a_22252_11246# a_24626_20040# 0.01597f
C3356 a_28334_21440# a_28334_21300# 0.1335f
C3357 quantizer2_lfsr_0.di_dith_amp[1] d_amp_s[1] 0.24925f
C3358 sg13cmos5l_inv_1_15.Y d_ena 0.03708f
C3359 dsm2_io_0.do_btest_en sg13cmos5l_nor2_2_0.B 0.01344f
C3360 sg13cmos5l_inv_1_13.Y sg13cmos5l_inv_1_17.Y 0.47905f
C3361 a_8747_8748# d_amp_s_b[2] 0.02544f
C3362 d_phi1 d_amp_s_b[2] 0.02057f
C3363 dsm2_io_vcmg_0.di_vcm_ext a_8974_5832# 0.01601f
C3364 d_dith[1] d_qclk 0.07829f
C3365 d_amp_s[0] di_osc_en 0.01063f
C3366 sg13cmos5l_or2_1_0.X sg13cmos5l_nor2_2_0.Y 0.19695f
C3367 m2_10908_16863# d_vcm_phi2 0.06032f
C3368 a_522_15144# vdd 0.0721f
C3369 dsm2_io_0.sg13cmos5l_inv_1_1.A a_2208_18213# 0.01862f
C3370 d_amp_s[2] d_dith[1] 0.01825f
C3371 clk_noverlap_0.sg13cmos5l_inv_1_0.A d_amp_s_b[3] 0.02597f
C3372 sg13cmos5l_nand2_1_2.Y a_14266_16020# 0.01536f
C3373 xvcm_vcf_b vcm_esd 1.17492f
C3374 sg13cmos5l_inv_1_3.Y do_q_dec 0.01218f
C3375 sg13cmos5l_inv_1_4.Y d_ena 0.04719f
C3376 dsm2_osc_0.dsm2_io_rx_1.di_b vcm_esd 0.0285f
C3377 a_24626_20600# dsm2_osc_0.d_btest_or 0.01657f
C3378 sg13cmos5l_inv_1_6.A vo_n 0.05535f
C3379 a_1286_12023# d_dith_en 0.04708f
C3380 dsm2_osc_0.sg13cmos5l_dfrbp_1_0.RESET_B dsm2_osc_0.dsm2_io_rx_0.di_b 0.486f
C3381 dsm2_io_0.sg13cmos5l_inv_1_1.A dsm2_io_vcmg_0.di_vcm_ext_b 0.10742f
C3382 a_22252_11246# a_24626_19900# 0.01601f
C3383 quantizer2_lfsr_0.sg13cmos5l_dfrbpq_1_6.Q quantizer2_lfsr_0.sg13cmos5l_dfrbpq_1_5.Q 0.56951f
C3384 sg13cmos5l_inv_1_17.A d_ena 0.12723f
C3385 sg13cmos5l_nand2_2_0.B sg13cmos5l_and2_1_5.B 0.01451f
C3386 a_2070_9446# quantizer2_lfsr_0.sg13cmos5l_dfrbpq_1_4.Q 0.19422f
C3387 a_537_8997# a_1286_9431# 0.01571f
C3388 a_1681_7153# a_1286_6839# 0.01058f
C3389 a_22368_558# do_clk_osc 0.049f
C3390 sg13cmos5l_and2_1_5.A a_15584_15091# 0.01461f
C3391 sg13cmos5l_and2_1_5.A sg13cmos5l_inv_1_0.Y 0.27753f
C3392 sg13cmos5l_inv_1_3.Y d_qclk 0.27871f
C3393 a_2034_13704# a_2079_12306# 0.24169f
C3394 a_2045_13664# a_2070_12038# 0.07916f
C3395 xvcm_vcf_b d_phi2 0.01227f
C3396 dsm2_io_0.do_btest_en d_dith_en 0.228f
C3397 quantizer2_lfsr_0.sg13cmos5l_dfrbpq_1_0.D a_567_8562# 0.01401f
C3398 quantizer2_lfsr_0.sg13cmos5l_dfrbpq_1_0.Q a_1367_1349# 0.05494f
C3399 vdd di_vcm_ext 0.50762f
C3400 xsc_vfb xsc_xcmfb1_vsw_cm_p 0.68536f
C3401 sg13cmos5l_inv_1_3.Y d_amp_s[2] 3.89031f
C3402 a_24626_20460# dsm2_osc_0.d_btest_or 0.01657f
C3403 sg13cmos5l_nor2_2_0.B d_qout_en 0.01192f
C3404 sg13cmos5l_inv_1_16.A sg13cmos5l_inv_1_14.A 0.02409f
C3405 d_qout_en d_amp_s[3] 0.19906f
C3406 sg13cmos5l_inv_2_4.Y vdd 0.32408f
C3407 quantizer2_lfsr_0.di_dith_amp[1] quantizer2_lfsr_0.sg13cmos5l_dfrbpq_1_11.D 0.48713f
C3408 a_2070_11214# a_2034_11112# 0.25046f
C3409 a_20000_21160# a_20000_21020# 0.1335f
C3410 a_24540_21160# a_24540_20880# 0.04477f
C3411 dsm2_io_0.do_trim_b[2] a_2208_22253# 0.03844f
C3412 a_1284_2799# d_dith_en 0.11059f
C3413 a_8013_14934# vdd 0.28492f
C3414 sg13cmos5l_nand2_1_2.Y xq_vg_q_2_ 0.84093f
C3415 inv_en_0.di inv_en_0.di_b 0.74281f
C3416 sg13cmos5l_nor2_1_0.Y sg13cmos5l_or2_1_0.X 0.16012f
C3417 sg13cmos5l_inv_1_9.Y d_phi1 0.01521f
C3418 quantizer2_lfsr_0.sg13cmos5l_dfrbpq_1_13.D a_1407_15314# 0.01122f
C3419 a_8880_5832# vdd 0.17483f
C3420 sg13cmos5l_inv_1_19.Y xq_vg_p_1_ 0.15158f
C3421 d_amp_s_b[1] d_dith[2] 0.03105f
C3422 dsm2_io_0.do_btest_en d_rst_b 0.04488f
C3423 dsm2_osc_0.sg13cmos5l_buf_2_0.A do_osc_oe 0.59377f
C3424 m2_10908_16863# do_q_b 0.04059f
C3425 sg13cmos5l_inv_1_6.Y sg13cmos5l_inv_1_2.A 0.0179f
C3426 sw_tgate_cmfb2_3.gb xsc_vc1r_n 0.06478f
C3427 sg13cmos5l_inv_1_5.Y vdd 0.37859f
C3428 sw_tgate_11.gb sw_tgate_cmfb2_1.gb 0.07462f
C3429 clk_noverlap_0.sg13cmos5l_dlygate4sd3_1_0.A d_qclk 0.34502f
C3430 sg13cmos5l_inv_1_17.Y sg13cmos5l_inv_1_14.A 0.02331f
C3431 xsc_vvg_n sw_tgate_11.gb 0.20149f
C3432 quantizer2_lfsr_0.sg13cmos5l_dfrbpq_1_0.Q d_dith[1] 0.03071f
C3433 sg13cmos5l_nand2_1_5.A sg13cmos5l_inv_1_16.A 0.48626f
C3434 dsm2_io_0.do_btest_en dsm2_io_0.sg13cmos5l_inv_1_4.A 0.01392f
C3435 a_14266_14856# vdd 0.25945f
C3436 dsm2_io_vcmg_0.di_vcm_ext_b quantizer2_lfsr_0.sg13cmos5l_dfrbpq_1_4.Q 0.0578f
C3437 di_vcm_ext d_amp_s_b[0] 0.01495f
C3438 sg13cmos5l_and2_1_5.X sg13cmos5l_nand2_2_0.B 0.02256f
C3439 sg13cmos5l_inv_1_4.Y sg13cmos5l_inv_1_13.Y 0.27963f
C3440 sg13cmos5l_inv_1_6.Y sg13cmos5l_inv_1_20.Y 1.09416f
C3441 a_24626_21160# a_24626_21020# 0.84953f
C3442 quantizer2_lfsr_0.sg13cmos5l_dfrbpq_1_2.D a_1284_16630# 0.13317f
C3443 quantizer2_lfsr_0.sg13cmos5l_dfrbpq_1_11.Q a_2049_2373# 0.03967f
C3444 sg13cmos5l_nor2_2_2.A do_q 0.10461f
C3445 a_533_2144# d_dith_en 0.30561f
C3446 dsm2_io_0.sg13cmos5l_inv_1_0.A vdd 0.30778f
C3447 quantizer2_lfsr_0.sg13cmos5l_dfrbpq_1_14.D d_qclk 0.01812f
C3448 sg13cmos5l_nand2_1_2.Y sg13cmos5l_inv_1_1.A 0.59745f
C3449 a_19964_18216# a_26670_16346# 0.05597f
C3450 a_13101_7164# clk_noverlap_0.sg13cmos5l_dlygate4sd3_1_7.X 0.30507f
C3451 a_20138_14766# m2_10908_16863# 0.01399f
C3452 sg13cmos5l_inv_1_13.Y sg13cmos5l_inv_1_17.A 0.05332f
C3453 d_dith_en d_qout_en 0.95026f
C3454 sg13cmos5l_inv_1_4.A a_11201_9808# 0.0756f
C3455 a_24626_23104# a_24626_22964# 0.53278f
C3456 do_q d_dith[0] 0.02214f
C3457 a_10483_7459# a_10291_7286# 0.01438f
C3458 quantizer2_lfsr_0.sg13cmos5l_dfrbpq_1_3.Q d_qclk 0.01556f
C3459 dsm2_io_vcmg_0.di_vcm_ext_b a_2070_12038# 0.01957f
C3460 a_1407_12722# a_1322_11954# 0.03546f
C3461 a_1284_13167# a_1324_11172# 0.01412f
C3462 a_24626_19760# bias_gm_0.bias_trim_0.vz 0.01806f
C3463 quantizer2_lfsr_0.sg13cmos5l_dfrbpq_1_1.D d_dith_en 1.29077f
C3464 a_5176_31469# vo_n 1.75329f
C3465 a_20138_14766# a_24214_15746# 0.07604f
C3466 a_4649_7224# d_phi1 0.01822f
C3467 sg13cmos5l_inv_1_17.A a_6874_14892# 0.01597f
C3468 a_2208_28397# a_2208_27629# 0.05462f
C3469 a_522_7538# d_dith_en 0.1175f
C3470 m2_10908_16863# m2_10908_16655# 0.07784f
C3471 sg13cmos5l_or2_1_0.X d_amp_s_b[2] 0.016f
C3472 a_567_13746# vdd 0.09469f
C3473 a_21276_2052# a_21830_2088# 0.0346f
C3474 dsm2_osc_0.dsm2_io_rx_1.di_b di_clk_sel 0.21498f
C3475 a_21498_769# vdd 0.23391f
C3476 a_28126_21020# a_28126_20740# 0.04477f
C3477 a_14829_7164# a_14548_7466# 0.18796f
C3478 a_13189_30111# xsc_vfb 0.17107f
C3479 a_21554_2798# a_22738_2088# 0.01118f
C3480 a_537_1221# d_dith_en 0.05975f
C3481 sg13cmos5l_inv_1_2.A vo_p 0.01478f
C3482 inv_en_0.di_b d_qi_b 0.165f
C3483 d_rst_b d_qout_en 0.57121f
C3484 xq_vg_q_2_ vdd 0.36147f
C3485 sg13cmos5l_nand2_1_2.Y sg13cmos5l_and2_1_5.B 0.17558f
C3486 sg13cmos5l_inv_1_9.Y d_phi2 0.01751f
C3487 a_22063_22964# a_22063_22824# 0.53278f
C3488 di_dith_en di_rst_b 0.11257f
C3489 sg13cmos5l_inv_1_20.Y vo_p 0.01802f
C3490 dsm2_io_vcmg_0.di_vcm_ext_b a_16941_5500# 0.20373f
C3491 quantizer2_lfsr_0.sg13cmos5l_dfrbpq_1_0.D quantizer2_lfsr_0.sg13cmos5l_dfrbpq_1_9.D 0.02902f
C3492 dsm2_osc_0.d_btest_or vi_esd 0.07069f
C3493 a_24626_19620# bias_gm_0.bias_trim_0.vz 0.02092f
C3494 dsm2_io_0.do_trim_b[1] a_22252_5274# 0.01183f
C3495 a_1324_3396# d_dith_en 0.30825f
C3496 sg13cmos5l_inv_1_6.Y xq_vg_q_1_ 0.07402f
C3497 a_20138_14766# a_22138_15446# 0.06025f
C3498 dsm2_osc_0.d_btest_or dsm2_osc_0.sg13cmos5l_dfrbp_1_0.Q_N 0.08907f
C3499 dsm2_io_0.do_trim_b[1] a_22252_8246# 0.03535f
C3500 a_2034_14421# vdd 0.27707f
C3501 xq_dith_v_bq d_amp_s[3] 0.09275f
C3502 a_20672_20740# a_20758_20880# 0.01899f
C3503 dsm2_osc_0.sg13cmos5l_dfrbp_1_0.RESET_B a_21681_1704# 0.24295f
C3504 sg13cmos5l_inv_1_16.Y xq_vg_q_2_ 0.23557f
C3505 a_558_518# d_dith_en 0.12039f
C3506 sg13cmos5l_inv_1_1.A vdd 0.19744f
C3507 a_1284_10575# vdd 0.17136f
C3508 a_11115_8888# a_11201_8888# 0.01899f
C3509 a_2045_8480# a_2049_7557# 0.36374f
C3510 clk_noverlap_0.sg13cmos5l_dlygate4sd3_1_0.A a_6859_7241# 0.03228f
C3511 a_27029_22964# a_27029_22824# 0.4505f
C3512 a_8392_5586# a_8768_5586# 0.05762f
C3513 a_2034_6645# d_dith_en 0.01965f
C3514 sg13cmos5l_inv_1_4.A sg13cmos5l_or2_1_0.X 0.08346f
C3515 dsm2_io_vcmg_0.di_vcm_ext_b a_13960_5586# 0.01736f
C3516 xsc_vc1r_n d_phi1 0.4585f
C3517 a_12424_5586# m2_10908_16863# 0.02098f
C3518 a_2208_27629# dsm2_io_0.do_trim_b[0] 0.0168f
C3519 sg13cmos5l_inv_1_4.Y sg13cmos5l_inv_1_14.A 0.02236f
C3520 clk_noverlap_0.sg13cmos5l_nor3_1_0.C vdd 0.36183f
C3521 sg13cmos5l_inv_1_3.A xq_vg_p_1_ 0.08787f
C3522 clk_noverlap_0.di_clk do_q 0.10659f
C3523 sg13cmos5l_inv_1_17.Y a_11201_9948# 0.02387f
C3524 sg13cmos5l_and2_1_2.X vdd 0.31083f
C3525 quantizer2_lfsr_0.sg13cmos5l_dfrbpq_1_11.Q vdd 0.48626f
C3526 sg13cmos5l_inv_1_16.Y sg13cmos5l_inv_1_1.A 0.01072f
C3527 sg13cmos5l_inv_1_17.A sg13cmos5l_inv_1_14.A 0.20982f
C3528 a_22000_594# vdd 0.13235f
C3529 sg13cmos5l_or2_1_0.X sg13cmos5l_inv_1_9.Y 0.2838f
C3530 sg13cmos5l_nand2_1_5.A sg13cmos5l_inv_1_15.Y 0.16067f
C3531 sg13cmos5l_nor2_1_0.Y d_ena 0.05642f
C3532 a_19964_18216# a_26670_14846# 0.06417f
C3533 sg13cmos5l_and2_1_5.X sg13cmos5l_nand2_1_2.Y 0.01409f
C3534 xq_vg_q_1_ vo_p 1.17321f
C3535 a_2208_18597# vdd 0.08048f
C3536 a_533_9920# vdd 0.20451f
C3537 a_13965_7164# d_phi2 0.05799f
C3538 sg13cmos5l_inv_1_16.Y a_11201_9028# 0.0123f
C3539 a_24626_22824# a_24626_22684# 0.53278f
C3540 xsc_vc1r_n vcm_esd 0.47465f
C3541 sg13cmos5l_and2_1_5.B vdd 0.52975f
C3542 a_2208_30701# a_2208_29933# 0.05462f
C3543 sg13cmos5l_or2_1_0.X sg13cmos5l_and2_2_1.X 0.05942f
C3544 sg13cmos5l_nand2_2_0.B sg13cmos5l_and2_1_5.A 0.06129f
C3545 quantizer2_lfsr_0.di_dith_amp[0] d_amp_s[0] 0.26595f
C3546 quantizer2_lfsr_0.sg13cmos5l_dfrbpq_1_2.Q a_2034_3336# 0.01053f
C3547 a_537_11589# a_567_11154# 0.02241f
C3548 a_2208_23021# vdd 0.53621f
C3549 a_522_9960# a_571_8868# 0.24435f
C3550 xq_vg_p_0_ a_11201_9808# 0.1017f
C3552 do_q do_q_dec 0.01753f
C3553 sg13cmos5l_or2_1_0.X sg13cmos5l_inv_1_2.Y 0.05988f
C3554 vo_p d_amp_s_b[3] 0.14647f
C3555 dsm2_io_vcmg_0.di_vcm_ext d_dith[1] 0.02404f
C3556 a_1284_13269# vdd 0.27797f
C3557 dsm2_osc_0.sg13cmos5l_dfrbp_1_0.RESET_B a_21617_558# 0.11398f
C3558 a_24258_20600# a_24540_20600# 0.04564f
C3559 a_23289_752# vdd 0.10597f
C3560 sg13cmos5l_inv_1_6.Y vo_n 0.01464f
C3561 sg13cmos5l_nand2_1_5.A sg13cmos5l_inv_1_17.A 0.33387f
C3562 a_1284_16630# quantizer2_lfsr_0.sg13cmos5l_dfrbpq_1_13.D 0.09293f
C3563 dsm2_io_vcmg_0.di_vcm_ext_b dsm2_io_vcmg_0.di_phi1_b 0.02273f
C3564 sw_tgate_cmfb2_1.p xsc_vfb 5.18204f
C3565 a_537_8997# vdd 0.23809f
C3566 dsm2_osc_0.ibias_in a_22368_558# 0.01581f
C3567 a_19000_826# vdd 0.07089f
C3568 a_20758_20740# d_ena 0.01376f
C3569 a_11656_5586# a_12424_5586# 0.05462f
C3570 a_22063_22684# a_20758_22420# 0.2552f
C3571 a_533_7328# a_571_6276# 0.07823f
C3572 a_522_7368# a_558_5702# 0.26205f
C3573 a_6817_30111# a_5176_31469# 0.26206f
C3574 quantizer2_lfsr_0.sg13cmos5l_dfrbpq_1_8.D d_dith_en 0.3167f
C3575 a_12820_7466# vdd 0.20754f
C3576 dsm2_osc_0.ibias_in dsm2_osc_0.ibias_pad 0.4043f
C3577 xsc_vc1r_n d_phi2 0.49337f
C3578 a_10132_15186# d_qi_b 0.20889f
C3579 a_558_10886# a_567_11154# 0.45119f
C3580 a_1286_12023# a_1600_11717# 0.01562f
C3581 d_dith[0] d_dith[2] 0.17763f
C3582 a_2034_5928# d_qclk 0.10877f
C3583 sg13cmos5l_nor2_1_0.Y a_8208_15626# 0.03175f
C3584 a_19964_18216# a_19904_17646# 1.49846f
C3585 d_ena d_amp_s_b[2] 0.01928f
C3586 a_533_7328# d_dith_en 0.30423f
C3587 dsm2_io_0.dsm2_io_rx_9.di_b dsm2_io_0.do_trim_b[0] 0.06211f
C3588 a_1407_12722# vdd 0.13586f
C3589 vdd d_amp_s[1] 0.8334f
C3590 a_24540_20600# a_24626_20600# 0.01899f
C3591 dsm2_osc_0.ibias_pad vcm_esd 0.11148f
C3592 xvcm_vcf_b di_osc_en 0.05508f
C3593 a_24712_874# vdd 0.01151f
C3594 sg13cmos5l_nor2_2_0.B d_qi_b 0.24546f
C3595 dsm2_osc_0.sg13cmos5l_dfrbp_1_0.RESET_B dsm2_osc_0.sg13cmos5l_dfrbp_1_0.CLK 0.50843f
C3596 sg13cmos5l_and2_1_5.X vdd 0.48498f
C3597 a_2070_11214# a_2049_10149# 0.01058f
C3598 a_20758_20600# d_ena 0.01376f
C3599 sg13cmos5l_inv_1_16.A sg13cmos5l_inv_1_18.Y 0.03991f
C3600 a_2049_4965# a_2079_4530# 0.02241f
C3601 a_537_6405# a_571_6276# 0.01562f
C3602 quantizer2_lfsr_0.sg13cmos5l_dfrbpq_1_11.D quantizer2_lfsr_0.sg13cmos5l_dfrbpq_1_7.D 0.02548f
C3603 a_5176_31117# a_5176_30111# 0.6865f
C3604 a_6638_31505# a_7224_31505# 0.01127f
C3605 a_12445_30191# a_8762_31505# 0.05103f
C3606 a_5176_31469# a_9348_31505# 1.17341f
C3607 a_20070_16046# vdd 0.19604f
C3608 dsm2_io_0.do_trim_b[1] a_2208_22253# 0.07941f
C3609 sg13cmos5l_inv_2_4.Y inv_en_0.di_b 0.06265f
C3610 vo_p vo_n 2.13117f
C3611 sg13cmos5l_inv_1_13.A xq_vg_q_2_ 0.08706f
C3612 a_1324_8580# a_1600_9125# 0.24435f
C3613 clk_noverlap_0.sg13cmos5l_dlygate4sd3_1_0.A clk_noverlap_0.sg13cmos5l_dlygate4sd3_1_0.X 0.04002f
C3614 sg13cmos5l_inv_1_8.Y sg13cmos5l_or2_1_0.X 0.01896f
C3615 dsm2_io_vcmg_0.di_vcm_ext_b d_phi1 0.0313f
C3616 sg13cmos5l_or2_1_0.X xq_vg_p_0_ 0.0871f
C3617 sg13cmos5l_inv_1_3.Y xq_vg_p_1_ 0.48635f
C3618 a_522_5493# vdd 0.27678f
C3619 a_537_6405# d_dith_en 0.05909f
C3620 clk_noverlap_0.sg13cmos5l_inv_1_5.Y vdd 0.22087f
C3621 a_24626_20600# a_28126_20460# 0.01899f
C3622 quantizer2_lfsr_0.di_dith_amp[1] a_1284_15861# 0.06317f
C3623 dsm2_osc_0.sg13cmos5l_dfrbp_1_0.RESET_B a_22347_812# 0.3184f
C3624 a_2208_31469# dsm2_io_0.do_trim_b[0] 0.0168f
C3625 d_amp_s_b[0] d_amp_s[1] 0.14538f
C3626 d_amp_s[0] d_amp_s_b[1] 0.56367f
C3627 dsm2_osc_0.dsm2_io_rx_1.di_b dsm2_osc_0.sg13cmos5l_mux2_1_0.A1 0.0327f
C3628 quantizer2_lfsr_0.sg13cmos5l_dfrbpq_1_14.D a_1284_10677# 0.11353f
C3629 a_19999_22824# vdd 0.01432f
C3630 sg13cmos5l_inv_1_4.A d_ena 0.25008f
C3631 a_22252_4374# a_22252_5274# 0.10061f
C3632 quantizer2_lfsr_0.sg13cmos5l_dfrbpq_1_2.D a_1690_16373# 0.02504f
C3633 sg13cmos5l_inv_1_17.Y sg13cmos5l_inv_1_18.Y 0.34222f
C3634 a_17025_7467# d_phi2 0.06864f
C3635 a_16648_5586# a_16832_5586# 0.05762f
C3636 a_1284_5391# a_1322_4178# 0.17382f
C3637 sg13cmos5l_and2_1_5.X sg13cmos5l_inv_1_10.Y 0.03318f
C3638 sg13cmos5l_inv_1_19.Y sg13cmos5l_nand2_1_2.Y 0.02762f
C3639 a_1324_5988# a_1367_6533# 0.26205f
C3640 a_26670_16046# vdd 0.0172f
C3641 dsm2_io_vcmg_0.di_phi1_b clk_noverlap_0.sg13cmos5l_inv_1_3.Y 0.10063f
C3642 sg13cmos5l_inv_1_13.A sg13cmos5l_inv_1_1.A 0.55193f
C3643 sg13cmos5l_inv_1_13.Y sg13cmos5l_inv_2_0.Y 0.11088f
C3644 a_2034_11829# a_2034_11446# 0.09257f
C3645 a_6757_9948# a_6757_9808# 0.97089f
C3646 dsm2_io_vcmg_0.di_vcm_ext_b vcm_esd 0.04587f
C3647 dsm2_io_vcmg_0.di_vcm_ext quantizer2_lfsr_0.sg13cmos5l_dfrbpq_1_14.D 0.0305f
C3648 d_dith_en d_qi_b 0.53298f
C3649 clk_noverlap_0.sg13cmos5l_inv_1_0.A d_phi1 0.03083f
C3650 sg13cmos5l_nand2_1_2.Y sg13cmos5l_and2_1_5.A 0.17382f
C3651 a_26284_874# vcm 0.0676f
C3652 quantizer2_lfsr_0.sg13cmos5l_dfrbpq_1_11.D vdd 1.33987f
C3653 a_8974_5832# vdd 0.01285f
C3654 a_28126_20460# a_24626_20460# 0.01899f
C3655 a_20672_20460# a_20672_20180# 0.04477f
C3656 m2_10908_16863# d_dith[0] 0.03659f
C3657 bias_gm_0.bias_trim_0.vz bias_gm_0.bias_trim_0.iout 0.6244f
C3658 a_22252_11246# dsm2_osc_0.d_btest_or 0.09538f
C3659 quantizer2_lfsr_0.sg13cmos5l_dfrbpq_1_13.Q a_1284_15861# 0.07813f
C3660 dsm2_osc_0.sg13cmos5l_inv_1_3.A dsm2_osc_0.ibias_pad 0.02273f
C3661 bias_gm_0.bias_trim_0.vz a_22252_7946# 10.4292f
C3662 xsc_vfb sw_tgate_cmfb2_1.gb 0.05318f
C3663 a_23674_2578# a_23674_2344# 0.01088f
C3664 a_2045_8480# a_2070_6854# 0.07916f
C3665 a_2034_8520# a_2079_7122# 0.24169f
C3666 a_2208_29165# vdd 0.57974f
C3667 a_15412_7466# d_phi2 0.05166f
C3668 a_15693_7164# a_15412_7466# 0.18796f
C3669 xsc_vfb xsc_vvg_n 1.19195f
C3670 clk_noverlap_0.sg13cmos5l_dlygate4sd3_1_0.A a_7993_7200# 0.03553f
C3671 a_24602_15146# vdd 0.12429f
C3672 d_rst_b d_qi_b 0.03225f
C3673 a_10120_5586# d_phi1 0.02214f
C3674 quantizer2_lfsr_0.sg13cmos5l_dfrbpq_1_4.Q a_2034_9237# 0.10437f
C3675 a_22252_7946# a_24404_8546# 0.12299f
C3676 dsm2_io_vcmg_0.di_vcm_ext_b d_phi2 0.12905f
C3677 a_13192_5586# vdd 0.52829f
C3678 sg13cmos5l_inv_1_13.A sg13cmos5l_and2_1_5.B 0.02093f
C3679 a_522_15314# d_dith_en 0.10549f
C3680 do_q_dec d_dith[2] 3.56793f
C3681 clk_noverlap_0.di_clk d_vcm_phi1_b 0.04742f
C3682 quantizer2_lfsr_0.di_dith_amp[0] a_1407_15314# 0.03451f
C3683 a_20758_20460# a_20758_20320# 0.84953f
C3684 dsm2_io_0.do_trim_b[0] a_24404_4674# 0.05752f
C3685 a_2208_28397# vdd 0.56337f
C3686 a_2045_3296# d_qclk 0.02918f
C3687 dsm2_osc_0.dsm2_io_rx_0.di_b dsm2_osc_0.sg13cmos5l_dfrbp_1_0.CLK 0.09494f
C3688 a_522_2518# vdd 0.17136f
C3689 a_8762_31505# vdd 0.51181f
C3690 a_22252_11246# a_24626_21720# 0.01626f
C3691 a_522_4776# a_533_4736# 0.20759f
C3692 a_28334_22280# a_28334_22140# 0.1335f
C3693 sg13cmos5l_inv_1_19.Y vdd 3.91804f
C3694 a_24214_14546# vdd 0.14056f
C3695 dsm2_osc_0.sg13cmos5l_dfrbp_1_0.RESET_B do_clk_osc 0.32289f
C3696 sg13cmos5l_nor2_2_0.Y do_q_b 0.03138f
C3697 clk_noverlap_0.sg13cmos5l_dlygate4sd3_1_0.A a_8105_7224# 0.02784f
C3698 sg13cmos5l_and2_1_5.A vdd 0.9168f
C3699 a_11201_8468# d_amp_s_b[1] 0.04069f
C3700 a_2034_8520# d_qclk 0.10692f
C3701 d_dith[2] d_qclk 0.03393f
C3702 a_2208_25325# dsm2_io_0.do_trim_b[0] 0.0168f
C3703 a_2208_24557# a_2208_23789# 0.05462f
C3704 sg13cmos5l_inv_1_6.A sg13cmos5l_or2_1_0.X 0.09828f
C3705 a_28334_20460# a_28334_20320# 0.1335f
C3706 a_24258_20320# a_24258_20040# 0.04477f
C3707 d_amp_s[2] d_dith[2] 0.02951f
C3708 dsm2_osc_0.sg13cmos5l_mux2_1_0.A1 dsm2_osc_0.sg13cmos5l_buf_2_0.A 0.1436f
C3709 d_phi1 d_qi 0.26426f
C3710 a_24626_22280# dsm2_osc_0.d_btest_or 0.01657f
C3711 a_2049_12741# d_qclk 0.22054f
C3712 sg13cmos5l_inv_1_16.A a_6757_9808# 0.01039f
C3713 sg13cmos5l_inv_1_9.Y sg13cmos5l_inv_1_13.Y 0.08592f
C3714 a_533_2144# a_537_1221# 0.36374f
C3715 a_2070_1670# a_2079_1938# 0.45119f
C3716 sg13cmos5l_nand2_1_5.A sg13cmos5l_nor2_1_0.Y 0.17968f
C3717 clk_noverlap_0.sg13cmos5l_inv_1_10.A vdd 0.28145f
C3718 sg13cmos5l_inv_1_19.Y sg13cmos5l_inv_1_16.Y 0.40812f
C3719 sg13cmos5l_inv_1_4.Y sg13cmos5l_inv_1_18.Y 0.19108f
C3720 xvcm_vcf_b d_vcm_phi2 0.11043f
C3721 a_6817_30111# vo_p 0.75952f
C3722 vcm ibias_test 0.10822f
C3723 a_558_4878# a_537_3813# 0.01058f
C3724 a_22252_11246# a_24626_21580# 0.01617f
C3725 clk_noverlap_0.di_clk m2_10908_16863# 4.83049f
C3726 a_23328_9146# vdd 0.08846f
C3727 a_22252_5274# dsm2_osc_0.ibias_in 0.0352f
C3728 a_24404_4674# a_23328_5574# 0.03582f
C3729 a_522_15144# d_dith_en 0.30845f
C3730 sg13cmos5l_inv_1_9.Y a_13985_15078# 0.01118f
C3731 sg13cmos5l_inv_1_17.A sg13cmos5l_inv_1_18.Y 0.05322f
C3732 sg13cmos5l_or2_1_0.X sg13cmos5l_inv_1_12.A 0.04097f
C3733 sg13cmos5l_inv_1_3.A sg13cmos5l_nand2_1_2.Y 0.0953f
C3734 clk_noverlap_0.sg13cmos5l_dlygate4sd3_1_9.A d_phi2 0.06915f
C3735 vdd di_dith_amp[0] 0.50853f
C3736 sg13cmos5l_inv_1_13.Y sg13cmos5l_and2_2_1.X 0.02753f
C3737 a_522_7702# a_1284_7983# 0.01202f
C3738 d_qclk d_vcm_phi1_b 0.01139f
C3739 quantizer2_lfsr_0.sg13cmos5l_dfrbpq_1_5.Q d_qclk 0.26314f
C3740 sg13cmos5l_inv_1_20.Y sg13cmos5l_inv_1_2.A 0.01721f
C3741 di_rst_b di_qout_en 0.11625f
C3742 dsm2_io_vcmg_0.di_vcm_ext_b di_clk_sel 0.60212f
C3743 a_1284_8085# vdd 0.28419f
C3744 dsm2_io_0.do_trim_b[0] vdd 12.3899f
C3745 a_12237_7164# vdd 0.26113f
C3746 a_24626_22140# dsm2_osc_0.d_btest_or 0.01657f
C3747 sw_tgate_cmfb2_3.gb vo_p 0.41667f
C3748 dsm2_io_vcmg_0.di_vcm_ext a_2208_17741# 0.02211f
C3749 inv_en_0.di_b sg13cmos5l_and2_1_5.B 0.11929f
C3750 a_522_2184# a_567_786# 0.24169f
C3751 a_1322_1586# a_1324_804# 0.20759f
C3752 a_533_2144# a_558_518# 0.07916f
C3753 a_9348_31505# vo_p 0.43723f
C3754 a_20000_22000# a_20000_21860# 0.1335f
C3755 a_24540_22000# a_24540_21720# 0.04477f
C3756 dsm2_io_0.sg13cmos5l_inv_1_6.A di_osc_en 0.01596f
C3757 clk_noverlap_0.sg13cmos5l_inv_1_1.A vdd 0.28145f
C3758 a_6757_9948# d_qclk 0.09615f
C3759 quantizer2_lfsr_0.sg13cmos5l_dfrbpq_1_13.Q a_1320_16467# 0.01147f
C3760 a_1690_16373# quantizer2_lfsr_0.sg13cmos5l_dfrbpq_1_13.D 0.01217f
C3761 a_11201_8888# a_13211_8748# 0.01899f
C3762 a_15496_5586# d_phi2 0.01579f
C3763 a_1322_4178# vdd 0.20468f
C3764 quantizer2_lfsr_0.sg13cmos5l_dfrbpq_1_2.D a_1367_11717# 0.02573f
C3765 a_6884_8680# vdd 0.18256f
C3766 a_20000_20180# a_20000_20040# 0.1335f
C3768 a_8747_8608# d_amp_s[0] 0.01295f
C3769 dsm2_osc_0.sg13cmos5l_buf_2_0.A a_20770_598# 0.15588f
C3770 dsm2_osc_0.d_btest_or vdd 6.41853f
C3771 a_10483_7459# d_qclk 0.12833f
C3772 sg13cmos5l_inv_1_0.Y a_13870_15077# 0.053f
C3773 a_533_12512# d_qclk 0.03807f
C3774 d_phi2 d_qi 0.25327f
C3775 a_537_1221# a_558_518# 0.02431f
C3776 m2_10908_16863# d_qclk 0.05521f
C3777 d_amp_s[0] d_dith[0] 0.01658f
C3778 a_19576_826# di_clk 0.02812f
C3779 a_21252_3394# a_23328_9146# 0.03532f
C3780 vi_esd do_q 0.04706f
C3781 a_1681_4561# a_1286_4247# 0.01058f
C3782 xsc_xcmfb1_vsw_cm_p xsc_vc1r_p 0.01509f
C3783 a_24626_22000# a_24626_21860# 0.84953f
C3784 a_2070_4262# quantizer2_lfsr_0.sg13cmos5l_dfrbpq_1_2.Q 0.19588f
C3785 sw_tgate_11.gb xsc_vc1r_n 0.36144f
C3786 a_8013_14934# d_dith_en 0.03348f
C3787 xsc_vfb xsc_xcmfb1_vsw_vbias 6.90948f
C3788 a_23328_5574# vdd 0.08846f
C3789 xvcm_vcf_t d_vcm_phi1_b 0.22283f
C3790 sg13cmos5l_inv_1_6.Y d_phi1 0.418f
C3791 quantizer2_lfsr_0.sg13cmos5l_dfrbpq_1_0.Q d_dith[2] 0.01382f
C3792 a_567_8562# vdd 0.09469f
C3793 dsm2_osc_0.dsm2_io_rx_0.di_b do_clk_osc 0.06095f
C3794 a_2070_9446# d_ena 0.01015f
C3795 sg13cmos5l_inv_1_3.A vdd 0.60961f
C3796 sg13cmos5l_inv_1_16.Y a_6884_8680# 0.08702f
C3797 clk_noverlap_0.sg13cmos5l_dlygate4sd3_1_3.X a_7723_7241# 0.30507f
C3798 quantizer2_lfsr_0.sg13cmos5l_dfrbpq_1_2.Q vdd 0.6849f
C3799 xq_vg_p_1_ do_q 0.05832f
C3800 sg13cmos5l_inv_2_0.Y do_q_b 0.03193f
C3801 sg13cmos5l_inv_1_13.Y xq_vg_p_0_ 0.13779f
C3802 sg13cmos5l_inv_1_20.Y xq_vg_q_1_ 0.03393f
C3803 dsm2_io_0.do_trim_b[0] a_21252_3394# 0.11758f
C3804 dsm2_io_0.do_trim_b[1] dsm2_io_0.do_trim_b[2] 22.1651f
C3805 dsm2_io_0.do_trim_b[0] dsm2_io_0.do_trim_b[3] 9.17013f
C3806 quantizer2_lfsr_0.di_dith_amp[0] d_amp_s_b[2] 0.03905f
C3807 sg13cmos5l_inv_2_4.Y d_rst_b 0.02199f
C3808 sg13cmos5l_and2_1_5.X inv_en_0.di_b 0.19823f
C3809 a_24626_20180# a_24626_20040# 0.84953f
C3810 a_571_8868# a_558_8294# 0.18486f
C3811 xq_vg_p_0_ a_12395_9628# 0.01203f
C3812 a_8747_8328# d_amp_s[0] 0.04677f
C3813 sg13cmos5l_inv_1_4.Y a_7437_15998# 0.08261f
C3814 a_537_11589# d_qclk 0.21592f
C3815 a_6884_8680# d_amp_s_b[0] 0.01595f
C3816 a_1367_1349# vdd 0.53335f
C3817 a_1324_804# a_1288_778# 0.24169f
C3818 dsm2_io_0.sg13cmos5l_inv_1_0.A d_dith_en 0.06642f
C3819 sg13cmos5l_inv_1_14.A sg13cmos5l_and2_2_1.X 0.33676f
C3820 a_28126_21860# a_28126_21580# 0.04477f
C3821 sg13cmos5l_inv_1_20.Y d_amp_s_b[3] 0.03076f
C3822 dsm2_io_0.sg13cmos5l_inv_1_0.A a_2208_19557# 0.02353f
C3823 sg13cmos5l_nand2_1_5.A sg13cmos5l_inv_1_4.A 0.41882f
C3824 sg13cmos5l_inv_1_3.A sg13cmos5l_inv_1_16.Y 0.14788f
C3825 a_10787_14878# sg13cmos5l_nor2_2_2.A 0.01524f
C3826 clk_noverlap_0.sg13cmos5l_inv_1_11.Y vdd 0.52663f
C3827 a_5995_7241# vdd 0.2609f
C3828 a_1284_8085# a_1407_7538# 0.07015f
C3829 a_11201_8748# a_11201_8608# 0.48787f
C3830 a_8661_8468# a_8747_8608# 0.01899f
C3831 sg13cmos5l_inv_1_3.Y sg13cmos5l_nand2_1_2.Y 0.41124f
C3832 sg13cmos5l_and2_1_5.X a_15491_15614# 0.02183f
C3833 clk_noverlap_0.sg13cmos5l_dlygate4sd3_1_12.A a_17025_7467# 0.12324f
C3834 clk_noverlap_0.sg13cmos5l_inv_1_1.Y clk_noverlap_0.di_clk 0.02345f
C3835 sg13cmos5l_inv_1_6.A d_ena 0.02165f
C3836 sg13cmos5l_or2_1_0.X d_qi 0.10485f
C3837 sg13cmos5l_or2_1_0.X sg13cmos5l_inv_1_12.Y 0.02982f
C3838 sg13cmos5l_inv_1_19.Y sg13cmos5l_inv_1_13.A 0.02458f
C3839 quantizer2_lfsr_0.sg13cmos5l_dfrbpq_1_2.D a_1284_7983# 0.013f
C3840 sg13cmos5l_inv_1_3.A d_amp_s_b[0] 0.03252f
C3841 quantizer2_lfsr_0.sg13cmos5l_dfrbpq_1_2.D a_1286_14615# 0.01108f
C3842 xvcm_vcf_t m2_10908_16863# 0.02314f
C3843 dsm2_io_0.do_trim_b[3] dsm2_osc_0.d_btest_or 0.54719f
C3844 a_2070_4262# d_dith[1] 0.01012f
C3845 dsm2_osc_0.d_btest_or a_21252_3394# 0.36372f
C3846 quantizer2_lfsr_0.sg13cmos5l_nor2_1_1.B quantizer2_lfsr_0.sg13cmos5l_dfrbpq_1_2.D 0.0365f
C3847 sg13cmos5l_nand2_1_5.A sg13cmos5l_inv_1_9.Y 0.32019f
C3848 a_20672_19900# a_20758_19900# 0.01899f
C3849 vo_p d_phi1 0.45751f
C3850 sg13cmos5l_inv_1_16.A d_qclk 0.02815f
C3851 quantizer2_lfsr_0.sg13cmos5l_dfrbpq_1_0.D quantizer2_lfsr_0.sg13cmos5l_dfrbpq_1_5.Q 0.05586f
C3852 quantizer2_lfsr_0.sg13cmos5l_dfrbpq_1_0.D a_2074_14933# 0.0409f
C3853 a_20770_598# a_20947_892# 0.01068f
C3854 quantizer2_lfsr_0.sg13cmos5l_dfrbpq_1_2.D a_1324_804# 0.02422f
C3855 a_15297_7467# vdd 0.15875f
C3856 inv_en_0.di d_qout_en 0.04048f
C3857 a_22386_2578# vdd 0.10536f
C3858 a_567_13746# d_dith_en 0.20929f
C3859 sg13cmos5l_inv_1_13.A sg13cmos5l_and2_1_5.A 0.04788f
C3860 a_11201_8608# d_amp_s_b[0] 0.02031f
C3861 dsm2_io_vcmg_0.di_vcm_ext_b d_ena 0.02252f
C3863 dsm2_io_0.do_btest_en d_qi_b 0.09336f
C3864 a_10757_9168# a_11115_9168# 0.03425f
C3865 a_21252_3394# a_23328_5574# 0.03532f
C3866 vdd d_dith[1] 1.04418f
C3867 sg13cmos5l_inv_1_14.A a_13088_15020# 0.01901f
C3868 a_20672_21580# a_20758_21720# 0.01899f
C3869 sg13cmos5l_inv_1_17.A a_6757_9808# 0.01329f
C3870 a_5176_31469# ibias_200n 0.82486f
C3871 vi ibias_test 0.45453f
C3872 a_2049_10149# a_1284_10575# 0.02017f
C3873 a_522_10677# a_522_10130# 0.07015f
C3874 xq_vg_q_2_ xq_vg_q_0_ 0.13401f
C3875 a_522_7538# a_533_7328# 0.03546f
C3876 a_2049_7557# a_2079_7122# 0.02241f
C3877 clk_noverlap_0.sg13cmos5l_dlygate4sd3_1_0.A clk_noverlap_0.sg13cmos5l_inv_1_6.A 0.0416f
C3878 a_16557_7164# a_16276_7466# 0.18796f
C3879 clk_noverlap_0.sg13cmos5l_inv_1_1.A a_10096_6736# 0.02677f
C3880 a_1284_15861# vdd 0.27818f
C3881 sg13cmos5l_inv_1_2.A vo_n 0.07751f
C3882 dsm2_osc_0.sg13cmos5l_dfrbp_1_0.RESET_B do_osc_oe 0.33612f
C3883 vo_p vcm_esd 0.42056f
C3884 a_2034_11446# a_2045_11072# 0.17382f
C3885 vdd di_btest_en 0.4952f
C3886 dsm2_osc_0.d_btest_or a_21276_2052# 0.19268f
C3887 a_20758_19900# a_24258_19760# 0.01899f
C3888 a_1367_14309# a_1288_13738# 0.45119f
C3889 xq_vg_p_0_ a_11201_9308# 0.01138f
C3890 sg13cmos5l_inv_1_17.Y d_qclk 0.08355f
C3891 sg13cmos5l_nor2_2_0.B sg13cmos5l_and2_1_5.B 0.22846f
C3892 a_22644_2344# vdd 0.25011f
C3893 dsm2_io_vcmg_0.di_vcm_ext_b di_osc_en 0.0615f
C3894 sg13cmos5l_inv_1_20.Y vo_n 0.01802f
C3895 clk_noverlap_0.sg13cmos5l_inv_1_0.A d_ena 0.33019f
C3896 a_10757_9168# a_10757_8888# 0.04477f
C3897 sg13cmos5l_inv_1_4.A a_11201_9948# 0.12506f
C3898 quantizer2_lfsr_0.sg13cmos5l_dfrbpq_1_0.D a_533_12512# 0.01367f
C3899 sg13cmos5l_nand2_1_5.A a_15130_14856# 0.06675f
C3900 dsm2_osc_0.ibias_in dsm2_osc_0.sg13cmos5l_dfrbp_1_0.RESET_B 0.49369f
C3901 sg13cmos5l_inv_1_9.Y do_q_b 0.05753f
C3902 quantizer2_lfsr_0.sg13cmos5l_dfrbpq_1_9.D vdd 0.32282f
C3903 sg13cmos5l_inv_1_3.Y a_8747_8888# 0.01149f
C3904 a_1284_10575# d_dith_en 0.11117f
C3905 sg13cmos5l_and2_1_5.B a_14849_15078# 0.01128f
C3906 d_amp_s[0] do_q_dec 0.01664f
C3907 d_amp_s_b[0] d_dith[1] 0.05396f
C3908 d_amp_s_b[1] d_amp_s_b[2] 1.22692f
C3909 xsc_vc1l_p d_qi 0.07196f
C3910 a_522_10294# a_558_10062# 0.16704f
C3911 xq_vg_p_1_ xq_vg_p_2_ 0.34912f
C3912 a_1284_7983# a_1322_6770# 0.17382f
C3913 a_11115_8328# a_11201_8328# 0.01899f
C3914 a_12424_5586# xvcm_vcf_b 0.01279f
C3915 a_11656_5586# xvcm_vcf_t 0.0129f
C3916 di_ena di_trim[0] 0.11257f
C3917 sg13cmos5l_inv_1_3.Y vdd 2.11133f
C3918 a_2208_32237# d_ena 0.0306f
C3919 sg13cmos5l_and2_2_1.X do_q_b 0.02746f
C3920 dsm2_osc_0.sg13cmos5l_dfrbp_1_0.RESET_B vcm_esd 0.07798f
C3921 quantizer2_lfsr_0.sg13cmos5l_dfrbpq_1_7.D quantizer2_lfsr_0.sg13cmos5l_dfrbpq_1_14.D 0.01293f
C3922 a_24258_19760# a_20758_19760# 0.01899f
C3923 a_522_4776# d_qclk 0.04965f
C3924 d_qout_en d_qi_b 0.13685f
C3925 sg13cmos5l_inv_1_6.A sg13cmos5l_inv_1_13.Y 0.08952f
C3926 vo_p d_phi2 0.0208f
C3927 clk_noverlap_0.sg13cmos5l_dlygate4sd3_1_0.A clk_noverlap_0.sg13cmos5l_dlygate4sd3_1_4.X 0.03803f
C3928 a_2049_7557# d_qclk 0.22659f
C3929 a_21617_558# a_22347_812# 0.17382f
C3930 sg13cmos5l_inv_1_6.Y sg13cmos5l_or2_1_0.X 0.15349f
C3931 sg13cmos5l_inv_1_19.Y inv_en_0.di_b 0.03772f
C3932 quantizer2_lfsr_0.sg13cmos5l_dfrbpq_1_11.Q d_dith_en 0.50615f
C3933 a_2208_26093# dsm2_io_0.do_trim_b[0] 0.01421f
C3934 a_8747_9028# a_10757_8888# 0.01899f
C3935 a_11201_9168# a_11201_9028# 0.48787f
C3936 dsm2_io_vcmg_0.di_vcm_ext a_2034_8520# 0.01554f
C3937 quantizer2_lfsr_0.sg13cmos5l_dfrbpq_1_0.D a_537_11589# 0.01101f
C3938 a_24258_21440# a_24540_21440# 0.04564f
C3939 a_2070_6030# a_2049_4965# 0.01058f
C3940 dsm2_io_vcmg_0.di_vcm_ext d_dith[2] 0.05046f
C3941 a_2070_1670# d_qclk 0.03459f
C3942 sg13cmos5l_inv_1_3.Y a_11201_8748# 0.01451f
C3943 a_533_9920# d_dith_en 0.30432f
C3944 d_amp_s[0] d_qclk 0.01356f
C3945 sg13cmos5l_nand2_2_0.B do_q 0.06275f
C3946 sg13cmos5l_inv_1_3.Y sg13cmos5l_inv_1_16.Y 0.02751f
C3947 inv_en_0.di_b sg13cmos5l_and2_1_5.A 0.08369f
C3948 dsm2_io_0.sg13cmos5l_inv_1_6.A a_2208_18981# 0.02387f
C3949 sg13cmos5l_nand2_1_5.A sg13cmos5l_inv_1_8.Y 0.14663f
C3950 a_1284_10575# a_1407_10130# 0.23043f
C3951 d_amp_s[0] d_amp_s[2] 0.38049f
C3952 d_amp_s[1] d_amp_s[3] 3.09933f
C3953 sg13cmos5l_and2_1_5.B d_dith_en 0.22706f
C3954 a_522_4776# a_567_3378# 0.24169f
C3955 a_533_4736# a_558_3110# 0.07916f
C3956 a_537_14181# a_558_13478# 0.02431f
C3957 clk_noverlap_0.sg13cmos5l_inv_1_3.Y d_ena 0.0441f
C3958 a_5176_31469# d_ena 0.11451f
C3959 dsm2_io_0.do_trim_b[3] di_btest_en 0.0379f
C3960 sg13cmos5l_inv_1_4.Y do_q_dec 0.01646f
C3961 clk_noverlap_0.sg13cmos5l_dlygate4sd3_1_0.A vdd 1.61662f
C3962 sg13cmos5l_inv_1_3.Y d_amp_s_b[0] 0.4791f
C3963 a_21830_2578# a_21736_2344# 0.09189f
C3964 sg13cmos5l_or2_1_0.X sg13cmos5l_inv_1_11.Y 0.03911f
C3965 sg13cmos5l_inv_1_3.A sg13cmos5l_inv_1_13.A 0.02349f
C3966 a_21554_2798# a_23294_2578# 0.10301f
C3967 quantizer2_lfsr_0.sg13cmos5l_dfrbpq_1_0.Q a_522_2901# 0.11051f
C3968 a_2070_3438# quantizer2_lfsr_0.sg13cmos5l_dfrbpq_1_11.Q 0.01796f
C3969 a_2034_3336# a_2045_3296# 0.20759f
C3970 quantizer2_lfsr_0.sg13cmos5l_dfrbpq_1_14.D vdd 0.32608f
C3971 sg13cmos5l_inv_1_18.Y d_amp_s_b[2] 0.02077f
C3972 dsm2_io_vcmg_0.di_vcm_ext d_vcm_phi1_b 0.05376f
C3973 dsm2_io_vcmg_0.di_vcm_ext quantizer2_lfsr_0.sg13cmos5l_dfrbpq_1_5.Q 0.01909f
C3974 dsm2_osc_0.sg13cmos5l_dfrbp_1_0.CLK a_22347_812# 0.05724f
C3975 a_24540_21440# a_24626_21440# 0.01899f
C3976 a_2208_18597# d_rst_b 0.01313f
C3977 clk_noverlap_0.sg13cmos5l_dlygate4sd3_1_7.X vdd 0.22837f
C3978 a_537_8997# d_dith_en 0.05917f
C3979 a_4537_7200# d_phi1 0.02548f
C3980 sg13cmos5l_inv_2_5.A a_13088_15020# 0.01071f
C3981 dsm2_io_0.do_trim_b[2] a_22252_4374# 0.8942f
C3982 dsm2_io_0.sg13cmos5l_inv_1_0.A di_dith_en 0.18482f
C3983 dsm2_osc_0.di_clk_ext di_clk 0.06885f
C3984 d_ena d_qi 0.26921f
C3985 sg13cmos5l_or2_1_0.X vo_p 0.42296f
C3986 quantizer2_lfsr_0.sg13cmos5l_dfrbpq_1_3.Q vdd 0.35183f
C3987 a_1324_13764# a_1288_13738# 0.24169f
C3988 sg13cmos5l_inv_1_9.Y d_amp_s_b[1] 0.01851f
C3989 sg13cmos5l_inv_1_4.Y d_qclk 0.0151f
C3990 a_2070_13806# a_2034_13704# 0.25046f
C3991 dsm2_osc_0.dsm2_io_rx_0.di_b do_osc_oe 0.01191f
C3992 a_1286_4247# d_qclk 0.2431f
C3993 sw_tgate_cmfb2_1.p xsc_vvg_p 0.93211f
C3994 a_21736_2344# a_22184_2052# 0.39782f
C3995 quantizer2_lfsr_0.sg13cmos5l_dfrbpq_1_13.D a_1286_14615# 0.01634f
C3996 a_10787_14878# d_qclk 0.20167f
C3997 quantizer2_lfsr_0.sg13cmos5l_nor2_1_1.B quantizer2_lfsr_0.sg13cmos5l_dfrbpq_1_13.D 0.44688f
C3998 dsm2_osc_0.sg13cmos5l_dfrbp_1_0.RESET_B dsm2_osc_0.sg13cmos5l_inv_1_3.A 0.20288f
C3999 a_1407_12722# d_dith_en 0.10049f
C4000 d_dith_en d_amp_s[1] 0.10556f
C4001 a_22499_864# a_22368_558# 0.28418f
C4002 sg13cmos5l_inv_1_17.A d_qclk 0.05667f
C4003 dsm2_osc_0.sg13cmos5l_inv_1_2.Y m2_10908_16863# 0.01134f
C4004 a_24626_21440# a_28126_21300# 0.01899f
C4005 a_8880_5832# a_9352_5586# 0.02203f
C4006 sg13cmos5l_and2_1_5.X d_dith_en 0.19423f
C4007 dsm2_osc_0.ibias_in dsm2_osc_0.dsm2_io_rx_0.di_b 0.19838f
C4008 dsm2_io_0.sg13cmos5l_inv_1_0.A di_rst_b 0.0379f
C4009 sg13cmos5l_nor2_1_0.Y a_7437_15998# 0.08338f
C4010 xq_vg_p_0_ a_11201_9948# 0.05012f
C4011 a_1324_3396# a_1600_3941# 0.24435f
C4012 a_21617_558# do_clk_osc 0.02413f
C4013 dsm2_io_vcmg_0.di_vcm_ext m2_10908_16863# 0.04662f
C4014 quantizer2_lfsr_0.sg13cmos5l_dfrbpq_1_2.D a_1324_5988# 0.02703f
C4015 sw_tgate_10.p d_qi 0.35541f
C4016 sg13cmos5l_inv_1_4.A sg13cmos5l_inv_1_18.Y 0.08231f
C4017 sg13cmos5l_nand2_1_2.Y xq_dith_v_bp 0.02318f
C4018 quantizer2_lfsr_0.di_dith_amp[0] a_2208_20141# 0.02445f
C4019 vi vcm 0.13714f
C4020 a_24540_19480# a_24626_19620# 0.01899f
C4021 m2_10908_16863# vi_esd 14.8033f
C4022 sw_tgate_11.gb d_qi 7.97249f
C4023 do_clk_osc di_clk 0.03759f
C4024 dsm2_osc_0.dsm2_io_rx_0.di_b vcm_esd 0.14321f
C4025 a_522_5493# d_dith_en 0.01883f
C4026 a_2034_4053# vdd 0.27638f
C4027 sg13cmos5l_nor2_1_0.Y d_dith[0] 0.01965f
C4028 a_8105_7224# clk_noverlap_0.sg13cmos5l_dlygate4sd3_1_4.A 0.12324f
C4029 a_22368_558# a_23195_985# 0.26205f
C4030 vdd di_trim[3] 0.51595f
C4031 quantizer2_lfsr_0.sg13cmos5l_dfrbpq_1_1.D a_522_15144# 0.03139f
C4032 a_20672_21300# a_20672_21020# 0.04477f
C4033 a_28126_21300# a_24626_21300# 0.01899f
C4034 sg13cmos5l_and2_1_5.X d_rst_b 2.88643f
C4035 sg13cmos5l_inv_1_3.A inv_en_0.di_b 0.0253f
C4036 sg13cmos5l_inv_1_9.Y sg13cmos5l_inv_1_18.Y 0.01164f
C4037 dsm2_io_vcmg_0.di_vcm_ext_b d_vcm_phi2 0.07606f
C4038 xsc_vc1l_p vo_p 12.3497f
C4039 a_2208_26861# d_ena 0.02234f
C4040 a_533_7328# a_537_6405# 0.36374f
C4041 a_2070_6854# a_2079_7122# 0.45119f
C4042 sg13cmos5l_nand2_1_2.Y do_q 0.05055f
C4043 sg13cmos5l_nand2_1_5.A sg13cmos5l_inv_1_6.A 0.49576f
C4044 quantizer2_lfsr_0.sg13cmos5l_dfrbpq_1_11.D d_dith_en 0.46392f
C4045 a_7241_7224# vdd 0.16085f
C4046 sg13cmos5l_inv_1_6.Y d_ena 0.95044f
C4047 a_2208_20717# a_2208_20613# 0.05762f
C4048 sg13cmos5l_inv_1_3.Y sg13cmos5l_inv_1_13.A 0.18605f
C4049 sg13cmos5l_nand2_1_2.Y a_13870_15077# 0.01197f
C4050 a_2368_16106# d_amp_s[2] 0.01476f
C4051 a_20758_21300# a_20758_21160# 0.84953f
C4052 a_23674_2578# vdd 0.06226f
C4053 a_8747_8608# d_amp_s_b[2] 0.0229f
C4054 sg13cmos5l_nor2_2_0.B sg13cmos5l_and2_1_5.A 0.19063f
C4055 xq_vg_p_0_ d_amp_s_b[1] 0.01203f
C4056 a_16557_7164# vdd 0.26218f
C4057 sg13cmos5l_nand2_1_5.A sg13cmos5l_inv_1_12.A 0.0913f
C4058 dsm2_io_vcmg_0.di_vcm_ext_b a_2045_8480# 0.01531f
C4059 a_1681_9745# a_1286_9431# 0.01058f
C4060 a_1322_6770# a_1324_5988# 0.20759f
C4061 d_amp_s_b[2] d_dith[0] 0.01281f
C4062 a_22347_812# do_clk_osc 0.01193f
C4063 a_2208_17741# vdd 0.12707f
C4064 sg13cmos5l_and2_1_5.A a_14849_15078# 0.05293f
C4065 xsc_vc1r_p sw_tgate_cmfb2_1.gb 0.07567f
C4066 dsm2_io_0.sg13cmos5l_inv_1_3.A di_dith_amp[1] 0.18586f
C4067 xsc_vc1l_n d_qi 0.06604f
C4068 xq_dith_v_bp vdd 0.79049f
C4069 a_2034_13704# a_2083_12612# 0.24435f
C4070 quantizer2_lfsr_0.sg13cmos5l_dfrbpq_1_2.D a_1367_3941# 0.0262f
C4071 xsc_vvg_p sw_tgate_cmfb2_1.gb 0.07945f
C4072 xsc_vvg_n xsc_vc1r_p 18.4245f
C4073 inv_en_0.di_b d_dith[1] 0.13216f
C4074 a_17421_7164# a_17140_7466# 0.18796f
C4075 dsm2_io_0.do_trim_b[3] di_trim[3] 0.18622f
C4076 a_2070_6854# d_qclk 0.03292f
C4077 xsc_vvg_p xsc_vvg_n 2.54249f
C4078 dsm2_osc_0.sg13cmos5l_inv_1_3.A dsm2_osc_0.dsm2_io_rx_0.di_b 0.13281f
C4079 a_22252_11246# a_24626_19760# 0.01606f
C4080 a_28334_21300# a_28334_21160# 0.1335f
C4081 a_24258_21160# a_24258_20880# 0.04477f
C4082 a_2045_5888# a_2083_4836# 0.07823f
C4083 a_2034_5928# a_2070_4262# 0.26205f
C4084 dsm2_osc_0.ibias_pad m2_10908_16655# 0.01215f
C4085 quantizer2_lfsr_0.di_dith_amp[0] dsm2_io_vcmg_0.di_vcm_ext_b 0.08621f
C4086 a_522_2518# d_dith_en 0.13334f
C4087 d_ena vo_p 0.27816f
C4088 a_522_15478# a_1284_15759# 0.01202f
C4089 sg13cmos5l_inv_1_19.Y d_dith_en 0.48729f
C4090 dsm2_io_vcmg_0.di_vcm_ext_b quantizer2_lfsr_0.sg13cmos5l_dfrbpq_1_6.Q 0.01496f
C4091 vdd do_q 1.18539f
C4092 a_2034_5928# vdd 0.07268f
C4093 sg13cmos5l_inv_1_19.Y xq_vg_q_0_ 0.06073f
C4094 a_522_12722# a_533_12512# 0.03546f
C4095 dsm2_osc_0.di_clk_ext do_clk_osc 0.06083f
C4096 sg13cmos5l_and2_1_5.A d_dith_en 0.15741f
C4097 a_24626_20320# dsm2_osc_0.d_btest_or 0.01657f
C4098 a_21681_1704# do_osc_oe 0.05459f
C4099 xq_dith_v_bp d_amp_s_b[0] 0.01738f
C4100 sg13cmos5l_inv_1_17.Y xq_vg_p_1_ 0.01503f
C4101 dsm2_osc_0.dsm2_io_rx_0.di_b di_clk_sel 0.04982f
C4102 a_13870_15077# vdd 0.15991f
C4103 sg13cmos5l_inv_1_4.A d_dith[0] 0.02532f
C4104 sg13cmos5l_nor2_1_0.Y do_q_dec 0.01305f
C4105 sg13cmos5l_inv_1_6.Y sg13cmos5l_inv_1_13.Y 0.0996f
C4106 a_22252_11246# a_24626_19620# 0.01612f
C4107 clk_noverlap_0.sg13cmos5l_dlygate4sd3_1_0.A a_5401_7200# 0.03649f
C4108 a_2045_3296# a_2049_2373# 0.36374f
C4109 clk_noverlap_0.di_clk xvcm_vcf_b 0.03708f
C4110 a_2045_11072# d_qclk 0.03615f
C4111 sg13cmos5l_nand2_1_2.Y xq_vg_p_2_ 0.84566f
C4112 a_6884_8680# d_amp_s[3] 0.76874f
C4113 sg13cmos5l_inv_1_4.A a_6757_9808# 0.01987f
C4114 a_10878_6484# d_ena 0.01f
C4115 a_522_12552# a_533_12512# 0.20759f
C4116 a_1284_13167# a_1322_11954# 0.17382f
C4117 sg13cmos5l_nor2_2_2.A sg13cmos5l_and2_2_1.X 0.01496f
C4118 dsm2_io_vcmg_0.di_vcm_ext d_amp_s[0] 0.03763f
C4119 a_6817_30111# vo_n 0.63474f
C4120 a_6817_30111# dsm2_io_0.do_trim_b[1] 0.02329f
C4121 a_24626_20180# dsm2_osc_0.d_btest_or 0.01657f
C4122 a_2034_6262# a_2045_5888# 0.17382f
C4123 a_10989_15998# d_qi 0.0963f
C4124 a_522_15478# a_533_15104# 0.17382f
C4125 a_20447_636# vdd 0.56507f
C4126 quantizer2_lfsr_0.sg13cmos5l_dfrbpq_1_11.Q a_1284_2799# 0.01009f
C4127 a_20000_21020# a_20000_20880# 0.1335f
C4128 sg13cmos5l_inv_1_3.A d_amp_s[3] 0.02171f
C4129 a_19964_18216# a_26670_16046# 0.0595f
C4130 vdd di_trim[2] 0.49457f
C4131 a_522_10294# vdd 0.17136f
C4132 a_24258_22964# a_24626_22964# 0.0182f
C4133 sg13cmos5l_nand2_1_5.A d_qi 0.25423f
C4134 a_522_5493# a_522_5110# 0.09257f
C4135 sg13cmos5l_nand2_1_5.A sg13cmos5l_inv_1_12.Y 0.12583f
C4136 sg13cmos5l_inv_1_13.Y vo_p 0.06088f
C4137 sw_tgate_cmfb2_3.gb vo_n 0.45008f
C4138 d_amp_s_b[2] do_q_dec 0.02668f
C4139 a_558_3110# a_567_3378# 0.45119f
C4140 a_522_12552# a_537_11589# 0.28324f
C4141 a_1322_4178# d_dith_en 0.29024f
C4142 dsm2_io_0.do_trim_b[1] a_22252_4374# 0.19473f
C4143 a_9348_31505# vo_n 2.70558f
C4144 dsm2_io_vcmg_0.di_vcm_ext_b d_amp_s_b[1] 0.05139f
C4145 sw_tgate_6.p d_qi 0.44682f
C4146 dsm2_io_0.sg13cmos5l_inv_1_4.A di_dith_amp[0] 0.18482f
C4147 a_1288_13738# vdd 0.09469f
C4148 xvcm_vcf_b d_qclk 0.05721f
C4149 a_22644_2344# a_22738_2088# 0.09811f
C4150 do_osc_oe di_clk 0.05542f
C4151 a_2045_3296# a_2083_2244# 0.07823f
C4152 a_24626_21020# a_24626_20880# 0.84953f
C4153 a_2034_3336# a_2070_1670# 0.26205f
C4154 dsm2_osc_0.sg13cmos5l_dfrbp_1_0.RESET_B dsm2_osc_0.sg13cmos5l_mux2_1_0.A1 0.47009f
C4155 sg13cmos5l_and2_1_2.X d_qout_en 0.02156f
C4156 a_2208_21485# a_2208_21293# 0.05462f
C4157 a_19964_18216# a_24602_15146# 0.07158f
C4158 di_qout_en di_vcm_ext 0.11257f
C4159 xq_vg_p_2_ vdd 0.36725f
C4160 a_11201_8328# d_amp_s[3] 0.06005f
C4161 a_13211_9028# a_13211_8748# 0.04477f
C4162 a_10757_8888# a_8747_8888# 0.01899f
C4163 quantizer2_lfsr_0.di_dith_amp[1] d_amp_s[0] 0.36187f
C4164 a_24626_22964# a_22252_11246# 0.06277f
C4165 xsc_vc1l_n vo_p 0.01907f
C4166 a_567_8562# d_dith_en 0.21441f
C4167 dsm2_io_vcmg_0.di_vcm_ext_b a_12424_5586# 0.01736f
C4168 dsm2_osc_0.ibias_in di_clk 0.05531f
C4169 clk_noverlap_0.sg13cmos5l_inv_1_5.Y clk_noverlap_0.sg13cmos5l_inv_1_5.A 0.07025f
C4170 sg13cmos5l_inv_1_3.A d_dith_en 0.17018f
C4171 d_amp_s_b[2] d_qclk 0.04961f
C4172 a_1681_12337# a_1324_11172# 0.25046f
C4173 a_533_12512# a_571_11460# 0.07823f
C4174 a_522_12552# a_558_10886# 0.26205f
C4175 a_10888_5586# m2_10908_16863# 0.02098f
C4176 quantizer2_lfsr_0.sg13cmos5l_dfrbpq_1_13.D a_1284_15759# 0.01686f
C4177 xsc_vc1r_p xsc_xcmfb1_vsw_vbias 0.03815f
C4178 sg13cmos5l_and2_1_5.B d_qout_en 0.03169f
C4179 sg13cmos5l_inv_1_6.Y sg13cmos5l_inv_1_14.A 0.0223f
C4180 quantizer2_lfsr_0.sg13cmos5l_dfrbpq_1_2.Q d_dith_en 0.34769f
C4181 a_24626_19480# bias_gm_0.bias_trim_0.vz 0.02385f
C4182 a_8857_7200# vdd 0.20766f
C4183 sg13cmos5l_inv_1_3.A xq_vg_q_0_ 1.39214f
C4184 sg13cmos5l_inv_1_4.Y xq_vg_p_1_ 0.19017f
C4185 d_amp_s[3] d_dith[1] 0.01832f
C4186 a_20138_14766# a_22138_15146# 0.06025f
C4187 d_amp_s_b[2] d_amp_s[2] 0.22055f
C4188 xsc_vvg_p xsc_xcmfb1_vsw_vbias 0.07569f
C4189 a_8302_15626# vdd 0.01295f
C4190 d_qi do_q_b 0.84144f
C4191 sg13cmos5l_inv_1_12.Y do_q_b 0.16768f
C4192 sg13cmos5l_inv_1_6.A sg13cmos5l_inv_1_18.Y 0.40889f
C4193 sg13cmos5l_inv_1_13.A xq_dith_v_bp 0.85924f
C4194 a_20672_20740# a_20758_20740# 0.01899f
C4195 a_2045_3296# vdd 0.20286f
C4196 sg13cmos5l_inv_1_17.A xq_vg_p_1_ 0.02746f
C4197 sg13cmos5l_inv_1_16.Y xq_vg_p_2_ 0.22303f
C4198 a_1367_1349# d_dith_en 0.1093f
C4199 sg13cmos5l_inv_1_4.A do_q_dec 0.02121f
C4200 sg13cmos5l_inv_1_8.Y d_dith[0] 0.02715f
C4201 sg13cmos5l_nand2_1_2.Y a_6757_9948# 0.02311f
C4202 a_5176_31469# xsc_vfb 0.04914f
C4203 a_2208_19085# vdd 0.1354f
C4204 clk_noverlap_0.di_clk dsm2_osc_0.sg13cmos5l_buf_2_0.A 0.03876f
C4205 a_11115_8888# a_11115_8608# 0.04477f
C4206 a_8661_8748# a_8747_8748# 0.01899f
C4207 dsm2_io_0.do_trim_b[2] ibias_200n 0.08699f
C4208 dsm2_osc_0.ibias_in dsm2_osc_0.sg13cmos5l_dfrbp_1_0.CLK 0.03367f
C4209 vcm_esd d_amp_s_b[3] 0.3802f
C4210 a_2208_31469# a_2208_30701# 0.05462f
C4211 sg13cmos5l_inv_2_5.A d_qi 0.01207f
C4212 a_2034_8520# vdd 0.10599f
C4213 a_558_3110# quantizer2_lfsr_0.sg13cmos5l_dfrbpq_1_0.Q 0.19024f
C4215 a_537_11589# a_571_11460# 0.01562f
C4216 vdd d_dith[2] 1.51999f
C4218 quantizer2_lfsr_0.sg13cmos5l_dfrbpq_1_9.D quantizer2_lfsr_0.sg13cmos5l_dfrbpq_1_12.Q 0.01342f
C4219 sg13cmos5l_inv_1_9.Y do_q_dec 0.01888f
C4220 a_20260_17236# a_19984_17824# 4.45896f
C4221 sg13cmos5l_nand2_1_5.A sg13cmos5l_inv_1_6.Y 0.12778f
C4222 sg13cmos5l_inv_1_13.A do_q 0.01972f
C4223 xsc_xcmfb1_vsw_cm_p vdd 3.19787f
C4224 sg13cmos5l_inv_1_13.A a_13594_16020# 0.01505f
C4225 a_2049_12741# vdd 0.23964f
C4226 a_20758_20740# a_24258_20600# 0.01899f
C4227 clk_noverlap_0.sg13cmos5l_dlygate4sd3_1_4.A vdd 0.22837f
C4228 sg13cmos5l_or2_1_0.X sg13cmos5l_inv_1_20.Y 0.08934f
C4229 sg13cmos5l_inv_1_3.Y d_amp_s[3] 0.12883f
C4230 dsm2_osc_0.dsm2_io_rx_0.di_b a_21478_2344# 0.01457f
C4231 d_qout_en d_amp_s[1] 0.04236f
C4232 sg13cmos5l_inv_1_4.A d_qclk 0.60511f
C4233 sg13cmos5l_inv_1_14.A vo_p 0.07751f
C4234 dsm2_osc_0.dsm2_io_rx_0.di_b di_osc_en 0.25834f
C4235 d_dith_en d_dith[1] 0.85154f
C4236 a_22930_1332# vdd 0.01323f
C4237 quantizer2_lfsr_0.di_dith_amp[0] quantizer2_lfsr_0.sg13cmos5l_nor2_1_1.B 0.44012f
C4238 a_10888_5586# a_11656_5586# 0.05462f
C4239 a_19999_22684# a_20000_22420# 0.06394f
C4240 a_1284_5493# a_1407_4946# 0.07015f
C4241 vo_n d_phi1 0.39906f
C4242 a_2208_20613# vdd 0.06889f
C4243 sg13cmos5l_and2_1_5.X d_qout_en 0.038f
C4244 vdd d_vcm_phi1_b 1.61825f
C4245 dsm2_io_0.dsm2_io_rx_9.di_b di_trim[0] 0.03707f
C4246 quantizer2_lfsr_0.sg13cmos5l_dfrbpq_1_5.Q vdd 0.56122f
C4247 a_2034_3670# a_2034_3506# 0.23043f
C4248 d_phi2 d_amp_s_b[3] 0.14313f
C4249 a_571_11460# a_558_10886# 0.18486f
C4250 quantizer2_lfsr_0.sg13cmos5l_dfrbpq_1_2.D a_1367_6533# 0.02604f
C4251 a_1324_11172# a_1367_11717# 0.26205f
C4252 sg13cmos5l_nand2_1_5.A sg13cmos5l_inv_1_11.Y 0.12529f
C4253 a_2070_6030# d_qclk 0.01421f
C4254 dsm2_io_0.do_trim_b[0] a_19964_18216# 0.05353f
C4255 d_amp_s_b[0] d_dith[2] 1.2787f
C4256 a_1284_13167# vdd 0.17136f
C4257 clk_noverlap_0.sg13cmos5l_inv_1_0.A a_10784_6484# 0.13606f
C4258 dsm2_osc_0.di_clk_ext do_osc_oe 0.24071f
C4259 sw_tgate_12.m d_qi 0.44708f
C4260 a_24258_20600# a_20758_20600# 0.01899f
C4261 d_rst_b d_dith[1] 0.05533f
C4262 dsm2_osc_0.sg13cmos5l_dfrbp_1_0.RESET_B a_22836_1332# 0.12383f
C4263 sg13cmos5l_and2_2_1.X d_qclk 0.38276f
C4264 sg13cmos5l_inv_1_6.Y do_q_b 0.01114f
C4265 a_6757_9948# vdd 0.01459f
C4266 quantizer2_lfsr_0.sg13cmos5l_dfrbpq_1_9.D d_dith_en 0.32188f
C4267 vo_n vcm_esd 0.39564f
C4268 a_522_4946# a_533_4736# 0.03546f
C4269 a_2049_4965# a_2083_4836# 0.01562f
C4270 vdd di_trim[1] 0.50705f
C4271 a_5176_31117# a_8762_31505# 0.51663f
C4272 a_6817_30111# a_9348_31505# 0.0408f
C4273 a_5176_31469# a_7224_31505# 1.06858f
C4274 dsm2_osc_0.ibias_in dsm2_osc_0.di_clk_ext 0.05439f
C4275 a_17140_7466# vdd 0.22764f
C4276 dsm2_io_0.do_trim_b[2] d_ena 0.02401f
C4277 quantizer2_lfsr_0.sg13cmos5l_nor2_1_0.A d_amp_s_b[2] 0.04916f
C4278 sg13cmos5l_inv_1_3.Y d_dith_en 0.25797f
C4279 a_1322_9362# a_1600_9125# 0.07823f
C4280 clk_noverlap_0.sg13cmos5l_dlygate4sd3_1_0.A a_4267_7241# 0.3108f
C4281 a_19964_18216# dsm2_osc_0.d_btest_or 1.0415f
C4282 sg13cmos5l_nand2_1_2.Y sg13cmos5l_inv_1_16.A 1.81116f
C4283 quantizer2_lfsr_0.sg13cmos5l_dfrbpq_1_11.D a_533_2144# 0.01723f
C4284 sg13cmos5l_inv_1_3.Y xq_vg_q_0_ 0.69067f
C4285 sg13cmos5l_or2_1_0.X xq_vg_q_1_ 0.05872f
C4286 a_10483_7459# vdd 0.28506f
C4287 a_533_12512# vdd 0.20451f
C4288 a_2034_8854# a_2034_8520# 0.01412f
C4289 a_11201_9808# vo_n 0.02287f
C4290 dsm2_osc_0.sg13cmos5l_dfrbp_1_0.RESET_B a_22499_864# 0.06772f
C4291 m2_10908_16863# vdd 1.24896f
C4292 dsm2_osc_0.sg13cmos5l_inv_1_3.A dsm2_osc_0.sg13cmos5l_dfrbp_1_0.CLK 0.11796f
C4293 sg13cmos5l_inv_1_11.Y do_q_b 0.01077f
C4294 sg13cmos5l_inv_1_3.Y a_11201_9168# 0.01416f
C4295 a_20328_23820# dsm2_io_0.do_trim_b[0] 0.06443f
C4296 sg13cmos5l_or2_1_0.X d_amp_s_b[3] 0.02413f
C4297 do_osc_oe do_clk_osc 1.20389f
C4298 a_522_2518# a_1284_2799# 0.01202f
C4299 a_20758_20460# d_ena 0.01376f
C4300 quantizer2_lfsr_0.sg13cmos5l_dfrbpq_1_11.D quantizer2_lfsr_0.sg13cmos5l_dfrbpq_1_1.D 0.06384f
C4301 a_24626_22420# a_24626_22280# 0.84953f
C4302 sg13cmos5l_inv_1_6.A d_dith[0] 0.02895f
C4303 a_16264_5586# a_16648_5586# 0.05462f
C4304 a_1322_6770# a_1367_6533# 0.07916f
C4305 a_12445_30191# sw_tgate_cmfb2_1.p 0.01212f
C4306 dsm2_io_0.do_trim_b[2] di_osc_en 0.01596f
C4307 a_24214_15746# vdd 0.12359f
C4308 quantizer2_lfsr_0.sg13cmos5l_dfrbpq_1_2.D quantizer2_lfsr_0.sg13cmos5l_dfrbpq_1_15.D 0.07667f
C4309 vo_n d_phi2 0.07649f
C4310 sg13cmos5l_and2_1_5.X sg13cmos5l_and2_1_4.X 0.02497f
C4311 a_558_10886# quantizer2_lfsr_0.sg13cmos5l_dfrbpq_1_7.D 0.19248f
C4312 clk_noverlap_0.sg13cmos5l_dlygate4sd3_1_7.X a_13569_7467# 0.12324f
C4313 sg13cmos5l_inv_1_13.A xq_vg_p_2_ 0.12291f
C4314 a_1286_9431# a_1288_8554# 0.02241f
C4315 a_2208_21293# vdd 0.12092f
C4316 sg13cmos5l_inv_2_5.Y d_qi 0.0253f
C4317 a_1681_14929# quantizer2_lfsr_0.sg13cmos5l_dfrbpq_1_0.D 0.01741f
C4318 sg13cmos5l_nand2_1_2.Y sg13cmos5l_inv_1_17.Y 0.08939f
C4319 dsm2_osc_0.ibias_in do_clk_osc 0.12408f
C4320 a_8392_5586# vdd 0.25522f
C4321 dsm2_io_vcmg_0.di_vcm_ext_b d_dith[0] 0.0233f
C4322 a_537_11589# vdd 0.23809f
C4323 dsm2_osc_0.sg13cmos5l_dfrbp_1_0.RESET_B a_23195_985# 0.12545f
C4324 bias_gm_0.bias_trim_0.vz a_22252_5274# 2.2201f
C4325 sg13cmos5l_inv_1_12.A d_dith[0] 0.01205f
C4326 quantizer2_lfsr_0.sg13cmos5l_dfrbpq_1_14.D d_dith_en 0.09088f
C4327 quantizer2_lfsr_0.sg13cmos5l_dfrbpq_1_2.D a_1324_8580# 0.02691f
C4328 a_20328_23820# dsm2_osc_0.d_btest_or 1.81775f
C4329 bias_gm_0.bias_trim_0.vz a_22252_8246# 4.41744f
C4330 a_2049_2373# a_2070_1670# 0.02431f
C4331 a_522_2518# a_533_2144# 0.17382f
C4332 a_2034_8520# a_2083_7428# 0.24435f
C4333 a_20758_20320# d_ena 0.01376f
C4334 xq_dith_v_bq d_amp_s[1] 0.12644f
C4335 a_2208_30701# vdd 0.54681f
C4336 a_24404_4674# bias_gm_0.bias_trim_0.iout 0.60773f
C4337 a_13684_7466# d_phi2 0.0518f
C4338 a_24626_22280# a_28126_22140# 0.01899f
C4339 a_20672_22140# a_20758_22140# 0.01899f
C4340 a_22138_15446# vdd 0.01702f
C4341 quantizer2_lfsr_0.sg13cmos5l_dfrbpq_1_3.Q d_dith_en 0.23572f
C4342 a_11201_8188# d_amp_s[1] 0.04333f
C4343 sg13cmos5l_inv_1_19.Y d_qout_en 0.1012f
C4344 a_22252_8546# a_22252_7946# 0.10061f
C4345 a_22252_8246# a_24404_8546# 0.01925f
C4346 quantizer2_lfsr_0.sg13cmos5l_dfrbpq_1_11.D a_558_518# 0.02797f
C4347 sg13cmos5l_inv_1_16.A vdd 1.32365f
C4348 a_11656_5586# vdd 0.50927f
C4349 a_558_10886# vdd 0.52277f
C4350 a_24540_20320# a_24626_20460# 0.01899f
C4351 sg13cmos5l_and2_1_5.A d_qout_en 0.03271f
C4353 dsm2_io_0.do_trim_b[0] a_22252_4074# 0.08938f
C4354 sg13cmos5l_or2_1_0.X vo_n 0.42989f
C4355 a_2034_13874# d_qclk 0.01105f
C4356 a_9833_7224# clk_noverlap_0.sg13cmos5l_nor3_1_0.C 0.15098f
C4357 a_1284_2799# a_1681_1969# 0.16704f
C4358 dsm2_osc_0.dsm2_io_rx_0.di_b a_22836_1332# 0.0549f
C4359 a_522_2901# vdd 0.27678f
C4360 a_19904_17646# a_24214_14546# 0.03311f
C4361 a_6638_31505# vdd 0.21295f
C4362 a_28126_22140# a_24626_22140# 0.01899f
C4363 a_28746_14846# vdd 0.18454f
C4364 dsm2_io_0.do_btest_en dsm2_osc_0.d_btest_or 6.82729f
C4365 quantizer2_lfsr_0.sg13cmos5l_dfrbpq_1_15.D di_clk_sel 0.0114f
C4366 sg13cmos5l_inv_1_16.A sg13cmos5l_inv_1_16.Y 0.26468f
C4367 quantizer2_lfsr_0.sg13cmos5l_dfrbpq_1_2.D a_1284_5493# 0.01308f
C4368 sg13cmos5l_inv_1_17.Y vdd 1.53434f
C4369 a_2070_8622# d_qclk 0.0121f
C4370 a_16648_5586# vdd 0.11665f
C4371 a_2208_25325# a_2208_24557# 0.05462f
C4372 a_2034_11829# vdd 0.27638f
C4373 a_2034_4053# d_dith_en 0.01766f
C4374 sw_tgate_cmfb2_3.gb d_phi1 1.33204f
C4375 sg13cmos5l_and2_1_5.B d_qi_b 0.03326f
C4376 dsm2_osc_0.sg13cmos5l_dfrbp_1_0.RESET_B m2_10908_16655# 0.14337f
C4377 vo_p d_amp_s_b[1] 0.11397f
C4378 a_2045_13664# d_qclk 0.02829f
C4379 sg13cmos5l_inv_1_9.Y a_12800_15736# 0.01054f
C4380 a_2083_2244# a_2070_1670# 0.18486f
C4381 a_7723_7241# d_qclk 0.01065f
C4382 sg13cmos5l_inv_1_6.Y sg13cmos5l_inv_1_18.Y 0.02884f
C4383 dsm2_osc_0.sg13cmos5l_mux2_1_0.A1 a_21681_1704# 0.08556f
C4384 bias_gm_0.bias_trim_0.iout vdd 4.21389f
C4385 dsm2_io_vcmg_0.di_vcm_ext_b clk_noverlap_0.di_clk 0.04393f
C4386 sw_tgate_cmfb2_1.p vdd 2.96371f
C4387 a_8747_9628# a_8747_9488# 0.19806f
C4388 clk_noverlap_0.sg13cmos5l_inv_1_10.A clk_noverlap_0.sg13cmos5l_inv_1_9.A 0.08534f
C4389 a_522_15144# a_567_13746# 0.24169f
C4390 a_533_15104# a_558_13478# 0.07916f
C4391 a_20758_22140# a_20758_22000# 0.84953f
C4392 clk_noverlap_0.sg13cmos5l_inv_1_1.Y vdd 0.28971f
C4393 a_22252_7946# vdd 9.90687f
C4394 a_2070_9446# d_qclk 0.03156f
C4395 sg13cmos5l_inv_1_16.Y sg13cmos5l_inv_1_17.Y 7.21976f
C4396 sg13cmos5l_inv_1_6.A do_q_dec 0.01827f
C4397 sg13cmos5l_inv_1_4.Y sg13cmos5l_nand2_1_2.Y 0.07891f
C4398 dsm2_io_vcmg_0.di_vcm_ext_b a_2079_7122# 0.01091f
C4399 sg13cmos5l_inv_1_13.A a_6757_9948# 0.02624f
C4400 xq_vg_q_1_ d_ena 0.02104f
C4401 a_14433_7467# d_phi2 0.04668f
C4402 a_16941_5500# d_phi2 0.11871f
C4403 vdd di_trim[0] 0.49385f
C4404 vo_n ibias_200n 0.08789f
C4405 dsm2_io_0.do_trim_b[1] ibias_200n 1.34903f
C4406 a_522_4776# vdd 0.0721f
C4407 sg13cmos5l_inv_1_13.Y sg13cmos5l_inv_1_2.A 0.02328f
C4408 a_537_14181# d_qclk 0.21588f
C4409 dsm2_io_0.do_trim_b[0] a_19904_17646# 0.11966f
C4410 sw_tgate_cmfb2_3.gb vcm_esd 0.97062f
C4411 sg13cmos5l_nor2_2_2.A d_qi 0.19702f
C4412 a_2049_7557# vdd 0.25349f
C4413 xsc_vc1l_p vo_n 0.01908f
C4414 sg13cmos5l_nand2_1_2.Y sg13cmos5l_inv_1_17.A 0.06401f
C4415 a_20758_20320# a_20758_20180# 0.84953f
C4416 a_2208_24557# vdd 0.57157f
C4417 sg13cmos5l_nor2_2_0.B do_q 0.01707f
C4418 a_20260_17236# ibias_200n 0.22538f
C4419 d_ena d_amp_s_b[3] 0.36125f
C4420 dsm2_io_vcmg_0.di_vcm_ext_b do_q_dec 0.16055f
C4421 quantizer2_lfsr_0.sg13cmos5l_dfrbpq_1_11.D quantizer2_lfsr_0.sg13cmos5l_dfrbpq_1_8.D 0.02219f
C4422 sg13cmos5l_inv_1_13.Y sg13cmos5l_inv_1_20.Y 6.23177f
C4423 a_522_2184# a_571_1092# 0.24435f
C4424 a_2070_1670# vdd 0.52341f
C4425 xsc_vc1r_p xsc_vc1r_n 8.46076f
C4426 sw_tgate_8.m d_qi 0.35541f
C4427 dsm2_io_vcmg_0.di_phi1_b d_phi1 0.23995f
C4428 vdd d_amp_s[0] 0.72812f
C4429 a_7224_31505# vo_p 0.2212f
C4430 d_qi d_dith[0] 0.04856f
C4431 sg13cmos5l_inv_1_12.Y d_dith[0] 0.02656f
C4432 clk_noverlap_0.sg13cmos5l_inv_1_0.A clk_noverlap_0.di_clk 0.02989f
C4433 inv_en_0.di_b d_dith[2] 0.17885f
C4434 a_2070_4262# a_2079_4530# 0.45119f
C4435 a_24258_22000# a_24258_21720# 0.04477f
C4436 a_28334_22140# a_28334_22000# 0.1335f
C4437 xsc_vvg_p xsc_vc1r_n 18.6991f
C4438 a_22252_11246# a_24626_21440# 0.0161f
C4439 quantizer2_lfsr_0.sg13cmos5l_dfrbpq_1_11.D a_533_7328# 0.0171f
C4440 a_6859_7241# a_7129_7200# 0.18796f
C4441 dsm2_io_0.sg13cmos5l_inv_1_3.A di_osc_en 0.01596f
C4442 a_11865_14889# do_q 0.01816f
C4443 sg13cmos5l_inv_1_20.Y a_13985_15078# 0.01003f
C4444 sg13cmos5l_inv_1_6.A d_qclk 0.07776f
C4445 sg13cmos5l_inv_1_9.Y sg13cmos5l_inv_1_0.Y 0.11587f
C4446 sg13cmos5l_inv_1_18.Y vo_p 0.01877f
C4447 a_2079_4530# vdd 0.09422f
C4448 sg13cmos5l_and2_1_5.X d_qi_b 0.02621f
C4449 a_19904_17646# dsm2_osc_0.d_btest_or 0.21265f
C4450 sg13cmos5l_inv_1_3.A d_qout_en 0.01805f
C4451 a_28334_20320# a_28334_20180# 0.1335f
C4452 sg13cmos5l_inv_1_15.Y vdd 0.32216f
C4453 sg13cmos5l_inv_1_7.Y sg13cmos5l_and2_1_5.B 0.01918f
C4454 a_19949_784# a_20447_636# 0.07072f
C4455 a_24712_874# vi 0.05249f
C4456 sw_tgate_cmfb2_3.gb d_phi2 0.13316f
C4457 dsm2_io_vcmg_0.di_vcm_ext_b d_qclk 0.23724f
C4458 a_24626_22000# dsm2_osc_0.d_btest_or 0.01657f
C4459 dsm2_osc_0.sg13cmos5l_mux2_1_0.A1 a_21617_558# 0.02065f
C4460 dsm2_io_0.do_trim_b[3] bias_gm_0.bias_trim_0.iout 0.93842f
C4461 a_21252_3394# bias_gm_0.bias_trim_0.iout 0.72586f
C4462 a_1324_804# a_1286_1655# 0.28324f
C4463 quantizer2_lfsr_0.di_dith_amp[0] a_1284_15759# 0.02899f
C4464 dsm2_io_vcmg_0.di_vcm_ext_b d_amp_s[2] 0.07871f
C4465 sg13cmos5l_inv_1_4.A xq_vg_p_1_ 0.03609f
C4466 a_21252_3394# a_22252_7946# 0.1854f
C4467 dsm2_io_0.do_trim_b[3] a_22252_7946# 0.1779f
C4468 a_1322_4178# a_1324_3396# 0.20759f
C4469 a_22252_11246# a_24626_21300# 0.01605f
C4470 d_amp_s_b[0] d_amp_s[0] 0.31789f
C4471 quantizer2_lfsr_0.di_dith_amp[1] a_1284_16630# 0.02812f
C4472 sg13cmos5l_inv_1_4.Y vdd 0.35374f
C4473 a_11201_8888# a_11201_8748# 0.48787f
C4474 d_dith_en do_q 0.02093f
C4475 a_2034_5928# d_dith_en 0.28339f
C4476 quantizer2_lfsr_0.sg13cmos5l_dfrbpq_1_2.D a_1407_4946# 0.01101f
C4477 clk_noverlap_0.sg13cmos5l_inv_1_3.Y clk_noverlap_0.di_clk 0.0671f
C4478 sg13cmos5l_inv_1_16.Y a_11201_8888# 0.01232f
C4479 sg13cmos5l_inv_1_15.Y sg13cmos5l_inv_1_16.Y 0.08617f
C4480 a_1286_4247# vdd 0.24867f
C4481 a_10787_14878# vdd 0.36257f
C4482 sg13cmos5l_inv_1_13.Y xq_vg_q_1_ 0.05814f
C4483 sg13cmos5l_inv_1_9.Y xq_vg_p_1_ 1.49543f
C4484 d_ena vo_n 0.34102f
C4485 xq_vg_p_0_ a_11259_9628# 0.021f
C4486 sg13cmos5l_inv_1_17.A vdd 1.39396f
C4487 clk_noverlap_0.sg13cmos5l_dlygate4sd3_1_0.A a_5513_7224# 0.02833f
C4488 dsm2_io_0.do_trim_b[1] d_ena 4.64669f
C4489 a_4649_7224# clk_noverlap_0.sg13cmos5l_dlygate4sd3_1_0.X 0.12324f
C4490 dsm2_osc_0.dsm2_io_rx_0.di_b m2_10908_16655# 0.01519f
C4491 a_24626_21860# dsm2_osc_0.d_btest_or 0.01657f
C4492 clk_noverlap_0.sg13cmos5l_inv_1_0.A d_qclk 0.26103f
C4493 dsm2_osc_0.ibias_in do_osc_oe 0.11887f
C4494 sg13cmos5l_inv_1_13.A sg13cmos5l_inv_1_16.A 0.3103f
C4495 a_1324_804# a_1600_1349# 0.24435f
C4496 a_20260_17236# d_ena 0.42332f
C4497 sw_tgate_cmfb2_1.gb sw_tgate_9.gb 0.01015f
C4498 sw_tgate_cmfb2_1.gb vdd 3.02456f
C4499 a_20000_21860# a_20000_21720# 0.1335f
C4500 sg13cmos5l_and2_2_1.X xq_vg_p_1_ 0.01729f
C4501 xsc_vvg_n sw_tgate_9.gb 0.42538f
C4502 sg13cmos5l_inv_1_4.Y sg13cmos5l_inv_1_16.Y 0.0298f
C4503 xsc_vvg_n vdd 1.27029f
C4504 dsm2_io_0.sg13cmos5l_inv_1_3.A a_2208_19661# 0.01981f
C4505 clk_noverlap_0.sg13cmos5l_inv_1_10.A a_11786_6736# 0.02677f
C4506 clk_noverlap_0.sg13cmos5l_dlygate4sd3_1_1.X d_qclk 0.01017f
C4507 sg13cmos5l_inv_1_2.A sg13cmos5l_inv_1_14.A 2.77742f
C4508 di_dith_amp[1] di_clk_sel 0.02982f
C4509 d_qout_en d_dith[1] 0.06464f
C4510 a_1288_8554# vdd 0.10435f
C4511 clk_noverlap_0.sg13cmos5l_dlygate4sd3_1_0.A clk_noverlap_0.sg13cmos5l_inv_1_5.A 0.02832f
C4512 vcm_esd do_osc_oe 0.03656f
C4513 sg13cmos5l_inv_1_6.Y d_dith[0] 0.03992f
C4514 a_1284_16630# quantizer2_lfsr_0.sg13cmos5l_dfrbpq_1_13.Q 0.27453f
C4515 a_562_16373# quantizer2_lfsr_0.sg13cmos5l_dfrbpq_1_1.D 0.01622f
C4516 d_phi1 vcm_esd 2.36432f
C4517 clk_noverlap_0.sg13cmos5l_inv_1_1.A clk_noverlap_0.sg13cmos5l_inv_1_0.Y 0.04958f
C4518 sg13cmos5l_inv_1_16.Y sg13cmos5l_inv_1_17.A 0.33558f
C4519 sg13cmos5l_and2_1_5.X sg13cmos5l_inv_1_7.Y 0.01287f
C4520 sg13cmos5l_inv_1_20.Y sg13cmos5l_inv_1_14.A 0.02242f
C4521 clk_noverlap_0.sg13cmos5l_dlygate4sd3_1_8.X d_phi2 0.06471f
C4522 a_13965_7164# clk_noverlap_0.sg13cmos5l_dlygate4sd3_1_7.A 0.30507f
C4523 a_20000_20040# a_20000_19900# 0.1335f
C4524 a_24540_20040# a_24540_19760# 0.04477f
C4525 xq_vg_p_0_ a_11259_9488# 0.01307f
C4526 a_1681_14929# a_1324_13764# 0.25046f
C4527 quantizer2_lfsr_0.sg13cmos5l_dfrbpq_1_0.D a_537_14181# 0.01777f
C4528 a_20447_636# a_20673_892# 0.02749f
C4529 quantizer2_lfsr_0.sg13cmos5l_dfrbpq_1_2.D a_1322_1586# 0.04894f
C4530 a_21478_2578# vdd 0.11962f
C4531 dsm2_osc_0.ibias_in vcm_esd 0.1074f
C4532 sg13cmos5l_inv_1_13.A sg13cmos5l_inv_1_17.Y 0.80846f
C4533 a_8747_9308# a_10757_9168# 0.01899f
C4534 a_24626_21860# a_24626_21720# 0.84953f
C4535 a_522_10294# d_dith_en 0.13349f
C4536 d_qi do_q_dec 0.06252f
C4537 sg13cmos5l_inv_1_11.Y d_dith[0] 0.02176f
C4538 a_558_5702# a_567_5970# 0.45119f
C4539 quantizer2_lfsr_0.sg13cmos5l_dfrbpq_1_4.Q d_ena 0.0129f
C4540 a_2049_7557# a_2083_7428# 0.01562f
C4541 a_522_7702# a_522_7368# 0.01412f
C4542 sg13cmos5l_and2_1_2.X sg13cmos5l_inv_1_5.Y 0.12961f
C4543 a_19999_22964# d_ena 0.01082f
C4544 sg13cmos5l_and2_1_5.B a_8013_14934# 0.20156f
C4545 a_2034_6262# a_2034_6098# 0.23043f
C4546 d_phi1 d_phi2 15.9647f
C4547 a_24626_20040# a_24626_19900# 0.84953f
C4548 sg13cmos5l_inv_1_3.Y d_qout_en 0.01576f
C4549 a_1600_14309# a_1367_14309# 0.18486f
C4550 a_1367_9125# a_1288_8554# 0.45119f
C4551 dsm2_osc_0.d_btest_or a_21554_2798# 0.73874f
C4552 sg13cmos5l_inv_1_3.A xq_dith_v_bq 2.1333f
C4553 a_21736_2344# vdd 0.26538f
C4554 dsm2_io_vcmg_0.di_vcm_ext_b quantizer2_lfsr_0.sg13cmos5l_nor2_1_0.A 0.08351f
C4555 a_11201_8468# d_amp_s_b[0] 0.03995f
C4556 a_1288_13738# d_dith_en 0.20559f
C4557 sg13cmos5l_inv_1_5.Y sg13cmos5l_and2_1_5.B 0.02476f
C4558 sg13cmos5l_inv_1_13.Y vo_n 0.06088f
C4559 a_11115_9168# a_11201_9168# 0.01899f
C4560 dsm2_io_vcmg_0.di_vcm_ext_b quantizer2_lfsr_0.sg13cmos5l_dfrbpq_1_0.D 0.01539f
C4561 d_amp_s[3] d_dith[2] 0.02275f
C4562 a_20672_21580# a_20758_21580# 0.01899f
C4563 sg13cmos5l_and2_1_5.A d_qi_b 0.03572f
C4564 dsm2_osc_0.sg13cmos5l_mux2_1_0.A1 dsm2_osc_0.di_clk_ext 0.26923f
C4565 dsm2_io_vcmg_0.di_phi1_b di_clk_sel 0.05361f
C4566 sg13cmos5l_and2_1_5.B a_14266_14856# 0.0505f
C4567 d_qi d_qclk 0.01858f
C4568 inv_en_0.di_b sg13cmos5l_inv_1_16.A 0.08625f
C4569 a_6757_9808# vo_p 0.0142f
C4570 a_10198_6736# vdd 0.01379f
C4571 a_10757_8328# a_8747_8328# 0.01899f
C4572 a_11115_8328# a_11201_8468# 0.01899f
C4573 xq_vg_p_0_ xq_vg_p_1_ 0.26736f
C4574 a_10120_5586# xvcm_vcf_t 0.01293f
C4575 a_10888_5586# xvcm_vcf_b 0.01236f
C4576 a_1407_15314# vdd 0.13642f
C4577 d_phi2 vcm_esd 0.74278f
C4578 clk_noverlap_0.sg13cmos5l_inv_1_11.Y clk_noverlap_0.sg13cmos5l_inv_1_0.Y 0.0748f
C4579 a_9556_15186# do_q_b 0.01064f
C4580 a_2070_6854# vdd 0.52426f
C4581 a_28126_19900# a_28126_19620# 0.04477f
C4582 sg13cmos5l_nor2_2_0.Y vdd 0.27009f
C4583 clk_noverlap_0.sg13cmos5l_dlygate4sd3_1_0.A a_8587_7241# 0.03228f
C4584 sg13cmos5l_and2_1_5.X sg13cmos5l_inv_2_4.Y 0.02238f
C4585 xsc_vc1l_n vo_n 12.3497f
C4586 a_2045_3296# d_dith_en 0.29362f
C4587 dsm2_osc_0.ibias_in dsm2_osc_0.sg13cmos5l_inv_1_3.A 0.10608f
C4588 a_2034_1466# d_dith[1] 0.07117f
C4589 a_20758_21580# a_24258_21440# 0.01899f
C4590 sg13cmos5l_inv_1_20.Y do_q_b 0.03534f
C4591 a_2208_19085# d_dith_en 0.02402f
C4592 sg13cmos5l_and2_1_5.X a_8013_14934# 0.07836f
C4593 sg13cmos5l_or2_1_0.X d_phi1 1.07306f
C4594 sg13cmos5l_nand2_2_0.B sg13cmos5l_inv_1_9.Y 0.02894f
C4595 a_11201_8328# a_11201_8188# 0.48787f
C4596 a_522_4776# a_571_3684# 0.24435f
C4597 a_6817_30111# d_ena 0.53144f
C4598 sw_tgate_cmfb2_1.p xsc_xcmfb1_vsw_cm_n 0.22404f
C4599 xq_dith_v_bq d_dith[1] 1.46127f
C4600 dsm2_osc_0.sg13cmos5l_mux2_1_0.A1 do_clk_osc 0.21925f
C4601 a_2034_8520# d_dith_en 0.27989f
C4602 dsm2_osc_0.sg13cmos5l_inv_1_3.A vcm_esd 0.0574f
C4603 d_dith_en d_dith[2] 0.01308f
C4604 sg13cmos5l_inv_1_6.Y do_q_dec 0.02276f
C4605 a_20672_19620# a_20758_19760# 0.01899f
C4606 a_2034_9237# a_2034_8690# 0.07015f
C4607 a_15693_7164# d_phi2 0.06001f
C4608 a_2083_4836# d_qclk 0.01293f
C4609 d_phi1 di_clk_sel 0.17755f
C4610 a_21478_2578# a_21276_2052# 0.09373f
C4611 sg13cmos5l_inv_1_4.Y sg13cmos5l_inv_1_13.A 0.06611f
C4612 sg13cmos5l_or2_1_0.X a_8768_15909# 0.02007f
C4613 sg13cmos5l_and2_1_5.X sg13cmos5l_inv_1_5.Y 0.01212f
C4614 a_21554_2798# a_22386_2578# 0.06805f
C4615 a_2049_12741# d_dith_en 0.04031f
C4616 dsm2_osc_0.sg13cmos5l_dfrbp_1_0.Q_N a_22368_558# 0.10536f
C4617 dsm2_osc_0.ibias_pad vi_esd 0.10626f
C4618 a_19984_17824# ibias_200n 0.07715f
C4619 a_1286_14615# d_qclk 0.23409f
C4620 a_2045_11072# vdd 0.20306f
C4621 dsm2_osc_0.ibias_pad dsm2_osc_0.sg13cmos5l_dfrbp_1_0.Q_N 0.01449f
C4622 dsm2_osc_0.sg13cmos5l_dfrbp_1_0.CLK a_22499_864# 0.21411f
C4623 a_24258_21440# a_20758_21440# 0.01899f
C4624 dsm2_osc_0.di_clk_ext a_20770_598# 0.08692f
C4625 sg13cmos5l_inv_1_13.A sg13cmos5l_inv_1_17.A 0.98385f
C4626 sg13cmos5l_inv_1_7.Y sg13cmos5l_and2_1_5.A 0.02437f
C4627 a_12705_7467# vdd 0.16017f
C4628 a_1324_804# d_qclk 0.08413f
C4629 dsm2_osc_0.ibias_in di_clk_sel 0.03901f
C4630 sg13cmos5l_inv_1_3.Y a_8747_8468# 0.01316f
C4631 xsc_xcmfb1_vsw_vbias vdd 1.36344f
C4632 a_19105_884# di_clk 0.20616f
C4633 a_6265_7200# vdd 0.21057f
C4634 a_1324_13764# a_1600_14309# 0.24435f
C4635 a_9348_31505# d_ena 0.01987f
C4636 di_dith_amp[1] di_osc_en 0.04773f
C4637 quantizer2_lfsr_0.sg13cmos5l_dfrbpq_1_5.Q d_dith_en 0.43233f
C4638 a_7723_7241# a_7993_7200# 0.18796f
C4639 quantizer2_lfsr_0.di_dith_amp[0] dsm2_io_0.sg13cmos5l_inv_1_3.A 0.01095f
C4640 sg13cmos5l_inv_1_6.Y d_qclk 0.02794f
C4641 vcm_esd di_clk_sel 0.07083f
C4642 sg13cmos5l_inv_1_14.A vo_n 0.01478f
C4643 sg13cmos5l_nand2_2_0.B a_15130_14856# 0.02295f
C4644 inv_en_0.di d_dith[1] 0.11685f
C4645 a_21276_2052# a_21736_2344# 0.29265f
C4646 a_23294_2578# a_22644_2344# 0.03559f
C4647 a_558_3110# vdd 0.52277f
C4648 sg13cmos5l_nor2_1_0.Y vdd 0.32454f
C4649 dsm2_osc_0.sg13cmos5l_dfrbp_1_0.RESET_B a_22184_2052# 0.13947f
C4650 a_21554_2798# a_22644_2344# 0.32409f
C4651 sg13cmos5l_inv_1_3.Y xq_dith_v_bq 0.31163f
C4652 a_1284_13167# d_dith_en 0.11055f
C4653 do_q_b di_clk 0.03991f
C4654 a_22499_864# a_22347_812# 0.3643f
C4655 dsm2_io_0.do_trim_b[2] bias_gm_0.bias_trim_0.vz 3.38494f
C4656 quantizer2_lfsr_0.di_dith_amp[0] d_amp_s_b[3] 0.01679f
C4657 xsc_vc1l_p d_phi1 0.53131f
C4658 dsm2_osc_0.sg13cmos5l_dfrbp_1_0.CLK a_23195_985# 0.04467f
C4659 vo_p do_q_dec 0.01634f
C4660 sg13cmos5l_and2_1_2.X sg13cmos5l_and2_1_5.B 0.01852f
C4661 sg13cmos5l_inv_1_3.Y a_11201_8188# 0.01206f
C4662 sg13cmos5l_or2_1_0.X d_phi2 0.1135f
C4663 a_1322_4178# a_1600_3941# 0.07823f
C4664 dsm2_io_vcmg_0.di_vcm_ext_b dsm2_io_vcmg_0.di_vcm_ext 2.4128f
C4665 a_20770_598# do_clk_osc 0.04656f
C4666 a_20758_22140# d_ena 0.01376f
C4667 sg13cmos5l_inv_1_20.Y d_amp_s_b[1] 0.05878f
C4668 a_2034_6262# d_qclk 0.01618f
C4669 inv_en_0.di_b sg13cmos5l_inv_1_15.Y 0.05818f
C4670 sg13cmos5l_inv_1_6.A xq_vg_p_1_ 0.0443f
C4671 quantizer2_lfsr_0.sg13cmos5l_dfrbpq_1_2.D a_1322_6770# 0.03009f
C4672 dsm2_io_vcmg_0.di_phi1_b d_ena 0.20314f
C4673 sw_tgate_cmfb2_3.gb sw_tgate_11.gb 0.09653f
C4674 a_24258_19480# a_24540_19480# 0.04564f
C4675 a_2034_13704# a_2049_12741# 0.28324f
C4676 dsm2_io_0.sg13cmos5l_inv_1_4.A a_2208_20613# 0.02374f
C4677 quantizer2_lfsr_0.sg13cmos5l_dfrbpq_1_3.Q a_2034_6645# 0.10539f
C4678 xvcm_vcf_b vdd 1.03909f
C4679 d_phi2 di_clk_sel 0.04718f
C4680 quantizer2_lfsr_0.sg13cmos5l_dfrbpq_1_2.D di_clk_sel 0.0339f
C4681 a_533_12512# d_dith_en 0.30441f
C4682 a_22347_812# a_23195_985# 0.07916f
C4683 sg13cmos5l_inv_1_4.A sg13cmos5l_nand2_1_2.Y 2.08949f
C4684 sg13cmos5l_inv_2_0.Y vdd 0.40208f
C4685 dsm2_io_0.do_btest_en do_q 0.03798f
C4686 dsm2_osc_0.dsm2_io_rx_1.di_b vdd 0.23397f
C4687 clk_noverlap_0.sg13cmos5l_dlygate4sd3_1_0.A clk_noverlap_0.sg13cmos5l_dlygate4sd3_1_2.X 0.03803f
C4688 vo_p d_qclk 0.05489f
C4689 sg13cmos5l_inv_1_4.Y inv_en_0.di_b 0.01922f
C4690 a_19984_17824# d_ena 0.86799f
C4691 a_8747_8888# d_amp_s_b[2] 0.01114f
C4692 vo_p d_amp_s[2] 0.08908f
C4693 inv_en_0.di_b a_10787_14878# 0.08853f
C4694 a_2070_9446# a_2079_9714# 0.45119f
C4695 a_533_9920# a_537_8997# 0.36374f
C4696 quantizer2_lfsr_0.sg13cmos5l_dfrbpq_1_5.Q a_2034_13704# 0.02544f
C4697 a_2083_7428# a_2070_6854# 0.18486f
C4698 a_1286_4247# a_1288_3370# 0.02241f
C4699 a_20758_22000# d_ena 0.01376f
C4700 vdd d_amp_s_b[2] 1.84265f
C4701 sw_tgate_cmfb2_1.gb xsc_xcmfb1_vsw_cm_n 0.39737f
C4702 sg13cmos5l_inv_1_19.Y a_8013_14934# 0.07879f
C4703 sg13cmos5l_inv_2_5.A sg13cmos5l_inv_1_0.A 0.05188f
C4704 sg13cmos5l_nand2_1_2.Y sg13cmos5l_inv_1_9.Y 0.07829f
C4705 a_22836_1332# do_clk_osc 0.02734f
C4706 a_24540_19480# a_24626_19480# 0.01899f
C4707 a_522_13269# a_522_12886# 0.09257f
C4708 quantizer2_lfsr_0.sg13cmos5l_dfrbpq_1_0.Q a_1324_804# 0.0236f
C4709 quantizer2_lfsr_0.sg13cmos5l_dfrbpq_1_1.Q a_856_16467# 0.0112f
C4710 sg13cmos5l_and2_1_5.A a_8013_14934# 0.11538f
C4711 sg13cmos5l_inv_1_12.A a_10592_15909# 0.09758f
C4712 a_537_11589# d_dith_en 0.05922f
C4713 a_22368_558# a_22258_594# 0.25046f
C4714 quantizer2_lfsr_0.di_dith_amp[0] a_2038_15217# 0.0247f
C4715 sg13cmos5l_and2_1_5.X sg13cmos5l_and2_1_2.X 0.01362f
C4716 quantizer2_lfsr_0.sg13cmos5l_nor2_1_1.B quantizer2_lfsr_0.sg13cmos5l_nor2_1_0.A 0.10802f
C4717 a_24540_21160# a_24626_21300# 0.01899f
C4718 quantizer2_lfsr_0.di_dith_amp[1] dsm2_io_vcmg_0.di_vcm_ext_b 0.29439f
C4719 dsm2_osc_0.sg13cmos5l_dfrbp_1_0.CLK m2_10908_16655# 0.03568f
C4720 d_ena d_phi1 0.57483f
C4721 xsc_vc1l_p d_phi2 1.31397f
C4722 a_11284_15186# d_qi 0.22446f
C4723 a_11201_8748# d_amp_s_b[2] 0.03288f
C4724 a_2038_15217# quantizer2_lfsr_0.sg13cmos5l_dfrbpq_1_6.Q 0.26714f
C4725 sg13cmos5l_inv_1_20.Y sg13cmos5l_inv_1_18.Y 0.13605f
C4726 a_1284_16630# vdd 0.1833f
C4727 quantizer2_lfsr_0.sg13cmos5l_nor2_1_1.B quantizer2_lfsr_0.sg13cmos5l_dfrbpq_1_0.D 0.01958f
C4728 sg13cmos5l_inv_1_16.Y d_amp_s_b[2] 1.62856f
C4729 sg13cmos5l_inv_1_5.Y sg13cmos5l_and2_1_5.A 0.01256f
C4730 a_1322_9362# a_1324_8580# 0.20759f
C4731 a_19105_884# dsm2_osc_0.di_clk_ext 0.37046f
C4732 a_22499_864# do_clk_osc 0.01118f
C4733 sg13cmos5l_and2_1_5.X sg13cmos5l_and2_1_5.B 0.16473f
C4734 sg13cmos5l_and2_1_5.A a_14266_14856# 0.03472f
C4735 d_amp_s_b[1] d_amp_s_b[3] 4.21932f
C4736 d_amp_s_b[0] d_amp_s_b[2] 4.08818f
C4737 a_1284_13269# a_1407_12722# 0.07015f
C4738 sg13cmos5l_inv_1_16.A d_dith_en 0.12136f
C4739 a_558_10886# d_dith_en 0.12693f
C4740 quantizer2_lfsr_0.sg13cmos5l_dfrbpq_1_2.D quantizer2_lfsr_0.sg13cmos5l_dfrbpq_1_13.D 0.70278f
C4741 a_22184_2052# dsm2_osc_0.dsm2_io_rx_0.di_b 0.11897f
C4742 dsm2_osc_0.di_clk_ext do_q_b 0.06263f
C4743 dsm2_io_vcmg_0.di_vcm_ext_b a_2079_9714# 0.01091f
C4744 sg13cmos5l_inv_1_4.A vdd 0.73344f
C4745 d_ena vcm_esd 0.06203f
C4746 a_16941_5500# d_vcm_phi2 0.0855f
C4747 a_522_2901# d_dith_en 0.01895f
C4748 sw_tgate_10.p d_phi1 0.07532f
C4749 a_1324_5988# a_1286_6839# 0.28324f
C4750 quantizer2_lfsr_0.sg13cmos5l_dfrbpq_1_0.D a_567_786# 0.01862f
C4751 clk_noverlap_0.di_clk dsm2_osc_0.dsm2_io_rx_0.di_b 0.02402f
C4752 dsm2_osc_0.ibias_in di_osc_en 0.07044f
C4753 sw_tgate_11.gb d_phi1 8.03227f
C4754 xsc_vc1r_p vo_p 0.05167f
C4755 sg13cmos5l_inv_1_4.A a_6874_16020# 0.01501f
C4756 sg13cmos5l_inv_1_19.Y xq_vg_q_2_ 0.19877f
C4758 sg13cmos5l_inv_1_9.Y vdd 2.46706f
C4759 xsc_vvg_p vo_p 0.04144f
C4760 a_20000_19340# a_19964_18216# 0.0104f
C4761 a_2049_12741# a_2079_12306# 0.02241f
C4762 d_amp_s[0] d_amp_s[3] 1.96801f
C4763 sg13cmos5l_inv_1_4.A sg13cmos5l_inv_1_16.Y 0.61457f
C4764 dsm2_osc_0.sg13cmos5l_mux2_1_0.A1 do_osc_oe 0.26935f
C4765 a_2034_11829# d_dith_en 0.01996f
C4766 a_1324_5988# d_qclk 0.07776f
C4767 quantizer2_lfsr_0.sg13cmos5l_dfrbpq_1_11.D a_533_9920# 0.0171f
C4768 sg13cmos5l_inv_1_18.Y xq_vg_q_1_ 0.01586f
C4769 sg13cmos5l_inv_1_19.Y a_8661_9028# 0.0135f
C4770 sg13cmos5l_inv_1_17.Y xq_vg_q_0_ 0.35509f
C4771 vcm_esd di_osc_en 0.09648f
C4772 d_qi vi_esd 0.41536f
C4773 a_21276_2052# dsm2_osc_0.dsm2_io_rx_1.di_b 0.02483f
C4774 dsm2_osc_0.sg13cmos5l_buf_2_0.A vdd 0.31868f
C4775 quantizer2_lfsr_0.sg13cmos5l_dfrbpq_1_7.D a_522_10677# 0.113f
C4776 a_2034_11112# a_2045_11072# 0.20759f
C4777 sg13cmos5l_and2_2_1.X vdd 6.03248f
C4778 a_20758_21160# a_20758_21020# 0.84953f
C4779 clk_noverlap_0.sg13cmos5l_dlygate4sd3_1_0.A a_9833_7224# 0.0172f
C4780 dsm2_osc_0.di_clk_ext m2_10908_16655# 0.28262f
C4781 a_8208_15626# a_8768_15909# 0.01132f
C4782 d_ena d_phi2 0.99609f
C4783 do_q_b do_clk_osc 0.14015f
C4784 sg13cmos5l_inv_1_2.Y vdd 0.39165f
C4785 sg13cmos5l_nand2_1_2.Y xq_vg_p_0_ 0.05349f
R0 do_clk_osc do_clk_osc.n0 47.1165
R1 do_clk_osc.n0 do_clk_osc.t0 8.80108
R2 do_clk_osc.n0 do_clk_osc.t1 6.04887
R3 do_osc_oe do_osc_oe.n1 28.513
R4 do_osc_oe.n1 do_osc_oe.n0 26.0488
R5 do_osc_oe.n1 do_osc_oe.t2 24.0198
R6 do_osc_oe.n0 do_osc_oe.t1 8.97718
R7 do_osc_oe.n0 do_osc_oe.t0 5.93749
R8 di_clk_sel di_clk_sel.n0 193.668
R9 di_clk_sel.n0 di_clk_sel.t0 8.70314
R10 di_clk_sel.n0 di_clk_sel.t1 7.501
R11 di_osc_en di_osc_en.n0 155.97
R12 di_osc_en.n0 di_osc_en.t0 8.70314
R13 di_osc_en.n0 di_osc_en.t1 7.501
R14 d_vcm_phi1_b d_vcm_phi1_b.n1 25.8349
R15 d_vcm_phi1_b d_vcm_phi1_b.n0 10.239
R16 d_vcm_phi1_b.n0 d_vcm_phi1_b.t0 9.55769
R17 d_vcm_phi1_b.n1 d_vcm_phi1_b.t3 7.84785
R18 d_vcm_phi1_b.n1 d_vcm_phi1_b.t2 7.51422
R19 d_vcm_phi1_b.n0 d_vcm_phi1_b.t1 5.68753
R20 d_qclk d_qclk.n17 80.2314
R21 d_qclk.n0 d_qclk.t18 54.754
R22 d_qclk.n0 d_qclk.t2 51.663
R23 d_qclk.n3 d_qclk.t17 33.3831
R24 d_qclk.n6 d_qclk.t14 33.3831
R25 d_qclk.n9 d_qclk.t11 33.3831
R26 d_qclk.n12 d_qclk.t8 33.3831
R27 d_qclk.n15 d_qclk.t5 33.3831
R28 d_qclk.n2 d_qclk.t20 25.9068
R29 d_qclk.n13 d_qclk.t7 25.9068
R30 d_qclk.n7 d_qclk.t13 25.777
R31 d_qclk.n4 d_qclk.t16 25.7752
R32 d_qclk.n10 d_qclk.t10 25.7752
R33 d_qclk.n17 d_qclk.t4 24.0391
R34 d_qclk.n2 d_qclk.t19 24.0056
R35 d_qclk.n4 d_qclk.t15 24.0056
R36 d_qclk.n7 d_qclk.t12 24.0056
R37 d_qclk.n10 d_qclk.t9 24.0056
R38 d_qclk.n13 d_qclk.t6 24.0056
R39 d_qclk.n16 d_qclk.t3 24.0056
R40 d_qclk d_qclk.n1 14.257
R41 d_qclk.n3 d_qclk.n2 13.1262
R42 d_qclk.n16 d_qclk.n15 12.5876
R43 d_qclk.n8 d_qclk.n7 9.98522
R44 d_qclk.n5 d_qclk.n4 9.97972
R45 d_qclk.n11 d_qclk.n10 9.97972
R46 d_qclk.n14 d_qclk.n13 9.97579
R47 d_qclk.n1 d_qclk.t1 8.99729
R48 d_qclk d_qclk.n0 8.46531
R49 d_qclk.n1 d_qclk.t0 5.6905
R50 d_qclk.n12 d_qclk.n11 3.1509
R51 d_qclk.n9 d_qclk.n8 3.1509
R52 d_qclk.n6 d_qclk.n5 3.1509
R53 d_qclk.n15 d_qclk.n14 3.0409
R54 d_qclk.n14 d_qclk.n12 2.4909
R55 d_qclk.n11 d_qclk.n9 2.4909
R56 d_qclk.n8 d_qclk.n6 2.4909
R57 d_qclk.n5 d_qclk.n3 2.4909
R58 d_qclk.n17 d_qclk.n16 1.74977
R59 d_dith[2] d_dith[2].n1 96.9552
R60 d_dith[2].n0 d_dith[2].t2 24.608
R61 d_dith[2].n0 d_dith[2].t3 24.0205
R62 d_dith[2] d_dith[2].n0 21.9683
R63 d_dith[2].n1 d_dith[2].t0 9.17768
R64 d_dith[2].n1 d_dith[2].t1 5.69802
R65 d_dith[0] d_dith[0].n0 81.7438
R66 d_dith[0] d_dith[0].n1 56.271
R67 d_dith[0].n1 d_dith[0].t2 24.9719
R68 d_dith[0].n1 d_dith[0].t3 24.0145
R69 d_dith[0].n0 d_dith[0].t1 9.17768
R70 d_dith[0].n0 d_dith[0].t0 5.69802
R71 do_q_dec do_q_dec.n0 64.6874
R72 do_q_dec.n0 do_q_dec.t0 8.77663
R73 do_q_dec.n0 do_q_dec.t1 6.02289
R74 do_q do_q.n0 51.655
R75 do_q.n0 do_q.t1 8.77663
R76 do_q.n0 do_q.t0 6.02289
R77 do_q_b do_q_b.n0 56.3763
R78 do_q_b.n0 do_q_b.t1 8.77663
R79 do_q_b.n0 do_q_b.t0 6.02289
R80 d_dith[1] d_dith[1].n1 81.2066
R81 d_dith[1].n0 d_dith[1].t2 24.6844
R82 d_dith[1].n0 d_dith[1].t3 24.0205
R83 d_dith[1].n1 d_dith[1].t0 9.17768
R84 d_dith[1].n1 d_dith[1].t1 5.69802
R85 d_dith[1] d_dith[1].n0 3.6547
R86 d_amp_s[2].n0 d_amp_s[2].t2 80.693
R87 d_amp_s[2].n2 d_amp_s[2].t4 42.7097
R88 d_amp_s[2].n0 d_amp_s[2].t3 42.3148
R89 d_amp_s[2] d_amp_s[2].n2 37.4469
R90 d_amp_s[2] d_amp_s[2].n0 24.4355
R91 d_amp_s[2].n1 d_amp_s[2].t0 9.48964
R92 d_amp_s[2].n2 d_amp_s[2].n1 9.04249
R93 d_amp_s[2].n1 d_amp_s[2].t1 5.65369
R94 d_amp_s_b[2].n0 d_amp_s_b[2].t2 99.0312
R95 d_amp_s_b[2] d_amp_s_b[2].n1 46.6759
R96 d_amp_s_b[2].n0 d_amp_s_b[2].t3 42.1458
R97 d_amp_s_b[2] d_amp_s_b[2].n0 23.9579
R98 d_amp_s_b[2].n1 d_amp_s_b[2].t1 8.92935
R99 d_amp_s_b[2].n1 d_amp_s_b[2].t0 5.98532
R100 d_amp_s[3].n0 d_amp_s[3].t2 113.832
R101 d_amp_s[3].n2 d_amp_s[3].t4 43.3697
R102 d_amp_s[3] d_amp_s[3].n0 43.3042
R103 d_amp_s[3] d_amp_s[3].n2 38.7748
R104 d_amp_s[3].n0 d_amp_s[3].t3 24.0132
R105 d_amp_s[3].n1 d_amp_s[3].t0 9.48964
R106 d_amp_s[3].n2 d_amp_s[3].n1 9.04249
R107 d_amp_s[3].n1 d_amp_s[3].t1 5.65369
R108 d_amp_s_b[3].n0 d_amp_s_b[3].t2 72.2608
R109 d_amp_s_b[3] d_amp_s_b[3].n1 47.9032
R110 d_amp_s_b[3] d_amp_s_b[3].n0 35.5519
R111 d_amp_s_b[3].n0 d_amp_s_b[3].t3 34.9536
R112 d_amp_s_b[3].n1 d_amp_s_b[3].t0 8.92935
R113 d_amp_s_b[3].n1 d_amp_s_b[3].t1 5.98532
R114 d_amp_s[1].n0 d_amp_s[1].t2 118.093
R115 d_amp_s[1] d_amp_s[1].n0 60.0043
R116 d_amp_s[1] d_amp_s[1].n2 59.4237
R117 d_amp_s[1].n2 d_amp_s[1].n1 27.7016
R118 d_amp_s[1].n2 d_amp_s[1].t4 24.182
R119 d_amp_s[1].n0 d_amp_s[1].t3 24.0132
R120 d_amp_s[1].n1 d_amp_s[1].t0 9.49007
R121 d_amp_s[1].n1 d_amp_s[1].t1 5.65426
R122 d_amp_s_b[1].n0 d_amp_s_b[1].t2 99.6634
R123 d_amp_s_b[1] d_amp_s_b[1].n1 50.3521
R124 d_amp_s_b[1].n0 d_amp_s_b[1].t3 43.3848
R125 d_amp_s_b[1] d_amp_s_b[1].n0 25.4695
R126 d_amp_s_b[1].n1 d_amp_s_b[1].t1 8.92935
R127 d_amp_s_b[1].n1 d_amp_s_b[1].t0 5.98532
R128 d_amp_s[0] d_amp_s[0].n2 63.5806
R129 d_amp_s[0].n0 d_amp_s[0].t2 46.2788
R130 d_amp_s[0].n2 d_amp_s[0].n1 27.4623
R131 d_amp_s[0].n0 d_amp_s[0].t3 24.2058
R132 d_amp_s[0].n2 d_amp_s[0].t4 24.1942
R133 d_amp_s[0] d_amp_s[0].n0 22.0633
R134 d_amp_s[0].n1 d_amp_s[0].t1 9.48964
R135 d_amp_s[0].n1 d_amp_s[0].t0 5.65369
R136 d_amp_s_b[0].n0 d_amp_s_b[0].t2 112.576
R137 d_amp_s_b[0] d_amp_s_b[0].n1 52.6761
R138 d_amp_s_b[0].n0 d_amp_s_b[0].t3 33.5346
R139 d_amp_s_b[0] d_amp_s_b[0].n0 30.7079
R140 d_amp_s_b[0].n1 d_amp_s_b[0].t1 8.92935
R141 d_amp_s_b[0].n1 d_amp_s_b[0].t0 5.98532
R142 vi_esd vi_esd.n12 104.117
R143 vi_esd.n10 vi_esd.n8 16.2545
R144 vi_esd.n10 vi_esd.n9 15.8236
R145 vi_esd.n11 vi_esd.t8 9.53317
R146 vi_esd.n7 vi_esd.t6 6.41573
R147 vi_esd.n1 vi_esd.t2 6.41384
R148 vi_esd vi_esd.n10 6.33487
R149 vi_esd.n1 vi_esd.t10 5.90366
R150 vi_esd.n7 vi_esd.t7 5.90366
R151 vi_esd.n4 vi_esd.t1 3.79442
R152 vi_esd.n2 vi_esd.t4 3.79253
R153 vi_esd.n6 vi_esd.t5 3.46449
R154 vi_esd.n0 vi_esd.t9 3.46316
R155 vi_esd.n4 vi_esd.t0 3.28126
R156 vi_esd.n2 vi_esd.t12 3.28126
R157 vi_esd.n11 vi_esd.t13 3.26285
R158 vi_esd.n12 vi_esd.t14 1.60459
R159 vi_esd.n1 vi_esd.n0 0.0489674
R160 vi_esd.n5 vi_esd.n4 0.0474976
R161 vi_esd.n3 vi_esd.n2 0.0489674
R162 vi_esd.n7 vi_esd.n6 0.0474976
R163 vi_esd.n12 vi_esd.n11 0.351901
R164 vi_esd.n5 vi_esd.t3 6.08571
R165 vi_esd.n3 vi_esd.t11 6.08557
R166 vi_esd.n9 vi_esd.n6 4.63926
R167 vi_esd.n8 vi_esd.n5 6.04726
R168 vi_esd.n9 vi_esd.n3 6.04741
R169 vi_esd.n8 vi_esd.n0 4.63941
R170 d_qi.n0 d_qi.t4 45.1373
R171 d_qi.n3 d_qi.t3 42.7012
R172 d_qi.n0 d_qi.t5 36.8816
R173 d_qi.n4 d_qi.t6 28.94
R174 d_qi.n5 d_qi.t9 28.94
R175 d_qi.n0 d_qi.n2 27.4785
R176 d_qi.n4 d_qi.t7 22.3968
R177 d_qi.n5 d_qi.t8 22.3968
R178 d_qi.n2 d_qi.t1 17.0005
R179 d_qi d_qi.n3 11.6977
R180 d_qi.n1 d_qi.t2 9.08036
R181 d_qi.n1 d_qi.t0 8.57036
R182 d_qi d_qi.n6 4.96935
R183 d_qi.n3 d_qi.n0 2.0531
R184 d_qi.n6 d_qi.n4 2.00933
R185 d_qi.n2 d_qi.n1 1.27762
R186 d_qi.n6 d_qi.n5 1.14753
R187 d_qi_b.n5 d_qi_b.t5 44.6198
R188 d_qi_b.n6 d_qi_b.t3 44.0536
R189 d_qi_b.n0 d_qi_b.t6 29.3366
R190 d_qi_b.n1 d_qi_b.t9 29.3366
R191 d_qi_b.n5 d_qi_b.n4 27.2528
R192 d_qi_b.n7 d_qi_b.t4 25.5328
R193 d_qi_b.n0 d_qi_b.t7 21.0668
R194 d_qi_b.n1 d_qi_b.t8 21.0668
R195 d_qi_b d_qi_b.n7 19.4921
R196 d_qi_b.n4 d_qi_b.t2 17.0005
R197 d_qi_b.n7 d_qi_b.n6 10.8683
R198 d_qi_b.n3 d_qi_b.t0 9.08036
R199 d_qi_b.n3 d_qi_b.t1 8.57036
R200 d_qi_b d_qi_b.n2 4.81762
R201 d_qi_b.n2 d_qi_b.n1 2.5525
R202 d_qi_b.n2 d_qi_b.n0 1.69071
R203 d_qi_b.n4 d_qi_b.n3 1.27762
R204 d_qi_b.n6 d_qi_b.n5 1.1951
R205 d_qout_en d_qout_en.n1 202.464
R206 d_qout_en d_qout_en.n0 51.4586
R207 d_qout_en.n0 d_qout_en.t2 24.8064
R208 d_qout_en.n0 d_qout_en.t3 24.0296
R209 d_qout_en.n1 d_qout_en.t1 9.23972
R210 d_qout_en.n1 d_qout_en.t0 5.65507
R211 d_rst_b d_rst_b.t2 86.0319
R212 d_rst_b d_rst_b.n0 63.8165
R213 d_rst_b.n0 d_rst_b.t0 9.23972
R214 d_rst_b.n0 d_rst_b.t1 5.65507
R215 d_dith_en.n1 d_dith_en.t34 77.6036
R216 d_dith_en.n18 d_dith_en.n0 76.6762
R217 d_dith_en.n14 d_dith_en.t10 45.9967
R218 d_dith_en.n5 d_dith_en.t28 45.9914
R219 d_dith_en.n11 d_dith_en.t16 45.9862
R220 d_dith_en.n8 d_dith_en.t22 45.9809
R221 d_dith_en.n3 d_dith_en.t4 45.9564
R222 d_dith_en.n18 d_dith_en.n17 44.2922
R223 d_dith_en.n1 d_dith_en.t35 43.459
R224 d_dith_en.t4 d_dith_en.t7 33.4028
R225 d_dith_en.t2 d_dith_en.t5 33.4028
R226 d_dith_en.t33 d_dith_en.t38 33.4028
R227 d_dith_en.t32 d_dith_en.t36 33.4028
R228 d_dith_en.t27 d_dith_en.t30 33.4028
R229 d_dith_en.t28 d_dith_en.t31 33.4028
R230 d_dith_en.t26 d_dith_en.t29 33.4028
R231 d_dith_en.t21 d_dith_en.t24 33.4028
R232 d_dith_en.t22 d_dith_en.t25 33.4028
R233 d_dith_en.t20 d_dith_en.t23 33.4028
R234 d_dith_en.t15 d_dith_en.t18 33.4028
R235 d_dith_en.t16 d_dith_en.t19 33.4028
R236 d_dith_en.t14 d_dith_en.t17 33.4028
R237 d_dith_en.t9 d_dith_en.t12 33.4028
R238 d_dith_en.t10 d_dith_en.t13 33.4028
R239 d_dith_en.t8 d_dith_en.t11 33.4028
R240 d_dith_en.t3 d_dith_en.t6 33.4028
R241 d_dith_en.n4 d_dith_en.t32 25.7169
R242 d_dith_en.n2 d_dith_en.t37 24.0863
R243 d_dith_en.n4 d_dith_en.t33 24.0661
R244 d_dith_en.n6 d_dith_en.t27 24.0544
R245 d_dith_en.n15 d_dith_en.t9 24.0544
R246 d_dith_en.n9 d_dith_en.t21 24.0426
R247 d_dith_en.n12 d_dith_en.t15 24.0424
R248 d_dith_en.n11 d_dith_en.t14 24.038
R249 d_dith_en.n3 d_dith_en.t2 24.0368
R250 d_dith_en.n5 d_dith_en.t26 24.0368
R251 d_dith_en.n8 d_dith_en.t20 24.0368
R252 d_dith_en.n14 d_dith_en.t8 24.0368
R253 d_dith_en.n0 d_dith_en.t3 24.0368
R254 d_dith_en d_dith_en.n18 20.0862
R255 d_dith_en.n2 d_dith_en.n1 15.4886
R256 d_dith_en.n0 d_dith_en.n16 14.6809
R257 d_dith_en.n7 d_dith_en.n4 14.6809
R258 d_dith_en.n17 d_dith_en.t0 9.23972
R259 d_dith_en.n16 d_dith_en.n15 9.0005
R260 d_dith_en.n13 d_dith_en.n12 9.0005
R261 d_dith_en.n10 d_dith_en.n9 9.0005
R262 d_dith_en.n7 d_dith_en.n6 9.0005
R263 d_dith_en d_dith_en.n2 7.53826
R264 d_dith_en.n16 d_dith_en.n13 5.6809
R265 d_dith_en.n13 d_dith_en.n10 5.6809
R266 d_dith_en.n10 d_dith_en.n7 5.6809
R267 d_dith_en.n17 d_dith_en.t1 5.65507
R268 d_dith_en.n6 d_dith_en.n5 1.78382
R269 d_dith_en.n15 d_dith_en.n14 1.78382
R270 d_dith_en.n0 d_dith_en.n3 1.7496
R271 d_dith_en.n12 d_dith_en.n11 1.68845
R272 d_dith_en.n9 d_dith_en.n8 1.68822
R273 vcm_esd.n22 vcm_esd.n20 89.1372
R274 vcm_esd vcm_esd.n22 51.5192
R275 vcm_esd.n22 vcm_esd 28.1899
R276 vcm_esd.n12 vcm_esd.n10 21.7891
R277 vcm_esd.t25 vcm_esd.t22 21.5766
R278 vcm_esd.n21 vcm_esd.t25 18.5126
R279 vcm_esd.n8 vcm_esd.t14 17.6958
R280 vcm_esd.n15 vcm_esd.t2 17.6958
R281 vcm_esd.n8 vcm_esd.t15 17.1724
R282 vcm_esd.n15 vcm_esd.t3 17.1724
R283 vcm_esd vcm_esd.n18 16.8037
R284 vcm_esd.n18 vcm_esd.n14 11.1642
R285 vcm_esd.n18 vcm_esd.n17 10.6254
R286 vcm_esd.n19 vcm_esd.t16 9.53317
R287 vcm_esd.n12 vcm_esd.n11 9.11282
R288 vcm_esd.n14 vcm_esd.n13 9.11282
R289 vcm_esd.n4 vcm_esd.t11 6.4153
R290 vcm_esd.n2 vcm_esd.t7 6.4134
R291 vcm_esd.n6 vcm_esd.t6 6.08571
R292 vcm_esd.n0 vcm_esd.t10 6.08514
R293 vcm_esd.n4 vcm_esd.t17 5.90323
R294 vcm_esd.n2 vcm_esd.t20 5.90323
R295 vcm_esd.n9 vcm_esd.t13 5.114
R296 vcm_esd.n16 vcm_esd.t1 5.114
R297 vcm_esd.n10 vcm_esd.t12 4.2226
R298 vcm_esd.n17 vcm_esd.t0 4.2226
R299 vcm_esd.n7 vcm_esd.t4 3.7949
R300 vcm_esd.n1 vcm_esd.t9 3.793
R301 vcm_esd.n1 vcm_esd.t8 3.28217
R302 vcm_esd.n7 vcm_esd.t5 3.28217
R303 vcm_esd.n19 vcm_esd.t23 3.26285
R304 vcm_esd.n21 vcm_esd.t19 3.25609
R305 vcm_esd.n20 vcm_esd.t24 1.60459
R306 vcm_esd vcm_esd.n21 1.29205
R307 vcm_esd.n14 vcm_esd.n12 1.22643
R308 vcm_esd.n1 vcm_esd.n0 0.0489674
R309 vcm_esd.n5 vcm_esd.n4 0.0474976
R310 vcm_esd.n3 vcm_esd.n2 0.0489674
R311 vcm_esd.n7 vcm_esd.n6 0.0474976
R312 vcm_esd.n20 vcm_esd.n19 0.351901
R313 vcm_esd.n10 vcm_esd.n9 0.311153
R314 vcm_esd.n17 vcm_esd.n16 0.311153
R315 vcm_esd.n9 vcm_esd.n8 0.12425
R316 vcm_esd.n16 vcm_esd.n15 0.12425
R317 vcm_esd.n5 vcm_esd.t18 3.46421
R318 vcm_esd.n3 vcm_esd.t21 3.46407
R319 vcm_esd.n13 vcm_esd.n6 6.04726
R320 vcm_esd.n11 vcm_esd.n5 4.63926
R321 vcm_esd.n13 vcm_esd.n3 4.63941
R322 vcm_esd.n11 vcm_esd.n0 6.04741
R323 d_phi2 d_phi2.n1 53.2129
R324 d_phi2.n6 d_phi2.n0 48.1571
R325 d_phi2.n7 d_phi2.t4 36.1122
R326 d_phi2.n0 d_phi2.t12 29.1484
R327 d_phi2.n5 d_phi2.t5 26.1717
R328 d_phi2.n4 d_phi2.t7 25.4555
R329 d_phi2.n7 d_phi2.t3 24.8105
R330 d_phi2.n1 d_phi2.t2 24.1914
R331 d_phi2.n2 d_phi2.t11 22.9159
R332 d_phi2.n2 d_phi2.t9 22.3879
R333 d_phi2.n4 d_phi2.t6 21.7899
R334 d_phi2.n1 d_phi2.n8 18.1596
R335 d_phi2.n0 d_phi2.t14 17.7435
R336 d_phi2.n3 d_phi2.t13 16.7755
R337 d_phi2.n0 d_phi2.t10 16.5327
R338 d_phi2.n3 d_phi2.t8 16.5327
R339 d_phi2.n0 d_phi2.n3 13.0485
R340 d_phi2.n8 d_phi2.t0 9.2649
R341 d_phi2.n8 d_phi2.t1 5.64978
R342 d_phi2.n0 d_phi2.n2 5.39428
R343 d_phi2.n1 d_phi2.n7 5.11802
R344 d_phi2.n6 d_phi2.n5 4.5005
R345 d_phi2.n5 d_phi2.n4 4.27305
R346 d_phi2 d_phi2.n6 1.07625
R347 d_phi1 d_phi1.n7 68.0772
R348 d_phi1 d_phi1.n1 48.1526
R349 d_phi1.n7 d_phi1.t2 31.4423
R350 d_phi1.n1 d_phi1.t6 29.6855
R351 d_phi1.n5 d_phi1.t5 26.3234
R352 d_phi1.n4 d_phi1.t3 25.6072
R353 d_phi1.n2 d_phi1.t8 25.1824
R354 d_phi1.n2 d_phi1.t12 24.6544
R355 d_phi1.n3 d_phi1.t9 22.8231
R356 d_phi1.n3 d_phi1.t11 22.2951
R357 d_phi1.n4 d_phi1.t4 21.9416
R358 d_phi1.n0 d_phi1.t10 16.5327
R359 d_phi1.n1 d_phi1.t7 16.5327
R360 d_phi1.n6 d_phi1.t0 8.53084
R361 d_phi1.n6 d_phi1.t1 6.38352
R362 d_phi1 d_phi1.n5 5.42452
R363 d_phi1.n0 d_phi1.n2 4.87075
R364 d_phi1.n7 d_phi1.n6 4.83994
R365 d_phi1.n0 d_phi1.n3 4.5005
R366 d_phi1.n5 d_phi1.n4 4.27305
R367 d_phi1.n1 d_phi1.n0 2.31291
R368 ibias_200n ibias_200n.n1 48.5286
R369 ibias_200n ibias_200n.t5 37.674
R370 ibias_200n.n0 ibias_200n.n2 26.3305
R371 ibias_200n.n2 ibias_200n.t2 26.2673
R372 ibias_200n.n3 ibias_200n.t1 23.1331
R373 ibias_200n.n3 ibias_200n.t0 23.1331
R374 ibias_200n.n4 ibias_200n.t4 23.1331
R375 ibias_200n.n4 ibias_200n.t3 23.1331
R376 ibias_200n.n0 ibias_200n.t6 17.1184
R377 ibias_200n.n0 ibias_200n.t7 17.1184
R378 ibias_200n.n1 ibias_200n.t8 17.1184
R379 ibias_200n.n1 ibias_200n.t9 17.1184
R380 ibias_200n.n2 ibias_200n.n3 5.05585
R381 ibias_200n.n2 ibias_200n.n4 4.75241
R382 ibias_200n.n1 ibias_200n.n0 1.21139
R383 vo_n.n3 vo_n.t24 58.8877
R384 vo_n.n13 vo_n.t14 32.8037
R385 vo_n.n13 vo_n.t13 30.7524
R386 vo_n vo_n.n7 30.0233
R387 vo_n.n14 vo_n.t12 26.2524
R388 vo_n.n16 vo_n.n8 19.7387
R389 vo_n.n0 vo_n.t2 17.6844
R390 vo_n.n1 vo_n.t1 17.6843
R391 vo_n.n1 vo_n.t0 17.1845
R392 vo_n.n0 vo_n.t3 17.1724
R393 vo_n.n16 vo_n.n15 10.8365
R394 vo_n.n9 vo_n.t18 7.67967
R395 vo_n.n12 vo_n.t22 6.94063
R396 vo_n.n14 vo_n.n13 6.55181
R397 vo_n.n10 vo_n.t20 6.39898
R398 vo_n.n11 vo_n.t21 6.39898
R399 vo_n.n9 vo_n.t19 6.39898
R400 vo_n.n8 vo_n.n0 6.12698
R401 vo_n.n15 vo_n.n12 6.03142
R402 vo_n.n0 vo_n.t23 5.10222
R403 vo_n.n1 vo_n.t4 5.09873
R404 vo_n.n1 vo_n.t8 5.10587
R405 vo_n.n1 vo_n.t5 4.59031
R406 vo_n.n7 vo_n.n6 4.53533
R407 vo_n.n3 vo_n.n2 4.53533
R408 vo_n.n5 vo_n.n4 4.53533
R409 vo_n.n4 vo_n.t16 3.35719
R410 vo_n.n6 vo_n.t17 3.35719
R411 vo_n.n2 vo_n.t15 3.35719
R412 vo_n.n6 vo_n.t11 2.00949
R413 vo_n.n2 vo_n.t9 2.00949
R414 vo_n.n4 vo_n.t10 2.00943
R415 vo_n.n12 vo_n.n11 1.95926
R416 vo_n.n10 vo_n.n9 1.94257
R417 vo_n.n11 vo_n.n10 1.28105
R418 vo_n vo_n.n16 0.448086
R419 vo_n.n15 vo_n.n14 0.399556
R420 vo_n.n5 vo_n.n3 0.310017
R421 vo_n.n7 vo_n.n5 0.310017
R422 vo_n.n0 vo_n.t6 17.686
R423 vo_n.n0 vo_n.t7 4.67729
R424 vo_n.n8 vo_n.n1 4.62537
R425 vo_p.n12 vo_p.t24 58.8877
R426 vo_p.n7 vo_p.t6 32.8037
R427 vo_p.n7 vo_p.t7 30.7524
R428 vo_p vo_p.n16 30.0878
R429 vo_p.n8 vo_p.t8 26.2524
R430 vo_p.n10 vo_p.n2 19.7387
R431 vo_p.n0 vo_p.t0 17.686
R432 vo_p.n1 vo_p.t3 17.6825
R433 vo_p.n1 vo_p.t14 17.6879
R434 vo_p.n0 vo_p.t1 17.1829
R435 vo_p.n1 vo_p.t2 17.1724
R436 vo_p.n10 vo_p.n9 10.8365
R437 vo_p.n3 vo_p.t22 7.78172
R438 vo_p.n6 vo_p.t18 7.04396
R439 vo_p.n8 vo_p.n7 6.55181
R440 vo_p.n3 vo_p.t21 6.50117
R441 vo_p.n5 vo_p.t19 6.50117
R442 vo_p.n4 vo_p.t20 6.50117
R443 vo_p.n2 vo_p.n1 6.12698
R444 vo_p.n9 vo_p.n6 5.57625
R445 vo_p.n0 vo_p.t23 5.10063
R446 vo_p.n1 vo_p.t4 5.1005
R447 vo_p.n0 vo_p.t13 4.59031
R448 vo_p.n12 vo_p.n11 4.53533
R449 vo_p.n16 vo_p.n15 4.53533
R450 vo_p.n14 vo_p.n13 4.53532
R451 vo_p.n13 vo_p.t10 3.35719
R452 vo_p.n11 vo_p.t11 3.35719
R453 vo_p.n15 vo_p.t9 3.35719
R454 vo_p.n11 vo_p.t16 2.00943
R455 vo_p.n15 vo_p.t17 2.00943
R456 vo_p.n13 vo_p.t15 2.00915
R457 vo_p.n6 vo_p.n5 1.95926
R458 vo_p.n4 vo_p.n3 1.94257
R459 vo_p.n5 vo_p.n4 1.28105
R460 vo_p vo_p.n10 0.630155
R461 vo_p.n9 vo_p.n8 0.399556
R462 vo_p.n16 vo_p.n14 0.310017
R463 vo_p.n14 vo_p.n12 0.310017
R464 vo_p.n0 vo_p.t12 5.10397
R465 vo_p.n1 vo_p.t5 4.67875
R466 vo_p.n2 vo_p.n0 4.62553
R467 d_ena.n9 d_ena.n7 153.679
R468 d_ena.n7 d_ena 98.7092
R469 d_ena.n10 d_ena.n2 74.1752
R470 d_ena.n3 d_ena.t8 64.2667
R471 d_ena.n10 d_ena.n9 53.2533
R472 d_ena d_ena.n5 37.2474
R473 d_ena.n3 d_ena.t6 33.5662
R474 d_ena.n5 d_ena.n3 33.5431
R475 d_ena.n1 d_ena.t5 30.5406
R476 d_ena.n7 d_ena.n6 27.3727
R477 d_ena.n2 d_ena.t10 27.3625
R478 d_ena.n8 d_ena.t14 26.9045
R479 d_ena.n6 d_ena.t2 24.9593
R480 d_ena.n6 d_ena.t3 24.1732
R481 d_ena.n8 d_ena.t11 22.7472
R482 d_ena d_ena.t12 21.5943
R483 d_ena.n1 d_ena.t4 17.5706
R484 d_ena d_ena.t13 16.5747
R485 d_ena.n0 d_ena.t0 15.9604
R486 d_ena.n0 d_ena.t1 14.698
R487 d_ena.n9 d_ena.n0 11.5577
R488 d_ena.n0 d_ena.n8 10.3055
R489 d_ena d_ena.n10 10.1934
R490 d_ena.n4 d_ena.t7 8.27072
R491 d_ena.n4 d_ena.t9 7.501
R492 d_ena.n5 d_ena.n4 4.53324
R493 d_ena.n2 d_ena.n1 3.99696
R494 vdd.n1494 vdd.n1200 61.7019
R495 vdd.n536 vdd.t659 61.424
R496 vdd.n541 vdd.t658 61.424
R497 vdd.n624 vdd.n623 45.7553
R498 vdd.n1495 vdd.n1194 45.3569
R499 vdd.n537 vdd.t763 43.0832
R500 vdd.n542 vdd.t580 43.0832
R501 vdd.n2075 vdd.n2074 39.923
R502 vdd.n2158 vdd.n2153 38.4237
R503 vdd.n540 vdd.t877 32.8698
R504 vdd.n540 vdd.t624 30.1624
R505 vdd.n535 vdd.t623 30.1614
R506 vdd.n1200 vdd.n1199 29.366
R507 vdd.n2091 vdd.n1988 29.2181
R508 vdd.n6 vdd.n2096 28.6791
R509 vdd.n1928 vdd.n1926 28.1275
R510 vdd.n1938 vdd.n1937 28.1275
R511 vdd.n1203 vdd.n1201 27.4639
R512 vdd.n1367 vdd.n1254 27.4639
R513 vdd.n2158 vdd.n2157 27.1308
R514 vdd.n193 vdd.n192 27.0893
R515 vdd.n1986 vdd.n1985 27.0005
R516 vdd.n1980 vdd.n1979 27.0005
R517 vdd.n1971 vdd.n1970 27.0005
R518 vdd.n1962 vdd.n1961 27.0005
R519 vdd.n1953 vdd.n1952 27.0005
R520 vdd.n1947 vdd.n1946 27.0005
R521 vdd.n419 vdd.n418 27.0005
R522 vdd.n410 vdd.n409 27.0005
R523 vdd.n401 vdd.n400 27.0005
R524 vdd.n392 vdd.n391 27.0005
R525 vdd.n383 vdd.n382 27.0005
R526 vdd.n374 vdd.n373 27.0005
R527 vdd.n365 vdd.n364 27.0005
R528 vdd.n356 vdd.n355 27.0005
R529 vdd.n347 vdd.n346 27.0005
R530 vdd.n338 vdd.n337 27.0005
R531 vdd.n329 vdd.n328 27.0005
R532 vdd.n320 vdd.n319 27.0005
R533 vdd.n2091 vdd.n2090 27.0005
R534 vdd.n1844 vdd.n1843 27.0005
R535 vdd.n1861 vdd.n1860 27.0005
R536 vdd.n1878 vdd.n1877 27.0005
R537 vdd.n1895 vdd.n1894 27.0005
R538 vdd.n1908 vdd.n1907 27.0005
R539 vdd.n1925 vdd.n1924 27.0005
R540 vdd.n1695 vdd.n1694 27.0005
R541 vdd.n1678 vdd.n1677 27.0005
R542 vdd.n1661 vdd.n1660 27.0005
R543 vdd.n1644 vdd.n1643 27.0005
R544 vdd.n1627 vdd.n1626 27.0005
R545 vdd.n1610 vdd.n1609 27.0005
R546 vdd.n1593 vdd.n1592 27.0005
R547 vdd.n1576 vdd.n1575 27.0005
R548 vdd.n1559 vdd.n1558 27.0005
R549 vdd.n1542 vdd.n1541 27.0005
R550 vdd.n1525 vdd.n1524 27.0005
R551 vdd.n1508 vdd.n1507 27.0005
R552 vdd.n202 vdd.t1786 26.8042
R553 vdd.n1232 vdd.n1222 24.874
R554 vdd.n1243 vdd.n1242 24.8721
R555 vdd.n1193 vdd.t1291 24.8718
R556 vdd.n533 vdd.t1354 24.3212
R557 vdd.n971 vdd.t1152 23.1331
R558 vdd.n887 vdd.t980 23.1331
R559 vdd.n720 vdd.t982 23.1331
R560 vdd.n795 vdd.t983 23.1331
R561 vdd.n980 vdd.t1188 22.3684
R562 vdd.n966 vdd.t1151 22.3684
R563 vdd.n891 vdd.t1187 22.3684
R564 vdd.n879 vdd.t1150 22.3684
R565 vdd.n1060 vdd.t1159 22.3684
R566 vdd.n1052 vdd.t984 22.3684
R567 vdd.n777 vdd.t986 22.3684
R568 vdd.n799 vdd.t1160 22.3684
R569 vdd.n538 vdd.n537 22.2407
R570 vdd.n657 vdd.t1370 21.5005
R571 vdd.n656 vdd.t1368 21.5005
R572 vdd.n655 vdd.t1366 21.5005
R573 vdd.n654 vdd.t1364 21.5005
R574 vdd.n653 vdd.t1362 21.5005
R575 vdd.n869 vdd.t1244 21.5005
R576 vdd.n868 vdd.t1242 21.5005
R577 vdd.n867 vdd.t1240 21.5005
R578 vdd.n750 vdd.t1239 21.5005
R579 vdd.n992 vdd.t1172 21.5005
R580 vdd.n993 vdd.t1170 21.5005
R581 vdd.n994 vdd.t1168 21.5005
R582 vdd.n995 vdd.t1167 21.5005
R583 vdd.n987 vdd.t1180 21.5005
R584 vdd.n986 vdd.t1178 21.5005
R585 vdd.n985 vdd.t1176 21.5005
R586 vdd.n984 vdd.t1175 21.5005
R587 vdd.n971 vdd.t1553 21.5005
R588 vdd.n898 vdd.t1166 21.5005
R589 vdd.n897 vdd.t1164 21.5005
R590 vdd.n896 vdd.t1162 21.5005
R591 vdd.n846 vdd.t1161 21.5005
R592 vdd.n951 vdd.t942 21.5005
R593 vdd.n952 vdd.t940 21.5005
R594 vdd.n953 vdd.t938 21.5005
R595 vdd.n954 vdd.t937 21.5005
R596 vdd.n946 vdd.t988 21.5005
R597 vdd.n945 vdd.t987 21.5005
R598 vdd.n942 vdd.t944 21.5005
R599 vdd.n941 vdd.t943 21.5005
R600 vdd.n910 vdd.t737 21.5005
R601 vdd.n909 vdd.t735 21.5005
R602 vdd.n908 vdd.t733 21.5005
R603 vdd.n857 vdd.t732 21.5005
R604 vdd.n923 vdd.t1604 21.5005
R605 vdd.n922 vdd.t1602 21.5005
R606 vdd.n921 vdd.t1600 21.5005
R607 vdd.n920 vdd.t1598 21.5005
R608 vdd.n919 vdd.t1596 21.5005
R609 vdd.n918 vdd.t1594 21.5005
R610 vdd.n917 vdd.t1592 21.5005
R611 vdd.n1014 vdd.t1529 21.5005
R612 vdd.n1013 vdd.t1527 21.5005
R613 vdd.n1012 vdd.t1525 21.5005
R614 vdd.n1011 vdd.t1523 21.5005
R615 vdd.n1010 vdd.t1521 21.5005
R616 vdd.n1009 vdd.t1519 21.5005
R617 vdd.n1008 vdd.t1517 21.5005
R618 vdd.n887 vdd.t1558 21.5005
R619 vdd.n1181 vdd.t1259 21.5005
R620 vdd.n1182 vdd.t1255 21.5005
R621 vdd.n1183 vdd.t1254 21.5005
R622 vdd.n1184 vdd.t1256 21.5005
R623 vdd.n1176 vdd.t936 21.5005
R624 vdd.n1175 vdd.t934 21.5005
R625 vdd.n1174 vdd.t932 21.5005
R626 vdd.n1173 vdd.t931 21.5005
R627 vdd.n825 vdd.t1186 21.5005
R628 vdd.n824 vdd.t1184 21.5005
R629 vdd.n823 vdd.t1182 21.5005
R630 vdd.n668 vdd.t1181 21.5005
R631 vdd.n1157 vdd.t1023 21.5005
R632 vdd.n1158 vdd.t1020 21.5005
R633 vdd.n1159 vdd.t1019 21.5005
R634 vdd.n1160 vdd.t1018 21.5005
R635 vdd.n1152 vdd.t579 21.5005
R636 vdd.n1151 vdd.t577 21.5005
R637 vdd.n1150 vdd.t575 21.5005
R638 vdd.n1149 vdd.t574 21.5005
R639 vdd.n814 vdd.t571 21.5005
R640 vdd.n813 vdd.t569 21.5005
R641 vdd.n812 vdd.t568 21.5005
R642 vdd.n680 vdd.t567 21.5005
R643 vdd.n1133 vdd.t731 21.5005
R644 vdd.n1134 vdd.t729 21.5005
R645 vdd.n1135 vdd.t727 21.5005
R646 vdd.n1136 vdd.t726 21.5005
R647 vdd.n1128 vdd.t586 21.5005
R648 vdd.n1127 vdd.t584 21.5005
R649 vdd.n1126 vdd.t581 21.5005
R650 vdd.n1125 vdd.t582 21.5005
R651 vdd.n757 vdd.t930 21.5005
R652 vdd.n756 vdd.t928 21.5005
R653 vdd.n755 vdd.t926 21.5005
R654 vdd.n692 vdd.t925 21.5005
R655 vdd.n1109 vdd.t1001 21.5005
R656 vdd.n1110 vdd.t999 21.5005
R657 vdd.n1111 vdd.t997 21.5005
R658 vdd.n1112 vdd.t996 21.5005
R659 vdd.n1104 vdd.t1437 21.5005
R660 vdd.n1103 vdd.t1435 21.5005
R661 vdd.n1102 vdd.t1433 21.5005
R662 vdd.n1101 vdd.t1431 21.5005
R663 vdd.n1100 vdd.t1429 21.5005
R664 vdd.n1099 vdd.t1427 21.5005
R665 vdd.n1098 vdd.t1425 21.5005
R666 vdd.n764 vdd.t684 21.5005
R667 vdd.n763 vdd.t682 21.5005
R668 vdd.n762 vdd.t680 21.5005
R669 vdd.n704 vdd.t679 21.5005
R670 vdd.n1080 vdd.t950 21.5005
R671 vdd.n1081 vdd.t949 21.5005
R672 vdd.n1084 vdd.t1011 21.5005
R673 vdd.n1085 vdd.t1010 21.5005
R674 vdd.n1075 vdd.t956 21.5005
R675 vdd.n1074 vdd.t954 21.5005
R676 vdd.n1073 vdd.t952 21.5005
R677 vdd.n1072 vdd.t951 21.5005
R678 vdd.n772 vdd.t1017 21.5005
R679 vdd.n771 vdd.t1014 21.5005
R680 vdd.n770 vdd.t1013 21.5005
R681 vdd.n716 vdd.t1012 21.5005
R682 vdd.n720 vdd.t1470 21.5005
R683 vdd.n1040 vdd.t1009 21.5005
R684 vdd.n1041 vdd.t1007 21.5005
R685 vdd.n1042 vdd.t1005 21.5005
R686 vdd.n1043 vdd.t1004 21.5005
R687 vdd.n1035 vdd.t1158 21.5005
R688 vdd.n1034 vdd.t1156 21.5005
R689 vdd.n1033 vdd.t1154 21.5005
R690 vdd.n1032 vdd.t1153 21.5005
R691 vdd.n785 vdd.t994 21.5005
R692 vdd.n784 vdd.t992 21.5005
R693 vdd.n783 vdd.t990 21.5005
R694 vdd.n732 vdd.t989 21.5005
R695 vdd.n743 vdd.t1512 21.5005
R696 vdd.n742 vdd.t1510 21.5005
R697 vdd.n741 vdd.t1508 21.5005
R698 vdd.n740 vdd.t1506 21.5005
R699 vdd.n739 vdd.t1504 21.5005
R700 vdd.n738 vdd.t1502 21.5005
R701 vdd.n737 vdd.t1500 21.5005
R702 vdd.n795 vdd.t1475 21.5005
R703 vdd.n925 vdd.n924 21.1749
R704 vdd.n537 vdd.n536 19.8287
R705 vdd.n542 vdd.n541 19.8287
R706 vdd.n2109 vdd.t1640 19.4609
R707 vdd.n1494 vdd.n1493 18.938
R708 vdd.n1208 vdd.n1204 18.3388
R709 vdd.n1211 vdd.n1210 18.331
R710 vdd.n535 vdd.n534 18.1191
R711 vdd.n2107 vdd.t1617 17.8805
R712 vdd.n636 vdd.t1738 17.809
R713 vdd.n646 vdd.t1737 17.809
R714 vdd.n2115 vdd.t1133 17.7509
R715 vdd.n2105 vdd.t602 17.7086
R716 vdd.n241 vdd.t1052 17.4748
R717 vdd.n248 vdd.t879 17.4199
R718 vdd.n250 vdd.t1056 17.4199
R719 vdd.n245 vdd.t1111 17.4199
R720 vdd.n243 vdd.t1112 17.4199
R721 vdd.n257 vdd.t1113 17.4199
R722 vdd.n259 vdd.t904 17.4199
R723 vdd.n263 vdd.t859 17.4199
R724 vdd.n265 vdd.t748 17.4199
R725 vdd.n238 vdd.t1644 17.4199
R726 vdd.n236 vdd.t722 17.4199
R727 vdd.n272 vdd.t518 17.4199
R728 vdd.n2122 vdd.t1247 17.4199
R729 vdd.n2124 vdd.t1126 17.4199
R730 vdd.n2012 vdd.t921 17.3693
R731 vdd.n4 vdd.t1086 17.4404
R732 vdd.n2076 vdd.t686 17.3693
R733 vdd.n2082 vdd.t710 17.3693
R734 vdd.n0 vdd.t1062 17.4404
R735 vdd.n2033 vdd.t1027 17.3693
R736 vdd.n2033 vdd.t751 17.3693
R737 vdd.n2038 vdd.t715 17.3693
R738 vdd.n2038 vdd.t1068 17.3693
R739 vdd.n2046 vdd.t959 17.3693
R740 vdd.n2046 vdd.t742 17.3693
R741 vdd.n2071 vdd.t910 17.3693
R742 vdd.n2071 vdd.t1093 17.3693
R743 vdd.n2065 vdd.t512 17.3693
R744 vdd.n2065 vdd.t595 17.3693
R745 vdd.n2059 vdd.t634 17.3693
R746 vdd.n2059 vdd.t633 17.3693
R747 vdd.n2149 vdd.t600 17.3693
R748 vdd.n1789 vdd.t531 17.3585
R749 vdd.n1737 vdd.t717 17.3585
R750 vdd.n1829 vdd.t665 17.3519
R751 vdd.n2013 vdd.t1209 17.3517
R752 vdd.n2015 vdd.t649 17.3517
R753 vdd.n2078 vdd.t668 17.3517
R754 vdd.n2083 vdd.t957 17.3517
R755 vdd.n2086 vdd.t1619 17.3517
R756 vdd.n2035 vdd.t1193 17.3517
R757 vdd.n2034 vdd.t995 17.3517
R758 vdd.n2042 vdd.t708 17.3517
R759 vdd.n2041 vdd.t1149 17.3517
R760 vdd.n2048 vdd.t589 17.3517
R761 vdd.n2047 vdd.t738 17.3517
R762 vdd.n2056 vdd.t591 17.3517
R763 vdd.n2055 vdd.t709 17.3517
R764 vdd.n2058 vdd.t907 17.3517
R765 vdd.n2057 vdd.t1131 17.3517
R766 vdd.n2052 vdd.t621 17.3517
R767 vdd.n2051 vdd.t1138 17.3517
R768 vdd.n2150 vdd.t1643 17.3517
R769 vdd.n543 vdd.n542 17.3479
R770 vdd.n433 vdd.t862 17.3326
R771 vdd.n7 vdd.t858 17.3326
R772 vdd.n1819 vdd.t689 17.3326
R773 vdd.n1807 vdd.t615 17.3326
R774 vdd.n1794 vdd.t530 17.3326
R775 vdd.n10 vdd.t667 17.3326
R776 vdd.n1778 vdd.t911 17.3326
R777 vdd.n1752 vdd.t632 17.3326
R778 vdd.n1743 vdd.t611 17.3326
R779 vdd.n119 vdd.t671 17.3326
R780 vdd.n1717 vdd.t541 17.3326
R781 vdd.n1705 vdd.t896 17.3326
R782 vdd.n133 vdd.t564 17.3519
R783 vdd.n2118 vdd.t642 17.3167
R784 vdd.n2119 vdd.t1610 17.3167
R785 vdd.n2113 vdd.t645 17.3167
R786 vdd.n2110 vdd.t603 17.3167
R787 vdd.n2112 vdd.t644 17.3167
R788 vdd.n2155 vdd.t1246 17.3098
R789 vdd.n2131 vdd.t1250 17.2755
R790 vdd.n2129 vdd.t517 17.2438
R791 vdd.n519 vdd.t876 17.2247
R792 vdd.n2088 vdd.t599 17.2247
R793 vdd.n2089 vdd.t640 17.2247
R794 vdd.n109 vdd.t703 17.3929
R795 vdd.t502 vdd.n1932 17.0005
R796 vdd.t502 vdd.n438 17.0005
R797 vdd.t502 vdd.n635 17.0005
R798 vdd.t502 vdd.n631 17.0005
R799 vdd.t502 vdd.n441 17.0005
R800 vdd.t502 vdd.n629 17.0005
R801 vdd.t502 vdd.n444 17.0005
R802 vdd.t502 vdd.n523 17.0005
R803 vdd.t502 vdd.n445 17.0005
R804 vdd.t502 vdd.n521 17.0005
R805 vdd.t502 vdd.n446 17.0005
R806 vdd.t502 vdd.n518 17.0005
R807 vdd.t502 vdd.n515 17.0005
R808 vdd.t502 vdd.n450 17.0005
R809 vdd.t502 vdd.n512 17.0005
R810 vdd.t502 vdd.n451 17.0005
R811 vdd.t502 vdd.n509 17.0005
R812 vdd.t502 vdd.n452 17.0005
R813 vdd.t502 vdd.n506 17.0005
R814 vdd.t502 vdd.n455 17.0005
R815 vdd.t502 vdd.n492 17.0005
R816 vdd.t502 vdd.n464 17.0005
R817 vdd.t502 vdd.n486 17.0005
R818 vdd.t502 vdd.n467 17.0005
R819 vdd.n1933 vdd.t502 17.0005
R820 vdd.n1929 vdd.n1928 17.0005
R821 vdd.n1930 vdd.n1929 17.0005
R822 vdd.n34 vdd.t617 5.61485
R823 vdd.n28 vdd.t617 5.61485
R824 vdd.n26 vdd.t617 1.51793
R825 vdd.t617 vdd.n23 1.34755
R826 vdd.n19 vdd.t617 1.51769
R827 vdd.n192 vdd.t10 17.0005
R828 vdd.t25 vdd.n204 17.0005
R829 vdd.t25 vdd.n208 17.0005
R830 vdd.n1936 vdd.n1935 17.0005
R831 vdd.n1937 vdd.n1936 17.0005
R832 vdd.t507 vdd.n118 5.61485
R833 vdd.n2013 vdd.t1083 17.0005
R834 vdd.n2015 vdd.t1065 17.0005
R835 vdd.n2078 vdd.t528 17.0005
R836 vdd.n2083 vdd.t533 17.0005
R837 vdd.n2086 vdd.t627 17.0005
R838 vdd.n2035 vdd.t1060 17.0005
R839 vdd.n2034 vdd.t1071 17.0005
R840 vdd.n2042 vdd.t885 17.0005
R841 vdd.n2041 vdd.t741 17.0005
R842 vdd.n2048 vdd.t685 17.0005
R843 vdd.n2047 vdd.t505 17.0005
R844 vdd.n2056 vdd.t669 17.0005
R845 vdd.n2055 vdd.t913 17.0005
R846 vdd.n2058 vdd.t1053 17.0005
R847 vdd.n2057 vdd.t1031 17.0005
R848 vdd.n2052 vdd.t655 17.0005
R849 vdd.n2051 vdd.t1110 17.0005
R850 vdd.n1830 vdd.t308 17.0005
R851 vdd.t308 vdd.n1706 17.0005
R852 vdd.t308 vdd.n1716 17.0005
R853 vdd.t308 vdd.n1718 17.0005
R854 vdd.t308 vdd.n1725 17.0005
R855 vdd.t308 vdd.n1729 17.0005
R856 vdd.t308 vdd.n1731 17.0005
R857 vdd.t308 vdd.n1733 17.0005
R858 vdd.t308 vdd.n1742 17.0005
R859 vdd.t308 vdd.n1749 17.0005
R860 vdd.t308 vdd.n1764 17.0005
R861 vdd.t308 vdd.n1766 17.0005
R862 vdd.t308 vdd.n1768 17.0005
R863 vdd.t308 vdd.n1781 17.0005
R864 vdd.n11 vdd.n10 0.35245
R865 vdd.t308 vdd.n1792 17.0005
R866 vdd.t308 vdd.n17 3.35234
R867 vdd.n16 vdd.n39 0.0351348
R868 vdd.t308 vdd.n1795 17.0005
R869 vdd.t308 vdd.n1799 17.0005
R870 vdd.t308 vdd.n1806 17.0005
R871 vdd.t308 vdd.n1808 17.0005
R872 vdd.t308 vdd.n1818 17.0005
R873 vdd.t308 vdd.n1820 17.0005
R874 vdd.t308 vdd.n1828 17.0005
R875 vdd.t515 vdd.n2136 17.0005
R876 vdd.t515 vdd.n2126 17.0005
R877 vdd.n2150 vdd.t601 17.0005
R878 vdd.n2104 vdd.t1611 17.0005
R879 vdd.n2117 vdd.n2116 17.0005
R880 vdd.t514 vdd.n2115 17.0005
R881 vdd.n2108 vdd.t1613 17.0005
R882 vdd.n2107 vdd.t641 17.0005
R883 vdd.n81 vdd.n134 8.47111
R884 vdd.n659 vdd.t1174 17.0005
R885 vdd.n658 vdd.t1288 17.0005
R886 vdd.n62 vdd.n790 17.0005
R887 vdd.n62 vdd.n63 4.17484
R888 vdd.n62 vdd.n64 4.17484
R889 vdd.n151 vdd.n62 5.61321
R890 vdd.n73 vdd.n791 17.0005
R891 vdd.n139 vdd.n73 4.17491
R892 vdd.n84 vdd.n803 17.0005
R893 vdd.n140 vdd.n84 4.17491
R894 vdd.n61 vdd.n805 17.0005
R895 vdd.n102 vdd.n50 4.17484
R896 vdd.n47 vdd.n753 17.0005
R897 vdd.n143 vdd.n146 5.61321
R898 vdd.n871 vdd.t1536 17.0005
R899 vdd.n1002 vdd.t1534 17.0005
R900 vdd.n834 vdd.t1541 17.0005
R901 vdd.n997 vdd.t1539 17.0005
R902 vdd.n837 vdd.t1546 17.0005
R903 vdd.n839 vdd.t1544 17.0005
R904 vdd.n978 vdd.t1549 17.0005
R905 vdd.n973 vdd.t1554 17.0005
R906 vdd.n967 vdd.t1563 17.0005
R907 vdd.n900 vdd.t1570 17.0005
R908 vdd.n961 vdd.t1568 17.0005
R909 vdd.n848 vdd.t1575 17.0005
R910 vdd.n956 vdd.t1573 17.0005
R911 vdd.n852 vdd.t1584 17.0005
R912 vdd.n943 vdd.t1580 17.0005
R913 vdd.n854 vdd.t1578 17.0005
R914 vdd.n912 vdd.t1589 17.0005
R915 vdd.n935 vdd.t1587 17.0005
R916 vdd.n929 vdd.t1606 17.0005
R917 vdd.n930 vdd.t1591 17.0005
R918 vdd.n746 vdd.t1531 17.0005
R919 vdd.n747 vdd.t1516 17.0005
R920 vdd.n892 vdd.t1565 17.0005
R921 vdd.n885 vdd.t1560 17.0005
R922 vdd.n880 vdd.t1551 17.0005
R923 vdd.n651 vdd.t1377 17.0005
R924 vdd.n1186 vdd.t1375 17.0005
R925 vdd.n663 vdd.t1382 17.0005
R926 vdd.n665 vdd.t1380 17.0005
R927 vdd.n827 vdd.t1387 17.0005
R928 vdd.n1167 vdd.t1385 17.0005
R929 vdd.n672 vdd.t1392 17.0005
R930 vdd.n1162 vdd.t1390 17.0005
R931 vdd.n675 vdd.t1397 17.0005
R932 vdd.n677 vdd.t1395 17.0005
R933 vdd.n816 vdd.t1402 17.0005
R934 vdd.n1143 vdd.t1400 17.0005
R935 vdd.n684 vdd.t1407 17.0005
R936 vdd.n1138 vdd.t1405 17.0005
R937 vdd.n687 vdd.t1412 17.0005
R938 vdd.n689 vdd.t1410 17.0005
R939 vdd.n759 vdd.t1417 17.0005
R940 vdd.n1119 vdd.t1415 17.0005
R941 vdd.n696 vdd.t1422 17.0005
R942 vdd.n1114 vdd.t1420 17.0005
R943 vdd.n700 vdd.t1439 17.0005
R944 vdd.n701 vdd.t1424 17.0005
R945 vdd.n766 vdd.t1444 17.0005
R946 vdd.n1092 vdd.t1442 17.0005
R947 vdd.n708 vdd.t1453 17.0005
R948 vdd.n1082 vdd.t1449 17.0005
R949 vdd.n1087 vdd.t1447 17.0005
R950 vdd.n711 vdd.t1458 17.0005
R951 vdd.n713 vdd.t1456 17.0005
R952 vdd.n774 vdd.t1463 17.0005
R953 vdd.n1066 vdd.t1461 17.0005
R954 vdd.n1061 vdd.t1466 17.0005
R955 vdd.n1056 vdd.t1471 17.0005
R956 vdd.n1050 vdd.t1480 17.0005
R957 vdd.n723 vdd.t1487 17.0005
R958 vdd.n1045 vdd.t1485 17.0005
R959 vdd.n727 vdd.t1492 17.0005
R960 vdd.n729 vdd.t1490 17.0005
R961 vdd.n787 vdd.t1497 17.0005
R962 vdd.n1026 vdd.t1495 17.0005
R963 vdd.n1020 vdd.t1514 17.0005
R964 vdd.n1021 vdd.t1499 17.0005
R965 vdd.n778 vdd.t1482 17.0005
R966 vdd.n793 vdd.t1477 17.0005
R967 vdd.n800 vdd.t1468 17.0005
R968 vdd.n1191 vdd.t1359 17.0005
R969 vdd.n1192 vdd.t899 17.0005
R970 vdd.n1212 vdd.t678 17.0005
R971 vdd.n1248 vdd.t900 17.0005
R972 vdd.n117 vdd.n116 0.00539495
R973 vdd.n1493 vdd.t0 17.0005
R974 vdd.n22 vdd.n24 3.35089
R975 vdd.n31 vdd.n24 5.64138
R976 vdd.n543 vdd.t1725 16.9576
R977 vdd.n925 vdd.t1608 16.5843
R978 vdd.n924 vdd.t1607 16.5843
R979 vdd.n1494 vdd 16.5035
R980 vdd.n2104 vdd.t1609 15.3014
R981 vdd.n2108 vdd.t1612 15.3014
R982 vdd.n167 vdd.t1710 15.2621
R983 vdd.n1696 vdd.t1695 15.2621
R984 vdd.t562 vdd.n1231 15.237
R985 vdd.t561 vdd.n1241 15.2358
R986 vdd.t1299 vdd.n1214 15.0005
R987 vdd.n1215 vdd.t1299 15.0005
R988 vdd.n1251 vdd.t1298 15.0005
R989 vdd.t1298 vdd.n1250 15.0005
R990 vdd.n562 vdd.t1346 15.0005
R991 vdd.n21 vdd.t1325 7.49074
R992 vdd.t1346 vdd.n561 15.0005
R993 vdd.t1309 vdd.n554 15.0005
R994 vdd.t1309 vdd.n600 15.0005
R995 vdd.t1309 vdd.n552 15.0005
R996 vdd.t1309 vdd.n553 15.0005
R997 vdd.n601 vdd.t1309 15.0005
R998 vdd.t1313 vdd.n613 15.0005
R999 vdd.n614 vdd.t1313 15.0005
R1000 vdd.t1315 vdd.n32 7.49074
R1001 vdd.n30 vdd.n32 0.0215213
R1002 vdd.n579 vdd.t1320 15.0005
R1003 vdd.t1320 vdd.n578 15.0005
R1004 vdd.n533 vdd.t1355 14.8345
R1005 vdd.n534 vdd.t1356 14.701
R1006 vdd.n1232 vdd.t562 14.2603
R1007 vdd.n1242 vdd.t561 14.2588
R1008 vdd.n295 vdd.n289 14.0575
R1009 vdd.n253 vdd.n242 13.9142
R1010 vdd.n215 vdd.n214 13.5005
R1011 vdd.n218 vdd.n217 13.5005
R1012 vdd.n221 vdd.n220 13.5005
R1013 vdd.n223 vdd.n222 13.5005
R1014 vdd.n227 vdd.n226 13.5005
R1015 vdd.n229 vdd.n228 13.5005
R1016 vdd.n232 vdd.n199 13.5005
R1017 vdd.n279 vdd.n278 13.5005
R1018 vdd.n274 vdd.n200 13.5005
R1019 vdd.n270 vdd.n269 13.5005
R1020 vdd.n268 vdd.n267 13.5005
R1021 vdd.n261 vdd.n235 13.5005
R1022 vdd.n255 vdd.n254 13.5005
R1023 vdd.n312 vdd.n311 13.5005
R1024 vdd.n310 vdd.n309 13.5005
R1025 vdd.n196 vdd.n195 13.5005
R1026 vdd.n198 vdd.n197 13.5005
R1027 vdd.n308 vdd.n307 13.5005
R1028 vdd.n306 vdd.n305 13.5005
R1029 vdd.n284 vdd.n282 13.5005
R1030 vdd.n285 vdd.n283 13.5005
R1031 vdd.n304 vdd.n303 13.5005
R1032 vdd.n302 vdd.n301 13.5005
R1033 vdd.n287 vdd.n286 13.5005
R1034 vdd.n297 vdd.n296 13.5005
R1035 vdd.n295 vdd.n294 13.5005
R1036 vdd.n253 vdd.n252 13.5005
R1037 vdd.n1367 vdd.n1366 13.5005
R1038 vdd.n1368 vdd.n1202 13.5005
R1039 vdd.n1341 vdd.n1201 13.5005
R1040 vdd.n314 vdd.n193 12.3641
R1041 vdd.n281 vdd.n280 12.2838
R1042 vdd.n225 vdd.n224 12.2838
R1043 vdd.n216 vdd.n194 12.2838
R1044 vdd.n623 vdd.n539 11.7115
R1045 vdd.n625 vdd.n624 11.7115
R1046 vdd.n320 vdd.n314 10.9658
R1047 vdd.n2093 vdd.t1694 9.85467
R1048 vdd.n2097 vdd.t1693 9.85054
R1049 vdd.n314 vdd.n313 9.84151
R1050 vdd.n1508 vdd.n1495 9.68829
R1051 vdd.n6 vdd.n1831 9.6165
R1052 vdd.n1987 vdd.n168 9.6165
R1053 vdd.n1191 vdd.t1357 9.58112
R1054 vdd.n2095 vdd.n2094 9.41238
R1055 vdd.n622 vdd.n621 9.12386
R1056 vdd.n567 vdd.n538 9.123
R1057 vdd.n1217 vdd.n1216 9.03878
R1058 vdd.n1221 vdd.n1220 9.03878
R1059 vdd.n1247 vdd.n1246 9.03878
R1060 vdd.n1253 vdd.n1252 9.03878
R1061 vdd.n2030 vdd.t924 8.84404
R1062 vdd.n2009 vdd.t1208 8.84304
R1063 vdd.n2030 vdd.t1002 8.84304
R1064 vdd.n437 vdd.t872 8.7637
R1065 vdd.n435 vdd.t871 8.7637
R1066 vdd.n633 vdd.t707 8.76154
R1067 vdd.n630 vdd.t1202 8.76154
R1068 vdd.n514 vdd.t1141 8.76154
R1069 vdd.n510 vdd.t979 8.76154
R1070 vdd.n507 vdd.t1269 8.76154
R1071 vdd.n454 vdd.t519 8.76154
R1072 vdd.n457 vdd.t675 8.76154
R1073 vdd.n489 vdd.t534 8.76154
R1074 vdd.n487 vdd.t868 8.76154
R1075 vdd.n428 vdd.t1075 8.76154
R1076 vdd.n1931 vdd.t522 8.76154
R1077 vdd.n2027 vdd.t1248 8.76154
R1078 vdd.n1761 vdd.t509 8.76154
R1079 vdd.n1763 vdd.t906 8.76154
R1080 vdd.n2140 vdd.t551 8.76154
R1081 vdd.n2127 vdd.t516 8.76154
R1082 vdd.n2156 vdd.t1641 8.76154
R1083 vdd.n162 vdd.t619 8.76154
R1084 vdd.n161 vdd.t563 8.76154
R1085 vdd.n481 vdd.t1030 8.76054
R1086 vdd.n483 vdd.t1078 8.76054
R1087 vdd.n493 vdd.t660 8.76054
R1088 vdd.n496 vdd.t677 8.76054
R1089 vdd.n505 vdd.t607 8.76054
R1090 vdd.n508 vdd.t1044 8.76054
R1091 vdd.n511 vdd.t1034 8.76054
R1092 vdd.n449 vdd.t762 8.76054
R1093 vdd.n428 vdd.t749 8.76054
R1094 vdd.n1931 vdd.t1295 8.76054
R1095 vdd.n2006 vdd.t740 8.76054
R1096 vdd.n2008 vdd.t1055 8.76054
R1097 vdd.n2027 vdd.t713 8.76054
R1098 vdd.n2028 vdd.t923 8.76054
R1099 vdd.n2028 vdd.t1003 8.76054
R1100 vdd.n1824 vdd.t506 8.76054
R1101 vdd.n1813 vdd.t593 8.76054
R1102 vdd.n1800 vdd.t610 8.76054
R1103 vdd.n1793 vdd.t666 8.76054
R1104 vdd.n10 vdd.t594 8.76054
R1105 vdd.n1782 vdd.t890 8.76054
R1106 vdd.n1773 vdd.t893 8.76054
R1107 vdd.n1769 vdd.t630 8.76054
R1108 vdd.n1765 vdd.t538 8.76054
R1109 vdd.n13 vdd.t695 8.76054
R1110 vdd.n1748 vdd.t616 8.76054
R1111 vdd.n123 vdd.t670 8.76054
R1112 vdd.n1732 vdd.t718 8.76054
R1113 vdd.n1724 vdd.t894 8.76054
R1114 vdd.n1712 vdd.t672 8.76054
R1115 vdd.n1700 vdd.t697 8.76054
R1116 vdd.n2139 vdd.t544 8.76054
R1117 vdd.n2141 vdd.t545 8.76054
R1118 vdd.n659 vdd.t1360 8.65563
R1119 vdd.t1360 vdd.n658 8.65563
R1120 vdd.n871 vdd.t1535 8.65563
R1121 vdd.n1002 vdd.t1532 8.65563
R1122 vdd.n834 vdd.t1540 8.65563
R1123 vdd.n997 vdd.t1537 8.65563
R1124 vdd.n837 vdd.t1545 8.65563
R1125 vdd.n839 vdd.t1542 8.65563
R1126 vdd.n978 vdd.t1547 8.65563
R1127 vdd.n973 vdd.t1552 8.65563
R1128 vdd.n967 vdd.t1561 8.65563
R1129 vdd.n900 vdd.t1569 8.65563
R1130 vdd.n961 vdd.t1566 8.65563
R1131 vdd.n848 vdd.t1574 8.65563
R1132 vdd.n956 vdd.t1571 8.65563
R1133 vdd.n852 vdd.t1583 8.65563
R1134 vdd.n854 vdd.t1576 8.65563
R1135 vdd.n912 vdd.t1588 8.65563
R1136 vdd.n935 vdd.t1585 8.65563
R1137 vdd.t1590 vdd.n929 8.65563
R1138 vdd.n930 vdd.t1590 8.65563
R1139 vdd.t1515 vdd.n746 8.65563
R1140 vdd.n747 vdd.t1515 8.65563
R1141 vdd.n892 vdd.t1564 8.65563
R1142 vdd.n885 vdd.t1557 8.65563
R1143 vdd.n880 vdd.t1550 8.65563
R1144 vdd.n651 vdd.t1376 8.65563
R1145 vdd.n1186 vdd.t1373 8.65563
R1146 vdd.n663 vdd.t1381 8.65563
R1147 vdd.n665 vdd.t1378 8.65563
R1148 vdd.n827 vdd.t1386 8.65563
R1149 vdd.n1167 vdd.t1383 8.65563
R1150 vdd.n672 vdd.t1391 8.65563
R1151 vdd.n1162 vdd.t1388 8.65563
R1152 vdd.n675 vdd.t1396 8.65563
R1153 vdd.n677 vdd.t1393 8.65563
R1154 vdd.n816 vdd.t1401 8.65563
R1155 vdd.n1143 vdd.t1398 8.65563
R1156 vdd.n684 vdd.t1406 8.65563
R1157 vdd.n1138 vdd.t1403 8.65563
R1158 vdd.n687 vdd.t1411 8.65563
R1159 vdd.n689 vdd.t1408 8.65563
R1160 vdd.n759 vdd.t1416 8.65563
R1161 vdd.n1119 vdd.t1413 8.65563
R1162 vdd.n696 vdd.t1421 8.65563
R1163 vdd.n1114 vdd.t1418 8.65563
R1164 vdd.t1423 vdd.n700 8.65563
R1165 vdd.n701 vdd.t1423 8.65563
R1166 vdd.n766 vdd.t1443 8.65563
R1167 vdd.n1092 vdd.t1440 8.65563
R1168 vdd.n708 vdd.t1452 8.65563
R1169 vdd.n1087 vdd.t1445 8.65563
R1170 vdd.n711 vdd.t1457 8.65563
R1171 vdd.n713 vdd.t1454 8.65563
R1172 vdd.n774 vdd.t1462 8.65563
R1173 vdd.n1066 vdd.t1459 8.65563
R1174 vdd.n1061 vdd.t1464 8.65563
R1175 vdd.n1056 vdd.t1469 8.65563
R1176 vdd.n1050 vdd.t1478 8.65563
R1177 vdd.n723 vdd.t1486 8.65563
R1178 vdd.n1045 vdd.t1483 8.65563
R1179 vdd.n727 vdd.t1491 8.65563
R1180 vdd.n729 vdd.t1488 8.65563
R1181 vdd.n787 vdd.t1496 8.65563
R1182 vdd.n1026 vdd.t1493 8.65563
R1183 vdd.t1498 vdd.n1020 8.65563
R1184 vdd.n1021 vdd.t1498 8.65563
R1185 vdd.n778 vdd.t1481 8.65563
R1186 vdd.n793 vdd.t1474 8.65563
R1187 vdd.n800 vdd.t1467 8.65563
R1188 vdd.n42 vdd.n24 1.08142
R1189 vdd.t507 vdd.n109 2.75496
R1190 vdd.t617 vdd.n18 1.17607
R1191 vdd.n1831 vdd.n133 0.0196165
R1192 vdd.t526 vdd.n82 1.13302
R1193 vdd.n137 vdd.n138 0.0017399
R1194 vdd.n136 vdd.n137 0.00174154
R1195 vdd.n135 vdd.n136 0.00174253
R1196 vdd.n113 vdd.n135 0.00380095
R1197 vdd.t526 vdd.n113 0.629016
R1198 vdd.t526 vdd.n99 0.848976
R1199 vdd.n99 vdd.n71 0.00623577
R1200 vdd.n67 vdd.n66 0.00485181
R1201 vdd.t1173 vdd.n60 1.13247
R1202 vdd.n73 vdd.n62 0.00483162
R1203 vdd.n74 vdd.n73 0.00930188
R1204 vdd.t1173 vdd.n74 0.512135
R1205 vdd.t1173 vdd.n61 1.88967
R1206 vdd.t1173 vdd.n95 0.999489
R1207 vdd.n95 vdd.n147 0.00496592
R1208 vdd.t1173 vdd.n87 0.999096
R1209 vdd.n144 vdd.t1173 1.88932
R1210 vdd.n144 vdd.n143 0.00291576
R1211 vdd.n57 vdd.n55 0.0107867
R1212 vdd.t1173 vdd.n57 0.445001
R1213 vdd.n79 vdd.n89 1.30662
R1214 vdd.t1128 vdd.n45 0.00683922
R1215 vdd.t573 vdd.n53 0.00502591
R1216 vdd.n53 vdd.n75 1.69854
R1217 vdd.n65 vdd.n75 2.83406
R1218 vdd.n128 vdd.n75 4.25095
R1219 vdd.n129 vdd.n75 4.25094
R1220 vdd.t898 vdd.n130 0.00174317
R1221 vdd.n92 vdd.n68 0.999421
R1222 vdd.n155 vdd.n112 0.00474925
R1223 vdd.n112 vdd.n68 4.25087
R1224 vdd.t897 vdd.n68 8.501
R1225 vdd.n153 vdd.n97 0.00583227
R1226 vdd.t764 vdd.n116 0.0439742
R1227 vdd.n122 vdd.n121 0.0341352
R1228 vdd.n126 vdd.n125 0.0341352
R1229 vdd.n69 vdd.n46 0.00144972
R1230 vdd.n158 vdd.t572 0.00158321
R1231 vdd.n69 vdd.n158 4.25071
R1232 vdd.n69 vdd.n157 4.25069
R1233 vdd.n69 vdd.n156 4.25069
R1234 vdd.n43 vdd.t384 0.00332829
R1235 vdd.n69 vdd.n108 1.70005
R1236 vdd.n69 vdd.n152 2.83428
R1237 vdd.n152 vdd.t897 0.00166656
R1238 vdd.n69 vdd.n97 1.70074
R1239 vdd.n98 vdd.t1287 0.0152368
R1240 vdd.n69 vdd.n98 0.12055
R1241 vdd.n69 vdd.n57 0.00583021
R1242 vdd.n69 vdd.n45 1.06177
R1243 vdd.n54 vdd.t1127 0.00826047
R1244 vdd.n54 vdd.t573 0.00521246
R1245 vdd.n69 vdd.n54 0.94329
R1246 vdd.t308 vdd.n1704 8.49975
R1247 vdd.t308 vdd.n1723 8.49975
R1248 vdd.t308 vdd.n1801 8.49975
R1249 vdd.n1216 vdd.t678 8.49415
R1250 vdd.n1220 vdd.t560 8.49415
R1251 vdd.n1246 vdd.t558 8.49415
R1252 vdd.n1252 vdd.t900 8.49415
R1253 vdd.n2123 vdd.n2103 8.48844
R1254 vdd.n580 vdd.n24 8.48402
R1255 vdd.n577 vdd.n24 8.48402
R1256 vdd.n21 vdd.n22 0.0945258
R1257 vdd.n545 vdd.n24 8.47888
R1258 vdd.n1929 vdd.n637 8.47856
R1259 vdd.n1929 vdd.n643 8.47856
R1260 vdd.t25 vdd.n230 8.47856
R1261 vdd.t25 vdd.n206 8.47856
R1262 vdd.n1936 vdd.n425 8.47856
R1263 vdd.n569 vdd.n22 0.168871
R1264 vdd.t502 vdd.n427 8.47111
R1265 vdd.t502 vdd.n429 8.47111
R1266 vdd.t502 vdd.n431 8.47111
R1267 vdd.t502 vdd.n434 8.47111
R1268 vdd.t502 vdd.n436 8.47111
R1269 vdd.n8 vdd.n7 0.12912
R1270 vdd.t502 vdd.n8 2.30249
R1271 vdd.t502 vdd.n439 8.47111
R1272 vdd.t502 vdd.n442 8.47111
R1273 vdd.t502 vdd.n626 8.47111
R1274 vdd.t502 vdd.n531 8.47111
R1275 vdd.t502 vdd.n529 8.47111
R1276 vdd.t502 vdd.n527 8.47111
R1277 vdd.t502 vdd.n525 8.47111
R1278 vdd.t502 vdd.n448 8.47111
R1279 vdd.t502 vdd.n453 8.47111
R1280 vdd.t502 vdd.n456 8.47111
R1281 vdd.t502 vdd.n459 8.47111
R1282 vdd.t502 vdd.n500 8.47111
R1283 vdd.t502 vdd.n497 8.47111
R1284 vdd.t502 vdd.n494 8.47111
R1285 vdd.t502 vdd.n462 8.47111
R1286 vdd.t502 vdd.n491 8.47111
R1287 vdd.t502 vdd.n488 8.47111
R1288 vdd.t502 vdd.n465 8.47111
R1289 vdd.t502 vdd.n484 8.47111
R1290 vdd.t502 vdd.n468 8.47111
R1291 vdd.t502 vdd.n470 8.47111
R1292 vdd.t502 vdd.n478 8.47111
R1293 vdd.t502 vdd.n475 8.47111
R1294 vdd.n33 vdd.t617 4.177
R1295 vdd.n293 vdd.n28 0.175825
R1296 vdd.n93 vdd.t617 5.61485
R1297 vdd.n291 vdd.n106 0.35053
R1298 vdd.n106 vdd.t617 2.72093
R1299 vdd.n288 vdd.t617 8.47111
R1300 vdd.n299 vdd.n107 0.35053
R1301 vdd.n107 vdd.t617 2.72093
R1302 vdd.n27 vdd.t617 1.34777
R1303 vdd.n287 vdd.n27 0.645244
R1304 vdd.n27 vdd.n301 0.653994
R1305 vdd.n78 vdd.t617 1.5176
R1306 vdd.t617 vdd.n96 1.34819
R1307 vdd.n282 vdd.n26 0.620526
R1308 vdd.n308 vdd.n23 0.570752
R1309 vdd.n80 vdd.t617 1.51813
R1310 vdd.n80 vdd.n196 0.604151
R1311 vdd.n20 vdd.t617 1.34759
R1312 vdd.n312 vdd.n18 0.676685
R1313 vdd.t10 vdd.n191 8.47111
R1314 vdd.t10 vdd.n175 8.47111
R1315 vdd.t10 vdd.n177 8.47111
R1316 vdd.t10 vdd.n179 8.47111
R1317 vdd.t10 vdd.n185 8.47111
R1318 vdd.t507 vdd.n35 4.177
R1319 vdd.n2088 vdd.n118 0.195825
R1320 vdd.t507 vdd.n2007 8.47111
R1321 vdd.t511 vdd.n2023 8.47111
R1322 vdd.t308 vdd.n1698 8.47111
R1323 vdd.t308 vdd.n1701 8.47111
R1324 vdd.t308 vdd.n1708 8.47111
R1325 vdd.t308 vdd.n1710 8.47111
R1326 vdd.t308 vdd.n1720 8.47111
R1327 vdd.t308 vdd.n1727 8.47111
R1328 vdd.t308 vdd.n122 4.22715
R1329 vdd.t308 vdd.n1735 8.47111
R1330 vdd.t308 vdd.n1740 8.47111
R1331 vdd.t308 vdd.n126 4.22715
R1332 vdd.t308 vdd.n1747 8.47111
R1333 vdd.t308 vdd.n1756 8.47111
R1334 vdd.t308 vdd.n1762 8.47111
R1335 vdd.t308 vdd.n1770 8.47111
R1336 vdd.t308 vdd.n1774 8.47111
R1337 vdd.t308 vdd.n1783 8.47111
R1338 vdd.t308 vdd.n1785 8.47111
R1339 vdd.t308 vdd.n1787 8.47111
R1340 vdd.t308 vdd.n1797 8.47111
R1341 vdd.t308 vdd.n1804 8.47111
R1342 vdd.t308 vdd.n1814 8.47111
R1343 vdd.t308 vdd.n1816 8.47111
R1344 vdd.t308 vdd.n1826 8.47111
R1345 vdd.t515 vdd.n2100 8.47111
R1346 vdd.t515 vdd.n2146 8.47111
R1347 vdd.t515 vdd.n2142 8.47111
R1348 vdd.t515 vdd.n2138 8.47111
R1349 vdd.t515 vdd.n2128 8.47111
R1350 vdd.n2157 vdd.n2154 8.47111
R1351 vdd.n83 vdd.n82 0.800952
R1352 vdd.n163 vdd.n138 8.47111
R1353 vdd.n164 vdd.n137 8.47111
R1354 vdd.n165 vdd.n136 8.47111
R1355 vdd.n166 vdd.n135 8.47111
R1356 vdd.n105 vdd.n104 0.882142
R1357 vdd.n72 vdd.n71 0.214089
R1358 vdd.n100 vdd.n66 1.97622
R1359 vdd.n1837 vdd.n1833 8.47111
R1360 vdd.n1839 vdd.n1833 8.47111
R1361 vdd.n1854 vdd.n1848 8.47111
R1362 vdd.n1856 vdd.n1848 8.47111
R1363 vdd.n1871 vdd.n1865 8.47111
R1364 vdd.n1873 vdd.n1865 8.47111
R1365 vdd.n1888 vdd.n1882 8.47111
R1366 vdd.n1890 vdd.n1882 8.47111
R1367 vdd.n1901 vdd.n1897 8.47111
R1368 vdd.n1903 vdd.n1897 8.47111
R1369 vdd.n1918 vdd.n1912 8.47111
R1370 vdd.n1920 vdd.n1912 8.47111
R1371 vdd.n1688 vdd.n1682 8.47111
R1372 vdd.n1690 vdd.n1682 8.47111
R1373 vdd.n1671 vdd.n1665 8.47111
R1374 vdd.n1673 vdd.n1665 8.47111
R1375 vdd.n1654 vdd.n1648 8.47111
R1376 vdd.n1656 vdd.n1648 8.47111
R1377 vdd.n1637 vdd.n1631 8.47111
R1378 vdd.n1639 vdd.n1631 8.47111
R1379 vdd.n1620 vdd.n1614 8.47111
R1380 vdd.n1622 vdd.n1614 8.47111
R1381 vdd.n1603 vdd.n1597 8.47111
R1382 vdd.n1605 vdd.n1597 8.47111
R1383 vdd.n1586 vdd.n1580 8.47111
R1384 vdd.n1588 vdd.n1580 8.47111
R1385 vdd.n1569 vdd.n1563 8.47111
R1386 vdd.n1571 vdd.n1563 8.47111
R1387 vdd.n1552 vdd.n1546 8.47111
R1388 vdd.n1554 vdd.n1546 8.47111
R1389 vdd.n1535 vdd.n1529 8.47111
R1390 vdd.n1537 vdd.n1529 8.47111
R1391 vdd.n1518 vdd.n1512 8.47111
R1392 vdd.n1520 vdd.n1512 8.47111
R1393 vdd.n1501 vdd.n1497 8.47111
R1394 vdd.n1503 vdd.n1497 8.47111
R1395 vdd.t0 vdd.n1370 8.47111
R1396 vdd.t0 vdd.n1371 8.47111
R1397 vdd.t0 vdd.n1488 8.47111
R1398 vdd.t0 vdd.n1484 8.47111
R1399 vdd.t0 vdd.n1374 8.47111
R1400 vdd.t0 vdd.n1376 8.47111
R1401 vdd.t0 vdd.n1479 8.47111
R1402 vdd.t0 vdd.n1475 8.47111
R1403 vdd.t0 vdd.n1379 8.47111
R1404 vdd.t0 vdd.n1381 8.47111
R1405 vdd.t0 vdd.n1470 8.47111
R1406 vdd.t0 vdd.n1466 8.47111
R1407 vdd.t0 vdd.n1384 8.47111
R1408 vdd.t0 vdd.n1386 8.47111
R1409 vdd.t0 vdd.n1461 8.47111
R1410 vdd.t0 vdd.n1457 8.47111
R1411 vdd.t0 vdd.n1389 8.47111
R1412 vdd.t0 vdd.n1391 8.47111
R1413 vdd.t0 vdd.n1452 8.47111
R1414 vdd.t0 vdd.n1448 8.47111
R1415 vdd.t0 vdd.n1394 8.47111
R1416 vdd.t0 vdd.n1396 8.47111
R1417 vdd.t0 vdd.n1443 8.47111
R1418 vdd.t0 vdd.n1439 8.47111
R1419 vdd.t0 vdd.n1399 8.47111
R1420 vdd.t0 vdd.n1401 8.47111
R1421 vdd.t0 vdd.n1434 8.47111
R1422 vdd.t0 vdd.n1430 8.47111
R1423 vdd.t0 vdd.n1404 8.47111
R1424 vdd.t0 vdd.n1406 8.47111
R1425 vdd.t0 vdd.n1425 8.47111
R1426 vdd.t0 vdd.n1421 8.47111
R1427 vdd.t0 vdd.n1409 8.47111
R1428 vdd.t0 vdd.n1411 8.47111
R1429 vdd.n59 vdd.n58 4.17472
R1430 vdd.n792 vdd.n91 0.223199
R1431 vdd.n91 vdd.n73 4.17472
R1432 vdd.n802 vdd.n150 0.202574
R1433 vdd.n150 vdd.n73 4.17472
R1434 vdd.n149 vdd.n84 4.17472
R1435 vdd.n101 vdd.n84 5.61321
R1436 vdd.n806 vdd.n148 0.223199
R1437 vdd.n148 vdd.n61 4.17472
R1438 vdd.n51 vdd.n50 3.30418
R1439 vdd.n808 vdd.n114 0.285074
R1440 vdd.n114 vdd.n50 4.17472
R1441 vdd.n810 vdd.n50 8.47018
R1442 vdd.n811 vdd.n147 8.47018
R1443 vdd.n818 vdd.n49 0.243824
R1444 vdd.n49 vdd.n48 4.17472
R1445 vdd.n820 vdd.n48 8.47018
R1446 vdd.n821 vdd.n47 8.47018
R1447 vdd.n88 vdd.n47 3.304
R1448 vdd.n829 vdd.n103 0.305699
R1449 vdd.n103 vdd.n47 4.17472
R1450 vdd.n830 vdd.n142 0.285074
R1451 vdd.n47 vdd.n142 4.17472
R1452 vdd.n753 vdd.n146 0.248272
R1453 vdd.n145 vdd.n143 5.61321
R1454 vdd.n56 vdd.n55 0.655821
R1455 vdd.n145 vdd.n56 1.12996
R1456 vdd.n831 vdd.n90 1.57272
R1457 vdd.n90 vdd.n76 2.68987
R1458 vdd.n76 vdd.n75 0.174811
R1459 vdd.n86 vdd.n68 0.207627
R1460 vdd.n111 vdd.n69 0.721292
R1461 vdd.n86 vdd.n111 2.17217
R1462 vdd.n1929 vdd.n647 8.468
R1463 vdd.n234 vdd.t25 8.468
R1464 vdd.n1249 vdd.t1297 8.24389
R1465 vdd.n1213 vdd.t1300 8.23598
R1466 vdd.n189 vdd.t1814 7.62628
R1467 vdd.n181 vdd.t1813 7.62628
R1468 vdd.n173 vdd.t1812 7.62628
R1469 vdd.n1984 vdd.t1711 7.62628
R1470 vdd.n1978 vdd.t1714 7.62628
R1471 vdd.n1969 vdd.t1720 7.62628
R1472 vdd.n1960 vdd.t1727 7.62628
R1473 vdd.n1951 vdd.t1733 7.62628
R1474 vdd.n1945 vdd.t1736 7.62628
R1475 vdd.n417 vdd.t1744 7.62628
R1476 vdd.n408 vdd.t1750 7.62628
R1477 vdd.n399 vdd.t1772 7.62628
R1478 vdd.n390 vdd.t1774 7.62628
R1479 vdd.n381 vdd.t1776 7.62628
R1480 vdd.n372 vdd.t1778 7.62628
R1481 vdd.n363 vdd.t1780 7.62628
R1482 vdd.n354 vdd.t1787 7.62628
R1483 vdd.n345 vdd.t1793 7.62628
R1484 vdd.n336 vdd.t1807 7.62628
R1485 vdd.n327 vdd.t1809 7.62628
R1486 vdd.n318 vdd.t1811 7.62628
R1487 vdd.n1821 vdd.t1709 7.62628
R1488 vdd.n1811 vdd.t1708 7.62628
R1489 vdd.n1802 vdd.t1707 7.62628
R1490 vdd.n38 vdd.t1706 7.62628
R1491 vdd.n1788 vdd.t1705 7.62628
R1492 vdd.n9 vdd.t1704 7.62628
R1493 vdd.n124 vdd.t1703 7.62628
R1494 vdd.n1736 vdd.t1702 7.62628
R1495 vdd.n120 vdd.t1701 7.62628
R1496 vdd.n1721 vdd.t1700 7.62628
R1497 vdd.n1711 vdd.t1699 7.62628
R1498 vdd.n1702 vdd.t1698 7.62628
R1499 vdd.n1842 vdd.t1697 7.62628
R1500 vdd.n1835 vdd.t1696 7.62628
R1501 vdd.n1859 vdd.t1713 7.62628
R1502 vdd.n1852 vdd.t1712 7.62628
R1503 vdd.n1876 vdd.t1719 7.62628
R1504 vdd.n1869 vdd.t1718 7.62628
R1505 vdd.n1893 vdd.t1724 7.62628
R1506 vdd.n1886 vdd.t1723 7.62628
R1507 vdd.n1906 vdd.t1732 7.62628
R1508 vdd.n1899 vdd.t1731 7.62628
R1509 vdd.n1923 vdd.t1735 7.62628
R1510 vdd.n1916 vdd.t1734 7.62628
R1511 vdd.n1693 vdd.t1743 7.62628
R1512 vdd.n1686 vdd.t1742 7.62628
R1513 vdd.n1676 vdd.t1749 7.62628
R1514 vdd.n1669 vdd.t1748 7.62628
R1515 vdd.n1659 vdd.t1754 7.62628
R1516 vdd.n1652 vdd.t1753 7.62628
R1517 vdd.n1642 vdd.t1758 7.62628
R1518 vdd.n1635 vdd.t1757 7.62628
R1519 vdd.n1625 vdd.t1762 7.62628
R1520 vdd.n1618 vdd.t1761 7.62628
R1521 vdd.n1608 vdd.t1766 7.62628
R1522 vdd.n1601 vdd.t1765 7.62628
R1523 vdd.n1591 vdd.t1770 7.62628
R1524 vdd.n1584 vdd.t1769 7.62628
R1525 vdd.n1574 vdd.t1785 7.62628
R1526 vdd.n1567 vdd.t1784 7.62628
R1527 vdd.n1557 vdd.t1791 7.62628
R1528 vdd.n1550 vdd.t1790 7.62628
R1529 vdd.n1540 vdd.t1797 7.62628
R1530 vdd.n1533 vdd.t1796 7.62628
R1531 vdd.n1523 vdd.t1801 7.62628
R1532 vdd.n1516 vdd.t1800 7.62628
R1533 vdd.n1506 vdd.t1805 7.62628
R1534 vdd.n1499 vdd.t1804 7.62628
R1535 vdd.n188 vdd.t1817 7.62594
R1536 vdd.n180 vdd.t1816 7.62594
R1537 vdd.n172 vdd.t1815 7.62594
R1538 vdd.n1974 vdd.t1717 7.62594
R1539 vdd.n1965 vdd.t1726 7.62594
R1540 vdd.n1956 vdd.t1730 7.62594
R1541 vdd.n1941 vdd.t1741 7.62594
R1542 vdd.n413 vdd.t1747 7.62594
R1543 vdd.n404 vdd.t1771 7.62594
R1544 vdd.n395 vdd.t1773 7.62594
R1545 vdd.n386 vdd.t1775 7.62594
R1546 vdd.n377 vdd.t1777 7.62594
R1547 vdd.n368 vdd.t1779 7.62594
R1548 vdd.n359 vdd.t1783 7.62594
R1549 vdd.n350 vdd.t1792 7.62594
R1550 vdd.n341 vdd.t1806 7.62594
R1551 vdd.n332 vdd.t1808 7.62594
R1552 vdd.n323 vdd.t1810 7.62594
R1553 vdd.n1847 vdd.t1716 7.62594
R1554 vdd.n1849 vdd.t1715 7.62594
R1555 vdd.n1864 vdd.t1722 7.62594
R1556 vdd.n1866 vdd.t1721 7.62594
R1557 vdd.n1881 vdd.t1729 7.62594
R1558 vdd.n1883 vdd.t1728 7.62594
R1559 vdd.n1911 vdd.t1740 7.62594
R1560 vdd.n1913 vdd.t1739 7.62594
R1561 vdd.n1681 vdd.t1746 7.62594
R1562 vdd.n1683 vdd.t1745 7.62594
R1563 vdd.n1664 vdd.t1752 7.62594
R1564 vdd.n1666 vdd.t1751 7.62594
R1565 vdd.n1647 vdd.t1756 7.62594
R1566 vdd.n1649 vdd.t1755 7.62594
R1567 vdd.n1630 vdd.t1760 7.62594
R1568 vdd.n1632 vdd.t1759 7.62594
R1569 vdd.n1613 vdd.t1764 7.62594
R1570 vdd.n1615 vdd.t1763 7.62594
R1571 vdd.n1596 vdd.t1768 7.62594
R1572 vdd.n1598 vdd.t1767 7.62594
R1573 vdd.n1579 vdd.t1782 7.62594
R1574 vdd.n1581 vdd.t1781 7.62594
R1575 vdd.n1562 vdd.t1789 7.62594
R1576 vdd.n1564 vdd.t1788 7.62594
R1577 vdd.n1545 vdd.t1795 7.62594
R1578 vdd.n1547 vdd.t1794 7.62594
R1579 vdd.n1528 vdd.t1799 7.62594
R1580 vdd.n1530 vdd.t1798 7.62594
R1581 vdd.n1511 vdd.t1803 7.62594
R1582 vdd.n1513 vdd.t1802 7.62594
R1583 vdd.n1490 vdd.t1818 7.62594
R1584 vdd.n1414 vdd.t1835 7.62594
R1585 vdd.n1417 vdd.t1834 7.62594
R1586 vdd.n1423 vdd.t1833 7.62594
R1587 vdd.n1426 vdd.t1832 7.62594
R1588 vdd.n1432 vdd.t1831 7.62594
R1589 vdd.n1435 vdd.t1830 7.62594
R1590 vdd.n1441 vdd.t1829 7.62594
R1591 vdd.n1444 vdd.t1828 7.62594
R1592 vdd.n1450 vdd.t1827 7.62594
R1593 vdd.n1453 vdd.t1826 7.62594
R1594 vdd.n1459 vdd.t1825 7.62594
R1595 vdd.n1462 vdd.t1824 7.62594
R1596 vdd.n1468 vdd.t1823 7.62594
R1597 vdd.n1471 vdd.t1822 7.62594
R1598 vdd.n1477 vdd.t1821 7.62594
R1599 vdd.n1480 vdd.t1820 7.62594
R1600 vdd.n1486 vdd.t1819 7.62594
R1601 vdd.n1219 vdd.t1303 7.58942
R1602 vdd.n1219 vdd.t1307 7.58942
R1603 vdd.n1218 vdd.t1304 7.58942
R1604 vdd.n1218 vdd.t1308 7.58942
R1605 vdd.n1245 vdd.t1302 7.58942
R1606 vdd.n1245 vdd.t1306 7.58942
R1607 vdd.n1244 vdd.t1301 7.58942
R1608 vdd.n1244 vdd.t1305 7.58942
R1609 vdd.n1247 vdd.n1243 7.46974
R1610 vdd.n1222 vdd.n1221 7.46974
R1611 vdd.n1844 vdd.n6 7.29736
R1612 vdd.n1987 vdd.n1986 7.29736
R1613 vdd.n2092 vdd.n2091 7.1141
R1614 vdd.n1194 vdd.n1193 6.82795
R1615 vdd.n1309 vdd.t809 6.76772
R1616 vdd.n1312 vdd.t805 6.76772
R1617 vdd.n1329 vdd.t804 6.76772
R1618 vdd.n1314 vdd.t802 6.76772
R1619 vdd.n1316 vdd.t800 6.76772
R1620 vdd.n1317 vdd.t798 6.76772
R1621 vdd.n1256 vdd.t797 6.76772
R1622 vdd.n1257 vdd.t796 6.76772
R1623 vdd.n1258 vdd.t795 6.76738
R1624 vdd.n1308 vdd.t811 6.76738
R1625 vdd.n1310 vdd.t808 6.76738
R1626 vdd.n1311 vdd.t807 6.76738
R1627 vdd.n1313 vdd.t806 6.76738
R1628 vdd.n1328 vdd.t803 6.76738
R1629 vdd.n1315 vdd.t801 6.76738
R1630 vdd.n2159 vdd.n2158 6.69463
R1631 vdd.n1239 vdd.t1037 6.41573
R1632 vdd.n1225 vdd.t1036 6.41384
R1633 vdd.n1355 vdd.t1677 6.24515
R1634 vdd.n1357 vdd.t1678 6.24515
R1635 vdd.n1362 vdd.t1680 6.24515
R1636 vdd.n1365 vdd.t1682 6.24515
R1637 vdd.n1319 vdd.t1684 6.24515
R1638 vdd.n1338 vdd.t1666 6.24515
R1639 vdd.n1342 vdd.t1667 6.24515
R1640 vdd.n1345 vdd.t1669 6.24515
R1641 vdd.n1350 vdd.t1671 6.24515
R1642 vdd.n1352 vdd.t1673 6.24515
R1643 vdd.n206 vdd.t27 6.20655
R1644 vdd.n1322 vdd.t1289 6.19886
R1645 vdd.n1335 vdd.t1201 6.19886
R1646 vdd.n276 vdd.t946 6.15116
R1647 vdd.n231 vdd.t1292 6.15116
R1648 vdd.n211 vdd.t29 6.15116
R1649 vdd.n219 vdd.t28 6.15116
R1650 vdd.n207 vdd.t26 6.15116
R1651 vdd.n2133 vdd.t548 6.13684
R1652 vdd.n1997 vdd.t712 6.12178
R1653 vdd.n1983 vdd.t395 6.11173
R1654 vdd.n1950 vdd.t233 6.11173
R1655 vdd.n317 vdd.t40 6.11173
R1656 vdd.n1834 vdd.t455 6.11173
R1657 vdd.n1898 vdd.t494 6.11173
R1658 vdd.n1498 vdd.t289 6.11173
R1659 vdd.n1832 vdd.t414 6.08295
R1660 vdd.n1896 vdd.t481 6.08295
R1661 vdd.n1496 vdd.t1665 6.08295
R1662 vdd.n1981 vdd.t115 6.07803
R1663 vdd.n1948 vdd.t224 6.07803
R1664 vdd.n315 vdd.t21 6.07803
R1665 vdd.n1416 vdd.t293 6.07759
R1666 vdd.n1229 vdd.t1035 6.03185
R1667 vdd.n1235 vdd.t1038 6.03185
R1668 vdd.n1231 vdd.n1226 6.02988
R1669 vdd.n1241 vdd.n1240 6.02988
R1670 vdd.n1347 vdd.t786 6.02741
R1671 vdd.n1344 vdd.t785 6.02741
R1672 vdd.n1340 vdd.t783 6.02741
R1673 vdd.n1337 vdd.t782 6.02741
R1674 vdd.n1334 vdd.t781 6.02741
R1675 vdd.n1331 vdd.t779 6.02741
R1676 vdd.n1326 vdd.t777 6.02741
R1677 vdd.n1323 vdd.t775 6.02741
R1678 vdd.n1363 vdd.t771 6.02741
R1679 vdd.n1320 vdd.t774 6.02676
R1680 vdd.t773 vdd.n1255 6.02676
R1681 vdd.n1360 vdd.t770 6.02676
R1682 vdd.n2031 vdd.t758 5.98925
R1683 vdd.n2039 vdd.t1206 5.98925
R1684 vdd.n2044 vdd.t739 5.98925
R1685 vdd.n2073 vdd.t626 5.98925
R1686 vdd.n2067 vdd.t650 5.98925
R1687 vdd.n2061 vdd.t598 5.98925
R1688 vdd.n2011 vdd.t1139 5.98882
R1689 vdd.n5 vdd.t724 6.01432
R1690 vdd.n1991 vdd.t536 5.98882
R1691 vdd.n2080 vdd.t508 5.98882
R1692 vdd.n1 vdd.t1115 6.01432
R1693 vdd.n2031 vdd.t1144 5.98882
R1694 vdd.n2039 vdd.t922 5.98882
R1695 vdd.n2044 vdd.t1236 5.98882
R1696 vdd.n2073 vdd.t663 5.98882
R1697 vdd.n2067 vdd.t510 5.98882
R1698 vdd.n2061 vdd.t596 5.98882
R1699 vdd.n516 vdd.t875 5.98829
R1700 vdd.n474 vdd.t1624 5.98829
R1701 vdd.n476 vdd.t977 5.98829
R1702 vdd.n471 vdd.t760 5.98829
R1703 vdd.n469 vdd.t981 5.98829
R1704 vdd.n474 vdd.t606 5.98786
R1705 vdd.n476 vdd.t711 5.98786
R1706 vdd.n471 vdd.t1199 5.98786
R1707 vdd.n469 vdd.t945 5.98786
R1708 vdd.n628 vdd.t985 5.98786
R1709 vdd.n440 vdd.t636 5.98786
R1710 vdd.n7 vdd.t978 5.98786
R1711 vdd.n7 vdd.t1124 5.98786
R1712 vdd.n524 vdd.t1026 5.98324
R1713 vdd.n1284 vdd.t822 5.97886
R1714 vdd.n1285 vdd.t824 5.97886
R1715 vdd.n1288 vdd.t830 5.97886
R1716 vdd.n1290 vdd.t834 5.97886
R1717 vdd.n1292 vdd.t838 5.97886
R1718 vdd.n1294 vdd.t842 5.97886
R1719 vdd.n1297 vdd.t848 5.97886
R1720 vdd.n1298 vdd.t850 5.97886
R1721 vdd.n1300 vdd.t854 5.97886
R1722 vdd.n1282 vdd.t818 5.97786
R1723 vdd.n2137 vdd.t549 5.97741
R1724 vdd.n432 vdd.t874 5.97426
R1725 vdd.n504 vdd.t1615 5.97212
R1726 vdd.n463 vdd.t869 5.97212
R1727 vdd.n498 vdd.t1215 5.97212
R1728 vdd.n499 vdd.t1216 5.97212
R1729 vdd.n526 vdd.t1119 5.97212
R1730 vdd.n528 vdd.t1120 5.97212
R1731 vdd.n2025 vdd.t613 5.97212
R1732 vdd.n14 vdd.t540 5.97212
R1733 vdd.n1771 vdd.t674 5.97212
R1734 vdd.n498 vdd.t881 5.97169
R1735 vdd.n499 vdd.t882 5.97169
R1736 vdd.n458 vdd.t661 5.97169
R1737 vdd.n501 vdd.t662 5.97169
R1738 vdd.n517 vdd.t1260 5.97169
R1739 vdd.n520 vdd.t1261 5.97169
R1740 vdd.n526 vdd.t587 5.97169
R1741 vdd.n528 vdd.t588 5.97169
R1742 vdd.n430 vdd.t1218 5.97169
R1743 vdd.n1998 vdd.t1205 5.97169
R1744 vdd.n2001 vdd.t1204 5.97169
R1745 vdd.n2025 vdd.t614 5.97169
R1746 vdd.n2145 vdd.t546 5.97169
R1747 vdd.n2147 vdd.t547 5.97169
R1748 vdd.n169 vdd.t33 5.97001
R1749 vdd.n186 vdd.t1676 5.97001
R1750 vdd.n184 vdd.t36 5.97001
R1751 vdd.n178 vdd.t43 5.97001
R1752 vdd.n176 vdd.t35 5.97001
R1753 vdd.n170 vdd.t18 5.97001
R1754 vdd.n1972 vdd.t292 5.97001
R1755 vdd.n1976 vdd.t497 5.97001
R1756 vdd.n1963 vdd.t381 5.97001
R1757 vdd.n1967 vdd.t1659 5.97001
R1758 vdd.n1954 vdd.t400 5.97001
R1759 vdd.n1958 vdd.t125 5.97001
R1760 vdd.n1939 vdd.t489 5.97001
R1761 vdd.n1943 vdd.t178 5.97001
R1762 vdd.n411 vdd.t391 5.97001
R1763 vdd.n415 vdd.t246 5.97001
R1764 vdd.n402 vdd.t235 5.97001
R1765 vdd.n406 vdd.t104 5.97001
R1766 vdd.n393 vdd.t186 5.97001
R1767 vdd.n397 vdd.t315 5.97001
R1768 vdd.n384 vdd.t92 5.97001
R1769 vdd.n388 vdd.t239 5.97001
R1770 vdd.n375 vdd.t195 5.97001
R1771 vdd.n379 vdd.t112 5.97001
R1772 vdd.n366 vdd.t457 5.97001
R1773 vdd.n370 vdd.t473 5.97001
R1774 vdd.n357 vdd.t107 5.97001
R1775 vdd.n361 vdd.t446 5.97001
R1776 vdd.n348 vdd.t348 5.97001
R1777 vdd.n352 vdd.t214 5.97001
R1778 vdd.n339 vdd.t109 5.97001
R1779 vdd.n343 vdd.t76 5.97001
R1780 vdd.n330 vdd.t24 5.97001
R1781 vdd.n334 vdd.t47 5.97001
R1782 vdd.n321 vdd.t5 5.97001
R1783 vdd.n325 vdd.t57 5.97001
R1784 vdd.n1825 vdd.t479 5.97001
R1785 vdd.n1815 vdd.t313 5.97001
R1786 vdd.n1817 vdd.t418 5.97001
R1787 vdd.n1805 vdd.t382 5.97001
R1788 vdd.n1809 vdd.t356 5.97001
R1789 vdd.n1796 vdd.t321 5.97001
R1790 vdd.n1798 vdd.t425 5.97001
R1791 vdd.n1791 vdd.t352 5.97001
R1792 vdd.n16 vdd.t475 5.97001
R1793 vdd.n1784 vdd.t327 5.97001
R1794 vdd.n1786 vdd.t411 5.97001
R1795 vdd.n1744 vdd.t329 5.97001
R1796 vdd.n10 vdd.t358 5.97001
R1797 vdd.n1739 vdd.t440 5.97001
R1798 vdd.n1741 vdd.t336 5.97001
R1799 vdd.n1730 vdd.t361 5.97001
R1800 vdd.n1734 vdd.t465 5.97001
R1801 vdd.n1726 vdd.t423 5.97001
R1802 vdd.n1728 vdd.t444 5.97001
R1803 vdd.n1715 vdd.t435 5.97001
R1804 vdd.n1719 vdd.t310 5.97001
R1805 vdd.n1707 vdd.t428 5.97001
R1806 vdd.n1709 vdd.t468 5.97001
R1807 vdd.n1699 vdd.t374 5.97001
R1808 vdd.n1838 vdd.t340 5.97001
R1809 vdd.n1840 vdd.t461 5.97001
R1810 vdd.n1845 vdd.t483 5.97001
R1811 vdd.n1857 vdd.t193 5.97001
R1812 vdd.n1855 vdd.t342 5.97001
R1813 vdd.n1850 vdd.t243 5.97001
R1814 vdd.n1862 vdd.t420 5.97001
R1815 vdd.n1874 vdd.t1657 5.97001
R1816 vdd.n1872 vdd.t298 5.97001
R1817 vdd.n1867 vdd.t307 5.97001
R1818 vdd.n1879 vdd.t189 5.97001
R1819 vdd.n1891 vdd.t368 5.97001
R1820 vdd.n1889 vdd.t392 5.97001
R1821 vdd.n1884 vdd.t416 5.97001
R1822 vdd.n1902 vdd.t433 5.97001
R1823 vdd.n1904 vdd.t183 5.97001
R1824 vdd.n1909 vdd.t402 5.97001
R1825 vdd.n1921 vdd.t271 5.97001
R1826 vdd.n1919 vdd.t226 5.97001
R1827 vdd.n1914 vdd.t161 5.97001
R1828 vdd.n1679 vdd.t492 5.97001
R1829 vdd.n1691 vdd.t165 5.97001
R1830 vdd.n1689 vdd.t378 5.97001
R1831 vdd.n1684 vdd.t163 5.97001
R1832 vdd.n1662 vdd.t265 5.97001
R1833 vdd.n1674 vdd.t320 5.97001
R1834 vdd.n1672 vdd.t220 5.97001
R1835 vdd.n1667 vdd.t360 5.97001
R1836 vdd.n1645 vdd.t130 5.97001
R1837 vdd.n1657 vdd.t332 5.97001
R1838 vdd.n1655 vdd.t98 5.97001
R1839 vdd.n1650 vdd.t346 5.97001
R1840 vdd.n1628 vdd.t344 5.97001
R1841 vdd.n1640 vdd.t487 5.97001
R1842 vdd.n1638 vdd.t202 5.97001
R1843 vdd.n1633 vdd.t70 5.97001
R1844 vdd.n1611 vdd.t269 5.97001
R1845 vdd.n1623 vdd.t297 5.97001
R1846 vdd.n1621 vdd.t145 5.97001
R1847 vdd.n1616 vdd.t191 5.97001
R1848 vdd.n1594 vdd.t485 5.97001
R1849 vdd.n1606 vdd.t155 5.97001
R1850 vdd.n1604 vdd.t274 5.97001
R1851 vdd.n1599 vdd.t180 5.97001
R1852 vdd.n1577 vdd.t351 5.97001
R1853 vdd.n1589 vdd.t439 5.97001
R1854 vdd.n1587 vdd.t337 5.97001
R1855 vdd.n1582 vdd.t471 5.97001
R1856 vdd.n1560 vdd.t73 5.97001
R1857 vdd.n1572 vdd.t168 5.97001
R1858 vdd.n1570 vdd.t151 5.97001
R1859 vdd.n1565 vdd.t120 5.97001
R1860 vdd.n1543 vdd.t459 5.97001
R1861 vdd.n1555 vdd.t212 5.97001
R1862 vdd.n1553 vdd.t66 5.97001
R1863 vdd.n1548 vdd.t499 5.97001
R1864 vdd.n1526 vdd.t317 5.97001
R1865 vdd.n1538 vdd.t450 5.97001
R1866 vdd.n1536 vdd.t89 5.97001
R1867 vdd.n1531 vdd.t122 5.97001
R1868 vdd.n1509 vdd.t59 5.97001
R1869 vdd.n1521 vdd.t55 5.97001
R1870 vdd.n1519 vdd.t437 5.97001
R1871 vdd.n1514 vdd.t283 5.97001
R1872 vdd.n1502 vdd.t262 5.97001
R1873 vdd.n1504 vdd.t1689 5.97001
R1874 vdd.n169 vdd.t11 5.96957
R1875 vdd.n186 vdd.t38 5.96957
R1876 vdd.n184 vdd.t32 5.96957
R1877 vdd.n178 vdd.t16 5.96957
R1878 vdd.n176 vdd.t50 5.96957
R1879 vdd.n170 vdd.t49 5.96957
R1880 vdd.n1972 vdd.t426 5.96957
R1881 vdd.n1976 vdd.t431 5.96957
R1882 vdd.n1963 vdd.t462 5.96957
R1883 vdd.n1967 vdd.t447 5.96957
R1884 vdd.n1954 vdd.t363 5.96957
R1885 vdd.n1958 vdd.t478 5.96957
R1886 vdd.n1939 vdd.t198 5.96957
R1887 vdd.n1943 vdd.t244 5.96957
R1888 vdd.n411 vdd.t409 5.96957
R1889 vdd.n415 vdd.t139 5.96957
R1890 vdd.n402 vdd.t215 5.96957
R1891 vdd.n406 vdd.t295 5.96957
R1892 vdd.n393 vdd.t442 5.96957
R1893 vdd.n397 vdd.t397 5.96957
R1894 vdd.n384 vdd.t463 5.96957
R1895 vdd.n388 vdd.t63 5.96957
R1896 vdd.n375 vdd.t141 5.96957
R1897 vdd.n379 vdd.t453 5.96957
R1898 vdd.n366 vdd.t387 5.96957
R1899 vdd.n370 vdd.t495 5.96957
R1900 vdd.n357 vdd.t490 5.96957
R1901 vdd.n361 vdd.t333 5.96957
R1902 vdd.n348 vdd.t136 5.96957
R1903 vdd.n352 vdd.t240 5.96957
R1904 vdd.n339 vdd.t1687 5.96957
R1905 vdd.n343 vdd.t1661 5.96957
R1906 vdd.n330 vdd.t1674 5.96957
R1907 vdd.n334 vdd.t30 5.96957
R1908 vdd.n321 vdd.t13 5.96957
R1909 vdd.n325 vdd.t51 5.96957
R1910 vdd.n1845 vdd.t432 5.96957
R1911 vdd.n1857 vdd.t407 5.96957
R1912 vdd.n1855 vdd.t370 5.96957
R1913 vdd.n1850 vdd.t84 5.96957
R1914 vdd.n1862 vdd.t469 5.96957
R1915 vdd.n1874 vdd.t429 5.96957
R1916 vdd.n1872 vdd.t389 5.96957
R1917 vdd.n1867 vdd.t175 5.96957
R1918 vdd.n1879 vdd.t396 5.96957
R1919 vdd.n1891 vdd.t365 5.96957
R1920 vdd.n1889 vdd.t405 5.96957
R1921 vdd.n1884 vdd.t467 5.96957
R1922 vdd.n1909 vdd.t280 5.96957
R1923 vdd.n1921 vdd.t318 5.96957
R1924 vdd.n1919 vdd.t349 5.96957
R1925 vdd.n1914 vdd.t228 5.96957
R1926 vdd.n1679 vdd.t100 5.96957
R1927 vdd.n1691 vdd.t152 5.96957
R1928 vdd.n1689 vdd.t86 5.96957
R1929 vdd.n1684 vdd.t452 5.96957
R1930 vdd.n1662 vdd.t385 5.96957
R1931 vdd.n1674 vdd.t323 5.96957
R1932 vdd.n1672 vdd.t200 5.96957
R1933 vdd.n1667 vdd.t81 5.96957
R1934 vdd.n1645 vdd.t403 5.96957
R1935 vdd.n1657 vdd.t412 5.96957
R1936 vdd.n1655 vdd.t96 5.96957
R1937 vdd.n1650 vdd.t170 5.96957
R1938 vdd.n1628 vdd.t203 5.96957
R1939 vdd.n1640 vdd.t241 5.96957
R1940 vdd.n1638 vdd.t377 5.96957
R1941 vdd.n1633 vdd.t134 5.96957
R1942 vdd.n1611 vdd.t127 5.96957
R1943 vdd.n1623 vdd.t201 5.96957
R1944 vdd.n1621 vdd.t375 5.96957
R1945 vdd.n1616 vdd.t477 5.96957
R1946 vdd.n1594 vdd.t219 5.96957
R1947 vdd.n1606 vdd.t207 5.96957
R1948 vdd.n1604 vdd.t196 5.96957
R1949 vdd.n1599 vdd.t326 5.96957
R1950 vdd.n1577 vdd.t354 5.96957
R1951 vdd.n1589 vdd.t171 5.96957
R1952 vdd.n1587 vdd.t166 5.96957
R1953 vdd.n1582 vdd.t118 5.96957
R1954 vdd.n1560 vdd.t205 5.96957
R1955 vdd.n1572 vdd.t311 5.96957
R1956 vdd.n1570 vdd.t143 5.96957
R1957 vdd.n1565 vdd.t218 5.96957
R1958 vdd.n1543 vdd.t231 5.96957
R1959 vdd.n1555 vdd.t93 5.96957
R1960 vdd.n1553 vdd.t229 5.96957
R1961 vdd.n1548 vdd.t237 5.96957
R1962 vdd.n1526 vdd.t209 5.96957
R1963 vdd.n1538 vdd.t225 5.96957
R1964 vdd.n1536 vdd.t369 5.96957
R1965 vdd.n1531 vdd.t132 5.96957
R1966 vdd.n1509 vdd.t284 5.96957
R1967 vdd.n1521 vdd.t286 5.96957
R1968 vdd.n1519 vdd.t60 5.96957
R1969 vdd.n1514 vdd.t78 5.96957
R1970 vdd.n1369 vdd.t8 5.96957
R1971 vdd.n1412 vdd.t301 5.96957
R1972 vdd.n1410 vdd.t302 5.96957
R1973 vdd.n1420 vdd.t305 5.96957
R1974 vdd.n1422 vdd.t1649 5.96957
R1975 vdd.n1407 vdd.t1655 5.96957
R1976 vdd.n1405 vdd.t1660 5.96957
R1977 vdd.n1429 vdd.t1653 5.96957
R1978 vdd.n1431 vdd.t1647 5.96957
R1979 vdd.n1402 vdd.t1692 5.96957
R1980 vdd.n1400 vdd.t1690 5.96957
R1981 vdd.n1438 vdd.t1686 5.96957
R1982 vdd.n1440 vdd.t260 5.96957
R1983 vdd.n1397 vdd.t259 5.96957
R1984 vdd.n1395 vdd.t257 5.96957
R1985 vdd.n1447 vdd.t256 5.96957
R1986 vdd.n1449 vdd.t254 5.96957
R1987 vdd.n1392 vdd.t253 5.96957
R1988 vdd.n1390 vdd.t251 5.96957
R1989 vdd.n1456 vdd.t250 5.96957
R1990 vdd.n1458 vdd.t247 5.96957
R1991 vdd.n1387 vdd.t273 5.96957
R1992 vdd.n1385 vdd.t266 5.96957
R1993 vdd.n1465 vdd.t279 5.96957
R1994 vdd.n1467 vdd.t277 5.96957
R1995 vdd.n1382 vdd.t276 5.96957
R1996 vdd.n1380 vdd.t1651 5.96957
R1997 vdd.n1474 vdd.t2 5.96957
R1998 vdd.n1476 vdd.t958 5.96957
R1999 vdd.n1377 vdd.t948 5.96957
R2000 vdd.n1375 vdd.t6 5.96957
R2001 vdd.n1483 vdd.t501 5.96957
R2002 vdd.n1485 vdd.t52 5.96957
R2003 vdd.n1372 vdd.t45 5.96957
R2004 vdd.n1489 vdd.t41 5.96957
R2005 vdd.n627 vdd.t880 5.96578
R2006 vdd.n530 vdd.t1140 5.96578
R2007 vdd.n495 vdd.t535 5.96578
R2008 vdd.n466 vdd.t1061 5.96578
R2009 vdd.n482 vdd.t1285 5.96578
R2010 vdd.n426 vdd.t1623 5.96578
R2011 vdd.n477 vdd.t883 5.96578
R2012 vdd.n479 vdd.t503 5.96578
R2013 vdd.n443 vdd.t1622 5.96578
R2014 vdd.n2024 vdd.t1235 5.96578
R2015 vdd.n1746 vdd.t622 5.96578
R2016 vdd.n1750 vdd.t746 5.96578
R2017 vdd.n1753 vdd.t1253 5.96578
R2018 vdd.n1755 vdd.t612 5.96578
R2019 vdd.n1758 vdd.t1296 5.96578
R2020 vdd.n1767 vdd.t539 5.96578
R2021 vdd.n1775 vdd.t542 5.96578
R2022 vdd.n1777 vdd.t698 5.96578
R2023 vdd.n1780 vdd.t673 5.96578
R2024 vdd.n12 vdd.t1137 5.96578
R2025 vdd.n426 vdd.t605 5.96534
R2026 vdd.n477 vdd.t976 5.96534
R2027 vdd.n479 vdd.t620 5.96534
R2028 vdd.n485 vdd.t747 5.96534
R2029 vdd.n460 vdd.t1046 5.96534
R2030 vdd.n502 vdd.t524 5.96534
R2031 vdd.n513 vdd.t752 5.96534
R2032 vdd.n522 vdd.t1033 5.96534
R2033 vdd.n532 vdd.t884 5.96534
R2034 vdd.n443 vdd.t637 5.96534
R2035 vdd.n632 vdd.t903 5.96534
R2036 vdd.n634 vdd.t1620 5.96534
R2037 vdd.n300 vdd.t860 5.96534
R2038 vdd.n299 vdd.t725 5.96534
R2039 vdd.n290 vdd.t1148 5.96534
R2040 vdd.n291 vdd.t1217 5.96534
R2041 vdd.n293 vdd.t1123 5.96534
R2042 vdd.n292 vdd.t878 5.96534
R2043 vdd.n37 vdd.t618 5.97717
R2044 vdd.n2000 vdd.t1614 5.96534
R2045 vdd.n2003 vdd.t1194 5.96534
R2046 vdd.n2005 vdd.t1621 5.96534
R2047 vdd.n2024 vdd.t750 5.96534
R2048 vdd.n1760 vdd.t892 5.96534
R2049 vdd.n1757 vdd.t693 5.96534
R2050 vdd.n14 vdd.t555 5.96534
R2051 vdd.n2132 vdd.t648 5.96534
R2052 vdd.n2135 vdd.t635 5.96534
R2053 vdd.n2143 vdd.t1282 5.96534
R2054 vdd.n2098 vdd.t1639 5.96534
R2055 vdd.n1827 vdd.t372 5.96091
R2056 vdd.n1697 vdd.t421 5.96091
R2057 vdd.n160 vdd.t527 5.9217
R2058 vdd.n490 vdd.t521 5.91992
R2059 vdd.n2099 vdd.t608 5.91992
R2060 vdd.n1224 vdd.t1051 5.90366
R2061 vdd.n1238 vdd.t1050 5.90366
R2062 vdd.n36 vdd.n81 2.81315
R2063 vdd.n132 vdd.t560 0.473963
R2064 vdd.n131 vdd.t558 0.474995
R2065 vdd.n60 vdd.n58 0.00366162
R2066 vdd.n144 vdd.n47 0.00433258
R2067 vdd.t570 vdd.n44 0.00371011
R2068 vdd.n44 vdd.n89 1.06182
R2069 vdd.t287 vdd.n89 1.41647
R2070 vdd.t1127 vdd.n85 1.69785
R2071 vdd.n130 vdd.n68 3.401
R2072 vdd.t566 vdd.n92 0.00503612
R2073 vdd.n154 vdd.n68 5.66778
R2074 vdd.t308 vdd.n133 4.26437
R2075 vdd.n69 vdd.n43 1.30639
R2076 vdd.n108 vdd.t566 0.00479713
R2077 vdd.n108 vdd.n154 0.00369891
R2078 vdd.n69 vdd.n159 5.66717
R2079 vdd.n69 vdd.t287 1.41701
R2080 vdd.n188 vdd.t12 5.65005
R2081 vdd.n189 vdd.t34 5.65005
R2082 vdd.n180 vdd.t15 5.65005
R2083 vdd.n181 vdd.t37 5.65005
R2084 vdd.n172 vdd.t48 5.65005
R2085 vdd.n173 vdd.t17 5.65005
R2086 vdd.n1984 vdd.t114 5.65005
R2087 vdd.n1974 vdd.t427 5.65005
R2088 vdd.n1978 vdd.t291 5.65005
R2089 vdd.n1965 vdd.t448 5.65005
R2090 vdd.n1969 vdd.t380 5.65005
R2091 vdd.n1956 vdd.t364 5.65005
R2092 vdd.n1960 vdd.t124 5.65005
R2093 vdd.n1951 vdd.t223 5.65005
R2094 vdd.n1941 vdd.t199 5.65005
R2095 vdd.n1945 vdd.t177 5.65005
R2096 vdd.n413 vdd.t140 5.65005
R2097 vdd.n417 vdd.t245 5.65005
R2098 vdd.n404 vdd.t216 5.65005
R2099 vdd.n408 vdd.t103 5.65005
R2100 vdd.n395 vdd.t398 5.65005
R2101 vdd.n399 vdd.t185 5.65005
R2102 vdd.n386 vdd.t64 5.65005
R2103 vdd.n390 vdd.t91 5.65005
R2104 vdd.n377 vdd.t142 5.65005
R2105 vdd.n381 vdd.t111 5.65005
R2106 vdd.n368 vdd.t388 5.65005
R2107 vdd.n372 vdd.t456 5.65005
R2108 vdd.n359 vdd.t334 5.65005
R2109 vdd.n363 vdd.t106 5.65005
R2110 vdd.n350 vdd.t137 5.65005
R2111 vdd.n354 vdd.t213 5.65005
R2112 vdd.n341 vdd.t1662 5.65005
R2113 vdd.n345 vdd.t75 5.65005
R2114 vdd.n332 vdd.t31 5.65005
R2115 vdd.n336 vdd.t23 5.65005
R2116 vdd.n323 vdd.t14 5.65005
R2117 vdd.n327 vdd.t4 5.65005
R2118 vdd.n318 vdd.t20 5.65005
R2119 vdd.n1821 vdd.t417 5.65005
R2120 vdd.n1811 vdd.t312 5.65005
R2121 vdd.n1802 vdd.t383 5.65005
R2122 vdd.n38 vdd.t322 5.65005
R2123 vdd.n1788 vdd.t353 5.65005
R2124 vdd.n9 vdd.t328 5.65005
R2125 vdd.n124 vdd.t330 5.65005
R2126 vdd.n1736 vdd.t441 5.65005
R2127 vdd.n120 vdd.t362 5.65005
R2128 vdd.n1721 vdd.t309 5.65005
R2129 vdd.n1711 vdd.t436 5.65005
R2130 vdd.n1702 vdd.t373 5.65005
R2131 vdd.n1842 vdd.t413 5.65005
R2132 vdd.n1835 vdd.t341 5.65005
R2133 vdd.n1847 vdd.t408 5.65005
R2134 vdd.n1859 vdd.t192 5.65005
R2135 vdd.n1849 vdd.t83 5.65005
R2136 vdd.n1852 vdd.t242 5.65005
R2137 vdd.n1864 vdd.t430 5.65005
R2138 vdd.n1876 vdd.t419 5.65005
R2139 vdd.n1866 vdd.t174 5.65005
R2140 vdd.n1869 vdd.t299 5.65005
R2141 vdd.n1881 vdd.t366 5.65005
R2142 vdd.n1893 vdd.t188 5.65005
R2143 vdd.n1883 vdd.t406 5.65005
R2144 vdd.n1886 vdd.t393 5.65005
R2145 vdd.n1906 vdd.t182 5.65005
R2146 vdd.n1899 vdd.t434 5.65005
R2147 vdd.n1911 vdd.t281 5.65005
R2148 vdd.n1923 vdd.t270 5.65005
R2149 vdd.n1913 vdd.t227 5.65005
R2150 vdd.n1916 vdd.t160 5.65005
R2151 vdd.n1681 vdd.t101 5.65005
R2152 vdd.n1693 vdd.t164 5.65005
R2153 vdd.n1683 vdd.t87 5.65005
R2154 vdd.n1686 vdd.t162 5.65005
R2155 vdd.n1664 vdd.t324 5.65005
R2156 vdd.n1676 vdd.t264 5.65005
R2157 vdd.n1666 vdd.t80 5.65005
R2158 vdd.n1669 vdd.t221 5.65005
R2159 vdd.n1647 vdd.t404 5.65005
R2160 vdd.n1659 vdd.t129 5.65005
R2161 vdd.n1649 vdd.t97 5.65005
R2162 vdd.n1652 vdd.t99 5.65005
R2163 vdd.n1630 vdd.t204 5.65005
R2164 vdd.n1642 vdd.t343 5.65005
R2165 vdd.n1632 vdd.t133 5.65005
R2166 vdd.n1635 vdd.t69 5.65005
R2167 vdd.n1613 vdd.t128 5.65005
R2168 vdd.n1625 vdd.t268 5.65005
R2169 vdd.n1615 vdd.t376 5.65005
R2170 vdd.n1618 vdd.t146 5.65005
R2171 vdd.n1596 vdd.t208 5.65005
R2172 vdd.n1608 vdd.t154 5.65005
R2173 vdd.n1598 vdd.t197 5.65005
R2174 vdd.n1601 vdd.t179 5.65005
R2175 vdd.n1579 vdd.t172 5.65005
R2176 vdd.n1591 vdd.t350 5.65005
R2177 vdd.n1581 vdd.t117 5.65005
R2178 vdd.n1584 vdd.t338 5.65005
R2179 vdd.n1562 vdd.t206 5.65005
R2180 vdd.n1574 vdd.t72 5.65005
R2181 vdd.n1564 vdd.t144 5.65005
R2182 vdd.n1567 vdd.t119 5.65005
R2183 vdd.n1545 vdd.t94 5.65005
R2184 vdd.n1557 vdd.t211 5.65005
R2185 vdd.n1547 vdd.t230 5.65005
R2186 vdd.n1550 vdd.t67 5.65005
R2187 vdd.n1528 vdd.t210 5.65005
R2188 vdd.n1540 vdd.t316 5.65005
R2189 vdd.n1530 vdd.t131 5.65005
R2190 vdd.n1533 vdd.t90 5.65005
R2191 vdd.n1511 vdd.t285 5.65005
R2192 vdd.n1523 vdd.t54 5.65005
R2193 vdd.n1513 vdd.t61 5.65005
R2194 vdd.n1516 vdd.t282 5.65005
R2195 vdd.n1506 vdd.t1664 5.65005
R2196 vdd.n1499 vdd.t263 5.65005
R2197 vdd.n1490 vdd.t9 5.65005
R2198 vdd.n1414 vdd.t294 5.65005
R2199 vdd.n1417 vdd.t303 5.65005
R2200 vdd.n1423 vdd.t1650 5.65005
R2201 vdd.n1426 vdd.t1652 5.65005
R2202 vdd.n1432 vdd.t1648 5.65005
R2203 vdd.n1435 vdd.t1685 5.65005
R2204 vdd.n1441 vdd.t258 5.65005
R2205 vdd.n1444 vdd.t255 5.65005
R2206 vdd.n1450 vdd.t252 5.65005
R2207 vdd.n1453 vdd.t249 5.65005
R2208 vdd.n1459 vdd.t248 5.65005
R2209 vdd.n1462 vdd.t267 5.65005
R2210 vdd.n1468 vdd.t275 5.65005
R2211 vdd.n1471 vdd.t1 5.65005
R2212 vdd.n1477 vdd.t947 5.65005
R2213 vdd.n1480 vdd.t7 5.65005
R2214 vdd.n1486 vdd.t44 5.65005
R2215 vdd.n2116 vdd.n2106 5.6487
R2216 vdd.n167 vdd.t371 5.64493
R2217 vdd.n1696 vdd.t422 5.64493
R2218 vdd.t10 vdd.n187 5.64096
R2219 vdd.t308 vdd.n1790 5.64096
R2220 vdd.t308 vdd.n1823 5.64096
R2221 vdd.t0 vdd.n1373 5.64096
R2222 vdd.t0 vdd.n1482 5.64096
R2223 vdd.t0 vdd.n1378 5.64096
R2224 vdd.t0 vdd.n1473 5.64096
R2225 vdd.t0 vdd.n1383 5.64096
R2226 vdd.t0 vdd.n1464 5.64096
R2227 vdd.t0 vdd.n1388 5.64096
R2228 vdd.t0 vdd.n1455 5.64096
R2229 vdd.t0 vdd.n1393 5.64096
R2230 vdd.t0 vdd.n1446 5.64096
R2231 vdd.t0 vdd.n1398 5.64096
R2232 vdd.t0 vdd.n1437 5.64096
R2233 vdd.t0 vdd.n1403 5.64096
R2234 vdd.t0 vdd.n1428 5.64096
R2235 vdd.t0 vdd.n1408 5.64096
R2236 vdd.t0 vdd.n1419 5.64096
R2237 vdd.t0 vdd.n1413 5.64096
R2238 vdd.t0 vdd.n1492 5.64013
R2239 vdd.t10 vdd.n183 5.64013
R2240 vdd.t308 vdd.n1738 5.64013
R2241 vdd.t308 vdd.n11 2.04431
R2242 vdd.n17 vdd.n16 0.0431742
R2243 vdd.n1841 vdd.n1833 5.64013
R2244 vdd.n1858 vdd.n1848 5.64013
R2245 vdd.n1875 vdd.n1865 5.64013
R2246 vdd.n1892 vdd.n1882 5.64013
R2247 vdd.n1905 vdd.n1897 5.64013
R2248 vdd.n1922 vdd.n1912 5.64013
R2249 vdd.n1692 vdd.n1682 5.64013
R2250 vdd.n1675 vdd.n1665 5.64013
R2251 vdd.n1658 vdd.n1648 5.64013
R2252 vdd.n1641 vdd.n1631 5.64013
R2253 vdd.n1624 vdd.n1614 5.64013
R2254 vdd.n1607 vdd.n1597 5.64013
R2255 vdd.n1590 vdd.n1580 5.64013
R2256 vdd.n1573 vdd.n1563 5.64013
R2257 vdd.n1556 vdd.n1546 5.64013
R2258 vdd.n1539 vdd.n1529 5.64013
R2259 vdd.n1522 vdd.n1512 5.64013
R2260 vdd.n1505 vdd.n1497 5.64013
R2261 vdd.n1929 vdd.n639 5.62801
R2262 vdd.n1929 vdd.n641 5.62801
R2263 vdd.n277 vdd.t25 5.62801
R2264 vdd.n568 vdd.n24 5.62801
R2265 vdd.n24 vdd.n41 5.62801
R2266 vdd.n1982 vdd.n1981 5.62104
R2267 vdd.n1975 vdd.n1973 5.62104
R2268 vdd.n1966 vdd.n1964 5.62104
R2269 vdd.n1957 vdd.n1955 5.62104
R2270 vdd.n1949 vdd.n1948 5.62104
R2271 vdd.n1942 vdd.n1940 5.62104
R2272 vdd.n414 vdd.n412 5.62104
R2273 vdd.n405 vdd.n403 5.62104
R2274 vdd.n396 vdd.n394 5.62104
R2275 vdd.n387 vdd.n385 5.62104
R2276 vdd.n378 vdd.n376 5.62104
R2277 vdd.n369 vdd.n367 5.62104
R2278 vdd.n360 vdd.n358 5.62104
R2279 vdd.n351 vdd.n349 5.62104
R2280 vdd.n342 vdd.n340 5.62104
R2281 vdd.n333 vdd.n331 5.62104
R2282 vdd.n324 vdd.n322 5.62104
R2283 vdd.n316 vdd.n315 5.62104
R2284 vdd.t0 vdd.n1416 5.62104
R2285 vdd.n251 vdd.t25 5.61869
R2286 vdd.n240 vdd.t25 5.61869
R2287 vdd.n260 vdd.t25 5.61869
R2288 vdd.n266 vdd.t25 5.61869
R2289 vdd.n1833 vdd.n1832 5.61857
R2290 vdd.n1848 vdd.n1846 5.61857
R2291 vdd.n1865 vdd.n1863 5.61857
R2292 vdd.n1882 vdd.n1880 5.61857
R2293 vdd.n1897 vdd.n1896 5.61857
R2294 vdd.n1912 vdd.n1910 5.61857
R2295 vdd.n1682 vdd.n1680 5.61857
R2296 vdd.n1665 vdd.n1663 5.61857
R2297 vdd.n1648 vdd.n1646 5.61857
R2298 vdd.n1631 vdd.n1629 5.61857
R2299 vdd.n1614 vdd.n1612 5.61857
R2300 vdd.n1597 vdd.n1595 5.61857
R2301 vdd.n1580 vdd.n1578 5.61857
R2302 vdd.n1563 vdd.n1561 5.61857
R2303 vdd.n1546 vdd.n1544 5.61857
R2304 vdd.n1529 vdd.n1527 5.61857
R2305 vdd.n1512 vdd.n1510 5.61857
R2306 vdd.n1497 vdd.n1496 5.61857
R2307 vdd.n831 vdd.n58 5.61509
R2308 vdd.n7 vdd.n634 0.25404
R2309 vdd.t502 vdd.n447 5.61485
R2310 vdd.t502 vdd.n503 5.61485
R2311 vdd.t502 vdd.n461 5.61485
R2312 vdd.t502 vdd.n480 5.61485
R2313 vdd.t502 vdd.n472 5.61485
R2314 vdd.t502 vdd.n473 5.61485
R2315 vdd.n298 vdd.t617 5.61485
R2316 vdd.n94 vdd.t617 4.17712
R2317 vdd.n304 vdd.n78 0.600911
R2318 vdd.n305 vdd.n77 0.570583
R2319 vdd.n77 vdd.t617 1.51772
R2320 vdd.n19 vdd.n309 0.610767
R2321 vdd.t507 vdd.n2081 5.61485
R2322 vdd.t507 vdd.n1992 5.61485
R2323 vdd.t507 vdd.n1994 5.61485
R2324 vdd.t507 vdd.n2010 5.61485
R2325 vdd.t507 vdd.n1995 5.61485
R2326 vdd.t507 vdd.n2004 5.61485
R2327 vdd.t507 vdd.n1996 5.61485
R2328 vdd.t507 vdd.n1999 5.61485
R2329 vdd.n2062 vdd.t511 5.61485
R2330 vdd.n2068 vdd.t511 5.61485
R2331 vdd.t511 vdd.n2017 5.61485
R2332 vdd.t511 vdd.n2045 5.61485
R2333 vdd.t511 vdd.n2020 5.61485
R2334 vdd.t511 vdd.n2032 5.61485
R2335 vdd.t511 vdd.n2022 5.61485
R2336 vdd.t511 vdd.n2029 5.61485
R2337 vdd.t308 vdd.n1714 5.61485
R2338 vdd.t308 vdd.n1745 5.61485
R2339 vdd.t308 vdd.n1751 5.61485
R2340 vdd.t308 vdd.n1754 5.61485
R2341 vdd.n15 vdd.n14 0.175395
R2342 vdd.t308 vdd.n15 2.72098
R2343 vdd.t308 vdd.n1759 5.61485
R2344 vdd.t308 vdd.n1772 5.61485
R2345 vdd.t308 vdd.n1776 5.61485
R2346 vdd.t308 vdd.n1779 5.61485
R2347 vdd.t308 vdd.n1810 5.61485
R2348 vdd.n2152 vdd.t515 5.61485
R2349 vdd.t515 vdd.n2144 5.61485
R2350 vdd.t515 vdd.n2101 5.61485
R2351 vdd.t515 vdd.n2102 5.61485
R2352 vdd.n110 vdd.n81 4.17719
R2353 vdd.n141 vdd.n61 4.17491
R2354 vdd.n822 vdd.n88 0.262733
R2355 vdd.n90 vdd.n89 0.0687082
R2356 vdd.n76 vdd.n86 2.5625
R2357 vdd.n1263 vdd.t789 5.56245
R2358 vdd.n1267 vdd.t813 5.56245
R2359 vdd.n1269 vdd.t856 5.56245
R2360 vdd.n1261 vdd.t765 5.56245
R2361 vdd.n1277 vdd.t791 5.56245
R2362 vdd.n1279 vdd.t815 5.56245
R2363 vdd.n1260 vdd.t766 5.56245
R2364 vdd.n1274 vdd.t792 5.56245
R2365 vdd.n1276 vdd.t816 5.56245
R2366 vdd.n1259 vdd.t768 5.56245
R2367 vdd.n1271 vdd.t794 5.56245
R2368 vdd.n1273 vdd.t818 5.56245
R2369 vdd.t768 vdd.n1258 5.56245
R2370 vdd.n1302 vdd.t854 5.56245
R2371 vdd.t787 vdd.n1305 5.56245
R2372 vdd.n1304 vdd.t812 5.56245
R2373 vdd.n1307 vdd.t787 5.56245
R2374 vdd.n1306 vdd.t1226 5.56245
R2375 vdd.n1262 vdd.t790 5.56245
R2376 vdd.n1264 vdd.t814 5.56245
R2377 vdd.n1266 vdd.t857 5.56245
R2378 vdd.n1308 vdd.t786 5.56245
R2379 vdd.n1309 vdd.t784 5.56245
R2380 vdd.n1310 vdd.t783 5.56245
R2381 vdd.n1311 vdd.t782 5.56245
R2382 vdd.t780 vdd.n1312 5.56245
R2383 vdd.n1313 vdd.t780 5.56245
R2384 vdd.n1329 vdd.t778 5.56245
R2385 vdd.t778 vdd.n1328 5.56245
R2386 vdd.t776 vdd.n1314 5.56245
R2387 vdd.n1315 vdd.t776 5.56245
R2388 vdd.t774 vdd.n1316 5.56245
R2389 vdd.n1317 vdd.t773 5.56245
R2390 vdd.n1256 vdd.t772 5.56245
R2391 vdd.t770 vdd.n1257 5.56245
R2392 vdd.n1254 vdd.n1203 5.55967
R2393 vdd.n752 vdd.n661 5.49429
R2394 vdd.n589 vdd.t962 5.42347
R2395 vdd.n548 vdd.t971 5.42347
R2396 vdd.n1217 vdd.n1203 4.9891
R2397 vdd.n1254 vdd.n1253 4.98909
R2398 vdd.n1179 vdd.n661 4.90413
R2399 vdd.n1368 vdd.n1367 4.85567
R2400 vdd.n1368 vdd.n1201 4.85567
R2401 vdd.n638 vdd.t148 4.83805
R2402 vdd.n642 vdd.t156 4.83805
R2403 vdd.n1927 vdd.t150 4.83763
R2404 vdd.n645 vdd.t149 4.83763
R2405 vdd.n644 vdd.t158 4.83763
R2406 vdd.n640 vdd.t157 4.83763
R2407 vdd.n1934 vdd.t755 4.83763
R2408 vdd.n424 vdd.t754 4.83763
R2409 vdd.n423 vdd.t1294 4.83763
R2410 vdd.n420 vdd.t1286 4.83763
R2411 vdd.n622 vdd.n543 4.81924
R2412 vdd.n619 vdd.n618 4.81912
R2413 vdd.n1003 vdd.n1001 4.7296
R2414 vdd.n873 vdd.n872 4.7296
R2415 vdd.n999 vdd.n998 4.7296
R2416 vdd.n875 vdd.n835 4.7296
R2417 vdd.n842 vdd.n840 4.7296
R2418 vdd.n877 vdd.n838 4.7296
R2419 vdd.n979 vdd.n977 4.7296
R2420 vdd.n975 vdd.n974 4.7296
R2421 vdd.n969 vdd.n968 4.7296
R2422 vdd.n962 vdd.n960 4.7296
R2423 vdd.n902 vdd.n901 4.7296
R2424 vdd.n958 vdd.n957 4.7296
R2425 vdd.n904 vdd.n849 4.7296
R2426 vdd.n858 vdd.n855 4.7296
R2427 vdd.n906 vdd.n853 4.7296
R2428 vdd.n936 vdd.n934 4.7296
R2429 vdd.n914 vdd.n913 4.7296
R2430 vdd.n932 vdd.n931 4.7296
R2431 vdd.n928 vdd.n916 4.7296
R2432 vdd.n863 vdd.n748 4.7296
R2433 vdd.n865 vdd.n745 4.7296
R2434 vdd.n894 vdd.n893 4.7296
R2435 vdd.n886 vdd.n884 4.7296
R2436 vdd.n882 vdd.n881 4.7296
R2437 vdd.n1188 vdd.n1187 4.7296
R2438 vdd.n754 vdd.n652 4.7296
R2439 vdd.n669 vdd.n666 4.7296
R2440 vdd.n830 vdd.n664 4.7296
R2441 vdd.n1168 vdd.n1166 4.7296
R2442 vdd.n829 vdd.n828 4.7296
R2443 vdd.n1164 vdd.n1163 4.7296
R2444 vdd.n822 vdd.n673 4.7296
R2445 vdd.n681 vdd.n678 4.7296
R2446 vdd.n819 vdd.n676 4.7296
R2447 vdd.n1144 vdd.n1142 4.7296
R2448 vdd.n818 vdd.n817 4.7296
R2449 vdd.n1140 vdd.n1139 4.7296
R2450 vdd.n809 vdd.n685 4.7296
R2451 vdd.n693 vdd.n690 4.7296
R2452 vdd.n808 vdd.n688 4.7296
R2453 vdd.n1120 vdd.n1118 4.7296
R2454 vdd.n761 vdd.n760 4.7296
R2455 vdd.n1116 vdd.n1115 4.7296
R2456 vdd.n807 vdd.n697 4.7296
R2457 vdd.n705 vdd.n702 4.7296
R2458 vdd.n806 vdd.n699 4.7296
R2459 vdd.n1093 vdd.n1091 4.7296
R2460 vdd.n768 vdd.n767 4.7296
R2461 vdd.n1089 vdd.n1088 4.7296
R2462 vdd.n769 vdd.n709 4.7296
R2463 vdd.n717 vdd.n714 4.7296
R2464 vdd.n804 vdd.n712 4.7296
R2465 vdd.n1067 vdd.n1065 4.7296
R2466 vdd.n776 vdd.n775 4.7296
R2467 vdd.n1063 vdd.n1062 4.7296
R2468 vdd.n1058 vdd.n1057 4.7296
R2469 vdd.n1051 vdd.n1049 4.7296
R2470 vdd.n1047 vdd.n1046 4.7296
R2471 vdd.n781 vdd.n724 4.7296
R2472 vdd.n733 vdd.n730 4.7296
R2473 vdd.n782 vdd.n728 4.7296
R2474 vdd.n1027 vdd.n1025 4.7296
R2475 vdd.n789 vdd.n788 4.7296
R2476 vdd.n1023 vdd.n1022 4.7296
R2477 vdd.n1019 vdd.n736 4.7296
R2478 vdd.n780 vdd.n779 4.7296
R2479 vdd.n794 vdd.n792 4.7296
R2480 vdd.n802 vdd.n801 4.7296
R2481 vdd.n1242 vdd.n1232 4.67057
R2482 vdd.n1231 vdd.n1230 4.64616
R2483 vdd.n1241 vdd.n1236 4.64616
R2484 vdd.n618 vdd.n617 4.59637
R2485 vdd.n566 vdd.n565 4.59599
R2486 vdd.n564 vdd.n563 4.59599
R2487 vdd.n560 vdd.n556 4.59599
R2488 vdd.n588 vdd.n587 4.59599
R2489 vdd.n592 vdd.n591 4.59599
R2490 vdd.n593 vdd.n551 4.59599
R2491 vdd.n595 vdd.n594 4.59599
R2492 vdd.n610 vdd.n609 4.59599
R2493 vdd.n612 vdd.n611 4.59599
R2494 vdd.n546 vdd.n544 4.59599
R2495 vdd.n597 vdd.n596 4.59599
R2496 vdd.n599 vdd.n598 4.59599
R2497 vdd.n590 vdd.n589 4.59599
R2498 vdd.n549 vdd.n548 4.59599
R2499 vdd.n1190 vdd.n1189 4.5005
R2500 vdd.n1185 vdd.n648 4.5005
R2501 vdd.n1172 vdd.n1171 4.5005
R2502 vdd.n1170 vdd.n1169 4.5005
R2503 vdd.n1161 vdd.n667 4.5005
R2504 vdd.n1148 vdd.n1147 4.5005
R2505 vdd.n1146 vdd.n1145 4.5005
R2506 vdd.n1137 vdd.n679 4.5005
R2507 vdd.n1124 vdd.n1123 4.5005
R2508 vdd.n1122 vdd.n1121 4.5005
R2509 vdd.n1113 vdd.n691 4.5005
R2510 vdd.n1097 vdd.n1096 4.5005
R2511 vdd.n1095 vdd.n1094 4.5005
R2512 vdd.n1086 vdd.n703 4.5005
R2513 vdd.n1071 vdd.n1070 4.5005
R2514 vdd.n1069 vdd.n1068 4.5005
R2515 vdd.n1060 vdd.n715 4.5005
R2516 vdd.n1055 vdd.n1054 4.5005
R2517 vdd.n1053 vdd.n1052 4.5005
R2518 vdd.n1044 vdd.n721 4.5005
R2519 vdd.n1031 vdd.n1030 4.5005
R2520 vdd.n1029 vdd.n1028 4.5005
R2521 vdd.n735 vdd.n731 4.5005
R2522 vdd.n1007 vdd.n1006 4.5005
R2523 vdd.n1005 vdd.n1004 4.5005
R2524 vdd.n996 vdd.n749 4.5005
R2525 vdd.n983 vdd.n982 4.5005
R2526 vdd.n981 vdd.n980 4.5005
R2527 vdd.n972 vdd.n841 4.5005
R2528 vdd.n966 vdd.n965 4.5005
R2529 vdd.n964 vdd.n963 4.5005
R2530 vdd.n955 vdd.n845 4.5005
R2531 vdd.n940 vdd.n939 4.5005
R2532 vdd.n938 vdd.n937 4.5005
R2533 vdd.n861 vdd.n856 4.5005
R2534 vdd.n927 vdd.n926 4.5005
R2535 vdd.n911 vdd.n851 4.5005
R2536 vdd.n948 vdd.n947 4.5005
R2537 vdd.n950 vdd.n949 4.5005
R2538 vdd.n899 vdd.n850 4.5005
R2539 vdd.n891 vdd.n890 4.5005
R2540 vdd.n889 vdd.n888 4.5005
R2541 vdd.n879 vdd.n836 4.5005
R2542 vdd.n989 vdd.n988 4.5005
R2543 vdd.n991 vdd.n990 4.5005
R2544 vdd.n870 vdd.n744 4.5005
R2545 vdd.n1016 vdd.n1015 4.5005
R2546 vdd.n1018 vdd.n1017 4.5005
R2547 vdd.n786 vdd.n726 4.5005
R2548 vdd.n1037 vdd.n1036 4.5005
R2549 vdd.n1039 vdd.n1038 4.5005
R2550 vdd.n777 vdd.n725 4.5005
R2551 vdd.n797 vdd.n796 4.5005
R2552 vdd.n799 vdd.n798 4.5005
R2553 vdd.n773 vdd.n710 4.5005
R2554 vdd.n1077 vdd.n1076 4.5005
R2555 vdd.n1079 vdd.n1078 4.5005
R2556 vdd.n765 vdd.n698 4.5005
R2557 vdd.n1106 vdd.n1105 4.5005
R2558 vdd.n1108 vdd.n1107 4.5005
R2559 vdd.n758 vdd.n686 4.5005
R2560 vdd.n1130 vdd.n1129 4.5005
R2561 vdd.n1132 vdd.n1131 4.5005
R2562 vdd.n815 vdd.n674 4.5005
R2563 vdd.n1154 vdd.n1153 4.5005
R2564 vdd.n1156 vdd.n1155 4.5005
R2565 vdd.n826 vdd.n662 4.5005
R2566 vdd.n1178 vdd.n1177 4.5005
R2567 vdd.n1180 vdd.n1179 4.5005
R2568 vdd.n658 vdd.n649 4.5005
R2569 vdd.n660 vdd.n659 4.5005
R2570 vdd.n1003 vdd.n1002 4.5005
R2571 vdd.n872 vdd.n871 4.5005
R2572 vdd.n998 vdd.n997 4.5005
R2573 vdd.n835 vdd.n834 4.5005
R2574 vdd.n840 vdd.n839 4.5005
R2575 vdd.n838 vdd.n837 4.5005
R2576 vdd.n979 vdd.n978 4.5005
R2577 vdd.n974 vdd.n973 4.5005
R2578 vdd.n968 vdd.n967 4.5005
R2579 vdd.n962 vdd.n961 4.5005
R2580 vdd.n901 vdd.n900 4.5005
R2581 vdd.n957 vdd.n956 4.5005
R2582 vdd.n849 vdd.n848 4.5005
R2583 vdd.n855 vdd.n854 4.5005
R2584 vdd.n944 vdd.n943 4.5005
R2585 vdd.n853 vdd.n852 4.5005
R2586 vdd.n936 vdd.n935 4.5005
R2587 vdd.n913 vdd.n912 4.5005
R2588 vdd.n931 vdd.n930 4.5005
R2589 vdd.n929 vdd.n928 4.5005
R2590 vdd.n748 vdd.n747 4.5005
R2591 vdd.n746 vdd.n745 4.5005
R2592 vdd.n893 vdd.n892 4.5005
R2593 vdd.n886 vdd.n885 4.5005
R2594 vdd.n881 vdd.n880 4.5005
R2595 vdd.n1187 vdd.n1186 4.5005
R2596 vdd.n652 vdd.n651 4.5005
R2597 vdd.n666 vdd.n665 4.5005
R2598 vdd.n664 vdd.n663 4.5005
R2599 vdd.n1168 vdd.n1167 4.5005
R2600 vdd.n828 vdd.n827 4.5005
R2601 vdd.n1163 vdd.n1162 4.5005
R2602 vdd.n673 vdd.n672 4.5005
R2603 vdd.n678 vdd.n677 4.5005
R2604 vdd.n676 vdd.n675 4.5005
R2605 vdd.n1144 vdd.n1143 4.5005
R2606 vdd.n817 vdd.n816 4.5005
R2607 vdd.n1139 vdd.n1138 4.5005
R2608 vdd.n685 vdd.n684 4.5005
R2609 vdd.n690 vdd.n689 4.5005
R2610 vdd.n688 vdd.n687 4.5005
R2611 vdd.n1120 vdd.n1119 4.5005
R2612 vdd.n760 vdd.n759 4.5005
R2613 vdd.n1115 vdd.n1114 4.5005
R2614 vdd.n697 vdd.n696 4.5005
R2615 vdd.n702 vdd.n701 4.5005
R2616 vdd.n700 vdd.n699 4.5005
R2617 vdd.n1093 vdd.n1092 4.5005
R2618 vdd.n767 vdd.n766 4.5005
R2619 vdd.n1088 vdd.n1087 4.5005
R2620 vdd.n1083 vdd.n1082 4.5005
R2621 vdd.n709 vdd.n708 4.5005
R2622 vdd.n714 vdd.n713 4.5005
R2623 vdd.n712 vdd.n711 4.5005
R2624 vdd.n1067 vdd.n1066 4.5005
R2625 vdd.n775 vdd.n774 4.5005
R2626 vdd.n1062 vdd.n1061 4.5005
R2627 vdd.n1057 vdd.n1056 4.5005
R2628 vdd.n1051 vdd.n1050 4.5005
R2629 vdd.n1046 vdd.n1045 4.5005
R2630 vdd.n724 vdd.n723 4.5005
R2631 vdd.n730 vdd.n729 4.5005
R2632 vdd.n728 vdd.n727 4.5005
R2633 vdd.n1027 vdd.n1026 4.5005
R2634 vdd.n788 vdd.n787 4.5005
R2635 vdd.n1022 vdd.n1021 4.5005
R2636 vdd.n1020 vdd.n1019 4.5005
R2637 vdd.n779 vdd.n778 4.5005
R2638 vdd.n794 vdd.n793 4.5005
R2639 vdd.n801 vdd.n800 4.5005
R2640 vdd.n1193 vdd.n1192 4.5005
R2641 vdd.n943 vdd.t1579 4.41246
R2642 vdd.n1082 vdd.t1448 4.41246
R2643 vdd.t308 vdd.n1829 4.26276
R2644 vdd.n159 vdd.n79 0.00771186
R2645 vdd.n832 vdd.t573 1.4175
R2646 vdd.n832 vdd.t1290 1.06319
R2647 vdd.t572 vdd.n65 0.00283312
R2648 vdd.n128 vdd.n158 0.00268712
R2649 vdd.n157 vdd.n128 0.00271599
R2650 vdd.n129 vdd.n157 0.0027281
R2651 vdd.n156 vdd.n129 0.00273417
R2652 vdd.t898 vdd.n156 0.00161814
R2653 vdd.n43 vdd.n130 0.00976039
R2654 vdd.n832 vdd.t384 0.264518
R2655 vdd.n155 vdd.n154 0.0019995
R2656 vdd.n152 vdd.n112 0.00258323
R2657 vdd.n153 vdd.t897 0.00166649
R2658 vdd.n832 vdd.n153 1.4175
R2659 vdd.t1287 vdd.n97 0.00299966
R2660 vdd.n2116 vdd.t514 4.2505
R2661 vdd.n2126 vdd.n2125 4.22752
R2662 vdd.n617 vdd.t1331 4.22278
R2663 vdd.n565 vdd.t1353 4.2226
R2664 vdd.n563 vdd.t1351 4.2226
R2665 vdd.n560 vdd.t1347 4.2226
R2666 vdd.n587 vdd.t866 4.2226
R2667 vdd.n591 vdd.t1345 4.2226
R2668 vdd.n551 vdd.t1310 4.2226
R2669 vdd.n594 vdd.t1336 4.2226
R2670 vdd.n609 vdd.t1189 4.2226
R2671 vdd.n612 vdd.t1314 4.2226
R2672 vdd.n546 vdd.t1332 4.2226
R2673 vdd.n596 vdd.t1341 4.2226
R2674 vdd.n599 vdd.t1338 4.2226
R2675 vdd.n589 vdd.t864 4.2226
R2676 vdd.n548 vdd.t1190 4.2226
R2677 vdd.n1983 vdd.n1982 4.20177
R2678 vdd.n1977 vdd.n1975 4.20177
R2679 vdd.n1968 vdd.n1966 4.20177
R2680 vdd.n1959 vdd.n1957 4.20177
R2681 vdd.n1950 vdd.n1949 4.20177
R2682 vdd.n1944 vdd.n1942 4.20177
R2683 vdd.n416 vdd.n414 4.20177
R2684 vdd.n407 vdd.n405 4.20177
R2685 vdd.n398 vdd.n396 4.20177
R2686 vdd.n389 vdd.n387 4.20177
R2687 vdd.n380 vdd.n378 4.20177
R2688 vdd.n371 vdd.n369 4.20177
R2689 vdd.n362 vdd.n360 4.20177
R2690 vdd.n353 vdd.n351 4.20177
R2691 vdd.n344 vdd.n342 4.20177
R2692 vdd.n335 vdd.n333 4.20177
R2693 vdd.n326 vdd.n324 4.20177
R2694 vdd.n317 vdd.n316 4.20177
R2695 vdd.n1834 vdd.n1833 4.20177
R2696 vdd.n1851 vdd.n1848 4.20177
R2697 vdd.n1868 vdd.n1865 4.20177
R2698 vdd.n1885 vdd.n1882 4.20177
R2699 vdd.n1898 vdd.n1897 4.20177
R2700 vdd.n1915 vdd.n1912 4.20177
R2701 vdd.n1685 vdd.n1682 4.20177
R2702 vdd.n1668 vdd.n1665 4.20177
R2703 vdd.n1651 vdd.n1648 4.20177
R2704 vdd.n1634 vdd.n1631 4.20177
R2705 vdd.n1617 vdd.n1614 4.20177
R2706 vdd.n1600 vdd.n1597 4.20177
R2707 vdd.n1583 vdd.n1580 4.20177
R2708 vdd.n1566 vdd.n1563 4.20177
R2709 vdd.n1549 vdd.n1546 4.20177
R2710 vdd.n1532 vdd.n1529 4.20177
R2711 vdd.n1515 vdd.n1512 4.20177
R2712 vdd.n1498 vdd.n1497 4.20177
R2713 vdd.t10 vdd.n171 4.20159
R2714 vdd.n247 vdd.t25 4.1955
R2715 vdd.n246 vdd.t25 4.1955
R2716 vdd.n256 vdd.t25 4.1955
R2717 vdd.n262 vdd.t25 4.1955
R2718 vdd.n239 vdd.t25 4.1955
R2719 vdd.t507 vdd.n2002 4.17719
R2720 vdd.t515 vdd.n2148 4.17719
R2721 vdd.t515 vdd.n2130 4.17719
R2722 vdd.n1188 vdd.n70 0.442377
R2723 vdd.n650 vdd.n69 4.17484
R2724 vdd.n670 vdd.n69 4.17484
R2725 vdd.n695 vdd.n69 4.17484
R2726 vdd.n706 vdd.n69 4.17484
R2727 vdd.n1090 vdd.n69 4.17484
R2728 vdd.n707 vdd.n69 4.17484
R2729 vdd.n718 vdd.n69 4.17484
R2730 vdd.n1000 vdd.n832 4.17484
R2731 vdd.n833 vdd.n832 4.17484
R2732 vdd.n843 vdd.n832 4.17484
R2733 vdd.n976 vdd.n832 4.17484
R2734 vdd.n970 vdd.n832 4.17484
R2735 vdd.n862 vdd.n832 4.17484
R2736 vdd.n878 vdd.n832 4.17484
R2737 vdd.n876 vdd.n832 4.17484
R2738 vdd.n874 vdd.n832 4.17484
R2739 vdd.n671 vdd.n69 4.17472
R2740 vdd.n682 vdd.n69 4.17472
R2741 vdd.n1141 vdd.n69 4.17472
R2742 vdd.n683 vdd.n69 4.17472
R2743 vdd.n694 vdd.n69 4.17472
R2744 vdd.n1059 vdd.n69 4.17472
R2745 vdd.n719 vdd.n69 4.17472
R2746 vdd.n1048 vdd.n69 4.17472
R2747 vdd.n722 vdd.n69 4.17472
R2748 vdd.n734 vdd.n69 4.17472
R2749 vdd.n959 vdd.n832 4.17472
R2750 vdd.n847 vdd.n832 4.17472
R2751 vdd.n859 vdd.n832 4.17472
R2752 vdd.n933 vdd.n832 4.17472
R2753 vdd.n915 vdd.n832 4.17472
R2754 vdd.n907 vdd.n832 4.17472
R2755 vdd.n905 vdd.n832 4.17472
R2756 vdd.n903 vdd.n832 4.17472
R2757 vdd.n883 vdd.n832 4.17472
R2758 vdd.n1209 vdd.n1206 4.15497
R2759 vdd.n616 vdd.t1317 4.08446
R2760 vdd.n558 vdd.t1329 4.08446
R2761 vdd.n559 vdd.t1327 4.08428
R2762 vdd.n557 vdd.t967 4.08428
R2763 vdd.n586 vdd.t965 4.08428
R2764 vdd.n572 vdd.t961 4.08428
R2765 vdd.n602 vdd.t973 4.08428
R2766 vdd.n575 vdd.t975 4.08428
R2767 vdd.n608 vdd.t969 4.08428
R2768 vdd.n547 vdd.t968 4.08428
R2769 vdd.n29 vdd.t1316 4.08428
R2770 vdd.n573 vdd.t1322 4.08428
R2771 vdd.n555 vdd.t960 4.08428
R2772 vdd.n1211 vdd.n1204 4.01816
R2773 vdd.n1192 vdd.n1191 3.93774
R2774 vdd.n1207 vdd.t901 3.85623
R2775 vdd.n1205 vdd.t559 3.85623
R2776 vdd.n1207 vdd.t902 3.85532
R2777 vdd.n1205 vdd.t557 3.85532
R2778 vdd.n1227 vdd.t1042 3.79442
R2779 vdd.n1233 vdd.t1039 3.79253
R2780 vdd.n1495 vdd.n1494 3.56458
R2781 vdd.n2094 vdd.t757 3.56351
R2782 vdd.n1306 vdd.t1227 3.56127
R2783 vdd.n1223 vdd.t1049 3.40944
R2784 vdd.n1237 vdd.t1047 3.40944
R2785 vdd.t617 vdd.n37 3.50201
R2786 vdd.n2155 vdd.n2154 3.38694
R2787 vdd.n271 vdd.t25 3.33038
R2788 vdd.t25 vdd.n203 3.33038
R2789 vdd.n1936 vdd.n421 3.33038
R2790 vdd.n1936 vdd.n422 3.33038
R2791 vdd.n571 vdd.n24 3.33038
R2792 vdd.n582 vdd.n24 3.33038
R2793 vdd.n550 vdd.n24 3.33038
R2794 vdd.n606 vdd.n24 3.33038
R2795 vdd.n0 vdd.n2087 0.572838
R2796 vdd.t507 vdd.n2085 3.30723
R2797 vdd.t507 vdd.n1989 3.30723
R2798 vdd.n4 vdd.n2016 0.572838
R2799 vdd.t507 vdd.n1993 3.30723
R2800 vdd.n2064 vdd.t511 3.30723
R2801 vdd.n2070 vdd.t511 3.30723
R2802 vdd.t511 vdd.n2050 3.30723
R2803 vdd.t511 vdd.n2019 3.30723
R2804 vdd.t511 vdd.n2037 3.30723
R2805 vdd.n1165 vdd.n69 3.30418
R2806 vdd.n844 vdd.n832 3.30418
R2807 vdd.n895 vdd.n832 3.30408
R2808 vdd.n866 vdd.n832 3.304
R2809 vdd.n1117 vdd.n69 3.304
R2810 vdd.n1064 vdd.n69 3.304
R2811 vdd.n1024 vdd.n69 3.304
R2812 vdd.n832 vdd.n751 3.304
R2813 vdd.n1228 vdd.t1041 3.28126
R2814 vdd.n1234 vdd.t1040 3.28126
R2815 vdd.n867 vdd.n750 3.2656
R2816 vdd.n868 vdd.n867 3.2656
R2817 vdd.n869 vdd.n868 3.2656
R2818 vdd.n995 vdd.n994 3.2656
R2819 vdd.n994 vdd.n993 3.2656
R2820 vdd.n993 vdd.n992 3.2656
R2821 vdd.n985 vdd.n984 3.2656
R2822 vdd.n986 vdd.n985 3.2656
R2823 vdd.n987 vdd.n986 3.2656
R2824 vdd.n896 vdd.n846 3.2656
R2825 vdd.n897 vdd.n896 3.2656
R2826 vdd.n898 vdd.n897 3.2656
R2827 vdd.n954 vdd.n953 3.2656
R2828 vdd.n953 vdd.n952 3.2656
R2829 vdd.n952 vdd.n951 3.2656
R2830 vdd.n942 vdd.n941 3.2656
R2831 vdd.n946 vdd.n945 3.2656
R2832 vdd.n908 vdd.n857 3.2656
R2833 vdd.n909 vdd.n908 3.2656
R2834 vdd.n910 vdd.n909 3.2656
R2835 vdd.n1184 vdd.n1183 3.2656
R2836 vdd.n1183 vdd.n1182 3.2656
R2837 vdd.n1182 vdd.n1181 3.2656
R2838 vdd.n1174 vdd.n1173 3.2656
R2839 vdd.n1175 vdd.n1174 3.2656
R2840 vdd.n1176 vdd.n1175 3.2656
R2841 vdd.n823 vdd.n668 3.2656
R2842 vdd.n824 vdd.n823 3.2656
R2843 vdd.n825 vdd.n824 3.2656
R2844 vdd.n1160 vdd.n1159 3.2656
R2845 vdd.n1159 vdd.n1158 3.2656
R2846 vdd.n1158 vdd.n1157 3.2656
R2847 vdd.n1150 vdd.n1149 3.2656
R2848 vdd.n1151 vdd.n1150 3.2656
R2849 vdd.n1152 vdd.n1151 3.2656
R2850 vdd.n812 vdd.n680 3.2656
R2851 vdd.n813 vdd.n812 3.2656
R2852 vdd.n814 vdd.n813 3.2656
R2853 vdd.n1136 vdd.n1135 3.2656
R2854 vdd.n1135 vdd.n1134 3.2656
R2855 vdd.n1134 vdd.n1133 3.2656
R2856 vdd.n1126 vdd.n1125 3.2656
R2857 vdd.n1127 vdd.n1126 3.2656
R2858 vdd.n1128 vdd.n1127 3.2656
R2859 vdd.n755 vdd.n692 3.2656
R2860 vdd.n756 vdd.n755 3.2656
R2861 vdd.n757 vdd.n756 3.2656
R2862 vdd.n1112 vdd.n1111 3.2656
R2863 vdd.n1111 vdd.n1110 3.2656
R2864 vdd.n1110 vdd.n1109 3.2656
R2865 vdd.n762 vdd.n704 3.2656
R2866 vdd.n763 vdd.n762 3.2656
R2867 vdd.n764 vdd.n763 3.2656
R2868 vdd.n1085 vdd.n1084 3.2656
R2869 vdd.n1081 vdd.n1080 3.2656
R2870 vdd.n1073 vdd.n1072 3.2656
R2871 vdd.n1074 vdd.n1073 3.2656
R2872 vdd.n1075 vdd.n1074 3.2656
R2873 vdd.n770 vdd.n716 3.2656
R2874 vdd.n771 vdd.n770 3.2656
R2875 vdd.n772 vdd.n771 3.2656
R2876 vdd.n1043 vdd.n1042 3.2656
R2877 vdd.n1042 vdd.n1041 3.2656
R2878 vdd.n1041 vdd.n1040 3.2656
R2879 vdd.n1033 vdd.n1032 3.2656
R2880 vdd.n1034 vdd.n1033 3.2656
R2881 vdd.n1035 vdd.n1034 3.2656
R2882 vdd.n783 vdd.n732 3.2656
R2883 vdd.n784 vdd.n783 3.2656
R2884 vdd.n785 vdd.n784 3.2656
R2885 vdd.n1283 vdd.t820 2.89829
R2886 vdd.n1286 vdd.t826 2.89829
R2887 vdd.n1287 vdd.t828 2.89829
R2888 vdd.n1289 vdd.t832 2.89829
R2889 vdd.n1291 vdd.t836 2.89829
R2890 vdd.n1293 vdd.t840 2.89829
R2891 vdd.n1295 vdd.t844 2.89829
R2892 vdd.n1296 vdd.t846 2.89829
R2893 vdd.n1299 vdd.t852 2.89829
R2894 vdd.n1253 vdd.n1247 2.86052
R2895 vdd.n1221 vdd.n1217 2.86052
R2896 vdd.n69 vdd.n70 1.03839
R2897 vdd.n832 vdd.t1128 0.566779
R2898 vdd.n832 vdd.t570 0.944957
R2899 vdd.n52 vdd.n44 0.0171154
R2900 vdd.n832 vdd.n52 0.338414
R2901 vdd.n832 vdd.n155 1.21499
R2902 vdd.n2121 vdd.n2103 2.80967
R2903 vdd.n2125 vdd.n2103 2.80967
R2904 vdd.t507 vdd.n1997 2.76153
R2905 vdd.t511 vdd.n2026 2.76153
R2906 vdd.t511 vdd.n2054 2.72562
R2907 vdd.t515 vdd.n2134 2.72142
R2908 vdd.n1353 vdd.n115 1.30156
R2909 vdd.n67 vdd.n160 2.45166
R2910 vdd.n1982 vdd.t113 2.43007
R2911 vdd.n1975 vdd.t290 2.43007
R2912 vdd.n1966 vdd.t379 2.43007
R2913 vdd.n1957 vdd.t123 2.43007
R2914 vdd.n1949 vdd.t222 2.43007
R2915 vdd.n1942 vdd.t176 2.43007
R2916 vdd.n414 vdd.t138 2.43007
R2917 vdd.n405 vdd.t102 2.43007
R2918 vdd.n396 vdd.t184 2.43007
R2919 vdd.n387 vdd.t62 2.43007
R2920 vdd.n378 vdd.t110 2.43007
R2921 vdd.n369 vdd.t386 2.43007
R2922 vdd.n360 vdd.t105 2.43007
R2923 vdd.n351 vdd.t135 2.43007
R2924 vdd.n342 vdd.t74 2.43007
R2925 vdd.n333 vdd.t22 2.43007
R2926 vdd.n324 vdd.t3 2.43007
R2927 vdd.n316 vdd.t19 2.43007
R2928 vdd.n2154 vdd.t1245 2.42907
R2929 vdd.n1272 vdd.n1271 2.36003
R2930 vdd.n1304 vdd.n1303 2.35996
R2931 vdd.n1265 vdd.n1264 2.3598
R2932 vdd.n1268 vdd.n1267 2.35978
R2933 vdd.n1278 vdd.n1277 2.35978
R2934 vdd.n1275 vdd.n1274 2.35968
R2935 vdd.n249 vdd.t25 2.32527
R2936 vdd.n244 vdd.t25 2.32527
R2937 vdd.n258 vdd.t25 2.32527
R2938 vdd.n264 vdd.t25 2.32527
R2939 vdd.n237 vdd.t25 2.32527
R2940 vdd.t515 vdd.n2151 2.32126
R2941 vdd.n273 vdd.t25 2.31951
R2942 vdd.n1861 vdd.n1844 2.09861
R2943 vdd.n1986 vdd.n1980 2.09861
R2944 vdd.n1280 vdd.n1279 2.05393
R2945 vdd.n1270 vdd.n1266 2.05393
R2946 vdd.n1287 vdd.n1286 2.00428
R2947 vdd.n1296 vdd.n1295 2.00428
R2948 vdd.n1303 vdd.n1302 1.9428
R2949 vdd.n1276 vdd.n1275 1.9427
R2950 vdd.n1269 vdd.n1268 1.9426
R2951 vdd.n1279 vdd.n1278 1.9426
R2952 vdd.n1266 vdd.n1265 1.94253
R2953 vdd.n1273 vdd.n1272 1.9424
R2954 vdd.n241 vdd.t25 1.93058
R2955 vdd.t526 vdd.n67 0.469691
R2956 vdd.n2093 vdd.n2092 1.84096
R2957 vdd.n1283 vdd.n1282 1.82053
R2958 vdd.n1286 vdd.n1285 1.82053
R2959 vdd.n1289 vdd.n1288 1.82053
R2960 vdd.n1291 vdd.n1290 1.82053
R2961 vdd.n1293 vdd.n1292 1.82053
R2962 vdd.n1295 vdd.n1294 1.82053
R2963 vdd.n1299 vdd.n1298 1.82053
R2964 vdd.n1284 vdd.n1283 1.8205
R2965 vdd.n1288 vdd.n1287 1.8205
R2966 vdd.n1290 vdd.n1289 1.8205
R2967 vdd.n1292 vdd.n1291 1.8205
R2968 vdd.n1294 vdd.n1293 1.8205
R2969 vdd.n1297 vdd.n1296 1.8205
R2970 vdd.n1300 vdd.n1299 1.8205
R2971 vdd.t25 vdd.n201 1.76358
R2972 vdd.n1878 vdd.n1861 1.75124
R2973 vdd.n1895 vdd.n1878 1.75124
R2974 vdd.n1908 vdd.n1895 1.75124
R2975 vdd.n1695 vdd.n1678 1.75124
R2976 vdd.n1678 vdd.n1661 1.75124
R2977 vdd.n1661 vdd.n1644 1.75124
R2978 vdd.n1644 vdd.n1627 1.75124
R2979 vdd.n1627 vdd.n1610 1.75124
R2980 vdd.n1610 vdd.n1593 1.75124
R2981 vdd.n1593 vdd.n1576 1.75124
R2982 vdd.n1576 vdd.n1559 1.75124
R2983 vdd.n1559 vdd.n1542 1.75124
R2984 vdd.n1542 vdd.n1525 1.75124
R2985 vdd.n1525 vdd.n1508 1.75124
R2986 vdd.n1980 vdd.n1971 1.75124
R2987 vdd.n1971 vdd.n1962 1.75124
R2988 vdd.n1962 vdd.n1953 1.75124
R2989 vdd.n419 vdd.n410 1.75124
R2990 vdd.n410 vdd.n401 1.75124
R2991 vdd.n401 vdd.n392 1.75124
R2992 vdd.n392 vdd.n383 1.75124
R2993 vdd.n383 vdd.n374 1.75124
R2994 vdd.n374 vdd.n365 1.75124
R2995 vdd.n365 vdd.n356 1.75124
R2996 vdd.n356 vdd.n347 1.75124
R2997 vdd.n347 vdd.n338 1.75124
R2998 vdd.n338 vdd.n329 1.75124
R2999 vdd.n329 vdd.n320 1.75124
R3000 vdd.n2159 vdd.n2097 1.66119
R3001 vdd.n1281 vdd.n1280 1.63675
R3002 vdd.n1285 vdd.n1284 1.63675
R3003 vdd.n1298 vdd.n1297 1.63675
R3004 vdd.n1301 vdd.n1270 1.63675
R3005 vdd.n653 vdd.n649 1.63305
R3006 vdd.n654 vdd.n653 1.63305
R3007 vdd.n655 vdd.n654 1.63305
R3008 vdd.n656 vdd.n655 1.63305
R3009 vdd.n657 vdd.n656 1.63305
R3010 vdd.n660 vdd.n657 1.63305
R3011 vdd.n944 vdd.n942 1.63305
R3012 vdd.n945 vdd.n944 1.63305
R3013 vdd.n918 vdd.n917 1.63305
R3014 vdd.n919 vdd.n918 1.63305
R3015 vdd.n920 vdd.n919 1.63305
R3016 vdd.n921 vdd.n920 1.63305
R3017 vdd.n922 vdd.n921 1.63305
R3018 vdd.n923 vdd.n922 1.63305
R3019 vdd.n1009 vdd.n1008 1.63305
R3020 vdd.n1010 vdd.n1009 1.63305
R3021 vdd.n1011 vdd.n1010 1.63305
R3022 vdd.n1012 vdd.n1011 1.63305
R3023 vdd.n1013 vdd.n1012 1.63305
R3024 vdd.n1014 vdd.n1013 1.63305
R3025 vdd.n1099 vdd.n1098 1.63305
R3026 vdd.n1100 vdd.n1099 1.63305
R3027 vdd.n1101 vdd.n1100 1.63305
R3028 vdd.n1102 vdd.n1101 1.63305
R3029 vdd.n1103 vdd.n1102 1.63305
R3030 vdd.n1104 vdd.n1103 1.63305
R3031 vdd.n1084 vdd.n1083 1.63305
R3032 vdd.n1083 vdd.n1081 1.63305
R3033 vdd.n738 vdd.n737 1.63305
R3034 vdd.n739 vdd.n738 1.63305
R3035 vdd.n740 vdd.n739 1.63305
R3036 vdd.n741 vdd.n740 1.63305
R3037 vdd.n742 vdd.n741 1.63305
R3038 vdd.n743 vdd.n742 1.63305
R3039 vdd.n1197 vdd.t553 1.612
R3040 vdd.n1926 vdd.n1925 1.59145
R3041 vdd.n1947 vdd.n1938 1.59145
R3042 vdd.n584 vdd.n24 1.56193
R3043 vdd.n604 vdd.n24 1.56193
R3044 vdd.n864 vdd.n863 1.54196
R3045 vdd.n865 vdd.n864 1.49391
R3046 vdd.n1354 vdd.n115 1.49274
R3047 vdd.n932 vdd.n860 1.48919
R3048 vdd.t507 vdd.n1990 1.43917
R3049 vdd.n916 vdd.n860 1.42912
R3050 vdd.n275 vdd.t25 1.39512
R3051 vdd vdd.n1368 1.38119
R3052 vdd.n1932 vdd.n1930 1.371
R3053 vdd.n1272 vdd.t1231 1.35687
R3054 vdd.n1303 vdd.t1232 1.35682
R3055 vdd.n1265 vdd.t1234 1.35677
R3056 vdd.n1278 vdd.t1228 1.35671
R3057 vdd.n1268 vdd.t1233 1.35671
R3058 vdd.n1275 vdd.t1229 1.35662
R3059 vdd.n1199 vdd.t553 1.35541
R3060 vdd.n1200 vdd 1.352
R3061 vdd.t507 vdd.n2077 1.3491
R3062 vdd.n587 vdd.n586 1.33992
R3063 vdd.n609 vdd.n608 1.33992
R3064 vdd.n565 vdd.n558 1.33953
R3065 vdd.n617 vdd.n616 1.33915
R3066 vdd.n620 vdd.n24 1.3299
R3067 vdd.n567 vdd.n42 0.754853
R3068 vdd.t25 vdd.n233 1.25459
R3069 vdd.t863 vdd.n40 0.198016
R3070 vdd.n1833 vdd.t339 1.21579
R3071 vdd.n1848 vdd.t82 1.21579
R3072 vdd.n1865 vdd.t173 1.21579
R3073 vdd.n1882 vdd.t187 1.21579
R3074 vdd.n1897 vdd.t181 1.21579
R3075 vdd.n1912 vdd.t159 1.21579
R3076 vdd.n1682 vdd.t85 1.21579
R3077 vdd.n1665 vdd.t79 1.21579
R3078 vdd.n1648 vdd.t95 1.21579
R3079 vdd.n1631 vdd.t68 1.21579
R3080 vdd.n1614 vdd.t126 1.21579
R3081 vdd.n1597 vdd.t153 1.21579
R3082 vdd.n1580 vdd.t116 1.21579
R3083 vdd.n1563 vdd.t71 1.21579
R3084 vdd.n1546 vdd.t65 1.21579
R3085 vdd.n1529 vdd.t88 1.21579
R3086 vdd.n1512 vdd.t53 1.21579
R3087 vdd.n1497 vdd.t261 1.21579
R3088 vdd.n1929 vdd.t147 1.21479
R3089 vdd.n1936 vdd.t753 1.21479
R3090 vdd.n2103 vdd.t1125 1.21479
R3091 vdd.n1267 vdd.n1263 1.20577
R3092 vdd.n1277 vdd.n1261 1.20577
R3093 vdd.n1274 vdd.n1260 1.20577
R3094 vdd.n1271 vdd.n1259 1.20577
R3095 vdd.n1305 vdd.n1304 1.20577
R3096 vdd.n1264 vdd.n1262 1.20577
R3097 vdd.n1307 vdd.n1306 1.20542
R3098 vdd.n1196 vdd.n1195 1.14549
R3099 vdd.n1197 vdd.n1196 1.13954
R3100 vdd.t25 vdd.n212 1.1344
R3101 vdd.t25 vdd.n205 1.1344
R3102 vdd.n1925 vdd.n1908 1.12597
R3103 vdd.n1953 vdd.n1947 1.12597
R3104 vdd.n2094 vdd.t756 1.11813
R3105 vdd.n616 vdd.n615 1.10873
R3106 vdd.n569 vdd.n558 1.10873
R3107 vdd.n570 vdd.n557 1.10833
R3108 vdd.n586 vdd.n585 1.10833
R3109 vdd.n583 vdd.n572 1.10833
R3110 vdd.n603 vdd.n602 1.10833
R3111 vdd.n576 vdd.n575 1.10833
R3112 vdd.n608 vdd.n607 1.10833
R3113 vdd.n605 vdd.n547 1.10833
R3114 vdd.n581 vdd.n555 1.10833
R3115 vdd.n1926 vdd.n1695 1.04261
R3116 vdd.n1938 vdd.n419 1.04261
R3117 vdd.t25 vdd.n213 1.03034
R3118 vdd.t25 vdd.n210 1.03034
R3119 vdd.t25 vdd.n209 1.03034
R3120 vdd.n1935 vdd 1.026
R3121 vdd.n1214 vdd.n1213 1.01893
R3122 vdd.n1250 vdd.n1249 1.0128
R3123 vdd.n2066 vdd.n2065 1.01111
R3124 vdd.n2046 vdd.n2018 1.01053
R3125 vdd.n2033 vdd.n2021 1.01053
R3126 vdd.n2040 vdd.n2038 1.01053
R3127 vdd.n2072 vdd.n2071 1.01053
R3128 vdd.n2060 vdd.n2059 1.01053
R3129 vdd.n1210 vdd.n1205 1.00508
R3130 vdd.n1208 vdd.n1207 0.997283
R3131 vdd.n2112 vdd.n2111 0.995738
R3132 vdd.n2121 vdd.n2120 0.969928
R3133 vdd.t507 vdd.n0 0.695622
R3134 vdd.n2082 vdd.n3 0.96917
R3135 vdd.n4 vdd.t507 0.695622
R3136 vdd.n2 vdd.n2012 0.969111
R3137 vdd.n131 vdd.n1244 0.747723
R3138 vdd.n132 vdd.n1218 0.742791
R3139 vdd.n2111 vdd.n2110 0.922405
R3140 vdd.n2113 vdd.n2106 0.906729
R3141 vdd.n1189 vdd.n649 0.868362
R3142 vdd.n661 vdd.n660 0.868362
R3143 vdd.n1004 vdd.n750 0.868362
R3144 vdd.n870 vdd.n869 0.868362
R3145 vdd.n996 vdd.n995 0.868362
R3146 vdd.n992 vdd.n991 0.868362
R3147 vdd.n984 vdd.n983 0.868362
R3148 vdd.n988 vdd.n987 0.868362
R3149 vdd.n972 vdd.n971 0.868362
R3150 vdd.n963 vdd.n846 0.868362
R3151 vdd.n899 vdd.n898 0.868362
R3152 vdd.n955 vdd.n954 0.868362
R3153 vdd.n951 vdd.n950 0.868362
R3154 vdd.n941 vdd.n940 0.868362
R3155 vdd.n947 vdd.n946 0.868362
R3156 vdd.n937 vdd.n857 0.868362
R3157 vdd.n911 vdd.n910 0.868362
R3158 vdd.n917 vdd.n861 0.868362
R3159 vdd.n927 vdd.n923 0.868362
R3160 vdd.n1008 vdd.n1007 0.868362
R3161 vdd.n1015 vdd.n1014 0.868362
R3162 vdd.n888 vdd.n887 0.868362
R3163 vdd.n1185 vdd.n1184 0.868362
R3164 vdd.n1181 vdd.n1180 0.868362
R3165 vdd.n1173 vdd.n1172 0.868362
R3166 vdd.n1177 vdd.n1176 0.868362
R3167 vdd.n1169 vdd.n668 0.868362
R3168 vdd.n826 vdd.n825 0.868362
R3169 vdd.n1161 vdd.n1160 0.868362
R3170 vdd.n1157 vdd.n1156 0.868362
R3171 vdd.n1149 vdd.n1148 0.868362
R3172 vdd.n1153 vdd.n1152 0.868362
R3173 vdd.n1145 vdd.n680 0.868362
R3174 vdd.n815 vdd.n814 0.868362
R3175 vdd.n1137 vdd.n1136 0.868362
R3176 vdd.n1133 vdd.n1132 0.868362
R3177 vdd.n1125 vdd.n1124 0.868362
R3178 vdd.n1129 vdd.n1128 0.868362
R3179 vdd.n1121 vdd.n692 0.868362
R3180 vdd.n758 vdd.n757 0.868362
R3181 vdd.n1113 vdd.n1112 0.868362
R3182 vdd.n1109 vdd.n1108 0.868362
R3183 vdd.n1098 vdd.n1097 0.868362
R3184 vdd.n1105 vdd.n1104 0.868362
R3185 vdd.n1094 vdd.n704 0.868362
R3186 vdd.n765 vdd.n764 0.868362
R3187 vdd.n1086 vdd.n1085 0.868362
R3188 vdd.n1080 vdd.n1079 0.868362
R3189 vdd.n1072 vdd.n1071 0.868362
R3190 vdd.n1076 vdd.n1075 0.868362
R3191 vdd.n1068 vdd.n716 0.868362
R3192 vdd.n773 vdd.n772 0.868362
R3193 vdd.n1055 vdd.n720 0.868362
R3194 vdd.n1044 vdd.n1043 0.868362
R3195 vdd.n1040 vdd.n1039 0.868362
R3196 vdd.n1032 vdd.n1031 0.868362
R3197 vdd.n1036 vdd.n1035 0.868362
R3198 vdd.n1028 vdd.n732 0.868362
R3199 vdd.n786 vdd.n785 0.868362
R3200 vdd.n737 vdd.n735 0.868362
R3201 vdd.n1018 vdd.n743 0.868362
R3202 vdd.n796 vdd.n795 0.868362
R3203 vdd.n1198 vdd.n1195 0.861078
R3204 vdd.n536 vdd.n535 0.8585
R3205 vdd.n541 vdd.n540 0.8585
R3206 vdd.n562 vdd.n559 0.857396
R3207 vdd.n561 vdd.n557 0.857396
R3208 vdd.n572 vdd.n554 0.857396
R3209 vdd.n602 vdd.n601 0.857396
R3210 vdd.n575 vdd.n553 0.857396
R3211 vdd.n613 vdd.n547 0.857396
R3212 vdd.n29 vdd.n614 0.857396
R3213 vdd.n573 vdd.n552 0.857396
R3214 vdd.n600 vdd.n555 0.857396
R3215 vdd.n1198 vdd.n1197 0.856993
R3216 vdd.n2118 vdd.n2117 0.853399
R3217 vdd.n2114 vdd.n2113 0.843833
R3218 vdd.n2 vdd.n2011 0.825836
R3219 vdd.t507 vdd.n1 0.698601
R3220 vdd.n2080 vdd.n3 0.825631
R3221 vdd.n5 vdd.t507 0.698601
R3222 vdd.n1006 vdd.n731 0.816819
R3223 vdd.n1017 vdd.n1016 0.816819
R3224 vdd.n559 vdd.n21 0.785208
R3225 vdd.n30 vdd.n29 0.785208
R3226 vdd.n574 vdd.n573 0.785208
R3227 vdd.n1243 vdd.n1204 0.771259
R3228 vdd.n1222 vdd.n1211 0.771259
R3229 vdd.n1004 vdd.n1003 0.76519
R3230 vdd.n872 vdd.n870 0.76519
R3231 vdd.n998 vdd.n996 0.76519
R3232 vdd.n991 vdd.n835 0.76519
R3233 vdd.n983 vdd.n840 0.76519
R3234 vdd.n988 vdd.n838 0.76519
R3235 vdd.n980 vdd.n979 0.76519
R3236 vdd.n974 vdd.n972 0.76519
R3237 vdd.n968 vdd.n966 0.76519
R3238 vdd.n963 vdd.n962 0.76519
R3239 vdd.n901 vdd.n899 0.76519
R3240 vdd.n957 vdd.n955 0.76519
R3241 vdd.n950 vdd.n849 0.76519
R3242 vdd.n940 vdd.n855 0.76519
R3243 vdd.n947 vdd.n853 0.76519
R3244 vdd.n937 vdd.n936 0.76519
R3245 vdd.n913 vdd.n911 0.76519
R3246 vdd.n931 vdd.n861 0.76519
R3247 vdd.n928 vdd.n927 0.76519
R3248 vdd.n1007 vdd.n748 0.76519
R3249 vdd.n1015 vdd.n745 0.76519
R3250 vdd.n893 vdd.n891 0.76519
R3251 vdd.n888 vdd.n886 0.76519
R3252 vdd.n881 vdd.n879 0.76519
R3253 vdd.n1187 vdd.n1185 0.76519
R3254 vdd.n1180 vdd.n652 0.76519
R3255 vdd.n1172 vdd.n666 0.76519
R3256 vdd.n1177 vdd.n664 0.76519
R3257 vdd.n1169 vdd.n1168 0.76519
R3258 vdd.n828 vdd.n826 0.76519
R3259 vdd.n1163 vdd.n1161 0.76519
R3260 vdd.n1156 vdd.n673 0.76519
R3261 vdd.n1148 vdd.n678 0.76519
R3262 vdd.n1153 vdd.n676 0.76519
R3263 vdd.n1145 vdd.n1144 0.76519
R3264 vdd.n817 vdd.n815 0.76519
R3265 vdd.n1139 vdd.n1137 0.76519
R3266 vdd.n1132 vdd.n685 0.76519
R3267 vdd.n1124 vdd.n690 0.76519
R3268 vdd.n1129 vdd.n688 0.76519
R3269 vdd.n1121 vdd.n1120 0.76519
R3270 vdd.n760 vdd.n758 0.76519
R3271 vdd.n1115 vdd.n1113 0.76519
R3272 vdd.n1108 vdd.n697 0.76519
R3273 vdd.n1097 vdd.n702 0.76519
R3274 vdd.n1105 vdd.n699 0.76519
R3275 vdd.n1094 vdd.n1093 0.76519
R3276 vdd.n767 vdd.n765 0.76519
R3277 vdd.n1088 vdd.n1086 0.76519
R3278 vdd.n1079 vdd.n709 0.76519
R3279 vdd.n1071 vdd.n714 0.76519
R3280 vdd.n1076 vdd.n712 0.76519
R3281 vdd.n1068 vdd.n1067 0.76519
R3282 vdd.n775 vdd.n773 0.76519
R3283 vdd.n1062 vdd.n1060 0.76519
R3284 vdd.n1057 vdd.n1055 0.76519
R3285 vdd.n1052 vdd.n1051 0.76519
R3286 vdd.n1046 vdd.n1044 0.76519
R3287 vdd.n1039 vdd.n724 0.76519
R3288 vdd.n1031 vdd.n730 0.76519
R3289 vdd.n1036 vdd.n728 0.76519
R3290 vdd.n1028 vdd.n1027 0.76519
R3291 vdd.n788 vdd.n786 0.76519
R3292 vdd.n1022 vdd.n735 0.76519
R3293 vdd.n1019 vdd.n1018 0.76519
R3294 vdd.n779 vdd.n777 0.76519
R3295 vdd.n796 vdd.n794 0.76519
R3296 vdd.n801 vdd.n799 0.76519
R3297 vdd.n2044 vdd.n2018 0.740776
R3298 vdd.n2031 vdd.n2021 0.740776
R3299 vdd.n2040 vdd.n2039 0.740776
R3300 vdd.n2073 vdd.n2072 0.740776
R3301 vdd.n2061 vdd.n2060 0.740776
R3302 vdd.n2067 vdd.n2066 0.740235
R3303 vdd.n2119 vdd.n2118 0.728595
R3304 vdd.n1209 vdd.n1208 0.726895
R3305 vdd.n1210 vdd.n1209 0.726495
R3306 vdd.n46 vdd.t1290 0.599961
R3307 vdd.n621 vdd.n620 0.672497
R3308 vdd.n296 vdd.n286 0.668854
R3309 vdd.n303 vdd.n302 0.668854
R3310 vdd.n42 vdd.n566 5.35528
R3311 vdd.n620 vdd.n619 0.658872
R3312 vdd.n1356 vdd.n1355 0.655
R3313 vdd.n1360 vdd.n1359 0.655
R3314 vdd.n1364 vdd.n1363 0.655
R3315 vdd.n1324 vdd.n1323 0.655
R3316 vdd.n1326 vdd.n1325 0.655
R3317 vdd.n1327 vdd.n1326 0.655
R3318 vdd.n1331 vdd.n1330 0.655
R3319 vdd.n1332 vdd.n1331 0.655
R3320 vdd.n1334 vdd.n1333 0.655
R3321 vdd.n1344 vdd.n1343 0.655
R3322 vdd.n1348 vdd.n1347 0.655
R3323 vdd.n1352 vdd.n1351 0.655
R3324 vdd.n2096 vdd.n1987 0.636614
R3325 vdd.n2077 vdd.n2075 0.627021
R3326 vdd.n127 vdd.n1198 0.624178
R3327 vdd.n1224 vdd.n1223 0.623153
R3328 vdd.n1229 vdd.n1228 0.623153
R3329 vdd.n1235 vdd.n1234 0.623153
R3330 vdd.n1238 vdd.n1237 0.623153
R3331 vdd.n1322 vdd.n1321 0.61375
R3332 vdd.n1336 vdd.n1335 0.61375
R3333 vdd.n302 vdd.n286 0.613158
R3334 vdd.n220 vdd.n209 0.601868
R3335 vdd.n1366 vdd.n1255 0.598625
R3336 vdd.n1341 vdd.n1340 0.598625
R3337 vdd.n226 vdd.n213 0.593003
R3338 vdd.n222 vdd.n210 0.591868
R3339 vdd vdd.n2159 0.588843
R3340 vdd.n296 vdd.n295 0.58531
R3341 vdd.n2077 vdd.n2076 0.582557
R3342 vdd.n2096 vdd.n2095 0.5813
R3343 vdd.n207 vdd.n205 0.578558
R3344 vdd.n229 vdd.n213 0.571868
R3345 vdd.n219 vdd.n210 0.565503
R3346 vdd.n217 vdd.n209 0.563003
R3347 vdd.n303 vdd.n285 0.557462
R3348 vdd.n285 vdd.n284 0.557462
R3349 vdd.n307 vdd.n306 0.557462
R3350 vdd.n307 vdd.n198 0.557462
R3351 vdd.n310 vdd.n195 0.557462
R3352 vdd.n311 vdd.n310 0.557462
R3353 vdd.n924 vdd.n856 0.555854
R3354 vdd.n926 vdd.n925 0.555854
R3355 vdd.n1357 vdd.n1356 0.5505
R3356 vdd.n1351 vdd.n1350 0.5505
R3357 vdd.n226 vdd.n212 0.546058
R3358 vdd.n611 vdd.n610 0.534569
R3359 vdd.n610 vdd.n549 0.534569
R3360 vdd.n593 vdd.n549 0.534569
R3361 vdd.n595 vdd.n593 0.534569
R3362 vdd.n598 vdd.n592 0.534569
R3363 vdd.n592 vdd.n590 0.534569
R3364 vdd.n590 vdd.n588 0.534569
R3365 vdd.n588 vdd.n556 0.534569
R3366 vdd.n212 vdd.n211 0.534094
R3367 vdd.n214 vdd.n205 0.516594
R3368 vdd.n1249 vdd.t900 0.515337
R3369 vdd.n1213 vdd.t678 0.512873
R3370 vdd.n1363 vdd.n1362 0.512
R3371 vdd.n1345 vdd.n1344 0.512
R3372 vdd.n233 vdd.n231 0.51152
R3373 vdd.n2075 vdd.n1990 0.502048
R3374 vdd.t507 vdd.n2 0.499357
R3375 vdd.n233 vdd.n232 0.489071
R3376 vdd.n276 vdd.n275 0.487826
R3377 vdd.n563 vdd.n562 0.483028
R3378 vdd.n561 vdd.n560 0.483028
R3379 vdd.n591 vdd.n554 0.483028
R3380 vdd.n601 vdd.n551 0.483028
R3381 vdd.n594 vdd.n553 0.483028
R3382 vdd.n613 vdd.n612 0.483028
R3383 vdd.n614 vdd.n546 0.483028
R3384 vdd.n596 vdd.n552 0.483028
R3385 vdd.n600 vdd.n599 0.483028
R3386 vdd.n1359 vdd.n1258 0.465808
R3387 vdd.n1348 vdd.n1307 0.465808
R3388 vdd.n1346 vdd.n1308 0.465808
R3389 vdd.n1339 vdd.n1310 0.465808
R3390 vdd.n1336 vdd.n1311 0.465808
R3391 vdd.n1332 vdd.n1313 0.465808
R3392 vdd.n1328 vdd.n1327 0.465808
R3393 vdd.n1324 vdd.n1315 0.465808
R3394 vdd.n1351 vdd.n1263 0.465462
R3395 vdd.n1355 vdd.n1261 0.465462
R3396 vdd.n1356 vdd.n1260 0.465462
R3397 vdd.n1358 vdd.n1259 0.465462
R3398 vdd.n1349 vdd.n1305 0.465462
R3399 vdd.n1352 vdd.n1262 0.465462
R3400 vdd.n1343 vdd.n1309 0.465462
R3401 vdd.n1333 vdd.n1312 0.465462
R3402 vdd.n1330 vdd.n1329 0.465462
R3403 vdd.n1325 vdd.n1314 0.465462
R3404 vdd.n1321 vdd.n1316 0.465462
R3405 vdd.n1318 vdd.n1317 0.465462
R3406 vdd.n1364 vdd.n1256 0.465462
R3407 vdd.n1361 vdd.n1257 0.465462
R3408 vdd.n2120 vdd.n2119 0.461452
R3409 vdd.n2110 vdd.n2109 0.461452
R3410 vdd.n607 vdd.n604 0.448066
R3411 vdd.n1209 vdd.t556 0.447868
R3412 vdd.n311 vdd.n194 0.44607
R3413 vdd.n585 vdd.n584 0.444247
R3414 vdd.n1319 vdd.n1318 0.43775
R3415 vdd.n1339 vdd.n1338 0.43775
R3416 vdd.n215 vdd.n193 0.431474
R3417 vdd.n275 vdd.n274 0.430949
R3418 vdd.n2151 vdd.n2149 0.426679
R3419 vdd.n624 vdd.n538 0.423507
R3420 vdd.n2066 vdd.t511 0.421514
R3421 vdd.n2060 vdd.t511 0.421271
R3422 vdd.n2072 vdd.t511 0.421271
R3423 vdd.t511 vdd.n2040 0.421271
R3424 vdd.t511 vdd.n2021 0.421271
R3425 vdd.t511 vdd.n2018 0.421271
R3426 vdd.n1270 vdd.n1269 0.417683
R3427 vdd.n1280 vdd.n1276 0.417683
R3428 vdd.n1281 vdd.n1273 0.417683
R3429 vdd.n1302 vdd.n1301 0.417337
R3430 vdd.n254 vdd.n235 0.414175
R3431 vdd.n2092 vdd 0.409071
R3432 vdd.n584 vdd.n583 0.408066
R3433 vdd.n1991 vdd.n1990 0.405837
R3434 vdd.n604 vdd.n603 0.404247
R3435 vdd.n1194 vdd.n1190 0.40413
R3436 vdd.n1190 vdd.n648 0.40413
R3437 vdd.n1171 vdd.n648 0.40413
R3438 vdd.n1171 vdd.n1170 0.40413
R3439 vdd.n1170 vdd.n667 0.40413
R3440 vdd.n1147 vdd.n667 0.40413
R3441 vdd.n1147 vdd.n1146 0.40413
R3442 vdd.n1146 vdd.n679 0.40413
R3443 vdd.n1123 vdd.n679 0.40413
R3444 vdd.n1123 vdd.n1122 0.40413
R3445 vdd.n1122 vdd.n691 0.40413
R3446 vdd.n1096 vdd.n691 0.40413
R3447 vdd.n1096 vdd.n1095 0.40413
R3448 vdd.n1095 vdd.n703 0.40413
R3449 vdd.n1070 vdd.n703 0.40413
R3450 vdd.n1070 vdd.n1069 0.40413
R3451 vdd.n1069 vdd.n715 0.40413
R3452 vdd.n1054 vdd.n715 0.40413
R3453 vdd.n1054 vdd.n1053 0.40413
R3454 vdd.n1053 vdd.n721 0.40413
R3455 vdd.n1030 vdd.n721 0.40413
R3456 vdd.n1030 vdd.n1029 0.40413
R3457 vdd.n1029 vdd.n731 0.40413
R3458 vdd.n1006 vdd.n1005 0.40413
R3459 vdd.n1005 vdd.n749 0.40413
R3460 vdd.n982 vdd.n749 0.40413
R3461 vdd.n982 vdd.n981 0.40413
R3462 vdd.n981 vdd.n841 0.40413
R3463 vdd.n965 vdd.n841 0.40413
R3464 vdd.n965 vdd.n964 0.40413
R3465 vdd.n964 vdd.n845 0.40413
R3466 vdd.n939 vdd.n845 0.40413
R3467 vdd.n939 vdd.n938 0.40413
R3468 vdd.n938 vdd.n856 0.40413
R3469 vdd.n926 vdd.n851 0.40413
R3470 vdd.n948 vdd.n851 0.40413
R3471 vdd.n949 vdd.n948 0.40413
R3472 vdd.n949 vdd.n850 0.40413
R3473 vdd.n890 vdd.n850 0.40413
R3474 vdd.n890 vdd.n889 0.40413
R3475 vdd.n889 vdd.n836 0.40413
R3476 vdd.n989 vdd.n836 0.40413
R3477 vdd.n990 vdd.n989 0.40413
R3478 vdd.n990 vdd.n744 0.40413
R3479 vdd.n1016 vdd.n744 0.40413
R3480 vdd.n1017 vdd.n726 0.40413
R3481 vdd.n1037 vdd.n726 0.40413
R3482 vdd.n1038 vdd.n1037 0.40413
R3483 vdd.n1038 vdd.n725 0.40413
R3484 vdd.n797 vdd.n725 0.40413
R3485 vdd.n798 vdd.n797 0.40413
R3486 vdd.n798 vdd.n710 0.40413
R3487 vdd.n1077 vdd.n710 0.40413
R3488 vdd.n1078 vdd.n1077 0.40413
R3489 vdd.n1078 vdd.n698 0.40413
R3490 vdd.n1106 vdd.n698 0.40413
R3491 vdd.n1107 vdd.n1106 0.40413
R3492 vdd.n1107 vdd.n686 0.40413
R3493 vdd.n1130 vdd.n686 0.40413
R3494 vdd.n1131 vdd.n1130 0.40413
R3495 vdd.n1131 vdd.n674 0.40413
R3496 vdd.n1154 vdd.n674 0.40413
R3497 vdd.n1155 vdd.n1154 0.40413
R3498 vdd.n1155 vdd.n662 0.40413
R3499 vdd.n1178 vdd.n662 0.40413
R3500 vdd.n1179 vdd.n1178 0.40413
R3501 vdd.n254 vdd.n253 0.395372
R3502 vdd.n268 vdd.n235 0.395372
R3503 vdd.n2151 vdd.n2150 0.385525
R3504 vdd.n273 vdd.n272 0.382638
R3505 vdd.n623 vdd.n622 0.381636
R3506 vdd.n1282 vdd.n1281 0.378625
R3507 vdd.n1301 vdd.n1300 0.378625
R3508 vdd.n269 vdd.n268 0.376568
R3509 vdd.n269 vdd.n200 0.376568
R3510 vdd.n279 vdd.n200 0.376568
R3511 vdd.n228 vdd.n199 0.376568
R3512 vdd.n228 vdd.n227 0.376568
R3513 vdd.n223 vdd.n221 0.376568
R3514 vdd.n221 vdd.n218 0.376568
R3515 vdd.n202 vdd.n201 0.3698
R3516 vdd.n274 vdd.n273 0.367968
R3517 vdd.n224 vdd.n198 0.362525
R3518 vdd.n278 vdd.n201 0.361528
R3519 vdd.n77 vdd.n308 0.623366
R3520 vdd.n2054 vdd.n1988 0.344892
R3521 vdd.n249 vdd.n248 0.341207
R3522 vdd.n245 vdd.n244 0.341207
R3523 vdd.n258 vdd.n257 0.341207
R3524 vdd.n264 vdd.n263 0.341207
R3525 vdd.n238 vdd.n237 0.341207
R3526 vdd.n1355 vdd.n1354 0.33875
R3527 vdd.n1353 vdd.n1352 0.33875
R3528 vdd.n2085 vdd.n2082 0.336433
R3529 vdd.n2076 vdd.n1989 0.336433
R3530 vdd.n2012 vdd.n1993 0.336433
R3531 vdd.n2065 vdd.n2064 0.336433
R3532 vdd.n2071 vdd.n2070 0.336433
R3533 vdd.n2050 vdd.n2046 0.336433
R3534 vdd.n2038 vdd.n2019 0.336433
R3535 vdd.n2037 vdd.n2033 0.336433
R3536 vdd.n306 vdd.n281 0.334677
R3537 vdd.n2085 vdd.n2084 0.331445
R3538 vdd.n2079 vdd.n1989 0.331445
R3539 vdd.n2014 vdd.n1993 0.331445
R3540 vdd.n2064 vdd.n2063 0.331445
R3541 vdd.n2070 vdd.n2069 0.331445
R3542 vdd.n2050 vdd.n2049 0.331445
R3543 vdd.n2043 vdd.n2019 0.331445
R3544 vdd.n2037 vdd.n2036 0.331445
R3545 vdd.n2134 vdd.n2133 0.327361
R3546 vdd.n250 vdd.n249 0.323769
R3547 vdd.n244 vdd.n243 0.323769
R3548 vdd.n259 vdd.n258 0.323769
R3549 vdd.n265 vdd.n264 0.323769
R3550 vdd.n237 vdd.n236 0.323769
R3551 vdd.n2134 vdd.n2131 0.320342
R3552 vdd.n2120 vdd.n2104 0.31675
R3553 vdd.n2109 vdd.n2108 0.31675
R3554 vdd.n2111 vdd.n2107 0.31675
R3555 vdd.n127 vdd.n1196 0.316278
R3556 vdd.n1065 vdd.n718 0.305828
R3557 vdd.n1025 vdd.n734 0.305699
R3558 vdd.n1118 vdd.n694 0.305699
R3559 vdd.n960 vdd.n959 0.305699
R3560 vdd.n903 vdd.n902 0.305699
R3561 vdd.n1166 vdd.n670 0.305566
R3562 vdd.n874 vdd.n873 0.305566
R3563 vdd.n1001 vdd.n1000 0.305566
R3564 vdd.n1998 vdd.n1997 0.302143
R3565 vdd.n2026 vdd.n2025 0.302143
R3566 vdd.n218 vdd.n216 0.301355
R3567 vdd.n105 vdd.n166 0.924212
R3568 vdd.n832 vdd.t1173 0.299246
R3569 vdd.n894 vdd.n862 0.292078
R3570 vdd.n970 vdd.n969 0.292078
R3571 vdd.n1164 vdd.n671 0.291949
R3572 vdd.n1063 vdd.n1059 0.291949
R3573 vdd.n1116 vdd.n695 0.291816
R3574 vdd.n1023 vdd.n111 0.945058
R3575 vdd.n717 vdd.n707 0.285203
R3576 vdd.n733 vdd.n722 0.285074
R3577 vdd.n693 vdd.n683 0.285074
R3578 vdd.n958 vdd.n847 0.285074
R3579 vdd.n905 vdd.n904 0.285074
R3580 vdd.n669 vdd.n650 0.284941
R3581 vdd.n876 vdd.n875 0.284941
R3582 vdd.n999 vdd.n833 0.284941
R3583 vdd.n2131 vdd.n2130 0.275761
R3584 vdd.n2054 vdd.n2053 0.273685
R3585 vdd.n2114 vdd.n2112 0.272881
R3586 vdd.n116 vdd.n115 0.00129565
R3587 vdd.n682 vdd.n681 0.271324
R3588 vdd.n1058 vdd.n719 0.271324
R3589 vdd.n916 vdd.n915 0.271324
R3590 vdd.n884 vdd.n883 0.271324
R3591 vdd.n933 vdd.n932 0.271324
R3592 vdd.n706 vdd.n705 0.271191
R3593 vdd.n976 vdd.n975 0.271191
R3594 vdd.n2156 vdd.n2155 0.267886
R3595 vdd.n618 vdd.n544 0.267534
R3596 vdd.n611 vdd.n544 0.267534
R3597 vdd.n597 vdd.n595 0.267534
R3598 vdd.n598 vdd.n597 0.267534
R3599 vdd.n564 vdd.n556 0.267534
R3600 vdd.n566 vdd.n564 0.267534
R3601 vdd.n1090 vdd.n1089 0.264578
R3602 vdd.n843 vdd.n842 0.264578
R3603 vdd.n1048 vdd.n1047 0.264449
R3604 vdd.n1141 vdd.n1140 0.264449
R3605 vdd.n907 vdd.n906 0.264449
R3606 vdd.n859 vdd.n858 0.264449
R3607 vdd.n878 vdd.n877 0.264316
R3608 vdd.n1207 vdd.n1206 0.263465
R3609 vdd.n1165 vdd.n1164 0.263043
R3610 vdd.n1024 vdd.n1023 0.262733
R3611 vdd.n1117 vdd.n1116 0.262733
R3612 vdd.n1064 vdd.n1063 0.262723
R3613 vdd.n866 vdd.n865 0.262723
R3614 vdd.n863 vdd.n751 0.262723
R3615 vdd.n1206 vdd.n1205 0.262691
R3616 vdd.n895 vdd.n894 0.262528
R3617 vdd.n969 vdd.n844 0.26242
R3618 vdd.n271 vdd.n270 0.259515
R3619 vdd.n1199 vdd.n1195 0.256088
R3620 vdd.n603 vdd.n550 0.255744
R3621 vdd.n583 vdd.n582 0.254515
R3622 vdd.n203 vdd.n202 0.252015
R3623 vdd.n882 vdd.n878 0.250828
R3624 vdd.n1049 vdd.n1048 0.250699
R3625 vdd.n1142 vdd.n1141 0.250699
R3626 vdd.n914 vdd.n907 0.250699
R3627 vdd.n934 vdd.n859 0.250699
R3628 vdd.n1091 vdd.n1090 0.250566
R3629 vdd.n1189 vdd.n70 5.55694
R3630 vdd.n977 vdd.n843 0.250566
R3631 vdd.n960 vdd.n844 0.249293
R3632 vdd.n902 vdd.n895 0.249193
R3633 vdd.n873 vdd.n866 0.248983
R3634 vdd.n1065 vdd.n1064 0.248983
R3635 vdd.n1001 vdd.n751 0.248983
R3636 vdd.n1025 vdd.n1024 0.248973
R3637 vdd.n1118 vdd.n1117 0.248973
R3638 vdd.n1166 vdd.n1165 0.24867
R3639 vdd.n59 vdd.n736 0.202574
R3640 vdd.n149 vdd.n804 0.285074
R3641 vdd.n51 vdd.n807 0.263043
R3642 vdd.n811 vdd.n810 0.248551
R3643 vdd.n821 vdd.n820 0.248551
R3644 vdd.n46 vdd.n56 2.42608
R3645 vdd.n232 vdd.n203 0.248244
R3646 vdd.n139 vdd.n780 0.243441
R3647 vdd.n140 vdd.n776 0.305316
R3648 vdd.n227 vdd.n225 0.244944
R3649 vdd.n1091 vdd.n706 0.243953
R3650 vdd.n977 vdd.n976 0.243953
R3651 vdd.n1049 vdd.n719 0.243824
R3652 vdd.n1142 vdd.n682 0.243824
R3653 vdd.n915 vdd.n914 0.243824
R3654 vdd.n883 vdd.n882 0.243824
R3655 vdd.n934 vdd.n933 0.243824
R3656 vdd.n33 vdd.n292 0.234894
R3657 vdd.n300 vdd.n107 0.360888
R3658 vdd.n301 vdd.n25 0.685158
R3659 vdd.n25 vdd.n304 0.688441
R3660 vdd.n35 vdd.n2090 0.247394
R3661 vdd.n100 vdd.n72 1.70541
R3662 vdd.n72 vdd.n105 2.04711
R3663 vdd.n166 vdd.n165 0.241078
R3664 vdd.n165 vdd.n164 0.241078
R3665 vdd.n164 vdd.n163 0.241078
R3666 vdd.n163 vdd.n83 0.963561
R3667 vdd.n83 vdd.n110 1.08592
R3668 vdd.n94 vdd.n300 0.235023
R3669 vdd.n2148 vdd.n2147 0.24028
R3670 vdd.n2148 vdd.n2099 0.237011
R3671 vdd.n24 vdd.n40 0.00180586
R3672 vdd.n2002 vdd.n2000 0.23528
R3673 vdd.n272 vdd.n271 0.230744
R3674 vdd.n422 vdd.n420 0.230744
R3675 vdd.n877 vdd.n876 0.230203
R3676 vdd.n1188 vdd.n650 0.230203
R3677 vdd.n842 vdd.n833 0.230203
R3678 vdd.n1047 vdd.n722 0.230074
R3679 vdd.n1140 vdd.n683 0.230074
R3680 vdd.n906 vdd.n905 0.230074
R3681 vdd.n858 vdd.n847 0.230074
R3682 vdd.n1089 vdd.n707 0.229941
R3683 vdd.n1934 vdd.n421 0.229515
R3684 vdd.n831 vdd.n736 0.228267
R3685 vdd.n2002 vdd.n2001 0.227011
R3686 vdd.n242 vdd.n241 0.226787
R3687 vdd.n280 vdd.n199 0.226141
R3688 vdd.n606 vdd.n605 0.225744
R3689 vdd.n571 vdd.n570 0.224515
R3690 vdd.n705 vdd.n695 0.223328
R3691 vdd.n284 vdd.n281 0.223285
R3692 vdd.n1059 vdd.n1058 0.223199
R3693 vdd.n681 vdd.n671 0.223199
R3694 vdd.n884 vdd.n862 0.223066
R3695 vdd.n975 vdd.n970 0.223066
R3696 vdd.n1715 vdd.n1714 0.222075
R3697 vdd.n1810 vdd.n1809 0.221736
R3698 vdd.n1320 vdd.n1319 0.21775
R3699 vdd.n1338 vdd.n1337 0.21775
R3700 vdd.n585 vdd.n571 0.215744
R3701 vdd.n607 vdd.n606 0.214515
R3702 vdd.n792 vdd.n139 0.27171
R3703 vdd.n806 vdd.n141 0.27171
R3704 vdd.n267 vdd.n239 0.210428
R3705 vdd.n875 vdd.n874 0.209578
R3706 vdd.n670 vdd.n669 0.209578
R3707 vdd.n1000 vdd.n999 0.209578
R3708 vdd.n694 vdd.n693 0.209449
R3709 vdd.n734 vdd.n733 0.209449
R3710 vdd.n904 vdd.n903 0.209449
R3711 vdd.n959 vdd.n958 0.209449
R3712 vdd.n718 vdd.n717 0.209316
R3713 vdd.n14 vdd.n13 0.208325
R3714 vdd.n1773 vdd.n1772 0.207986
R3715 vdd.n256 vdd.n255 0.207928
R3716 vdd.n247 vdd.n242 0.205428
R3717 vdd.n2081 vdd.n2080 0.201736
R3718 vdd.n1992 vdd.n1991 0.201736
R3719 vdd.n2011 vdd.n1994 0.201736
R3720 vdd.n2062 vdd.n2061 0.201736
R3721 vdd.n2068 vdd.n2067 0.201736
R3722 vdd.n2045 vdd.n2044 0.201736
R3723 vdd.n2039 vdd.n2020 0.201736
R3724 vdd.n2032 vdd.n2031 0.201736
R3725 vdd.n2008 vdd.n1995 0.196736
R3726 vdd.n2029 vdd.n2028 0.196736
R3727 vdd.n2130 vdd.n2129 0.19653
R3728 vdd.n224 vdd.n195 0.195437
R3729 vdd.n2001 vdd.n1996 0.193325
R3730 vdd.n1999 vdd.n1998 0.193325
R3731 vdd.n187 vdd.n186 0.190118
R3732 vdd.n1791 vdd.n1790 0.190118
R3733 vdd.n1413 vdd.n1412 0.190118
R3734 vdd.n1420 vdd.n1419 0.190118
R3735 vdd.n1408 vdd.n1407 0.190118
R3736 vdd.n1429 vdd.n1428 0.190118
R3737 vdd.n1403 vdd.n1402 0.190118
R3738 vdd.n1438 vdd.n1437 0.190118
R3739 vdd.n1398 vdd.n1397 0.190118
R3740 vdd.n1447 vdd.n1446 0.190118
R3741 vdd.n1393 vdd.n1392 0.190118
R3742 vdd.n1456 vdd.n1455 0.190118
R3743 vdd.n1388 vdd.n1387 0.190118
R3744 vdd.n1465 vdd.n1464 0.190118
R3745 vdd.n1383 vdd.n1382 0.190118
R3746 vdd.n1474 vdd.n1473 0.190118
R3747 vdd.n1378 vdd.n1377 0.190118
R3748 vdd.n1483 vdd.n1482 0.190118
R3749 vdd.n1373 vdd.n1372 0.190118
R3750 vdd.n2010 vdd.n2009 0.187986
R3751 vdd.n2030 vdd.n2022 0.187986
R3752 vdd.n117 vdd.n1353 1.48406
R3753 vdd.n790 vdd.n59 0.309136
R3754 vdd.n151 vdd.n781 0.203245
R3755 vdd.n791 vdd.n151 0.248272
R3756 vdd.n803 vdd.n150 0.309136
R3757 vdd.n805 vdd.n101 0.248272
R3758 vdd.n248 vdd.n247 0.186192
R3759 vdd.n246 vdd.n245 0.186192
R3760 vdd.n257 vdd.n256 0.186192
R3761 vdd.n263 vdd.n262 0.186192
R3762 vdd.n239 vdd.n238 0.186192
R3763 vdd.n473 vdd.n426 0.185825
R3764 vdd.n477 vdd.n472 0.185825
R3765 vdd.n480 vdd.n479 0.185825
R3766 vdd.n513 vdd.n447 0.185825
R3767 vdd.n299 vdd.n298 0.185825
R3768 vdd.n11 vdd.n12 0.314042
R3769 vdd.n1755 vdd.n1754 0.185825
R3770 vdd.n2132 vdd.n2102 0.185825
R3771 vdd.n2144 vdd.n2143 0.185825
R3772 vdd.n424 vdd.n421 0.185744
R3773 vdd.n582 vdd.n581 0.185744
R3774 vdd.n461 vdd.n460 0.185486
R3775 vdd.n503 vdd.n502 0.185486
R3776 vdd.n2005 vdd.n2004 0.185486
R3777 vdd.n2003 vdd.n1996 0.185486
R3778 vdd.n2000 vdd.n1999 0.185486
R3779 vdd.n1776 vdd.n1775 0.185486
R3780 vdd.n1746 vdd.n1745 0.185486
R3781 vdd.n423 vdd.n422 0.184515
R3782 vdd.n576 vdd.n550 0.184515
R3783 vdd.n1492 vdd.n1489 0.184196
R3784 vdd.n184 vdd.n183 0.183859
R3785 vdd.n1739 vdd.n1738 0.183859
R3786 vdd.n1841 vdd.n1840 0.183859
R3787 vdd.n1858 vdd.n1857 0.183859
R3788 vdd.n1875 vdd.n1874 0.183859
R3789 vdd.n1892 vdd.n1891 0.183859
R3790 vdd.n1905 vdd.n1904 0.183859
R3791 vdd.n1922 vdd.n1921 0.183859
R3792 vdd.n1692 vdd.n1691 0.183859
R3793 vdd.n1675 vdd.n1674 0.183859
R3794 vdd.n1658 vdd.n1657 0.183859
R3795 vdd.n1641 vdd.n1640 0.183859
R3796 vdd.n1624 vdd.n1623 0.183859
R3797 vdd.n1607 vdd.n1606 0.183859
R3798 vdd.n1590 vdd.n1589 0.183859
R3799 vdd.n1573 vdd.n1572 0.183859
R3800 vdd.n1556 vdd.n1555 0.183859
R3801 vdd.n1539 vdd.n1538 0.183859
R3802 vdd.n1522 vdd.n1521 0.183859
R3803 vdd.n1505 vdd.n1504 0.183859
R3804 vdd.n2152 vdd.n2099 0.183325
R3805 vdd.n34 vdd.n289 0.186736
R3806 vdd.n283 vdd.n78 0.593044
R3807 vdd.n20 vdd.n196 0.590705
R3808 vdd.n6 vdd.n36 9.08631
R3809 vdd.n262 vdd.n261 0.177928
R3810 vdd.n2004 vdd.n2003 0.175825
R3811 vdd.n1751 vdd.n1750 0.175825
R3812 vdd.n1779 vdd.n1778 0.175825
R3813 vdd.n1777 vdd.n1776 0.175825
R3814 vdd.n1759 vdd.n1758 0.175825
R3815 vdd.n1757 vdd.n15 0.35072
R3816 vdd.n2140 vdd.n2101 0.175825
R3817 vdd.n1780 vdd.n1779 0.175486
R3818 vdd.n1760 vdd.n1759 0.175486
R3819 vdd.n1754 vdd.n1753 0.175486
R3820 vdd.n1752 vdd.n1751 0.175486
R3821 vdd.n2135 vdd.n2102 0.175486
R3822 vdd.n2143 vdd.n2101 0.175486
R3823 vdd.n252 vdd.n246 0.175428
R3824 vdd.n1772 vdd.n1771 0.174575
R3825 vdd.n2009 vdd.n1994 0.173325
R3826 vdd.n2032 vdd.n2030 0.173325
R3827 vdd.n474 vdd.n473 0.172986
R3828 vdd.n472 vdd.n471 0.172986
R3829 vdd.n2128 vdd.n2127 0.170789
R3830 vdd.n179 vdd.n178 0.169539
R3831 vdd.n1815 vdd.n1814 0.169539
R3832 vdd.n1805 vdd.n1804 0.169539
R3833 vdd.n1735 vdd.n1734 0.169539
R3834 vdd.n1720 vdd.n1719 0.169539
R3835 vdd.n1710 vdd.n1709 0.169539
R3836 vdd.n1370 vdd.n1369 0.169539
R3837 vdd.n802 vdd.n91 0.291949
R3838 vdd.n807 vdd.n148 0.291949
R3839 vdd.n822 vdd.n821 0.169213
R3840 vdd.n1824 vdd.n1823 0.168868
R3841 vdd.n278 vdd.n277 0.168692
R3842 vdd.n2006 vdd.n1995 0.168325
R3843 vdd.n2029 vdd.n2027 0.168325
R3844 vdd.n168 vdd.n167 0.166554
R3845 vdd.n1831 vdd.n1696 0.166554
R3846 vdd.n499 vdd.n461 0.164575
R3847 vdd.n503 vdd.n501 0.164575
R3848 vdd.n2010 vdd.n2008 0.164575
R3849 vdd.n2028 vdd.n2022 0.164575
R3850 vdd.n2129 vdd.n2128 0.164539
R3851 vdd.n517 vdd.n447 0.164236
R3852 vdd.n2145 vdd.n2144 0.164236
R3853 vdd.n191 vdd.n169 0.162039
R3854 vdd.n176 vdd.n175 0.162039
R3855 vdd.n1787 vdd.n1786 0.162039
R3856 vdd.n1730 vdd.n122 0.195559
R3857 vdd.n1838 vdd.n1837 0.162039
R3858 vdd.n1855 vdd.n1854 0.162039
R3859 vdd.n1872 vdd.n1871 0.162039
R3860 vdd.n1889 vdd.n1888 0.162039
R3861 vdd.n1902 vdd.n1901 0.162039
R3862 vdd.n1919 vdd.n1918 0.162039
R3863 vdd.n1689 vdd.n1688 0.162039
R3864 vdd.n1672 vdd.n1671 0.162039
R3865 vdd.n1655 vdd.n1654 0.162039
R3866 vdd.n1638 vdd.n1637 0.162039
R3867 vdd.n1621 vdd.n1620 0.162039
R3868 vdd.n1604 vdd.n1603 0.162039
R3869 vdd.n1587 vdd.n1586 0.162039
R3870 vdd.n1570 vdd.n1569 0.162039
R3871 vdd.n1553 vdd.n1552 0.162039
R3872 vdd.n1536 vdd.n1535 0.162039
R3873 vdd.n1519 vdd.n1518 0.162039
R3874 vdd.n1502 vdd.n1501 0.162039
R3875 vdd.n1410 vdd.n1409 0.162039
R3876 vdd.n1425 vdd.n1422 0.162039
R3877 vdd.n1405 vdd.n1404 0.162039
R3878 vdd.n1434 vdd.n1431 0.162039
R3879 vdd.n1400 vdd.n1399 0.162039
R3880 vdd.n1443 vdd.n1440 0.162039
R3881 vdd.n1395 vdd.n1394 0.162039
R3882 vdd.n1452 vdd.n1449 0.162039
R3883 vdd.n1390 vdd.n1389 0.162039
R3884 vdd.n1461 vdd.n1458 0.162039
R3885 vdd.n1385 vdd.n1384 0.162039
R3886 vdd.n1470 vdd.n1467 0.162039
R3887 vdd.n1380 vdd.n1379 0.162039
R3888 vdd.n1479 vdd.n1476 0.162039
R3889 vdd.n1375 vdd.n1374 0.162039
R3890 vdd.n1488 vdd.n1485 0.162039
R3891 vdd.n251 vdd.n250 0.158867
R3892 vdd.n243 vdd.n240 0.158867
R3893 vdd.n260 vdd.n259 0.158867
R3894 vdd.n266 vdd.n265 0.158867
R3895 vdd.n297 vdd.n288 0.157039
R3896 vdd.n2026 vdd.n2024 0.15694
R3897 vdd.n252 vdd.n251 0.155162
R3898 vdd.n481 vdd.n480 0.154236
R3899 vdd.n2014 vdd.n2013 0.152808
R3900 vdd.n2016 vdd.n2015 0.152808
R3901 vdd.n2079 vdd.n2078 0.152808
R3902 vdd.n2084 vdd.n2083 0.152808
R3903 vdd.n2087 vdd.n2086 0.152808
R3904 vdd.n2036 vdd.n2035 0.152808
R3905 vdd.n2036 vdd.n2034 0.152808
R3906 vdd.n2043 vdd.n2042 0.152808
R3907 vdd.n2043 vdd.n2041 0.152808
R3908 vdd.n2049 vdd.n2048 0.152808
R3909 vdd.n2049 vdd.n2047 0.152808
R3910 vdd.n2069 vdd.n2056 0.152808
R3911 vdd.n2069 vdd.n2055 0.152808
R3912 vdd.n2063 vdd.n2058 0.152808
R3913 vdd.n2063 vdd.n2057 0.152808
R3914 vdd.n2053 vdd.n2052 0.152808
R3915 vdd.n2053 vdd.n2051 0.152808
R3916 vdd.n261 vdd.n260 0.152662
R3917 vdd.n1359 vdd.n1358 0.15175
R3918 vdd.n1361 vdd.n1360 0.15175
R3919 vdd.n1318 vdd.n1255 0.15175
R3920 vdd.n1321 vdd.n1320 0.15175
R3921 vdd.n1325 vdd.n1324 0.15175
R3922 vdd.n1333 vdd.n1332 0.15175
R3923 vdd.n1337 vdd.n1336 0.15175
R3924 vdd.n1340 vdd.n1339 0.15175
R3925 vdd.n1347 vdd.n1346 0.15175
R3926 vdd.n1349 vdd.n1348 0.15175
R3927 vdd.n280 vdd.n279 0.150927
R3928 vdd.n819 vdd.n49 0.271324
R3929 vdd.n804 vdd.n140 0.209835
R3930 vdd.n630 vdd.n439 0.148289
R3931 vdd.n1701 vdd.n1700 0.148289
R3932 vdd.n2084 vdd.n1 0.317708
R3933 vdd.n2081 vdd.n2079 0.147075
R3934 vdd.n2016 vdd.n1992 0.147075
R3935 vdd.n5 vdd.n2014 0.317708
R3936 vdd.n2063 vdd.n2062 0.147075
R3937 vdd.n2069 vdd.n2068 0.147075
R3938 vdd.n2049 vdd.n2017 0.147075
R3939 vdd.n2045 vdd.n2043 0.147075
R3940 vdd.n2036 vdd.n2020 0.147075
R3941 vdd.n488 vdd.n487 0.147039
R3942 vdd.n1931 vdd.n427 0.147039
R3943 vdd.n1763 vdd.n1762 0.147039
R3944 vdd.n2142 vdd.n2139 0.147039
R3945 vdd.n569 vdd.n568 0.146192
R3946 vdd.n615 vdd.n41 0.145854
R3947 vdd.n298 vdd.n297 0.144236
R3948 vdd.n1362 vdd.n1361 0.1435
R3949 vdd.n1346 vdd.n1345 0.1435
R3950 vdd.n171 vdd.n170 0.1426
R3951 vdd.n1977 vdd.n1976 0.142219
R3952 vdd.n1968 vdd.n1967 0.142219
R3953 vdd.n1959 vdd.n1958 0.142219
R3954 vdd.n1944 vdd.n1943 0.142219
R3955 vdd.n416 vdd.n415 0.142219
R3956 vdd.n407 vdd.n406 0.142219
R3957 vdd.n398 vdd.n397 0.142219
R3958 vdd.n389 vdd.n388 0.142219
R3959 vdd.n380 vdd.n379 0.142219
R3960 vdd.n371 vdd.n370 0.142219
R3961 vdd.n362 vdd.n361 0.142219
R3962 vdd.n353 vdd.n352 0.142219
R3963 vdd.n344 vdd.n343 0.142219
R3964 vdd.n335 vdd.n334 0.142219
R3965 vdd.n326 vdd.n325 0.142219
R3966 vdd.n1851 vdd.n1850 0.142219
R3967 vdd.n1868 vdd.n1867 0.142219
R3968 vdd.n1885 vdd.n1884 0.142219
R3969 vdd.n1915 vdd.n1914 0.142219
R3970 vdd.n1685 vdd.n1684 0.142219
R3971 vdd.n1668 vdd.n1667 0.142219
R3972 vdd.n1651 vdd.n1650 0.142219
R3973 vdd.n1634 vdd.n1633 0.142219
R3974 vdd.n1617 vdd.n1616 0.142219
R3975 vdd.n1600 vdd.n1599 0.142219
R3976 vdd.n1583 vdd.n1582 0.142219
R3977 vdd.n1566 vdd.n1565 0.142219
R3978 vdd.n1549 vdd.n1548 0.142219
R3979 vdd.n1532 vdd.n1531 0.142219
R3980 vdd.n1515 vdd.n1514 0.142219
R3981 vdd.n810 vdd.n809 0.141713
R3982 vdd.n1745 vdd.n1744 0.139575
R3983 vdd.n500 vdd.n499 0.137039
R3984 vdd.n501 vdd.n456 0.137039
R3985 vdd.n527 vdd.n526 0.137039
R3986 vdd.n2146 vdd.n2145 0.137039
R3987 vdd.n832 vdd.n98 0.201169
R3988 vdd.n2074 vdd.n2017 0.135486
R3989 vdd.n2007 vdd.n2006 0.133289
R3990 vdd.n2027 vdd.n2023 0.133289
R3991 vdd.n2025 vdd.n2023 0.133289
R3992 vdd.n225 vdd.n223 0.132124
R3993 vdd.n491 vdd.n489 0.132039
R3994 vdd.n505 vdd.n453 0.132039
R3995 vdd.n449 vdd.n448 0.132039
R3996 vdd.n429 vdd.n428 0.132039
R3997 vdd.n1770 vdd.n1769 0.132039
R3998 vdd.n425 vdd.n423 0.130881
R3999 vdd.n425 vdd.n424 0.130881
R4000 vdd.n437 vdd.n436 0.129539
R4001 vdd.n190 vdd.n188 0.12922
R4002 vdd.n182 vdd.n180 0.12922
R4003 vdd.n174 vdd.n172 0.12922
R4004 vdd.n1979 vdd.n1974 0.12922
R4005 vdd.n1970 vdd.n1965 0.12922
R4006 vdd.n1961 vdd.n1956 0.12922
R4007 vdd.n1946 vdd.n1941 0.12922
R4008 vdd.n418 vdd.n413 0.12922
R4009 vdd.n409 vdd.n404 0.12922
R4010 vdd.n400 vdd.n395 0.12922
R4011 vdd.n391 vdd.n386 0.12922
R4012 vdd.n382 vdd.n377 0.12922
R4013 vdd.n373 vdd.n368 0.12922
R4014 vdd.n364 vdd.n359 0.12922
R4015 vdd.n355 vdd.n350 0.12922
R4016 vdd.n346 vdd.n341 0.12922
R4017 vdd.n337 vdd.n332 0.12922
R4018 vdd.n328 vdd.n323 0.12922
R4019 vdd.n1860 vdd.n1847 0.12922
R4020 vdd.n1853 vdd.n1849 0.12922
R4021 vdd.n1877 vdd.n1864 0.12922
R4022 vdd.n1870 vdd.n1866 0.12922
R4023 vdd.n1894 vdd.n1881 0.12922
R4024 vdd.n1887 vdd.n1883 0.12922
R4025 vdd.n1924 vdd.n1911 0.12922
R4026 vdd.n1917 vdd.n1913 0.12922
R4027 vdd.n1694 vdd.n1681 0.12922
R4028 vdd.n1687 vdd.n1683 0.12922
R4029 vdd.n1677 vdd.n1664 0.12922
R4030 vdd.n1670 vdd.n1666 0.12922
R4031 vdd.n1660 vdd.n1647 0.12922
R4032 vdd.n1653 vdd.n1649 0.12922
R4033 vdd.n1643 vdd.n1630 0.12922
R4034 vdd.n1636 vdd.n1632 0.12922
R4035 vdd.n1626 vdd.n1613 0.12922
R4036 vdd.n1619 vdd.n1615 0.12922
R4037 vdd.n1609 vdd.n1596 0.12922
R4038 vdd.n1602 vdd.n1598 0.12922
R4039 vdd.n1592 vdd.n1579 0.12922
R4040 vdd.n1585 vdd.n1581 0.12922
R4041 vdd.n1575 vdd.n1562 0.12922
R4042 vdd.n1568 vdd.n1564 0.12922
R4043 vdd.n1558 vdd.n1545 0.12922
R4044 vdd.n1551 vdd.n1547 0.12922
R4045 vdd.n1541 vdd.n1528 0.12922
R4046 vdd.n1534 vdd.n1530 0.12922
R4047 vdd.n1524 vdd.n1511 0.12922
R4048 vdd.n1517 vdd.n1513 0.12922
R4049 vdd.n1491 vdd.n1490 0.12922
R4050 vdd.n1415 vdd.n1414 0.12922
R4051 vdd.n1418 vdd.n1417 0.12922
R4052 vdd.n1424 vdd.n1423 0.12922
R4053 vdd.n1427 vdd.n1426 0.12922
R4054 vdd.n1433 vdd.n1432 0.12922
R4055 vdd.n1436 vdd.n1435 0.12922
R4056 vdd.n1442 vdd.n1441 0.12922
R4057 vdd.n1445 vdd.n1444 0.12922
R4058 vdd.n1451 vdd.n1450 0.12922
R4059 vdd.n1454 vdd.n1453 0.12922
R4060 vdd.n1460 vdd.n1459 0.12922
R4061 vdd.n1463 vdd.n1462 0.12922
R4062 vdd.n1469 vdd.n1468 0.12922
R4063 vdd.n1472 vdd.n1471 0.12922
R4064 vdd.n1478 vdd.n1477 0.12922
R4065 vdd.n1481 vdd.n1480 0.12922
R4066 vdd.n1487 vdd.n1486 0.12922
R4067 vdd.n190 vdd.n189 0.128884
R4068 vdd.n182 vdd.n181 0.128884
R4069 vdd.n174 vdd.n173 0.128884
R4070 vdd.n1985 vdd.n1984 0.128884
R4071 vdd.n1979 vdd.n1978 0.128884
R4072 vdd.n1970 vdd.n1969 0.128884
R4073 vdd.n1961 vdd.n1960 0.128884
R4074 vdd.n1952 vdd.n1951 0.128884
R4075 vdd.n1946 vdd.n1945 0.128884
R4076 vdd.n418 vdd.n417 0.128884
R4077 vdd.n409 vdd.n408 0.128884
R4078 vdd.n400 vdd.n399 0.128884
R4079 vdd.n391 vdd.n390 0.128884
R4080 vdd.n382 vdd.n381 0.128884
R4081 vdd.n373 vdd.n372 0.128884
R4082 vdd.n364 vdd.n363 0.128884
R4083 vdd.n355 vdd.n354 0.128884
R4084 vdd.n346 vdd.n345 0.128884
R4085 vdd.n337 vdd.n336 0.128884
R4086 vdd.n328 vdd.n327 0.128884
R4087 vdd.n319 vdd.n318 0.128884
R4088 vdd.n1822 vdd.n1821 0.128884
R4089 vdd.n1803 vdd.n1802 0.128884
R4090 vdd.n39 vdd.n38 0.128884
R4091 vdd.n1789 vdd.n1788 0.128884
R4092 vdd.n10 vdd.n9 0.128884
R4093 vdd.n125 vdd.n124 0.128884
R4094 vdd.n1737 vdd.n1736 0.128884
R4095 vdd.n121 vdd.n120 0.128884
R4096 vdd.n1722 vdd.n1721 0.128884
R4097 vdd.n1703 vdd.n1702 0.128884
R4098 vdd.n1843 vdd.n1842 0.128884
R4099 vdd.n1836 vdd.n1835 0.128884
R4100 vdd.n1860 vdd.n1859 0.128884
R4101 vdd.n1853 vdd.n1852 0.128884
R4102 vdd.n1877 vdd.n1876 0.128884
R4103 vdd.n1870 vdd.n1869 0.128884
R4104 vdd.n1894 vdd.n1893 0.128884
R4105 vdd.n1887 vdd.n1886 0.128884
R4106 vdd.n1907 vdd.n1906 0.128884
R4107 vdd.n1900 vdd.n1899 0.128884
R4108 vdd.n1924 vdd.n1923 0.128884
R4109 vdd.n1917 vdd.n1916 0.128884
R4110 vdd.n1694 vdd.n1693 0.128884
R4111 vdd.n1687 vdd.n1686 0.128884
R4112 vdd.n1677 vdd.n1676 0.128884
R4113 vdd.n1670 vdd.n1669 0.128884
R4114 vdd.n1660 vdd.n1659 0.128884
R4115 vdd.n1653 vdd.n1652 0.128884
R4116 vdd.n1643 vdd.n1642 0.128884
R4117 vdd.n1636 vdd.n1635 0.128884
R4118 vdd.n1626 vdd.n1625 0.128884
R4119 vdd.n1619 vdd.n1618 0.128884
R4120 vdd.n1609 vdd.n1608 0.128884
R4121 vdd.n1602 vdd.n1601 0.128884
R4122 vdd.n1592 vdd.n1591 0.128884
R4123 vdd.n1585 vdd.n1584 0.128884
R4124 vdd.n1575 vdd.n1574 0.128884
R4125 vdd.n1568 vdd.n1567 0.128884
R4126 vdd.n1558 vdd.n1557 0.128884
R4127 vdd.n1551 vdd.n1550 0.128884
R4128 vdd.n1541 vdd.n1540 0.128884
R4129 vdd.n1534 vdd.n1533 0.128884
R4130 vdd.n1524 vdd.n1523 0.128884
R4131 vdd.n1517 vdd.n1516 0.128884
R4132 vdd.n1507 vdd.n1506 0.128884
R4133 vdd.n1500 vdd.n1499 0.128884
R4134 vdd.n214 vdd.n206 0.128381
R4135 vdd.n475 vdd.n474 0.128289
R4136 vdd.n476 vdd.n475 0.128289
R4137 vdd.n471 vdd.n470 0.128289
R4138 vdd.n470 vdd.n469 0.128289
R4139 vdd.n818 vdd.n811 0.127963
R4140 vdd.n534 vdd.n533 0.127456
R4141 vdd.n436 vdd.n435 0.127039
R4142 vdd.n1771 vdd.n1770 0.127039
R4143 vdd.n277 vdd.n276 0.125854
R4144 vdd.n484 vdd.n482 0.125789
R4145 vdd.n466 vdd.n465 0.125789
R4146 vdd.n495 vdd.n494 0.125789
R4147 vdd.n531 vdd.n530 0.125789
R4148 vdd.n532 vdd.n531 0.125789
R4149 vdd.n434 vdd.n433 0.125789
R4150 vdd.n292 vdd.n34 0.185825
R4151 vdd.n293 vdd.n33 0.244894
R4152 vdd.n93 vdd.n291 0.185825
R4153 vdd.n106 vdd.n290 0.360888
R4154 vdd.n2100 vdd.n2098 0.125789
R4155 vdd.n2153 vdd.n2152 0.125486
R4156 vdd.n430 vdd.n429 0.124539
R4157 vdd.n1812 vdd.n1810 0.123325
R4158 vdd.n100 vdd.n160 0.468905
R4159 vdd.n255 vdd.n240 0.122662
R4160 vdd.n305 vdd.n26 0.57344
R4161 vdd.n1714 vdd.n1713 0.121736
R4162 vdd.n63 vdd.n789 0.305828
R4163 vdd.n102 vdd.n761 0.305566
R4164 vdd.n498 vdd.n497 0.120789
R4165 vdd.n500 vdd.n498 0.120789
R4166 vdd.n459 vdd.n458 0.120789
R4167 vdd.n528 vdd.n527 0.120789
R4168 vdd.n529 vdd.n528 0.120789
R4169 vdd.n2147 vdd.n2146 0.120789
R4170 vdd.n161 vdd.n134 0.147039
R4171 vdd.n267 vdd.n266 0.120162
R4172 vdd.n581 vdd.n580 0.119957
R4173 vdd.n577 vdd.n576 0.119957
R4174 vdd.n539 vdd.n462 0.119539
R4175 vdd.n647 vdd.n646 0.119493
R4176 vdd.n1985 vdd.n1981 0.119294
R4177 vdd.n1979 vdd.n1973 0.119294
R4178 vdd.n1970 vdd.n1964 0.119294
R4179 vdd.n1961 vdd.n1955 0.119294
R4180 vdd.n1952 vdd.n1948 0.119294
R4181 vdd.n1946 vdd.n1940 0.119294
R4182 vdd.n418 vdd.n412 0.119294
R4183 vdd.n409 vdd.n403 0.119294
R4184 vdd.n400 vdd.n394 0.119294
R4185 vdd.n391 vdd.n385 0.119294
R4186 vdd.n382 vdd.n376 0.119294
R4187 vdd.n373 vdd.n367 0.119294
R4188 vdd.n364 vdd.n358 0.119294
R4189 vdd.n355 vdd.n349 0.119294
R4190 vdd.n346 vdd.n340 0.119294
R4191 vdd.n337 vdd.n331 0.119294
R4192 vdd.n328 vdd.n322 0.119294
R4193 vdd.n319 vdd.n315 0.119294
R4194 vdd.n1416 vdd.n1415 0.119294
R4195 vdd.n621 vdd.n41 0.118692
R4196 vdd.n568 vdd.n567 0.118354
R4197 vdd.n491 vdd.n490 0.118289
R4198 vdd.n1843 vdd.n1832 0.118021
R4199 vdd.n1860 vdd.n1846 0.118021
R4200 vdd.n1877 vdd.n1863 0.118021
R4201 vdd.n1894 vdd.n1880 0.118021
R4202 vdd.n1907 vdd.n1896 0.118021
R4203 vdd.n1924 vdd.n1910 0.118021
R4204 vdd.n1694 vdd.n1680 0.118021
R4205 vdd.n1677 vdd.n1663 0.118021
R4206 vdd.n1660 vdd.n1646 0.118021
R4207 vdd.n1643 vdd.n1629 0.118021
R4208 vdd.n1626 vdd.n1612 0.118021
R4209 vdd.n1609 vdd.n1595 0.118021
R4210 vdd.n1592 vdd.n1578 0.118021
R4211 vdd.n1575 vdd.n1561 0.118021
R4212 vdd.n1558 vdd.n1544 0.118021
R4213 vdd.n1541 vdd.n1527 0.118021
R4214 vdd.n1524 vdd.n1510 0.118021
R4215 vdd.n1507 vdd.n1496 0.118021
R4216 vdd.n2095 vdd.n2093 0.117414
R4217 vdd.n431 vdd.n430 0.117039
R4218 vdd.n478 vdd.n477 0.115789
R4219 vdd.n479 vdd.n468 0.115789
R4220 vdd.n485 vdd.n465 0.115789
R4221 vdd.n460 vdd.n459 0.115789
R4222 vdd.n457 vdd.n456 0.115789
R4223 vdd.n454 vdd.n453 0.115789
R4224 vdd.n514 vdd.n448 0.115789
R4225 vdd.n530 vdd.n529 0.115789
R4226 vdd.n626 vdd.n532 0.115789
R4227 vdd.n443 vdd.n442 0.115789
R4228 vdd.n8 vdd.n632 0.441603
R4229 vdd.n290 vdd.n288 0.115789
R4230 vdd.n2007 vdd.n2005 0.115789
R4231 vdd.n12 vdd.n1783 0.115789
R4232 vdd.n1775 vdd.n1774 0.115789
R4233 vdd.n1756 vdd.n1755 0.115789
R4234 vdd.n1747 vdd.n1746 0.115789
R4235 vdd.n1743 vdd.n126 0.149309
R4236 vdd.n435 vdd.n434 0.114539
R4237 vdd.n1828 vdd.n1827 0.11425
R4238 vdd.n1830 vdd.n1697 0.11425
R4239 vdd.n1846 vdd.n1845 0.113443
R4240 vdd.n1863 vdd.n1862 0.113443
R4241 vdd.n1880 vdd.n1879 0.113443
R4242 vdd.n1910 vdd.n1909 0.113443
R4243 vdd.n1680 vdd.n1679 0.113443
R4244 vdd.n1663 vdd.n1662 0.113443
R4245 vdd.n1646 vdd.n1645 0.113443
R4246 vdd.n1629 vdd.n1628 0.113443
R4247 vdd.n1612 vdd.n1611 0.113443
R4248 vdd.n1595 vdd.n1594 0.113443
R4249 vdd.n1578 vdd.n1577 0.113443
R4250 vdd.n1561 vdd.n1560 0.113443
R4251 vdd.n1544 vdd.n1543 0.113443
R4252 vdd.n1527 vdd.n1526 0.113443
R4253 vdd.n1510 vdd.n1509 0.113443
R4254 vdd.n643 vdd.n642 0.113381
R4255 vdd.n638 vdd.n637 0.113381
R4256 vdd.n642 vdd.n641 0.113354
R4257 vdd.n639 vdd.n638 0.113354
R4258 vdd.n478 vdd.n476 0.113289
R4259 vdd.n469 vdd.n468 0.113289
R4260 vdd.n628 vdd.n442 0.113289
R4261 vdd.n440 vdd.n439 0.113289
R4262 vdd.n313 vdd.n194 0.111892
R4263 vdd.n484 vdd.n483 0.109539
R4264 vdd.n489 vdd.n488 0.109539
R4265 vdd.n494 vdd.n493 0.109539
R4266 vdd.n428 vdd.n427 0.109539
R4267 vdd.n1762 vdd.n1761 0.109539
R4268 vdd.n2142 vdd.n2141 0.109539
R4269 vdd.n1796 vdd.n1795 0.10925
R4270 vdd.n1784 vdd.n10 0.10925
R4271 vdd.n1742 vdd.n1741 0.10925
R4272 vdd.n1729 vdd.n1728 0.10925
R4273 vdd.n2137 vdd.n2136 0.10925
R4274 vdd.n1973 vdd.n1972 0.108516
R4275 vdd.n1964 vdd.n1963 0.108516
R4276 vdd.n1955 vdd.n1954 0.108516
R4277 vdd.n1940 vdd.n1939 0.108516
R4278 vdd.n412 vdd.n411 0.108516
R4279 vdd.n403 vdd.n402 0.108516
R4280 vdd.n394 vdd.n393 0.108516
R4281 vdd.n385 vdd.n384 0.108516
R4282 vdd.n376 vdd.n375 0.108516
R4283 vdd.n367 vdd.n366 0.108516
R4284 vdd.n358 vdd.n357 0.108516
R4285 vdd.n349 vdd.n348 0.108516
R4286 vdd.n340 vdd.n339 0.108516
R4287 vdd.n331 vdd.n330 0.108516
R4288 vdd.n322 vdd.n321 0.108516
R4289 vdd.n463 vdd.n462 0.108289
R4290 vdd.n149 vdd.n769 0.230074
R4291 vdd.n809 vdd.n114 0.230074
R4292 vdd.n142 vdd.n754 0.230074
R4293 vdd.n647 vdd.n644 0.106993
R4294 vdd.n236 vdd.n234 0.106993
R4295 vdd.n2088 vdd.n35 0.224894
R4296 vdd.n1358 vdd.n1357 0.105
R4297 vdd.n1350 vdd.n1349 0.105
R4298 vdd.n526 vdd.n525 0.104539
R4299 vdd.n294 vdd.n28 0.224236
R4300 vdd.n230 vdd.n229 0.103381
R4301 vdd.n1812 vdd.n1811 0.103002
R4302 vdd.n1713 vdd.n1711 0.103002
R4303 vdd.n1818 vdd.n1817 0.10175
R4304 vdd.n1799 vdd.n1798 0.10175
R4305 vdd.n1726 vdd.n1725 0.10175
R4306 vdd.n1707 vdd.n1706 0.10175
R4307 vdd.n820 vdd.n819 0.100463
R4308 vdd.n64 vdd.n782 0.284941
R4309 vdd.n432 vdd.n431 0.099539
R4310 vdd.t511 vdd.t504 0.0965452
R4311 vdd.n641 vdd.n640 0.0961924
R4312 vdd.n645 vdd.n639 0.0961924
R4313 vdd.n2115 vdd.n2114 0.0961154
R4314 vdd.n644 vdd.n643 0.0958812
R4315 vdd.n1927 vdd.n637 0.0958812
R4316 vdd.n231 vdd.n230 0.0958812
R4317 vdd.n497 vdd.n496 0.094539
R4318 vdd.n2139 vdd.n2138 0.094539
R4319 vdd.n1814 vdd.n1813 0.093289
R4320 vdd.n1783 vdd.n1782 0.093289
R4321 vdd.n1774 vdd.n1773 0.093289
R4322 vdd.n13 vdd.n1756 0.093289
R4323 vdd.n1748 vdd.n1747 0.093289
R4324 vdd.n1712 vdd.n1710 0.093289
R4325 vdd.n625 vdd.n444 0.09175
R4326 vdd.n525 vdd.n524 0.090789
R4327 vdd.n524 vdd.n523 0.0905
R4328 vdd.n570 vdd.n21 0.090239
R4329 vdd.n605 vdd.n545 0.090239
R4330 vdd.n1985 vdd.n1983 0.0896341
R4331 vdd.n1979 vdd.n1977 0.0896341
R4332 vdd.n1970 vdd.n1968 0.0896341
R4333 vdd.n1961 vdd.n1959 0.0896341
R4334 vdd.n1952 vdd.n1950 0.0896341
R4335 vdd.n1946 vdd.n1944 0.0896341
R4336 vdd.n418 vdd.n416 0.0896341
R4337 vdd.n409 vdd.n407 0.0896341
R4338 vdd.n400 vdd.n398 0.0896341
R4339 vdd.n391 vdd.n389 0.0896341
R4340 vdd.n382 vdd.n380 0.0896341
R4341 vdd.n373 vdd.n371 0.0896341
R4342 vdd.n364 vdd.n362 0.0896341
R4343 vdd.n355 vdd.n353 0.0896341
R4344 vdd.n346 vdd.n344 0.0896341
R4345 vdd.n337 vdd.n335 0.0896341
R4346 vdd.n328 vdd.n326 0.0896341
R4347 vdd.n319 vdd.n317 0.0896341
R4348 vdd.n1836 vdd.n1834 0.0896341
R4349 vdd.n1853 vdd.n1851 0.0896341
R4350 vdd.n1870 vdd.n1868 0.0896341
R4351 vdd.n1887 vdd.n1885 0.0896341
R4352 vdd.n1900 vdd.n1898 0.0896341
R4353 vdd.n1917 vdd.n1915 0.0896341
R4354 vdd.n1687 vdd.n1685 0.0896341
R4355 vdd.n1670 vdd.n1668 0.0896341
R4356 vdd.n1653 vdd.n1651 0.0896341
R4357 vdd.n1636 vdd.n1634 0.0896341
R4358 vdd.n1619 vdd.n1617 0.0896341
R4359 vdd.n1602 vdd.n1600 0.0896341
R4360 vdd.n1585 vdd.n1583 0.0896341
R4361 vdd.n1568 vdd.n1566 0.0896341
R4362 vdd.n1551 vdd.n1549 0.0896341
R4363 vdd.n1534 vdd.n1532 0.0896341
R4364 vdd.n1517 vdd.n1515 0.0896341
R4365 vdd.n1500 vdd.n1498 0.0896341
R4366 vdd.n626 vdd.n625 0.089539
R4367 vdd.n174 vdd.n171 0.0892512
R4368 vdd.n125 vdd.n123 0.089125
R4369 vdd.n635 vdd.n633 0.088
R4370 vdd.n1800 vdd.n1799 0.088
R4371 vdd.n1793 vdd.n1792 0.088
R4372 vdd.n1782 vdd.n1781 0.088
R4373 vdd.n1749 vdd.n1748 0.088
R4374 vdd.n1733 vdd.n1732 0.088
R4375 vdd.n1725 vdd.n1724 0.088
R4376 vdd.n508 vdd.n452 0.08675
R4377 vdd.n512 vdd.n511 0.08675
R4378 vdd.n512 vdd.n510 0.08675
R4379 vdd.n1828 vdd.n168 0.08675
R4380 vdd.n1766 vdd.n1765 0.08675
R4381 vdd.n1713 vdd.n1712 0.08675
R4382 vdd.n1831 vdd.n1830 0.08675
R4383 vdd.n830 vdd.n103 0.209449
R4384 vdd.n1813 vdd.n1812 0.0855
R4385 vdd.n2149 vdd.n2100 0.083289
R4386 vdd.n2122 vdd.n2121 0.0825713
R4387 vdd.n309 vdd.n20 0.583517
R4388 vdd.n2125 vdd.n2124 0.0808901
R4389 vdd.n615 vdd.n31 0.106146
R4390 vdd.n101 vdd.n769 0.203245
R4391 vdd.n754 vdd.n753 0.0795625
R4392 vdd.n185 vdd.n184 0.079539
R4393 vdd.n177 vdd.n176 0.079539
R4394 vdd.n1817 vdd.n1816 0.079539
R4395 vdd.n1798 vdd.n1797 0.079539
R4396 vdd.n1786 vdd.n1785 0.079539
R4397 vdd.n1740 vdd.n1739 0.079539
R4398 vdd.n1727 vdd.n1726 0.079539
R4399 vdd.n1708 vdd.n1707 0.079539
R4400 vdd.n1840 vdd.n1839 0.079539
R4401 vdd.n1839 vdd.n1838 0.079539
R4402 vdd.n1857 vdd.n1856 0.079539
R4403 vdd.n1856 vdd.n1855 0.079539
R4404 vdd.n1874 vdd.n1873 0.079539
R4405 vdd.n1873 vdd.n1872 0.079539
R4406 vdd.n1891 vdd.n1890 0.079539
R4407 vdd.n1890 vdd.n1889 0.079539
R4408 vdd.n1904 vdd.n1903 0.079539
R4409 vdd.n1903 vdd.n1902 0.079539
R4410 vdd.n1921 vdd.n1920 0.079539
R4411 vdd.n1920 vdd.n1919 0.079539
R4412 vdd.n1691 vdd.n1690 0.079539
R4413 vdd.n1690 vdd.n1689 0.079539
R4414 vdd.n1674 vdd.n1673 0.079539
R4415 vdd.n1673 vdd.n1672 0.079539
R4416 vdd.n1657 vdd.n1656 0.079539
R4417 vdd.n1656 vdd.n1655 0.079539
R4418 vdd.n1640 vdd.n1639 0.079539
R4419 vdd.n1639 vdd.n1638 0.079539
R4420 vdd.n1623 vdd.n1622 0.079539
R4421 vdd.n1622 vdd.n1621 0.079539
R4422 vdd.n1606 vdd.n1605 0.079539
R4423 vdd.n1605 vdd.n1604 0.079539
R4424 vdd.n1589 vdd.n1588 0.079539
R4425 vdd.n1588 vdd.n1587 0.079539
R4426 vdd.n1572 vdd.n1571 0.079539
R4427 vdd.n1571 vdd.n1570 0.079539
R4428 vdd.n1555 vdd.n1554 0.079539
R4429 vdd.n1554 vdd.n1553 0.079539
R4430 vdd.n1538 vdd.n1537 0.079539
R4431 vdd.n1537 vdd.n1536 0.079539
R4432 vdd.n1521 vdd.n1520 0.079539
R4433 vdd.n1520 vdd.n1519 0.079539
R4434 vdd.n1504 vdd.n1503 0.079539
R4435 vdd.n1503 vdd.n1502 0.079539
R4436 vdd.n1411 vdd.n1410 0.079539
R4437 vdd.n1422 vdd.n1421 0.079539
R4438 vdd.n1406 vdd.n1405 0.079539
R4439 vdd.n1431 vdd.n1430 0.079539
R4440 vdd.n1401 vdd.n1400 0.079539
R4441 vdd.n1440 vdd.n1439 0.079539
R4442 vdd.n1396 vdd.n1395 0.079539
R4443 vdd.n1449 vdd.n1448 0.079539
R4444 vdd.n1391 vdd.n1390 0.079539
R4445 vdd.n1458 vdd.n1457 0.079539
R4446 vdd.n1386 vdd.n1385 0.079539
R4447 vdd.n1467 vdd.n1466 0.079539
R4448 vdd.n1381 vdd.n1380 0.079539
R4449 vdd.n1476 vdd.n1475 0.079539
R4450 vdd.n1376 vdd.n1375 0.079539
R4451 vdd.n1485 vdd.n1484 0.079539
R4452 vdd.n1489 vdd.n1371 0.079539
R4453 vdd.n197 vdd.n80 0.589897
R4454 vdd.n270 vdd.n234 0.0769928
R4455 vdd.n518 vdd.n517 0.07675
R4456 vdd.n1327 vdd.n1202 0.076125
R4457 vdd.n1330 vdd.n1202 0.076125
R4458 vdd.n216 vdd.n215 0.0757137
R4459 vdd.n31 vdd.n30 0.050657
R4460 vdd.n464 vdd.n463 0.073
R4461 vdd.n521 vdd.n519 0.073
R4462 vdd.n217 vdd.n208 0.073
R4463 vdd.n96 vdd.n282 0.574446
R4464 vdd.n186 vdd.n185 0.072039
R4465 vdd.n178 vdd.n177 0.072039
R4466 vdd.n1826 vdd.n1825 0.072039
R4467 vdd.n1816 vdd.n1815 0.072039
R4468 vdd.n1797 vdd.n1796 0.072039
R4469 vdd.n1785 vdd.n1784 0.072039
R4470 vdd.n1741 vdd.n1740 0.072039
R4471 vdd.n1728 vdd.n1727 0.072039
R4472 vdd.n1709 vdd.n1708 0.072039
R4473 vdd.n1699 vdd.n1698 0.072039
R4474 vdd.n2138 vdd.n2137 0.072039
R4475 vdd.n1412 vdd.n1411 0.072039
R4476 vdd.n1421 vdd.n1420 0.072039
R4477 vdd.n1407 vdd.n1406 0.072039
R4478 vdd.n1430 vdd.n1429 0.072039
R4479 vdd.n1402 vdd.n1401 0.072039
R4480 vdd.n1439 vdd.n1438 0.072039
R4481 vdd.n1397 vdd.n1396 0.072039
R4482 vdd.n1448 vdd.n1447 0.072039
R4483 vdd.n1392 vdd.n1391 0.072039
R4484 vdd.n1457 vdd.n1456 0.072039
R4485 vdd.n1387 vdd.n1386 0.072039
R4486 vdd.n1466 vdd.n1465 0.072039
R4487 vdd.n1382 vdd.n1381 0.072039
R4488 vdd.n1475 vdd.n1474 0.072039
R4489 vdd.n1377 vdd.n1376 0.072039
R4490 vdd.n1484 vdd.n1483 0.072039
R4491 vdd.n1372 vdd.n1371 0.072039
R4492 vdd.n483 vdd.n467 0.07175
R4493 vdd.n493 vdd.n492 0.07175
R4494 vdd.n509 vdd.n507 0.07175
R4495 vdd.n312 vdd.n19 0.583157
R4496 vdd.n162 vdd.n36 0.274744
R4497 vdd.n2157 vdd.n2156 0.070789
R4498 vdd.n516 vdd.n446 0.068
R4499 vdd.n629 vdd.n628 0.068
R4500 vdd.n441 vdd.n440 0.068
R4501 vdd.n1216 vdd.n1215 0.0674395
R4502 vdd.n1252 vdd.n1251 0.0674395
R4503 vdd.n1827 vdd.n1826 0.067039
R4504 vdd.n1698 vdd.n1697 0.067039
R4505 vdd.n2074 vdd.n2073 0.06675
R4506 vdd.n121 vdd.n119 0.066625
R4507 vdd.n829 vdd.n88 0.248973
R4508 vdd.n791 vdd.n780 0.0658125
R4509 vdd.n805 vdd.n768 0.0658125
R4510 vdd.n146 vdd.n752 0.189495
R4511 vdd.n191 vdd.n190 0.065789
R4512 vdd.n175 vdd.n174 0.065789
R4513 vdd.n1789 vdd.n1787 0.065789
R4514 vdd.n1837 vdd.n1836 0.065789
R4515 vdd.n1854 vdd.n1853 0.065789
R4516 vdd.n1871 vdd.n1870 0.065789
R4517 vdd.n1888 vdd.n1887 0.065789
R4518 vdd.n1901 vdd.n1900 0.065789
R4519 vdd.n1918 vdd.n1917 0.065789
R4520 vdd.n1688 vdd.n1687 0.065789
R4521 vdd.n1671 vdd.n1670 0.065789
R4522 vdd.n1654 vdd.n1653 0.065789
R4523 vdd.n1637 vdd.n1636 0.065789
R4524 vdd.n1620 vdd.n1619 0.065789
R4525 vdd.n1603 vdd.n1602 0.065789
R4526 vdd.n1586 vdd.n1585 0.065789
R4527 vdd.n1569 vdd.n1568 0.065789
R4528 vdd.n1552 vdd.n1551 0.065789
R4529 vdd.n1535 vdd.n1534 0.065789
R4530 vdd.n1518 vdd.n1517 0.065789
R4531 vdd.n1501 vdd.n1500 0.065789
R4532 vdd.n1418 vdd.n1409 0.065789
R4533 vdd.n1425 vdd.n1424 0.065789
R4534 vdd.n1427 vdd.n1404 0.065789
R4535 vdd.n1434 vdd.n1433 0.065789
R4536 vdd.n1436 vdd.n1399 0.065789
R4537 vdd.n1443 vdd.n1442 0.065789
R4538 vdd.n1445 vdd.n1394 0.065789
R4539 vdd.n1452 vdd.n1451 0.065789
R4540 vdd.n1454 vdd.n1389 0.065789
R4541 vdd.n1461 vdd.n1460 0.065789
R4542 vdd.n1463 vdd.n1384 0.065789
R4543 vdd.n1470 vdd.n1469 0.065789
R4544 vdd.n1472 vdd.n1379 0.065789
R4545 vdd.n1479 vdd.n1478 0.065789
R4546 vdd.n1481 vdd.n1374 0.065789
R4547 vdd.n1488 vdd.n1487 0.065789
R4548 vdd.n32 vdd.n545 0.0868098
R4549 vdd.n486 vdd.n485 0.0655
R4550 vdd.n455 vdd.n454 0.0655
R4551 vdd.n515 vdd.n514 0.0655
R4552 vdd.n523 vdd.n522 0.0655
R4553 vdd.n444 vdd.n443 0.0655
R4554 vdd.n629 vdd.n627 0.0655
R4555 vdd.n632 vdd.n631 0.0655
R4556 vdd.n211 vdd.n204 0.0655
R4557 vdd.n1819 vdd.n1818 0.0655
R4558 vdd.n1807 vdd.n1806 0.0655
R4559 vdd.n1794 vdd.n39 0.0655
R4560 vdd.n1781 vdd.n1780 0.0655
R4561 vdd.n1768 vdd.n1767 0.0655
R4562 vdd.n1750 vdd.n1749 0.0655
R4563 vdd.n1718 vdd.n1717 0.0655
R4564 vdd.n1706 vdd.n1705 0.0655
R4565 vdd.n2136 vdd.n2135 0.0655
R4566 vdd.n504 vdd.n452 0.06425
R4567 vdd.n1226 vdd.n1223 0.0640556
R4568 vdd.n1230 vdd.n1229 0.0640556
R4569 vdd.n1236 vdd.n1235 0.0640556
R4570 vdd.n1240 vdd.n1237 0.0640556
R4571 vdd.n490 vdd.n464 0.063
R4572 vdd.n2106 vdd.n2105 0.0625361
R4573 vdd.n313 vdd.n18 13.9689
R4574 vdd.n182 vdd.n179 0.062039
R4575 vdd.n1804 vdd.n1803 0.062039
R4576 vdd.n1737 vdd.n1735 0.062039
R4577 vdd.n1722 vdd.n1720 0.062039
R4578 vdd.n1703 vdd.n1701 0.062039
R4579 vdd.n1491 vdd.n1370 0.062039
R4580 vdd.n539 vdd.n492 0.06175
R4581 vdd vdd.n1933 0.0605
R4582 vdd.n520 vdd.n446 0.0605
R4583 vdd.n521 vdd.n520 0.0605
R4584 vdd.n141 vdd.n768 0.243441
R4585 vdd.n145 vdd.n752 0.18262
R4586 vdd.n1705 vdd.n1704 0.0584996
R4587 vdd.n506 vdd.n504 0.05675
R4588 vdd.n1933 vdd.n426 0.0555
R4589 vdd.n467 vdd.n466 0.0555
R4590 vdd.n502 vdd.n455 0.0555
R4591 vdd.n515 vdd.n513 0.0555
R4592 vdd.n522 vdd.n445 0.0555
R4593 vdd.n627 vdd.n441 0.0555
R4594 vdd.n635 vdd.n634 0.0555
R4595 vdd.n1820 vdd.n1819 0.0555
R4596 vdd.n1808 vdd.n1807 0.0555
R4597 vdd.n1795 vdd.n1794 0.0555
R4598 vdd.n1767 vdd.n1766 0.0555
R4599 vdd.n119 vdd.n1729 0.0555
R4600 vdd.n1717 vdd.n1716 0.0555
R4601 vdd.n37 vdd.n289 0.0982824
R4602 vdd.n518 vdd.n516 0.053
R4603 vdd.n1930 vdd.n636 0.053
R4604 vdd.n438 vdd.n437 0.05175
R4605 vdd.n2153 vdd.n2098 0.0505
R4606 vdd.n1219 vdd.n132 0.918278
R4607 vdd.n1245 vdd.n131 0.913135
R4608 vdd.n506 vdd.n505 0.04925
R4609 vdd.n507 vdd.n451 0.04925
R4610 vdd.n450 vdd.n449 0.04925
R4611 vdd.n1769 vdd.n1768 0.04925
R4612 vdd.n134 vdd.n162 0.109539
R4613 vdd.n1220 vdd.n1219 0.0489879
R4614 vdd.n1246 vdd.n1245 0.0489879
R4615 vdd.n519 vdd.n445 0.048
R4616 vdd.n1744 vdd.n1743 0.04675
R4617 vdd.n2089 vdd.n109 0.30716
R4618 vdd.n2059 vdd.n1988 0.0455
R4619 vdd.n64 vdd.n781 0.230203
R4620 vdd.n183 vdd.n182 0.0448003
R4621 vdd.n1738 vdd.n1737 0.0448003
R4622 vdd.n1843 vdd.n1841 0.0448003
R4623 vdd.n1860 vdd.n1858 0.0448003
R4624 vdd.n1877 vdd.n1875 0.0448003
R4625 vdd.n1894 vdd.n1892 0.0448003
R4626 vdd.n1907 vdd.n1905 0.0448003
R4627 vdd.n1924 vdd.n1922 0.0448003
R4628 vdd.n1694 vdd.n1692 0.0448003
R4629 vdd.n1677 vdd.n1675 0.0448003
R4630 vdd.n1660 vdd.n1658 0.0448003
R4631 vdd.n1643 vdd.n1641 0.0448003
R4632 vdd.n1626 vdd.n1624 0.0448003
R4633 vdd.n1609 vdd.n1607 0.0448003
R4634 vdd.n1592 vdd.n1590 0.0448003
R4635 vdd.n1575 vdd.n1573 0.0448003
R4636 vdd.n1558 vdd.n1556 0.0448003
R4637 vdd.n1541 vdd.n1539 0.0448003
R4638 vdd.n1524 vdd.n1522 0.0448003
R4639 vdd.n1507 vdd.n1505 0.0448003
R4640 vdd.n1226 vdd.n1225 0.0445
R4641 vdd.n1230 vdd.n1227 0.0445
R4642 vdd.n1236 vdd.n1233 0.0445
R4643 vdd.n1240 vdd.n1239 0.0445
R4644 vdd.n1492 vdd.n1491 0.0444648
R4645 vdd.n190 vdd.n187 0.0423097
R4646 vdd.n1790 vdd.n1789 0.0423097
R4647 vdd.n1823 vdd.n1822 0.0423097
R4648 vdd.n1487 vdd.n1373 0.0423097
R4649 vdd.n1482 vdd.n1481 0.0423097
R4650 vdd.n1478 vdd.n1378 0.0423097
R4651 vdd.n1473 vdd.n1472 0.0423097
R4652 vdd.n1469 vdd.n1383 0.0423097
R4653 vdd.n1464 vdd.n1463 0.0423097
R4654 vdd.n1460 vdd.n1388 0.0423097
R4655 vdd.n1455 vdd.n1454 0.0423097
R4656 vdd.n1451 vdd.n1393 0.0423097
R4657 vdd.n1446 vdd.n1445 0.0423097
R4658 vdd.n1442 vdd.n1398 0.0423097
R4659 vdd.n1437 vdd.n1436 0.0423097
R4660 vdd.n1433 vdd.n1403 0.0423097
R4661 vdd.n1428 vdd.n1427 0.0423097
R4662 vdd.n1424 vdd.n1408 0.0423097
R4663 vdd.n1419 vdd.n1418 0.0423097
R4664 vdd.n1415 vdd.n1413 0.0423097
R4665 vdd.n23 vdd.n197 0.603379
R4666 vdd.n1323 vdd.n1322 0.04175
R4667 vdd.n1335 vdd.n1334 0.04175
R4668 vdd.n1928 vdd.n1927 0.0405
R4669 vdd.n1937 vdd.n420 0.0405
R4670 vdd.n1935 vdd.n1934 0.0405
R4671 vdd.n96 vdd.n283 0.599832
R4672 vdd.n1365 vdd.n1364 0.039
R4673 vdd.n1343 vdd.n1342 0.039
R4674 vdd.n222 vdd.n204 0.038
R4675 vdd.n2124 vdd.n2123 0.0376295
R4676 vdd.n2123 vdd.n2122 0.0376295
R4677 vdd.n94 vdd.n287 0.216011
R4678 vdd.n578 vdd.n577 0.0361656
R4679 vdd.n580 vdd.n579 0.0361656
R4680 vdd.n1801 vdd.n1800 0.0359996
R4681 vdd.n1724 vdd.n1723 0.0359996
R4682 vdd.n487 vdd.n486 0.03425
R4683 vdd.n509 vdd.n508 0.03425
R4684 vdd.n511 vdd.n451 0.03425
R4685 vdd.n510 vdd.n450 0.03425
R4686 vdd.n1932 vdd.n1931 0.03425
R4687 vdd.n1765 vdd.n1764 0.03425
R4688 vdd.n1764 vdd.n1763 0.03425
R4689 vdd.n110 vdd.n161 0.213261
R4690 vdd.n631 vdd.n630 0.033
R4691 vdd.n633 vdd.n438 0.033
R4692 vdd.n640 vdd.n636 0.033
R4693 vdd.n646 vdd.n645 0.033
R4694 vdd.n17 vdd.n1793 0.203124
R4695 vdd.n123 vdd.n1742 0.033
R4696 vdd.n1732 vdd.n1731 0.033
R4697 vdd.n1215 vdd.n1212 0.0288871
R4698 vdd.n1251 vdd.n1248 0.0288871
R4699 vdd.n118 vdd.n2087 0.146736
R4700 vdd.n2117 vdd.n2105 0.0256087
R4701 vdd.n63 vdd.n782 0.209316
R4702 vdd.n808 vdd.n102 0.209578
R4703 vdd.n2133 vdd.n2132 0.023
R4704 vdd.n482 vdd.n481 0.02175
R4705 vdd.n496 vdd.n495 0.02175
R4706 vdd.n1825 vdd.n1824 0.02175
R4707 vdd.n1700 vdd.n1699 0.02175
R4708 vdd.n578 vdd.n574 0.0210495
R4709 vdd.n579 vdd.n574 0.0210495
R4710 vdd.n1214 vdd.n1212 0.020371
R4711 vdd.n1250 vdd.n1248 0.020371
R4712 vdd.n1829 vdd.n168 0.019616
R4713 vdd.n192 vdd.n169 0.01925
R4714 vdd.n1809 vdd.n1808 0.01925
R4715 vdd.n1731 vdd.n1730 0.01925
R4716 vdd.n1716 vdd.n1715 0.01925
R4717 vdd.n1366 vdd.n1365 0.018375
R4718 vdd.n1342 vdd.n1341 0.018375
R4719 vdd.n433 vdd.n432 0.01675
R4720 vdd.n294 vdd.n93 0.136736
R4721 vdd.n1761 vdd.n1760 0.01675
R4722 vdd.n2141 vdd.n2140 0.01675
R4723 vdd.n208 vdd.n207 0.0155
R4724 vdd.n1225 vdd.n1224 0.0137759
R4725 vdd.n1234 vdd.n1233 0.0137759
R4726 vdd.n1228 vdd.n1227 0.0118793
R4727 vdd.n1239 vdd.n1238 0.0118793
R4728 vdd.n1806 vdd.n1805 0.01175
R4729 vdd.n1792 vdd.n1791 0.01175
R4730 vdd.n1734 vdd.n1733 0.01175
R4731 vdd.n1719 vdd.n1718 0.01175
R4732 vdd.n1493 vdd.n1369 0.01175
R4733 vdd.n1778 vdd.n1777 0.0105
R4734 vdd.n1758 vdd.n1757 0.0105
R4735 vdd.n1753 vdd.n1752 0.0105
R4736 vdd.n2127 vdd.n2126 0.0105
R4737 vdd.n113 vdd.n104 0.00786061
R4738 vdd.n220 vdd.n219 0.008
R4739 vdd.n2090 vdd.n2089 0.008
R4740 vdd.n458 vdd.n457 0.0055
R4741 vdd.n1822 vdd.n1820 0.0055
R4742 vdd.n864 vdd.n832 0.00435268
R4743 vdd.n790 vdd.n789 0.0039375
R4744 vdd.n803 vdd.n776 0.0039375
R4745 vdd.n51 vdd.n761 0.24867
R4746 vdd.n1704 vdd.n1703 0.00349963
R4747 vdd.n1723 vdd.n1722 0.00349963
R4748 vdd.n1803 vdd.n1801 0.00349963
R4749 vdd.n860 vdd.n832 0.00344978
R4750 vdd.n1354 vdd.n117 1.38797
R4751 vdd.t553 vdd.n127 0.371565
R4752 vdd.n69 vdd.n68 0.0174999
R4753 vdd.n89 vdd.n85 0.0207876
R4754 vdd.n66 vdd.n71 0.0175008
R4755 vdd.n85 vdd.n75 0.0161877
R4756 vdd.n84 vdd.n74 0.00791311
R4757 vdd.n99 vdd.n104 0.0147386
R4758 vdd.t384 vdd.n92 0.013931
R4759 vdd.n82 vdd.n81 0.0120712
R4760 vdd.t1127 vdd.t287 0.0117365
R4761 vdd.n68 vdd.n75 0.0115
R4762 vdd.n89 vdd.n58 0.0114997
R4763 vdd.t287 vdd.n52 0.00510556
R4764 vdd.n84 vdd.n61 0.0108276
R4765 vdd.n79 vdd.t1173 0.0105841
R4766 vdd.t1290 vdd.n53 0.00812343
R4767 vdd.n60 vdd.n62 0.00831986
R4768 vdd.n143 vdd.n55 0.00924932
R4769 vdd.n138 vdd.n82 0.00906926
R4770 vdd.n95 vdd.n50 0.00852095
R4771 vdd.n45 vdd.t570 0.00536496
R4772 vdd.t1128 vdd.n159 0.00815233
R4773 vdd.n61 vdd.n50 0.0079992
R4774 vdd.n87 vdd.n47 0.00799294
R4775 vdd.n147 vdd.n48 0.00699961
R4776 vdd.t1290 vdd.n65 0.00699767
R4777 vdd.n48 vdd.n87 0.00648854
R4778 vdd.n619 vdd.n40 8.63444
R4779 vdd.t507 vdd.n3 1.4969
R4780 vdd.n2097 vdd.n6 1.33433
R4781 vdd.n25 vdd.t617 1.08145
R4782 vss.n5040 vss.n5038 1.073e+06
R4783 vss.n5333 vss.n5041 573641
R4784 vss.n6371 vss.n2346 185412
R4785 vss.n5331 vss.n5043 178261
R4786 vss.n5307 vss.n5082 78085.7
R4787 vss.n6024 vss.n6023 72600
R4788 vss.n5989 vss.t519 61081.4
R4789 vss.n5966 vss.t53 61081.4
R4790 vss.n5688 vss.t222 61081.4
R4791 vss.n5665 vss.t794 61081.4
R4792 vss.n5642 vss.t821 61081.4
R4793 vss.n5908 vss.n5907 55220.9
R4794 vss.n6026 vss.n3996 52421.1
R4795 vss.n5907 vss.t1045 50180.1
R4796 vss.n5309 vss.n5308 50160.6
R4797 vss.n5308 vss.n5307 47700
R4798 vss.n5085 vss.n5084 45900
R4799 vss.n3227 vss.n3226 45900
R4800 vss.n5922 vss.n5921 35066.7
R4801 vss.n5919 vss.n5918 35066.7
R4802 vss.n5916 vss.n5915 35066.7
R4803 vss.n5913 vss.n5912 35066.7
R4804 vss.n5910 vss.n5909 35066.7
R4805 vss.n5923 vss.n5922 30453.5
R4806 vss.n5920 vss.n5919 30453.5
R4807 vss.n5917 vss.n5916 30453.5
R4808 vss.n5914 vss.n5913 30453.5
R4809 vss.n5911 vss.n5910 30453.5
R4810 vss.n4604 vss.n4286 28838.7
R4811 vss.n4617 vss.n3996 19899.9
R4812 vss.n5926 vss.n5924 16229.5
R4813 vss.n6025 vss.n6024 13244
R4814 vss.t1940 vss.n5309 13181.3
R4815 vss.t498 vss.n5923 12785
R4816 vss.t551 vss.n5920 12785
R4817 vss.t613 vss.n5917 12785
R4818 vss.t844 vss.n5914 12785
R4819 vss.t864 vss.n5911 12785
R4820 vss.t649 vss.n5908 12785
R4821 vss.n5082 vss.t0 12691.5
R4822 vss.n5082 vss.n5081 12428.6
R4823 vss.n6370 vss.n852 12393.4
R4824 vss.n852 vss.n856 12393.4
R4825 vss.n856 vss.n862 12393.4
R4826 vss.n862 vss.n868 12393.4
R4827 vss.n868 vss.n872 12393.4
R4828 vss.n872 vss.n878 12393.4
R4829 vss.n878 vss.n882 12393.4
R4830 vss.n882 vss.n886 12393.4
R4831 vss.n886 vss.n892 12393.4
R4832 vss.n6024 vss.n3996 12290.3
R4833 vss.n892 vss.n896 11475.4
R4834 vss.n4605 vss.n4604 10717.7
R4835 vss.t1665 vss.t1639 10176.5
R4836 vss.n5085 vss.n5082 9985.71
R4837 vss.n6041 vss.n3227 9985.71
R4838 vss.n4 vss.n6030 9596.42
R4839 vss.n5315 vss.t1982 9351.97
R4840 vss.n6035 vss.n3241 9230.92
R4841 vss.n6040 vss.n6039 8700.4
R4842 vss.n2930 vss.n2928 8634.86
R4843 vss.n2870 vss.n2868 8634.86
R4844 vss.n5314 vss.n5313 8467.26
R4845 vss.n5306 vss.n5085 8041.67
R4846 vss.n647 vss.n287 0.00152045
R4847 vss.n6039 vss.n3227 7824.32
R4848 vss.n5075 vss.n5074 7717.31
R4849 vss.n5286 vss.n5282 7717.31
R4850 vss.n5084 vss.n5083 7028.57
R4851 vss.n3226 vss.n3225 7028.57
R4852 vss.t32 vss.t1665 6976.56
R4853 vss.n6373 vss.n6372 6602.66
R4854 vss.n5068 vss.n2345 6597.67
R4855 vss.n5332 vss.n5331 6586.68
R4856 vss.n5068 vss.n5043 6561.72
R4857 vss.n86 vss.n71 6419.79
R4858 vss.n5372 vss.t626 6353.22
R4859 vss.n2792 vss.n647 6155.5
R4860 vss.n3012 vss.n2299 5931.29
R4861 vss.n740 vss.n741 5931.29
R4862 vss.n6030 vss.n6029 5640.39
R4863 vss.n1238 vss.t583 5508.2
R4864 vss.t1639 vss.t960 5495.1
R4865 vss.n2753 vss.t775 5295.45
R4866 vss.t1430 vss.t1428 5274.51
R4867 vss.t1428 vss.t1426 5274.51
R4868 vss.t1426 vss.t1423 5274.51
R4869 vss.n6371 vss.n6370 5229.51
R4870 vss.n5103 vss.n5079 5134.53
R4871 vss.n5289 vss.n5288 5134.53
R4872 vss.n6035 vss.n6034 4890.17
R4873 vss.t1937 vss.n5043 4838.19
R4874 vss.n71 vss.n3996 4814.52
R4875 vss.n6025 vss.n1035 4811.77
R4876 vss.n5083 vss.n2299 4542.86
R4877 vss.n3225 vss.n741 4542.86
R4878 vss.n2357 vss.n2355 4500
R4879 vss.n6372 vss.n6371 4265.89
R4880 vss.t821 vss.n5641 4262.19
R4881 vss.t794 vss.n5664 4262.19
R4882 vss.t222 vss.n5687 4262.19
R4883 vss.t53 vss.n5965 4262.19
R4884 vss.t519 vss.n5988 4262.19
R4885 vss.n5926 vss.n5925 4081.4
R4886 vss.n287 vss.t757 4053.95
R4887 vss.n5077 vss.n5076 3983.61
R4888 vss.n5285 vss.n5284 3983.61
R4889 vss.n6369 vss.n2357 3962.37
R4890 vss.n6373 vss.n2345 3937.92
R4891 vss.n5924 vss.t489 3933.96
R4892 vss.n5921 vss.t144 3933.96
R4893 vss.n5918 vss.t572 3933.96
R4894 vss.n5915 vss.t933 3933.96
R4895 vss.n5912 vss.t1294 3933.96
R4896 vss.n5909 vss.t1177 3933.96
R4897 vss.n5333 vss.n5332 3924.17
R4898 vss.n270 vss.t757 3886.36
R4899 vss.t1435 vss.n5071 3885.7
R4900 vss.n5079 vss.t1187 3885.19
R4901 vss.t1979 vss.n5333 3854.82
R4902 vss.t1423 vss.n2361 3833.33
R4903 vss.t545 vss.n5078 3804.3
R4904 vss.n5076 vss.n5075 3710.25
R4905 vss.n5286 vss.n5285 3710.25
R4906 vss.n6409 vss.n1135 3656.34
R4907 vss.n1238 vss.n1049 3639.34
R4908 vss.n5308 vss.n5072 3625.62
R4909 vss.n5658 vss.t1080 3508.06
R4910 vss.n5681 vss.t1065 3508.06
R4911 vss.n5959 vss.t1109 3508.06
R4912 vss.n5982 vss.t1131 3508.06
R4913 vss.n6004 vss.t1135 3508.06
R4914 vss.n6042 vss.n6041 3383.33
R4915 vss.n5281 vss.n3228 3278.51
R4916 vss.n6041 vss.n6040 3042.1
R4917 vss.t489 vss.t498 2886.79
R4918 vss.t144 vss.t551 2886.79
R4919 vss.t572 vss.t613 2886.79
R4920 vss.t933 vss.t844 2886.79
R4921 vss.t1294 vss.t864 2886.79
R4922 vss.t1177 vss.t649 2886.79
R4923 vss.t478 vss.t956 2848.4
R4924 vss.t979 vss.t870 2848.4
R4925 vss.t980 vss.t479 2848.4
R4926 vss.t477 vss.t957 2848.4
R4927 vss.n5640 vss.t1239 2835.37
R4928 vss.n5663 vss.t654 2835.37
R4929 vss.n5686 vss.t221 2835.37
R4930 vss.n5964 vss.t226 2835.37
R4931 vss.n5987 vss.t927 2835.37
R4932 vss.n6011 vss.t990 2642.55
R4933 vss.n5073 vss.t1915 2591.93
R4934 vss.t2090 vss.n5287 2591.93
R4935 vss.n5287 vss.t840 2461.88
R4936 vss.n1321 vss.t618 2374.56
R4937 vss.n1450 vss.t679 2374.56
R4938 vss.t1045 vss.t853 2266.85
R4939 vss.t853 vss.t1057 2266.85
R4940 vss.t1057 vss.t1138 2266.85
R4941 vss.t1138 vss.t1140 2266.85
R4942 vss.t1140 vss.t1142 2266.85
R4943 vss.t923 vss.t814 2266.85
R4944 vss.t814 vss.t724 2266.85
R4945 vss.t724 vss.t2129 2266.85
R4946 vss.t2129 vss.t689 2266.85
R4947 vss.t689 vss.t32 2266.85
R4948 vss.n5079 vss.t1915 2082.96
R4949 vss.n5288 vss.t2090 2082.96
R4950 vss.n5311 vss.t1940 2059.7
R4951 vss.n6011 vss.t472 1991.49
R4952 vss.n6180 vss.n2696 1960.32
R4953 vss.t1080 vss.t1148 1862.9
R4954 vss.t1065 vss.t1310 1862.9
R4955 vss.t1109 vss.t79 1862.9
R4956 vss.t1131 vss.t90 1862.9
R4957 vss.t1135 vss.t485 1862.9
R4958 vss.n5334 vss.t1982 1839.29
R4959 vss.t840 vss.n5286 1677.13
R4960 vss.n5076 vss.n1135 1672.13
R4961 vss.n5285 vss.n1049 1672.13
R4962 vss.n2357 vss.n2356 1671.22
R4963 vss.n5600 vss.t1056 1596.66
R4964 vss.n5906 vss.t1430 1593.14
R4965 vss.n5659 vss.t1286 1576.27
R4966 vss.n5682 vss.t544 1576.27
R4967 vss.n5960 vss.t577 1576.27
R4968 vss.n5983 vss.t962 1576.27
R4969 vss.n6005 vss.t2084 1576.27
R4970 vss.n1321 vss.n1121 1568.9
R4971 vss.n1450 vss.n1062 1568.9
R4972 vss.n5601 vss.t46 1496.42
R4973 vss.n5906 vss.t960 1450.98
R4974 vss.n4605 vss.n13 1420.01
R4975 vss.n4283 vss.t2128 1413.9
R4976 vss.n5906 vss.t923 1386.24
R4977 vss.n5040 vss.n5039 1375.36
R4978 vss.n5041 vss.n5040 1371.31
R4979 vss.t608 vss.n5073 1278.03
R4980 vss.n5078 vss.n5077 1241.38
R4981 vss.n5281 vss.n3241 1241.38
R4982 vss.n5069 vss.n5068 1211.48
R4983 vss.n2345 vss.n2344 1211.46
R4984 vss.n2870 vss.n2869 1157.61
R4985 vss.n2930 vss.n2929 1157.61
R4986 vss.t476 vss.n5281 1140.96
R4987 vss.n5078 vss.t475 1140.96
R4988 vss.n5311 vss.t1937 1029.85
R4989 vss.n430 vss.n5372 1008.79
R4990 vss.n5286 vss.n1065 937.221
R4991 vss.n6394 vss.n366 4917.42
R4992 vss.n6034 vss.n363 935.711
R4993 vss.t1142 vss.n5906 880.619
R4994 vss.n5076 vss.t666 854.077
R4995 vss.n5285 vss.t667 854.077
R4996 vss.n270 vss.t1256 830.867
R4997 vss.t956 vss.t979 813.831
R4998 vss.t870 vss.t476 813.831
R4999 vss.t479 vss.t475 813.831
R5000 vss.t957 vss.t980 813.831
R5001 vss.n5372 vss.n5371 779.828
R5002 vss.n652 vss.n2870 753.604
R5003 vss.n2931 vss.n2930 753.604
R5004 vss.n6173 vss.n6172 724.832
R5005 vss.n6188 vss.n6187 724.442
R5006 vss.n5283 vss.n3241 722.822
R5007 vss.n5076 vss.n1121 720.848
R5008 vss.n5285 vss.n1062 720.848
R5009 vss.n6180 vss.n6179 708.894
R5010 vss.n6181 vss.n6180 708.894
R5011 vss.n5336 vss.n5335 684.611
R5012 vss.n5331 vss.n840 1967.08
R5013 vss.t775 vss.n270 659.091
R5014 vss.n6026 vss.n6025 654.453
R5015 vss.n5282 vss.t478 654.255
R5016 vss.n5074 vss.t477 654.255
R5017 vss.n6369 vss.n6368 652.319
R5018 vss.n5658 vss.t949 646.659
R5019 vss.n5681 vss.t1075 646.659
R5020 vss.n5959 vss.t610 646.659
R5021 vss.n5982 vss.t660 646.659
R5022 vss.n6004 vss.t1123 646.659
R5023 vss.n3907 vss.n3894 646.375
R5024 vss.n5332 vss.n5042 644.98
R5025 vss.n2363 vss.n2361 637.255
R5026 vss.n5592 vss.t1024 634.38
R5027 vss.n5584 vss.t669 634.38
R5028 vss.n5575 vss.t130 634.38
R5029 vss.n5567 vss.t549 634.38
R5030 vss.n5559 vss.t17 634.38
R5031 vss.n3871 vss.n363 632.174
R5032 vss.n365 vss.n364 0.00149324
R5033 vss.n5334 vss.t1979 625
R5034 vss.n896 vss.n6369 618.28
R5035 vss.n412 vss.t1877 354.654
R5036 vss.n6394 vss.n843 606.239
R5037 vss.n6035 vss.n6033 606.239
R5038 vss.t949 vss.t700 593.452
R5039 vss.t1075 vss.t797 593.452
R5040 vss.t610 vss.t225 593.452
R5041 vss.t660 vss.t56 593.452
R5042 vss.t1123 vss.t522 593.452
R5043 vss.n456 vss.t2020 334.527
R5044 vss.n454 vss.t2025 334.527
R5045 vss.n452 vss.t2030 334.527
R5046 vss.n436 vss.n5377 592.514
R5047 vss.n434 vss.n5379 592.514
R5048 vss.n432 vss.n5381 592.514
R5049 vss.n845 vss.n6373 1731.33
R5050 vss.n4605 vss.n4283 589.125
R5051 vss.t628 vss.n448 586.514
R5052 vss.t1191 vss.n450 586.514
R5053 vss.n444 vss.t1438 586.514
R5054 vss.n440 vss.t715 586.514
R5055 vss.t585 vss.n449 586.514
R5056 vss.n441 vss.t1385 586.514
R5057 vss.n439 vss.t473 586.514
R5058 vss.t139 vss.n447 586.053
R5059 vss.t135 vss.n445 586.053
R5060 vss.n442 vss.t453 586.053
R5061 vss.n6190 vss.n6188 580.332
R5062 vss.n6172 vss.n361 579.943
R5063 vss.n6372 vss.n2325 572.519
R5064 vss.t482 vss.n1111 569.508
R5065 vss.n5422 vss.t11 540
R5066 vss.n5284 vss.n5283 537.144
R5067 vss.n5430 vss.t587 528
R5068 vss.t133 vss.n5415 528
R5069 vss.n2694 vss.n362 519.46
R5070 vss.n438 vss.n5342 514.514
R5071 vss.n5423 vss.t1434 504
R5072 vss.t446 vss.n4286 500
R5073 vss.t2082 vss.t1181 486.842
R5074 vss.n445 vss.t926 484.053
R5075 vss.n5316 vss.n5315 460.512
R5076 vss.n88 vss.n86 0.00147032
R5077 vss.n4402 vss.t244 440.789
R5078 vss.n5308 vss.n5079 435.94
R5079 vss.n5099 vss.t92 430.493
R5080 vss.t1646 vss.n513 252.065
R5081 vss.n518 vss.t1671 252.065
R5082 vss.t1620 vss.n523 252.065
R5083 vss.t1603 vss.n476 252.065
R5084 vss.t1586 vss.n472 252.065
R5085 vss.t1925 vss.n422 252.065
R5086 vss.n418 vss.t1892 252.065
R5087 vss.t1181 vss.t2122 427.632
R5088 vss.n6221 vss.n2688 427.132
R5089 vss.n2686 vss.n2049 427.132
R5090 vss.n6221 vss.n515 427.132
R5091 vss.n3792 vss.n2049 427.132
R5092 vss.n520 vss.n6221 427.132
R5093 vss.n6234 vss.n2049 427.132
R5094 vss.n6394 vss.n2317 427.132
R5095 vss.n848 vss.n365 451.396
R5096 vss.n2536 vss.n2534 427.132
R5097 vss.n2536 vss.n859 427.132
R5098 vss.n2536 vss.n865 427.132
R5099 vss.n2536 vss.n2505 427.132
R5100 vss.n875 vss.n2536 427.132
R5101 vss.n2550 vss.n2549 427.132
R5102 vss.n2550 vss.n2487 427.132
R5103 vss.n889 vss.n2550 427.132
R5104 vss.n2601 vss.n2600 427.132
R5105 vss.n899 vss.n6300 427.132
R5106 vss.n474 vss.n6242 427.132
R5107 vss.n6255 vss.n2049 427.132
R5108 vss.n6280 vss.n6279 427.132
R5109 vss.n6277 vss.n2049 427.132
R5110 vss.n6035 vss.n424 427.132
R5111 vss.n427 vss.t1945 252.041
R5112 vss.n427 vss.n3967 427.755
R5113 vss.n6035 vss.n420 427.132
R5114 vss.n6035 vss.n415 427.132
R5115 vss.n399 vss.n3871 427.132
R5116 vss.n402 vss.t1819 252.041
R5117 vss.n402 vss.n3865 427.755
R5118 vss.n394 vss.n3853 427.132
R5119 vss.n397 vss.t1797 252.041
R5120 vss.n397 vss.n3758 427.755
R5121 vss.n3853 vss.n3852 427.132
R5122 vss.n392 vss.t1780 252.041
R5123 vss.n392 vss.n3841 427.755
R5124 vss.n3853 vss.n3835 427.132
R5125 vss.n388 vss.t1763 252.041
R5126 vss.n388 vss.n3769 427.755
R5127 vss.n3853 vss.n381 427.132
R5128 vss.n384 vss.t1746 252.041
R5129 vss.n384 vss.n3822 427.755
R5130 vss.n3853 vss.n376 427.132
R5131 vss.n379 vss.t1729 252.041
R5132 vss.n379 vss.n3805 427.755
R5133 vss.n5431 vss.t2113 420
R5134 vss.t2114 vss.n5414 420
R5135 vss.n6370 vss.n850 427.132
R5136 vss.n853 vss.n852 427.132
R5137 vss.n857 vss.n856 427.132
R5138 vss.n863 vss.n862 427.132
R5139 vss.n869 vss.n868 427.132
R5140 vss.n873 vss.n872 427.132
R5141 vss.n879 vss.n878 427.132
R5142 vss.n883 vss.n882 427.132
R5143 vss.n887 vss.n886 427.132
R5144 vss.n893 vss.n892 427.132
R5145 vss.n897 vss.n896 427.132
R5146 vss.n921 vss.n2049 427.132
R5147 vss.n926 vss.n2049 427.132
R5148 vss.n931 vss.n2049 427.132
R5149 vss.n936 vss.n2049 427.132
R5150 vss.n941 vss.n2049 427.132
R5151 vss.n946 vss.n2049 427.132
R5152 vss.t220 vss.t676 403.587
R5153 vss.n447 vss.t941 400.053
R5154 vss.t903 vss.n442 400.053
R5155 vss.n2858 vss.n2857 399.757
R5156 vss.n2938 vss.n2937 399.757
R5157 vss.n6394 vss.n2318 391.445
R5158 vss.n2370 vss.t1545 391.161
R5159 vss.n5313 vss.t1955 384.231
R5160 vss.t1952 vss.n840 398.12
R5161 vss.n6006 vss.t238 362.5
R5162 vss.t2050 vss.n371 213.57
R5163 vss.n1310 vss.t87 358.745
R5164 vss.n1250 vss.t494 358.745
R5165 vss.n5290 vss.t810 358.745
R5166 vss.n4 vss.n23 0.0830315
R5167 vss.n5311 vss.n5310 354.168
R5168 vss.n5925 vss.n67 353.414
R5169 vss.n5314 vss.n1155 353.289
R5170 vss.t1282 vss.n5593 352.437
R5171 vss.t703 vss.n5585 352.437
R5172 vss.t611 vss.n5576 352.437
R5173 vss.t546 vss.n5568 352.437
R5174 vss.t634 vss.n5560 352.437
R5175 vss.n4 vss.n25 1179
R5176 vss.n451 vss.t2015 346.527
R5177 vss.n1374 vss.t85 343.349
R5178 vss.n1460 vss.t137 343.349
R5179 vss.t1870 vss.n843 341.894
R5180 vss.n6033 vss.t1872 341.894
R5181 vss.t1880 vss.n6031 341.894
R5182 vss.n5637 vss.t1199 341.668
R5183 vss.n5660 vss.t1149 341.668
R5184 vss.n5683 vss.t127 341.668
R5185 vss.n5961 vss.t9 341.668
R5186 vss.n5984 vss.t1147 341.668
R5187 vss.n5103 vss.n5099 338.565
R5188 vss.n5290 vss.n5289 338.565
R5189 vss.n845 vss.t1867 354.19
R5190 vss.n412 vss.t1875 354.652
R5191 vss.n5643 vss.t1290 337.5
R5192 vss.n5666 vss.t650 337.5
R5193 vss.n5689 vss.t711 337.5
R5194 vss.n5967 vss.t681 337.5
R5195 vss.n5990 vss.t1053 337.5
R5196 vss.n1310 vss.n1111 331.839
R5197 vss.n1250 vss.n1065 331.839
R5198 vss.t2017 vss.n458 346.526
R5199 vss.t2022 vss.n456 346.526
R5200 vss.t2027 vss.n454 346.526
R5201 vss.t2032 vss.n452 346.526
R5202 vss.t2037 vss.n436 346.514
R5203 vss.t2042 vss.n434 346.514
R5204 vss.t1324 vss.n5596 329.168
R5205 vss.t873 vss.n5588 329.168
R5206 vss.t606 vss.n5580 329.168
R5207 vss.t578 vss.n5571 329.168
R5208 vss.t1049 vss.n5563 329.168
R5209 vss.t554 vss.n5554 329.168
R5210 vss.n5312 vss.n5311 328.676
R5211 vss.n5648 vss.t2099 326.649
R5212 vss.n5671 vss.t994 326.649
R5213 vss.n5695 vss.t480 326.649
R5214 vss.n5972 vss.t548 326.649
R5215 vss.n5995 vss.t236 326.649
R5216 vss.n6011 vss.n68 322.019
R5217 vss.t875 vss.n481 319.836
R5218 vss.t0 vss.n5072 319.469
R5219 vss.n4394 vss.t155 319.445
R5220 vss.n5377 vss.t2035 318
R5221 vss.n5379 vss.t2040 318
R5222 vss.n5381 vss.t2045 318
R5223 vss.n1374 vss.n1124 317.598
R5224 vss.n1460 vss.n1051 317.598
R5225 vss.t1955 vss.n5312 314.788
R5226 vss.t882 vss.t482 313.901
R5227 vss.t449 vss.t2101 313.901
R5228 vss.t2101 vss.t881 313.901
R5229 vss.t881 vss.t129 313.901
R5230 vss.t129 vss.t5 313.901
R5231 vss.t52 vss.t220 313.901
R5232 vss.t676 vss.t608 313.901
R5233 vss.n6411 vss.n1229 309.976
R5234 vss.n5459 vss.n5458 308.752
R5235 vss.t2005 vss.n461 183.794
R5236 vss.n460 vss.n5339 308.752
R5237 vss.n4403 vss.t517 305.557
R5238 vss.n4403 vss.t534 305.557
R5239 vss.n5640 vss.n5594 305.159
R5240 vss.n5663 vss.n5586 305.159
R5241 vss.n5686 vss.n5578 305.159
R5242 vss.n5964 vss.n5569 305.159
R5243 vss.n5987 vss.n5561 305.159
R5244 vss.t2057 vss.n430 304.526
R5245 vss.n4395 vss.t20 302.084
R5246 vss.n5106 vss.t96 300.483
R5247 vss.t1203 vss.n5162 300.483
R5248 vss.n4385 vss.t509 298.611
R5249 vss.t1545 vss.n2364 296.118
R5250 vss.n4390 vss.t540 295.139
R5251 vss.n432 vss.t2057 304.514
R5252 vss.n5135 vss.t2067 287.425
R5253 vss.n6410 vss.t204 285.036
R5254 vss.n5310 vss.t1952 284.723
R5255 vss.n5121 vss.t589 284.432
R5256 vss.n5131 vss.t35 284.432
R5257 vss.t1207 vss.n5145 284.432
R5258 vss.n5153 vss.t835 284.432
R5259 vss.n5134 vss.t37 282.519
R5260 vss.n5122 vss.t591 281.67
R5261 vss.t1205 vss.n5142 281.67
R5262 vss.t248 vss.n4347 281.25
R5263 vss.n410 vss.t1872 280.87
R5264 vss.n842 vss.t1870 280.87
R5265 vss.n6032 vss.t1880 280.87
R5266 vss.t246 vss.n4365 277.779
R5267 vss.n6180 vss.n2698 276.498
R5268 vss.n6180 vss.n2697 276.498
R5269 vss.n5111 vss.t1295 275.45
R5270 vss.t1152 vss.n5161 275.45
R5271 vss.n4031 vss.t523 275.425
R5272 vss.n4055 vss.t631 275.425
R5273 vss.n4079 vss.t928 275.425
R5274 vss.n4103 vss.t1309 275.425
R5275 vss.n4127 vss.t1248 275.425
R5276 vss.n4151 vss.t1251 275.425
R5277 vss.t1277 vss.n4158 275.425
R5278 vss.t1400 vss.n5594 275.072
R5279 vss.t1397 vss.n5586 275.072
R5280 vss.t1394 vss.n5578 275.072
R5281 vss.t1393 vss.n5569 275.072
R5282 vss.t1411 vss.n5561 275.072
R5283 vss.t2020 vss.n5373 274.514
R5284 vss.t2025 vss.n5374 274.514
R5285 vss.t2030 vss.n5375 274.514
R5286 vss.t2035 vss.n5376 274.514
R5287 vss.t2040 vss.n5378 274.514
R5288 vss.t2045 vss.n5380 274.514
R5289 vss.t507 vss.n4354 274.307
R5290 vss.n5112 vss.t1297 272.688
R5291 vss.t1150 vss.n5156 272.688
R5292 vss.t1198 vss.n5117 272.455
R5293 vss.t1023 vss.n5127 272.455
R5294 vss.n5149 vss.t1041 272.455
R5295 vss.n5903 vss.n4017 271.187
R5296 vss.n5700 vss.n4019 271.187
R5297 vss.n5900 vss.n4021 271.187
R5298 vss.n5706 vss.n4029 271.187
R5299 vss.n5712 vss.n4041 271.187
R5300 vss.n5888 vss.n4043 271.187
R5301 vss.n5715 vss.n4045 271.187
R5302 vss.n5882 vss.n4053 271.187
R5303 vss.n5876 vss.n4065 271.187
R5304 vss.n5727 vss.n4067 271.187
R5305 vss.n5873 vss.n4069 271.187
R5306 vss.n5733 vss.n4077 271.187
R5307 vss.n5741 vss.n4089 271.187
R5308 vss.n5856 vss.n4091 271.187
R5309 vss.n5744 vss.n4093 271.187
R5310 vss.n5850 vss.n4101 271.187
R5311 vss.n5841 vss.n4113 271.187
R5312 vss.n5760 vss.n4115 271.187
R5313 vss.n5838 vss.n4117 271.187
R5314 vss.n5766 vss.n4125 271.187
R5315 vss.n5773 vss.n4137 271.187
R5316 vss.n5818 vss.n4139 271.187
R5317 vss.n5776 vss.n4141 271.187
R5318 vss.n5812 vss.n4149 271.187
R5319 vss.n5783 vss.n4153 271.187
R5320 vss.n5792 vss.n4163 271.187
R5321 vss.n5800 vss.n4165 271.187
R5322 vss.t149 vss.n4365 270.834
R5323 vss.n5152 vss.t1043 270.543
R5324 vss.t1196 vss.n5112 269.693
R5325 vss.t1021 vss.n5122 269.693
R5326 vss.n5140 vss.t2069 269.462
R5327 vss.n652 vss.t296 268.988
R5328 vss.t298 vss.n2858 268.988
R5329 vss.n2938 vss.t292 268.988
R5330 vss.t294 vss.n2931 268.988
R5331 vss.n6036 vss.n6035 268.762
R5332 vss.t1867 vss.n842 268.575
R5333 vss.t1877 vss.n6032 268.575
R5334 vss.t1875 vss.n410 268.575
R5335 vss.t728 vss.n4169 266.95
R5336 vss.n5154 vss.t837 266.467
R5337 vss.t975 vss.n2924 265.058
R5338 vss.t2076 vss.n2864 265.058
R5339 vss.n2928 vss.t190 264.269
R5340 vss.n2868 vss.t195 264.269
R5341 vss.n6411 vss.n6410 263.659
R5342 vss.t988 vss.n4157 262.712
R5343 vss.n5380 vss.t2042 262.514
R5344 vss.n5378 vss.t2037 262.514
R5345 vss.n5376 vss.t2032 262.514
R5346 vss.n5375 vss.t2027 262.514
R5347 vss.n5374 vss.t2022 262.514
R5348 vss.n5373 vss.t2017 262.514
R5349 vss.t2015 vss.n438 262.514
R5350 vss.t2079 vss.n4368 260.418
R5351 vss.n5075 vss.t449 260.091
R5352 vss.n4359 vss.t21 258.483
R5353 vss.n4167 vss.t455 258.476
R5354 vss.t48 vss.n5597 258.334
R5355 vss.t2135 vss.n5589 258.334
R5356 vss.t2141 vss.n5581 258.334
R5357 vss.t84 vss.n5572 258.334
R5358 vss.t2117 vss.n5564 258.334
R5359 vss.t1061 vss.t500 258.334
R5360 vss.t2120 vss.n5556 258.334
R5361 vss.n5648 vss.n5592 257.88
R5362 vss.n5671 vss.n5584 257.88
R5363 vss.n5695 vss.n5575 257.88
R5364 vss.n5972 vss.n5567 257.88
R5365 vss.n5995 vss.n5559 257.88
R5366 vss.n6040 vss.n3228 257.514
R5367 vss.n6297 vss.n6296 255.761
R5368 vss.t143 vss.n87 9.25959
R5369 vss.n5141 vss.t1395 251.498
R5370 vss.t1907 vss.n5069 251.417
R5371 vss.n2344 vss.t1882 251.417
R5372 vss.n5142 vss.t981 248.736
R5373 vss.n4240 vss.n4223 245.784
R5374 vss.n4256 vss.n4215 245.784
R5375 vss.n4231 vss.n4205 245.784
R5376 vss.n4271 vss.n4201 245.627
R5377 vss.n2688 vss.t1643 242.846
R5378 vss.t1651 vss.n2686 242.846
R5379 vss.t1666 vss.n515 242.846
R5380 vss.t1674 vss.n3792 242.846
R5381 vss.n520 vss.t1617 242.846
R5382 vss.t1625 vss.n6234 242.846
R5383 vss.n5071 vss.t1910 242.846
R5384 vss.t1885 vss.n2317 242.846
R5385 vss.n848 vss.t1814 242.846
R5386 vss.n2534 vss.t1721 242.846
R5387 vss.t1713 vss.n859 242.846
R5388 vss.t1705 vss.n865 242.846
R5389 vss.n2505 vss.t1697 242.846
R5390 vss.n875 vss.t1689 242.846
R5391 vss.n2549 vss.t1663 242.846
R5392 vss.n2487 vss.t1637 242.846
R5393 vss.n889 vss.t1578 242.846
R5394 vss.n2600 vss.t1570 242.846
R5395 vss.n899 vss.t1562 242.846
R5396 vss.n474 vss.t1600 242.846
R5397 vss.t1608 vss.n6255 242.846
R5398 vss.n6279 vss.t1583 242.846
R5399 vss.t1591 vss.n6277 242.846
R5400 vss.t1942 vss.n424 242.846
R5401 vss.t1920 vss.n420 242.846
R5402 vss.n24 vss.t1928 242.846
R5403 vss.t1887 vss.n415 242.846
R5404 vss.t1895 vss.n3938 242.846
R5405 vss.n399 vss.t1816 242.846
R5406 vss.n394 vss.t1794 242.846
R5407 vss.n3852 vss.t1777 242.846
R5408 vss.n3835 vss.t1760 242.846
R5409 vss.t1743 vss.n381 242.846
R5410 vss.t1726 vss.n376 242.846
R5411 vss.n5155 vss.t991 242.516
R5412 vss.n4237 vss.t157 242.169
R5413 vss.t162 vss.n4209 242.169
R5414 vss.n5659 vss.n5658 241.935
R5415 vss.n5682 vss.n5681 241.935
R5416 vss.n5960 vss.n5959 241.935
R5417 vss.n5983 vss.n5982 241.935
R5418 vss.n6005 vss.n6004 241.935
R5419 vss.n4278 vss.n4193 240
R5420 vss.n5156 vss.t992 239.754
R5421 vss.n4383 vss.t2078 239.583
R5422 vss.t24 vss.n4226 238.554
R5423 vss.n5904 vss.n4016 237.288
R5424 vss.n5901 vss.n4020 237.288
R5425 vss.n5702 vss.n4022 237.288
R5426 vss.n5898 vss.n4026 237.288
R5427 vss.n5705 vss.n4028 237.288
R5428 vss.n5708 vss.n4034 237.288
R5429 vss.n5892 vss.n4036 237.288
R5430 vss.n5711 vss.n4040 237.288
R5431 vss.n5714 vss.n4044 237.288
R5432 vss.n5886 vss.n4046 237.288
R5433 vss.n5717 vss.n4050 237.288
R5434 vss.n5883 vss.n4052 237.288
R5435 vss.n5880 vss.n4058 237.288
R5436 vss.n5723 vss.n4060 237.288
R5437 vss.n5877 vss.n4064 237.288
R5438 vss.n5874 vss.n4068 237.288
R5439 vss.n5729 vss.n4070 237.288
R5440 vss.n5871 vss.n4074 237.288
R5441 vss.n5732 vss.n4076 237.288
R5442 vss.n5735 vss.n4082 237.288
R5443 vss.n5865 vss.n4084 237.288
R5444 vss.n5740 vss.n4088 237.288
R5445 vss.n5743 vss.n4092 237.288
R5446 vss.n5854 vss.n4094 237.288
R5447 vss.n5746 vss.n4098 237.288
R5448 vss.n5851 vss.n4100 237.288
R5449 vss.n5848 vss.n4106 237.288
R5450 vss.n5753 vss.n4108 237.288
R5451 vss.n5842 vss.n4112 237.288
R5452 vss.n5839 vss.n4116 237.288
R5453 vss.n5762 vss.n4118 237.288
R5454 vss.n5836 vss.n4122 237.288
R5455 vss.n5765 vss.n4124 237.288
R5456 vss.n5768 vss.n4130 237.288
R5457 vss.n5827 vss.n4132 237.288
R5458 vss.n5772 vss.n4136 237.288
R5459 vss.n5775 vss.n4140 237.288
R5460 vss.n5816 vss.n4142 237.288
R5461 vss.n5778 vss.n4146 237.288
R5462 vss.n5813 vss.n4148 237.288
R5463 vss.n5810 vss.n4154 237.288
R5464 vss.n5785 vss.n4156 237.288
R5465 vss.n5804 vss.n4160 237.288
R5466 vss.n5801 vss.n4164 237.288
R5467 vss.n5796 vss.n4168 237.288
R5468 vss.n5600 vss.t664 236.29
R5469 vss.n518 vss.t1669 252.065
R5470 vss.t1811 vss.n850 251.417
R5471 vss.t1718 vss.n853 251.417
R5472 vss.n857 vss.t1710 251.417
R5473 vss.n863 vss.t1702 251.417
R5474 vss.t1694 vss.n869 251.417
R5475 vss.n873 vss.t1686 251.417
R5476 vss.t1660 vss.n879 251.417
R5477 vss.t1634 vss.n883 251.417
R5478 vss.n887 vss.t1575 251.417
R5479 vss.t1567 vss.n893 251.417
R5480 vss.n897 vss.t1559 251.417
R5481 vss.n3967 vss.t1947 235.714
R5482 vss.n422 vss.t1923 252.065
R5483 vss.n418 vss.t1890 252.065
R5484 vss.n3865 vss.t1821 235.714
R5485 vss.n3758 vss.t1799 235.714
R5486 vss.n3841 vss.t1782 235.714
R5487 vss.n3769 vss.t1765 235.714
R5488 vss.n3822 vss.t1748 235.714
R5489 vss.n3805 vss.t1731 235.714
R5490 vss.t661 vss.n4203 234.94
R5491 vss.n371 vss.n5361 235.102
R5492 vss.t1187 vss.t545 232.946
R5493 vss.n4401 vss.t685 232.639
R5494 vss.n375 vss.t1974 140.087
R5495 vss.n3894 vss.n3893 232.346
R5496 vss.n4614 vss.t637 231.885
R5497 vss.n3946 vss.n1229 231.565
R5498 vss.t986 vss.n4161 228.815
R5499 vss.t1950 vss.n916 242.846
R5500 vss.t1824 vss.n921 242.846
R5501 vss.t1802 vss.n926 242.846
R5502 vss.t1785 vss.n931 242.846
R5503 vss.t1768 vss.n936 242.846
R5504 vss.t1751 vss.n941 242.846
R5505 vss.t1734 vss.n946 242.846
R5506 vss.n271 vss.n270 206.171
R5507 vss.n1885 vss.n1570 224.825
R5508 vss.n1889 vss.n1588 224.825
R5509 vss.n1893 vss.n1566 224.825
R5510 vss.n1896 vss.n1599 224.825
R5511 vss.n1899 vss.n1558 224.825
R5512 vss.n1908 vss.n1607 224.825
R5513 vss.n1912 vss.n1546 224.825
R5514 vss.n1916 vss.n1616 224.825
R5515 vss.n1919 vss.n1542 224.825
R5516 vss.n1922 vss.n1621 224.825
R5517 vss.n1931 vss.n1531 224.825
R5518 vss.n1935 vss.n1635 224.825
R5519 vss.n1939 vss.n1527 224.825
R5520 vss.n1942 vss.n1644 224.825
R5521 vss.n1945 vss.n1519 224.825
R5522 vss.n1954 vss.n1652 224.825
R5523 vss.n1958 vss.n1512 224.825
R5524 vss.n1962 vss.n1666 224.825
R5525 vss.n1965 vss.n1508 224.825
R5526 vss.n1968 vss.n1671 224.825
R5527 vss.n1977 vss.n1497 224.825
R5528 vss.n1981 vss.n1685 224.825
R5529 vss.n1985 vss.n1493 224.825
R5530 vss.n1988 vss.n1693 224.825
R5531 vss.n1991 vss.n1490 224.825
R5532 vss.n2000 vss.n1707 224.825
R5533 vss.n2004 vss.n1483 224.825
R5534 vss.n2008 vss.n1721 224.825
R5535 vss.n2011 vss.n1479 224.825
R5536 vss.n6397 vss.n6396 224.825
R5537 vss.n2863 vss.t188 223.76
R5538 vss.t595 vss.n2859 223.76
R5539 vss.n2936 vss.t1221 223.76
R5540 vss.t187 vss.n2932 223.76
R5541 vss.n4274 vss.t641 218.825
R5542 vss.t558 vss.t242 218.825
R5543 vss.t1383 vss.n4220 216.868
R5544 vss.t1136 vss.n4014 216.102
R5545 vss.t1133 vss.n4038 216.102
R5546 vss.t1110 vss.n4062 216.102
R5547 vss.t1104 vss.n4086 216.102
R5548 vss.t1099 vss.n4110 216.102
R5549 vss.t1093 vss.n4134 216.102
R5550 vss.n916 vss.n4 1470.9
R5551 vss.n5074 vss.t461 212.014
R5552 vss.n5282 vss.t838 212.014
R5553 vss.t487 vss.n4027 211.864
R5554 vss.t234 vss.n4035 211.864
R5555 vss.t141 vss.n4051 211.864
R5556 vss.t630 vss.n4059 211.864
R5557 vss.t570 vss.n4075 211.864
R5558 vss.t568 vss.n4083 211.864
R5559 vss.t931 vss.n4099 211.864
R5560 vss.t1331 vss.n4107 211.864
R5561 vss.t1292 vss.n4123 211.864
R5562 vss.t950 vss.n4131 211.864
R5563 vss.t1175 vss.n4147 211.864
R5564 vss.t1380 vss.n4155 211.864
R5565 vss.t684 vss.n4344 211.806
R5566 vss.n6011 vss.n27 210.904
R5567 vss.n2927 vss.t974 209.756
R5568 vss.t191 vss.n2925 209.756
R5569 vss.t194 vss.n2865 209.756
R5570 vss.n2867 vss.t2077 209.756
R5571 vss.t1089 vss.t993 208.333
R5572 vss.t1101 vss.t673 208.333
R5573 vss.t1063 vss.t963 208.333
R5574 vss.t1118 vss.t934 208.333
R5575 vss.t1134 vss.t16 208.333
R5576 vss.n4 vss.n24 1470.9
R5577 vss.n4 vss.n3938 1470.9
R5578 vss.n2363 vss.t1550 205.882
R5579 vss.n5371 vss.t2047 205.666
R5580 vss.t2055 vss.n25 205.666
R5581 vss.n2355 vss.n2137 204.869
R5582 vss.n4025 vss.t1410 203.391
R5583 vss.n4049 vss.t1409 203.391
R5584 vss.n4073 vss.t1407 203.391
R5585 vss.n4097 vss.t1404 203.391
R5586 vss.n4121 vss.t1401 203.391
R5587 vss.n4145 vss.t1398 203.391
R5588 vss.t1276 vss.n4162 203.391
R5589 vss.t159 vss.n4212 202.411
R5590 vss.n510 vss.t1643 200.613
R5591 vss.n514 vss.t1666 200.613
R5592 vss.t1617 vss.n519 200.613
R5593 vss.t1600 vss.n473 200.613
R5594 vss.n469 vss.t1583 200.613
R5595 vss.n425 vss.t1942 200.613
R5596 vss.n419 vss.t1920 200.613
R5597 vss.n414 vss.t1887 200.613
R5598 vss.t1816 vss.n400 200.613
R5599 vss.t1794 vss.n395 200.613
R5600 vss.n390 vss.t1777 200.613
R5601 vss.n386 vss.t1760 200.613
R5602 vss.n382 vss.t1743 200.613
R5603 vss.n377 vss.t1726 200.613
R5604 vss.n2687 vss.t1651 200.613
R5605 vss.n3793 vss.t1674 200.613
R5606 vss.n6235 vss.t1625 200.613
R5607 vss.t1910 vss.n5070 200.613
R5608 vss.n2342 vss.t1885 200.613
R5609 vss.t1814 vss.n847 200.613
R5610 vss.t1721 vss.n2533 200.613
R5611 vss.n858 vss.t1713 200.613
R5612 vss.n864 vss.t1705 200.613
R5613 vss.t1697 vss.n2504 200.613
R5614 vss.t1689 vss.n874 200.613
R5615 vss.t1663 vss.n2548 200.613
R5616 vss.t1637 vss.n2486 200.613
R5617 vss.t1578 vss.n888 200.613
R5618 vss.t1570 vss.n2599 200.613
R5619 vss.t1562 vss.n898 200.613
R5620 vss.n6256 vss.t1608 200.613
R5621 vss.n6278 vss.t1591 200.613
R5622 vss.n3966 vss.t1950 200.613
R5623 vss.t1928 vss.n3993 200.613
R5624 vss.n3939 vss.t1895 200.613
R5625 vss.n3864 vss.t1824 200.613
R5626 vss.n3757 vss.t1802 200.613
R5627 vss.n3840 vss.t1785 200.613
R5628 vss.n3768 vss.t1768 200.613
R5629 vss.n3821 vss.t1751 200.613
R5630 vss.n3804 vss.t1734 200.613
R5631 vss.n2585 vss.n194 200.518
R5632 vss.n2747 vss.n2689 199.791
R5633 vss.t1121 vss.n4018 199.154
R5634 vss.t1126 vss.n4042 199.154
R5635 vss.t1116 vss.n4066 199.154
R5636 vss.t1102 vss.n4090 199.154
R5637 vss.t1097 vss.n4114 199.154
R5638 vss.t1071 vss.n4138 199.154
R5639 vss.n4207 vss.t1180 198.796
R5640 vss.t905 vss.n2698 198.157
R5641 vss.t192 vss.n2697 198.157
R5642 vss.t2052 vss.n5367 197.369
R5643 vss.n6394 vss.n6393 196.99
R5644 vss.n6035 vss.n404 196.99
R5645 vss.n3916 vss.n408 14.4987
R5646 vss.n1878 vss.n1574 196.721
R5647 vss.n1881 vss.n1578 196.721
R5648 vss.n1884 vss.n1571 196.721
R5649 vss.n1888 vss.n1587 196.721
R5650 vss.n1892 vss.n1567 196.721
R5651 vss.n1901 vss.n1601 196.721
R5652 vss.n1904 vss.n1555 196.721
R5653 vss.n1907 vss.n1606 196.721
R5654 vss.n1911 vss.n1552 196.721
R5655 vss.n1915 vss.n1615 196.721
R5656 vss.n1924 vss.n1540 196.721
R5657 vss.n1927 vss.n1629 196.721
R5658 vss.n1930 vss.n1532 196.721
R5659 vss.n1934 vss.n1632 196.721
R5660 vss.n1938 vss.n1528 196.721
R5661 vss.n1947 vss.n1646 196.721
R5662 vss.n1950 vss.n1516 196.721
R5663 vss.n1953 vss.n1651 196.721
R5664 vss.n1957 vss.n1513 196.721
R5665 vss.n1961 vss.n1665 196.721
R5666 vss.n1970 vss.n1506 196.721
R5667 vss.n1973 vss.n1679 196.721
R5668 vss.n1976 vss.n1498 196.721
R5669 vss.n1980 vss.n1682 196.721
R5670 vss.n1984 vss.n1494 196.721
R5671 vss.n1993 vss.n1701 196.721
R5672 vss.n1996 vss.n1487 196.721
R5673 vss.n1999 vss.n1706 196.721
R5674 vss.n2003 vss.n1484 196.721
R5675 vss.n2007 vss.n1720 196.721
R5676 vss.n2586 vss.n2050 193.879
R5677 vss.n2587 vss.n2051 193.879
R5678 vss.n2588 vss.n2052 193.879
R5679 vss.n2589 vss.n2053 193.879
R5680 vss.n2590 vss.n2054 193.879
R5681 vss.n2603 vss.n2056 193.879
R5682 vss.n2604 vss.n2057 193.879
R5683 vss.n2605 vss.n2058 193.879
R5684 vss.n2606 vss.n2059 193.879
R5685 vss.n2607 vss.n2060 193.879
R5686 vss.n2608 vss.n2061 193.879
R5687 vss.n2609 vss.n2062 193.879
R5688 vss.n2610 vss.n2063 193.879
R5689 vss.n2611 vss.n2064 193.879
R5690 vss.n2612 vss.n2065 193.879
R5691 vss.n2613 vss.n2066 193.879
R5692 vss.n2614 vss.n2067 193.879
R5693 vss.n2615 vss.n2068 193.879
R5694 vss.n2616 vss.n2069 193.879
R5695 vss.n2617 vss.n2070 193.879
R5696 vss.n2618 vss.n2071 193.879
R5697 vss.n2619 vss.n2072 193.879
R5698 vss.n2620 vss.n2073 193.879
R5699 vss.n2621 vss.n2074 193.879
R5700 vss.n2622 vss.n2075 193.879
R5701 vss.n2623 vss.n2077 193.879
R5702 vss.n2624 vss.n2078 193.879
R5703 vss.n2625 vss.n2079 193.879
R5704 vss.n2626 vss.n2080 193.879
R5705 vss.n2627 vss.n2081 193.879
R5706 vss.n2628 vss.n2082 193.879
R5707 vss.n2629 vss.n2083 193.879
R5708 vss.n2630 vss.n2084 193.879
R5709 vss.n2631 vss.n2085 193.879
R5710 vss.n2632 vss.n2086 193.879
R5711 vss.n2633 vss.n2087 193.879
R5712 vss.n2634 vss.n2088 193.879
R5713 vss.n2635 vss.n2089 193.879
R5714 vss.n6298 vss.n2090 193.879
R5715 vss.n2637 vss.n2099 193.879
R5716 vss.n2638 vss.n2100 193.879
R5717 vss.n2639 vss.n2101 193.879
R5718 vss.n2640 vss.n2102 193.879
R5719 vss.n2641 vss.n2103 193.879
R5720 vss.n2643 vss.n2105 193.879
R5721 vss.n2644 vss.n2106 193.879
R5722 vss.n2645 vss.n2107 193.879
R5723 vss.n2646 vss.n2108 193.879
R5724 vss.n2647 vss.n2109 193.879
R5725 vss.n2648 vss.n2110 193.879
R5726 vss.n2649 vss.n2111 193.879
R5727 vss.n2650 vss.n2112 193.879
R5728 vss.n2651 vss.n2113 193.879
R5729 vss.n2652 vss.n2114 193.879
R5730 vss.n2653 vss.n2115 193.879
R5731 vss.n2654 vss.n2116 193.879
R5732 vss.n2655 vss.n2117 193.879
R5733 vss.n2656 vss.n2118 193.879
R5734 vss.n2657 vss.n2119 193.879
R5735 vss.n2658 vss.n2120 193.879
R5736 vss.n2659 vss.n2121 193.879
R5737 vss.n2660 vss.n2122 193.879
R5738 vss.n2661 vss.n2123 193.879
R5739 vss.n2662 vss.n2124 193.879
R5740 vss.n6282 vss.n2126 193.879
R5741 vss.n6283 vss.n2127 193.879
R5742 vss.n6284 vss.n2128 193.879
R5743 vss.n6285 vss.n2129 193.879
R5744 vss.n6286 vss.n2130 193.879
R5745 vss.n6287 vss.n2131 193.879
R5746 vss.n6288 vss.n2132 193.879
R5747 vss.n6289 vss.n2133 193.879
R5748 vss.n6290 vss.n2134 193.879
R5749 vss.n6291 vss.n2135 193.879
R5750 vss.n6292 vss.n2136 193.879
R5751 vss.t1450 vss.n1592 193.208
R5752 vss.t1465 vss.n1544 193.208
R5753 vss.t1480 vss.n1637 193.208
R5754 vss.t1495 vss.n1510 193.208
R5755 vss.t1510 vss.n1687 193.208
R5756 vss.t1525 vss.n1481 193.208
R5757 vss.n185 vss.t792 192.99
R5758 vss.t1648 vss.n2687 192.042
R5759 vss.t1671 vss.n3793 192.042
R5760 vss.t1622 vss.n6235 192.042
R5761 vss.n5070 vss.t1907 192.042
R5762 vss.n2342 vss.t1882 192.042
R5763 vss.n847 vss.t1811 192.042
R5764 vss.n2533 vss.t1718 192.042
R5765 vss.t1710 vss.n858 192.042
R5766 vss.t1702 vss.n864 192.042
R5767 vss.n2504 vss.t1694 192.042
R5768 vss.t1686 vss.n874 192.042
R5769 vss.n2548 vss.t1660 192.042
R5770 vss.n2486 vss.t1634 192.042
R5771 vss.t1575 vss.n888 192.042
R5772 vss.n2599 vss.t1567 192.042
R5773 vss.t1559 vss.n898 192.042
R5774 vss.t1605 vss.n6256 192.042
R5775 vss.t1588 vss.n6278 192.042
R5776 vss.t1947 vss.n3966 192.042
R5777 vss.n3993 vss.t1925 192.042
R5778 vss.t1892 vss.n3939 192.042
R5779 vss.t1821 vss.n3864 192.042
R5780 vss.t1799 vss.n3757 192.042
R5781 vss.t1782 vss.n3840 192.042
R5782 vss.t1765 vss.n3768 192.042
R5783 vss.t1748 vss.n3821 192.042
R5784 vss.t1731 vss.n3804 192.042
R5785 vss.t1646 vss.n510 192.041
R5786 vss.t1669 vss.n514 192.041
R5787 vss.t1620 vss.n519 192.041
R5788 vss.t1603 vss.n473 192.041
R5789 vss.t1586 vss.n469 192.041
R5790 vss.n425 vss.t1945 192.041
R5791 vss.n419 vss.t1923 192.041
R5792 vss.t1890 vss.n414 192.041
R5793 vss.n400 vss.t1819 192.041
R5794 vss.n395 vss.t1797 192.041
R5795 vss.n390 vss.t1780 192.041
R5796 vss.n386 vss.t1763 192.041
R5797 vss.n382 vss.t1746 192.041
R5798 vss.n377 vss.t1729 192.041
R5799 vss.t941 vss.n5431 192
R5800 vss.n5414 vss.t903 192
R5801 vss.n2602 vss.n2601 190.476
R5802 vss.n6300 vss.n6299 190.476
R5803 vss.n6242 vss.n2642 190.476
R5804 vss.n6281 vss.n6280 190.476
R5805 vss.n5041 vss.n5037 190.231
R5806 vss.n5925 vss.n27 190.078
R5807 vss.n4607 vss.n4190 188.406
R5808 vss.n4242 vss.n4228 187.952
R5809 vss.n4245 vss.n4224 187.952
R5810 vss.n4239 vss.n4222 187.952
R5811 vss.n4261 vss.n4214 187.952
R5812 vss.n4233 vss.n4210 187.952
R5813 vss.n4268 vss.n4208 187.952
R5814 vss.n4230 vss.n4204 187.952
R5815 vss.n4615 vss.n4202 187.952
R5816 vss.n5524 vss.t1348 187.097
R5817 vss.t1443 vss.n1585 186.184
R5818 vss.t1458 vss.n1554 186.184
R5819 vss.t1473 vss.n1630 186.184
R5820 vss.t1488 vss.n1515 186.184
R5821 vss.t1503 vss.n1680 186.184
R5822 vss.t1518 vss.n1486 186.184
R5823 vss.n5927 vss.n67 185.638
R5824 vss.t1024 vss.t559 184.175
R5825 vss.t669 vss.t602 184.175
R5826 vss.t130 vss.t2103 184.175
R5827 vss.t549 vss.t145 184.175
R5828 vss.t17 vss.t147 184.175
R5829 vss.t537 vss.t442 184.029
R5830 vss.t686 vss.t2098 184.029
R5831 vss.n4984 vss.n4802 183.871
R5832 vss.n4983 vss.n4801 183.871
R5833 vss.n4982 vss.n4800 183.871
R5834 vss.n4981 vss.n4799 183.871
R5835 vss.n4980 vss.n4798 183.871
R5836 vss.n4979 vss.n4797 183.871
R5837 vss.n4978 vss.n4796 183.871
R5838 vss.n4977 vss.n4795 183.871
R5839 vss.n4976 vss.n4794 183.871
R5840 vss.n4975 vss.n4793 183.871
R5841 vss.n4974 vss.n4792 183.871
R5842 vss.n4973 vss.n4791 183.871
R5843 vss.n4972 vss.n4790 183.871
R5844 vss.n4971 vss.n4789 183.871
R5845 vss.n4970 vss.n4788 183.871
R5846 vss.n4969 vss.n4787 183.871
R5847 vss.n4968 vss.n4786 183.871
R5848 vss.n4967 vss.n4785 183.871
R5849 vss.n4966 vss.n4784 183.871
R5850 vss.n4965 vss.n4783 183.871
R5851 vss.n4964 vss.n4782 183.871
R5852 vss.n4963 vss.n4781 183.871
R5853 vss.n4962 vss.n4780 183.871
R5854 vss.n4961 vss.n4779 183.871
R5855 vss.n4960 vss.n4778 183.871
R5856 vss.n4959 vss.n4777 183.871
R5857 vss.n4958 vss.n4776 183.871
R5858 vss.n4957 vss.n4775 183.871
R5859 vss.n4956 vss.n4774 183.871
R5860 vss.n4955 vss.n4773 183.871
R5861 vss.n4954 vss.n4772 183.871
R5862 vss.n4953 vss.n4771 183.871
R5863 vss.n4952 vss.n4770 183.871
R5864 vss.n4951 vss.n4769 183.871
R5865 vss.n4950 vss.n4768 183.871
R5866 vss.n4949 vss.n4767 183.871
R5867 vss.n4948 vss.n4766 183.871
R5868 vss.n4947 vss.n4765 183.871
R5869 vss.n4946 vss.n4764 183.871
R5870 vss.n4945 vss.n4763 183.871
R5871 vss.n4944 vss.n4762 183.871
R5872 vss.n4943 vss.n4761 183.871
R5873 vss.n4942 vss.n4760 183.871
R5874 vss.n4941 vss.n4759 183.871
R5875 vss.n4939 vss.n4757 183.871
R5876 vss.n4938 vss.n4756 183.871
R5877 vss.n4937 vss.n4755 183.871
R5878 vss.n4936 vss.n4754 183.871
R5879 vss.n4935 vss.n4753 183.871
R5880 vss.n4934 vss.n4752 183.871
R5881 vss.n4933 vss.n4751 183.871
R5882 vss.n4932 vss.n4750 183.871
R5883 vss.n4931 vss.n4749 183.871
R5884 vss.n4930 vss.n4748 183.871
R5885 vss.n4929 vss.n4747 183.871
R5886 vss.n4928 vss.n4746 183.871
R5887 vss.n4927 vss.n4745 183.871
R5888 vss.n4926 vss.n4744 183.871
R5889 vss.n4925 vss.n4743 183.871
R5890 vss.n4924 vss.n4742 183.871
R5891 vss.n4923 vss.n4741 183.871
R5892 vss.n4922 vss.n4740 183.871
R5893 vss.n4921 vss.n4739 183.871
R5894 vss.n4920 vss.n4738 183.871
R5895 vss.n4919 vss.n4737 183.871
R5896 vss.n4918 vss.n4736 183.871
R5897 vss.n4917 vss.n4735 183.871
R5898 vss.n4916 vss.n4734 183.871
R5899 vss.n4915 vss.n4733 183.871
R5900 vss.n4914 vss.n4732 183.871
R5901 vss.n4913 vss.n4731 183.871
R5902 vss.n4912 vss.n4730 183.871
R5903 vss.n4910 vss.n4728 183.871
R5904 vss.n4909 vss.n4727 183.871
R5905 vss.n4908 vss.n4726 183.871
R5906 vss.n4907 vss.n4725 183.871
R5907 vss.n4906 vss.n4724 183.871
R5908 vss.n4905 vss.n4723 183.871
R5909 vss.n4904 vss.n4722 183.871
R5910 vss.n4903 vss.n4721 183.871
R5911 vss.n4902 vss.n4720 183.871
R5912 vss.n4901 vss.n4719 183.871
R5913 vss.n4900 vss.n4718 183.871
R5914 vss.n4899 vss.n4717 183.871
R5915 vss.n4898 vss.n4716 183.871
R5916 vss.n4897 vss.n4715 183.871
R5917 vss.n4896 vss.n4714 183.871
R5918 vss.n4895 vss.n4713 183.871
R5919 vss.n4894 vss.n4712 183.871
R5920 vss.n4893 vss.n4710 183.871
R5921 vss.n4892 vss.n4709 183.871
R5922 vss.n4891 vss.n4708 183.871
R5923 vss.n4890 vss.n4707 183.871
R5924 vss.n4889 vss.n4706 183.871
R5925 vss.n4888 vss.n4705 183.871
R5926 vss.n4887 vss.n4704 183.871
R5927 vss.n4886 vss.n4703 183.871
R5928 vss.n4885 vss.n4702 183.871
R5929 vss.n4884 vss.n4701 183.871
R5930 vss.n4882 vss.n4699 183.871
R5931 vss.n4881 vss.n4698 183.871
R5932 vss.n4880 vss.n4697 183.871
R5933 vss.n4879 vss.n4696 183.871
R5934 vss.n4878 vss.n4695 183.871
R5935 vss.n4877 vss.n4694 183.871
R5936 vss.n4876 vss.n4693 183.871
R5937 vss.n4875 vss.n4692 183.871
R5938 vss.n4874 vss.n4691 183.871
R5939 vss.n4873 vss.n4690 183.871
R5940 vss.n4872 vss.n4689 183.871
R5941 vss.n4871 vss.n4688 183.871
R5942 vss.n4870 vss.n4687 183.871
R5943 vss.n4869 vss.n4686 183.871
R5944 vss.n4868 vss.n4685 183.871
R5945 vss.n4867 vss.n4684 183.871
R5946 vss.n4866 vss.n4683 183.871
R5947 vss.n4865 vss.n4682 183.871
R5948 vss.n4864 vss.n4681 183.871
R5949 vss.n4863 vss.n4680 183.871
R5950 vss.n4862 vss.n4679 183.871
R5951 vss.n4861 vss.n4678 183.871
R5952 vss.n4860 vss.n4677 183.871
R5953 vss.n4859 vss.n4676 183.871
R5954 vss.n4858 vss.n4675 183.871
R5955 vss.n4857 vss.n4674 183.871
R5956 vss.n4856 vss.n4673 183.871
R5957 vss.n4855 vss.n4672 183.871
R5958 vss.n4853 vss.n4670 183.871
R5959 vss.n4852 vss.n4669 183.871
R5960 vss.n4851 vss.n4668 183.871
R5961 vss.n4850 vss.n4667 183.871
R5962 vss.n4849 vss.n4666 183.871
R5963 vss.n4848 vss.n4665 183.871
R5964 vss.n4847 vss.n4664 183.871
R5965 vss.n4846 vss.n4663 183.871
R5966 vss.n4845 vss.n4662 183.871
R5967 vss.n4844 vss.n4661 183.871
R5968 vss.n4843 vss.n4660 183.871
R5969 vss.n4842 vss.n4659 183.871
R5970 vss.n4841 vss.n4658 183.871
R5971 vss.n4840 vss.n4657 183.871
R5972 vss.n4839 vss.n4656 183.871
R5973 vss.n4838 vss.n4655 183.871
R5974 vss.n4837 vss.n4654 183.871
R5975 vss.n4836 vss.n4653 183.871
R5976 vss.n4835 vss.n4652 183.871
R5977 vss.n4834 vss.n4651 183.871
R5978 vss.n4833 vss.n4650 183.871
R5979 vss.n4832 vss.n4649 183.871
R5980 vss.n4831 vss.n4648 183.871
R5981 vss.n4830 vss.n4647 183.871
R5982 vss.n4829 vss.n4646 183.871
R5983 vss.n4828 vss.n4645 183.871
R5984 vss.n4827 vss.n4644 183.871
R5985 vss.n4826 vss.n4643 183.871
R5986 vss.t180 vss.n4642 183.871
R5987 vss.n4825 vss.n4641 183.871
R5988 vss.n4824 vss.n4640 183.871
R5989 vss.n4823 vss.n4639 183.871
R5990 vss.n4822 vss.n4638 183.871
R5991 vss.n4821 vss.n4637 183.871
R5992 vss.n4820 vss.n4636 183.871
R5993 vss.n4819 vss.n4635 183.871
R5994 vss.n4818 vss.n4634 183.871
R5995 vss.n4817 vss.n4633 183.871
R5996 vss.n4816 vss.n4632 183.871
R5997 vss.n4815 vss.n4631 183.871
R5998 vss.n4814 vss.n4630 183.871
R5999 vss.n4813 vss.n4629 183.871
R6000 vss.n4812 vss.n4628 183.871
R6001 vss.n4810 vss.n4626 183.871
R6002 vss.n4809 vss.n4625 183.871
R6003 vss.n4808 vss.n4624 183.871
R6004 vss.t1995 vss.n464 183.796
R6005 vss.n4273 vss.n4200 183.53
R6006 vss.n4277 vss.n4196 183.53
R6007 vss.n4282 vss.n4192 183.53
R6008 vss.n5923 vss.n5703 182.203
R6009 vss.n5920 vss.n5885 182.203
R6010 vss.n5917 vss.n5730 182.203
R6011 vss.n5914 vss.n5853 182.203
R6012 vss.n5911 vss.n5763 182.203
R6013 vss.n5908 vss.n5815 182.203
R6014 vss.n5496 vss.n84 180.429
R6015 vss.n464 vss.t1997 177.696
R6016 vss.n2862 vss.t594 177.606
R6017 vss.t189 vss.n2860 177.606
R6018 vss.n2935 vss.t186 177.606
R6019 vss.t1222 vss.n2933 177.606
R6020 vss.n273 vss.t751 174.462
R6021 vss.n2467 vss.n527 173.439
R6022 vss.n6023 vss.n6022 170.969
R6023 vss.n368 vss.t2047 170.508
R6024 vss.n367 vss.t2055 170.507
R6025 vss.n5701 vss.n4020 169.493
R6026 vss.n5704 vss.n4026 169.493
R6027 vss.n5896 vss.n4028 169.493
R6028 vss.n5710 vss.n4036 169.493
R6029 vss.n5887 vss.n4044 169.493
R6030 vss.n5884 vss.n4050 169.493
R6031 vss.n5719 vss.n4052 169.493
R6032 vss.n5878 vss.n4060 169.493
R6033 vss.n5728 vss.n4068 169.493
R6034 vss.n5731 vss.n4074 169.493
R6035 vss.n5869 vss.n4076 169.493
R6036 vss.n5739 vss.n4084 169.493
R6037 vss.n5855 vss.n4092 169.493
R6038 vss.n5852 vss.n4098 169.493
R6039 vss.n5748 vss.n4100 169.493
R6040 vss.n5843 vss.n4108 169.493
R6041 vss.n5761 vss.n4116 169.493
R6042 vss.n5764 vss.n4122 169.493
R6043 vss.n5834 vss.n4124 169.493
R6044 vss.n5771 vss.n4132 169.493
R6045 vss.n5817 vss.n4140 169.493
R6046 vss.n5814 vss.n4146 169.493
R6047 vss.n5780 vss.n4148 169.493
R6048 vss.n5805 vss.n4156 169.493
R6049 vss.n5788 vss.n4160 169.493
R6050 vss.n5802 vss.n4162 169.493
R6051 vss.n5793 vss.n4164 169.493
R6052 vss.n5799 vss.n4168 169.493
R6053 vss.t2000 vss.n5339 167.684
R6054 vss.t2010 vss.n5459 167.684
R6055 vss.t805 vss.n5597 166.667
R6056 vss.t560 vss.n5589 166.667
R6057 vss.t603 vss.n5581 166.667
R6058 vss.t2104 vss.n5572 166.667
R6059 vss.t146 vss.n5564 166.667
R6060 vss.t148 vss.n5556 166.667
R6061 vss.n2364 vss.n2363 166.571
R6062 vss.t1195 vss.n4013 165.255
R6063 vss.n5922 vss.n5894 165.255
R6064 vss.t1178 vss.n4037 165.255
R6065 vss.n5919 vss.n5721 165.255
R6066 vss.t659 vss.n4061 165.255
R6067 vss.n5916 vss.n5867 165.255
R6068 vss.t702 vss.n4085 165.255
R6069 vss.n5913 vss.n5751 165.255
R6070 vss.t1228 vss.n4109 165.255
R6071 vss.n5910 vss.n5829 165.255
R6072 vss.t985 vss.n4133 165.255
R6073 vss.t1445 vss.n1886 165.106
R6074 vss.t1460 vss.n1909 165.106
R6075 vss.t1475 vss.n1932 165.106
R6076 vss.t1490 vss.n1955 165.106
R6077 vss.t1505 vss.n1978 165.106
R6078 vss.t1520 vss.n2001 165.106
R6079 vss.n5023 vss.n5022 164.517
R6080 vss.n367 vss.t2052 163.332
R6081 vss.t2050 vss.n368 163.331
R6082 vss.t501 vss.t250 163.195
R6083 vss.t151 vss.t502 163.195
R6084 vss.n467 vss.t1990 99.9974
R6085 vss.n4252 vss.t1419 162.651
R6086 vss.t5 vss.t462 161.435
R6087 vss.n4613 vss.n4190 159.421
R6088 vss.n4616 vss.n4228 159.036
R6089 vss.n4250 vss.n4222 159.036
R6090 vss.n4238 vss.n4218 159.036
R6091 vss.n4255 vss.n4216 159.036
R6092 vss.n4235 vss.n4214 159.036
R6093 vss.n4262 vss.n4210 159.036
R6094 vss.n4232 vss.n4208 159.036
R6095 vss.n4269 vss.n4204 159.036
R6096 vss.n2550 vss.n288 158.825
R6097 vss.n6221 vss.n6220 158.825
R6098 vss.n2448 vss.n1859 157.895
R6099 vss.n2442 vss.n1863 157.895
R6100 vss.n2461 vss.n1872 157.895
R6101 vss.n2436 vss.n1875 157.895
R6102 vss.n822 vss.t48 157.335
R6103 vss.n816 vss.t2135 157.335
R6104 vss.n810 vss.t2141 157.335
R6105 vss.n804 vss.t84 157.335
R6106 vss.n798 vss.t2117 157.335
R6107 vss.n482 vss.t2120 157.335
R6108 vss.t2113 vss.n5430 156
R6109 vss.n5415 vss.t2114 156
R6110 vss.n4272 vss.n4200 155.294
R6111 vss.n4276 vss.n4196 155.294
R6112 vss.n4279 vss.n4192 155.294
R6113 vss.n4940 vss.t172 154.839
R6114 vss.n5521 vss.n4623 154.839
R6115 vss.n5522 vss.n4623 154.839
R6116 vss.n5519 vss.n4620 154.839
R6117 vss.n6022 vss.n3997 154.839
R6118 vss.t974 vss.n2926 154.458
R6119 vss.n2926 vss.t191 154.458
R6120 vss.n2866 vss.t194 154.458
R6121 vss.t2077 vss.n2866 154.458
R6122 vss.n2636 vss.n2091 153.061
R6123 vss.t1218 vss.n4351 152.779
R6124 vss.t462 vss.t52 152.466
R6125 vss.n4234 vss.t161 151.808
R6126 vss.t2122 vss.t446 151.316
R6127 vss.t1453 vss.n1559 151.054
R6128 vss.t1468 vss.n1618 151.054
R6129 vss.t1483 vss.n1520 151.054
R6130 vss.t1498 vss.n1668 151.054
R6131 vss.t1513 vss.n1491 151.054
R6132 vss.t1528 vss.n1723 151.054
R6133 vss.t1213 vss.t805 150
R6134 vss.n5600 vss.n5598 150
R6135 vss.t696 vss.t560 150
R6136 vss.n5659 vss.n5590 150
R6137 vss.t713 vss.t603 150
R6138 vss.n5682 vss.n5582 150
R6139 vss.t947 vss.t2104 150
R6140 vss.n5960 vss.n5573 150
R6141 vss.t1144 vss.t146 150
R6142 vss.n5983 vss.n5565 150
R6143 vss.n6005 vss.n5557 150
R6144 vss.n2924 vss.t905 149.851
R6145 vss.n2864 vss.t192 149.851
R6146 vss.t502 vss.n4361 149.306
R6147 vss.t2125 vss.n4621 148.387
R6148 vss.t1130 vss.n4032 148.305
R6149 vss.t1119 vss.n4056 148.305
R6150 vss.t1113 vss.n4080 148.305
R6151 vss.t1077 vss.n4104 148.305
R6152 vss.t1085 vss.n4128 148.305
R6153 vss.t1083 vss.n4152 148.305
R6154 vss.t2007 vss.n5460 147.167
R6155 vss.t2002 vss.n459 147.167
R6156 vss.t1997 vss.n465 147.166
R6157 vss.n6031 vss.n4 2062.4
R6158 vss.n5076 vss.n1124 145.923
R6159 vss.n5285 vss.n1051 145.923
R6160 vss.t442 vss.n3994 145.833
R6161 vss.t178 vss.n4671 145.161
R6162 vss.t1440 vss.n1573 144.029
R6163 vss.t1455 vss.n1602 144.029
R6164 vss.t1470 vss.n1539 144.029
R6165 vss.t1485 vss.n1647 144.029
R6166 vss.t1500 vss.n1505 144.029
R6167 vss.t1515 vss.n1702 144.029
R6168 vss.n5021 vss.n1035 143.709
R6169 vss.n5265 vss.n3228 143.498
R6170 vss.n2363 vss.t1548 143.183
R6171 vss.t535 vss.n4344 142.362
R6172 vss.t1069 vss.t699 141.667
R6173 vss.t1100 vss.t1291 141.667
R6174 vss.t1059 vss.t2100 141.667
R6175 vss.t1060 vss.t227 141.667
R6176 vss.t1125 vss.t1159 141.667
R6177 vss.n465 vss.t2000 141.069
R6178 vss.n463 vss.t1995 141.067
R6179 vss.t2005 vss.n459 141.067
R6180 vss.n5460 vss.t2010 141.067
R6181 vss.n5306 vss.n5305 141.005
R6182 vss.n1878 vss.n1575 140.516
R6183 vss.n1881 vss.n1572 140.516
R6184 vss.n1884 vss.n1586 140.516
R6185 vss.n1888 vss.n1568 140.516
R6186 vss.n1892 vss.n1591 140.516
R6187 vss.n1895 vss.n1565 140.516
R6188 vss.n1898 vss.n1600 140.516
R6189 vss.n1901 vss.n1557 140.516
R6190 vss.n1904 vss.n1603 140.516
R6191 vss.n1907 vss.n1553 140.516
R6192 vss.n1911 vss.n1614 140.516
R6193 vss.n1915 vss.n1545 140.516
R6194 vss.n1918 vss.n1617 140.516
R6195 vss.n1921 vss.n1541 140.516
R6196 vss.n1924 vss.n1622 140.516
R6197 vss.n1927 vss.n1533 140.516
R6198 vss.n1930 vss.n1631 140.516
R6199 vss.n1934 vss.n1529 140.516
R6200 vss.n1938 vss.n1636 140.516
R6201 vss.n1941 vss.n1526 140.516
R6202 vss.n1944 vss.n1645 140.516
R6203 vss.n1947 vss.n1518 140.516
R6204 vss.n1950 vss.n1650 140.516
R6205 vss.n1953 vss.n1514 140.516
R6206 vss.n1957 vss.n1658 140.516
R6207 vss.n1961 vss.n1511 140.516
R6208 vss.n1964 vss.n1667 140.516
R6209 vss.n1967 vss.n1507 140.516
R6210 vss.n1970 vss.n1672 140.516
R6211 vss.n1973 vss.n1499 140.516
R6212 vss.n1976 vss.n1681 140.516
R6213 vss.n1980 vss.n1495 140.516
R6214 vss.n1984 vss.n1686 140.516
R6215 vss.n1987 vss.n1492 140.516
R6216 vss.n1990 vss.n1700 140.516
R6217 vss.n1993 vss.n1489 140.516
R6218 vss.n1996 vss.n1705 140.516
R6219 vss.n1999 vss.n1485 140.516
R6220 vss.n2003 vss.n1713 140.516
R6221 vss.n2007 vss.n1482 140.516
R6222 vss.n2010 vss.n1722 140.516
R6223 vss.n2013 vss.n1478 140.516
R6224 vss.n3955 vss.n4 825.942
R6225 vss.t1964 vss.n5042 138.944
R6226 vss.n5647 vss.t1400 137.536
R6227 vss.n5670 vss.t1397 137.536
R6228 vss.n5694 vss.t1394 137.536
R6229 vss.n5971 vss.t1393 137.536
R6230 vss.n5994 vss.t1411 137.536
R6231 vss.t1179 vss.t148 137.5
R6232 vss.n4241 vss.t688 137.35
R6233 vss.n2774 vss.n2718 136.674
R6234 vss.n2772 vss.n2717 136.674
R6235 vss.n2772 vss.n2736 136.674
R6236 vss.n2770 vss.n2737 136.674
R6237 vss.n5698 vss.n4017 135.594
R6238 vss.n5902 vss.n4019 135.594
R6239 vss.n5701 vss.n4021 135.594
R6240 vss.n5899 vss.n4023 135.594
R6241 vss.n5704 vss.n4027 135.594
R6242 vss.n5896 vss.n4029 135.594
R6243 vss.n5707 vss.n4033 135.594
R6244 vss.n5893 vss.n4035 135.594
R6245 vss.n5710 vss.n4037 135.594
R6246 vss.n5890 vss.n4041 135.594
R6247 vss.n5713 vss.n4043 135.594
R6248 vss.n5887 vss.n4045 135.594
R6249 vss.n5716 vss.n4047 135.594
R6250 vss.n5884 vss.n4051 135.594
R6251 vss.n5719 vss.n4053 135.594
R6252 vss.n5881 vss.n4057 135.594
R6253 vss.n5722 vss.n4059 135.594
R6254 vss.n5878 vss.n4061 135.594
R6255 vss.n5725 vss.n4065 135.594
R6256 vss.n5875 vss.n4067 135.594
R6257 vss.n5728 vss.n4069 135.594
R6258 vss.n5872 vss.n4071 135.594
R6259 vss.n5731 vss.n4075 135.594
R6260 vss.n5869 vss.n4077 135.594
R6261 vss.n5734 vss.n4081 135.594
R6262 vss.n5866 vss.n4083 135.594
R6263 vss.n5739 vss.n4085 135.594
R6264 vss.n5863 vss.n4089 135.594
R6265 vss.n5742 vss.n4091 135.594
R6266 vss.n5855 vss.n4093 135.594
R6267 vss.n5745 vss.n4095 135.594
R6268 vss.n5852 vss.n4099 135.594
R6269 vss.n5748 vss.n4101 135.594
R6270 vss.n5849 vss.n4105 135.594
R6271 vss.n5752 vss.n4107 135.594
R6272 vss.n5843 vss.n4109 135.594
R6273 vss.n5755 vss.n4113 135.594
R6274 vss.n5840 vss.n4115 135.594
R6275 vss.n5761 vss.n4117 135.594
R6276 vss.n5837 vss.n4119 135.594
R6277 vss.n5764 vss.n4123 135.594
R6278 vss.n5834 vss.n4125 135.594
R6279 vss.n5767 vss.n4129 135.594
R6280 vss.n5828 vss.n4131 135.594
R6281 vss.n5771 vss.n4133 135.594
R6282 vss.n5825 vss.n4137 135.594
R6283 vss.n5774 vss.n4139 135.594
R6284 vss.n5817 vss.n4141 135.594
R6285 vss.n5777 vss.n4143 135.594
R6286 vss.n5814 vss.n4147 135.594
R6287 vss.n5780 vss.n4149 135.594
R6288 vss.n5811 vss.n4153 135.594
R6289 vss.n5784 vss.n4155 135.594
R6290 vss.n5805 vss.n4157 135.594
R6291 vss.n5788 vss.n4161 135.594
R6292 vss.n5799 vss.n4169 135.594
R6293 vss.n463 vss.n5474 134.971
R6294 vss.n3946 vss.t1969 134.425
R6295 vss.t1977 vss.n3955 134.425
R6296 vss.t1967 vss.n5316 134.425
R6297 vss.n4811 vss.t439 132.258
R6298 vss.t594 vss.n2861 131.452
R6299 vss.n2861 vss.t189 131.452
R6300 vss.t186 vss.n2934 131.452
R6301 vss.n2934 vss.t1222 131.452
R6302 vss.n3894 vss.n4 131.194
R6303 vss.t559 vss.t2133 130.97
R6304 vss.t602 vss.t2139 130.97
R6305 vss.t2103 vss.t81 130.97
R6306 vss.t145 vss.t2115 130.97
R6307 vss.t147 vss.t2118 130.97
R6308 vss.n4606 vss.t240 130.589
R6309 vss.t26 vss.n4225 130.12
R6310 vss.n1891 vss.t1448 129.977
R6311 vss.n1914 vss.t1463 129.977
R6312 vss.n1937 vss.t1478 129.977
R6313 vss.n1960 vss.t1493 129.977
R6314 vss.n1983 vss.t1508 129.977
R6315 vss.n2006 vss.t1523 129.977
R6316 vss.t542 vss.t503 128.472
R6317 vss.t539 vss.t501 128.472
R6318 vss.t1216 vss.t508 128.472
R6319 vss.t19 vss.t1218 128.472
R6320 vss.t515 vss.t535 128.472
R6321 vss.n2453 vss.t1535 127.71
R6322 vss.n4199 vss.t662 127.059
R6323 vss.t662 vss.n4198 127.059
R6324 vss.t150 vss.n4219 126.507
R6325 vss.n5367 vss.n5361 125.599
R6326 vss.n375 vss.t1972 140.085
R6327 vss.t1448 vss.n1890 122.951
R6328 vss.t1463 vss.n1913 122.951
R6329 vss.t1478 vss.n1936 122.951
R6330 vss.t1493 vss.n1959 122.951
R6331 vss.t1508 vss.n1982 122.951
R6332 vss.t1523 vss.n2005 122.951
R6333 vss.n5361 vss.n460 122.775
R6334 vss.n4311 vss.n12 122.379
R6335 vss.n4446 vss.n4316 122.379
R6336 vss.n4437 vss.n4306 122.379
R6337 vss.n4447 vss.n4317 122.379
R6338 vss.n4436 vss.n4305 122.379
R6339 vss.n4451 vss.n4321 122.379
R6340 vss.n4432 vss.n4301 122.379
R6341 vss.n4452 vss.n4322 122.379
R6342 vss.n4431 vss.n4300 122.379
R6343 vss.n4457 vss.n4328 122.379
R6344 vss.n4426 vss.n4295 122.379
R6345 vss.n4458 vss.n4329 122.379
R6346 vss.n4425 vss.n4294 122.379
R6347 vss.n4462 vss.n4333 122.379
R6348 vss.n4421 vss.n4290 122.379
R6349 vss.n4463 vss.n4334 122.379
R6350 vss.n4420 vss.n166 122.379
R6351 vss.n4601 vss.n4600 122.379
R6352 vss.n2356 vss.n527 122.356
R6353 vss.n5342 vss.t2012 121.951
R6354 vss.n4401 vss.t684 121.528
R6355 vss.n2446 vss.n1856 120.743
R6356 vss.n2451 vss.n1860 120.743
R6357 vss.n2441 vss.n1864 120.743
R6358 vss.n2459 vss.n1867 120.743
R6359 vss.n2438 vss.n1870 120.743
R6360 vss.n2435 vss.n1876 120.743
R6361 vss.n4251 vss.t150 119.278
R6362 vss.t259 vss.n4216 119.278
R6363 vss.n2585 vss.n288 119.118
R6364 vss.n6220 vss.n2689 119.118
R6365 vss.n4478 vss.n4287 118.882
R6366 vss.n530 vss.n6395 118.843
R6367 vss.t488 vss.n4022 118.644
R6368 vss.t142 vss.n4046 118.644
R6369 vss.t571 vss.n4070 118.644
R6370 vss.t932 vss.n4094 118.644
R6371 vss.t1293 vss.n4118 118.644
R6372 vss.t1176 vss.n4142 118.644
R6373 vss.n6030 vss.n3994 118.63
R6374 vss.n6056 vss.n2186 118.597
R6375 vss.n6054 vss.n2182 118.597
R6376 vss.n6052 vss.n2178 118.597
R6377 vss.n6050 vss.n2174 118.597
R6378 vss.n5335 vss.n5334 118.46
R6379 vss.n1348 vss.n1157 118.421
R6380 vss.t918 vss.n1153 118.421
R6381 vss.n1354 vss.n1149 118.421
R6382 vss.n1339 vss.n1145 118.421
R6383 vss.n1335 vss.t1238 118.421
R6384 vss.n1333 vss.n1137 118.421
R6385 vss.n4396 vss.t686 118.056
R6386 vss.n1029 vss.n5023 116.76
R6387 vss.t1108 vss.t635 116.668
R6388 vss.t1163 vss.n6027 116.537
R6389 vss.n6029 vss.t1350 116.537
R6390 vss.n4911 vss.t174 116.129
R6391 vss.n4244 vss.t26 115.663
R6392 vss.n4476 vss.n4466 115.385
R6393 vss.n4383 vss.t542 114.584
R6394 vss.t553 vss.n4032 114.407
R6395 vss.t15 vss.n4056 114.407
R6396 vss.t880 vss.n4080 114.407
R6397 vss.t1334 vss.n4104 114.407
R6398 vss.t1289 vss.n4128 114.407
R6399 vss.t1210 vss.n4152 114.407
R6400 vss.n1862 vss.t1533 113.778
R6401 vss.t1969 vss.n372 112.904
R6402 vss.n3956 vss.t1977 112.903
R6403 vss.n5319 vss.t1967 112.903
R6404 vss.t1836 vss.n2324 112.859
R6405 vss.n3916 vss.t1844 112.859
R6406 vss.t1846 vss.n3889 112.859
R6407 vss.n1879 vss.n1575 112.412
R6408 vss.n1882 vss.n1572 112.412
R6409 vss.n1885 vss.n1586 112.412
R6410 vss.n1889 vss.n1568 112.412
R6411 vss.n1893 vss.n1591 112.412
R6412 vss.n1896 vss.n1565 112.412
R6413 vss.n1899 vss.n1600 112.412
R6414 vss.n1902 vss.n1557 112.412
R6415 vss.n1905 vss.n1603 112.412
R6416 vss.n1908 vss.n1553 112.412
R6417 vss.n1912 vss.n1614 112.412
R6418 vss.n1916 vss.n1545 112.412
R6419 vss.n1919 vss.n1617 112.412
R6420 vss.n1922 vss.n1541 112.412
R6421 vss.n1925 vss.n1622 112.412
R6422 vss.n1928 vss.n1533 112.412
R6423 vss.n1931 vss.n1631 112.412
R6424 vss.n1935 vss.n1529 112.412
R6425 vss.n1939 vss.n1636 112.412
R6426 vss.n1942 vss.n1526 112.412
R6427 vss.n1945 vss.n1645 112.412
R6428 vss.n1948 vss.n1518 112.412
R6429 vss.n1951 vss.n1650 112.412
R6430 vss.n1954 vss.n1514 112.412
R6431 vss.n1958 vss.n1658 112.412
R6432 vss.n1962 vss.n1511 112.412
R6433 vss.n1965 vss.n1667 112.412
R6434 vss.n1968 vss.n1507 112.412
R6435 vss.n1971 vss.n1672 112.412
R6436 vss.n1974 vss.n1499 112.412
R6437 vss.n1977 vss.n1681 112.412
R6438 vss.n1981 vss.n1495 112.412
R6439 vss.n1985 vss.n1686 112.412
R6440 vss.n1988 vss.n1492 112.412
R6441 vss.n1991 vss.n1700 112.412
R6442 vss.n1994 vss.n1489 112.412
R6443 vss.n1997 vss.n1705 112.412
R6444 vss.n2000 vss.n1485 112.412
R6445 vss.n2004 vss.n1713 112.412
R6446 vss.n2008 vss.n1482 112.412
R6447 vss.n2011 vss.n1722 112.412
R6448 vss.n6396 vss.n1478 112.412
R6449 vss.n6028 vss.t1163 112.263
R6450 vss.t1350 vss.n6028 112.26
R6451 vss.n4492 vss.n4297 111.888
R6452 vss.n4472 vss.n4336 111.888
R6453 vss.t244 vss.t1215 111.843
R6454 vss.t7 vss.n1147 110.526
R6455 vss.t1839 vss.n2320 108.755
R6456 vss.n3887 vss.t1841 108.755
R6457 vss.t1849 vss.n3888 108.755
R6458 vss.t639 vss.n4202 108.434
R6459 vss.n4604 vss.n4603 108.392
R6460 vss.n4471 vss.n4417 108.392
R6461 vss.n4527 vss.n4413 108.392
R6462 vss.t1974 vss.n3956 108.386
R6463 vss.n5319 vss.t1964 108.386
R6464 vss.t1972 vss.n372 108.385
R6465 vss.n2792 vss.n2791 108.365
R6466 vss.n2754 vss.n2753 108.365
R6467 vss.t926 vss.n5423 108.001
R6468 vss.n4173 vss.n4172 106.811
R6469 vss.t919 vss.n1160 106.579
R6470 vss.t176 vss.n4700 106.453
R6471 vss.n5697 vss.t1195 105.933
R6472 vss.n5922 vss.n4033 105.933
R6473 vss.n5891 vss.t1178 105.933
R6474 vss.n5919 vss.n4057 105.933
R6475 vss.n5724 vss.t659 105.933
R6476 vss.n5916 vss.n4081 105.933
R6477 vss.n5864 vss.t702 105.933
R6478 vss.n5913 vss.n4105 105.933
R6479 vss.n5754 vss.t1228 105.933
R6480 vss.n5910 vss.n4129 105.933
R6481 vss.n5826 vss.t985 105.933
R6482 vss.t503 vss.n4377 105.706
R6483 vss.n2775 vss.n2734 105.198
R6484 vss.n2769 vss.n2715 105.198
R6485 vss.n4488 vss.n4325 104.895
R6486 vss.n4474 vss.n4289 104.895
R6487 vss.n5523 vss.t2127 103.227
R6488 vss.n5104 vss.n5103 102.879
R6489 vss.n2447 vss.n1856 102.168
R6490 vss.n2443 vss.n1860 102.168
R6491 vss.n2452 vss.n1864 102.168
R6492 vss.n2440 vss.n1867 102.168
R6493 vss.n2460 vss.n1870 102.168
R6494 vss.n2437 vss.n1873 102.168
R6495 vss.n3071 vss.n2250 101.894
R6496 vss.n3182 vss.n2231 101.894
R6497 vss.n3057 vss.n2228 101.894
R6498 vss.n3053 vss.n2222 101.894
R6499 vss.n3032 vss.n2187 101.894
R6500 vss.n3218 vss.n2183 101.894
R6501 vss.n3027 vss.n2179 101.894
R6502 vss.n3018 vss.n2171 101.894
R6503 vss.t1410 vss.n4024 101.695
R6504 vss.t1409 vss.n4048 101.695
R6505 vss.t1407 vss.n4072 101.695
R6506 vss.t1404 vss.n4096 101.695
R6507 vss.t1401 vss.n4120 101.695
R6508 vss.t1398 vss.n4144 101.695
R6509 vss.n4613 vss.n4189 101.45
R6510 vss.n4617 vss.n4616 101.448
R6511 vss.n4477 vss.n4467 101.4
R6512 vss.n4530 vss.n4469 101.4
R6513 vss.n4241 vss.n4225 101.206
R6514 vss.n4238 vss.n4219 101.206
R6515 vss.n4255 vss.n4217 101.206
R6516 vss.n4235 vss.n4215 101.206
R6517 vss.n4262 vss.n4211 101.206
R6518 vss.n4232 vss.n4209 101.206
R6519 vss.n4229 vss.n4203 101.206
R6520 vss.n3136 vss.n3135 100.224
R6521 vss.n3097 vss.n3096 100.224
R6522 vss.n2869 vss.n2754 99.8631
R6523 vss.n2929 vss.n2791 99.8631
R6524 vss.n2439 vss.t1538 99.8457
R6525 vss.n2463 vss.t1543 99.8457
R6526 vss.n5284 vss.n1229 99.763
R6527 vss.t190 vss.n2927 99.1578
R6528 vss.n2925 vss.t975 99.1578
R6529 vss.n2865 vss.t2076 99.1578
R6530 vss.t195 vss.n2867 99.1578
R6531 vss.n4272 vss.n4201 98.824
R6532 vss.n4276 vss.n4197 98.824
R6533 vss.n4279 vss.n4193 98.824
R6534 vss.n3099 vss.n2275 98.5528
R6535 vss.n3140 vss.n2271 98.5528
R6536 vss.n3092 vss.n2267 98.5528
R6537 vss.n3179 vss.n2232 98.5528
R6538 vss.n3184 vss.n2226 98.5528
R6539 vss.n3055 vss.n2223 98.5528
R6540 vss.n3190 vss.n2220 98.5528
R6541 vss.n4508 vss.n4315 97.9026
R6542 vss.n4493 vss.n4296 97.9026
R6543 vss.n4473 vss.n4335 97.9026
R6544 vss.t1416 vss.n4016 97.4581
R6545 vss.t996 vss.n4040 97.4581
R6546 vss.t938 vss.n4064 97.4581
R6547 vss.t2 vss.n4088 97.4581
R6548 vss.t707 vss.n4112 97.4581
R6549 vss.t1319 vss.n4136 97.4581
R6550 vss.t685 vss.t2123 97.2227
R6551 vss.t1987 vss.n5337 96.9215
R6552 vss.t1992 vss.n467 96.9215
R6553 vss.n6010 vss.t875 95.8338
R6554 vss.n6006 vss.t1179 95.8338
R6555 vss.t1249 vss.n3102 95.2121
R6556 vss.n3089 vss.n2266 95.2121
R6557 vss.n3003 vss.n2265 95.2121
R6558 vss.n3004 vss.n2261 95.2121
R6559 vss.n3079 vss.n2258 95.2121
R6560 vss.n3005 vss.n2257 95.2121
R6561 vss.n3156 vss.n2254 95.2121
R6562 vss.n6082 vss.n2200 95.2121
R6563 vss.n6084 vss.n2196 95.2121
R6564 vss.n6086 vss.n2192 95.2121
R6565 vss.n6088 vss.n2188 95.2121
R6566 vss.t828 vss.n2175 95.2121
R6567 vss.n2462 vss.t1540 95.2017
R6568 vss.t573 vss.n1151 94.7373
R6569 vss.t1234 vss.n1143 94.7373
R6570 vss.n1361 vss.t1236 94.7373
R6571 vss.t161 vss.n4211 93.9764
R6572 vss.t955 vss.n2279 93.5417
R6573 vss.n3006 vss.t375 93.5417
R6574 vss.n5521 vss.n84 93.3325
R6575 vss.n283 vss.t68 93.0702
R6576 vss.n5522 vss.n4622 92.2495
R6577 vss.n4618 vss.n3997 92.2495
R6578 vss.t1215 vss.t2082 92.1058
R6579 vss.n2995 vss.n2296 91.8713
R6580 vss.n3117 vss.n2295 91.8713
R6581 vss.n2996 vss.n2292 91.8713
R6582 vss.n3111 vss.n2291 91.8713
R6583 vss.n2997 vss.n2288 91.8713
R6584 vss.n3123 vss.n2287 91.8713
R6585 vss.n2998 vss.n2284 91.8713
R6586 vss.n3104 vss.n2283 91.8713
R6587 vss.n6047 vss.n2167 91.8713
R6588 vss.n6099 vss.n2166 91.8713
R6589 vss.n6045 vss.n2163 91.8713
R6590 vss.n6044 vss.n2159 91.8713
R6591 vss.n6103 vss.n2158 91.8713
R6592 vss.n2636 vss.n2090 91.8372
R6593 vss.n284 vss.t2136 91.7639
R6594 vss.n2790 vss.n2726 91.1167
R6595 vss.n2789 vss.n2727 91.1167
R6596 vss.n2788 vss.n2725 91.1167
R6597 vss.n2787 vss.n2728 91.1167
R6598 vss.n2786 vss.n2724 91.1167
R6599 vss.n2785 vss.n2729 91.1167
R6600 vss.n2784 vss.n2723 91.1167
R6601 vss.n2783 vss.n2730 91.1167
R6602 vss.n2782 vss.n2722 91.1167
R6603 vss.n2780 vss.n2721 91.1167
R6604 vss.n2779 vss.n2732 91.1167
R6605 vss.n2778 vss.n2720 91.1167
R6606 vss.n2776 vss.n2719 91.1167
R6607 vss.n2768 vss.n2738 91.1167
R6608 vss.n2766 vss.n2739 91.1167
R6609 vss.n2765 vss.n2713 91.1167
R6610 vss.n2764 vss.n2740 91.1167
R6611 vss.n2762 vss.n2741 91.1167
R6612 vss.n2761 vss.n2711 91.1167
R6613 vss.n2760 vss.n2742 91.1167
R6614 vss.n2759 vss.n2710 91.1167
R6615 vss.n2758 vss.n2743 91.1167
R6616 vss.n2757 vss.n2709 91.1167
R6617 vss.n2756 vss.n2744 91.1167
R6618 vss.n2755 vss.n2708 91.1167
R6619 vss.n2952 vss.n2951 91.1167
R6620 vss.n4513 vss.n4308 90.9096
R6621 vss.n4489 vss.n4324 90.9096
R6622 vss.t2078 vss.t505 90.2783
R6623 vss.t153 vss.t1216 90.2783
R6624 vss.n5080 vss.t976 90.2009
R6625 vss.n2999 vss.t600 90.2009
R6626 vss.t1323 vss.n3141 90.2009
R6627 vss.n6064 vss.t911 90.2009
R6628 vss.n6096 vss.t2075 90.2009
R6629 vss.n6043 vss.n6042 90.2009
R6630 vss.n6128 vss.t605 90.2009
R6631 vss.t1984 vss.n5336 89.2292
R6632 vss.n5337 vss.t1984 89.2292
R6633 vss.n5927 vss.n5926 88.9836
R6634 vss.n4015 vss.t1136 88.9836
R6635 vss.n5923 vss.n4023 88.9836
R6636 vss.n5895 vss.t1130 88.9836
R6637 vss.n4039 vss.t1133 88.9836
R6638 vss.n5920 vss.n4047 88.9836
R6639 vss.n5720 vss.t1119 88.9836
R6640 vss.n4063 vss.t1110 88.9836
R6641 vss.n5917 vss.n4071 88.9836
R6642 vss.n5868 vss.t1113 88.9836
R6643 vss.n4087 vss.t1104 88.9836
R6644 vss.n5914 vss.n4095 88.9836
R6645 vss.n5749 vss.t1077 88.9836
R6646 vss.n4111 vss.t1099 88.9836
R6647 vss.n5911 vss.n4119 88.9836
R6648 vss.n5833 vss.t1085 88.9836
R6649 vss.n4135 vss.t1093 88.9836
R6650 vss.n5908 vss.n4143 88.9836
R6651 vss.n5781 vss.t1083 88.9836
R6652 vss.n15 vss.n4532 88.6045
R6653 vss.t910 vss.n2268 88.5306
R6654 vss.n6294 vss.n6293 88.4359
R6655 vss.n2952 vss.n285 88.2983
R6656 vss.n286 vss.n2726 88.2973
R6657 vss.n6383 vss.t1839 88.2358
R6658 vss.t1841 vss.n3879 88.2358
R6659 vss.n3892 vss.t1849 88.2358
R6660 vss.n1887 vss.t1445 87.8225
R6661 vss.n1910 vss.t1460 87.8225
R6662 vss.n1933 vss.t1475 87.8225
R6663 vss.n1956 vss.t1490 87.8225
R6664 vss.n1979 vss.t1505 87.8225
R6665 vss.n2002 vss.t1520 87.8225
R6666 vss.n4529 vss.n4468 87.4131
R6667 vss.n4615 vss.n73 87.3297
R6668 vss.n4245 vss.n83 87.3258
R6669 vss.n4252 vss.n82 87.3258
R6670 vss.n4236 vss.n80 87.3258
R6671 vss.n4233 vss.n79 87.3258
R6672 vss.n4230 vss.n77 87.3258
R6673 vss.n180 vss.n4415 87.2787
R6674 vss.n6097 vss.t833 86.8602
R6675 vss.t21 vss.t1417 86.8061
R6676 vss.t1381 vss.n4223 86.7475
R6677 vss.n824 vss.t1324 86.5025
R6678 vss.n817 vss.t873 86.5025
R6679 vss.n811 vss.t606 86.5025
R6680 vss.n805 vss.t578 86.5025
R6681 vss.n799 vss.t1049 86.5025
R6682 vss.n481 vss.t554 86.5025
R6683 vss.n530 vss.n2049 86.4312
R6684 vss.n681 vss.n2014 86.3436
R6685 vss.n680 vss.n2015 86.3436
R6686 vss.n679 vss.n2016 86.3436
R6687 vss.n678 vss.n2017 86.3436
R6688 vss.n677 vss.n2018 86.3436
R6689 vss.n676 vss.n2019 86.3436
R6690 vss.n675 vss.n2020 86.3436
R6691 vss.n674 vss.n2021 86.3436
R6692 vss.n673 vss.n2022 86.3436
R6693 vss.n672 vss.n2023 86.3436
R6694 vss.n671 vss.n2024 86.3436
R6695 vss.n670 vss.n2025 86.3436
R6696 vss.n669 vss.n2026 86.3436
R6697 vss.n668 vss.n2027 86.3436
R6698 vss.n667 vss.n2028 86.3436
R6699 vss.n666 vss.n2029 86.3436
R6700 vss.n665 vss.n2030 86.3436
R6701 vss.n664 vss.n2031 86.3436
R6702 vss.n663 vss.n2032 86.3436
R6703 vss.n662 vss.n2033 86.3436
R6704 vss.n661 vss.n2034 86.3436
R6705 vss.n660 vss.n2035 86.3436
R6706 vss.n659 vss.n2036 86.3436
R6707 vss.n658 vss.n2037 86.3436
R6708 vss.n655 vss.n2038 86.3436
R6709 vss.n1858 vss.t1530 85.9138
R6710 vss.t753 vss.n273 57.4544
R6711 vss.t751 vss.n272 85.6631
R6712 vss.n2860 vss.t595 85.2977
R6713 vss.n2933 vss.t187 85.2977
R6714 vss.t188 vss.n2862 85.2977
R6715 vss.t1221 vss.n2935 85.2977
R6716 vss.t106 vss.n2801 85.2508
R6717 vss.n15 vss.n18 0.0324074
R6718 vss.t552 vss.n4034 84.7463
R6719 vss.n5893 vss.t552 84.7463
R6720 vss.t13 vss.n4058 84.7463
R6721 vss.n5722 vss.t13 84.7463
R6722 vss.t879 vss.n4082 84.7463
R6723 vss.n5866 vss.t879 84.7463
R6724 vss.t1333 vss.n4106 84.7463
R6725 vss.n5752 vss.t1333 84.7463
R6726 vss.t1288 vss.n4130 84.7463
R6727 vss.n5828 vss.t1288 84.7463
R6728 vss.t1208 vss.n4154 84.7463
R6729 vss.n5784 vss.t1208 84.7463
R6730 vss.n656 vss.n2039 84.5591
R6731 vss.n2326 vss.t1836 84.1318
R6732 vss.n3881 vss.t1844 84.1318
R6733 vss.n3901 vss.t1846 84.1318
R6734 vss.n4509 vss.n4314 83.9166
R6735 vss.n4490 vss.n4299 83.9166
R6736 vss.n4479 vss.n4332 83.9166
R6737 vss.n2752 vss.t759 83.8977
R6738 vss.t745 vss.n902 83.8977
R6739 vss.n2799 vss.t1254 83.8977
R6740 vss.n5520 vss.t2125 83.8715
R6741 vss.n5637 vss.t1213 83.3338
R6742 vss.n5660 vss.t696 83.3338
R6743 vss.n5683 vss.t713 83.3338
R6744 vss.n5961 vss.t947 83.3338
R6745 vss.n5984 vss.t1144 83.3338
R6746 vss.n956 vss.n4323 83.1782
R6747 vss.n5699 vss.n28 83.093
R6748 vss.n5901 vss.n29 83.093
R6749 vss.n5702 vss.n30 83.093
R6750 vss.n5708 vss.n32 83.093
R6751 vss.n5892 vss.n33 83.093
R6752 vss.n5889 vss.n34 83.093
R6753 vss.n5714 vss.n35 83.093
R6754 vss.n5886 vss.n36 83.093
R6755 vss.n5880 vss.n38 83.093
R6756 vss.n5723 vss.n39 83.093
R6757 vss.n5726 vss.n40 83.093
R6758 vss.n5874 vss.n41 83.093
R6759 vss.n5729 vss.n42 83.093
R6760 vss.n5735 vss.n44 83.093
R6761 vss.n5865 vss.n45 83.093
R6762 vss.n5859 vss.n46 83.093
R6763 vss.n5743 vss.n47 83.093
R6764 vss.n5854 vss.n48 83.093
R6765 vss.n5848 vss.n50 83.093
R6766 vss.n5753 vss.n51 83.093
R6767 vss.n5757 vss.n52 83.093
R6768 vss.n5839 vss.n53 83.093
R6769 vss.n5762 vss.n54 83.093
R6770 vss.n5768 vss.n56 83.093
R6771 vss.n5827 vss.n57 83.093
R6772 vss.n5821 vss.n58 83.093
R6773 vss.n5775 vss.n59 83.093
R6774 vss.n5816 vss.n60 83.093
R6775 vss.n5810 vss.n62 83.093
R6776 vss.n5785 vss.n63 83.093
R6777 vss.n5789 vss.n64 83.093
R6778 vss.n5801 vss.n65 83.093
R6779 vss.n1358 vss.t1235 82.8952
R6780 vss.n657 vss.n2040 82.7032
R6781 vss.n2093 vss.n2042 82.7032
R6782 vss.n2094 vss.n2043 82.7032
R6783 vss.n2095 vss.n2044 82.7032
R6784 vss.n2097 vss.n2046 82.7032
R6785 vss.n2098 vss.n2047 82.7032
R6786 vss.t1184 vss.n2225 81.8491
R6787 vss.n5338 vss.t1987 81.401
R6788 vss.t1530 vss.n1857 81.2698
R6789 vss.n366 vss.n2316 81.2957
R6790 vss.n6118 vss.n2138 81.2488
R6791 vss.t761 vss.n282 80.8918
R6792 vss.n1879 vss.t1440 80.7967
R6793 vss.n1902 vss.t1455 80.7967
R6794 vss.n1925 vss.t1470 80.7967
R6795 vss.n1948 vss.t1485 80.7967
R6796 vss.n1971 vss.t1500 80.7967
R6797 vss.n1994 vss.t1515 80.7967
R6798 vss.n2447 vss.n526 80.5716
R6799 vss.t459 vss.n4165 80.509
R6800 vss.n4499 vss.n4435 80.4201
R6801 vss.n6101 vss.t1433 80.1787
R6802 vss.t508 vss.n4354 79.8616
R6803 vss.n2316 vss.n2315 79.7008
R6804 vss.n2988 vss.n2314 79.7008
R6805 vss.n2987 vss.n2313 79.7008
R6806 vss.n2989 vss.n2312 79.7008
R6807 vss.n2986 vss.n2311 79.7008
R6808 vss.n2990 vss.n2310 79.7008
R6809 vss.n2985 vss.n2309 79.7008
R6810 vss.n2991 vss.n2308 79.7008
R6811 vss.n2984 vss.n2307 79.7008
R6812 vss.n2983 vss.n2305 79.7008
R6813 vss.n2993 vss.n2304 79.7008
R6814 vss.n2982 vss.n2303 79.7008
R6815 vss.n2981 vss.n2301 79.7008
R6816 vss.n3011 vss.n2300 79.7008
R6817 vss.n6104 vss.n2154 79.7008
R6818 vss.n6105 vss.n2153 79.7008
R6819 vss.n6107 vss.n2151 79.7008
R6820 vss.n6108 vss.n2150 79.7008
R6821 vss.n6109 vss.n2149 79.7008
R6822 vss.n6111 vss.n2147 79.7008
R6823 vss.n6112 vss.n2146 79.7008
R6824 vss.n6113 vss.n2145 79.7008
R6825 vss.n6114 vss.n2144 79.7008
R6826 vss.n6115 vss.n2143 79.7008
R6827 vss.n6116 vss.n2142 79.7008
R6828 vss.n6119 vss.n2141 79.7008
R6829 vss.n6117 vss.n2140 79.7008
R6830 vss.n6118 vss.n2139 79.7008
R6831 vss.n2929 vss.n286 79.1867
R6832 vss.n2869 vss.n285 79.1857
R6833 vss.t1183 vss.n2229 78.5083
R6834 vss.t1990 vss.n5338 78.3231
R6835 vss.n4883 vss.t176 77.4198
R6836 vss.n5523 vss.n4621 77.4198
R6837 vss.n5519 vss.n4619 77.4198
R6838 vss.n4515 vss.n4307 76.9236
R6839 vss.n4482 vss.n4292 76.9236
R6840 vss.t812 vss.n2262 76.8379
R6841 vss.n6081 vss.n3042 76.8379
R6842 vss.n6083 vss.n3207 76.8379
R6843 vss.n6085 vss.n3036 76.8379
R6844 vss.n6087 vss.n3210 76.8379
R6845 vss.t668 vss.n4163 76.2717
R6846 vss.n6039 vss.n6038 76.1517
R6847 vss.n2356 vss.n528 75.925
R6848 vss.n4173 vss.n526 75.9247
R6849 vss.n5083 vss.n2300 75.6136
R6850 vss.n3225 vss.n2154 75.6136
R6851 vss.n4498 vss.n4449 73.4271
R6852 vss.n2751 vss.t66 73.0722
R6853 vss.n2573 vss.t743 73.0722
R6854 vss.t59 vss.n903 73.0722
R6855 vss.n6295 vss.n2092 72.9735
R6856 vss.n4384 vss.t2079 72.9172
R6857 vss.n2790 vss.n2727 72.8934
R6858 vss.n2788 vss.n2728 72.8934
R6859 vss.n2787 vss.n2724 72.8934
R6860 vss.n2786 vss.n2729 72.8934
R6861 vss.n2784 vss.n2730 72.8934
R6862 vss.n2783 vss.n2722 72.8934
R6863 vss.n2782 vss.n2731 72.8934
R6864 vss.n2781 vss.n2721 72.8934
R6865 vss.n2780 vss.n2732 72.8934
R6866 vss.n2779 vss.n2720 72.8934
R6867 vss.n2778 vss.n2733 72.8934
R6868 vss.n2777 vss.n2719 72.8934
R6869 vss.n2776 vss.n2734 72.8934
R6870 vss.n2768 vss.n2715 72.8934
R6871 vss.n2767 vss.n2738 72.8934
R6872 vss.n2766 vss.n2714 72.8934
R6873 vss.n2765 vss.n2739 72.8934
R6874 vss.n2764 vss.n2713 72.8934
R6875 vss.n2763 vss.n2740 72.8934
R6876 vss.n2762 vss.n2712 72.8934
R6877 vss.n2761 vss.n2741 72.8934
R6878 vss.n2760 vss.n2711 72.8934
R6879 vss.n2758 vss.n2710 72.8934
R6880 vss.n2757 vss.n2743 72.8934
R6881 vss.n2756 vss.n2709 72.8934
R6882 vss.n2951 vss.n2708 72.8934
R6883 vss.n4242 vss.n4227 72.2897
R6884 vss.n4239 vss.n4221 72.2897
R6885 vss.n4261 vss.n4213 72.2897
R6886 vss.n528 vss.n1574 72.1973
R6887 vss.n19 vss.n4 0.459489
R6888 vss.n5698 vss.t1416 72.0344
R6889 vss.n5890 vss.t996 72.0344
R6890 vss.n5725 vss.t938 72.0344
R6891 vss.n5863 vss.t2 72.0344
R6892 vss.n5755 vss.t707 72.0344
R6893 vss.n5825 vss.t1319 72.0344
R6894 vss.t1434 vss.n5422 72.0005
R6895 vss.t231 vss.t888 71.7494
R6896 vss.t87 vss.t231 71.7494
R6897 vss.t580 vss.t625 71.7494
R6898 vss.t494 vss.t580 71.7494
R6899 vss.t810 vss.t855 71.7494
R6900 vss.t855 vss.t1270 71.7494
R6901 vss.t70 vss.n2750 71.719
R6902 vss.n5309 vss.t1435 71.2867
R6903 vss.n1880 vss.n1578 71.1926
R6904 vss.n1883 vss.n1571 71.1926
R6905 vss.n1894 vss.n1592 71.1926
R6906 vss.n1897 vss.n1559 71.1926
R6907 vss.n1900 vss.n1601 71.1926
R6908 vss.n1903 vss.n1555 71.1926
R6909 vss.n1906 vss.n1606 71.1926
R6910 vss.n1917 vss.n1544 71.1926
R6911 vss.n1920 vss.n1618 71.1926
R6912 vss.n1923 vss.n1540 71.1926
R6913 vss.n1926 vss.n1629 71.1926
R6914 vss.n1929 vss.n1532 71.1926
R6915 vss.n1940 vss.n1637 71.1926
R6916 vss.n1943 vss.n1520 71.1926
R6917 vss.n1946 vss.n1646 71.1926
R6918 vss.n1949 vss.n1516 71.1926
R6919 vss.n1952 vss.n1651 71.1926
R6920 vss.n1963 vss.n1510 71.1926
R6921 vss.n1966 vss.n1668 71.1926
R6922 vss.n1969 vss.n1506 71.1926
R6923 vss.n1972 vss.n1679 71.1926
R6924 vss.n1975 vss.n1498 71.1926
R6925 vss.n1986 vss.n1687 71.1926
R6926 vss.n1989 vss.n1491 71.1926
R6927 vss.n1992 vss.n1701 71.1926
R6928 vss.n1995 vss.n1487 71.1926
R6929 vss.n1998 vss.n1706 71.1926
R6930 vss.n2009 vss.n1481 71.1926
R6931 vss.n2012 vss.n1723 71.1926
R6932 vss.n6296 vss.n630 71.1926
R6933 vss.n1350 vss.n1153 71.0531
R6934 vss.n1344 vss.n1160 71.0531
R6935 vss.t922 vss.n1163 71.0531
R6936 vss.n1337 vss.n1141 71.0531
R6937 vss.n1363 vss.t1238 71.0531
R6938 vss.n1363 vss.n1137 71.0531
R6939 vss.n2773 vss.t899 70.6155
R6940 vss.n2771 vss.t184 70.6155
R6941 vss.n4273 vss.n4199 70.5887
R6942 vss.n4277 vss.n4195 70.5887
R6943 vss.t497 vss.n31 70.3812
R6944 vss.t550 vss.n37 70.3812
R6945 vss.t612 vss.n43 70.3812
R6946 vss.t843 vss.n49 70.3812
R6947 vss.t863 vss.n55 70.3812
R6948 vss.t648 vss.n61 70.3812
R6949 vss.t198 vss.n3119 70.1564
R6950 vss.n3000 vss.t909 70.1564
R6951 vss.t1232 vss.n3154 70.1564
R6952 vss.n6062 vss.t598 70.1564
R6953 vss.n6094 vss.t203 70.1564
R6954 vss.n6048 vss.n3223 70.1564
R6955 vss.n6130 vss.n6129 70.1564
R6956 vss.n6102 vss.t914 70.1564
R6957 vss.n4510 vss.n4313 69.9306
R6958 vss.t1214 vss.n822 69.8359
R6959 vss.t698 vss.n816 69.8359
R6960 vss.t714 vss.n810 69.8359
R6961 vss.t948 vss.n804 69.8359
R6962 vss.t1146 vss.n798 69.8359
R6963 vss.n4402 vss.t2080 69.4449
R6964 vss.n1029 vss.n5024 69.2012
R6965 vss.n4236 vss.t259 68.6752
R6966 vss.t229 vss.t2107 68.67
R6967 vss.t85 vss.t229 68.67
R6968 vss.t893 vss.t2112 68.67
R6969 vss.t137 vss.t893 68.67
R6970 vss.n3007 vss.n2249 68.486
R6971 vss.n3162 vss.n2246 68.486
R6972 vss.n3008 vss.n2245 68.486
R6973 vss.n3064 vss.n2242 68.486
R6974 vss.n3009 vss.n2241 68.486
R6975 vss.n3175 vss.n2238 68.486
R6976 vss.n3010 vss.n2237 68.486
R6977 vss.n6133 vss.n2234 68.486
R6978 vss.n6074 vss.n2217 68.486
R6979 vss.n6071 vss.n2216 68.486
R6980 vss.n6076 vss.n2213 68.486
R6981 vss.n6069 vss.n2212 68.486
R6982 vss.n6078 vss.n2209 68.486
R6983 vss.n6067 vss.n2208 68.486
R6984 vss.n6080 vss.n2205 68.486
R6985 vss.n6065 vss.n2204 68.486
R6986 vss.t958 vss.n2723 68.3376
R6987 vss.t898 vss.n2731 68.3376
R6988 vss.t901 vss.n2712 68.3376
R6989 vss.t597 vss.n2742 68.3376
R6990 vss.n5904 vss.n4015 67.7971
R6991 vss.n5924 vss.t499 67.7971
R6992 vss.n5898 vss.n4025 67.7971
R6993 vss.n5895 vss.n4031 67.7971
R6994 vss.n5711 vss.n4039 67.7971
R6995 vss.n5921 vss.t233 67.7971
R6996 vss.n5717 vss.n4049 67.7971
R6997 vss.n5720 vss.n4055 67.7971
R6998 vss.n5877 vss.n4063 67.7971
R6999 vss.n5918 vss.t2102 67.7971
R7000 vss.n5871 vss.n4073 67.7971
R7001 vss.n5868 vss.n4079 67.7971
R7002 vss.n5740 vss.n4087 67.7971
R7003 vss.n5915 vss.t709 67.7971
R7004 vss.n5746 vss.n4097 67.7971
R7005 vss.n5749 vss.n4103 67.7971
R7006 vss.n5842 vss.n4111 67.7971
R7007 vss.n5912 vss.t2083 67.7971
R7008 vss.n5836 vss.n4121 67.7971
R7009 vss.n5833 vss.n4127 67.7971
R7010 vss.n5772 vss.n4135 67.7971
R7011 vss.n5909 vss.t730 67.7971
R7012 vss.n5778 vss.n4145 67.7971
R7013 vss.n5781 vss.n4151 67.7971
R7014 vss.n5796 vss.n4167 67.7971
R7015 vss.t174 vss.n4729 67.7424
R7016 vss.n2988 vss.n2315 67.4392
R7017 vss.n2989 vss.n2313 67.4392
R7018 vss.n2986 vss.n2312 67.4392
R7019 vss.n2990 vss.n2311 67.4392
R7020 vss.n2991 vss.n2309 67.4392
R7021 vss.n2984 vss.n2308 67.4392
R7022 vss.n2992 vss.n2307 67.4392
R7023 vss.n2983 vss.n2306 67.4392
R7024 vss.n2993 vss.n2305 67.4392
R7025 vss.n2982 vss.n2304 67.4392
R7026 vss.n2994 vss.n2303 67.4392
R7027 vss.n2981 vss.n2302 67.4392
R7028 vss.n3011 vss.n2301 67.4392
R7029 vss.n6104 vss.n2153 67.4392
R7030 vss.n6105 vss.n2152 67.4392
R7031 vss.n6106 vss.n2151 67.4392
R7032 vss.n6107 vss.n2150 67.4392
R7033 vss.n6108 vss.n2149 67.4392
R7034 vss.n6109 vss.n2148 67.4392
R7035 vss.n6110 vss.n2147 67.4392
R7036 vss.n6111 vss.n2146 67.4392
R7037 vss.n6112 vss.n2145 67.4392
R7038 vss.n6114 vss.n2143 67.4392
R7039 vss.n6115 vss.n2142 67.4392
R7040 vss.n6116 vss.n2141 67.4392
R7041 vss.n6117 vss.n2139 67.4392
R7042 vss.n2536 vss.n2535 67.2459
R7043 vss.n3853 vss.n2694 67.2459
R7044 vss.t202 vss.n3214 66.8156
R7045 vss.n5641 vss.t1069 66.6672
R7046 vss.n5664 vss.t1100 66.6672
R7047 vss.n5687 vss.t1059 66.6672
R7048 vss.n5965 vss.t1060 66.6672
R7049 vss.n5988 vss.t1125 66.6672
R7050 vss.n6011 vss.t1108 66.6672
R7051 vss.t500 vss.t525 66.6672
R7052 vss.t899 vss.n2735 66.0597
R7053 vss.t184 vss.n2716 66.0597
R7054 vss.t599 vss.n2189 65.1453
R7055 vss.n2443 vss.n1859 65.016
R7056 vss.n2452 vss.n1863 65.016
R7057 vss.n2440 vss.n1866 65.016
R7058 vss.n2460 vss.n1869 65.016
R7059 vss.n2437 vss.n1872 65.016
R7060 vss.n2463 vss.n1875 65.016
R7061 vss.n443 vss.t133 64.5275
R7062 vss.t587 vss.n446 64.5265
R7063 vss.t499 vss.n4018 63.5598
R7064 vss.t233 vss.n4042 63.5598
R7065 vss.t2102 vss.n4066 63.5598
R7066 vss.t709 vss.n4090 63.5598
R7067 vss.t2083 vss.n4114 63.5598
R7068 vss.t730 vss.n4138 63.5598
R7069 vss.n5907 vss.n4159 63.5598
R7070 vss.n5038 vss.n69 63.3511
R7071 vss.n4511 vss.n4310 62.9376
R7072 vss.n4497 vss.n4320 62.9376
R7073 vss.n4481 vss.n4293 62.9376
R7074 vss.t992 vss.n5155 62.8747
R7075 vss.n952 vss.n4330 62.8032
R7076 vss.t539 vss.t149 62.5005
R7077 vss.n966 vss.n4312 62.1992
R7078 vss.n5084 vss.n2298 61.8045
R7079 vss.n3129 vss.n2283 61.8045
R7080 vss.n3086 vss.n2263 61.8045
R7081 vss.n3153 vss.n2259 61.8045
R7082 vss.n3077 vss.n2255 61.8045
R7083 vss.n3159 vss.n2251 61.8045
R7084 vss.n3063 vss.n2239 61.8045
R7085 vss.n3178 vss.n2235 61.8045
R7086 vss.n3059 vss.n2232 61.8045
R7087 vss.n3183 vss.n2229 61.8045
R7088 vss.n3189 vss.n2223 61.8045
R7089 vss.n3043 vss.n2204 61.8045
R7090 vss.n3219 vss.n2180 61.8045
R7091 vss.n3024 vss.n2176 61.8045
R7092 vss.n3222 vss.n2172 61.8045
R7093 vss.t913 vss.n2168 61.8045
R7094 vss.n3226 vss.n2155 61.8045
R7095 vss.t1180 vss.n4206 61.4463
R7096 vss.n6027 vss.n6026 61.3903
R7097 vss.n2985 vss.t1030 61.3084
R7098 vss.n2992 vss.t1009 61.3084
R7099 vss.n6110 vss.t1014 61.3084
R7100 vss.n6113 vss.t1037 61.3084
R7101 vss.n5039 vss.n69 61.1474
R7102 vss.t824 vss.n5269 60.6201
R7103 vss.n2441 vss.n1865 60.5676
R7104 vss.n2459 vss.n1868 60.5676
R7105 vss.n2438 vss.n1871 60.5676
R7106 vss.n2462 vss.n1874 60.5676
R7107 vss.n2435 vss.n1877 60.5676
R7108 vss.n5647 vss.t1282 60.1724
R7109 vss.n5670 vss.t703 60.1724
R7110 vss.n5694 vss.t611 60.1724
R7111 vss.n5971 vss.t546 60.1724
R7112 vss.n5994 vss.t634 60.1724
R7113 vss.n3101 vss.n3100 60.1341
R7114 vss.n3138 vss.n3137 60.1341
R7115 vss.t601 vss.t995 60.1341
R7116 vss.n3147 vss.n3146 60.1341
R7117 vss.n6046 vss.t1306 60.1341
R7118 vss.n4282 vss.t1420 60.0005
R7119 vss.n5334 vss.n5037 59.8616
R7120 vss.n4511 vss.n4441 59.4411
R7121 vss.n4512 vss.t1422 59.4411
R7122 vss.n4500 vss.t998 59.4411
R7123 vss.n4497 vss.n4450 59.4411
R7124 vss.n4491 vss.t260 59.4411
R7125 vss.n4481 vss.n4424 59.4411
R7126 vss.n4480 vss.t165 59.4411
R7127 vss.n4475 vss.t1421 59.4411
R7128 vss.t1421 vss.n167 59.4411
R7129 vss.n4528 vss.t490 59.4411
R7130 vss.n5897 vss.t487 59.3225
R7131 vss.n5709 vss.t234 59.3225
R7132 vss.n5718 vss.t141 59.3225
R7133 vss.n5879 vss.t630 59.3225
R7134 vss.n5870 vss.t570 59.3225
R7135 vss.n5736 vss.t568 59.3225
R7136 vss.n5747 vss.t931 59.3225
R7137 vss.n5847 vss.t1331 59.3225
R7138 vss.n5835 vss.t1292 59.3225
R7139 vss.n5769 vss.t950 59.3225
R7140 vss.n5779 vss.t1175 59.3225
R7141 vss.n5809 vss.t1380 59.3225
R7142 vss.n5802 vss.t668 59.3225
R7143 vss.n6296 vss.n682 59.2556
R7144 vss.n1356 vss.t1233 59.211
R7145 vss.t1237 vss.n1139 59.211
R7146 vss.n4390 vss.t507 59.0283
R7147 vss.n19 vss.n4533 72.9316
R7148 vss.n3116 vss.n2294 58.4637
R7149 vss.n3122 vss.n2290 58.4637
R7150 vss.n3107 vss.n2286 58.4637
R7151 vss.n3129 vss.n2282 58.4637
R7152 vss.n3101 vss.n2278 58.4637
R7153 vss.n3138 vss.n2274 58.4637
R7154 vss.n3094 vss.n2270 58.4637
R7155 vss.n3147 vss.n2266 58.4637
R7156 vss.n3059 vss.n2231 58.4637
R7157 vss.n3056 vss.n2225 58.4637
R7158 vss.n3189 vss.n2222 58.4637
R7159 vss.n3052 vss.n2219 58.4637
R7160 vss.n3196 vss.n2215 58.4637
R7161 vss.n3049 vss.n2211 58.4637
R7162 vss.n3201 vss.n2207 58.4637
R7163 vss.n3043 vss.n2203 58.4637
R7164 vss.n3040 vss.n2199 58.4637
R7165 vss.n3208 vss.n2195 58.4637
R7166 vss.t1199 vss.n5598 58.3338
R7167 vss.t1149 vss.n5590 58.3338
R7168 vss.t127 vss.n5582 58.3338
R7169 vss.t9 vss.n5573 58.3338
R7170 vss.t1147 vss.n5565 58.3338
R7171 vss.t1538 vss.n1869 58.05
R7172 vss.n284 vss.t113 57.936
R7173 vss.n4213 vss.t159 57.8318
R7174 vss.n5023 vss.n1030 57.4791
R7175 vss.t925 vss.n1157 57.2373
R7176 vss.t885 vss.n1166 57.2373
R7177 vss.t626 vss.t2111 57.0076
R7178 vss.t2111 vss.t204 57.0076
R7179 vss.t915 vss.n2187 56.7934
R7180 vss.t978 vss.n2184 56.7934
R7181 vss.n6055 vss.n3031 56.7934
R7182 vss.n6053 vss.n3219 56.7934
R7183 vss.n6051 vss.n3024 56.7934
R7184 vss.n6293 vss.n2045 56.7573
R7185 vss.t240 vss.n4605 56.4711
R7186 vss.n1887 vss.n1587 56.2066
R7187 vss.n1891 vss.n1567 56.2066
R7188 vss.n1910 vss.n1552 56.2066
R7189 vss.n1914 vss.n1615 56.2066
R7190 vss.n1933 vss.n1632 56.2066
R7191 vss.n1937 vss.n1528 56.2066
R7192 vss.n1956 vss.n1513 56.2066
R7193 vss.n1960 vss.n1665 56.2066
R7194 vss.n1979 vss.n1682 56.2066
R7195 vss.n1983 vss.n1494 56.2066
R7196 vss.n2002 vss.n1484 56.2066
R7197 vss.n2006 vss.n1720 56.2066
R7198 vss.n4500 vss.n4303 55.9446
R7199 vss.n5458 vss.n5342 55.7019
R7200 vss.n4384 vss.t246 55.5561
R7201 vss.n1174 vss.t877 55.2576
R7202 vss.n1215 vss.t878 55.2576
R7203 vss.t113 vss.n274 55.2286
R7204 vss.n5707 vss.t553 55.0852
R7205 vss.n5881 vss.t15 55.0852
R7206 vss.n5734 vss.t880 55.0852
R7207 vss.n5849 vss.t1334 55.0852
R7208 vss.n5767 vss.t1289 55.0852
R7209 vss.n5811 vss.t1210 55.0852
R7210 vss.n5793 vss.t459 55.0852
R7211 vss.n5361 vss.t2002 54.8785
R7212 vss.n5495 vss.n4624 54.555
R7213 vss.n4269 vss.t556 54.2174
R7214 vss.t981 vss.n5141 53.8927
R7215 vss.n5075 vss.t882 53.8122
R7216 vss.n2937 vss.t104 53.5719
R7217 vss.t513 vss.n2191 53.4526
R7218 vss.t1533 vss.n1861 53.4061
R7219 vss.t525 vss.n482 53.1692
R7220 vss.t11 vss.n444 52.5136
R7221 vss.n4510 vss.n4443 52.4481
R7222 vss.n4480 vss.n4460 52.4481
R7223 vss.n4395 vss.t19 52.0838
R7224 vss.n4396 vss.t248 52.0838
R7225 vss.n5168 vss.t374 51.7837
R7226 vss.n3007 vss.n2248 51.7822
R7227 vss.n3160 vss.n2247 51.7822
R7228 vss.n3008 vss.n2244 51.7822
R7229 vss.n3066 vss.n2243 51.7822
R7230 vss.n3166 vss.n2242 51.7822
R7231 vss.n3009 vss.n2240 51.7822
R7232 vss.t564 vss.n2238 51.7822
R7233 vss.n3010 vss.n2236 51.7822
R7234 vss.n3177 vss.n2234 51.7822
R7235 vss.n6073 vss.n2220 51.7822
R7236 vss.n6072 vss.n2219 51.7822
R7237 vss.n6075 vss.n2216 51.7822
R7238 vss.n6070 vss.n2215 51.7822
R7239 vss.n6077 vss.n2212 51.7822
R7240 vss.n6068 vss.n2211 51.7822
R7241 vss.n6078 vss.n2210 51.7822
R7242 vss.n6066 vss.n2207 51.7822
R7243 vss.n6080 vss.n2206 51.7822
R7244 vss.t439 vss.n4627 51.6134
R7245 vss.t2127 vss.n4620 51.6134
R7246 vss.t822 vss.n5593 51.5764
R7247 vss.t795 vss.n5585 51.5764
R7248 vss.t223 vss.n5576 51.5764
R7249 vss.t54 vss.n5568 51.5764
R7250 vss.t520 vss.n5560 51.5764
R7251 vss.n2795 vss.t747 51.4213
R7252 vss.t1431 vss.n2562 51.4213
R7253 vss.n2587 vss.n2050 51.0209
R7254 vss.n2588 vss.n2051 51.0209
R7255 vss.n2589 vss.n2052 51.0209
R7256 vss.n2590 vss.n2053 51.0209
R7257 vss.n2602 vss.n2054 51.0209
R7258 vss.n2603 vss.n2055 51.0209
R7259 vss.n2604 vss.n2056 51.0209
R7260 vss.n2605 vss.n2057 51.0209
R7261 vss.n2606 vss.n2058 51.0209
R7262 vss.n2607 vss.n2059 51.0209
R7263 vss.n2608 vss.n2060 51.0209
R7264 vss.n2609 vss.n2061 51.0209
R7265 vss.n2610 vss.n2062 51.0209
R7266 vss.n2611 vss.n2063 51.0209
R7267 vss.n2612 vss.n2064 51.0209
R7268 vss.n2613 vss.n2065 51.0209
R7269 vss.n2614 vss.n2066 51.0209
R7270 vss.n2615 vss.n2067 51.0209
R7271 vss.n2616 vss.n2068 51.0209
R7272 vss.n2617 vss.n2069 51.0209
R7273 vss.n2618 vss.n2070 51.0209
R7274 vss.n2619 vss.n2071 51.0209
R7275 vss.n2620 vss.n2072 51.0209
R7276 vss.n2621 vss.n2073 51.0209
R7277 vss.n2622 vss.n2074 51.0209
R7278 vss.n6299 vss.n2075 51.0209
R7279 vss.n2623 vss.n2076 51.0209
R7280 vss.n2624 vss.n2077 51.0209
R7281 vss.n2625 vss.n2078 51.0209
R7282 vss.n2626 vss.n2079 51.0209
R7283 vss.n2627 vss.n2080 51.0209
R7284 vss.n2628 vss.n2081 51.0209
R7285 vss.n2629 vss.n2082 51.0209
R7286 vss.n2630 vss.n2083 51.0209
R7287 vss.n2631 vss.n2084 51.0209
R7288 vss.n2632 vss.n2085 51.0209
R7289 vss.n2633 vss.n2086 51.0209
R7290 vss.n2634 vss.n2087 51.0209
R7291 vss.n2635 vss.n2088 51.0209
R7292 vss.n6298 vss.n2089 51.0209
R7293 vss.n2638 vss.n2099 51.0209
R7294 vss.n2639 vss.n2100 51.0209
R7295 vss.n2640 vss.n2101 51.0209
R7296 vss.n2641 vss.n2102 51.0209
R7297 vss.n2642 vss.n2103 51.0209
R7298 vss.n2643 vss.n2104 51.0209
R7299 vss.n2644 vss.n2105 51.0209
R7300 vss.n2645 vss.n2106 51.0209
R7301 vss.n2646 vss.n2107 51.0209
R7302 vss.n2647 vss.n2108 51.0209
R7303 vss.n2648 vss.n2109 51.0209
R7304 vss.n2649 vss.n2110 51.0209
R7305 vss.n2650 vss.n2111 51.0209
R7306 vss.n2651 vss.n2112 51.0209
R7307 vss.n2652 vss.n2113 51.0209
R7308 vss.n2653 vss.n2114 51.0209
R7309 vss.n2654 vss.n2115 51.0209
R7310 vss.n2655 vss.n2116 51.0209
R7311 vss.n2656 vss.n2117 51.0209
R7312 vss.n2657 vss.n2118 51.0209
R7313 vss.n2658 vss.n2119 51.0209
R7314 vss.n2659 vss.n2120 51.0209
R7315 vss.n2660 vss.n2121 51.0209
R7316 vss.n2661 vss.n2122 51.0209
R7317 vss.n2662 vss.n2123 51.0209
R7318 vss.n6281 vss.n2124 51.0209
R7319 vss.n6282 vss.n2125 51.0209
R7320 vss.n6283 vss.n2126 51.0209
R7321 vss.n6284 vss.n2127 51.0209
R7322 vss.n6285 vss.n2128 51.0209
R7323 vss.n6286 vss.n2129 51.0209
R7324 vss.n6287 vss.n2130 51.0209
R7325 vss.n6288 vss.n2131 51.0209
R7326 vss.n6289 vss.n2132 51.0209
R7327 vss.n6290 vss.n2133 51.0209
R7328 vss.n6291 vss.n2134 51.0209
R7329 vss.n6292 vss.n2135 51.0209
R7330 vss.n6294 vss.n2136 51.0209
R7331 vss.n5899 vss.t488 50.848
R7332 vss.n5716 vss.t142 50.848
R7333 vss.n5872 vss.t571 50.848
R7334 vss.n5745 vss.t932 50.848
R7335 vss.n5837 vss.t1293 50.848
R7336 vss.n5777 vss.t1176 50.848
R7337 vss.t73 vss.n276 50.8096
R7338 vss.n4229 vss.t639 50.6029
R7339 vss.t1325 vss.n2745 50.3024
R7340 vss.t509 vss.n4359 50.1497
R7341 vss.n2777 vss.t959 50.1144
R7342 vss.n2767 vss.t596 50.1144
R7343 vss.t977 vss.n3109 50.1119
R7344 vss.n3001 vss.t601 50.1119
R7345 vss.t200 vss.n3081 50.1119
R7346 vss.n3170 vss.t1034 50.1119
R7347 vss.n6072 vss.n3193 50.1119
R7348 vss.n6070 vss.n3050 50.1119
R7349 vss.n6076 vss.t1035 50.1119
R7350 vss.n6068 vss.t1013 50.1119
R7351 vss.n6060 vss.t912 50.1119
R7352 vss.n6092 vss.t2074 50.1119
R7353 vss.n2565 vss.t108 50.0682
R7354 vss.t1091 vss.t1089 50.0005
R7355 vss.t993 vss.t1214 50.0005
R7356 vss.t1067 vss.t1101 50.0005
R7357 vss.t673 vss.t698 50.0005
R7358 vss.t1105 vss.t1063 50.0005
R7359 vss.t963 vss.t714 50.0005
R7360 vss.t1111 vss.t1118 50.0005
R7361 vss.t934 vss.t948 50.0005
R7362 vss.t1128 vss.t1134 50.0005
R7363 vss.t16 vss.t1146 50.0005
R7364 vss.t92 vss.t208 49.3279
R7365 vss.n5903 vss.n28 49.1947
R7366 vss.n5700 vss.n29 49.1947
R7367 vss.n5900 vss.n30 49.1947
R7368 vss.n5897 vss.n31 49.1947
R7369 vss.n5894 vss.n32 49.1947
R7370 vss.n5709 vss.n33 49.1947
R7371 vss.n5712 vss.n34 49.1947
R7372 vss.n5888 vss.n35 49.1947
R7373 vss.n5715 vss.n36 49.1947
R7374 vss.n5718 vss.n37 49.1947
R7375 vss.n5721 vss.n38 49.1947
R7376 vss.n5879 vss.n39 49.1947
R7377 vss.n5876 vss.n40 49.1947
R7378 vss.n5727 vss.n41 49.1947
R7379 vss.n5873 vss.n42 49.1947
R7380 vss.n5870 vss.n43 49.1947
R7381 vss.n5867 vss.n44 49.1947
R7382 vss.n5736 vss.n45 49.1947
R7383 vss.n5741 vss.n46 49.1947
R7384 vss.n5856 vss.n47 49.1947
R7385 vss.n5744 vss.n48 49.1947
R7386 vss.n5747 vss.n49 49.1947
R7387 vss.n5751 vss.n50 49.1947
R7388 vss.n5847 vss.n51 49.1947
R7389 vss.n5841 vss.n52 49.1947
R7390 vss.n5760 vss.n53 49.1947
R7391 vss.n5838 vss.n54 49.1947
R7392 vss.n5835 vss.n55 49.1947
R7393 vss.n5829 vss.n56 49.1947
R7394 vss.n5769 vss.n57 49.1947
R7395 vss.n5773 vss.n58 49.1947
R7396 vss.n5818 vss.n59 49.1947
R7397 vss.n5776 vss.n60 49.1947
R7398 vss.n5779 vss.n61 49.1947
R7399 vss.n5783 vss.n62 49.1947
R7400 vss.n5809 vss.n63 49.1947
R7401 vss.n5803 vss.n64 49.1947
R7402 vss.n5792 vss.n65 49.1947
R7403 vss.n87 vss.n86 27.5491
R7404 vss.n4498 vss.n4319 48.9515
R7405 vss.n4485 vss.n4291 48.9515
R7406 vss.n4520 vss.n1475 48.883
R7407 vss.t257 vss.t515 48.6116
R7408 vss.t909 vss.n2276 48.4415
R7409 vss.n4984 vss.n4803 48.3876
R7410 vss.n4983 vss.n4802 48.3876
R7411 vss.n4982 vss.n4801 48.3876
R7412 vss.n4981 vss.n4800 48.3876
R7413 vss.n4980 vss.n4799 48.3876
R7414 vss.n4979 vss.n4798 48.3876
R7415 vss.n4978 vss.n4797 48.3876
R7416 vss.n4977 vss.n4796 48.3876
R7417 vss.n4976 vss.n4795 48.3876
R7418 vss.n4975 vss.n4794 48.3876
R7419 vss.n4974 vss.n4793 48.3876
R7420 vss.n4973 vss.n4792 48.3876
R7421 vss.n4972 vss.n4791 48.3876
R7422 vss.n4971 vss.n4790 48.3876
R7423 vss.n4970 vss.n4789 48.3876
R7424 vss.n4969 vss.n4788 48.3876
R7425 vss.n4967 vss.n4786 48.3876
R7426 vss.n4966 vss.n4785 48.3876
R7427 vss.n4965 vss.n4784 48.3876
R7428 vss.n4964 vss.n4783 48.3876
R7429 vss.n4963 vss.n4782 48.3876
R7430 vss.n4962 vss.n4781 48.3876
R7431 vss.n4961 vss.n4780 48.3876
R7432 vss.n4960 vss.n4779 48.3876
R7433 vss.n4959 vss.n4778 48.3876
R7434 vss.n4958 vss.n4777 48.3876
R7435 vss.n4957 vss.n4776 48.3876
R7436 vss.n4956 vss.n4775 48.3876
R7437 vss.n4955 vss.n4774 48.3876
R7438 vss.n4954 vss.n4773 48.3876
R7439 vss.n4953 vss.n4772 48.3876
R7440 vss.n4952 vss.n4771 48.3876
R7441 vss.n4951 vss.n4770 48.3876
R7442 vss.n4950 vss.n4769 48.3876
R7443 vss.n4949 vss.n4768 48.3876
R7444 vss.n4948 vss.n4767 48.3876
R7445 vss.n4947 vss.n4766 48.3876
R7446 vss.n4946 vss.n4765 48.3876
R7447 vss.n4945 vss.n4764 48.3876
R7448 vss.n4944 vss.n4763 48.3876
R7449 vss.n4943 vss.n4762 48.3876
R7450 vss.n4942 vss.n4761 48.3876
R7451 vss.n4941 vss.n4760 48.3876
R7452 vss.n4940 vss.n4759 48.3876
R7453 vss.n4939 vss.n4758 48.3876
R7454 vss.n4938 vss.n4757 48.3876
R7455 vss.n4937 vss.n4756 48.3876
R7456 vss.n4936 vss.n4755 48.3876
R7457 vss.n4935 vss.n4754 48.3876
R7458 vss.n4934 vss.n4753 48.3876
R7459 vss.n4933 vss.n4752 48.3876
R7460 vss.n4932 vss.n4751 48.3876
R7461 vss.n4931 vss.n4750 48.3876
R7462 vss.n4930 vss.n4749 48.3876
R7463 vss.n4929 vss.n4748 48.3876
R7464 vss.n4928 vss.n4747 48.3876
R7465 vss.n4927 vss.n4746 48.3876
R7466 vss.n4926 vss.n4745 48.3876
R7467 vss.n4925 vss.n4744 48.3876
R7468 vss.n4924 vss.n4743 48.3876
R7469 vss.n4923 vss.n4742 48.3876
R7470 vss.n4922 vss.n4741 48.3876
R7471 vss.n4921 vss.n4740 48.3876
R7472 vss.n4920 vss.n4739 48.3876
R7473 vss.n4919 vss.n4738 48.3876
R7474 vss.n4918 vss.n4737 48.3876
R7475 vss.n4917 vss.n4736 48.3876
R7476 vss.n4916 vss.n4735 48.3876
R7477 vss.n4915 vss.n4734 48.3876
R7478 vss.n4914 vss.n4733 48.3876
R7479 vss.n4913 vss.n4732 48.3876
R7480 vss.n4912 vss.n4731 48.3876
R7481 vss.n4911 vss.n4730 48.3876
R7482 vss.n4910 vss.n4729 48.3876
R7483 vss.n4909 vss.n4728 48.3876
R7484 vss.n4908 vss.n4727 48.3876
R7485 vss.n4907 vss.n4726 48.3876
R7486 vss.n4906 vss.n4725 48.3876
R7487 vss.n4905 vss.n4724 48.3876
R7488 vss.n4904 vss.n4723 48.3876
R7489 vss.n4903 vss.n4722 48.3876
R7490 vss.n4902 vss.n4721 48.3876
R7491 vss.n4901 vss.n4720 48.3876
R7492 vss.n4900 vss.n4719 48.3876
R7493 vss.n4899 vss.n4718 48.3876
R7494 vss.n4898 vss.n4717 48.3876
R7495 vss.n4897 vss.n4716 48.3876
R7496 vss.n4896 vss.n4715 48.3876
R7497 vss.n4895 vss.n4714 48.3876
R7498 vss.n4894 vss.n4713 48.3876
R7499 vss.n5022 vss.n4712 48.3876
R7500 vss.n4893 vss.n4711 48.3876
R7501 vss.n4892 vss.n4710 48.3876
R7502 vss.n4891 vss.n4709 48.3876
R7503 vss.n4890 vss.n4708 48.3876
R7504 vss.n4889 vss.n4707 48.3876
R7505 vss.n4888 vss.n4706 48.3876
R7506 vss.n4887 vss.n4705 48.3876
R7507 vss.n4886 vss.n4704 48.3876
R7508 vss.n4885 vss.n4703 48.3876
R7509 vss.n4884 vss.n4702 48.3876
R7510 vss.n4883 vss.n4701 48.3876
R7511 vss.n4882 vss.n4700 48.3876
R7512 vss.n4881 vss.n4699 48.3876
R7513 vss.n4880 vss.n4698 48.3876
R7514 vss.n4879 vss.n4697 48.3876
R7515 vss.n4878 vss.n4696 48.3876
R7516 vss.n4877 vss.n4695 48.3876
R7517 vss.n4876 vss.n4694 48.3876
R7518 vss.n4875 vss.n4693 48.3876
R7519 vss.n4874 vss.n4692 48.3876
R7520 vss.n4873 vss.n4691 48.3876
R7521 vss.n4872 vss.n4690 48.3876
R7522 vss.n4871 vss.n4689 48.3876
R7523 vss.n4870 vss.n4688 48.3876
R7524 vss.n4869 vss.n4687 48.3876
R7525 vss.n4868 vss.n4686 48.3876
R7526 vss.n4867 vss.n4685 48.3876
R7527 vss.n4866 vss.n4684 48.3876
R7528 vss.n4865 vss.n4683 48.3876
R7529 vss.n4864 vss.n4682 48.3876
R7530 vss.n4863 vss.n4681 48.3876
R7531 vss.n4862 vss.n4680 48.3876
R7532 vss.n4861 vss.n4679 48.3876
R7533 vss.n4860 vss.n4678 48.3876
R7534 vss.n4859 vss.n4677 48.3876
R7535 vss.n4858 vss.n4676 48.3876
R7536 vss.n4857 vss.n4675 48.3876
R7537 vss.n4856 vss.n4674 48.3876
R7538 vss.n4855 vss.n4673 48.3876
R7539 vss.n4854 vss.n4672 48.3876
R7540 vss.n4853 vss.n4671 48.3876
R7541 vss.n4852 vss.n4670 48.3876
R7542 vss.n4851 vss.n4669 48.3876
R7543 vss.n4850 vss.n4668 48.3876
R7544 vss.n4849 vss.n4667 48.3876
R7545 vss.n4848 vss.n4666 48.3876
R7546 vss.n4847 vss.n4665 48.3876
R7547 vss.n4846 vss.n4664 48.3876
R7548 vss.n4845 vss.n4663 48.3876
R7549 vss.n4844 vss.n4662 48.3876
R7550 vss.n4843 vss.n4661 48.3876
R7551 vss.n4842 vss.n4660 48.3876
R7552 vss.n4841 vss.n4659 48.3876
R7553 vss.n4840 vss.n4658 48.3876
R7554 vss.n4839 vss.n4657 48.3876
R7555 vss.n4838 vss.n4656 48.3876
R7556 vss.n4837 vss.n4655 48.3876
R7557 vss.n4836 vss.n4654 48.3876
R7558 vss.n4835 vss.n4653 48.3876
R7559 vss.n4834 vss.n4652 48.3876
R7560 vss.n4833 vss.n4651 48.3876
R7561 vss.n4832 vss.n4650 48.3876
R7562 vss.n4831 vss.n4649 48.3876
R7563 vss.n4830 vss.n4648 48.3876
R7564 vss.n4829 vss.n4647 48.3876
R7565 vss.n4828 vss.n4646 48.3876
R7566 vss.n4827 vss.n4645 48.3876
R7567 vss.n4826 vss.n4644 48.3876
R7568 vss.t180 vss.n4643 48.3876
R7569 vss.n4825 vss.n4642 48.3876
R7570 vss.n4824 vss.n4641 48.3876
R7571 vss.n4823 vss.n4640 48.3876
R7572 vss.n4822 vss.n4639 48.3876
R7573 vss.n4821 vss.n4638 48.3876
R7574 vss.n4820 vss.n4637 48.3876
R7575 vss.n4819 vss.n4636 48.3876
R7576 vss.n4818 vss.n4635 48.3876
R7577 vss.n4817 vss.n4634 48.3876
R7578 vss.n4816 vss.n4633 48.3876
R7579 vss.n4815 vss.n4632 48.3876
R7580 vss.n4814 vss.n4631 48.3876
R7581 vss.n4813 vss.n4630 48.3876
R7582 vss.n4812 vss.n4629 48.3876
R7583 vss.n4811 vss.n4628 48.3876
R7584 vss.n4810 vss.n4627 48.3876
R7585 vss.n4809 vss.n4626 48.3876
R7586 vss.n4808 vss.n4625 48.3876
R7587 vss.t1243 vss.n5268 48.3703
R7588 vss.n3543 vss.n3534 48.2426
R7589 vss.n1158 vss.t573 47.3689
R7590 vss.t920 vss.n1149 47.3689
R7591 vss.n1341 vss.t922 47.3689
R7592 vss.n1164 vss.t1234 47.3689
R7593 vss.n1167 vss.t615 47.3689
R7594 vss.t108 vss.n2564 47.3618
R7595 vss.n4268 vss.t164 46.9885
R7596 vss.t556 vss.n4205 46.9885
R7597 vss.n3067 vss.n3066 46.7711
R7598 vss.n3171 vss.n3170 46.7711
R7599 vss.n3062 vss.n3061 46.7711
R7600 vss.t2074 vss.n3030 46.7711
R7601 vss.n959 vss.n4448 46.7032
R7602 vss.t2098 vss.n4345 46.6775
R7603 vss.n5926 vss.n4013 46.6107
R7604 vss.t455 vss.n4166 46.6107
R7605 vss.n2446 vss.n1857 46.4401
R7606 vss.n2451 vss.n1861 46.4401
R7607 vss.t747 vss.n2562 46.0086
R7608 vss.n2794 vss.t1431 46.0086
R7609 vss.n1898 vss.t1453 45.6679
R7610 vss.n1921 vss.t1468 45.6679
R7611 vss.n1944 vss.t1483 45.6679
R7612 vss.n1967 vss.t1498 45.6679
R7613 vss.n1990 vss.t1513 45.6679
R7614 vss.n2013 vss.t1528 45.6679
R7615 vss.n4512 vss.n4440 45.455
R7616 vss.n4482 vss.n4423 45.455
R7617 vss.n907 vss.n906 10.8848
R7618 vss.t1348 vss.n4619 45.1618
R7619 vss.t1087 vss.n5267 45.1456
R7620 vss.t215 vss.n2208 45.1007
R7621 vss.t912 vss.n2193 45.1007
R7622 vss.n5275 vss.t1244 45.0343
R7623 vss.n5658 vss.n5657 45.021
R7624 vss.n5681 vss.n5680 45.021
R7625 vss.n5959 vss.n5958 45.021
R7626 vss.n5982 vss.n5981 45.021
R7627 vss.n6004 vss.n6003 45.021
R7628 vss.t991 vss.n5154 44.9107
R7629 vss.n5642 vss.n824 44.8359
R7630 vss.n5665 vss.n817 44.8359
R7631 vss.n5688 vss.n811 44.8359
R7632 vss.n5966 vss.n805 44.8359
R7633 vss.n5989 vss.n799 44.8359
R7634 vss.n4804 vss.n4174 44.6636
R7635 vss.n5038 vss.n68 44.2375
R7636 vss.n906 vss.t780 44.1181
R7637 vss.t739 vss.n905 44.1181
R7638 vss.n2748 vss.t765 44.1181
R7639 vss.t640 vss.n75 44.0263
R7640 vss.n2816 vss.t100 43.4879
R7641 vss.n4607 vss.t640 43.4788
R7642 vss.n5086 vss.t1435 43.4371
R7643 vss.n5086 vss.t735 43.4371
R7644 vss.n3149 vss.t1231 43.4303
R7645 vss.t593 vss.n3074 43.4303
R7646 vss.n3167 vss.t1010 43.4303
R7647 vss.n6049 vss.t832 43.4303
R7648 vss.n5315 vss.n5314 43.4216
R7649 vss.n4221 vss.t1383 43.374
R7650 vss.n2857 vss.n2750 43.3023
R7651 vss.n2937 vss.n2575 43.3023
R7652 vss.n1880 vss.n1573 43.0896
R7653 vss.n1883 vss.n1585 43.0896
R7654 vss.n1894 vss.n1566 43.0896
R7655 vss.n1897 vss.n1599 43.0896
R7656 vss.n1900 vss.n1558 43.0896
R7657 vss.n1903 vss.n1602 43.0896
R7658 vss.n1906 vss.n1554 43.0896
R7659 vss.n1917 vss.n1616 43.0896
R7660 vss.n1920 vss.n1542 43.0896
R7661 vss.n1923 vss.n1621 43.0896
R7662 vss.n1926 vss.n1539 43.0896
R7663 vss.n1929 vss.n1630 43.0896
R7664 vss.n1940 vss.n1527 43.0896
R7665 vss.n1943 vss.n1644 43.0896
R7666 vss.n1946 vss.n1519 43.0896
R7667 vss.n1949 vss.n1647 43.0896
R7668 vss.n1952 vss.n1515 43.0896
R7669 vss.n1963 vss.n1666 43.0896
R7670 vss.n1966 vss.n1508 43.0896
R7671 vss.n1969 vss.n1671 43.0896
R7672 vss.n1972 vss.n1505 43.0896
R7673 vss.n1975 vss.n1680 43.0896
R7674 vss.n1986 vss.n1493 43.0896
R7675 vss.n1989 vss.n1693 43.0896
R7676 vss.n1992 vss.n1490 43.0896
R7677 vss.n1995 vss.n1702 43.0896
R7678 vss.n1998 vss.n1486 43.0896
R7679 vss.n2009 vss.n1721 43.0896
R7680 vss.n2012 vss.n1479 43.0896
R7681 vss.n6397 vss.n630 43.0896
R7682 vss.n6368 vss.n2346 43.0493
R7683 vss.t1031 vss.n2302 42.916
R7684 vss.t1038 vss.n2152 42.916
R7685 vss.t652 vss.n5276 42.4584
R7686 vss.n5803 vss.t986 42.3734
R7687 vss.n4499 vss.n4304 41.9585
R7688 vss.n4502 vss.n962 6.05041
R7689 vss.t44 vss.n5265 41.921
R7690 vss.n5305 vss.t735 41.9198
R7691 vss.t1435 vss.n2318 41.9179
R7692 vss.n4806 vss.n4012 41.8712
R7693 vss.n4805 vss.n4175 41.8712
R7694 vss.n4997 vss.n4176 41.8712
R7695 vss.n4998 vss.n4010 41.8712
R7696 vss.n4996 vss.n4177 41.8712
R7697 vss.n4999 vss.n4009 41.8712
R7698 vss.n4995 vss.n4178 41.8712
R7699 vss.n5000 vss.n4008 41.8712
R7700 vss.n4994 vss.n4179 41.8712
R7701 vss.n5001 vss.n4007 41.8712
R7702 vss.n4993 vss.n4180 41.8712
R7703 vss.n5002 vss.n4006 41.8712
R7704 vss.n4992 vss.n4181 41.8712
R7705 vss.n5003 vss.n4005 41.8712
R7706 vss.n4991 vss.n4182 41.8712
R7707 vss.n4990 vss.n4183 41.8712
R7708 vss.t167 vss.n4003 41.8712
R7709 vss.n4989 vss.n4184 41.8712
R7710 vss.n5005 vss.n4002 41.8712
R7711 vss.n4988 vss.n4185 41.8712
R7712 vss.n5006 vss.n4001 41.8712
R7713 vss.n4987 vss.n4186 41.8712
R7714 vss.n5007 vss.n4000 41.8712
R7715 vss.n4986 vss.n4187 41.8712
R7716 vss.n5008 vss.n3999 41.8712
R7717 vss.n4985 vss.n4188 41.8712
R7718 vss.n5009 vss.n3998 41.8712
R7719 vss.n6021 vss.n6020 41.8712
R7720 vss.n959 vss.n4318 41.8242
R7721 vss.t972 vss.t199 41.76
R7722 vss.t861 vss.n2246 41.76
R7723 vss.t604 vss.n2164 41.76
R7724 vss.t250 vss.n4361 41.6672
R7725 vss.n2775 vss.n2718 41.4168
R7726 vss.n2769 vss.n2737 41.4168
R7727 vss.t897 vss.n2725 41.0028
R7728 vss.t959 vss.n2733 41.0028
R7729 vss.t596 vss.n2714 41.0028
R7730 vss.t902 vss.n2744 41.0028
R7731 vss.n4410 vss.t2121 40.5034
R7732 vss.n2753 vss.n274 40.3459
R7733 vss.t1073 vss.n3093 40.0896
R7734 vss.t859 vss.n3160 40.0896
R7735 vss.n966 vss.n4442 39.6003
R7736 vss.t792 vss.t790 39.5881
R7737 vss.t296 vss.n2863 39.1438
R7738 vss.t292 vss.n2936 39.1438
R7739 vss.n2859 vss.t298 39.1438
R7740 vss.n2932 vss.t294 39.1438
R7741 vss.n5024 vss.n4803 38.7102
R7742 vss.n4968 vss.t170 38.7102
R7743 vss.n4854 vss.t178 38.7102
R7744 vss.n1882 vss.t1443 38.6422
R7745 vss.n1905 vss.t1458 38.6422
R7746 vss.n1928 vss.t1473 38.6422
R7747 vss.n1951 vss.t1488 38.6422
R7748 vss.n1974 vss.t1503 38.6422
R7749 vss.n1997 vss.t1518 38.6422
R7750 vss.n4286 vss.n4 18643.2
R7751 vss.n4509 vss.n4444 38.462
R7752 vss.n4490 vss.n4430 38.462
R7753 vss.t260 vss.n4298 38.462
R7754 vss.n4479 vss.n4461 38.462
R7755 vss.n4529 vss.n4415 38.462
R7756 vss.t1033 vss.n2247 38.4192
R7757 vss.n6172 vss.n192 38.2048
R7758 vss.t540 vss.n4356 38.1949
R7759 vss.n5699 vss.t1121 38.1361
R7760 vss.n5924 vss.n5902 38.1361
R7761 vss.n5889 vss.t1126 38.1361
R7762 vss.n5921 vss.n5713 38.1361
R7763 vss.n5726 vss.t1116 38.1361
R7764 vss.n5918 vss.n5875 38.1361
R7765 vss.n5859 vss.t1102 38.1361
R7766 vss.n5915 vss.n5742 38.1361
R7767 vss.n5757 vss.t1097 38.1361
R7768 vss.n5912 vss.n5840 38.1361
R7769 vss.n5821 vss.t1071 38.1361
R7770 vss.n5909 vss.n5774 38.1361
R7771 vss.n6188 vss.n276 37.5743
R7772 vss.t614 vss.n1163 37.5005
R7773 vss.n5643 vss.t1091 37.5005
R7774 vss.n5666 vss.t1067 37.5005
R7775 vss.n5689 vss.t1105 37.5005
R7776 vss.n5967 vss.t1111 37.5005
R7777 vss.n5990 vss.t1128 37.5005
R7778 vss.t635 vss.n5554 37.5005
R7779 vss.n6010 vss.t1061 37.5005
R7780 vss.t238 vss.n5557 37.5005
R7781 vss.n761 vss.t4 36.9236
R7782 vss.t219 vss.n781 36.9236
R7783 vss.n2987 vss.t1002 36.7852
R7784 vss.n2994 vss.t1031 36.7852
R7785 vss.n6106 vss.t1038 36.7852
R7786 vss.n6119 vss.t1015 36.7852
R7787 vss.n280 vss.t72 36.7827
R7788 vss.n6063 vss.n3040 36.7488
R7789 vss.n6061 vss.n3208 36.7488
R7790 vss.n6059 vss.n3034 36.7488
R7791 vss.n6057 vss.n3213 36.7488
R7792 vss.n5276 vss.t1322 36.5465
R7793 vss.n2886 vss.t67 36.3221
R7794 vss.n2884 vss.t1257 36.3221
R7795 vss.n2823 vss.t1255 36.3221
R7796 vss.n2826 vss.t60 36.3221
R7797 vss.n281 vss.t785 36.2908
R7798 vss.t1395 vss.n5140 35.9286
R7799 vss.n682 vss.n2014 35.5535
R7800 vss.n681 vss.n2015 35.5535
R7801 vss.n680 vss.n2016 35.5535
R7802 vss.n679 vss.n2017 35.5535
R7803 vss.n678 vss.n2018 35.5535
R7804 vss.n677 vss.n2019 35.5535
R7805 vss.n676 vss.n2020 35.5535
R7806 vss.n675 vss.n2021 35.5535
R7807 vss.n674 vss.n2022 35.5535
R7808 vss.n673 vss.n2023 35.5535
R7809 vss.n672 vss.n2024 35.5535
R7810 vss.n671 vss.n2025 35.5535
R7811 vss.n670 vss.n2026 35.5535
R7812 vss.n669 vss.n2027 35.5535
R7813 vss.n668 vss.n2028 35.5535
R7814 vss.n667 vss.n2029 35.5535
R7815 vss.n666 vss.n2030 35.5535
R7816 vss.n665 vss.n2031 35.5535
R7817 vss.n664 vss.n2032 35.5535
R7818 vss.n663 vss.n2033 35.5535
R7819 vss.n662 vss.n2034 35.5535
R7820 vss.n661 vss.n2035 35.5535
R7821 vss.n660 vss.n2036 35.5535
R7822 vss.n659 vss.n2037 35.5535
R7823 vss.n658 vss.n2038 35.5535
R7824 vss.n655 vss.n2039 35.5535
R7825 vss.t1235 vss.n1166 35.5268
R7826 vss.t615 vss.t1237 35.5268
R7827 vss.n1174 vss.t463 35.0202
R7828 vss.n1215 vss.t841 35.0202
R7829 vss.n3179 vss.n2233 34.9692
R7830 vss.n3058 vss.n2230 34.9692
R7831 vss.t490 vss.n4414 34.9655
R7832 vss.n272 vss.t749 34.9261
R7833 vss.n271 vss.t755 30.2351
R7834 vss.n4394 vss.t153 34.7227
R7835 vss.t2099 vss.t822 34.3845
R7836 vss.t994 vss.t795 34.3845
R7837 vss.t480 vss.t223 34.3845
R7838 vss.t548 vss.t54 34.3845
R7839 vss.t236 vss.t520 34.3845
R7840 vss.n656 vss.n2040 34.0546
R7841 vss.n657 vss.n2041 34.0546
R7842 vss.n2092 vss.n2042 34.0546
R7843 vss.n2093 vss.n2043 34.0546
R7844 vss.n2094 vss.n2044 34.0546
R7845 vss.n2095 vss.n2045 34.0546
R7846 vss.n2096 vss.n2046 34.0546
R7847 vss.n2097 vss.n2047 34.0546
R7848 vss.n2098 vss.n2048 34.0546
R7849 vss.n5697 vss.n4014 33.8988
R7850 vss.n5703 vss.n4024 33.8988
R7851 vss.n5706 vss.n4030 33.8988
R7852 vss.n5891 vss.n4038 33.8988
R7853 vss.n5885 vss.n4048 33.8988
R7854 vss.n5882 vss.n4054 33.8988
R7855 vss.n5724 vss.n4062 33.8988
R7856 vss.n5730 vss.n4072 33.8988
R7857 vss.n5733 vss.n4078 33.8988
R7858 vss.n5864 vss.n4086 33.8988
R7859 vss.n5853 vss.n4096 33.8988
R7860 vss.n5850 vss.n4102 33.8988
R7861 vss.n5754 vss.n4110 33.8988
R7862 vss.n5763 vss.n4120 33.8988
R7863 vss.n5766 vss.n4126 33.8988
R7864 vss.n5826 vss.n4134 33.8988
R7865 vss.n5815 vss.n4144 33.8988
R7866 vss.n5812 vss.n4150 33.8988
R7867 vss.n5786 vss.n4158 33.8988
R7868 vss.n5789 vss.t1276 33.8988
R7869 vss.n5800 vss.n4166 33.8988
R7870 vss.n1356 vss.t614 33.5531
R7871 vss.n5077 vss.t677 33.5531
R7872 vss.n5529 vss.n5528 33.5316
R7873 vss.n282 vss.t70 33.5303
R7874 vss.n3107 vss.n3106 33.4081
R7875 vss.n3086 vss.n3085 33.4081
R7876 vss.n3159 vss.n3158 33.4081
R7877 vss.n3163 vss.n3162 33.4081
R7878 vss.n3065 vss.n3064 33.4081
R7879 vss.n3176 vss.n3175 33.4081
R7880 vss.n6133 vss.n6132 33.4081
R7881 vss.t1290 vss.n5642 33.3338
R7882 vss.t650 vss.n5665 33.3338
R7883 vss.t711 vss.n5688 33.3338
R7884 vss.t681 vss.n5966 33.3338
R7885 vss.t1053 vss.n5989 33.3338
R7886 vss.t304 vss.n6173 33.3307
R7887 vss.n6179 vss.t306 33.3307
R7888 vss.t308 vss.n6181 33.3307
R7889 vss.n6187 vss.t310 33.3307
R7890 vss.t733 vss.n2221 33.2988
R7891 vss.n194 vss.t61 33.1619
R7892 vss.n278 vss.t110 33.161
R7893 vss.n5024 vss.n1024 33.0563
R7894 vss.t1864 vss.n3230 33.0335
R7895 vss.n5117 vss.t1196 32.9346
R7896 vss.n5127 vss.t1021 32.9346
R7897 vss.t1043 vss.n5149 32.9346
R7898 vss.n1308 vss.n735 32.5797
R7899 vss.n1306 vss.n733 32.5797
R7900 vss.n1391 vss.n737 32.5797
R7901 vss.n1299 vss.n768 32.5797
R7902 vss.n1397 vss.n764 32.5797
R7903 vss.n1399 vss.n770 32.5797
R7904 vss.n1294 vss.n762 32.5797
R7905 vss.n1290 vss.n774 32.5797
R7906 vss.n1409 vss.n776 32.5797
R7907 vss.n1413 vss.n756 32.5797
R7908 vss.n1416 vss.n778 32.5797
R7909 vss.n1279 vss.n754 32.5797
R7910 vss.n1423 vss.n782 32.5797
R7911 vss.n1272 vss.n750 32.5797
R7912 vss.n1428 vss.n748 32.5797
R7913 vss.t609 vss.n791 32.5797
R7914 vss.n1434 vss.n789 32.5797
R7915 vss.n1436 vss.n793 32.5797
R7916 vss.n2857 vss.n281 32.5103
R7917 vss.t983 vss.n6174 32.5039
R7918 vss.n6178 vss.t197 32.5039
R7919 vss.t907 vss.n6182 32.5039
R7920 vss.n6186 vss.t1220 32.5039
R7921 vss.n2793 vss.n2792 32.4768
R7922 vss.t384 vss.t393 32.3443
R7923 vss.n6405 vss.n6404 32.2247
R7924 vss.t66 vss.n269 32.2245
R7925 vss.n3230 vss.t1861 31.8933
R7926 vss.n2789 vss.t897 31.8912
R7927 vss.n2755 vss.t902 31.8912
R7928 vss.n6036 vss.t1864 31.8365
R7929 vss.n266 vss.n360 31.8273
R7930 vss.n264 vss.n358 31.8273
R7931 vss.n263 vss.n357 31.8273
R7932 vss.n262 vss.n356 31.8273
R7933 vss.n261 vss.n355 31.8273
R7934 vss.n259 vss.n353 31.8273
R7935 vss.n258 vss.n352 31.8273
R7936 vss.n256 vss.n350 31.8273
R7937 vss.n255 vss.n349 31.8273
R7938 vss.n254 vss.n348 31.8273
R7939 vss.n253 vss.n347 31.8273
R7940 vss.n251 vss.n345 31.8273
R7941 vss.n250 vss.n344 31.8273
R7942 vss.n249 vss.n343 31.8273
R7943 vss.n248 vss.n342 31.8273
R7944 vss.n247 vss.n341 31.8273
R7945 vss.n246 vss.n340 31.8273
R7946 vss.n245 vss.n339 31.8273
R7947 vss.n244 vss.n338 31.8273
R7948 vss.n242 vss.n336 31.8273
R7949 vss.n241 vss.n335 31.8273
R7950 vss.n239 vss.n333 31.8273
R7951 vss.n238 vss.n332 31.8273
R7952 vss.n237 vss.n331 31.8273
R7953 vss.n236 vss.n330 31.8273
R7954 vss.n234 vss.n328 31.8273
R7955 vss.n233 vss.n327 31.8273
R7956 vss.n231 vss.n325 31.8273
R7957 vss.n230 vss.n324 31.8273
R7958 vss.n229 vss.n323 31.8273
R7959 vss.n228 vss.n322 31.8273
R7960 vss.n227 vss.n321 31.8273
R7961 vss.n226 vss.n320 31.8273
R7962 vss.n225 vss.n319 31.8273
R7963 vss.n223 vss.n317 31.8273
R7964 vss.n222 vss.n316 31.8273
R7965 vss.n220 vss.n314 31.8273
R7966 vss.n219 vss.n313 31.8273
R7967 vss.n218 vss.n312 31.8273
R7968 vss.n217 vss.n311 31.8273
R7969 vss.n216 vss.n310 31.8273
R7970 vss.n215 vss.n309 31.8273
R7971 vss.n214 vss.n308 31.8273
R7972 vss.n212 vss.n306 31.8273
R7973 vss.n211 vss.n305 31.8273
R7974 vss.n209 vss.n303 31.8273
R7975 vss.n208 vss.n302 31.8273
R7976 vss.n207 vss.n301 31.8273
R7977 vss.n206 vss.n300 31.8273
R7978 vss.n205 vss.n299 31.8273
R7979 vss.n204 vss.n298 31.8273
R7980 vss.n203 vss.n297 31.8273
R7981 vss.n201 vss.n295 31.8273
R7982 vss.n200 vss.n294 31.8273
R7983 vss.n198 vss.n292 31.8273
R7984 vss.n197 vss.n291 31.8273
R7985 vss.n196 vss.n290 31.8273
R7986 vss.n195 vss.n289 31.8273
R7987 vss.n196 vss.n289 31.8273
R7988 vss.n197 vss.n290 31.8273
R7989 vss.n198 vss.n291 31.8273
R7990 vss.n199 vss.n292 31.8273
R7991 vss.n199 vss.n293 31.8273
R7992 vss.n200 vss.n293 31.8273
R7993 vss.n201 vss.n294 31.8273
R7994 vss.n202 vss.n295 31.8273
R7995 vss.n202 vss.n296 31.8273
R7996 vss.n203 vss.n296 31.8273
R7997 vss.n204 vss.n297 31.8273
R7998 vss.n205 vss.n298 31.8273
R7999 vss.n206 vss.n299 31.8273
R8000 vss.n207 vss.n300 31.8273
R8001 vss.n208 vss.n301 31.8273
R8002 vss.n209 vss.n302 31.8273
R8003 vss.n210 vss.n303 31.8273
R8004 vss.n210 vss.n304 31.8273
R8005 vss.n211 vss.n304 31.8273
R8006 vss.n212 vss.n305 31.8273
R8007 vss.n213 vss.n306 31.8273
R8008 vss.n213 vss.n307 31.8273
R8009 vss.n214 vss.n307 31.8273
R8010 vss.n215 vss.n308 31.8273
R8011 vss.n216 vss.n309 31.8273
R8012 vss.n217 vss.n310 31.8273
R8013 vss.n218 vss.n311 31.8273
R8014 vss.n219 vss.n312 31.8273
R8015 vss.n220 vss.n313 31.8273
R8016 vss.n221 vss.n314 31.8273
R8017 vss.n221 vss.n315 31.8273
R8018 vss.n222 vss.n315 31.8273
R8019 vss.n223 vss.n316 31.8273
R8020 vss.n224 vss.n317 31.8273
R8021 vss.n224 vss.n318 31.8273
R8022 vss.n225 vss.n318 31.8273
R8023 vss.n226 vss.n319 31.8273
R8024 vss.n227 vss.n320 31.8273
R8025 vss.n228 vss.n321 31.8273
R8026 vss.n229 vss.n322 31.8273
R8027 vss.n230 vss.n323 31.8273
R8028 vss.n231 vss.n324 31.8273
R8029 vss.n232 vss.n325 31.8273
R8030 vss.n232 vss.n326 31.8273
R8031 vss.n233 vss.n326 31.8273
R8032 vss.n234 vss.n327 31.8273
R8033 vss.n235 vss.n328 31.8273
R8034 vss.n235 vss.n329 31.8273
R8035 vss.n236 vss.n329 31.8273
R8036 vss.n237 vss.n330 31.8273
R8037 vss.n238 vss.n331 31.8273
R8038 vss.n239 vss.n332 31.8273
R8039 vss.n240 vss.n333 31.8273
R8040 vss.n240 vss.n334 31.8273
R8041 vss.n241 vss.n334 31.8273
R8042 vss.n242 vss.n335 31.8273
R8043 vss.n243 vss.n336 31.8273
R8044 vss.n243 vss.n337 31.8273
R8045 vss.n244 vss.n337 31.8273
R8046 vss.n245 vss.n338 31.8273
R8047 vss.n246 vss.n339 31.8273
R8048 vss.n247 vss.n340 31.8273
R8049 vss.n248 vss.n341 31.8273
R8050 vss.n249 vss.n342 31.8273
R8051 vss.n250 vss.n343 31.8273
R8052 vss.n251 vss.n344 31.8273
R8053 vss.n252 vss.n345 31.8273
R8054 vss.n252 vss.n346 31.8273
R8055 vss.n253 vss.n346 31.8273
R8056 vss.n254 vss.n347 31.8273
R8057 vss.n255 vss.n348 31.8273
R8058 vss.n256 vss.n349 31.8273
R8059 vss.n257 vss.n350 31.8273
R8060 vss.n257 vss.n351 31.8273
R8061 vss.n258 vss.n351 31.8273
R8062 vss.n259 vss.n352 31.8273
R8063 vss.n260 vss.n353 31.8273
R8064 vss.n260 vss.n354 31.8273
R8065 vss.n261 vss.n354 31.8273
R8066 vss.n262 vss.n355 31.8273
R8067 vss.n263 vss.n356 31.8273
R8068 vss.n264 vss.n357 31.8273
R8069 vss.n265 vss.n358 31.8273
R8070 vss.n265 vss.n359 31.8273
R8071 vss.n266 vss.n359 31.8273
R8072 vss.t251 vss.n3115 31.7377
R8073 vss.t1018 vss.n2226 31.7377
R8074 vss.n3057 vss.n2227 31.6284
R8075 vss.n3188 vss.n2224 31.6284
R8076 vss.n3053 vss.n2221 31.6284
R8077 vss.n4513 vss.n4439 31.469
R8078 vss.n4489 vss.n4454 31.469
R8079 vss.n4528 vss.n4468 31.469
R8080 vss.n1030 vss.n5021 31.4105
R8081 vss.t20 vss.n4347 31.2505
R8082 vss.n2535 vss.n361 30.7079
R8083 vss.n6190 vss.n2694 30.7079
R8084 vss.t1002 vss.n2314 30.6545
R8085 vss.t1015 vss.n2140 30.6545
R8086 vss.n2355 vss.n2091 30.6127
R8087 vss.t891 vss.n771 30.4077
R8088 vss.n1403 vss.t385 30.4077
R8089 vss.n1276 vss.t405 30.4077
R8090 vss.n751 vss.t623 30.4077
R8091 vss.t1535 vss.n1866 30.1863
R8092 vss.n5118 vss.t1198 30.1728
R8093 vss.n5128 vss.t1023 30.1728
R8094 vss.t1041 vss.n5146 30.1728
R8095 vss.t199 vss.n3125 30.0673
R8096 vss.n3002 vss.t910 30.0673
R8097 vss.t1231 vss.n3148 30.0673
R8098 vss.n3075 vss.t593 30.0673
R8099 vss.n3061 vss.t1011 30.0673
R8100 vss.n3183 vss.t1040 30.0673
R8101 vss.n3056 vss.t1018 30.0673
R8102 vss.n6074 vss.t1012 30.0673
R8103 vss.n6071 vss.n3051 30.0673
R8104 vss.n6069 vss.n3200 30.0673
R8105 vss.n6067 vss.n3046 30.0673
R8106 vss.n6066 vss.t1036 30.0673
R8107 vss.n6065 vss.n3202 30.0673
R8108 vss.n6058 vss.t599 30.0673
R8109 vss.n6090 vss.t202 30.0673
R8110 vss.n6098 vss.t913 30.0673
R8111 vss.n4521 vss.n4520 30.0164
R8112 vss.t50 vss.n2233 29.958
R8113 vss.t1297 vss.n5111 29.9406
R8114 vss.n5161 vss.t1150 29.9406
R8115 vss.t523 vss.n4030 29.6615
R8116 vss.t631 vss.n4054 29.6615
R8117 vss.t928 vss.n4078 29.6615
R8118 vss.t1309 vss.n4102 29.6615
R8119 vss.t1248 vss.n4126 29.6615
R8120 vss.t1251 vss.n4150 29.6615
R8121 vss.n4159 vss.t1277 29.6615
R8122 vss.t102 vss.n2580 29.6223
R8123 vss.t1244 vss.n5272 29.5961
R8124 vss.n4271 vss.n75 29.5336
R8125 vss.n4614 vss.n73 29.5333
R8126 vss.n4240 vss.n83 29.4945
R8127 vss.n4237 vss.n82 29.4945
R8128 vss.n4256 vss.n80 29.4945
R8129 vss.n4265 vss.n79 29.4945
R8130 vss.n4270 vss.n77 29.4945
R8131 vss.n4345 vss.t257 29.3164
R8132 vss.n6038 vss.t1861 29.2767
R8133 vss.n6015 vss.n5552 29.2181
R8134 vss.n5047 vss.n1474 29.2058
R8135 vss.n4606 vss.n4191 29.1125
R8136 vss.t172 vss.n4758 29.0328
R8137 vss.n5307 vss.n5306 29.0016
R8138 vss.n6379 vss.n2321 28.997
R8139 vss.n3902 vss.n3891 28.997
R8140 vss.n3900 vss.n3890 28.997
R8141 vss.n3882 vss.n3878 28.997
R8142 vss.t741 vss.n904 28.9921
R8143 vss.t1253 vss.n2578 28.9921
R8144 vss.n2749 vss.t763 28.9921
R8145 vss.n88 vss.n2370 697.561
R8146 vss.n195 vss.n2137 28.4782
R8147 vss.t804 vss.t952 28.4541
R8148 vss.n2995 vss.n2297 28.3969
R8149 vss.n3115 vss.n2295 28.3969
R8150 vss.n3119 vss.n2294 28.3969
R8151 vss.n2996 vss.n2293 28.3969
R8152 vss.n3121 vss.n2291 28.3969
R8153 vss.t253 vss.n3121 28.3969
R8154 vss.n3109 vss.n2290 28.3969
R8155 vss.n2997 vss.n2289 28.3969
R8156 vss.n3106 vss.n2287 28.3969
R8157 vss.n3125 vss.n2286 28.3969
R8158 vss.n2998 vss.n2285 28.3969
R8159 vss.t600 vss.n2280 28.3969
R8160 vss.t1040 vss.n2228 28.3969
R8161 vss.n6097 vss.n2169 28.3969
R8162 vss.n6048 vss.n2168 28.3969
R8163 vss.n6098 vss.n2167 28.3969
R8164 vss.n6099 vss.n2165 28.3969
R8165 vss.n6046 vss.n2164 28.3969
R8166 vss.n6100 vss.n2163 28.3969
R8167 vss.n6101 vss.n2161 28.3969
R8168 vss.n6129 vss.n2160 28.3969
R8169 vss.n6102 vss.n2159 28.3969
R8170 vss.n6044 vss.n2158 28.3969
R8171 vss.n6103 vss.n2157 28.3969
R8172 vss.n6043 vss.n2156 28.3969
R8173 vss.n6128 vss.n2155 28.3969
R8174 vss.t391 vss.n757 28.2358
R8175 vss.t394 vss.n777 28.2358
R8176 vss.n6034 vss.n2138 28.1153
R8177 vss.n1886 vss.n1570 28.1035
R8178 vss.n1890 vss.n1588 28.1035
R8179 vss.n1909 vss.n1607 28.1035
R8180 vss.n1913 vss.n1546 28.1035
R8181 vss.n1932 vss.n1531 28.1035
R8182 vss.n1936 vss.n1635 28.1035
R8183 vss.n1955 vss.n1652 28.1035
R8184 vss.n1959 vss.n1512 28.1035
R8185 vss.n1978 vss.n1497 28.1035
R8186 vss.n1982 vss.n1685 28.1035
R8187 vss.n2001 vss.n1707 28.1035
R8188 vss.n2005 vss.n1483 28.1035
R8189 vss.t1295 vss.n5106 28.0287
R8190 vss.n5162 vss.t1152 28.0287
R8191 vss.n4515 vss.n4514 27.9725
R8192 vss.n4502 vss.n4302 27.9725
R8193 vss.t196 vss.n6175 27.8395
R8194 vss.n6177 vss.t984 27.8395
R8195 vss.t1219 vss.n6183 27.8395
R8196 vss.n6185 vss.t908 27.8395
R8197 vss.t1322 vss.n5275 27.8371
R8198 vss.t517 vss.n4343 27.7783
R8199 vss.t534 vss.n4402 27.7783
R8200 vss.n6401 vss.n6400 27.7193
R8201 vss.n2774 vss.n2735 27.3354
R8202 vss.n2773 vss.n2717 27.3354
R8203 vss.n2771 vss.n2736 27.3354
R8204 vss.n2770 vss.n2716 27.3354
R8205 vss.n6306 vss.n2471 27.1094
R8206 vss.n6311 vss.n6310 27.0005
R8207 vss.n3959 vss.n3958 27.0005
R8208 vss.n6263 vss.n6261 27.0005
R8209 vss.n6260 vss.n6259 27.0005
R8210 vss.n6239 vss.n6238 27.0005
R8211 vss.n2672 vss.n2666 27.0005
R8212 vss.n3797 vss.n3796 27.0005
R8213 vss.n3885 vss.n3876 27.0005
R8214 vss.n3920 vss.n3919 27.0005
R8215 vss.n3923 vss.n3922 27.0005
R8216 vss.n3943 vss.n3942 27.0005
R8217 vss.n3979 vss.n3977 27.0005
R8218 vss.n6015 vss.n6014 27.0005
R8219 vss.n5323 vss.n5322 27.0005
R8220 vss.n5055 vss.n5054 27.0005
R8221 vss.n5325 vss.n5324 27.0005
R8222 vss.n5065 vss.n5046 27.0005
R8223 vss.n2340 vss.n2330 27.0005
R8224 vss.n6377 vss.n6376 27.0005
R8225 vss.n6388 vss.n6387 27.0005
R8226 vss.n6390 vss.n6389 27.0005
R8227 vss.n2349 vss.n2329 27.0005
R8228 vss.n2527 vss.n2526 27.0005
R8229 vss.n2525 vss.n2524 27.0005
R8230 vss.n2516 vss.n2515 27.0005
R8231 vss.n2498 vss.n2490 27.0005
R8232 vss.n2540 vss.n2539 27.0005
R8233 vss.n2542 vss.n2541 27.0005
R8234 vss.n2480 vss.n2472 27.0005
R8235 vss.n2554 vss.n2553 27.0005
R8236 vss.n2593 vss.n2555 27.0005
R8237 vss.n6304 vss.n6303 27.0005
R8238 vss.n5359 vss.n1471 27.0005
R8239 vss.n3976 vss.n3975 27.0005
R8240 vss.n3875 vss.n3874 27.0005
R8241 vss.n3857 vss.n3856 27.0005
R8242 vss.n3850 vss.n3750 27.0005
R8243 vss.n3833 vss.n3832 27.0005
R8244 vss.n3831 vss.n3830 27.0005
R8245 vss.n3814 vss.n3813 27.0005
R8246 vss.n6338 vss.t2322 26.9144
R8247 vss.n6319 vss.t2373 26.9134
R8248 vss.t530 vss.n3152 26.7266
R8249 vss.t203 vss.n3220 26.7266
R8250 vss.t61 vss.n193 26.699
R8251 vss.t110 vss.n279 26.6987
R8252 vss.t2106 vss.n769 26.0638
R8253 vss.t619 vss.n758 26.0638
R8254 vss.n749 vss.t2108 26.0638
R8255 vss.n6293 vss.n2096 25.9464
R8256 vss.n952 vss.n4459 25.7241
R8257 vss.n5004 vss.t2060 25.7106
R8258 vss.t1420 vss.n4191 25.5831
R8259 vss.t1540 vss.n1873 25.5423
R8260 vss.t1419 vss.n4218 25.3017
R8261 vss.t164 vss.n4207 25.3017
R8262 vss.n3871 vss.n362 25.2322
R8263 vss.n2937 vss.n2576 25.2106
R8264 vss.n2797 vss.n2566 25.2059
R8265 vss.n2798 vss.n2567 25.2059
R8266 vss.n2803 vss.n2571 25.2059
R8267 vss.n2806 vss.n2574 25.2059
R8268 vss.n2807 vss.n2574 25.2059
R8269 vss.n2804 vss.n2572 25.2059
R8270 vss.n2804 vss.n2571 25.2059
R8271 vss.n2803 vss.n2570 25.2059
R8272 vss.n2800 vss.n2569 25.2059
R8273 vss.n2798 vss.n2566 25.2059
R8274 vss.n2796 vss.n2563 25.2059
R8275 vss.n5289 vss.n5252 25.0798
R8276 vss.n3003 vss.n2264 25.0562
R8277 vss.n3148 vss.n2263 25.0562
R8278 vss.n3085 vss.n2262 25.0562
R8279 vss.n3004 vss.n2260 25.0562
R8280 vss.n3081 vss.n2259 25.0562
R8281 vss.n3152 vss.n2258 25.0562
R8282 vss.n3005 vss.n2256 25.0562
R8283 vss.n3154 vss.n2255 25.0562
R8284 vss.n3076 vss.n2254 25.0562
R8285 vss.n3006 vss.n2252 25.0562
R8286 vss.n3074 vss.n2251 25.0562
R8287 vss.n3158 vss.n2250 25.0562
R8288 vss.n6081 vss.n2203 25.0562
R8289 vss.n6064 vss.n2202 25.0562
R8290 vss.n6063 vss.n2200 25.0562
R8291 vss.n6083 vss.n2199 25.0562
R8292 vss.n6062 vss.n2198 25.0562
R8293 vss.t598 vss.n2197 25.0562
R8294 vss.n6061 vss.n2196 25.0562
R8295 vss.n6085 vss.n2195 25.0562
R8296 vss.n6060 vss.n2194 25.0562
R8297 vss.n6059 vss.n2192 25.0562
R8298 vss.n6087 vss.n2191 25.0562
R8299 vss.n6058 vss.n2190 25.0562
R8300 vss.n6057 vss.n2188 25.0562
R8301 vss.t798 vss.n2224 24.9469
R8302 vss.n5201 vss.n1410 24.5442
R8303 vss.n4508 vss.n4445 24.476
R8304 vss.n4491 vss.n4429 24.476
R8305 vss.n4493 vss.n4427 24.476
R8306 vss.n4473 vss.n4464 24.476
R8307 vss.n4530 vss.n4414 24.476
R8308 vss.n3526 vss.t211 24.4617
R8309 vss.n2751 vss.t761 24.3577
R8310 vss.t743 vss.n903 24.3577
R8311 vss.n2805 vss.t59 24.3577
R8312 vss.n5474 vss.n8 4.29696
R8313 vss.t940 vss.t367 23.8919
R8314 vss.t387 vss.n775 23.8919
R8315 vss.n755 vss.t403 23.8919
R8316 vss.t398 vss.t895 23.8919
R8317 vss.n2586 vss.n2585 23.81
R8318 vss.n2689 vss.n2637 23.81
R8319 vss.n1348 vss.n1155 23.6847
R8320 vss.t918 vss.n1158 23.6847
R8321 vss.n1352 vss.n1151 23.6847
R8322 vss.n1344 vss.t920 23.6847
R8323 vss.n1354 vss.n1161 23.6847
R8324 vss.n1341 vss.n1147 23.6847
R8325 vss.n1339 vss.n1164 23.6847
R8326 vss.n1358 vss.n1143 23.6847
R8327 vss.t1236 vss.n1141 23.6847
R8328 vss.n1361 vss.n1167 23.6847
R8329 vss.n1335 vss.n1139 23.6847
R8330 vss.t763 vss.n280 23.5477
R8331 vss.n2453 vss.n1865 23.4159
R8332 vss.n2439 vss.n1868 23.4159
R8333 vss.n2461 vss.n1871 23.4159
R8334 vss.n2436 vss.n1874 23.4159
R8335 vss.n2467 vss.n1877 23.4159
R8336 vss.n3110 vss.t977 23.3858
R8337 vss.n3082 vss.t200 23.3858
R8338 vss.t563 vss.n3076 23.3858
R8339 vss.n3069 vss.t1033 23.3858
R8340 vss.n6176 vss.t196 23.1751
R8341 vss.t984 vss.n6176 23.1751
R8342 vss.n6184 vss.t1219 23.1751
R8343 vss.t908 vss.n6184 23.1751
R8344 vss.t72 vss.n275 23.0798
R8345 vss.n5283 vss.t717 22.9798
R8346 vss.n2781 vss.t898 22.7795
R8347 vss.n2763 vss.t901 22.7795
R8348 vss.n4807 vss.t436 22.7723
R8349 vss.t2063 vss.n2 22.5911
R8350 vss.n451 vss.t1191 22.5275
R8351 vss.t1438 vss.n443 22.5275
R8352 vss.n446 vss.t135 22.5275
R8353 vss.t715 vss.n439 22.5146
R8354 vss.t453 vss.n441 22.5146
R8355 vss.n449 vss.t628 22.5146
R8356 vss.n450 vss.t585 22.5136
R8357 vss.n448 vss.t139 22.5136
R8358 vss.t1385 vss.n440 22.5136
R8359 vss.t473 vss.n458 22.5275
R8360 vss.t208 vss.t94 22.422
R8361 vss.n6188 vss.n279 22.2872
R8362 vss.n5277 vss.t652 21.9243
R8363 vss.n3554 vss.t1335 21.9041
R8364 vss.n3559 vss.t1337 21.9041
R8365 vss.n3536 vss.t1336 21.9041
R8366 vss.n3550 vss.t1432 21.9041
R8367 vss.n1175 vss.n1174 21.8065
R8368 vss.n1216 vss.n1215 21.8065
R8369 vss.n3572 vss.t847 21.7311
R8370 vss.n3566 vss.t849 21.7311
R8371 vss.n1393 vss.t377 21.72
R8372 vss.n1302 vss.t382 21.72
R8373 vss.n1430 vss.t410 21.72
R8374 vss.n1266 vss.t407 21.72
R8375 vss.n3118 vss.n2296 21.7154
R8376 vss.n3112 vss.n2292 21.7154
R8377 vss.n3124 vss.n2288 21.7154
R8378 vss.n3105 vss.n2284 21.7154
R8379 vss.n3149 vss.n2264 21.7154
R8380 vss.n3155 vss.n2256 21.7154
R8381 vss.n3161 vss.n2248 21.7154
R8382 vss.n3067 vss.n2244 21.7154
R8383 vss.n3171 vss.n2240 21.7154
R8384 vss.n3062 vss.n2236 21.7154
R8385 vss.t1011 vss.n2235 21.7154
R8386 vss.n3184 vss.n2696 21.7154
R8387 vss.t1012 vss.n2218 21.7154
R8388 vss.n3200 vss.n2213 21.7154
R8389 vss.n3046 vss.n2209 21.7154
R8390 vss.n3202 vss.n2205 21.7154
R8391 vss.n3206 vss.n2201 21.7154
R8392 vss.n3037 vss.n2197 21.7154
R8393 vss.n3033 vss.n2189 21.7154
R8394 vss.n3214 vss.n2185 21.7154
R8395 vss.n3030 vss.n2181 21.7154
R8396 vss.n3220 vss.n2177 21.7154
R8397 vss.n3021 vss.n2173 21.7154
R8398 vss.n3223 vss.n2169 21.7154
R8399 vss.n3014 vss.n2165 21.7154
R8400 vss.n6130 vss.n2161 21.7154
R8401 vss.t914 vss.n2160 21.7154
R8402 vss.n5077 vss.n1333 21.711
R8403 vss.n4227 vss.t24 21.6872
R8404 vss.t688 vss.n4224 21.6872
R8405 vss.n6172 vss.n193 21.6563
R8406 vss.t255 vss.n2230 21.6061
R8407 vss.n3587 vss.t341 21.5005
R8408 vss.n3586 vss.t339 21.5005
R8409 vss.n3585 vss.t337 21.5005
R8410 vss.n3576 vss.t845 21.5005
R8411 vss.n3577 vss.t347 21.5005
R8412 vss.n3571 vss.t848 21.5005
R8413 vss.n3570 vss.t350 21.5005
R8414 vss.n3565 vss.t850 21.5005
R8415 vss.n3564 vss.t353 21.5005
R8416 vss.n3554 vss.t851 21.5005
R8417 vss.n3556 vss.t852 21.5005
R8418 vss.n3557 vss.t356 21.5005
R8419 vss.n3547 vss.t365 21.5005
R8420 vss.n3548 vss.t361 21.5005
R8421 vss.t759 vss.n283 21.3519
R8422 vss.n5950 vss.n5949 21.2609
R8423 vss.t641 vss.n4197 21.177
R8424 vss.t6 vss.n784 21.177
R8425 vss.n4477 vss.n4338 20.9795
R8426 vss.t591 vss.n5121 20.9586
R8427 vss.t37 vss.n5131 20.9586
R8428 vss.n5145 vss.t1205 20.9586
R8429 vss.t837 vss.n5153 20.9586
R8430 vss.n4385 vss.t151 20.8338
R8431 vss.n4804 vss.n70 20.1815
R8432 vss.t68 vss.n269 20.0482
R8433 vss.n5081 vss.n2298 20.045
R8434 vss.n3131 vss.n3130 20.045
R8435 vss.n3140 vss.n3139 20.045
R8436 vss.n3094 vss.t1073 20.045
R8437 vss.n3092 vss.n3091 20.045
R8438 vss.n3058 vss.t1183 20.045
R8439 vss.n3188 vss.t1184 20.045
R8440 vss.n3224 vss.t604 20.045
R8441 vss.t726 vss.n3224 20.045
R8442 vss.n180 vss.n11 19.8971
R8443 vss.t921 vss.t7 19.7373
R8444 vss.n1388 vss.n735 19.548
R8445 vss.n1388 vss.n733 19.548
R8446 vss.n1304 vss.n767 19.548
R8447 vss.n1395 vss.n768 19.548
R8448 vss.n1297 vss.n764 19.548
R8449 vss.n1401 vss.n772 19.548
R8450 vss.t31 vss.n772 19.548
R8451 vss.n1405 vss.n760 19.548
R8452 vss.n1405 vss.n774 19.548
R8453 vss.n1288 vss.n758 19.548
R8454 vss.n1411 vss.n757 19.548
R8455 vss.n1418 vss.n754 19.548
R8456 vss.t642 vss.n752 19.548
R8457 vss.n1274 vss.n752 19.548
R8458 vss.n1425 vss.n784 19.548
R8459 vss.n1268 vss.n748 19.548
R8460 vss.n1432 vss.n747 19.548
R8461 vss.n1262 vss.n789 19.548
R8462 vss.n1262 vss.n793 19.548
R8463 vss.n3692 vss.t1307 19.5005
R8464 vss.n3691 vss.t213 19.5005
R8465 vss.n3395 vss.t672 19.5005
R8466 vss.n3401 vss.t1227 19.5005
R8467 vss.n3592 vss.t1376 19.5005
R8468 vss.n3500 vss.t1265 19.5005
R8469 vss.n3618 vss.t1194 19.5005
R8470 vss.n3619 vss.t2071 19.5005
R8471 vss.n2946 vss.t2362 19.4525
R8472 vss.n2876 vss.t2361 19.4476
R8473 vss.n2808 vss.n2577 19.4383
R8474 vss.n2813 vss.n2583 19.4383
R8475 vss.n2814 vss.n2584 19.4383
R8476 vss.n2814 vss.n2583 19.4383
R8477 vss.n2813 vss.n2582 19.4383
R8478 vss.n2812 vss.n2582 19.4383
R8479 vss.n2811 vss.n2579 19.4383
R8480 vss.n2809 vss.n2577 19.4383
R8481 vss.n5023 vss.n4711 19.3553
R8482 vss.t436 vss.n4011 19.0994
R8483 vss.n5252 vss.t1203 19.0908
R8484 vss.t835 vss.n5152 19.0467
R8485 vss.t96 vss.n5104 19.0457
R8486 vss.t889 vss.n777 19.005
R8487 vss.t620 vss.n778 19.005
R8488 vss.t182 vss.n780 19.005
R8489 vss.n4377 vss.t537 18.8997
R8490 vss.n6358 vss.n2376 18.7458
R8491 vss.n4601 vss.n11 18.649
R8492 vss.n5178 vss.t1188 18.6418
R8493 vss.n5169 vss.t1201 18.6418
R8494 vss.n3541 vss.t2142 18.6235
R8495 vss.n3540 vss.t2143 18.6235
R8496 vss.n3539 vss.t2175 18.6235
R8497 vss.n3538 vss.t2174 18.6235
R8498 vss.n956 vss.n4453 18.6213
R8499 vss.n5244 vss.t399 18.5846
R8500 vss.n5210 vss.t369 18.5846
R8501 vss.n5039 vss.n70 18.5421
R8502 vss.n6175 vss.t983 18.5106
R8503 vss.t197 vss.n6177 18.5106
R8504 vss.n6183 vss.t907 18.5106
R8505 vss.t1220 vss.n6185 18.5106
R8506 vss.t1009 vss.n2306 18.3929
R8507 vss.t1014 vss.n2148 18.3929
R8508 vss.n3120 vss.n2293 18.3747
R8509 vss.n3126 vss.n2285 18.3747
R8510 vss.n3103 vss.n2281 18.3747
R8511 vss.n3136 vss.n2277 18.3747
R8512 vss.t470 vss.n3098 18.3747
R8513 vss.n3097 vss.n2273 18.3747
R8514 vss.n3142 vss.n2269 18.3747
R8515 vss.n3090 vss.n2265 18.3747
R8516 vss.n3150 vss.t812 18.3747
R8517 vss.n3151 vss.n2261 18.3747
R8518 vss.n3080 vss.n2257 18.3747
R8519 vss.n3157 vss.n2253 18.3747
R8520 vss.n3071 vss.n2249 18.3747
R8521 vss.n3163 vss.n2245 18.3747
R8522 vss.t1010 vss.n2243 18.3747
R8523 vss.n3065 vss.n2241 18.3747
R8524 vss.n3193 vss.n2218 18.3747
R8525 vss.n3050 vss.n2214 18.3747
R8526 vss.t1013 vss.n2210 18.3747
R8527 vss.n3044 vss.n2206 18.3747
R8528 vss.n3042 vss.n2202 18.3747
R8529 vss.n3207 vss.n2198 18.3747
R8530 vss.n3036 vss.n2194 18.3747
R8531 vss.n3210 vss.n2190 18.3747
R8532 vss.n3018 vss.n2170 18.3747
R8533 vss.t1304 vss.n2166 18.3747
R8534 vss.n3013 vss.n2162 18.3747
R8535 vss.t1190 vss.n3252 18.2991
R8536 vss.n5641 vss.n5640 18.2932
R8537 vss.n5664 vss.n5663 18.2932
R8538 vss.n5687 vss.n5686 18.2932
R8539 vss.n5965 vss.n5964 18.2932
R8540 vss.n5988 vss.n5987 18.2932
R8541 vss.t589 vss.n5118 18.1968
R8542 vss.t35 vss.n5128 18.1968
R8543 vss.n5146 vss.t1207 18.1968
R8544 vss.n5296 vss.n5295 18.1553
R8545 vss.n4378 vss.t543 18.0249
R8546 vss.n4387 vss.t541 18.0249
R8547 vss.n4397 vss.t536 18.0249
R8548 vss.t2069 vss.n5135 17.9646
R8549 vss.n3229 vss.t2232 17.9562
R8550 vss.n5509 vss.n1 18.5115
R8551 vss.n3236 vss.t2233 17.8861
R8552 vss.n3582 vss.t344 17.877
R8553 vss.n3553 vss.t358 17.877
R8554 vss.n3537 vss.t359 17.877
R8555 vss.n3527 vss.t345 17.877
R8556 vss.n4341 vss.t2081 17.8083
R8557 vss.n2841 vss.t784 17.7155
R8558 vss.n2839 vss.t783 17.7155
R8559 vss.n2837 vss.t781 17.7155
R8560 vss.n2835 vss.t782 17.7155
R8561 vss.n2887 vss.t117 17.7052
R8562 vss.n2889 vss.t121 17.7052
R8563 vss.n2828 vss.t101 17.7052
R8564 vss.n2825 vss.t105 17.7052
R8565 vss.n2882 vss.t125 17.688
R8566 vss.n2880 vss.t69 17.688
R8567 vss.n2878 vss.t71 17.688
R8568 vss.n2843 vss.t774 17.688
R8569 vss.n2817 vss.t1313 17.688
R8570 vss.n2819 vss.t720 17.688
R8571 vss.n2821 vss.t721 17.688
R8572 vss.n4195 vss.t558 17.6476
R8573 vss.t242 vss.n4194 17.6476
R8574 vss.t1422 vss.n4309 17.483
R8575 vss.n4514 vss.n4438 17.483
R8576 vss.n4488 vss.n4455 17.483
R8577 vss.n4474 vss.n4419 17.483
R8578 vss.n4527 vss.n4469 17.483
R8579 vss.n5187 vss.n5186 17.4497
R8580 vss.n5249 vss.n5248 17.4497
R8581 vss.n3015 vss.t727 17.3902
R8582 vss.n4408 vss.t1182 17.3511
R8583 vss.n4381 vss.t504 17.3511
R8584 vss.n4366 vss.t247 17.3511
R8585 vss.n4362 vss.t510 17.3511
R8586 vss.n4357 vss.t23 17.3511
R8587 vss.n4391 vss.t1217 17.3511
R8588 vss.n4348 vss.t687 17.3511
R8589 vss.n5235 vss.t400 17.3443
R8590 vss.n5236 vss.t409 17.3443
R8591 vss.n5230 vss.t404 17.3443
R8592 vss.n5176 vss.t386 17.3443
R8593 vss.n5227 vss.t390 17.3443
R8594 vss.n5229 vss.t396 17.3443
R8595 vss.n5214 vss.t378 17.3443
R8596 vss.n5215 vss.t368 17.3443
R8597 vss.n5138 vss.t1396 17.3368
R8598 vss.n5526 vss.t1349 17.3268
R8599 vss.n1191 vss.t493 17.3263
R8600 vss.n4363 vss.t152 17.3263
R8601 vss.n3186 vss.t799 17.3263
R8602 vss.n3185 vss.t256 17.3263
R8603 vss.n5183 vss.t376 17.3263
R8604 vss.n3143 vss.t1074 17.3263
R8605 vss.n5294 vss.t95 17.3263
R8606 vss.n5270 vss.t1088 17.3263
R8607 vss.n5424 vss.t12 17.3263
R8608 vss.n5506 vss.t469 17.3263
R8609 vss.n6402 vss.n1474 17.316
R8610 vss.n5553 vss.t636 17.3129
R8611 vss.n6007 vss.t526 17.3129
R8612 vss.n5558 vss.t239 17.3129
R8613 vss.n4407 vss.t245 17.303
R8614 vss.n2899 vss.t766 17.2686
R8615 vss.n2900 vss.t764 17.2686
R8616 vss.n2901 vss.t762 17.2686
R8617 vss.n2902 vss.t760 17.2686
R8618 vss.n2903 vss.t758 17.2686
R8619 vss.n2904 vss.t756 17.2686
R8620 vss.n2910 vss.t748 17.2686
R8621 vss.n2911 vss.t746 17.2686
R8622 vss.n2912 vss.t744 17.2686
R8623 vss.n2913 vss.t742 17.2686
R8624 vss.n2914 vss.t740 17.2686
R8625 vss.n2915 vss.t737 17.2686
R8626 vss.n287 vss.n2791 17.267
R8627 vss.n287 vss.n2754 17.267
R8628 vss.n4248 vss.t27 17.2607
R8629 vss.n4609 vss.t557 17.2604
R8630 vss.n4280 vss.t243 17.2395
R8631 vss.n5929 vss.t1122 17.2395
R8632 vss.n5937 vss.t1127 17.2395
R8633 vss.n5945 vss.t1117 17.2395
R8634 vss.n5860 vss.t1103 17.2395
R8635 vss.n5758 vss.t1098 17.2395
R8636 vss.n5822 vss.t1072 17.2395
R8637 vss.n5999 vss.t1124 17.2395
R8638 vss.n5977 vss.t1132 17.2395
R8639 vss.n5954 vss.t1114 17.2395
R8640 vss.n5676 vss.t1076 17.2395
R8641 vss.n5653 vss.t1095 17.2395
R8642 vss.n5645 vss.t1092 17.2395
R8643 vss.n5668 vss.t1068 17.2395
R8644 vss.n5691 vss.t1106 17.2395
R8645 vss.n5969 vss.t1112 17.2395
R8646 vss.n5992 vss.t1129 17.2395
R8647 vss.n6008 vss.t1062 17.2395
R8648 vss.n2668 vss.t1628 17.2313
R8649 vss.n2668 vss.t1619 17.2313
R8650 vss.n6229 vss.t1624 17.2313
R8651 vss.n6229 vss.t1632 17.2313
R8652 vss.n3779 vss.t1680 17.2313
R8653 vss.n3779 vss.t1668 17.2313
R8654 vss.n3787 vss.t1673 17.2313
R8655 vss.n3787 vss.t1684 17.2313
R8656 vss.n2669 vss.t1654 17.2313
R8657 vss.n2669 vss.t1645 17.2313
R8658 vss.n2681 vss.t1650 17.2313
R8659 vss.n2681 vss.t1658 17.2313
R8660 vss.n1583 vss.t1442 17.2313
R8661 vss.n1589 vss.t1447 17.2313
R8662 vss.n1597 vss.t1452 17.2313
R8663 vss.n1604 vss.t1457 17.2313
R8664 vss.n1612 vss.t1462 17.2313
R8665 vss.n1619 vss.t1467 17.2313
R8666 vss.n1627 vss.t1472 17.2313
R8667 vss.n1633 vss.t1477 17.2313
R8668 vss.n1642 vss.t1482 17.2313
R8669 vss.n1648 vss.t1487 17.2313
R8670 vss.n1663 vss.t1492 17.2313
R8671 vss.n1669 vss.t1497 17.2313
R8672 vss.n1677 vss.t1502 17.2313
R8673 vss.n1683 vss.t1507 17.2313
R8674 vss.n1698 vss.t1512 17.2313
R8675 vss.n1703 vss.t1517 17.2313
R8676 vss.n1718 vss.t1522 17.2313
R8677 vss.n1477 vss.t1527 17.2313
R8678 vss.n2449 vss.t1532 17.2313
R8679 vss.n2434 vss.t1537 17.2313
R8680 vss.n2465 vss.t1542 17.2313
R8681 vss.n2372 vss.t1547 17.2313
R8682 vss.n2374 vss.t1552 17.2313
R8683 vss.n5327 vss.t1939 17.2313
R8684 vss.n5327 vss.t1954 17.2313
R8685 vss.n2332 vss.t1869 17.2313
R8686 vss.n2351 vss.t1813 17.2313
R8687 vss.n2351 vss.t1827 17.2313
R8688 vss.n2532 vss.t1720 17.2313
R8689 vss.n2532 vss.t1724 17.2313
R8690 vss.n2518 vss.t1712 17.2313
R8691 vss.n2518 vss.t1716 17.2313
R8692 vss.n2509 vss.t1704 17.2313
R8693 vss.n2509 vss.t1708 17.2313
R8694 vss.n2503 vss.t1696 17.2313
R8695 vss.n2503 vss.t1700 17.2313
R8696 vss.n2492 vss.t1688 17.2313
R8697 vss.n2492 vss.t1692 17.2313
R8698 vss.n2547 vss.t1662 17.2313
R8699 vss.n2547 vss.t1677 17.2313
R8700 vss.n2485 vss.t1636 17.2313
R8701 vss.n2485 vss.t1641 17.2313
R8702 vss.n2474 vss.t1577 17.2313
R8703 vss.n2474 vss.t1581 17.2313
R8704 vss.n2598 vss.t1569 17.2313
R8705 vss.n2598 vss.t1573 17.2313
R8706 vss.n2557 vss.t1561 17.2313
R8707 vss.n2557 vss.t1565 17.2313
R8708 vss.n5057 vss.t1966 17.2313
R8709 vss.n2337 vss.t1884 17.2313
R8710 vss.n2337 vss.t1898 17.2313
R8711 vss.n5062 vss.t1909 17.2313
R8712 vss.n5062 vss.t1913 17.2313
R8713 vss.n6241 vss.t1611 17.2313
R8714 vss.n6241 vss.t1602 17.2313
R8715 vss.n6250 vss.t1607 17.2313
R8716 vss.n6250 vss.t1615 17.2313
R8717 vss.n2663 vss.t1594 17.2313
R8718 vss.n2663 vss.t1585 17.2313
R8719 vss.n6272 vss.t1590 17.2313
R8720 vss.n6272 vss.t1598 17.2313
R8721 vss.n5478 vss.t1989 17.2313
R8722 vss.n5475 vss.t1994 17.2313
R8723 vss.n5466 vss.t1999 17.2313
R8724 vss.n5341 vss.t2004 17.2313
R8725 vss.n5452 vss.t2009 17.2313
R8726 vss.n5456 vss.t2014 17.2313
R8727 vss.n5403 vss.t2019 17.2313
R8728 vss.n5400 vss.t2024 17.2313
R8729 vss.n5397 vss.t2029 17.2313
R8730 vss.n5394 vss.t2034 17.2313
R8731 vss.n5390 vss.t2039 17.2313
R8732 vss.n5386 vss.t2044 17.2313
R8733 vss.n5357 vss.t2049 17.2313
R8734 vss.n3961 vss.t1958 17.2313
R8735 vss.n3961 vss.t1943 17.2313
R8736 vss.n3748 vss.t1931 17.2313
R8737 vss.n3748 vss.t1922 17.2313
R8738 vss.n3986 vss.t1927 17.2313
R8739 vss.n3986 vss.t1935 17.2313
R8740 vss.n3925 vss.t1901 17.2313
R8741 vss.n3925 vss.t1889 17.2313
R8742 vss.n3933 vss.t1894 17.2313
R8743 vss.n3933 vss.t1905 17.2313
R8744 vss.n3242 vss.t1874 17.2313
R8745 vss.n3249 vss.t1879 17.2313
R8746 vss.n3877 vss.t1855 17.2313
R8747 vss.n3904 vss.t1859 17.2313
R8748 vss.n3883 vss.t1843 17.2313
R8749 vss.n3911 vss.t1848 17.2313
R8750 vss.n918 vss.t1949 17.2313
R8751 vss.n918 vss.t1962 17.2313
R8752 vss.n3859 vss.t1830 17.2313
R8753 vss.n3859 vss.t1817 17.2313
R8754 vss.n923 vss.t1823 17.2313
R8755 vss.n923 vss.t1834 17.2313
R8756 vss.n3752 vss.t1805 17.2313
R8757 vss.n3752 vss.t1795 17.2313
R8758 vss.n928 vss.t1801 17.2313
R8759 vss.n928 vss.t1809 17.2313
R8760 vss.n3847 vss.t1788 17.2313
R8761 vss.n3847 vss.t1778 17.2313
R8762 vss.n933 vss.t1784 17.2313
R8763 vss.n933 vss.t1792 17.2313
R8764 vss.n3775 vss.t1771 17.2313
R8765 vss.n3775 vss.t1761 17.2313
R8766 vss.n938 vss.t1767 17.2313
R8767 vss.n938 vss.t1775 17.2313
R8768 vss.n3816 vss.t1754 17.2313
R8769 vss.n3816 vss.t1744 17.2313
R8770 vss.n943 vss.t1750 17.2313
R8771 vss.n943 vss.t1758 17.2313
R8772 vss.n3799 vss.t1737 17.2313
R8773 vss.n3799 vss.t1727 17.2313
R8774 vss.n948 vss.t1733 17.2313
R8775 vss.n948 vss.t1741 17.2313
R8776 vss.n3945 vss.t1971 17.2313
R8777 vss.n3952 vss.t1976 17.2313
R8778 vss.n5368 vss.t2054 17.2313
R8779 vss.n6378 vss.t1852 17.2313
R8780 vss.n2327 vss.t1838 17.2313
R8781 vss.n6363 vss.t1556 17.2313
R8782 vss.n5052 vss.t1981 17.2313
R8783 vss.n4266 vss.t163 17.2297
R8784 vss.n5484 vss.t1985 17.2284
R8785 vss.n5356 vss.t2058 17.2284
R8786 vss.n5432 vss.t942 17.2247
R8787 vss.n5416 vss.t904 17.2247
R8788 vss.n1465 vss.t627 17.2226
R8789 vss.n1239 vss.t584 17.2226
R8790 vss.n1453 vss.t894 17.2226
R8791 vss.n1251 vss.t680 17.2226
R8792 vss.n1441 vss.t581 17.2226
R8793 vss.n1264 vss.t466 17.2226
R8794 vss.n1421 vss.t624 17.2226
R8795 vss.n1295 vss.t892 17.2226
R8796 vss.n1389 vss.t887 17.2226
R8797 vss.n1314 vss.t232 17.2226
R8798 vss.n1376 vss.t575 17.2226
R8799 vss.n1326 vss.t450 17.2226
R8800 vss.n1364 vss.t230 17.2226
R8801 vss.n1342 vss.t8 17.2226
R8802 vss.n5263 vss.t1271 17.2226
R8803 vss.n5278 vss.t653 17.2226
R8804 vss.n4258 vss.t158 17.2205
R8805 vss.n3025 vss.t829 17.2205
R8806 vss.n5115 vss.t1197 17.2205
R8807 vss.n5119 vss.t590 17.2205
R8808 vss.n5125 vss.t1022 17.2205
R8809 vss.n5129 vss.t36 17.2205
R8810 vss.n5147 vss.t1042 17.2205
R8811 vss.n5150 vss.t1044 17.2205
R8812 vss.n5157 vss.t836 17.2142
R8813 vss.n1468 vss.t205 17.2124
R8814 vss.n1235 vss.t896 17.2124
R8815 vss.n1456 vss.t138 17.2124
R8816 vss.n1247 vss.t582 17.2124
R8817 vss.n1444 vss.t678 17.2124
R8818 vss.n1260 vss.t452 17.2124
R8819 vss.n1426 vss.t496 17.2124
R8820 vss.n1300 vss.t936 17.2124
R8821 vss.n1384 vss.t576 17.2124
R8822 vss.n1317 vss.t88 17.2124
R8823 vss.n1372 vss.t86 17.2124
R8824 vss.n1329 vss.t464 17.2124
R8825 vss.n1359 vss.t616 17.2124
R8826 vss.n1346 vss.t574 17.2124
R8827 vss.n3022 vss.t831 17.2124
R8828 vss.n5279 vss.t811 17.2124
R8829 vss.n5273 vss.t825 17.2124
R8830 vss.n5503 vss.t1240 17.2122
R8831 vss.n5931 vss.t524 17.212
R8832 vss.n5939 vss.t632 17.212
R8833 vss.n5947 vss.t929 17.212
R8834 vss.n5857 vss.t1078 17.212
R8835 vss.n5831 vss.t1086 17.212
R8836 vss.n5819 vss.t1084 17.212
R8837 vss.n5991 vss.t1054 17.212
R8838 vss.n5968 vss.t682 17.212
R8839 vss.n5690 vss.t712 17.212
R8840 vss.n5667 vss.t651 17.212
R8841 vss.n5644 vss.t1090 17.212
R8842 vss.n5631 vss.t1082 17.212
R8843 vss.n5654 vss.t1025 17.212
R8844 vss.n5677 vss.t670 17.212
R8845 vss.n5955 vss.t131 17.212
R8846 vss.n5978 vss.t633 17.212
R8847 vss.n6000 vss.t18 17.212
R8848 vss.n4284 vss.t241 17.2042
R8849 vss.n5905 vss.t1137 17.2042
R8850 vss.n5935 vss.t997 17.2042
R8851 vss.n5943 vss.t939 17.2042
R8852 vss.n5861 vss.t3 17.2042
R8853 vss.n5844 vss.t708 17.2042
R8854 vss.n5823 vss.t1094 17.2042
R8855 vss.n5997 vss.t486 17.2042
R8856 vss.n5975 vss.t91 17.2042
R8857 vss.n5952 vss.t80 17.2042
R8858 vss.n5674 vss.t1066 17.2042
R8859 vss.n5651 vss.t1081 17.2042
R8860 vss.n5595 vss.t1070 17.2042
R8861 vss.n5587 vss.t874 17.2042
R8862 vss.n5579 vss.t607 17.2042
R8863 vss.n5570 vss.t579 17.2042
R8864 vss.n5562 vss.t1050 17.2042
R8865 vss.n6013 vss.t555 17.2042
R8866 vss.n4399 vss.t258 17.174
R8867 vss.n4349 vss.t249 17.174
R8868 vss.n3083 vss.t43 17.174
R8869 vss.n3087 vss.t813 17.174
R8870 vss.n5504 vss.t58 17.174
R8871 vss.n3531 vss.t846 17.1508
R8872 vss.n4410 vss.t447 17.1504
R8873 vss.n5790 vss.t987 17.1443
R8874 vss.n5633 vss.t1055 17.1443
R8875 vss.n5608 vss.t954 17.1443
R8876 vss.n6366 vss.n2346 17.103
R8877 vss.n1228 vss 17.0193
R8878 vss.n6134 vss.n6133 17.0021
R8879 vss.n840 vss.n839 0.413476
R8880 vss.n845 vss.n844 0.464033
R8881 vss.n850 vss.n849 0.649832
R8882 vss.n854 vss.n853 0.649832
R8883 vss.n860 vss.n857 0.649832
R8884 vss.n866 vss.n863 0.649832
R8885 vss.n870 vss.n869 0.649832
R8886 vss.n876 vss.n873 0.649832
R8887 vss.n880 vss.n879 0.649832
R8888 vss.n884 vss.n883 0.649832
R8889 vss.n890 vss.n887 0.649832
R8890 vss.n894 vss.n893 0.649832
R8891 vss.n900 vss.n897 0.649832
R8892 vss.n916 vss.n915 0.649832
R8893 vss.n921 vss.n920 0.649832
R8894 vss.n926 vss.n925 0.649832
R8895 vss.n931 vss.n930 0.649832
R8896 vss.n936 vss.n935 0.649832
R8897 vss.n941 vss.n940 0.649832
R8898 vss.n946 vss.n945 0.649832
R8899 vss.n6412 vss.n1228 17.0005
R8900 vss.n6412 vss.n1040 17.0005
R8901 vss.n6412 vss.n1227 17.0005
R8902 vss.n6412 vss.n1042 17.0005
R8903 vss.n6412 vss.n1226 17.0005
R8904 vss.n6412 vss.n1044 17.0005
R8905 vss.n6412 vss.n1225 17.0005
R8906 vss.n6412 vss.n1046 17.0005
R8907 vss.n6412 vss.n1224 17.0005
R8908 vss.n6412 vss.n1048 17.0005
R8909 vss.n6412 vss.n1223 17.0005
R8910 vss.n6412 vss.n1052 17.0005
R8911 vss.n6412 vss.n1222 17.0005
R8912 vss.n6412 vss.n1054 17.0005
R8913 vss.n6412 vss.n1221 17.0005
R8914 vss.n6412 vss.n1056 17.0005
R8915 vss.n6412 vss.n1220 17.0005
R8916 vss.n6412 vss.n1058 17.0005
R8917 vss.n6412 vss.n1219 17.0005
R8918 vss.n6412 vss.n1060 17.0005
R8919 vss.n6412 vss.n1218 17.0005
R8920 vss.n6412 vss.n1061 17.0005
R8921 vss.n6412 vss.n1217 17.0005
R8922 vss.n6412 vss.n1063 17.0005
R8923 vss.n6412 vss.n1214 17.0005
R8924 vss.n6412 vss.n1066 17.0005
R8925 vss.n6412 vss.n1213 17.0005
R8926 vss.n6412 vss.n1068 17.0005
R8927 vss.n6412 vss.n1212 17.0005
R8928 vss.n6412 vss.n1070 17.0005
R8929 vss.n6412 vss.n1211 17.0005
R8930 vss.n6412 vss.n1072 17.0005
R8931 vss.n6412 vss.n1210 17.0005
R8932 vss.n6412 vss.n1074 17.0005
R8933 vss.n6412 vss.n1209 17.0005
R8934 vss.n6412 vss.n1075 17.0005
R8935 vss.n6412 vss.n788 17.0005
R8936 vss.n6412 vss.n793 17.0005
R8937 vss.n6412 vss.n1077 17.0005
R8938 vss.n6412 vss.n789 17.0005
R8939 vss.n6412 vss.n1208 17.0005
R8940 vss.n6412 vss.n792 17.0005
R8941 vss.n6412 vss.n790 17.0005
R8942 vss.n6412 vss.n791 17.0005
R8943 vss.n6412 vss.n1079 17.0005
R8944 vss.n6412 vss.n747 17.0005
R8945 vss.n6412 vss.n1207 17.0005
R8946 vss.n6412 vss.n1080 17.0005
R8947 vss.n6412 vss.n1206 17.0005
R8948 vss.n6412 vss.n786 17.0005
R8949 vss.n6412 vss.n1082 17.0005
R8950 vss.n6412 vss.n748 17.0005
R8951 vss.n6412 vss.n1205 17.0005
R8952 vss.n6412 vss.n785 17.0005
R8953 vss.n6412 vss.n749 17.0005
R8954 vss.n6412 vss.n784 17.0005
R8955 vss.n6412 vss.n1084 17.0005
R8956 vss.n6412 vss.n750 17.0005
R8957 vss.n6412 vss.n1204 17.0005
R8958 vss.n6412 vss.n783 17.0005
R8959 vss.n6412 vss.n751 17.0005
R8960 vss.n6412 vss.n782 17.0005
R8961 vss.n6412 vss.n1086 17.0005
R8962 vss.n6412 vss.n752 17.0005
R8963 vss.n6412 vss.n1203 17.0005
R8964 vss.n6412 vss.n781 17.0005
R8965 vss.n6412 vss.n753 17.0005
R8966 vss.n6412 vss.n780 17.0005
R8967 vss.n6412 vss.n1088 17.0005
R8968 vss.n6412 vss.n754 17.0005
R8969 vss.n6412 vss.n1202 17.0005
R8970 vss.n6412 vss.n779 17.0005
R8971 vss.n6412 vss.n755 17.0005
R8972 vss.n6412 vss.n778 17.0005
R8973 vss.n6412 vss.n1090 17.0005
R8974 vss.n6412 vss.n756 17.0005
R8975 vss.n6412 vss.n1201 17.0005
R8976 vss.n6412 vss.n1091 17.0005
R8977 vss.n6412 vss.n1092 17.0005
R8978 vss.n6412 vss.n1200 17.0005
R8979 vss.n6412 vss.n1199 17.0005
R8980 vss.n6412 vss.n777 17.0005
R8981 vss.n6412 vss.n1093 17.0005
R8982 vss.n6412 vss.n757 17.0005
R8983 vss.n6412 vss.n1197 17.0005
R8984 vss.n6412 vss.n1094 17.0005
R8985 vss.n6412 vss.n1095 17.0005
R8986 vss.n6412 vss.n1196 17.0005
R8987 vss.n6412 vss.n1195 17.0005
R8988 vss.n6412 vss.n776 17.0005
R8989 vss.n6412 vss.n1096 17.0005
R8990 vss.n6412 vss.n758 17.0005
R8991 vss.n6412 vss.n1193 17.0005
R8992 vss.n6412 vss.n775 17.0005
R8993 vss.n6412 vss.n1097 17.0005
R8994 vss.n6412 vss.n759 17.0005
R8995 vss.n6412 vss.n1192 17.0005
R8996 vss.n6412 vss.n774 17.0005
R8997 vss.n6412 vss.n1098 17.0005
R8998 vss.n6412 vss.n760 17.0005
R8999 vss.n6412 vss.n1190 17.0005
R9000 vss.n6412 vss.n773 17.0005
R9001 vss.n6412 vss.n761 17.0005
R9002 vss.n6412 vss.n772 17.0005
R9003 vss.n6412 vss.n1100 17.0005
R9004 vss.n6412 vss.n762 17.0005
R9005 vss.n6412 vss.n1189 17.0005
R9006 vss.n6412 vss.n771 17.0005
R9007 vss.n6412 vss.n763 17.0005
R9008 vss.n6412 vss.n770 17.0005
R9009 vss.n6412 vss.n1102 17.0005
R9010 vss.n6412 vss.n764 17.0005
R9011 vss.n6412 vss.n1188 17.0005
R9012 vss.n6412 vss.n769 17.0005
R9013 vss.n6412 vss.n765 17.0005
R9014 vss.n6412 vss.n768 17.0005
R9015 vss.n6412 vss.n1104 17.0005
R9016 vss.n6412 vss.n766 17.0005
R9017 vss.n6412 vss.n1187 17.0005
R9018 vss.n6412 vss.n1105 17.0005
R9019 vss.n6412 vss.n1186 17.0005
R9020 vss.n6412 vss.n767 17.0005
R9021 vss.n6412 vss.n1107 17.0005
R9022 vss.n6412 vss.n737 17.0005
R9023 vss.n6412 vss.n1185 17.0005
R9024 vss.n6412 vss.n732 17.0005
R9025 vss.n6412 vss.n736 17.0005
R9026 vss.n6412 vss.n733 17.0005
R9027 vss.n6412 vss.n1109 17.0005
R9028 vss.n6412 vss.n735 17.0005
R9029 vss.n6412 vss.n1184 17.0005
R9030 vss.n6412 vss.n734 17.0005
R9031 vss.n6412 vss.n1183 17.0005
R9032 vss.n6412 vss.n1112 17.0005
R9033 vss.n6412 vss.n1182 17.0005
R9034 vss.n6412 vss.n1114 17.0005
R9035 vss.n6412 vss.n1181 17.0005
R9036 vss.n6412 vss.n1116 17.0005
R9037 vss.n6412 vss.n1180 17.0005
R9038 vss.n6412 vss.n1118 17.0005
R9039 vss.n6412 vss.n1179 17.0005
R9040 vss.n6412 vss.n1120 17.0005
R9041 vss.n6412 vss.n1178 17.0005
R9042 vss.n6412 vss.n1123 17.0005
R9043 vss.n6412 vss.n1177 17.0005
R9044 vss.n6412 vss.n1125 17.0005
R9045 vss.n6412 vss.n1176 17.0005
R9046 vss.n6412 vss.n1126 17.0005
R9047 vss.n6412 vss.n1173 17.0005
R9048 vss.n6412 vss.n1128 17.0005
R9049 vss.n6412 vss.n1172 17.0005
R9050 vss.n6412 vss.n1130 17.0005
R9051 vss.n6412 vss.n1171 17.0005
R9052 vss.n6412 vss.n1132 17.0005
R9053 vss.n6412 vss.n1170 17.0005
R9054 vss.n6412 vss.n1134 17.0005
R9055 vss.n6412 vss.n1169 17.0005
R9056 vss.n6412 vss.n1137 17.0005
R9057 vss.n6412 vss.n1138 17.0005
R9058 vss.n6412 vss.t1238 17.0005
R9059 vss.n6412 vss.n1168 17.0005
R9060 vss.n6412 vss.n1139 17.0005
R9061 vss.n6412 vss.n1167 17.0005
R9062 vss.n6412 vss.n1141 17.0005
R9063 vss.n6412 vss.n1142 17.0005
R9064 vss.n6412 vss.n1166 17.0005
R9065 vss.n6412 vss.n1165 17.0005
R9066 vss.n6412 vss.n1143 17.0005
R9067 vss.n6412 vss.n1164 17.0005
R9068 vss.n6412 vss.n1145 17.0005
R9069 vss.n6412 vss.n1146 17.0005
R9070 vss.n6412 vss.n1163 17.0005
R9071 vss.n6412 vss.n1162 17.0005
R9072 vss.n6412 vss.n1147 17.0005
R9073 vss.n6412 vss.n1161 17.0005
R9074 vss.n6412 vss.n1149 17.0005
R9075 vss.n6412 vss.n1150 17.0005
R9076 vss.n6412 vss.n1160 17.0005
R9077 vss.n6412 vss.n1159 17.0005
R9078 vss.n6412 vss.n1151 17.0005
R9079 vss.n6412 vss.n1158 17.0005
R9080 vss.n6412 vss.n1153 17.0005
R9081 vss.n6412 vss.n1154 17.0005
R9082 vss.n6412 vss.n1157 17.0005
R9083 vss.n6412 vss.n1156 17.0005
R9084 vss.n6412 vss.n1155 17.0005
R9085 vss.n6413 vss.n6412 17.0005
R9086 vss.n6409 vss.n6408 17.0005
R9087 vss.n6409 vss.n1230 17.0005
R9088 vss.n6409 vss.n1469 17.0005
R9089 vss.n6409 vss.n1231 17.0005
R9090 vss.n6409 vss.n1467 17.0005
R9091 vss.n6409 vss.n1232 17.0005
R9092 vss.n6409 vss.n1466 17.0005
R9093 vss.n6409 vss.n1233 17.0005
R9094 vss.n6409 vss.n1464 17.0005
R9095 vss.n6409 vss.n1234 17.0005
R9096 vss.n6409 vss.n1463 17.0005
R9097 vss.n6409 vss.n1236 17.0005
R9098 vss.n6409 vss.n1462 17.0005
R9099 vss.n6409 vss.n1237 17.0005
R9100 vss.n6409 vss.n1461 17.0005
R9101 vss.n6409 vss.n1238 17.0005
R9102 vss.n6409 vss.n1240 17.0005
R9103 vss.n6409 vss.n1459 17.0005
R9104 vss.n6409 vss.n1241 17.0005
R9105 vss.n6409 vss.n1458 17.0005
R9106 vss.n6409 vss.n1242 17.0005
R9107 vss.n6409 vss.n1457 17.0005
R9108 vss.n6409 vss.n1243 17.0005
R9109 vss.n6409 vss.n1455 17.0005
R9110 vss.n6409 vss.n1244 17.0005
R9111 vss.n6409 vss.n1454 17.0005
R9112 vss.n6409 vss.n1245 17.0005
R9113 vss.n6409 vss.n1452 17.0005
R9114 vss.n6409 vss.n1246 17.0005
R9115 vss.n6409 vss.n1451 17.0005
R9116 vss.n6409 vss.n1248 17.0005
R9117 vss.n6409 vss.n1449 17.0005
R9118 vss.n6409 vss.n1249 17.0005
R9119 vss.n6409 vss.n1448 17.0005
R9120 vss.n6409 vss.n1252 17.0005
R9121 vss.n6409 vss.n1447 17.0005
R9122 vss.n6409 vss.n1253 17.0005
R9123 vss.n6409 vss.n1446 17.0005
R9124 vss.n6409 vss.n1254 17.0005
R9125 vss.n6409 vss.n1445 17.0005
R9126 vss.n6409 vss.n1255 17.0005
R9127 vss.n6409 vss.n1443 17.0005
R9128 vss.n6409 vss.n1256 17.0005
R9129 vss.n6409 vss.n1442 17.0005
R9130 vss.n6409 vss.n1257 17.0005
R9131 vss.n6409 vss.n1440 17.0005
R9132 vss.n6409 vss.n1258 17.0005
R9133 vss.n6409 vss.n1439 17.0005
R9134 vss.n6409 vss.n1259 17.0005
R9135 vss.n6409 vss.n1261 17.0005
R9136 vss.n6409 vss.n1436 17.0005
R9137 vss.n6409 vss.n1435 17.0005
R9138 vss.n6409 vss.n1262 17.0005
R9139 vss.n6409 vss.n1263 17.0005
R9140 vss.n6409 vss.n1434 17.0005
R9141 vss.n6409 vss.n1433 17.0005
R9142 vss.n6409 vss.t609 17.0005
R9143 vss.n6409 vss.n1265 17.0005
R9144 vss.n6409 vss.n1432 17.0005
R9145 vss.n6409 vss.n1431 17.0005
R9146 vss.n6409 vss.n1266 17.0005
R9147 vss.n6409 vss.n1267 17.0005
R9148 vss.n6409 vss.n1430 17.0005
R9149 vss.n6409 vss.n1429 17.0005
R9150 vss.n6409 vss.n1268 17.0005
R9151 vss.n6409 vss.n1269 17.0005
R9152 vss.n6409 vss.n1428 17.0005
R9153 vss.n6409 vss.n1427 17.0005
R9154 vss.n6409 vss.n1270 17.0005
R9155 vss.n6409 vss.n1271 17.0005
R9156 vss.n6409 vss.n1425 17.0005
R9157 vss.n6409 vss.n1424 17.0005
R9158 vss.n6409 vss.n1272 17.0005
R9159 vss.n6409 vss.n1273 17.0005
R9160 vss.n6409 vss.n1423 17.0005
R9161 vss.n6409 vss.n1422 17.0005
R9162 vss.n6409 vss.n1274 17.0005
R9163 vss.n6409 vss.n1275 17.0005
R9164 vss.n6409 vss.n1420 17.0005
R9165 vss.n6409 vss.n1419 17.0005
R9166 vss.n6409 vss.n1276 17.0005
R9167 vss.n6409 vss.n1278 17.0005
R9168 vss.n6409 vss.n1418 17.0005
R9169 vss.n6409 vss.n1417 17.0005
R9170 vss.n6409 vss.n1279 17.0005
R9171 vss.n6409 vss.n1280 17.0005
R9172 vss.n6409 vss.n1416 17.0005
R9173 vss.n6409 vss.n1415 17.0005
R9174 vss.n6409 vss.n1281 17.0005
R9175 vss.n6409 vss.n1282 17.0005
R9176 vss.n6409 vss.n1413 17.0005
R9177 vss.n6409 vss.n1412 17.0005
R9178 vss.n6409 vss.n1283 17.0005
R9179 vss.n6409 vss.n1285 17.0005
R9180 vss.n6409 vss.n1411 17.0005
R9181 vss.n6409 vss.n1410 17.0005
R9182 vss.n6409 vss.n1286 17.0005
R9183 vss.n6409 vss.n1287 17.0005
R9184 vss.n6409 vss.n1409 17.0005
R9185 vss.n6409 vss.n1408 17.0005
R9186 vss.n6409 vss.n1288 17.0005
R9187 vss.n6409 vss.n1289 17.0005
R9188 vss.n6409 vss.n1407 17.0005
R9189 vss.n6409 vss.n1406 17.0005
R9190 vss.n6409 vss.n1290 17.0005
R9191 vss.n6409 vss.n1291 17.0005
R9192 vss.n6409 vss.n1405 17.0005
R9193 vss.n6409 vss.n1404 17.0005
R9194 vss.n6409 vss.n1403 17.0005
R9195 vss.n6409 vss.n1402 17.0005
R9196 vss.n6409 vss.n1292 17.0005
R9197 vss.n6409 vss.n1293 17.0005
R9198 vss.n6409 vss.n1401 17.0005
R9199 vss.n6409 vss.n1400 17.0005
R9200 vss.n6409 vss.n1294 17.0005
R9201 vss.n6409 vss.n1296 17.0005
R9202 vss.n6409 vss.n1399 17.0005
R9203 vss.n6409 vss.n1398 17.0005
R9204 vss.n6409 vss.n1297 17.0005
R9205 vss.n6409 vss.n1298 17.0005
R9206 vss.n6409 vss.n1397 17.0005
R9207 vss.n6409 vss.n1396 17.0005
R9208 vss.n6409 vss.n1299 17.0005
R9209 vss.n6409 vss.n1301 17.0005
R9210 vss.n6409 vss.n1395 17.0005
R9211 vss.n6409 vss.n1394 17.0005
R9212 vss.n6409 vss.n1302 17.0005
R9213 vss.n6409 vss.n1303 17.0005
R9214 vss.n6409 vss.n1393 17.0005
R9215 vss.n6409 vss.n1392 17.0005
R9216 vss.n6409 vss.n1304 17.0005
R9217 vss.n6409 vss.n1305 17.0005
R9218 vss.n6409 vss.n1391 17.0005
R9219 vss.n6409 vss.n1390 17.0005
R9220 vss.n6409 vss.n1306 17.0005
R9221 vss.n6409 vss.n1307 17.0005
R9222 vss.n6409 vss.n1388 17.0005
R9223 vss.n6409 vss.n1387 17.0005
R9224 vss.n6409 vss.n1308 17.0005
R9225 vss.n6409 vss.n1309 17.0005
R9226 vss.n6409 vss.n1386 17.0005
R9227 vss.n6409 vss.n1385 17.0005
R9228 vss.n6409 vss.n1312 17.0005
R9229 vss.n6409 vss.n1383 17.0005
R9230 vss.n6409 vss.n1313 17.0005
R9231 vss.n6409 vss.n1382 17.0005
R9232 vss.n6409 vss.n1315 17.0005
R9233 vss.n6409 vss.n1381 17.0005
R9234 vss.n6409 vss.n1316 17.0005
R9235 vss.n6409 vss.n1380 17.0005
R9236 vss.n6409 vss.n1318 17.0005
R9237 vss.n6409 vss.n1379 17.0005
R9238 vss.n6409 vss.n1319 17.0005
R9239 vss.n6409 vss.n1378 17.0005
R9240 vss.n6409 vss.n1320 17.0005
R9241 vss.n6409 vss.n1377 17.0005
R9242 vss.n6409 vss.n1322 17.0005
R9243 vss.n6409 vss.n1375 17.0005
R9244 vss.n6409 vss.n1323 17.0005
R9245 vss.n6409 vss.n1373 17.0005
R9246 vss.n6409 vss.n1324 17.0005
R9247 vss.n6409 vss.n1371 17.0005
R9248 vss.n6409 vss.n1325 17.0005
R9249 vss.n6409 vss.n1370 17.0005
R9250 vss.n6409 vss.n1327 17.0005
R9251 vss.n6409 vss.n1369 17.0005
R9252 vss.n6409 vss.n1328 17.0005
R9253 vss.n6409 vss.n1368 17.0005
R9254 vss.n6409 vss.n1330 17.0005
R9255 vss.n6409 vss.n1367 17.0005
R9256 vss.n6409 vss.n1331 17.0005
R9257 vss.n6409 vss.n1366 17.0005
R9258 vss.n6409 vss.n1332 17.0005
R9259 vss.n6409 vss.n1365 17.0005
R9260 vss.n6409 vss.n1333 17.0005
R9261 vss.n6409 vss.n1334 17.0005
R9262 vss.n6409 vss.n1363 17.0005
R9263 vss.n6409 vss.n1362 17.0005
R9264 vss.n6409 vss.n1335 17.0005
R9265 vss.n6409 vss.n1336 17.0005
R9266 vss.n6409 vss.n1361 17.0005
R9267 vss.n6409 vss.n1360 17.0005
R9268 vss.n6409 vss.n1337 17.0005
R9269 vss.n6409 vss.n1338 17.0005
R9270 vss.n6409 vss.n1358 17.0005
R9271 vss.n6409 vss.n1357 17.0005
R9272 vss.n6409 vss.n1339 17.0005
R9273 vss.n6409 vss.n1340 17.0005
R9274 vss.n6409 vss.n1356 17.0005
R9275 vss.n6409 vss.n1355 17.0005
R9276 vss.n6409 vss.n1341 17.0005
R9277 vss.n6409 vss.n1343 17.0005
R9278 vss.n6409 vss.n1354 17.0005
R9279 vss.n6409 vss.n1353 17.0005
R9280 vss.n6409 vss.n1344 17.0005
R9281 vss.n6409 vss.n1345 17.0005
R9282 vss.n6409 vss.n1352 17.0005
R9283 vss.n6409 vss.n1351 17.0005
R9284 vss.n6409 vss.t918 17.0005
R9285 vss.n6409 vss.n1347 17.0005
R9286 vss.n6409 vss.n1350 17.0005
R9287 vss.n6409 vss.n1349 17.0005
R9288 vss.n6409 vss.n1348 17.0005
R9289 vss.n6409 vss.n1039 17.0005
R9290 vss.n467 vss.n466 0.0152243
R9291 vss.n86 vss.n6021 17.0005
R9292 vss.n86 vss.n3998 17.0005
R9293 vss.n86 vss.n4188 17.0005
R9294 vss.n86 vss.n3999 17.0005
R9295 vss.n86 vss.n4187 17.0005
R9296 vss.n86 vss.n4000 17.0005
R9297 vss.n86 vss.n4186 17.0005
R9298 vss.n86 vss.n4001 17.0005
R9299 vss.n86 vss.n4185 17.0005
R9300 vss.n86 vss.n4002 17.0005
R9301 vss.n86 vss.n4184 17.0005
R9302 vss.n86 vss.n4003 17.0005
R9303 vss.n86 vss.n4183 17.0005
R9304 vss.n86 vss.n4004 17.0005
R9305 vss.n86 vss.n4182 17.0005
R9306 vss.n86 vss.n4005 17.0005
R9307 vss.n86 vss.n4181 17.0005
R9308 vss.n86 vss.n4006 17.0005
R9309 vss.n86 vss.n4180 17.0005
R9310 vss.n86 vss.n4007 17.0005
R9311 vss.n86 vss.n4179 17.0005
R9312 vss.n86 vss.n4008 17.0005
R9313 vss.n86 vss.n4178 17.0005
R9314 vss.n86 vss.n4009 17.0005
R9315 vss.n86 vss.n4177 17.0005
R9316 vss.n86 vss.n4010 17.0005
R9317 vss.n86 vss.n4176 17.0005
R9318 vss.n86 vss.n4011 17.0005
R9319 vss.n86 vss.n4175 17.0005
R9320 vss.n86 vss.n4012 17.0005
R9321 vss.n86 vss.n4174 17.0005
R9322 vss.n1022 vss.n1024 17.0005
R9323 vss.n6020 vss.n1022 17.0005
R9324 vss.n5009 vss.n1022 17.0005
R9325 vss.n4985 vss.n1022 17.0005
R9326 vss.n5008 vss.n1022 17.0005
R9327 vss.n4986 vss.n1022 17.0005
R9328 vss.n5007 vss.n1022 17.0005
R9329 vss.n4987 vss.n1022 17.0005
R9330 vss.n5006 vss.n1022 17.0005
R9331 vss.n4988 vss.n1022 17.0005
R9332 vss.n5005 vss.n1022 17.0005
R9333 vss.n4989 vss.n1022 17.0005
R9334 vss.t167 vss.n1022 17.0005
R9335 vss.n4990 vss.n1022 17.0005
R9336 vss.n5004 vss.n1022 17.0005
R9337 vss.n4991 vss.n1022 17.0005
R9338 vss.n5003 vss.n1022 17.0005
R9339 vss.n4992 vss.n1022 17.0005
R9340 vss.n5002 vss.n1022 17.0005
R9341 vss.n4993 vss.n1022 17.0005
R9342 vss.n5001 vss.n1022 17.0005
R9343 vss.n4994 vss.n1022 17.0005
R9344 vss.n5000 vss.n1022 17.0005
R9345 vss.n4995 vss.n1022 17.0005
R9346 vss.n4999 vss.n1022 17.0005
R9347 vss.n4996 vss.n1022 17.0005
R9348 vss.n4998 vss.n1022 17.0005
R9349 vss.n4997 vss.n1038 8.50075
R9350 vss.n1036 vss.n1024 17.0005
R9351 vss.n6020 vss.n1036 17.0005
R9352 vss.n1036 vss.n5009 17.0005
R9353 vss.n1036 vss.n4985 17.0005
R9354 vss.n1036 vss.n5008 17.0005
R9355 vss.n1036 vss.n4986 17.0005
R9356 vss.n1036 vss.n5007 17.0005
R9357 vss.n1036 vss.n4987 17.0005
R9358 vss.n1036 vss.n5006 17.0005
R9359 vss.n1036 vss.n4988 17.0005
R9360 vss.n1036 vss.n5005 17.0005
R9361 vss.n1036 vss.n4989 17.0005
R9362 vss.n1036 vss.t167 17.0005
R9363 vss.n1036 vss.n4990 17.0005
R9364 vss.n1036 vss.n5004 17.0005
R9365 vss.n1036 vss.n4991 17.0005
R9366 vss.n1036 vss.n5003 17.0005
R9367 vss.n1036 vss.n4992 17.0005
R9368 vss.n1036 vss.n5002 17.0005
R9369 vss.n1036 vss.n4993 17.0005
R9370 vss.n1036 vss.n5001 17.0005
R9371 vss.n1036 vss.n4994 17.0005
R9372 vss.n1036 vss.n5000 17.0005
R9373 vss.n1036 vss.n4995 17.0005
R9374 vss.n1036 vss.n4999 17.0005
R9375 vss.n1036 vss.n4996 17.0005
R9376 vss.n1036 vss.n4998 17.0005
R9377 vss.n1036 vss.n1038 0.00149998
R9378 vss.n6022 vss.n86 17.0005
R9379 vss.n86 vss.n4619 17.0005
R9380 vss.n86 vss.n4620 17.0005
R9381 vss.n86 vss.n4621 17.0005
R9382 vss.n86 vss.n4623 17.0005
R9383 vss.n86 vss.n4624 17.0005
R9384 vss.n86 vss.n4625 17.0005
R9385 vss.n86 vss.n4626 17.0005
R9386 vss.n86 vss.n4627 17.0005
R9387 vss.n86 vss.n4628 17.0005
R9388 vss.n86 vss.n4629 17.0005
R9389 vss.n86 vss.n4630 17.0005
R9390 vss.n86 vss.n4631 17.0005
R9391 vss.n86 vss.n4632 17.0005
R9392 vss.n86 vss.n4633 17.0005
R9393 vss.n86 vss.n4634 17.0005
R9394 vss.n86 vss.n4635 17.0005
R9395 vss.n86 vss.n4636 17.0005
R9396 vss.n86 vss.n4637 17.0005
R9397 vss.n86 vss.n4638 17.0005
R9398 vss.n86 vss.n4639 17.0005
R9399 vss.n86 vss.n4640 17.0005
R9400 vss.n86 vss.n4641 17.0005
R9401 vss.n86 vss.n4642 17.0005
R9402 vss.n86 vss.n4643 17.0005
R9403 vss.n86 vss.n4644 17.0005
R9404 vss.n86 vss.n4645 17.0005
R9405 vss.n86 vss.n4646 17.0005
R9406 vss.n86 vss.n4647 17.0005
R9407 vss.n86 vss.n4648 17.0005
R9408 vss.n86 vss.n4649 17.0005
R9409 vss.n86 vss.n4650 17.0005
R9410 vss.n86 vss.n4651 17.0005
R9411 vss.n86 vss.n4652 17.0005
R9412 vss.n86 vss.n4653 17.0005
R9413 vss.n86 vss.n4654 17.0005
R9414 vss.n86 vss.n4655 17.0005
R9415 vss.n86 vss.n4656 17.0005
R9416 vss.n86 vss.n4657 17.0005
R9417 vss.n86 vss.n4658 17.0005
R9418 vss.n86 vss.n4659 17.0005
R9419 vss.n86 vss.n4660 17.0005
R9420 vss.n86 vss.n4661 17.0005
R9421 vss.n86 vss.n4662 17.0005
R9422 vss.n86 vss.n4663 17.0005
R9423 vss.n86 vss.n4664 17.0005
R9424 vss.n86 vss.n4665 17.0005
R9425 vss.n86 vss.n4666 17.0005
R9426 vss.n86 vss.n4667 17.0005
R9427 vss.n86 vss.n4668 17.0005
R9428 vss.n86 vss.n4669 17.0005
R9429 vss.n86 vss.n4670 17.0005
R9430 vss.n86 vss.n4671 17.0005
R9431 vss.n86 vss.n4672 17.0005
R9432 vss.n86 vss.n4673 17.0005
R9433 vss.n86 vss.n4674 17.0005
R9434 vss.n86 vss.n4675 17.0005
R9435 vss.n86 vss.n4676 17.0005
R9436 vss.n86 vss.n4677 17.0005
R9437 vss.n86 vss.n4678 17.0005
R9438 vss.n86 vss.n4679 17.0005
R9439 vss.n86 vss.n4680 17.0005
R9440 vss.n86 vss.n4681 17.0005
R9441 vss.n86 vss.n4682 17.0005
R9442 vss.n86 vss.n4683 17.0005
R9443 vss.n86 vss.n4684 17.0005
R9444 vss.n86 vss.n4685 17.0005
R9445 vss.n86 vss.n4686 17.0005
R9446 vss.n86 vss.n4687 17.0005
R9447 vss.n86 vss.n4688 17.0005
R9448 vss.n86 vss.n4689 17.0005
R9449 vss.n86 vss.n4690 17.0005
R9450 vss.n86 vss.n4691 17.0005
R9451 vss.n86 vss.n4692 17.0005
R9452 vss.n86 vss.n4693 17.0005
R9453 vss.n86 vss.n4694 17.0005
R9454 vss.n86 vss.n4695 17.0005
R9455 vss.n86 vss.n4696 17.0005
R9456 vss.n86 vss.n4697 17.0005
R9457 vss.n86 vss.n4698 17.0005
R9458 vss.n86 vss.n4699 17.0005
R9459 vss.n86 vss.n4700 17.0005
R9460 vss.n86 vss.n4701 17.0005
R9461 vss.n86 vss.n4702 17.0005
R9462 vss.n86 vss.n4703 17.0005
R9463 vss.n86 vss.n4704 17.0005
R9464 vss.n86 vss.n4705 17.0005
R9465 vss.n86 vss.n4706 17.0005
R9466 vss.n86 vss.n4707 17.0005
R9467 vss.n86 vss.n4708 17.0005
R9468 vss.n86 vss.n4709 17.0005
R9469 vss.n86 vss.n4710 17.0005
R9470 vss.n86 vss.n4711 17.0005
R9471 vss.n86 vss.n4712 17.0005
R9472 vss.n86 vss.n4713 17.0005
R9473 vss.n86 vss.n4714 17.0005
R9474 vss.n86 vss.n4715 17.0005
R9475 vss.n86 vss.n4716 17.0005
R9476 vss.n86 vss.n4717 17.0005
R9477 vss.n86 vss.n4718 17.0005
R9478 vss.n86 vss.n4719 17.0005
R9479 vss.n86 vss.n4720 17.0005
R9480 vss.n86 vss.n4721 17.0005
R9481 vss.n86 vss.n4722 17.0005
R9482 vss.n86 vss.n4723 17.0005
R9483 vss.n86 vss.n4724 17.0005
R9484 vss.n86 vss.n4725 17.0005
R9485 vss.n86 vss.n4726 17.0005
R9486 vss.n86 vss.n4727 17.0005
R9487 vss.n86 vss.n4728 17.0005
R9488 vss.n86 vss.n4729 17.0005
R9489 vss.n86 vss.n4730 17.0005
R9490 vss.n86 vss.n4731 17.0005
R9491 vss.n86 vss.n4732 17.0005
R9492 vss.n86 vss.n4733 17.0005
R9493 vss.n86 vss.n4734 17.0005
R9494 vss.n86 vss.n4735 17.0005
R9495 vss.n86 vss.n4736 17.0005
R9496 vss.n86 vss.n4737 17.0005
R9497 vss.n86 vss.n4738 17.0005
R9498 vss.n86 vss.n4739 17.0005
R9499 vss.n86 vss.n4740 17.0005
R9500 vss.n86 vss.n4741 17.0005
R9501 vss.n86 vss.n4742 17.0005
R9502 vss.n86 vss.n4743 17.0005
R9503 vss.n86 vss.n4744 17.0005
R9504 vss.n86 vss.n4745 17.0005
R9505 vss.n86 vss.n4746 17.0005
R9506 vss.n86 vss.n4747 17.0005
R9507 vss.n86 vss.n4748 17.0005
R9508 vss.n86 vss.n4749 17.0005
R9509 vss.n86 vss.n4750 17.0005
R9510 vss.n86 vss.n4751 17.0005
R9511 vss.n86 vss.n4752 17.0005
R9512 vss.n86 vss.n4753 17.0005
R9513 vss.n86 vss.n4754 17.0005
R9514 vss.n86 vss.n4755 17.0005
R9515 vss.n86 vss.n4756 17.0005
R9516 vss.n86 vss.n4757 17.0005
R9517 vss.n86 vss.n4758 17.0005
R9518 vss.n86 vss.n4759 17.0005
R9519 vss.n86 vss.n4760 17.0005
R9520 vss.n86 vss.n4761 17.0005
R9521 vss.n86 vss.n4762 17.0005
R9522 vss.n86 vss.n4763 17.0005
R9523 vss.n86 vss.n4764 17.0005
R9524 vss.n86 vss.n4765 17.0005
R9525 vss.n86 vss.n4766 17.0005
R9526 vss.n86 vss.n4767 17.0005
R9527 vss.n86 vss.n4768 17.0005
R9528 vss.n86 vss.n4769 17.0005
R9529 vss.n86 vss.n4770 17.0005
R9530 vss.n86 vss.n4771 17.0005
R9531 vss.n86 vss.n4772 17.0005
R9532 vss.n86 vss.n4773 17.0005
R9533 vss.n86 vss.n4774 17.0005
R9534 vss.n86 vss.n4775 17.0005
R9535 vss.n86 vss.n4776 17.0005
R9536 vss.n86 vss.n4777 17.0005
R9537 vss.n86 vss.n4778 17.0005
R9538 vss.n86 vss.n4779 17.0005
R9539 vss.n86 vss.n4780 17.0005
R9540 vss.n86 vss.n4781 17.0005
R9541 vss.n86 vss.n4782 17.0005
R9542 vss.n86 vss.n4783 17.0005
R9543 vss.n86 vss.n4784 17.0005
R9544 vss.n86 vss.n4785 17.0005
R9545 vss.n86 vss.n4786 17.0005
R9546 vss.n86 vss.n4787 17.0005
R9547 vss.n86 vss.n4788 17.0005
R9548 vss.n86 vss.n4789 17.0005
R9549 vss.n86 vss.n4790 17.0005
R9550 vss.n86 vss.n4791 17.0005
R9551 vss.n86 vss.n4792 17.0005
R9552 vss.n86 vss.n4793 17.0005
R9553 vss.n86 vss.n4794 17.0005
R9554 vss.n86 vss.n4795 17.0005
R9555 vss.n86 vss.n4796 17.0005
R9556 vss.n86 vss.n4797 17.0005
R9557 vss.n86 vss.n4798 17.0005
R9558 vss.n86 vss.n4799 17.0005
R9559 vss.n86 vss.n4800 17.0005
R9560 vss.n86 vss.n4801 17.0005
R9561 vss.n86 vss.n4802 17.0005
R9562 vss.n86 vss.n4803 17.0005
R9563 vss.n1022 vss.n4808 17.0005
R9564 vss.n1022 vss.n4809 17.0005
R9565 vss.n1022 vss.n4810 17.0005
R9566 vss.n1022 vss.n4811 17.0005
R9567 vss.n1022 vss.n4812 17.0005
R9568 vss.n1022 vss.n4813 17.0005
R9569 vss.n1022 vss.n4814 17.0005
R9570 vss.n1022 vss.n4815 17.0005
R9571 vss.n1022 vss.n4816 17.0005
R9572 vss.n1022 vss.n4817 17.0005
R9573 vss.n1022 vss.n4818 17.0005
R9574 vss.n1022 vss.n4819 17.0005
R9575 vss.n1022 vss.n4820 17.0005
R9576 vss.n1022 vss.n4821 17.0005
R9577 vss.n1022 vss.n4822 17.0005
R9578 vss.n1022 vss.n4823 17.0005
R9579 vss.n1022 vss.n4824 17.0005
R9580 vss.n1022 vss.n4825 17.0005
R9581 vss.n1022 vss.t180 17.0005
R9582 vss.n1022 vss.n4826 17.0005
R9583 vss.n1022 vss.n4827 17.0005
R9584 vss.n1022 vss.n4828 17.0005
R9585 vss.n1022 vss.n4829 17.0005
R9586 vss.n1022 vss.n4830 17.0005
R9587 vss.n1022 vss.n4831 17.0005
R9588 vss.n1022 vss.n4832 17.0005
R9589 vss.n1022 vss.n4833 17.0005
R9590 vss.n1022 vss.n4834 17.0005
R9591 vss.n1022 vss.n4835 17.0005
R9592 vss.n1022 vss.n4836 17.0005
R9593 vss.n1022 vss.n4837 17.0005
R9594 vss.n1022 vss.n4838 17.0005
R9595 vss.n1022 vss.n4839 17.0005
R9596 vss.n1022 vss.n4840 17.0005
R9597 vss.n1022 vss.n4841 17.0005
R9598 vss.n1022 vss.n4842 17.0005
R9599 vss.n1022 vss.n4843 17.0005
R9600 vss.n1022 vss.n4844 17.0005
R9601 vss.n1022 vss.n4845 17.0005
R9602 vss.n1022 vss.n4846 17.0005
R9603 vss.n1022 vss.n4847 17.0005
R9604 vss.n1022 vss.n4848 17.0005
R9605 vss.n1022 vss.n4849 17.0005
R9606 vss.n1022 vss.n4850 17.0005
R9607 vss.n1022 vss.n4851 17.0005
R9608 vss.n1022 vss.n4852 17.0005
R9609 vss.n1022 vss.n4853 17.0005
R9610 vss.n1022 vss.n4854 17.0005
R9611 vss.n1022 vss.n4855 17.0005
R9612 vss.n1022 vss.n4856 17.0005
R9613 vss.n1022 vss.n4857 17.0005
R9614 vss.n1022 vss.n4858 17.0005
R9615 vss.n1022 vss.n4859 17.0005
R9616 vss.n1022 vss.n4860 17.0005
R9617 vss.n1022 vss.n4861 17.0005
R9618 vss.n1022 vss.n4862 17.0005
R9619 vss.n1022 vss.n4863 17.0005
R9620 vss.n1022 vss.n4864 17.0005
R9621 vss.n1022 vss.n4865 17.0005
R9622 vss.n1022 vss.n4866 17.0005
R9623 vss.n1022 vss.n4867 17.0005
R9624 vss.n1022 vss.n4868 17.0005
R9625 vss.n1022 vss.n4869 17.0005
R9626 vss.n1022 vss.n4870 17.0005
R9627 vss.n1022 vss.n4871 17.0005
R9628 vss.n1022 vss.n4872 17.0005
R9629 vss.n1022 vss.n4873 17.0005
R9630 vss.n1022 vss.n4874 17.0005
R9631 vss.n1022 vss.n4875 17.0005
R9632 vss.n1022 vss.n4876 17.0005
R9633 vss.n1022 vss.n4877 17.0005
R9634 vss.n1022 vss.n4878 17.0005
R9635 vss.n1022 vss.n4879 17.0005
R9636 vss.n1022 vss.n4880 17.0005
R9637 vss.n1022 vss.n4881 17.0005
R9638 vss.n1022 vss.n4882 17.0005
R9639 vss.n1022 vss.n4883 17.0005
R9640 vss.n1022 vss.n4884 17.0005
R9641 vss.n1022 vss.n4885 17.0005
R9642 vss.n1022 vss.n4886 17.0005
R9643 vss.n1022 vss.n4887 17.0005
R9644 vss.n1022 vss.n4888 17.0005
R9645 vss.n1022 vss.n4889 17.0005
R9646 vss.n1022 vss.n4890 17.0005
R9647 vss.n1022 vss.n4891 17.0005
R9648 vss.n1022 vss.n4892 17.0005
R9649 vss.n1022 vss.n4893 17.0005
R9650 vss.n5022 vss.n1022 17.0005
R9651 vss.n1022 vss.n4894 17.0005
R9652 vss.n1022 vss.n4895 17.0005
R9653 vss.n1022 vss.n4896 17.0005
R9654 vss.n1022 vss.n4897 17.0005
R9655 vss.n1022 vss.n4898 17.0005
R9656 vss.n1022 vss.n4899 17.0005
R9657 vss.n1022 vss.n4900 17.0005
R9658 vss.n1022 vss.n4901 17.0005
R9659 vss.n1022 vss.n4902 17.0005
R9660 vss.n1022 vss.n4903 17.0005
R9661 vss.n1022 vss.n4904 17.0005
R9662 vss.n1022 vss.n4905 17.0005
R9663 vss.n1022 vss.n4906 17.0005
R9664 vss.n1022 vss.n4907 17.0005
R9665 vss.n1022 vss.n4908 17.0005
R9666 vss.n1022 vss.n4909 17.0005
R9667 vss.n1022 vss.n4910 17.0005
R9668 vss.n1022 vss.n4911 17.0005
R9669 vss.n1022 vss.n4912 17.0005
R9670 vss.n1022 vss.n4913 17.0005
R9671 vss.n1022 vss.n4914 17.0005
R9672 vss.n1022 vss.n4915 17.0005
R9673 vss.n1022 vss.n4916 17.0005
R9674 vss.n1022 vss.n4917 17.0005
R9675 vss.n1022 vss.n4918 17.0005
R9676 vss.n1022 vss.n4919 17.0005
R9677 vss.n1022 vss.n4920 17.0005
R9678 vss.n1022 vss.n4921 17.0005
R9679 vss.n1022 vss.n4922 17.0005
R9680 vss.n1022 vss.n4923 17.0005
R9681 vss.n1022 vss.n4924 17.0005
R9682 vss.n1022 vss.n4925 17.0005
R9683 vss.n1022 vss.n4926 17.0005
R9684 vss.n1022 vss.n4927 17.0005
R9685 vss.n1022 vss.n4928 17.0005
R9686 vss.n1022 vss.n4929 17.0005
R9687 vss.n1022 vss.n4930 17.0005
R9688 vss.n1022 vss.n4931 17.0005
R9689 vss.n1022 vss.n4932 17.0005
R9690 vss.n1022 vss.n4933 17.0005
R9691 vss.n1022 vss.n4934 17.0005
R9692 vss.n1022 vss.n4935 17.0005
R9693 vss.n1022 vss.n4936 17.0005
R9694 vss.n1022 vss.n4937 17.0005
R9695 vss.n1022 vss.n4938 17.0005
R9696 vss.n1022 vss.n4939 17.0005
R9697 vss.n1022 vss.n4940 17.0005
R9698 vss.n1022 vss.n4941 17.0005
R9699 vss.n1022 vss.n4942 17.0005
R9700 vss.n1022 vss.n4943 17.0005
R9701 vss.n1022 vss.n4944 17.0005
R9702 vss.n1022 vss.n4945 17.0005
R9703 vss.n1022 vss.n4946 17.0005
R9704 vss.n1022 vss.n4947 17.0005
R9705 vss.n1022 vss.n4948 17.0005
R9706 vss.n1022 vss.n4949 17.0005
R9707 vss.n1022 vss.n4950 17.0005
R9708 vss.n1022 vss.n4951 17.0005
R9709 vss.n1022 vss.n4952 17.0005
R9710 vss.n1022 vss.n4953 17.0005
R9711 vss.n1022 vss.n4954 17.0005
R9712 vss.n1022 vss.n4955 17.0005
R9713 vss.n1022 vss.n4956 17.0005
R9714 vss.n1022 vss.n4957 17.0005
R9715 vss.n1022 vss.n4958 17.0005
R9716 vss.n1022 vss.n4959 17.0005
R9717 vss.n1022 vss.n4960 17.0005
R9718 vss.n1022 vss.n4961 17.0005
R9719 vss.n1022 vss.n4962 17.0005
R9720 vss.n1022 vss.n4963 17.0005
R9721 vss.n1022 vss.n4964 17.0005
R9722 vss.n1022 vss.n4965 17.0005
R9723 vss.n1022 vss.n4966 17.0005
R9724 vss.n1022 vss.n4967 17.0005
R9725 vss.n1022 vss.n4968 17.0005
R9726 vss.n1022 vss.n4969 17.0005
R9727 vss.n1022 vss.n4970 17.0005
R9728 vss.n1022 vss.n4971 17.0005
R9729 vss.n1022 vss.n4972 17.0005
R9730 vss.n1022 vss.n4973 17.0005
R9731 vss.n1022 vss.n4974 17.0005
R9732 vss.n1022 vss.n4975 17.0005
R9733 vss.n1022 vss.n4976 17.0005
R9734 vss.n1022 vss.n4977 17.0005
R9735 vss.n1022 vss.n4978 17.0005
R9736 vss.n1022 vss.n4979 17.0005
R9737 vss.n1022 vss.n4980 17.0005
R9738 vss.n1022 vss.n4981 17.0005
R9739 vss.n1022 vss.n4982 17.0005
R9740 vss.n1022 vss.n4983 17.0005
R9741 vss.n1022 vss.n4984 17.0005
R9742 vss.n5525 vss.n3997 17.0005
R9743 vss.n5525 vss.n5524 17.0005
R9744 vss.n5525 vss.n5519 17.0005
R9745 vss.n5525 vss.n5523 17.0005
R9746 vss.n5525 vss.n5520 17.0005
R9747 vss.n5525 vss.n5522 17.0005
R9748 vss.n5525 vss.n5521 17.0005
R9749 vss.n4 vss.n3253 17.0005
R9750 vss.n5459 vss.n437 17.0005
R9751 vss.n437 vss.n461 0.00343609
R9752 vss.n466 vss.n5339 17.0005
R9753 vss.n531 vss.n1724 17.0005
R9754 vss.n531 vss.n1854 17.0005
R9755 vss.n531 vss.n1725 17.0005
R9756 vss.n531 vss.n1853 17.0005
R9757 vss.n531 vss.n1726 17.0005
R9758 vss.n531 vss.n1852 17.0005
R9759 vss.n531 vss.n1727 17.0005
R9760 vss.n531 vss.n1851 17.0005
R9761 vss.n531 vss.n1728 17.0005
R9762 vss.n531 vss.n1850 17.0005
R9763 vss.n531 vss.n1729 17.0005
R9764 vss.n531 vss.n1849 17.0005
R9765 vss.n531 vss.n1730 17.0005
R9766 vss.n531 vss.n1848 17.0005
R9767 vss.n531 vss.n1731 17.0005
R9768 vss.n531 vss.n1847 17.0005
R9769 vss.n531 vss.n1732 17.0005
R9770 vss.n531 vss.n1846 17.0005
R9771 vss.n531 vss.n1733 17.0005
R9772 vss.n531 vss.n1845 17.0005
R9773 vss.n531 vss.n1734 17.0005
R9774 vss.n531 vss.n1844 17.0005
R9775 vss.n531 vss.n1735 17.0005
R9776 vss.n531 vss.n1843 17.0005
R9777 vss.n531 vss.n1736 17.0005
R9778 vss.n531 vss.n1842 17.0005
R9779 vss.n531 vss.n1737 17.0005
R9780 vss.n531 vss.n1841 17.0005
R9781 vss.n531 vss.n1738 17.0005
R9782 vss.n531 vss.n1840 17.0005
R9783 vss.n531 vss.n1739 17.0005
R9784 vss.n531 vss.n1839 17.0005
R9785 vss.n531 vss.n1740 17.0005
R9786 vss.n531 vss.n1838 17.0005
R9787 vss.n531 vss.n1741 17.0005
R9788 vss.n531 vss.n1837 17.0005
R9789 vss.n531 vss.n1742 17.0005
R9790 vss.n531 vss.n1836 17.0005
R9791 vss.n531 vss.n1743 17.0005
R9792 vss.n531 vss.n1835 17.0005
R9793 vss.n531 vss.n1744 17.0005
R9794 vss.n531 vss.n1834 17.0005
R9795 vss.n531 vss.n1745 17.0005
R9796 vss.n531 vss.n1833 17.0005
R9797 vss.n531 vss.n1746 17.0005
R9798 vss.n531 vss.n1832 17.0005
R9799 vss.n531 vss.n1747 17.0005
R9800 vss.n531 vss.n1831 17.0005
R9801 vss.n531 vss.n1748 17.0005
R9802 vss.n531 vss.n1830 17.0005
R9803 vss.n531 vss.n1749 17.0005
R9804 vss.n531 vss.n1829 17.0005
R9805 vss.n531 vss.n1750 17.0005
R9806 vss.n531 vss.n1828 17.0005
R9807 vss.n531 vss.n1751 17.0005
R9808 vss.n531 vss.n1827 17.0005
R9809 vss.n531 vss.n1752 17.0005
R9810 vss.n531 vss.n1826 17.0005
R9811 vss.n531 vss.n1753 17.0005
R9812 vss.n531 vss.n1825 17.0005
R9813 vss.n531 vss.n1754 17.0005
R9814 vss.n531 vss.n1824 17.0005
R9815 vss.n531 vss.n1755 17.0005
R9816 vss.n531 vss.n1823 17.0005
R9817 vss.n531 vss.n1756 17.0005
R9818 vss.n531 vss.n1822 17.0005
R9819 vss.n531 vss.n1757 17.0005
R9820 vss.n531 vss.n1821 17.0005
R9821 vss.n531 vss.n1758 17.0005
R9822 vss.n531 vss.n1820 17.0005
R9823 vss.n531 vss.n1759 17.0005
R9824 vss.n531 vss.n1819 17.0005
R9825 vss.n531 vss.n1760 17.0005
R9826 vss.n531 vss.n1818 17.0005
R9827 vss.n531 vss.n1761 17.0005
R9828 vss.n531 vss.n1817 17.0005
R9829 vss.n531 vss.n1762 17.0005
R9830 vss.n531 vss.n1816 17.0005
R9831 vss.n531 vss.n1763 17.0005
R9832 vss.n531 vss.n1815 17.0005
R9833 vss.n531 vss.n1764 17.0005
R9834 vss.n531 vss.n1814 17.0005
R9835 vss.n531 vss.n1765 17.0005
R9836 vss.n531 vss.n1813 17.0005
R9837 vss.n531 vss.n1766 17.0005
R9838 vss.n531 vss.n1812 17.0005
R9839 vss.n531 vss.n1767 17.0005
R9840 vss.n531 vss.n1811 17.0005
R9841 vss.n531 vss.n1768 17.0005
R9842 vss.n531 vss.n1810 17.0005
R9843 vss.n531 vss.n1769 17.0005
R9844 vss.n531 vss.n1809 17.0005
R9845 vss.n531 vss.n1770 17.0005
R9846 vss.n531 vss.n1808 17.0005
R9847 vss.n531 vss.n1771 17.0005
R9848 vss.n531 vss.n1807 17.0005
R9849 vss.n531 vss.n1772 17.0005
R9850 vss.n531 vss.n1806 17.0005
R9851 vss.n531 vss.n1773 17.0005
R9852 vss.n531 vss.n1805 17.0005
R9853 vss.n531 vss.n1774 17.0005
R9854 vss.n531 vss.n1804 17.0005
R9855 vss.n531 vss.n1775 17.0005
R9856 vss.n531 vss.n1803 17.0005
R9857 vss.n531 vss.n1776 17.0005
R9858 vss.n531 vss.n1802 17.0005
R9859 vss.n531 vss.n1777 17.0005
R9860 vss.n531 vss.n1801 17.0005
R9861 vss.n531 vss.n1778 17.0005
R9862 vss.n531 vss.n1800 17.0005
R9863 vss.n531 vss.n1779 17.0005
R9864 vss.n531 vss.n1799 17.0005
R9865 vss.n531 vss.n1780 17.0005
R9866 vss.n531 vss.n1798 17.0005
R9867 vss.n531 vss.n1781 17.0005
R9868 vss.n531 vss.n1797 17.0005
R9869 vss.n531 vss.n1782 17.0005
R9870 vss.n531 vss.n1796 17.0005
R9871 vss.n531 vss.n1783 17.0005
R9872 vss.n531 vss.n1795 17.0005
R9873 vss.n531 vss.n1784 17.0005
R9874 vss.n531 vss.n1794 17.0005
R9875 vss.n531 vss.n1785 17.0005
R9876 vss.n531 vss.n1793 17.0005
R9877 vss.n531 vss.n1786 17.0005
R9878 vss.n531 vss.n1792 17.0005
R9879 vss.n531 vss.n1787 17.0005
R9880 vss.n531 vss.n1791 17.0005
R9881 vss.n531 vss.n1788 17.0005
R9882 vss.n531 vss.n1790 17.0005
R9883 vss.n531 vss.n1789 17.0005
R9884 vss.n4 vss.n3323 17.0005
R9885 vss.n4 vss.n3321 17.0005
R9886 vss.n4 vss.n3320 17.0005
R9887 vss.n4 vss.n3315 17.0005
R9888 vss.n4 vss.n3304 17.0005
R9889 vss.n4 vss.n3299 17.0005
R9890 vss.n4 vss.n3282 17.0005
R9891 vss.n4 vss.n3267 17.0005
R9892 vss.n4 vss.n3257 17.0005
R9893 vss.n4 vss.n3255 17.0005
R9894 vss.n18 vss.n19 0.0802607
R9895 vss.n14 vss.n4413 17.0005
R9896 vss.n14 vss.n4469 17.0005
R9897 vss.n14 vss.n4414 17.0005
R9898 vss.n14 vss.n4468 17.0005
R9899 vss.n14 vss.n4415 17.0005
R9900 vss.n4600 vss.n14 17.0005
R9901 vss.n14 vss.n4416 17.0005
R9902 vss.n14 vss.n4467 17.0005
R9903 vss.n14 vss.n4417 17.0005
R9904 vss.n14 vss.n4466 17.0005
R9905 vss.n14 vss.n4418 17.0005
R9906 vss.n14 vss.n4465 17.0005
R9907 vss.n14 vss.n4419 17.0005
R9908 vss.n14 vss.n4464 17.0005
R9909 vss.n14 vss.n4420 17.0005
R9910 vss.n14 vss.n4463 17.0005
R9911 vss.n14 vss.n4421 17.0005
R9912 vss.n14 vss.n4462 17.0005
R9913 vss.n14 vss.n4422 17.0005
R9914 vss.n14 vss.n4461 17.0005
R9915 vss.n14 vss.n4423 17.0005
R9916 vss.n14 vss.n4460 17.0005
R9917 vss.n14 vss.n4424 17.0005
R9918 vss.n14 vss.n4459 17.0005
R9919 vss.n14 vss.n4425 17.0005
R9920 vss.n14 vss.n4458 17.0005
R9921 vss.n14 vss.n4426 17.0005
R9922 vss.n14 vss.n4457 17.0005
R9923 vss.n14 vss.n4427 17.0005
R9924 vss.n14 vss.n4456 17.0005
R9925 vss.n14 vss.n4428 17.0005
R9926 vss.n14 vss.n4455 17.0005
R9927 vss.n14 vss.n4429 17.0005
R9928 vss.n14 vss.n4454 17.0005
R9929 vss.n14 vss.n4430 17.0005
R9930 vss.n14 vss.n4453 17.0005
R9931 vss.n14 vss.n4431 17.0005
R9932 vss.n14 vss.n4452 17.0005
R9933 vss.n14 vss.n4432 17.0005
R9934 vss.n14 vss.n4451 17.0005
R9935 vss.n14 vss.n4433 17.0005
R9936 vss.n14 vss.n4450 17.0005
R9937 vss.n14 vss.n4434 17.0005
R9938 vss.n14 vss.n4449 17.0005
R9939 vss.n14 vss.n4435 17.0005
R9940 vss.n14 vss.n4448 17.0005
R9941 vss.n14 vss.n4436 17.0005
R9942 vss.n14 vss.n4447 17.0005
R9943 vss.n14 vss.n4437 17.0005
R9944 vss.n14 vss.n4446 17.0005
R9945 vss.n14 vss.n4438 17.0005
R9946 vss.n14 vss.n4445 17.0005
R9947 vss.n14 vss.n4439 17.0005
R9948 vss.n14 vss.n4444 17.0005
R9949 vss.n14 vss.n4440 17.0005
R9950 vss.n14 vss.n4443 17.0005
R9951 vss.n14 vss.n4441 17.0005
R9952 vss.n14 vss.n4442 17.0005
R9953 vss.n14 vss.n12 17.0005
R9954 vss.n4602 vss.n4601 17.0005
R9955 vss.n4602 vss.n4287 17.0005
R9956 vss.n4602 vss.n4338 17.0005
R9957 vss.n4602 vss.n4288 17.0005
R9958 vss.n4602 vss.n4337 17.0005
R9959 vss.n4602 vss.n167 17.0005
R9960 vss.n4602 vss.n4336 17.0005
R9961 vss.n4602 vss.n4289 17.0005
R9962 vss.n4602 vss.n4335 17.0005
R9963 vss.n4602 vss.n166 17.0005
R9964 vss.n4602 vss.n4334 17.0005
R9965 vss.n4602 vss.n4290 17.0005
R9966 vss.n4602 vss.n4333 17.0005
R9967 vss.n4602 vss.n4291 17.0005
R9968 vss.n4602 vss.n4332 17.0005
R9969 vss.n4602 vss.n4292 17.0005
R9970 vss.n4602 vss.n4331 17.0005
R9971 vss.n4602 vss.n4293 17.0005
R9972 vss.n4602 vss.n4330 17.0005
R9973 vss.n4602 vss.n4294 17.0005
R9974 vss.n4602 vss.n4329 17.0005
R9975 vss.n4602 vss.n4295 17.0005
R9976 vss.n4602 vss.n4328 17.0005
R9977 vss.n4602 vss.n4296 17.0005
R9978 vss.n4602 vss.n4326 17.0005
R9979 vss.n4602 vss.n4297 17.0005
R9980 vss.n4602 vss.n4325 17.0005
R9981 vss.n4602 vss.n4298 17.0005
R9982 vss.n4602 vss.n4324 17.0005
R9983 vss.n4602 vss.n4299 17.0005
R9984 vss.n4602 vss.n4323 17.0005
R9985 vss.n4602 vss.n4300 17.0005
R9986 vss.n4602 vss.n4322 17.0005
R9987 vss.n4602 vss.n4301 17.0005
R9988 vss.n4602 vss.n4321 17.0005
R9989 vss.n4602 vss.n4302 17.0005
R9990 vss.n4602 vss.n4320 17.0005
R9991 vss.n4602 vss.n4303 17.0005
R9992 vss.n4602 vss.n4319 17.0005
R9993 vss.n4602 vss.n4304 17.0005
R9994 vss.n4602 vss.n4318 17.0005
R9995 vss.n4602 vss.n4305 17.0005
R9996 vss.n4602 vss.n4317 17.0005
R9997 vss.n4602 vss.n4306 17.0005
R9998 vss.n4602 vss.n4316 17.0005
R9999 vss.n4602 vss.n4307 17.0005
R10000 vss.n4602 vss.n4315 17.0005
R10001 vss.n4602 vss.n4308 17.0005
R10002 vss.n4602 vss.n4314 17.0005
R10003 vss.n4602 vss.n4309 17.0005
R10004 vss.n4602 vss.n4313 17.0005
R10005 vss.n4602 vss.n4310 17.0005
R10006 vss.n4602 vss.n4312 17.0005
R10007 vss.n4602 vss.n4311 17.0005
R10008 vss.n4603 vss.n4602 17.0005
R10009 vss.n4404 vss.n4403 17.0005
R10010 vss.n4404 vss.n4343 17.0005
R10011 vss.n4404 vss.n4401 17.0005
R10012 vss.n4404 vss.n4344 17.0005
R10013 vss.n4404 vss.n4396 17.0005
R10014 vss.n4404 vss.n4347 17.0005
R10015 vss.n4404 vss.n4395 17.0005
R10016 vss.n4404 vss.n4351 17.0005
R10017 vss.n4404 vss.n4353 17.0005
R10018 vss.n4404 vss.n4394 17.0005
R10019 vss.n4404 vss.n4393 17.0005
R10020 vss.n4404 vss.n4354 17.0005
R10021 vss.n4404 vss.n4390 17.0005
R10022 vss.n4404 vss.n4356 17.0005
R10023 vss.n4404 vss.n4358 17.0005
R10024 vss.n4404 vss.n4389 17.0005
R10025 vss.n4404 vss.n4385 17.0005
R10026 vss.n4404 vss.n4361 17.0005
R10027 vss.n4404 vss.t539 17.0005
R10028 vss.n4404 vss.n4365 17.0005
R10029 vss.n4404 vss.n4384 17.0005
R10030 vss.n4404 vss.n4368 17.0005
R10031 vss.n4404 vss.n4383 17.0005
R10032 vss.n4404 vss.n4376 17.0005
R10033 vss.n4404 vss.n3994 17.0005
R10034 vss.n4404 vss.n4374 17.0005
R10035 vss.n86 vss.n4202 17.0005
R10036 vss.n86 vss.n4203 17.0005
R10037 vss.n86 vss.n4204 17.0005
R10038 vss.n86 vss.n4205 17.0005
R10039 vss.n86 vss.n4206 17.0005
R10040 vss.n86 vss.n4207 17.0005
R10041 vss.n86 vss.n4208 17.0005
R10042 vss.n86 vss.n4209 17.0005
R10043 vss.n86 vss.n4210 17.0005
R10044 vss.n86 vss.n4211 17.0005
R10045 vss.n86 vss.n4212 17.0005
R10046 vss.n86 vss.n4213 17.0005
R10047 vss.n86 vss.n4214 17.0005
R10048 vss.n86 vss.n4215 17.0005
R10049 vss.n86 vss.n4216 17.0005
R10050 vss.n86 vss.n4217 17.0005
R10051 vss.n86 vss.n4218 17.0005
R10052 vss.n86 vss.n4219 17.0005
R10053 vss.n86 vss.n4220 17.0005
R10054 vss.n86 vss.n4221 17.0005
R10055 vss.n86 vss.n4222 17.0005
R10056 vss.n86 vss.n4223 17.0005
R10057 vss.n86 vss.n4224 17.0005
R10058 vss.n86 vss.n4225 17.0005
R10059 vss.n86 vss.n4226 17.0005
R10060 vss.n86 vss.n4227 17.0005
R10061 vss.n86 vss.n4228 17.0005
R10062 vss.t638 vss.n4615 17.0005
R10063 vss.t638 vss.n4229 17.0005
R10064 vss.t638 vss.n4270 17.0005
R10065 vss.t638 vss.n4230 17.0005
R10066 vss.t638 vss.n4269 17.0005
R10067 vss.t638 vss.n4231 17.0005
R10068 vss.t638 vss.n4268 17.0005
R10069 vss.t638 vss.n4232 17.0005
R10070 vss.t638 vss.n4265 17.0005
R10071 vss.t638 vss.n4233 17.0005
R10072 vss.t638 vss.n4262 17.0005
R10073 vss.t638 vss.n4234 17.0005
R10074 vss.t638 vss.n4261 17.0005
R10075 vss.t638 vss.n4235 17.0005
R10076 vss.t638 vss.n4256 17.0005
R10077 vss.t638 vss.n4236 17.0005
R10078 vss.t638 vss.n4255 17.0005
R10079 vss.t638 vss.n4237 17.0005
R10080 vss.t638 vss.n4252 17.0005
R10081 vss.t638 vss.n4238 17.0005
R10082 vss.t638 vss.n4251 17.0005
R10083 vss.t638 vss.n4239 17.0005
R10084 vss.t638 vss.n4250 17.0005
R10085 vss.t638 vss.n4240 17.0005
R10086 vss.t638 vss.n4245 17.0005
R10087 vss.t638 vss.n4241 17.0005
R10088 vss.t638 vss.n4244 17.0005
R10089 vss.t638 vss.n4242 17.0005
R10090 vss.n4616 vss.t638 17.0005
R10091 vss.n86 vss.n4190 17.0005
R10092 vss.n86 vss.n4189 17.0005
R10093 vss.t638 vss.n4271 17.0005
R10094 vss.t638 vss.n4607 17.0005
R10095 vss.t638 vss.n4613 17.0005
R10096 vss.t638 vss.n4614 17.0005
R10097 vss.n86 vss.n4192 17.0005
R10098 vss.n86 vss.n4193 17.0005
R10099 vss.n86 vss.n4194 17.0005
R10100 vss.n86 vss.n4195 17.0005
R10101 vss.n86 vss.n4196 17.0005
R10102 vss.n86 vss.n4197 17.0005
R10103 vss.n86 vss.n4198 17.0005
R10104 vss.n86 vss.n4199 17.0005
R10105 vss.n86 vss.n4200 17.0005
R10106 vss.n86 vss.n4201 17.0005
R10107 vss.t638 vss.n4606 17.0005
R10108 vss.t638 vss.n4282 17.0005
R10109 vss.t638 vss.n4279 17.0005
R10110 vss.t638 vss.n4278 17.0005
R10111 vss.t638 vss.n4277 17.0005
R10112 vss.t638 vss.n4276 17.0005
R10113 vss.t638 vss.n4274 17.0005
R10114 vss.t638 vss.n4273 17.0005
R10115 vss.t638 vss.n4272 17.0005
R10116 vss.n4340 vss.t448 17.0005
R10117 vss.n4369 vss.t443 17.0005
R10118 vss.n4378 vss.t444 17.0005
R10119 vss.n4387 vss.t22 17.0005
R10120 vss.n4397 vss.t516 17.0005
R10121 vss.n531 vss.n1856 17.0005
R10122 vss.n531 vss.n1857 17.0005
R10123 vss.n531 vss.n1858 17.0005
R10124 vss.n531 vss.n1859 17.0005
R10125 vss.n531 vss.n1860 17.0005
R10126 vss.n531 vss.n1861 17.0005
R10127 vss.n531 vss.n1862 17.0005
R10128 vss.n531 vss.n1863 17.0005
R10129 vss.n531 vss.n1864 17.0005
R10130 vss.n531 vss.n1866 17.0005
R10131 vss.n531 vss.n1867 17.0005
R10132 vss.n531 vss.n1869 17.0005
R10133 vss.n531 vss.n1870 17.0005
R10134 vss.n531 vss.n1872 17.0005
R10135 vss.n531 vss.n1873 17.0005
R10136 vss.n531 vss.n1875 17.0005
R10137 vss.n531 vss.n1876 17.0005
R10138 vss.n531 vss.n1878 17.0005
R10139 vss.n531 vss.n1879 17.0005
R10140 vss.n531 vss.n1881 17.0005
R10141 vss.n531 vss.n1882 17.0005
R10142 vss.n531 vss.n1884 17.0005
R10143 vss.n531 vss.n1885 17.0005
R10144 vss.n531 vss.n1886 17.0005
R10145 vss.n531 vss.n1887 17.0005
R10146 vss.n531 vss.n1888 17.0005
R10147 vss.n531 vss.n1889 17.0005
R10148 vss.n531 vss.n1890 17.0005
R10149 vss.n531 vss.n1891 17.0005
R10150 vss.n531 vss.n1892 17.0005
R10151 vss.n531 vss.n1893 17.0005
R10152 vss.n531 vss.n1895 17.0005
R10153 vss.n531 vss.n1896 17.0005
R10154 vss.n531 vss.n1898 17.0005
R10155 vss.n531 vss.n1899 17.0005
R10156 vss.n531 vss.n1901 17.0005
R10157 vss.n531 vss.n1902 17.0005
R10158 vss.n531 vss.n1904 17.0005
R10159 vss.n531 vss.n1905 17.0005
R10160 vss.n531 vss.n1907 17.0005
R10161 vss.n531 vss.n1908 17.0005
R10162 vss.n531 vss.n1909 17.0005
R10163 vss.n531 vss.n1910 17.0005
R10164 vss.n531 vss.n1911 17.0005
R10165 vss.n531 vss.n1912 17.0005
R10166 vss.n531 vss.n1913 17.0005
R10167 vss.n531 vss.n1914 17.0005
R10168 vss.n531 vss.n1915 17.0005
R10169 vss.n531 vss.n1916 17.0005
R10170 vss.n531 vss.n1918 17.0005
R10171 vss.n531 vss.n1919 17.0005
R10172 vss.n531 vss.n1921 17.0005
R10173 vss.n531 vss.n1922 17.0005
R10174 vss.n531 vss.n1924 17.0005
R10175 vss.n531 vss.n1925 17.0005
R10176 vss.n531 vss.n1927 17.0005
R10177 vss.n531 vss.n1928 17.0005
R10178 vss.n531 vss.n1930 17.0005
R10179 vss.n531 vss.n1931 17.0005
R10180 vss.n531 vss.n1932 17.0005
R10181 vss.n531 vss.n1933 17.0005
R10182 vss.n531 vss.n1934 17.0005
R10183 vss.n531 vss.n1935 17.0005
R10184 vss.n531 vss.n1936 17.0005
R10185 vss.n531 vss.n1937 17.0005
R10186 vss.n531 vss.n1938 17.0005
R10187 vss.n531 vss.n1939 17.0005
R10188 vss.n531 vss.n1941 17.0005
R10189 vss.n531 vss.n1942 17.0005
R10190 vss.n531 vss.n1944 17.0005
R10191 vss.n531 vss.n1945 17.0005
R10192 vss.n531 vss.n1947 17.0005
R10193 vss.n531 vss.n1948 17.0005
R10194 vss.n531 vss.n1950 17.0005
R10195 vss.n531 vss.n1951 17.0005
R10196 vss.n531 vss.n1953 17.0005
R10197 vss.n531 vss.n1954 17.0005
R10198 vss.n531 vss.n1955 17.0005
R10199 vss.n531 vss.n1956 17.0005
R10200 vss.n531 vss.n1957 17.0005
R10201 vss.n531 vss.n1958 17.0005
R10202 vss.n531 vss.n1959 17.0005
R10203 vss.n531 vss.n1960 17.0005
R10204 vss.n531 vss.n1961 17.0005
R10205 vss.n531 vss.n1962 17.0005
R10206 vss.n531 vss.n1964 17.0005
R10207 vss.n531 vss.n1965 17.0005
R10208 vss.n531 vss.n1967 17.0005
R10209 vss.n531 vss.n1968 17.0005
R10210 vss.n531 vss.n1970 17.0005
R10211 vss.n531 vss.n1971 17.0005
R10212 vss.n531 vss.n1973 17.0005
R10213 vss.n531 vss.n1974 17.0005
R10214 vss.n531 vss.n1976 17.0005
R10215 vss.n531 vss.n1977 17.0005
R10216 vss.n531 vss.n1978 17.0005
R10217 vss.n531 vss.n1979 17.0005
R10218 vss.n531 vss.n1980 17.0005
R10219 vss.n531 vss.n1981 17.0005
R10220 vss.n531 vss.n1982 17.0005
R10221 vss.n531 vss.n1983 17.0005
R10222 vss.n531 vss.n1984 17.0005
R10223 vss.n531 vss.n1985 17.0005
R10224 vss.n531 vss.n1987 17.0005
R10225 vss.n531 vss.n1988 17.0005
R10226 vss.n531 vss.n1990 17.0005
R10227 vss.n531 vss.n1991 17.0005
R10228 vss.n531 vss.n1993 17.0005
R10229 vss.n531 vss.n1994 17.0005
R10230 vss.n531 vss.n1996 17.0005
R10231 vss.n531 vss.n1997 17.0005
R10232 vss.n531 vss.n1999 17.0005
R10233 vss.n531 vss.n2000 17.0005
R10234 vss.n531 vss.n2001 17.0005
R10235 vss.n531 vss.n2002 17.0005
R10236 vss.n531 vss.n2003 17.0005
R10237 vss.n531 vss.n2004 17.0005
R10238 vss.n531 vss.n2005 17.0005
R10239 vss.n531 vss.n2006 17.0005
R10240 vss.n531 vss.n2007 17.0005
R10241 vss.n531 vss.n2008 17.0005
R10242 vss.n531 vss.n2010 17.0005
R10243 vss.n531 vss.n2011 17.0005
R10244 vss.n531 vss.n2013 17.0005
R10245 vss.n6396 vss.n531 17.0005
R10246 vss.n531 vss.n2014 17.0005
R10247 vss.n531 vss.n2015 17.0005
R10248 vss.n531 vss.n2016 17.0005
R10249 vss.n531 vss.n2017 17.0005
R10250 vss.n531 vss.n2018 17.0005
R10251 vss.n531 vss.n2019 17.0005
R10252 vss.n531 vss.n2020 17.0005
R10253 vss.n531 vss.n2021 17.0005
R10254 vss.n531 vss.n2022 17.0005
R10255 vss.n531 vss.n2023 17.0005
R10256 vss.n531 vss.n2024 17.0005
R10257 vss.n531 vss.n2025 17.0005
R10258 vss.n531 vss.n2026 17.0005
R10259 vss.n531 vss.n2027 17.0005
R10260 vss.n531 vss.n2028 17.0005
R10261 vss.n531 vss.n2029 17.0005
R10262 vss.n531 vss.n2030 17.0005
R10263 vss.n531 vss.n2031 17.0005
R10264 vss.n531 vss.n2032 17.0005
R10265 vss.n531 vss.n2033 17.0005
R10266 vss.n531 vss.n2034 17.0005
R10267 vss.n531 vss.n2035 17.0005
R10268 vss.n531 vss.n2036 17.0005
R10269 vss.n531 vss.n2037 17.0005
R10270 vss.n531 vss.n2038 17.0005
R10271 vss.n531 vss.n2039 17.0005
R10272 vss.n531 vss.n2040 17.0005
R10273 vss.n531 vss.n2041 17.0005
R10274 vss.n531 vss.n2042 17.0005
R10275 vss.n531 vss.n2043 17.0005
R10276 vss.n531 vss.n2044 17.0005
R10277 vss.n531 vss.n2045 17.0005
R10278 vss.n531 vss.n2046 17.0005
R10279 vss.n531 vss.n2047 17.0005
R10280 vss.n531 vss.n2048 17.0005
R10281 vss.n6327 vss.n2379 17.0005
R10282 vss.n6358 vss.n2378 17.0005
R10283 vss.n6367 vss.n6366 17.0005
R10284 vss.n6367 vss.n2358 17.0005
R10285 vss.n6367 vss.n6362 17.0005
R10286 vss.n6367 vss.n2359 17.0005
R10287 vss.n6393 vss.n6392 17.0005
R10288 vss.n6392 vss.n2320 17.0005
R10289 vss.n6392 vss.n2326 17.0005
R10290 vss.n6392 vss.n2324 17.0005
R10291 vss.n6392 vss.n2325 17.0005
R10292 vss.n6384 vss.n6383 17.0005
R10293 vss.n6171 vss.n2699 17.0005
R10294 vss.n2850 vss.n2695 17.0005
R10295 vss.n6037 vss.n3233 17.0005
R10296 vss.n369 vss.n5367 17.0005
R10297 vss.n369 vss.n371 0.0353859
R10298 vss.n3944 vss.t1970 17.0005
R10299 vss.n2951 vss.n287 17.0005
R10300 vss.n287 vss.n2755 17.0005
R10301 vss.n287 vss.n2756 17.0005
R10302 vss.n287 vss.n2757 17.0005
R10303 vss.n287 vss.n2758 17.0005
R10304 vss.n287 vss.n2759 17.0005
R10305 vss.n287 vss.n2760 17.0005
R10306 vss.n287 vss.n2761 17.0005
R10307 vss.n287 vss.n2762 17.0005
R10308 vss.n287 vss.n2763 17.0005
R10309 vss.n287 vss.n2764 17.0005
R10310 vss.n287 vss.n2765 17.0005
R10311 vss.n287 vss.n2766 17.0005
R10312 vss.n287 vss.n2767 17.0005
R10313 vss.n287 vss.n2768 17.0005
R10314 vss.n287 vss.n2770 17.0005
R10315 vss.n287 vss.n2771 17.0005
R10316 vss.n287 vss.n2772 17.0005
R10317 vss.n287 vss.n2773 17.0005
R10318 vss.n287 vss.n2774 17.0005
R10319 vss.n287 vss.n2776 17.0005
R10320 vss.n287 vss.n2777 17.0005
R10321 vss.n287 vss.n2778 17.0005
R10322 vss.n287 vss.n2779 17.0005
R10323 vss.n287 vss.n2780 17.0005
R10324 vss.n287 vss.n2781 17.0005
R10325 vss.n287 vss.n2782 17.0005
R10326 vss.n287 vss.n2783 17.0005
R10327 vss.n287 vss.n2784 17.0005
R10328 vss.n287 vss.n2785 17.0005
R10329 vss.n287 vss.n2786 17.0005
R10330 vss.n287 vss.n2787 17.0005
R10331 vss.n287 vss.n2788 17.0005
R10332 vss.n287 vss.n2789 17.0005
R10333 vss.n287 vss.n2790 17.0005
R10334 vss.n287 vss.n2793 17.0005
R10335 vss.n287 vss.n2794 17.0005
R10336 vss.n287 vss.n2795 17.0005
R10337 vss.n287 vss.n2799 17.0005
R10338 vss.n287 vss.n902 17.0005
R10339 vss.n287 vss.n2801 17.0005
R10340 vss.n287 vss.n2802 17.0005
R10341 vss.n287 vss.n2805 17.0005
R10342 vss.n287 vss.n903 17.0005
R10343 vss.n509 vss.n904 8.50235
R10344 vss.n287 vss.n2810 17.0005
R10345 vss.n287 vss.n2815 17.0005
R10346 vss.n287 vss.n509 0.00130357
R10347 vss.n287 vss.n907 2.03982
R10348 vss.n2882 vss.t126 17.0005
R10349 vss.n2883 vss.t114 17.0005
R10350 vss.n2880 vss.t75 17.0005
R10351 vss.n2881 vss.t115 17.0005
R10352 vss.n2878 vss.t76 17.0005
R10353 vss.n2879 vss.t119 17.0005
R10354 vss.n2897 vss.t766 17.0005
R10355 vss.n2896 vss.t777 17.0005
R10356 vss.n2895 vss.t787 17.0005
R10357 vss.n2894 vss.t74 17.0005
R10358 vss.n2893 vss.t78 17.0005
R10359 vss.n2892 vss.t123 17.0005
R10360 vss.n2844 vss.t767 17.0005
R10361 vss.n2845 vss.t776 17.0005
R10362 vss.n2846 vss.t786 17.0005
R10363 vss.n2847 vss.t111 17.0005
R10364 vss.n2848 vss.t112 17.0005
R10365 vss.n2849 vss.t124 17.0005
R10366 vss.t756 vss.n2843 17.0005
R10367 vss.n2842 vss.t754 17.0005
R10368 vss.n2841 vss.t773 17.0005
R10369 vss.n2840 vss.t752 17.0005
R10370 vss.n2839 vss.t772 17.0005
R10371 vss.n2838 vss.t750 17.0005
R10372 vss.n2837 vss.t770 17.0005
R10373 vss.n2836 vss.t748 17.0005
R10374 vss.n2835 vss.t771 17.0005
R10375 vss.t737 vss.n2834 17.0005
R10376 vss.n2833 vss.t768 17.0005
R10377 vss.n2832 vss.t778 17.0005
R10378 vss.n2831 vss.t62 17.0005
R10379 vss.n2830 vss.t64 17.0005
R10380 vss.n2829 vss.t98 17.0005
R10381 vss.n2917 vss.t738 17.0005
R10382 vss.n2918 vss.t769 17.0005
R10383 vss.n2919 vss.t779 17.0005
R10384 vss.n2920 vss.t63 17.0005
R10385 vss.n2921 vss.t65 17.0005
R10386 vss.n2922 vss.t99 17.0005
R10387 vss.n267 vss.n2562 8.50087
R10388 vss.n267 vss.n2564 17.0005
R10389 vss.n267 vss.n2565 17.0005
R10390 vss.n267 vss.n902 17.0005
R10391 vss.n267 vss.n2568 17.0005
R10392 vss.n267 vss.n903 17.0005
R10393 vss.n267 vss.n2573 17.0005
R10394 vss.n267 vss.n2575 17.0005
R10395 vss.n267 vss.n2576 17.0005
R10396 vss.n267 vss.n2578 17.0005
R10397 vss.n267 vss.n2580 17.0005
R10398 vss.n267 vss.n2581 17.0005
R10399 vss.n267 vss.n905 8.50075
R10400 vss.n267 vss.n906 17.0005
R10401 vss.n287 vss.n2816 17.0005
R10402 vss.n364 vss.n2091 17.0005
R10403 vss.n364 vss.n2090 17.0005
R10404 vss.n364 vss.n2089 17.0005
R10405 vss.n364 vss.n2088 17.0005
R10406 vss.n364 vss.n2087 17.0005
R10407 vss.n364 vss.n2086 17.0005
R10408 vss.n364 vss.n2085 17.0005
R10409 vss.n364 vss.n2084 17.0005
R10410 vss.n364 vss.n2083 17.0005
R10411 vss.n364 vss.n2082 17.0005
R10412 vss.n364 vss.n2081 17.0005
R10413 vss.n364 vss.n2080 17.0005
R10414 vss.n364 vss.n2079 17.0005
R10415 vss.n364 vss.n2078 17.0005
R10416 vss.n364 vss.n2077 17.0005
R10417 vss.n364 vss.n2076 17.0005
R10418 vss.n364 vss.n2075 17.0005
R10419 vss.n364 vss.n2074 17.0005
R10420 vss.n364 vss.n2073 17.0005
R10421 vss.n364 vss.n2072 17.0005
R10422 vss.n364 vss.n2071 17.0005
R10423 vss.n364 vss.n2070 17.0005
R10424 vss.n364 vss.n2069 17.0005
R10425 vss.n364 vss.n2068 17.0005
R10426 vss.n364 vss.n2067 17.0005
R10427 vss.n364 vss.n2066 17.0005
R10428 vss.n364 vss.n2065 17.0005
R10429 vss.n364 vss.n2064 17.0005
R10430 vss.n364 vss.n2063 17.0005
R10431 vss.n364 vss.n2062 17.0005
R10432 vss.n364 vss.n2061 17.0005
R10433 vss.n364 vss.n2060 17.0005
R10434 vss.n364 vss.n2059 17.0005
R10435 vss.n364 vss.n2058 17.0005
R10436 vss.n364 vss.n2057 17.0005
R10437 vss.n364 vss.n2056 17.0005
R10438 vss.n364 vss.n2055 17.0005
R10439 vss.n364 vss.n2054 17.0005
R10440 vss.n364 vss.n2053 17.0005
R10441 vss.n364 vss.n2052 17.0005
R10442 vss.n364 vss.n2051 17.0005
R10443 vss.n364 vss.n2050 17.0005
R10444 vss.n267 vss.n6298 17.0005
R10445 vss.n267 vss.n2635 17.0005
R10446 vss.n267 vss.n2634 17.0005
R10447 vss.n267 vss.n2633 17.0005
R10448 vss.n267 vss.n2632 17.0005
R10449 vss.n267 vss.n2631 17.0005
R10450 vss.n267 vss.n2630 17.0005
R10451 vss.n267 vss.n2629 17.0005
R10452 vss.n267 vss.n2628 17.0005
R10453 vss.n267 vss.n2627 17.0005
R10454 vss.n267 vss.n2626 17.0005
R10455 vss.n267 vss.n2625 17.0005
R10456 vss.n267 vss.n2624 17.0005
R10457 vss.n267 vss.n2623 17.0005
R10458 vss.n6299 vss.n267 17.0005
R10459 vss.n267 vss.n2622 17.0005
R10460 vss.n267 vss.n2621 17.0005
R10461 vss.n267 vss.n2620 17.0005
R10462 vss.n267 vss.n2619 17.0005
R10463 vss.n267 vss.n2618 17.0005
R10464 vss.n267 vss.n2617 17.0005
R10465 vss.n267 vss.n2616 17.0005
R10466 vss.n267 vss.n2615 17.0005
R10467 vss.n267 vss.n2614 17.0005
R10468 vss.n267 vss.n2613 17.0005
R10469 vss.n267 vss.n2612 17.0005
R10470 vss.n267 vss.n2611 17.0005
R10471 vss.n267 vss.n2610 17.0005
R10472 vss.n267 vss.n2609 17.0005
R10473 vss.n267 vss.n2608 17.0005
R10474 vss.n267 vss.n2607 17.0005
R10475 vss.n267 vss.n2606 17.0005
R10476 vss.n267 vss.n2605 17.0005
R10477 vss.n267 vss.n2604 17.0005
R10478 vss.n267 vss.n2603 17.0005
R10479 vss.n267 vss.n2602 17.0005
R10480 vss.n267 vss.n2590 17.0005
R10481 vss.n267 vss.n2589 17.0005
R10482 vss.n267 vss.n2588 17.0005
R10483 vss.n267 vss.n2587 17.0005
R10484 vss.n267 vss.n2586 17.0005
R10485 vss.n267 vss.n6297 17.0005
R10486 vss.n364 vss.n655 17.0005
R10487 vss.n364 vss.n658 17.0005
R10488 vss.n364 vss.n659 17.0005
R10489 vss.n364 vss.n660 17.0005
R10490 vss.n364 vss.n661 17.0005
R10491 vss.n364 vss.n662 17.0005
R10492 vss.n364 vss.n663 17.0005
R10493 vss.n364 vss.n664 17.0005
R10494 vss.n364 vss.n665 17.0005
R10495 vss.n364 vss.n666 17.0005
R10496 vss.n364 vss.n667 17.0005
R10497 vss.n364 vss.n668 17.0005
R10498 vss.n364 vss.n669 17.0005
R10499 vss.n364 vss.n670 17.0005
R10500 vss.n364 vss.n671 17.0005
R10501 vss.n364 vss.n672 17.0005
R10502 vss.n364 vss.n673 17.0005
R10503 vss.n364 vss.n674 17.0005
R10504 vss.n364 vss.n675 17.0005
R10505 vss.n364 vss.n676 17.0005
R10506 vss.n364 vss.n677 17.0005
R10507 vss.n364 vss.n678 17.0005
R10508 vss.n364 vss.n679 17.0005
R10509 vss.n364 vss.n680 17.0005
R10510 vss.n364 vss.n681 17.0005
R10511 vss.n364 vss.n682 17.0005
R10512 vss.n267 vss.n655 17.0005
R10513 vss.n267 vss.n658 17.0005
R10514 vss.n267 vss.n659 17.0005
R10515 vss.n267 vss.n660 17.0005
R10516 vss.n267 vss.n661 17.0005
R10517 vss.n267 vss.n662 17.0005
R10518 vss.n267 vss.n663 17.0005
R10519 vss.n267 vss.n664 17.0005
R10520 vss.n267 vss.n665 17.0005
R10521 vss.n267 vss.n666 17.0005
R10522 vss.n267 vss.n667 17.0005
R10523 vss.n267 vss.n668 17.0005
R10524 vss.n267 vss.n669 17.0005
R10525 vss.n267 vss.n670 17.0005
R10526 vss.n267 vss.n671 17.0005
R10527 vss.n267 vss.n672 17.0005
R10528 vss.n267 vss.n673 17.0005
R10529 vss.n267 vss.n674 17.0005
R10530 vss.n267 vss.n675 17.0005
R10531 vss.n267 vss.n676 17.0005
R10532 vss.n267 vss.n677 17.0005
R10533 vss.n267 vss.n678 17.0005
R10534 vss.n267 vss.n679 17.0005
R10535 vss.n267 vss.n680 17.0005
R10536 vss.n267 vss.n681 17.0005
R10537 vss.n267 vss.n682 17.0005
R10538 vss.n364 vss.n2098 17.0005
R10539 vss.n364 vss.n2097 17.0005
R10540 vss.n364 vss.n2096 17.0005
R10541 vss.n364 vss.n2095 17.0005
R10542 vss.n364 vss.n2094 17.0005
R10543 vss.n364 vss.n2093 17.0005
R10544 vss.n364 vss.n2092 17.0005
R10545 vss.n364 vss.n657 17.0005
R10546 vss.n364 vss.n656 17.0005
R10547 vss.n267 vss.n657 17.0005
R10548 vss.n267 vss.n656 17.0005
R10549 vss.n364 vss.n2099 17.0005
R10550 vss.n364 vss.n2100 17.0005
R10551 vss.n364 vss.n2101 17.0005
R10552 vss.n364 vss.n2102 17.0005
R10553 vss.n364 vss.n2103 17.0005
R10554 vss.n364 vss.n2104 17.0005
R10555 vss.n364 vss.n2105 17.0005
R10556 vss.n364 vss.n2106 17.0005
R10557 vss.n364 vss.n2107 17.0005
R10558 vss.n364 vss.n2108 17.0005
R10559 vss.n364 vss.n2109 17.0005
R10560 vss.n364 vss.n2110 17.0005
R10561 vss.n364 vss.n2111 17.0005
R10562 vss.n364 vss.n2112 17.0005
R10563 vss.n364 vss.n2113 17.0005
R10564 vss.n364 vss.n2114 17.0005
R10565 vss.n364 vss.n2115 17.0005
R10566 vss.n364 vss.n2116 17.0005
R10567 vss.n364 vss.n2117 17.0005
R10568 vss.n364 vss.n2118 17.0005
R10569 vss.n364 vss.n2119 17.0005
R10570 vss.n364 vss.n2120 17.0005
R10571 vss.n364 vss.n2121 17.0005
R10572 vss.n364 vss.n2122 17.0005
R10573 vss.n364 vss.n2123 17.0005
R10574 vss.n364 vss.n2124 17.0005
R10575 vss.n364 vss.n2125 17.0005
R10576 vss.n364 vss.n2126 17.0005
R10577 vss.n364 vss.n2127 17.0005
R10578 vss.n364 vss.n2128 17.0005
R10579 vss.n364 vss.n2129 17.0005
R10580 vss.n364 vss.n2130 17.0005
R10581 vss.n364 vss.n2131 17.0005
R10582 vss.n364 vss.n2132 17.0005
R10583 vss.n364 vss.n2133 17.0005
R10584 vss.n364 vss.n2134 17.0005
R10585 vss.n364 vss.n2135 17.0005
R10586 vss.n364 vss.n2136 17.0005
R10587 vss.n267 vss.n2637 17.0005
R10588 vss.n267 vss.n2638 17.0005
R10589 vss.n267 vss.n2639 17.0005
R10590 vss.n267 vss.n2640 17.0005
R10591 vss.n267 vss.n2641 17.0005
R10592 vss.n267 vss.n2642 17.0005
R10593 vss.n267 vss.n2643 17.0005
R10594 vss.n267 vss.n2644 17.0005
R10595 vss.n267 vss.n2645 17.0005
R10596 vss.n267 vss.n2646 17.0005
R10597 vss.n267 vss.n2647 17.0005
R10598 vss.n267 vss.n2648 17.0005
R10599 vss.n267 vss.n2649 17.0005
R10600 vss.n267 vss.n2650 17.0005
R10601 vss.n267 vss.n2651 17.0005
R10602 vss.n267 vss.n2652 17.0005
R10603 vss.n267 vss.n2653 17.0005
R10604 vss.n267 vss.n2654 17.0005
R10605 vss.n267 vss.n2655 17.0005
R10606 vss.n267 vss.n2656 17.0005
R10607 vss.n267 vss.n2657 17.0005
R10608 vss.n267 vss.n2658 17.0005
R10609 vss.n267 vss.n2659 17.0005
R10610 vss.n267 vss.n2660 17.0005
R10611 vss.n267 vss.n2661 17.0005
R10612 vss.n267 vss.n2662 17.0005
R10613 vss.n267 vss.n6281 17.0005
R10614 vss.n267 vss.n6282 17.0005
R10615 vss.n267 vss.n6283 17.0005
R10616 vss.n267 vss.n6284 17.0005
R10617 vss.n267 vss.n6285 17.0005
R10618 vss.n267 vss.n6286 17.0005
R10619 vss.n267 vss.n6287 17.0005
R10620 vss.n267 vss.n6288 17.0005
R10621 vss.n267 vss.n6289 17.0005
R10622 vss.n267 vss.n6290 17.0005
R10623 vss.n267 vss.n6291 17.0005
R10624 vss.n267 vss.n6292 17.0005
R10625 vss.n267 vss.n6294 17.0005
R10626 vss.n511 vss.n513 0.00196766
R10627 vss.n521 vss.n523 0.00196766
R10628 vss.n2667 vss.t1618 17.0005
R10629 vss.n6237 vss.t1627 17.0005
R10630 vss.n6224 vss.t1621 17.0005
R10631 vss.n6225 vss.t1630 17.0005
R10632 vss.n6222 vss.t1623 17.0005
R10633 vss.n6223 vss.t1631 17.0005
R10634 vss.n6230 vss.t1626 17.0005
R10635 vss.n6231 vss.t1633 17.0005
R10636 vss.n3778 vss.t1667 17.0005
R10637 vss.n3795 vss.t1679 17.0005
R10638 vss.n3782 vss.t1670 17.0005
R10639 vss.n3783 vss.t1682 17.0005
R10640 vss.n3780 vss.t1672 17.0005
R10641 vss.n3781 vss.t1683 17.0005
R10642 vss.n3788 vss.t1675 17.0005
R10643 vss.n3789 vss.t1685 17.0005
R10644 vss.n2670 vss.t1644 17.0005
R10645 vss.n2671 vss.t1653 17.0005
R10646 vss.n2676 vss.t1647 17.0005
R10647 vss.n2677 vss.t1656 17.0005
R10648 vss.n2674 vss.t1649 17.0005
R10649 vss.n2675 vss.t1657 17.0005
R10650 vss.n2682 vss.t1652 17.0005
R10651 vss.n2683 vss.t1659 17.0005
R10652 vss.n2953 vss.n2952 17.0005
R10653 vss.n2953 vss.n2708 17.0005
R10654 vss.n2953 vss.n2744 17.0005
R10655 vss.n2953 vss.n2709 17.0005
R10656 vss.n2953 vss.n2743 17.0005
R10657 vss.n2953 vss.n2710 17.0005
R10658 vss.n2953 vss.n2742 17.0005
R10659 vss.n2953 vss.n2711 17.0005
R10660 vss.n2953 vss.n2741 17.0005
R10661 vss.n2953 vss.n2712 17.0005
R10662 vss.n2953 vss.n2740 17.0005
R10663 vss.n2953 vss.n2713 17.0005
R10664 vss.n2953 vss.n2739 17.0005
R10665 vss.n2953 vss.n2714 17.0005
R10666 vss.n2953 vss.n2738 17.0005
R10667 vss.n2953 vss.n2715 17.0005
R10668 vss.n2953 vss.n2737 17.0005
R10669 vss.n2953 vss.n2716 17.0005
R10670 vss.n2953 vss.n2736 17.0005
R10671 vss.n2953 vss.n2717 17.0005
R10672 vss.n2953 vss.n2735 17.0005
R10673 vss.n2953 vss.n2718 17.0005
R10674 vss.n2953 vss.n2734 17.0005
R10675 vss.n2953 vss.n2719 17.0005
R10676 vss.n2953 vss.n2733 17.0005
R10677 vss.n2953 vss.n2720 17.0005
R10678 vss.n2953 vss.n2732 17.0005
R10679 vss.n2953 vss.n2721 17.0005
R10680 vss.n2953 vss.n2731 17.0005
R10681 vss.n2953 vss.n2722 17.0005
R10682 vss.n2953 vss.n2730 17.0005
R10683 vss.n2953 vss.n2723 17.0005
R10684 vss.n2953 vss.n2729 17.0005
R10685 vss.n2953 vss.n2724 17.0005
R10686 vss.n2953 vss.n2728 17.0005
R10687 vss.n2953 vss.n2725 17.0005
R10688 vss.n2953 vss.n2727 17.0005
R10689 vss.n2953 vss.n2726 17.0005
R10690 vss.n2706 vss.n2697 17.0005
R10691 vss.n2706 vss.n2698 17.0005
R10692 vss.n364 vss.n2139 17.0005
R10693 vss.n364 vss.n2140 17.0005
R10694 vss.n364 vss.n2141 17.0005
R10695 vss.n364 vss.n2142 17.0005
R10696 vss.n364 vss.n2143 17.0005
R10697 vss.n364 vss.n2144 17.0005
R10698 vss.n364 vss.n2145 17.0005
R10699 vss.n364 vss.n2146 17.0005
R10700 vss.n364 vss.n2147 17.0005
R10701 vss.n364 vss.n2148 17.0005
R10702 vss.n364 vss.n2149 17.0005
R10703 vss.n364 vss.n2150 17.0005
R10704 vss.n364 vss.n2151 17.0005
R10705 vss.n364 vss.n2152 17.0005
R10706 vss.n364 vss.n2153 17.0005
R10707 vss.n364 vss.n2154 17.0005
R10708 vss.n364 vss.n741 17.0005
R10709 vss.n364 vss.n2155 17.0005
R10710 vss.n364 vss.n2156 17.0005
R10711 vss.n364 vss.n2157 17.0005
R10712 vss.n364 vss.n2158 17.0005
R10713 vss.n364 vss.n2159 17.0005
R10714 vss.n364 vss.n2160 17.0005
R10715 vss.n364 vss.n2161 17.0005
R10716 vss.n364 vss.n2162 17.0005
R10717 vss.n364 vss.n2163 17.0005
R10718 vss.n364 vss.n2164 17.0005
R10719 vss.n364 vss.n2165 17.0005
R10720 vss.n364 vss.n2166 17.0005
R10721 vss.n364 vss.n2167 17.0005
R10722 vss.n364 vss.n2168 17.0005
R10723 vss.n364 vss.n2169 17.0005
R10724 vss.n364 vss.n2170 17.0005
R10725 vss.n364 vss.n2171 17.0005
R10726 vss.n364 vss.n2172 17.0005
R10727 vss.n364 vss.n2173 17.0005
R10728 vss.n364 vss.n2174 17.0005
R10729 vss.n364 vss.n2175 17.0005
R10730 vss.n364 vss.n2176 17.0005
R10731 vss.n364 vss.n2177 17.0005
R10732 vss.n364 vss.n2178 17.0005
R10733 vss.n364 vss.n2179 17.0005
R10734 vss.n364 vss.n2180 17.0005
R10735 vss.n364 vss.n2181 17.0005
R10736 vss.n364 vss.n2182 17.0005
R10737 vss.n364 vss.n2183 17.0005
R10738 vss.n364 vss.n2184 17.0005
R10739 vss.n364 vss.n2185 17.0005
R10740 vss.n364 vss.n2186 17.0005
R10741 vss.n364 vss.n2187 17.0005
R10742 vss.n364 vss.n2188 17.0005
R10743 vss.n364 vss.n2189 17.0005
R10744 vss.n364 vss.n2190 17.0005
R10745 vss.n364 vss.n2191 17.0005
R10746 vss.n364 vss.n2192 17.0005
R10747 vss.n364 vss.n2193 17.0005
R10748 vss.n364 vss.n2194 17.0005
R10749 vss.n364 vss.n2195 17.0005
R10750 vss.n364 vss.n2196 17.0005
R10751 vss.n364 vss.n2197 17.0005
R10752 vss.n364 vss.n2198 17.0005
R10753 vss.n364 vss.n2199 17.0005
R10754 vss.n364 vss.n2200 17.0005
R10755 vss.n364 vss.n2201 17.0005
R10756 vss.n364 vss.n2202 17.0005
R10757 vss.n364 vss.n2203 17.0005
R10758 vss.n364 vss.n2204 17.0005
R10759 vss.n364 vss.n2205 17.0005
R10760 vss.n364 vss.n2206 17.0005
R10761 vss.n364 vss.n2207 17.0005
R10762 vss.n364 vss.n2208 17.0005
R10763 vss.n364 vss.n2209 17.0005
R10764 vss.n364 vss.n2210 17.0005
R10765 vss.n364 vss.n2211 17.0005
R10766 vss.n364 vss.n2212 17.0005
R10767 vss.n364 vss.n2213 17.0005
R10768 vss.n364 vss.n2214 17.0005
R10769 vss.n364 vss.n2215 17.0005
R10770 vss.n364 vss.n2216 17.0005
R10771 vss.n364 vss.n2217 17.0005
R10772 vss.n364 vss.n2218 17.0005
R10773 vss.n364 vss.n2219 17.0005
R10774 vss.n364 vss.n2220 17.0005
R10775 vss.n364 vss.n2222 17.0005
R10776 vss.n364 vss.n2223 17.0005
R10777 vss.n364 vss.n2225 17.0005
R10778 vss.n364 vss.n2226 17.0005
R10779 vss.n364 vss.n2228 17.0005
R10780 vss.n364 vss.n2229 17.0005
R10781 vss.n364 vss.n2231 17.0005
R10782 vss.n364 vss.n2232 17.0005
R10783 vss.n364 vss.n2234 17.0005
R10784 vss.n364 vss.n2235 17.0005
R10785 vss.n364 vss.n2236 17.0005
R10786 vss.n364 vss.n2237 17.0005
R10787 vss.n364 vss.n2238 17.0005
R10788 vss.n364 vss.n2239 17.0005
R10789 vss.n364 vss.n2240 17.0005
R10790 vss.n364 vss.n2241 17.0005
R10791 vss.n364 vss.n2242 17.0005
R10792 vss.n364 vss.n2243 17.0005
R10793 vss.n364 vss.n2244 17.0005
R10794 vss.n364 vss.n2245 17.0005
R10795 vss.n364 vss.n2246 17.0005
R10796 vss.n364 vss.n2247 17.0005
R10797 vss.n364 vss.n2248 17.0005
R10798 vss.n364 vss.n2249 17.0005
R10799 vss.n364 vss.n2250 17.0005
R10800 vss.n364 vss.n2251 17.0005
R10801 vss.n364 vss.n2252 17.0005
R10802 vss.n364 vss.n2253 17.0005
R10803 vss.n364 vss.n2254 17.0005
R10804 vss.n364 vss.n2255 17.0005
R10805 vss.n364 vss.n2256 17.0005
R10806 vss.n364 vss.n2257 17.0005
R10807 vss.n364 vss.n2258 17.0005
R10808 vss.n364 vss.n2259 17.0005
R10809 vss.n364 vss.n2260 17.0005
R10810 vss.n364 vss.n2261 17.0005
R10811 vss.n364 vss.n2262 17.0005
R10812 vss.n364 vss.n2263 17.0005
R10813 vss.n364 vss.n2264 17.0005
R10814 vss.n364 vss.n2265 17.0005
R10815 vss.n364 vss.n2266 17.0005
R10816 vss.n364 vss.n2267 17.0005
R10817 vss.n364 vss.n2268 17.0005
R10818 vss.n364 vss.n2269 17.0005
R10819 vss.n364 vss.n2270 17.0005
R10820 vss.n364 vss.n2271 17.0005
R10821 vss.n364 vss.n2272 17.0005
R10822 vss.n364 vss.n2273 17.0005
R10823 vss.n364 vss.n2274 17.0005
R10824 vss.n364 vss.n2275 17.0005
R10825 vss.n364 vss.n2276 17.0005
R10826 vss.n364 vss.n2277 17.0005
R10827 vss.n364 vss.n2278 17.0005
R10828 vss.n364 vss.n2279 17.0005
R10829 vss.n364 vss.n2280 17.0005
R10830 vss.n364 vss.n2281 17.0005
R10831 vss.n364 vss.n2282 17.0005
R10832 vss.n364 vss.n2283 17.0005
R10833 vss.n364 vss.n2284 17.0005
R10834 vss.n364 vss.n2285 17.0005
R10835 vss.n364 vss.n2286 17.0005
R10836 vss.n364 vss.n2287 17.0005
R10837 vss.n364 vss.n2288 17.0005
R10838 vss.n364 vss.n2289 17.0005
R10839 vss.n364 vss.n2290 17.0005
R10840 vss.n364 vss.n2291 17.0005
R10841 vss.n364 vss.n2292 17.0005
R10842 vss.n364 vss.n2293 17.0005
R10843 vss.n364 vss.n2294 17.0005
R10844 vss.n364 vss.n2295 17.0005
R10845 vss.n364 vss.n2296 17.0005
R10846 vss.n364 vss.n2297 17.0005
R10847 vss.n364 vss.n2298 17.0005
R10848 vss.n364 vss.n2299 17.0005
R10849 vss.n364 vss.n2300 17.0005
R10850 vss.n364 vss.n2301 17.0005
R10851 vss.n364 vss.n2302 17.0005
R10852 vss.n364 vss.n2303 17.0005
R10853 vss.n364 vss.n2304 17.0005
R10854 vss.n364 vss.n2305 17.0005
R10855 vss.n364 vss.n2306 17.0005
R10856 vss.n364 vss.n2307 17.0005
R10857 vss.n364 vss.n2308 17.0005
R10858 vss.n364 vss.n2309 17.0005
R10859 vss.n364 vss.n2310 17.0005
R10860 vss.n364 vss.n2311 17.0005
R10861 vss.n364 vss.n2312 17.0005
R10862 vss.n364 vss.n2313 17.0005
R10863 vss.n364 vss.n2314 17.0005
R10864 vss.n364 vss.n2315 17.0005
R10865 vss.n3012 vss.n3011 17.0005
R10866 vss.n3012 vss.n2981 17.0005
R10867 vss.n3012 vss.n2994 17.0005
R10868 vss.n3012 vss.n2982 17.0005
R10869 vss.n3012 vss.n2993 17.0005
R10870 vss.n3012 vss.n2983 17.0005
R10871 vss.n3012 vss.n2992 17.0005
R10872 vss.n3012 vss.n2984 17.0005
R10873 vss.n3012 vss.n2991 17.0005
R10874 vss.n3012 vss.n2985 17.0005
R10875 vss.n3012 vss.n2990 17.0005
R10876 vss.n3012 vss.n2986 17.0005
R10877 vss.n3012 vss.n2989 17.0005
R10878 vss.n3012 vss.n2987 17.0005
R10879 vss.n3012 vss.n2988 17.0005
R10880 vss.n3012 vss.n2316 17.0005
R10881 vss.n5302 vss.n5301 17.0005
R10882 vss.n5301 vss.n5293 17.0005
R10883 vss.n488 vss.n788 17.0005
R10884 vss.n488 vss.n793 17.0005
R10885 vss.n488 vss.n789 17.0005
R10886 vss.n488 vss.n792 17.0005
R10887 vss.n488 vss.n790 17.0005
R10888 vss.n488 vss.n791 17.0005
R10889 vss.n488 vss.n747 17.0005
R10890 vss.n488 vss.n786 17.0005
R10891 vss.n488 vss.n748 17.0005
R10892 vss.n488 vss.n785 17.0005
R10893 vss.n488 vss.n749 17.0005
R10894 vss.n488 vss.n784 17.0005
R10895 vss.n488 vss.n750 17.0005
R10896 vss.n488 vss.n783 17.0005
R10897 vss.n488 vss.n751 17.0005
R10898 vss.n488 vss.n782 17.0005
R10899 vss.n488 vss.n752 17.0005
R10900 vss.n488 vss.n781 17.0005
R10901 vss.n488 vss.n753 17.0005
R10902 vss.n488 vss.n780 17.0005
R10903 vss.n488 vss.n754 17.0005
R10904 vss.n488 vss.n779 17.0005
R10905 vss.n488 vss.n755 17.0005
R10906 vss.n488 vss.n778 17.0005
R10907 vss.n488 vss.n756 17.0005
R10908 vss.n488 vss.n777 17.0005
R10909 vss.n488 vss.n757 17.0005
R10910 vss.n488 vss.n776 17.0005
R10911 vss.n488 vss.n758 17.0005
R10912 vss.n488 vss.n775 17.0005
R10913 vss.n488 vss.n759 17.0005
R10914 vss.n488 vss.n774 17.0005
R10915 vss.n488 vss.n760 17.0005
R10916 vss.n488 vss.n773 17.0005
R10917 vss.n488 vss.n761 17.0005
R10918 vss.n488 vss.n772 17.0005
R10919 vss.n488 vss.n762 17.0005
R10920 vss.n488 vss.n771 17.0005
R10921 vss.n488 vss.n763 17.0005
R10922 vss.n488 vss.n770 17.0005
R10923 vss.n488 vss.n764 17.0005
R10924 vss.n488 vss.n769 17.0005
R10925 vss.n488 vss.n765 17.0005
R10926 vss.n488 vss.n768 17.0005
R10927 vss.n488 vss.n766 17.0005
R10928 vss.n488 vss.n767 17.0005
R10929 vss.n726 vss.n737 17.0005
R10930 vss.n726 vss.n732 17.0005
R10931 vss.n726 vss.n736 17.0005
R10932 vss.n726 vss.n733 17.0005
R10933 vss.n726 vss.n735 17.0005
R10934 vss.n726 vss.n727 1.51694
R10935 vss.n5301 vss.n5260 17.0005
R10936 vss.n5301 vss.n5254 17.0005
R10937 vss.n5301 vss.n5253 17.0005
R10938 vss.n5301 vss.n5265 17.0005
R10939 vss.n5301 vss.n5267 17.0005
R10940 vss.n5301 vss.n5268 17.0005
R10941 vss.n5301 vss.n5276 17.0005
R10942 vss.n3177 vss.n3012 17.0005
R10943 vss.n3061 vss.n3012 17.0005
R10944 vss.n3012 vss.n3010 17.0005
R10945 vss.n3175 vss.n3012 17.0005
R10946 vss.t564 vss.n3012 17.0005
R10947 vss.n3170 vss.n3012 17.0005
R10948 vss.n3012 vss.n3009 17.0005
R10949 vss.n3064 vss.n3012 17.0005
R10950 vss.n3166 vss.n3012 17.0005
R10951 vss.n3066 vss.n3012 17.0005
R10952 vss.n3012 vss.n3008 17.0005
R10953 vss.n3162 vss.n3012 17.0005
R10954 vss.n3068 vss.n3012 17.0005
R10955 vss.n3160 vss.n3012 17.0005
R10956 vss.n3012 vss.n3007 17.0005
R10957 vss.n3158 vss.n3012 17.0005
R10958 vss.n3074 vss.n3012 17.0005
R10959 vss.n3012 vss.n3006 17.0005
R10960 vss.n3156 vss.n3012 17.0005
R10961 vss.n3076 vss.n3012 17.0005
R10962 vss.n3154 vss.n3012 17.0005
R10963 vss.n3012 vss.n3005 17.0005
R10964 vss.n3079 vss.n3012 17.0005
R10965 vss.n3152 vss.n3012 17.0005
R10966 vss.n3081 vss.n3012 17.0005
R10967 vss.n3012 vss.n3004 17.0005
R10968 vss.n3150 vss.n3012 17.0005
R10969 vss.n3085 vss.n3012 17.0005
R10970 vss.n3148 vss.n3012 17.0005
R10971 vss.n3012 vss.n3003 17.0005
R10972 vss.n3089 vss.n3012 17.0005
R10973 vss.n3146 vss.n3012 17.0005
R10974 vss.n3091 vss.n3012 17.0005
R10975 vss.n3012 vss.n3002 17.0005
R10976 vss.n3141 vss.n3012 17.0005
R10977 vss.n3093 vss.n3012 17.0005
R10978 vss.n3139 vss.n3012 17.0005
R10979 vss.n3012 vss.n3001 17.0005
R10980 vss.n3096 vss.n3012 17.0005
R10981 vss.n3137 vss.n3012 17.0005
R10982 vss.n3098 vss.n3012 17.0005
R10983 vss.n3012 vss.n3000 17.0005
R10984 vss.n3135 vss.n3012 17.0005
R10985 vss.n3100 vss.n3012 17.0005
R10986 vss.n3130 vss.n3012 17.0005
R10987 vss.n3012 vss.n2999 17.0005
R10988 vss.n3102 vss.n3012 17.0005
R10989 vss.n3104 vss.n3012 17.0005
R10990 vss.n3012 vss.n2998 17.0005
R10991 vss.n3125 vss.n3012 17.0005
R10992 vss.n3106 vss.n3012 17.0005
R10993 vss.n3123 vss.n3012 17.0005
R10994 vss.n3012 vss.n2997 17.0005
R10995 vss.n3109 vss.n3012 17.0005
R10996 vss.n3121 vss.n3012 17.0005
R10997 vss.n3111 vss.n3012 17.0005
R10998 vss.n3012 vss.n2996 17.0005
R10999 vss.n3119 vss.n3012 17.0005
R11000 vss.n3115 vss.n3012 17.0005
R11001 vss.n3117 vss.n3012 17.0005
R11002 vss.n3012 vss.n2995 17.0005
R11003 vss.n5080 vss.n3012 17.0005
R11004 vss.n740 vss.n6128 17.0005
R11005 vss.n740 vss.n6043 17.0005
R11006 vss.n740 vss.n6103 17.0005
R11007 vss.n740 vss.n6044 17.0005
R11008 vss.n740 vss.n6102 17.0005
R11009 vss.n6129 vss.n740 17.0005
R11010 vss.n740 vss.n6101 17.0005
R11011 vss.n740 vss.n6045 17.0005
R11012 vss.n740 vss.n6100 17.0005
R11013 vss.n740 vss.n6046 17.0005
R11014 vss.n740 vss.n6099 17.0005
R11015 vss.n740 vss.n6047 17.0005
R11016 vss.n740 vss.n6098 17.0005
R11017 vss.n740 vss.n6048 17.0005
R11018 vss.n740 vss.n6097 17.0005
R11019 vss.n740 vss.n6049 17.0005
R11020 vss.n740 vss.n6096 17.0005
R11021 vss.n740 vss.n6050 17.0005
R11022 vss.n740 vss.n6095 17.0005
R11023 vss.n740 vss.n6051 17.0005
R11024 vss.n740 vss.n6094 17.0005
R11025 vss.n740 vss.n6052 17.0005
R11026 vss.n740 vss.n6093 17.0005
R11027 vss.n740 vss.n6053 17.0005
R11028 vss.n740 vss.n6092 17.0005
R11029 vss.n740 vss.n6054 17.0005
R11030 vss.n740 vss.n6091 17.0005
R11031 vss.n740 vss.n6055 17.0005
R11032 vss.n740 vss.n6090 17.0005
R11033 vss.n740 vss.n6056 17.0005
R11034 vss.n740 vss.n6089 17.0005
R11035 vss.n740 vss.n6057 17.0005
R11036 vss.n740 vss.n6088 17.0005
R11037 vss.n740 vss.n6058 17.0005
R11038 vss.n740 vss.n6087 17.0005
R11039 vss.n740 vss.n6059 17.0005
R11040 vss.n740 vss.n6086 17.0005
R11041 vss.n740 vss.n6060 17.0005
R11042 vss.n740 vss.n6085 17.0005
R11043 vss.n740 vss.n6061 17.0005
R11044 vss.n740 vss.n6084 17.0005
R11045 vss.n740 vss.n6062 17.0005
R11046 vss.n740 vss.n6083 17.0005
R11047 vss.n740 vss.n6063 17.0005
R11048 vss.n740 vss.n6082 17.0005
R11049 vss.n740 vss.n6064 17.0005
R11050 vss.n740 vss.n6081 17.0005
R11051 vss.n740 vss.n6065 17.0005
R11052 vss.n740 vss.n6080 17.0005
R11053 vss.n740 vss.n6066 17.0005
R11054 vss.n740 vss.n6079 17.0005
R11055 vss.n740 vss.n6067 17.0005
R11056 vss.n740 vss.n6078 17.0005
R11057 vss.n740 vss.n6068 17.0005
R11058 vss.n740 vss.n6077 17.0005
R11059 vss.n740 vss.n6069 17.0005
R11060 vss.n740 vss.n6076 17.0005
R11061 vss.n740 vss.n6070 17.0005
R11062 vss.n740 vss.n6075 17.0005
R11063 vss.n740 vss.n6071 17.0005
R11064 vss.n740 vss.n6074 17.0005
R11065 vss.n740 vss.n6072 17.0005
R11066 vss.n740 vss.n6073 17.0005
R11067 vss.n6131 vss.n6130 17.0005
R11068 vss.n6131 vss.n3013 17.0005
R11069 vss.n6131 vss.n3224 17.0005
R11070 vss.n6131 vss.n3014 17.0005
R11071 vss.n6131 vss.t1304 17.0005
R11072 vss.n6131 vss.t913 17.0005
R11073 vss.n6131 vss.n3223 17.0005
R11074 vss.n6131 vss.n3018 17.0005
R11075 vss.n6131 vss.n3222 17.0005
R11076 vss.n6131 vss.n3021 17.0005
R11077 vss.n6131 vss.n3221 17.0005
R11078 vss.n6131 vss.n3024 17.0005
R11079 vss.n6131 vss.n3220 17.0005
R11080 vss.n6131 vss.n3027 17.0005
R11081 vss.n6131 vss.n3219 17.0005
R11082 vss.n6131 vss.n3030 17.0005
R11083 vss.n6131 vss.n3218 17.0005
R11084 vss.n6131 vss.n3031 17.0005
R11085 vss.n6131 vss.n3214 17.0005
R11086 vss.n6131 vss.n3032 17.0005
R11087 vss.n6131 vss.n3213 17.0005
R11088 vss.n6131 vss.n3033 17.0005
R11089 vss.n6131 vss.n3210 17.0005
R11090 vss.n6131 vss.n3034 17.0005
R11091 vss.n6131 vss.n3209 17.0005
R11092 vss.n6131 vss.n3036 17.0005
R11093 vss.n6131 vss.n3208 17.0005
R11094 vss.n6131 vss.n3037 17.0005
R11095 vss.n6131 vss.n3207 17.0005
R11096 vss.n6131 vss.n3040 17.0005
R11097 vss.n6131 vss.n3041 17.0005
R11098 vss.n6131 vss.n3206 17.0005
R11099 vss.n6131 vss.n3042 17.0005
R11100 vss.n6131 vss.n3043 17.0005
R11101 vss.n6131 vss.n3202 17.0005
R11102 vss.n6131 vss.n3044 17.0005
R11103 vss.n6131 vss.n3201 17.0005
R11104 vss.n6131 vss.n3046 17.0005
R11105 vss.n6131 vss.t1013 17.0005
R11106 vss.n6131 vss.n3049 17.0005
R11107 vss.n6131 vss.n3200 17.0005
R11108 vss.n6131 vss.n3050 17.0005
R11109 vss.n6131 vss.n3196 17.0005
R11110 vss.n6131 vss.n3051 17.0005
R11111 vss.n6131 vss.n3193 17.0005
R11112 vss.n6131 vss.n3052 17.0005
R11113 vss.n6131 vss.n3190 17.0005
R11114 vss.n6131 vss.n3053 17.0005
R11115 vss.n6131 vss.n3189 17.0005
R11116 vss.n6131 vss.n3055 17.0005
R11117 vss.n6131 vss.n3188 17.0005
R11118 vss.n6131 vss.n3056 17.0005
R11119 vss.n6131 vss.n3184 17.0005
R11120 vss.n6131 vss.n3057 17.0005
R11121 vss.n6131 vss.n3183 17.0005
R11122 vss.n6131 vss.n3058 17.0005
R11123 vss.n6131 vss.n3182 17.0005
R11124 vss.n6131 vss.n3059 17.0005
R11125 vss.n6131 vss.n3179 17.0005
R11126 vss.n6132 vss.n6131 17.0005
R11127 vss.n6131 vss.n3178 17.0005
R11128 vss.n6131 vss.n3062 17.0005
R11129 vss.n6131 vss.n3176 17.0005
R11130 vss.n6131 vss.n3063 17.0005
R11131 vss.n6131 vss.n3171 17.0005
R11132 vss.n6131 vss.n3065 17.0005
R11133 vss.n6131 vss.n3167 17.0005
R11134 vss.n6131 vss.n3067 17.0005
R11135 vss.n6131 vss.n3163 17.0005
R11136 vss.n6131 vss.n3069 17.0005
R11137 vss.n6131 vss.n3161 17.0005
R11138 vss.n6131 vss.n3071 17.0005
R11139 vss.n6131 vss.n3159 17.0005
R11140 vss.n6131 vss.n3075 17.0005
R11141 vss.n6131 vss.n3157 17.0005
R11142 vss.n6131 vss.n3077 17.0005
R11143 vss.n6131 vss.n3155 17.0005
R11144 vss.n6131 vss.n3080 17.0005
R11145 vss.n6131 vss.n3153 17.0005
R11146 vss.n6131 vss.n3082 17.0005
R11147 vss.n6131 vss.n3151 17.0005
R11148 vss.n6131 vss.n3086 17.0005
R11149 vss.n6131 vss.n3149 17.0005
R11150 vss.n6131 vss.n3090 17.0005
R11151 vss.n6131 vss.n3147 17.0005
R11152 vss.n6131 vss.n3092 17.0005
R11153 vss.n6131 vss.n3142 17.0005
R11154 vss.n6131 vss.n3094 17.0005
R11155 vss.n6131 vss.n3140 17.0005
R11156 vss.n6131 vss.n3097 17.0005
R11157 vss.n6131 vss.n3138 17.0005
R11158 vss.n6131 vss.n3099 17.0005
R11159 vss.n6131 vss.n3136 17.0005
R11160 vss.n6131 vss.n3101 17.0005
R11161 vss.n6131 vss.n3131 17.0005
R11162 vss.n6131 vss.n3103 17.0005
R11163 vss.n6131 vss.n3129 17.0005
R11164 vss.n6131 vss.n3105 17.0005
R11165 vss.n6131 vss.n3126 17.0005
R11166 vss.n6131 vss.n3107 17.0005
R11167 vss.n6131 vss.n3124 17.0005
R11168 vss.n6131 vss.n3110 17.0005
R11169 vss.n6131 vss.n3122 17.0005
R11170 vss.n6131 vss.n3112 17.0005
R11171 vss.n6131 vss.n3120 17.0005
R11172 vss.n6131 vss.n3116 17.0005
R11173 vss.n6131 vss.n3118 17.0005
R11174 vss.n740 vss.n6118 17.0005
R11175 vss.n740 vss.n6117 17.0005
R11176 vss.n740 vss.n6119 17.0005
R11177 vss.n740 vss.n6116 17.0005
R11178 vss.n740 vss.n6115 17.0005
R11179 vss.n740 vss.n6114 17.0005
R11180 vss.n740 vss.n6113 17.0005
R11181 vss.n740 vss.n6112 17.0005
R11182 vss.n740 vss.n6111 17.0005
R11183 vss.n740 vss.n6110 17.0005
R11184 vss.n740 vss.n6109 17.0005
R11185 vss.n740 vss.n6108 17.0005
R11186 vss.n740 vss.n6107 17.0005
R11187 vss.n740 vss.n6106 17.0005
R11188 vss.n740 vss.n6105 17.0005
R11189 vss.n740 vss.n6104 17.0005
R11190 vss.n5301 vss.n5161 17.0005
R11191 vss.n5301 vss.n5155 17.0005
R11192 vss.n5301 vss.n5154 17.0005
R11193 vss.n5301 vss.n5153 17.0005
R11194 vss.n5301 vss.n5149 17.0005
R11195 vss.n5301 vss.n5145 17.0005
R11196 vss.n5301 vss.n5141 17.0005
R11197 vss.n5301 vss.n5140 17.0005
R11198 vss.n5301 vss.n5135 17.0005
R11199 vss.n5301 vss.n5131 17.0005
R11200 vss.n5301 vss.n5127 17.0005
R11201 vss.n5301 vss.n5121 17.0005
R11202 vss.n5301 vss.n5117 17.0005
R11203 vss.n5301 vss.n5111 17.0005
R11204 vss.n5301 vss.n5102 17.0005
R11205 vss.n86 vss.n4169 17.0005
R11206 vss.n86 vss.n4168 17.0005
R11207 vss.n86 vss.n4167 17.0005
R11208 vss.n86 vss.n4166 17.0005
R11209 vss.n86 vss.n4165 17.0005
R11210 vss.n86 vss.n4164 17.0005
R11211 vss.n86 vss.n4163 17.0005
R11212 vss.n86 vss.n4162 17.0005
R11213 vss.n86 vss.n4161 17.0005
R11214 vss.n86 vss.n4160 17.0005
R11215 vss.n86 vss.n4159 17.0005
R11216 vss.n86 vss.n4158 17.0005
R11217 vss.n86 vss.n4157 17.0005
R11218 vss.n86 vss.n4156 17.0005
R11219 vss.n86 vss.n4155 17.0005
R11220 vss.n86 vss.n4154 17.0005
R11221 vss.n86 vss.n4153 17.0005
R11222 vss.n86 vss.n4152 17.0005
R11223 vss.n86 vss.n4151 17.0005
R11224 vss.n86 vss.n4150 17.0005
R11225 vss.n86 vss.n4149 17.0005
R11226 vss.n86 vss.n4148 17.0005
R11227 vss.n86 vss.n4147 17.0005
R11228 vss.n86 vss.n4146 17.0005
R11229 vss.n86 vss.n4145 17.0005
R11230 vss.n86 vss.n4144 17.0005
R11231 vss.n86 vss.n4143 17.0005
R11232 vss.n86 vss.n4142 17.0005
R11233 vss.n86 vss.n4141 17.0005
R11234 vss.n86 vss.n4140 17.0005
R11235 vss.n86 vss.n4139 17.0005
R11236 vss.n86 vss.n4138 17.0005
R11237 vss.n86 vss.n4137 17.0005
R11238 vss.n86 vss.n4136 17.0005
R11239 vss.n86 vss.n4135 17.0005
R11240 vss.n86 vss.n4134 17.0005
R11241 vss.n86 vss.n4133 17.0005
R11242 vss.n86 vss.n4132 17.0005
R11243 vss.n86 vss.n4131 17.0005
R11244 vss.n86 vss.n4130 17.0005
R11245 vss.n86 vss.n4129 17.0005
R11246 vss.n86 vss.n4128 17.0005
R11247 vss.n86 vss.n4127 17.0005
R11248 vss.n86 vss.n4126 17.0005
R11249 vss.n86 vss.n4125 17.0005
R11250 vss.n86 vss.n4124 17.0005
R11251 vss.n86 vss.n4123 17.0005
R11252 vss.n86 vss.n4122 17.0005
R11253 vss.n86 vss.n4121 17.0005
R11254 vss.n86 vss.n4120 17.0005
R11255 vss.n86 vss.n4119 17.0005
R11256 vss.n86 vss.n4118 17.0005
R11257 vss.n86 vss.n4117 17.0005
R11258 vss.n86 vss.n4116 17.0005
R11259 vss.n86 vss.n4115 17.0005
R11260 vss.n86 vss.n4114 17.0005
R11261 vss.n86 vss.n4113 17.0005
R11262 vss.n86 vss.n4112 17.0005
R11263 vss.n86 vss.n4111 17.0005
R11264 vss.n86 vss.n4110 17.0005
R11265 vss.n86 vss.n4109 17.0005
R11266 vss.n86 vss.n4108 17.0005
R11267 vss.n86 vss.n4107 17.0005
R11268 vss.n86 vss.n4106 17.0005
R11269 vss.n86 vss.n4105 17.0005
R11270 vss.n86 vss.n4104 17.0005
R11271 vss.n86 vss.n4103 17.0005
R11272 vss.n86 vss.n4102 17.0005
R11273 vss.n86 vss.n4101 17.0005
R11274 vss.n86 vss.n4100 17.0005
R11275 vss.n86 vss.n4099 17.0005
R11276 vss.n86 vss.n4098 17.0005
R11277 vss.n86 vss.n4097 17.0005
R11278 vss.n86 vss.n4096 17.0005
R11279 vss.n86 vss.n4095 17.0005
R11280 vss.n86 vss.n4094 17.0005
R11281 vss.n86 vss.n4093 17.0005
R11282 vss.n86 vss.n4092 17.0005
R11283 vss.n86 vss.n4091 17.0005
R11284 vss.n86 vss.n4090 17.0005
R11285 vss.n86 vss.n4089 17.0005
R11286 vss.n86 vss.n4088 17.0005
R11287 vss.n86 vss.n4087 17.0005
R11288 vss.n86 vss.n4086 17.0005
R11289 vss.n86 vss.n4085 17.0005
R11290 vss.n86 vss.n4084 17.0005
R11291 vss.n86 vss.n4083 17.0005
R11292 vss.n86 vss.n4082 17.0005
R11293 vss.n86 vss.n4081 17.0005
R11294 vss.n86 vss.n4080 17.0005
R11295 vss.n86 vss.n4079 17.0005
R11296 vss.n86 vss.n4078 17.0005
R11297 vss.n86 vss.n4077 17.0005
R11298 vss.n86 vss.n4076 17.0005
R11299 vss.n86 vss.n4075 17.0005
R11300 vss.n86 vss.n4074 17.0005
R11301 vss.n86 vss.n4073 17.0005
R11302 vss.n86 vss.n4072 17.0005
R11303 vss.n86 vss.n4071 17.0005
R11304 vss.n86 vss.n4070 17.0005
R11305 vss.n86 vss.n4069 17.0005
R11306 vss.n86 vss.n4068 17.0005
R11307 vss.n86 vss.n4067 17.0005
R11308 vss.n86 vss.n4066 17.0005
R11309 vss.n86 vss.n4065 17.0005
R11310 vss.n86 vss.n4064 17.0005
R11311 vss.n86 vss.n4063 17.0005
R11312 vss.n86 vss.n4062 17.0005
R11313 vss.n86 vss.n4061 17.0005
R11314 vss.n86 vss.n4060 17.0005
R11315 vss.n86 vss.n4059 17.0005
R11316 vss.n86 vss.n4058 17.0005
R11317 vss.n86 vss.n4057 17.0005
R11318 vss.n86 vss.n4056 17.0005
R11319 vss.n86 vss.n4055 17.0005
R11320 vss.n86 vss.n4054 17.0005
R11321 vss.n86 vss.n4053 17.0005
R11322 vss.n86 vss.n4052 17.0005
R11323 vss.n86 vss.n4051 17.0005
R11324 vss.n86 vss.n4050 17.0005
R11325 vss.n86 vss.n4049 17.0005
R11326 vss.n86 vss.n4048 17.0005
R11327 vss.n86 vss.n4047 17.0005
R11328 vss.n86 vss.n4046 17.0005
R11329 vss.n86 vss.n4045 17.0005
R11330 vss.n86 vss.n4044 17.0005
R11331 vss.n86 vss.n4043 17.0005
R11332 vss.n86 vss.n4042 17.0005
R11333 vss.n86 vss.n4041 17.0005
R11334 vss.n86 vss.n4040 17.0005
R11335 vss.n86 vss.n4039 17.0005
R11336 vss.n86 vss.n4038 17.0005
R11337 vss.n86 vss.n4037 17.0005
R11338 vss.n86 vss.n4036 17.0005
R11339 vss.n86 vss.n4035 17.0005
R11340 vss.n86 vss.n4034 17.0005
R11341 vss.n86 vss.n4033 17.0005
R11342 vss.n86 vss.n4032 17.0005
R11343 vss.n86 vss.n4031 17.0005
R11344 vss.n86 vss.n4030 17.0005
R11345 vss.n86 vss.n4029 17.0005
R11346 vss.n86 vss.n4028 17.0005
R11347 vss.n86 vss.n4027 17.0005
R11348 vss.n86 vss.n4026 17.0005
R11349 vss.n86 vss.n4025 17.0005
R11350 vss.n86 vss.n4024 17.0005
R11351 vss.n86 vss.n4023 17.0005
R11352 vss.n86 vss.n4022 17.0005
R11353 vss.n86 vss.n4021 17.0005
R11354 vss.n86 vss.n4020 17.0005
R11355 vss.n86 vss.n4019 17.0005
R11356 vss.n86 vss.n4018 17.0005
R11357 vss.n86 vss.n4017 17.0005
R11358 vss.n86 vss.n4016 17.0005
R11359 vss.n86 vss.n4015 17.0005
R11360 vss.n86 vss.n4014 17.0005
R11361 vss.n86 vss.n4013 17.0005
R11362 vss.t143 vss.n5927 17.0005
R11363 vss.t143 vss.n5697 17.0005
R11364 vss.t143 vss.n5904 17.0005
R11365 vss.t143 vss.n5698 17.0005
R11366 vss.t143 vss.n5903 17.0005
R11367 vss.t143 vss.n5699 17.0005
R11368 vss.t143 vss.n5902 17.0005
R11369 vss.t143 vss.n5700 17.0005
R11370 vss.t143 vss.n5901 17.0005
R11371 vss.t143 vss.n5701 17.0005
R11372 vss.t143 vss.n5900 17.0005
R11373 vss.t143 vss.n5702 17.0005
R11374 vss.t143 vss.n5899 17.0005
R11375 vss.t143 vss.n5703 17.0005
R11376 vss.t143 vss.n5898 17.0005
R11377 vss.t143 vss.n5704 17.0005
R11378 vss.t143 vss.n5897 17.0005
R11379 vss.t143 vss.n5705 17.0005
R11380 vss.t143 vss.n5896 17.0005
R11381 vss.t143 vss.n5706 17.0005
R11382 vss.t143 vss.n5895 17.0005
R11383 vss.t143 vss.n5707 17.0005
R11384 vss.t143 vss.n5894 17.0005
R11385 vss.t143 vss.n5708 17.0005
R11386 vss.t143 vss.n5893 17.0005
R11387 vss.t143 vss.n5709 17.0005
R11388 vss.t143 vss.n5892 17.0005
R11389 vss.t143 vss.n5710 17.0005
R11390 vss.t143 vss.n5891 17.0005
R11391 vss.t143 vss.n5711 17.0005
R11392 vss.t143 vss.n5890 17.0005
R11393 vss.t143 vss.n5712 17.0005
R11394 vss.t143 vss.n5889 17.0005
R11395 vss.t143 vss.n5713 17.0005
R11396 vss.t143 vss.n5888 17.0005
R11397 vss.t143 vss.n5714 17.0005
R11398 vss.t143 vss.n5887 17.0005
R11399 vss.t143 vss.n5715 17.0005
R11400 vss.t143 vss.n5886 17.0005
R11401 vss.t143 vss.n5716 17.0005
R11402 vss.t143 vss.n5885 17.0005
R11403 vss.t143 vss.n5717 17.0005
R11404 vss.t143 vss.n5884 17.0005
R11405 vss.t143 vss.n5718 17.0005
R11406 vss.t143 vss.n5883 17.0005
R11407 vss.t143 vss.n5719 17.0005
R11408 vss.t143 vss.n5882 17.0005
R11409 vss.t143 vss.n5720 17.0005
R11410 vss.t143 vss.n5881 17.0005
R11411 vss.t143 vss.n5721 17.0005
R11412 vss.t143 vss.n5880 17.0005
R11413 vss.t143 vss.n5722 17.0005
R11414 vss.t143 vss.n5879 17.0005
R11415 vss.t143 vss.n5723 17.0005
R11416 vss.t143 vss.n5878 17.0005
R11417 vss.t143 vss.n5724 17.0005
R11418 vss.t143 vss.n5877 17.0005
R11419 vss.t143 vss.n5725 17.0005
R11420 vss.t143 vss.n5876 17.0005
R11421 vss.t143 vss.n5726 17.0005
R11422 vss.t143 vss.n5875 17.0005
R11423 vss.t143 vss.n5727 17.0005
R11424 vss.t143 vss.n5874 17.0005
R11425 vss.t143 vss.n5728 17.0005
R11426 vss.t143 vss.n5873 17.0005
R11427 vss.t143 vss.n5729 17.0005
R11428 vss.t143 vss.n5872 17.0005
R11429 vss.t143 vss.n5730 17.0005
R11430 vss.t143 vss.n5871 17.0005
R11431 vss.t143 vss.n5731 17.0005
R11432 vss.t143 vss.n5870 17.0005
R11433 vss.t143 vss.n5732 17.0005
R11434 vss.t143 vss.n5869 17.0005
R11435 vss.t143 vss.n5733 17.0005
R11436 vss.t143 vss.n5868 17.0005
R11437 vss.t143 vss.n5734 17.0005
R11438 vss.t143 vss.n5867 17.0005
R11439 vss.t143 vss.n5735 17.0005
R11440 vss.t143 vss.n5866 17.0005
R11441 vss.t143 vss.n5696 17.0005
R11442 vss.t143 vss.n5736 17.0005
R11443 vss.t143 vss.n5865 17.0005
R11444 vss.t143 vss.n5739 17.0005
R11445 vss.t143 vss.n5864 17.0005
R11446 vss.t143 vss.n5740 17.0005
R11447 vss.t143 vss.n5863 17.0005
R11448 vss.t143 vss.n5741 17.0005
R11449 vss.t143 vss.n5859 17.0005
R11450 vss.t143 vss.n5742 17.0005
R11451 vss.t143 vss.n5856 17.0005
R11452 vss.t143 vss.n5743 17.0005
R11453 vss.t143 vss.n5855 17.0005
R11454 vss.t143 vss.n5744 17.0005
R11455 vss.t143 vss.n5854 17.0005
R11456 vss.t143 vss.n5745 17.0005
R11457 vss.t143 vss.n5853 17.0005
R11458 vss.t143 vss.n5746 17.0005
R11459 vss.t143 vss.n5852 17.0005
R11460 vss.t143 vss.n5747 17.0005
R11461 vss.t143 vss.n5851 17.0005
R11462 vss.t143 vss.n5748 17.0005
R11463 vss.t143 vss.n5850 17.0005
R11464 vss.t143 vss.n5749 17.0005
R11465 vss.t143 vss.n5849 17.0005
R11466 vss.t143 vss.n5751 17.0005
R11467 vss.t143 vss.n5848 17.0005
R11468 vss.t143 vss.n5752 17.0005
R11469 vss.t143 vss.n5847 17.0005
R11470 vss.t143 vss.n5753 17.0005
R11471 vss.t143 vss.n5843 17.0005
R11472 vss.t143 vss.n5754 17.0005
R11473 vss.t143 vss.n5842 17.0005
R11474 vss.t143 vss.n5755 17.0005
R11475 vss.t143 vss.n5841 17.0005
R11476 vss.t143 vss.n5757 17.0005
R11477 vss.t143 vss.n5840 17.0005
R11478 vss.t143 vss.n5760 17.0005
R11479 vss.t143 vss.n5839 17.0005
R11480 vss.t143 vss.n5761 17.0005
R11481 vss.t143 vss.n5838 17.0005
R11482 vss.t143 vss.n5762 17.0005
R11483 vss.t143 vss.n5837 17.0005
R11484 vss.t143 vss.n5763 17.0005
R11485 vss.t143 vss.n5836 17.0005
R11486 vss.t143 vss.n5764 17.0005
R11487 vss.t143 vss.n5835 17.0005
R11488 vss.t143 vss.n5765 17.0005
R11489 vss.t143 vss.n5834 17.0005
R11490 vss.t143 vss.n5766 17.0005
R11491 vss.t143 vss.n5833 17.0005
R11492 vss.t143 vss.n5767 17.0005
R11493 vss.t143 vss.n5829 17.0005
R11494 vss.t143 vss.n5768 17.0005
R11495 vss.t143 vss.n5828 17.0005
R11496 vss.t143 vss.n5769 17.0005
R11497 vss.t143 vss.n5827 17.0005
R11498 vss.t143 vss.n5771 17.0005
R11499 vss.t143 vss.n5826 17.0005
R11500 vss.t143 vss.n5772 17.0005
R11501 vss.t143 vss.n5825 17.0005
R11502 vss.t143 vss.n5773 17.0005
R11503 vss.t143 vss.n5821 17.0005
R11504 vss.t143 vss.n5774 17.0005
R11505 vss.t143 vss.n5818 17.0005
R11506 vss.t143 vss.n5775 17.0005
R11507 vss.t143 vss.n5817 17.0005
R11508 vss.t143 vss.n5776 17.0005
R11509 vss.t143 vss.n5816 17.0005
R11510 vss.t143 vss.n5777 17.0005
R11511 vss.t143 vss.n5815 17.0005
R11512 vss.t143 vss.n5778 17.0005
R11513 vss.t143 vss.n5814 17.0005
R11514 vss.t143 vss.n5779 17.0005
R11515 vss.t143 vss.n5813 17.0005
R11516 vss.t143 vss.n5780 17.0005
R11517 vss.t143 vss.n5812 17.0005
R11518 vss.t143 vss.n5781 17.0005
R11519 vss.t143 vss.n5811 17.0005
R11520 vss.t143 vss.n5783 17.0005
R11521 vss.t143 vss.n5810 17.0005
R11522 vss.t143 vss.n5784 17.0005
R11523 vss.t143 vss.n5809 17.0005
R11524 vss.t143 vss.n5785 17.0005
R11525 vss.t143 vss.n5805 17.0005
R11526 vss.t143 vss.n5786 17.0005
R11527 vss.t143 vss.n5804 17.0005
R11528 vss.t143 vss.n5788 17.0005
R11529 vss.t143 vss.n5803 17.0005
R11530 vss.t143 vss.n5789 17.0005
R11531 vss.t143 vss.n5802 17.0005
R11532 vss.t143 vss.n5792 17.0005
R11533 vss.t143 vss.n5801 17.0005
R11534 vss.t143 vss.n5793 17.0005
R11535 vss.t143 vss.n5800 17.0005
R11536 vss.t143 vss.n5796 17.0005
R11537 vss.t143 vss.n5799 17.0005
R11538 vss.t1415 vss.n5554 17.0005
R11539 vss.n6012 vss.t1415 17.0005
R11540 vss.t1415 vss.n6010 17.0005
R11541 vss.t1415 vss.n6009 17.0005
R11542 vss.t1415 vss.n5556 17.0005
R11543 vss.t1415 vss.n6006 17.0005
R11544 vss.t1415 vss.n5557 17.0005
R11545 vss.n797 vss.n795 5.61485
R11546 vss.n6001 vss.n795 17.0005
R11547 vss.t521 vss.n5995 17.0005
R11548 vss.t521 vss.n5560 17.0005
R11549 vss.t521 vss.n5994 17.0005
R11550 vss.t521 vss.n5561 17.0005
R11551 vss.t521 vss.n5563 17.0005
R11552 vss.t521 vss.n5990 17.0005
R11553 vss.t521 vss.n5564 17.0005
R11554 vss.t521 vss.n5984 17.0005
R11555 vss.t521 vss.n5565 17.0005
R11556 vss.n803 vss.n801 5.61485
R11557 vss.n5979 vss.n801 17.0005
R11558 vss.t55 vss.n5972 17.0005
R11559 vss.t55 vss.n5568 17.0005
R11560 vss.t55 vss.n5971 17.0005
R11561 vss.t55 vss.n5569 17.0005
R11562 vss.t55 vss.n5571 17.0005
R11563 vss.t55 vss.n5967 17.0005
R11564 vss.t55 vss.n5572 17.0005
R11565 vss.t55 vss.n5961 17.0005
R11566 vss.t55 vss.n5573 17.0005
R11567 vss.n809 vss.n807 5.61485
R11568 vss.n5956 vss.n807 17.0005
R11569 vss.t224 vss.n5695 17.0005
R11570 vss.t224 vss.n5576 17.0005
R11571 vss.t224 vss.n5577 17.0005
R11572 vss.t224 vss.n5694 17.0005
R11573 vss.t224 vss.n5578 17.0005
R11574 vss.t224 vss.n5580 17.0005
R11575 vss.t224 vss.n5689 17.0005
R11576 vss.t224 vss.n5581 17.0005
R11577 vss.t224 vss.n5683 17.0005
R11578 vss.t224 vss.n5582 17.0005
R11579 vss.n815 vss.n813 5.61485
R11580 vss.n5678 vss.n813 17.0005
R11581 vss.t796 vss.n5671 17.0005
R11582 vss.t796 vss.n5585 17.0005
R11583 vss.t796 vss.n5670 17.0005
R11584 vss.t796 vss.n5586 17.0005
R11585 vss.t796 vss.n5588 17.0005
R11586 vss.t796 vss.n5666 17.0005
R11587 vss.t796 vss.n5589 17.0005
R11588 vss.t796 vss.n5660 17.0005
R11589 vss.t796 vss.n5590 17.0005
R11590 vss.n821 vss.n819 5.61485
R11591 vss.n5655 vss.n819 17.0005
R11592 vss.t823 vss.n5648 17.0005
R11593 vss.t823 vss.n5593 17.0005
R11594 vss.t823 vss.n5647 17.0005
R11595 vss.t823 vss.n5594 17.0005
R11596 vss.t823 vss.n5596 17.0005
R11597 vss.t823 vss.n5643 17.0005
R11598 vss.t823 vss.n5597 17.0005
R11599 vss.t823 vss.n5637 17.0005
R11600 vss.t823 vss.n5598 17.0005
R11601 vss.t47 vss.n5636 17.0005
R11602 vss.n827 vss.n5634 17.0005
R11603 vss.n827 vss.n5603 17.0005
R11604 vss.n5630 vss.n170 17.0005
R11605 vss.n5628 vss.n170 17.0005
R11606 vss.n5625 vss.n829 17.0005
R11607 vss.n829 vss.n5607 17.0005
R11608 vss.n5621 vss.n186 17.0005
R11609 vss.n186 vss.n5609 17.0005
R11610 vss.n187 vss.n5620 17.0005
R11611 vss.n187 vss.n826 8.47111
R11612 vss.n2468 vss.n2467 17.0005
R11613 vss.n2468 vss.n2435 17.0005
R11614 vss.n2468 vss.n2463 17.0005
R11615 vss.n2468 vss.n2436 17.0005
R11616 vss.n2468 vss.n2462 17.0005
R11617 vss.n2468 vss.n2437 17.0005
R11618 vss.n2468 vss.n2461 17.0005
R11619 vss.n2468 vss.n2438 17.0005
R11620 vss.n2468 vss.n2460 17.0005
R11621 vss.n2468 vss.n2439 17.0005
R11622 vss.n2468 vss.n2459 17.0005
R11623 vss.n2468 vss.n2440 17.0005
R11624 vss.n2468 vss.n2453 17.0005
R11625 vss.n2468 vss.n2441 17.0005
R11626 vss.n2468 vss.n2452 17.0005
R11627 vss.n2468 vss.n2442 17.0005
R11628 vss.n2468 vss.n2451 17.0005
R11629 vss.n2468 vss.n2443 17.0005
R11630 vss.n2468 vss.n2448 17.0005
R11631 vss.n2468 vss.n2446 17.0005
R11632 vss.n2468 vss.n2447 17.0005
R11633 vss.n6398 vss.n6397 17.0005
R11634 vss.n6398 vss.n1478 17.0005
R11635 vss.n6398 vss.n1723 17.0005
R11636 vss.n6398 vss.n1479 17.0005
R11637 vss.n6398 vss.n1722 17.0005
R11638 vss.n6398 vss.n1481 17.0005
R11639 vss.n6398 vss.n1721 17.0005
R11640 vss.n6398 vss.n1482 17.0005
R11641 vss.n6398 vss.n1720 17.0005
R11642 vss.n6398 vss.n1483 17.0005
R11643 vss.n6398 vss.n1713 17.0005
R11644 vss.n6398 vss.n1484 17.0005
R11645 vss.n6398 vss.n1707 17.0005
R11646 vss.n6398 vss.n1485 17.0005
R11647 vss.n6398 vss.n1706 17.0005
R11648 vss.n6398 vss.n1486 17.0005
R11649 vss.n6398 vss.n1705 17.0005
R11650 vss.n6398 vss.n1487 17.0005
R11651 vss.n6398 vss.n1702 17.0005
R11652 vss.n6398 vss.n1489 17.0005
R11653 vss.n6398 vss.n1701 17.0005
R11654 vss.n6398 vss.n1490 17.0005
R11655 vss.n6398 vss.n1700 17.0005
R11656 vss.n6398 vss.n1491 17.0005
R11657 vss.n6398 vss.n1693 17.0005
R11658 vss.n6398 vss.n1492 17.0005
R11659 vss.n6398 vss.n1687 17.0005
R11660 vss.n6398 vss.n1493 17.0005
R11661 vss.n6398 vss.n1686 17.0005
R11662 vss.n6398 vss.n1494 17.0005
R11663 vss.n6398 vss.n1685 17.0005
R11664 vss.n6398 vss.n1495 17.0005
R11665 vss.n6398 vss.n1682 17.0005
R11666 vss.n6398 vss.n1497 17.0005
R11667 vss.n6398 vss.n1681 17.0005
R11668 vss.n6398 vss.n1498 17.0005
R11669 vss.n6398 vss.n1680 17.0005
R11670 vss.n6398 vss.n1499 17.0005
R11671 vss.n6398 vss.n1679 17.0005
R11672 vss.n6398 vss.n1505 17.0005
R11673 vss.n6398 vss.n1672 17.0005
R11674 vss.n6398 vss.n1506 17.0005
R11675 vss.n6398 vss.n1671 17.0005
R11676 vss.n6398 vss.n1507 17.0005
R11677 vss.n6398 vss.n1668 17.0005
R11678 vss.n6398 vss.n1508 17.0005
R11679 vss.n6398 vss.n1667 17.0005
R11680 vss.n6398 vss.n1510 17.0005
R11681 vss.n6398 vss.n1666 17.0005
R11682 vss.n6398 vss.n1511 17.0005
R11683 vss.n6398 vss.n1665 17.0005
R11684 vss.n6398 vss.n1512 17.0005
R11685 vss.n6398 vss.n1658 17.0005
R11686 vss.n6398 vss.n1513 17.0005
R11687 vss.n6398 vss.n1652 17.0005
R11688 vss.n6398 vss.n1514 17.0005
R11689 vss.n6398 vss.n1651 17.0005
R11690 vss.n6398 vss.n1515 17.0005
R11691 vss.n6398 vss.n1650 17.0005
R11692 vss.n6398 vss.n1516 17.0005
R11693 vss.n6398 vss.n1647 17.0005
R11694 vss.n6398 vss.n1518 17.0005
R11695 vss.n6398 vss.n1646 17.0005
R11696 vss.n6398 vss.n1519 17.0005
R11697 vss.n6398 vss.n1645 17.0005
R11698 vss.n6398 vss.n1520 17.0005
R11699 vss.n6398 vss.n1644 17.0005
R11700 vss.n6398 vss.n1526 17.0005
R11701 vss.n6398 vss.n1637 17.0005
R11702 vss.n6398 vss.n1527 17.0005
R11703 vss.n6398 vss.n1636 17.0005
R11704 vss.n6398 vss.n1528 17.0005
R11705 vss.n6398 vss.n1635 17.0005
R11706 vss.n6398 vss.n1529 17.0005
R11707 vss.n6398 vss.n1632 17.0005
R11708 vss.n6398 vss.n1531 17.0005
R11709 vss.n6398 vss.n1631 17.0005
R11710 vss.n6398 vss.n1532 17.0005
R11711 vss.n6398 vss.n1630 17.0005
R11712 vss.n6398 vss.n1533 17.0005
R11713 vss.n6398 vss.n1629 17.0005
R11714 vss.n6398 vss.n1539 17.0005
R11715 vss.n6398 vss.n1622 17.0005
R11716 vss.n6398 vss.n1540 17.0005
R11717 vss.n6398 vss.n1621 17.0005
R11718 vss.n6398 vss.n1541 17.0005
R11719 vss.n6398 vss.n1618 17.0005
R11720 vss.n6398 vss.n1542 17.0005
R11721 vss.n6398 vss.n1617 17.0005
R11722 vss.n6398 vss.n1544 17.0005
R11723 vss.n6398 vss.n1616 17.0005
R11724 vss.n6398 vss.n1545 17.0005
R11725 vss.n6398 vss.n1615 17.0005
R11726 vss.n6398 vss.n1546 17.0005
R11727 vss.n6398 vss.n1614 17.0005
R11728 vss.n6398 vss.n1552 17.0005
R11729 vss.n6398 vss.n1607 17.0005
R11730 vss.n6398 vss.n1553 17.0005
R11731 vss.n6398 vss.n1606 17.0005
R11732 vss.n6398 vss.n1554 17.0005
R11733 vss.n6398 vss.n1603 17.0005
R11734 vss.n6398 vss.n1555 17.0005
R11735 vss.n6398 vss.n1602 17.0005
R11736 vss.n6398 vss.n1557 17.0005
R11737 vss.n6398 vss.n1601 17.0005
R11738 vss.n6398 vss.n1558 17.0005
R11739 vss.n6398 vss.n1600 17.0005
R11740 vss.n6398 vss.n1559 17.0005
R11741 vss.n6398 vss.n1599 17.0005
R11742 vss.n6398 vss.n1565 17.0005
R11743 vss.n6398 vss.n1592 17.0005
R11744 vss.n6398 vss.n1566 17.0005
R11745 vss.n6398 vss.n1591 17.0005
R11746 vss.n6398 vss.n1567 17.0005
R11747 vss.n6398 vss.n1588 17.0005
R11748 vss.n6398 vss.n1568 17.0005
R11749 vss.n6398 vss.n1587 17.0005
R11750 vss.n6398 vss.n1570 17.0005
R11751 vss.n6398 vss.n1586 17.0005
R11752 vss.n6398 vss.n1571 17.0005
R11753 vss.n6398 vss.n1585 17.0005
R11754 vss.n6398 vss.n1572 17.0005
R11755 vss.n6398 vss.n1578 17.0005
R11756 vss.n6398 vss.n1573 17.0005
R11757 vss.n6398 vss.n1575 17.0005
R11758 vss.n6398 vss.n1574 17.0005
R11759 vss.n1576 vss.t1441 17.0005
R11760 vss.n1581 vss.t1444 17.0005
R11761 vss.n1579 vss.t1446 17.0005
R11762 vss.n1594 vss.t1449 17.0005
R11763 vss.n1593 vss.t1451 17.0005
R11764 vss.n1562 vss.t1454 17.0005
R11765 vss.n1560 vss.t1456 17.0005
R11766 vss.n1609 vss.t1459 17.0005
R11767 vss.n1608 vss.t1461 17.0005
R11768 vss.n1549 vss.t1464 17.0005
R11769 vss.n1547 vss.t1466 17.0005
R11770 vss.n1624 vss.t1469 17.0005
R11771 vss.n1623 vss.t1471 17.0005
R11772 vss.n1536 vss.t1474 17.0005
R11773 vss.n1534 vss.t1476 17.0005
R11774 vss.n1639 vss.t1479 17.0005
R11775 vss.n1638 vss.t1481 17.0005
R11776 vss.n1523 vss.t1484 17.0005
R11777 vss.n1521 vss.t1486 17.0005
R11778 vss.n1654 vss.t1489 17.0005
R11779 vss.n1653 vss.t1491 17.0005
R11780 vss.n1661 vss.t1494 17.0005
R11781 vss.n1659 vss.t1496 17.0005
R11782 vss.n1674 vss.t1499 17.0005
R11783 vss.n1673 vss.t1501 17.0005
R11784 vss.n1502 vss.t1504 17.0005
R11785 vss.n1500 vss.t1506 17.0005
R11786 vss.n1689 vss.t1509 17.0005
R11787 vss.n1688 vss.t1511 17.0005
R11788 vss.n1696 vss.t1514 17.0005
R11789 vss.n1694 vss.t1516 17.0005
R11790 vss.n1709 vss.t1519 17.0005
R11791 vss.n1708 vss.t1521 17.0005
R11792 vss.n1716 vss.t1524 17.0005
R11793 vss.n1714 vss.t1526 17.0005
R11794 vss.n1476 vss.t1529 17.0005
R11795 vss.n2444 vss.t1531 17.0005
R11796 vss.n2455 vss.t1534 17.0005
R11797 vss.n2454 vss.t1536 17.0005
R11798 vss.n2433 vss.t1539 17.0005
R11799 vss.n2432 vss.t1541 17.0005
R11800 vss.n2464 vss.t1544 17.0005
R11801 vss.n2371 vss.t1546 17.0005
R11802 vss.n2367 vss.t1549 17.0005
R11803 vss.n2365 vss.t1551 17.0005
R11804 vss.n6308 vss.t1553 17.0005
R11805 vss.n6307 vss.t1555 17.0005
R11806 vss.n6364 vss.t1558 17.0005
R11807 vss.n5317 vss.t1965 17.0005
R11808 vss.n5056 vss.t1968 17.0005
R11809 vss.n5049 vss.t1983 17.0005
R11810 vss.n5050 vss.t1980 17.0005
R11811 vss.n5044 vss.t1941 17.0005
R11812 vss.n5045 vss.t1956 17.0005
R11813 vss.n5310 vss.n839 17.0005
R11814 vss.n5328 vss.t1938 17.0005
R11815 vss.n5329 vss.t1953 17.0005
R11816 vss.n5063 vss.t1911 17.0005
R11817 vss.n5064 vss.t1914 17.0005
R11818 vss.n5058 vss.t1908 17.0005
R11819 vss.n5059 vss.t1912 17.0005
R11820 vss.n2338 vss.t1886 17.0005
R11821 vss.n2339 vss.t1899 17.0005
R11822 vss.n2333 vss.t1883 17.0005
R11823 vss.n2334 vss.t1897 17.0005
R11824 vss.n2331 vss.t1871 17.0005
R11825 vss.n6374 vss.t1868 17.0005
R11826 vss.n6386 vss.t1853 17.0005
R11827 vss.n6380 vss.t1851 17.0005
R11828 vss.n2328 vss.t1840 17.0005
R11829 vss.n2322 vss.t1837 17.0005
R11830 vss.n2347 vss.t1815 17.0005
R11831 vss.n2348 vss.t1828 17.0005
R11832 vss.n2352 vss.t1812 17.0005
R11833 vss.n2353 vss.t1826 17.0005
R11834 vss.n2506 vss.t1722 17.0005
R11835 vss.n2507 vss.t1725 17.0005
R11836 vss.n2529 vss.t1719 17.0005
R11837 vss.n2530 vss.t1723 17.0005
R11838 vss.n2517 vss.t1714 17.0005
R11839 vss.n2523 vss.t1717 17.0005
R11840 vss.n2519 vss.t1711 17.0005
R11841 vss.n2520 vss.t1715 17.0005
R11842 vss.n2508 vss.t1706 17.0005
R11843 vss.n2514 vss.t1709 17.0005
R11844 vss.n2510 vss.t1703 17.0005
R11845 vss.n2511 vss.t1707 17.0005
R11846 vss.n2496 vss.t1698 17.0005
R11847 vss.n2497 vss.t1701 17.0005
R11848 vss.n2500 vss.t1695 17.0005
R11849 vss.n2501 vss.t1699 17.0005
R11850 vss.n2491 vss.t1690 17.0005
R11851 vss.n2538 vss.t1693 17.0005
R11852 vss.n2493 vss.t1687 17.0005
R11853 vss.n2494 vss.t1691 17.0005
R11854 vss.n2488 vss.t1664 17.0005
R11855 vss.n2489 vss.t1678 17.0005
R11856 vss.n2544 vss.t1661 17.0005
R11857 vss.n2545 vss.t1676 17.0005
R11858 vss.n2478 vss.t1638 17.0005
R11859 vss.n2479 vss.t1642 17.0005
R11860 vss.n2482 vss.t1635 17.0005
R11861 vss.n2483 vss.t1640 17.0005
R11862 vss.n2473 vss.t1579 17.0005
R11863 vss.n2552 vss.t1582 17.0005
R11864 vss.n2475 vss.t1576 17.0005
R11865 vss.n2476 vss.t1580 17.0005
R11866 vss.n2591 vss.t1571 17.0005
R11867 vss.n2592 vss.t1574 17.0005
R11868 vss.n2595 vss.t1568 17.0005
R11869 vss.n2596 vss.t1572 17.0005
R11870 vss.n2556 vss.t1563 17.0005
R11871 vss.n6302 vss.t1566 17.0005
R11872 vss.n2558 vss.t1560 17.0005
R11873 vss.n2559 vss.t1564 17.0005
R11874 vss.n475 vss.n476 0.00196766
R11875 vss.n6240 vss.t1601 17.0005
R11876 vss.n6258 vss.t1610 17.0005
R11877 vss.n6245 vss.t1604 17.0005
R11878 vss.n6246 vss.t1613 17.0005
R11879 vss.n6243 vss.t1606 17.0005
R11880 vss.n6244 vss.t1614 17.0005
R11881 vss.n6251 vss.t1609 17.0005
R11882 vss.n6252 vss.t1616 17.0005
R11883 vss.n470 vss.n472 0.00196766
R11884 vss.n2664 vss.t1584 17.0005
R11885 vss.n6262 vss.t1593 17.0005
R11886 vss.n6267 vss.t1587 17.0005
R11887 vss.n6268 vss.t1596 17.0005
R11888 vss.n6265 vss.t1589 17.0005
R11889 vss.n6266 vss.t1597 17.0005
R11890 vss.n6273 vss.t1592 17.0005
R11891 vss.n6274 vss.t1599 17.0005
R11892 vss.n2817 vss.t1316 17.0005
R11893 vss.n2818 vss.t103 17.0005
R11894 vss.n2819 vss.t722 17.0005
R11895 vss.n2820 vss.t107 17.0005
R11896 vss.n2821 vss.t723 17.0005
R11897 vss.n2822 vss.t109 17.0005
R11898 vss.n5481 vss.t1986 17.0005
R11899 vss.n5032 vss.t1988 17.0005
R11900 vss.n5035 vss.t1991 17.0005
R11901 vss.n5033 vss.t1993 17.0005
R11902 vss.n5471 vss.t1996 17.0005
R11903 vss.n5468 vss.t1998 17.0005
R11904 vss.n5463 vss.t2001 17.0005
R11905 vss.n5340 vss.t2003 17.0005
R11906 vss.n5448 vss.t2006 17.0005
R11907 vss.n5447 vss.t2008 17.0005
R11908 vss.n5446 vss.t2011 17.0005
R11909 vss.n5445 vss.t2013 17.0005
R11910 vss.n5442 vss.t2016 17.0005
R11911 vss.n914 vss.n431 5.64879
R11912 vss.n5381 vss.n429 17.0005
R11913 vss.n5385 vss.n429 17.0005
R11914 vss.n5379 vss.n433 17.0005
R11915 vss.n5389 vss.n433 17.0005
R11916 vss.n5377 vss.n435 17.0005
R11917 vss.n5393 vss.n435 17.0005
R11918 vss.n452 vss.n435 0.00138287
R11919 vss.n453 vss.n435 5.64438
R11920 vss.n455 vss.n435 5.64438
R11921 vss.n457 vss.n435 5.64438
R11922 vss.n435 vss.n5414 17.0005
R11923 vss.n435 vss.n5415 17.0005
R11924 vss.n435 vss.n5422 17.0005
R11925 vss.n435 vss.n5423 17.0005
R11926 vss.n435 vss.n5430 17.0005
R11927 vss.n435 vss.n5431 17.0005
R11928 vss.n5355 vss.t2059 17.0005
R11929 vss.n5354 vss.t2046 17.0005
R11930 vss.n5353 vss.t2043 17.0005
R11931 vss.n5352 vss.t2041 17.0005
R11932 vss.n5351 vss.t2038 17.0005
R11933 vss.n5350 vss.t2036 17.0005
R11934 vss.n5349 vss.t2033 17.0005
R11935 vss.n5348 vss.t2031 17.0005
R11936 vss.n5347 vss.t2028 17.0005
R11937 vss.n5346 vss.t2026 17.0005
R11938 vss.n5345 vss.t2023 17.0005
R11939 vss.n5344 vss.t2021 17.0005
R11940 vss.n5343 vss.t2018 17.0005
R11941 vss.n3528 vss.t343 17.0005
R11942 vss.n3529 vss.t336 17.0005
R11943 vss.n3578 vss.t348 17.0005
R11944 vss.n3568 vss.t351 17.0005
R11945 vss.n3533 vss.t354 17.0005
R11946 vss.n3558 vss.t357 17.0005
R11947 vss.n3535 vss.t364 17.0005
R11948 vss.n3549 vss.t362 17.0005
R11949 vss.n5358 vss.t2048 17.0005
R11950 vss.n5363 vss.t2051 17.0005
R11951 vss.n5362 vss.t2053 17.0005
R11952 vss.n5369 vss.t2056 17.0005
R11953 vss.n3960 vss.t1944 17.0005
R11954 vss.n3974 vss.t1957 17.0005
R11955 vss.n3967 vss.n915 17.0005
R11956 vss.n426 vss.n427 0.0258175
R11957 vss.n3970 vss.t1946 17.0005
R11958 vss.n3971 vss.t1960 17.0005
R11959 vss.n3962 vss.t1948 17.0005
R11960 vss.n3968 vss.t1961 17.0005
R11961 vss.n3963 vss.t1951 17.0005
R11962 vss.n3964 vss.t1963 17.0005
R11963 vss.n3749 vss.t1921 17.0005
R11964 vss.n3978 vss.t1930 17.0005
R11965 vss.n3990 vss.t1924 17.0005
R11966 vss.n3991 vss.t1933 17.0005
R11967 vss.n3981 vss.t1926 17.0005
R11968 vss.n3988 vss.t1934 17.0005
R11969 vss.n3982 vss.t1929 17.0005
R11970 vss.n3983 vss.t1936 17.0005
R11971 vss.n3924 vss.t1888 17.0005
R11972 vss.n3941 vss.t1900 17.0005
R11973 vss.n3928 vss.t1891 17.0005
R11974 vss.n3929 vss.t1903 17.0005
R11975 vss.n3926 vss.t1893 17.0005
R11976 vss.n3927 vss.t1904 17.0005
R11977 vss.n3934 vss.t1896 17.0005
R11978 vss.n3935 vss.t1906 17.0005
R11979 vss.n3921 vss.t1873 17.0005
R11980 vss.n3245 vss.t1876 17.0005
R11981 vss.n3244 vss.t1878 17.0005
R11982 vss.n3250 vss.t1881 17.0005
R11983 vss.n405 vss.n3907 17.0005
R11984 vss.n405 vss.n3888 17.0005
R11985 vss.n405 vss.n3892 17.0005
R11986 vss.n405 vss.n3889 17.0005
R11987 vss.n3916 vss.n405 17.0005
R11988 vss.n405 vss.n3881 17.0005
R11989 vss.n405 vss.n3887 17.0005
R11990 vss.n405 vss.n404 17.0005
R11991 vss.n407 vss.n3901 17.0005
R11992 vss.n407 vss.n408 1.25213
R11993 vss.n407 vss.n3879 17.0005
R11994 vss.n3918 vss.t1854 17.0005
R11995 vss.n3896 vss.t1857 17.0005
R11996 vss.n3895 vss.t1858 17.0005
R11997 vss.n3903 vss.t1860 17.0005
R11998 vss.n3884 vss.t1842 17.0005
R11999 vss.n3914 vss.t1845 17.0005
R12000 vss.n3908 vss.t1847 17.0005
R12001 vss.n3909 vss.t1850 17.0005
R12002 vss.n3858 vss.t1818 17.0005
R12003 vss.n3873 vss.t1829 17.0005
R12004 vss.n3865 vss.n920 17.0005
R12005 vss.n401 vss.n402 0.0258175
R12006 vss.n3868 vss.t1820 17.0005
R12007 vss.n3869 vss.t1832 17.0005
R12008 vss.n3860 vss.t1822 17.0005
R12009 vss.n3866 vss.t1833 17.0005
R12010 vss.n3861 vss.t1825 17.0005
R12011 vss.n3862 vss.t1835 17.0005
R12012 vss.n3751 vss.t1796 17.0005
R12013 vss.n3855 vss.t1804 17.0005
R12014 vss.n3758 vss.n925 17.0005
R12015 vss.n396 vss.n397 0.0258175
R12016 vss.n3761 vss.t1798 17.0005
R12017 vss.n3762 vss.t1807 17.0005
R12018 vss.n3753 vss.t1800 17.0005
R12019 vss.n3759 vss.t1808 17.0005
R12020 vss.n3754 vss.t1803 17.0005
R12021 vss.n3755 vss.t1810 17.0005
R12022 vss.n3848 vss.t1779 17.0005
R12023 vss.n3849 vss.t1787 17.0005
R12024 vss.n3841 vss.n930 17.0005
R12025 vss.n391 vss.n392 0.0258175
R12026 vss.n3844 vss.t1781 17.0005
R12027 vss.n3845 vss.t1790 17.0005
R12028 vss.n3836 vss.t1783 17.0005
R12029 vss.n3842 vss.t1791 17.0005
R12030 vss.n3837 vss.t1786 17.0005
R12031 vss.n3838 vss.t1793 17.0005
R12032 vss.n3776 vss.t1762 17.0005
R12033 vss.n3777 vss.t1770 17.0005
R12034 vss.n3769 vss.n935 17.0005
R12035 vss.n387 vss.n388 0.0258175
R12036 vss.n3772 vss.t1764 17.0005
R12037 vss.n3773 vss.t1773 17.0005
R12038 vss.n3764 vss.t1766 17.0005
R12039 vss.n3770 vss.t1774 17.0005
R12040 vss.n3765 vss.t1769 17.0005
R12041 vss.n3766 vss.t1776 17.0005
R12042 vss.n3815 vss.t1745 17.0005
R12043 vss.n3829 vss.t1753 17.0005
R12044 vss.n3822 vss.n940 17.0005
R12045 vss.n383 vss.n384 0.0258175
R12046 vss.n3825 vss.t1747 17.0005
R12047 vss.n3826 vss.t1756 17.0005
R12048 vss.n3817 vss.t1749 17.0005
R12049 vss.n3823 vss.t1757 17.0005
R12050 vss.n3818 vss.t1752 17.0005
R12051 vss.n3819 vss.t1759 17.0005
R12052 vss.n3798 vss.t1728 17.0005
R12053 vss.n3812 vss.t1736 17.0005
R12054 vss.n3805 vss.n945 17.0005
R12055 vss.n378 vss.n379 0.0258175
R12056 vss.n3808 vss.t1730 17.0005
R12057 vss.n3809 vss.t1739 17.0005
R12058 vss.n3800 vss.t1732 17.0005
R12059 vss.n3806 vss.t1740 17.0005
R12060 vss.n3801 vss.t1735 17.0005
R12061 vss.n3802 vss.t1742 17.0005
R12062 vss.n3948 vss.t1973 17.0005
R12063 vss.n3947 vss.t1975 17.0005
R12064 vss.n3953 vss.t1978 17.0005
R12065 vss.n4341 vss.t518 17.0005
R12066 vss.n5501 vss.n8 17.875
R12067 vss.n5199 vss.t1202 16.7943
R12068 vss.n5203 vss.t1189 16.7943
R12069 vss.n86 vss.n4617 16.7421
R12070 vss.n3075 vss.t201 16.7043
R12071 vss.n3176 vss.t566 16.7043
R12072 vss.n3051 vss.t1389 16.7043
R12073 vss.t982 vss.n2193 16.7043
R12074 vss.n6089 vss.n3032 16.7043
R12075 vss.n6095 vss.n3221 16.7043
R12076 vss.n5509 vss.n2 16.6927
R12077 vss.n2810 vss.t741 16.3871
R12078 vss.n904 vss.t1253 16.3871
R12079 vss.t785 vss.n2749 16.3871
R12080 vss.t2060 vss.n4004 16.1611
R12081 vss.n5021 vss.n23 47.8772
R12082 vss.n6023 vss.n71 16.1295
R12083 vss.t2067 vss.n5134 16.0526
R12084 vss.n742 vss.n6146 16.0316
R12085 vss.n5269 vss.t1243 16.0133
R12086 vss.n6297 vss.n360 15.9139
R12087 vss.n4531 vss.n4413 15.7775
R12088 vss.n5906 vss.n2376 15.7722
R12089 vss.n2581 vss.t102 15.7568
R12090 vss.t935 vss.n766 15.7471
R12091 vss.t495 vss.n786 15.7471
R12092 vss.n1311 vss.t483 15.4447
R12093 vss.n1194 vss.t484 15.4447
R12094 vss.n1198 vss.t883 15.4447
R12095 vss.n3944 vss.t2181 15.3099
R12096 vss.n6237 vss.t2340 15.3099
R12097 vss.n2667 vss.t2344 15.3099
R12098 vss.n6231 vss.t2337 15.3099
R12099 vss.n6230 vss.t2341 15.3099
R12100 vss.n3795 vss.t2315 15.3099
R12101 vss.n3778 vss.t2321 15.3099
R12102 vss.n3789 vss.t2312 15.3099
R12103 vss.n3788 vss.t2318 15.3099
R12104 vss.n2671 vss.t2328 15.3099
R12105 vss.n2670 vss.t2334 15.3099
R12106 vss.n2683 vss.t2325 15.3099
R12107 vss.n2682 vss.t2331 15.3099
R12108 vss.n1581 vss.t2422 15.3099
R12109 vss.n1594 vss.t2420 15.3099
R12110 vss.n1562 vss.t2418 15.3099
R12111 vss.n1609 vss.t2416 15.3099
R12112 vss.n1549 vss.t2414 15.3099
R12113 vss.n1624 vss.t2412 15.3099
R12114 vss.n1536 vss.t2410 15.3099
R12115 vss.n1639 vss.t2408 15.3099
R12116 vss.n1523 vss.t2406 15.3099
R12117 vss.n1654 vss.t2404 15.3099
R12118 vss.n1661 vss.t2402 15.3099
R12119 vss.n1674 vss.t2400 15.3099
R12120 vss.n1502 vss.t2398 15.3099
R12121 vss.n1689 vss.t2396 15.3099
R12122 vss.n1696 vss.t2394 15.3099
R12123 vss.n1709 vss.t2392 15.3099
R12124 vss.n1716 vss.t2390 15.3099
R12125 vss.n1476 vss.t2388 15.3099
R12126 vss.n2455 vss.t2386 15.3099
R12127 vss.n2433 vss.t2384 15.3099
R12128 vss.n2464 vss.t2382 15.3099
R12129 vss.n2367 vss.t2380 15.3099
R12130 vss.n6308 vss.t2378 15.3099
R12131 vss.n6364 vss.t2376 15.3099
R12132 vss.n5056 vss.t2186 15.3099
R12133 vss.n5049 vss.t2176 15.3099
R12134 vss.n5045 vss.t2188 15.3099
R12135 vss.n5044 vss.t2194 15.3099
R12136 vss.n5064 vss.t2208 15.3099
R12137 vss.n5063 vss.t2210 15.3099
R12138 vss.n2339 vss.t2212 15.3099
R12139 vss.n2338 vss.t2218 15.3099
R12140 vss.n2331 vss.t2224 15.3099
R12141 vss.n6386 vss.t2230 15.3099
R12142 vss.n2328 vss.t2238 15.3099
R12143 vss.n2348 vss.t2244 15.3099
R12144 vss.n2347 vss.t2290 15.3099
R12145 vss.n2507 vss.t2292 15.3099
R12146 vss.n2506 vss.t2294 15.3099
R12147 vss.n2523 vss.t2296 15.3099
R12148 vss.n2517 vss.t2298 15.3099
R12149 vss.n2514 vss.t2300 15.3099
R12150 vss.n2508 vss.t2302 15.3099
R12151 vss.n2497 vss.t2304 15.3099
R12152 vss.n2496 vss.t2306 15.3099
R12153 vss.n2538 vss.t2308 15.3099
R12154 vss.n2491 vss.t2310 15.3099
R12155 vss.n2489 vss.t2316 15.3099
R12156 vss.n2488 vss.t2323 15.3099
R12157 vss.n2479 vss.t2329 15.3099
R12158 vss.n2478 vss.t2335 15.3099
R12159 vss.n2552 vss.t2363 15.3099
R12160 vss.n2473 vss.t2365 15.3099
R12161 vss.n2592 vss.t2367 15.3099
R12162 vss.n2591 vss.t2369 15.3099
R12163 vss.n6302 vss.t2371 15.3099
R12164 vss.n2556 vss.t2374 15.3099
R12165 vss.n6258 vss.t2348 15.3099
R12166 vss.n6240 vss.t2352 15.3099
R12167 vss.n6252 vss.t2345 15.3099
R12168 vss.n6251 vss.t2349 15.3099
R12169 vss.n6262 vss.t2356 15.3099
R12170 vss.n2664 vss.t2360 15.3099
R12171 vss.n6274 vss.t2353 15.3099
R12172 vss.n6273 vss.t2357 15.3099
R12173 vss.n5032 vss.t2168 15.3099
R12174 vss.n5033 vss.t2166 15.3099
R12175 vss.n5468 vss.t2164 15.3099
R12176 vss.n5340 vss.t2162 15.3099
R12177 vss.n5447 vss.t2160 15.3099
R12178 vss.n5445 vss.t2158 15.3099
R12179 vss.n5354 vss.t2145 15.3099
R12180 vss.n5352 vss.t2147 15.3099
R12181 vss.n5350 vss.t2149 15.3099
R12182 vss.n5348 vss.t2151 15.3099
R12183 vss.n5346 vss.t2153 15.3099
R12184 vss.n5344 vss.t2155 15.3099
R12185 vss.n5358 vss.t2173 15.3099
R12186 vss.n5369 vss.t2170 15.3099
R12187 vss.n3974 vss.t2185 15.3099
R12188 vss.n3960 vss.t2193 15.3099
R12189 vss.n3964 vss.t2182 15.3099
R12190 vss.n3963 vss.t2190 15.3099
R12191 vss.n3978 vss.t2199 15.3099
R12192 vss.n3749 vss.t2203 15.3099
R12193 vss.n3983 vss.t2196 15.3099
R12194 vss.n3982 vss.t2200 15.3099
R12195 vss.n3941 vss.t2207 15.3099
R12196 vss.n3924 vss.t2217 15.3099
R12197 vss.n3935 vss.t2204 15.3099
R12198 vss.n3934 vss.t2214 15.3099
R12199 vss.n3921 vss.t2223 15.3099
R12200 vss.n3250 vss.t2220 15.3099
R12201 vss.n3918 vss.t2229 15.3099
R12202 vss.n3903 vss.t2226 15.3099
R12203 vss.n3884 vss.t2237 15.3099
R12204 vss.n3909 vss.t2234 15.3099
R12205 vss.n3873 vss.t2243 15.3099
R12206 vss.n3858 vss.t2249 15.3099
R12207 vss.n3862 vss.t2240 15.3099
R12208 vss.n3861 vss.t2246 15.3099
R12209 vss.n3855 vss.t2253 15.3099
R12210 vss.n3751 vss.t2257 15.3099
R12211 vss.n3755 vss.t2250 15.3099
R12212 vss.n3754 vss.t2254 15.3099
R12213 vss.n3849 vss.t2261 15.3099
R12214 vss.n3848 vss.t2265 15.3099
R12215 vss.n3838 vss.t2258 15.3099
R12216 vss.n3837 vss.t2262 15.3099
R12217 vss.n3777 vss.t2269 15.3099
R12218 vss.n3776 vss.t2273 15.3099
R12219 vss.n3766 vss.t2266 15.3099
R12220 vss.n3765 vss.t2270 15.3099
R12221 vss.n3829 vss.t2277 15.3099
R12222 vss.n3815 vss.t2281 15.3099
R12223 vss.n3819 vss.t2274 15.3099
R12224 vss.n3818 vss.t2278 15.3099
R12225 vss.n3812 vss.t2285 15.3099
R12226 vss.n3798 vss.t2289 15.3099
R12227 vss.n3802 vss.t2282 15.3099
R12228 vss.n3801 vss.t2286 15.3099
R12229 vss.n3953 vss.t2178 15.3099
R12230 vss.n4340 vss.t445 15.3014
R12231 vss.n4369 vss.t441 15.3014
R12232 vss.n1437 vss.t930 15.2967
R12233 vss.n6225 vss.t2339 15.2696
R12234 vss.n6224 vss.t2343 15.2696
R12235 vss.n6223 vss.t2338 15.2696
R12236 vss.n6222 vss.t2342 15.2696
R12237 vss.n3783 vss.t2314 15.2696
R12238 vss.n3782 vss.t2320 15.2696
R12239 vss.n3781 vss.t2313 15.2696
R12240 vss.n3780 vss.t2319 15.2696
R12241 vss.n2677 vss.t2327 15.2696
R12242 vss.n2676 vss.t2333 15.2696
R12243 vss.n2675 vss.t2326 15.2696
R12244 vss.n2674 vss.t2332 15.2696
R12245 vss.n1576 vss.t2423 15.2696
R12246 vss.n1579 vss.t2421 15.2696
R12247 vss.n1593 vss.t2419 15.2696
R12248 vss.n1560 vss.t2417 15.2696
R12249 vss.n1608 vss.t2415 15.2696
R12250 vss.n1547 vss.t2413 15.2696
R12251 vss.n1623 vss.t2411 15.2696
R12252 vss.n1534 vss.t2409 15.2696
R12253 vss.n1638 vss.t2407 15.2696
R12254 vss.n1521 vss.t2405 15.2696
R12255 vss.n1653 vss.t2403 15.2696
R12256 vss.n1659 vss.t2401 15.2696
R12257 vss.n1673 vss.t2399 15.2696
R12258 vss.n1500 vss.t2397 15.2696
R12259 vss.n1688 vss.t2395 15.2696
R12260 vss.n1694 vss.t2393 15.2696
R12261 vss.n1708 vss.t2391 15.2696
R12262 vss.n1714 vss.t2389 15.2696
R12263 vss.n2444 vss.t2387 15.2696
R12264 vss.n2454 vss.t2385 15.2696
R12265 vss.n2432 vss.t2383 15.2696
R12266 vss.n2371 vss.t2381 15.2696
R12267 vss.n2365 vss.t2379 15.2696
R12268 vss.n6307 vss.t2377 15.2696
R12269 vss.n5317 vss.t2187 15.2696
R12270 vss.n5050 vss.t2177 15.2696
R12271 vss.n5329 vss.t2189 15.2696
R12272 vss.n5328 vss.t2195 15.2696
R12273 vss.n5059 vss.t2209 15.2696
R12274 vss.n5058 vss.t2211 15.2696
R12275 vss.n2334 vss.t2213 15.2696
R12276 vss.n2333 vss.t2219 15.2696
R12277 vss.n6374 vss.t2225 15.2696
R12278 vss.n6380 vss.t2231 15.2696
R12279 vss.n2322 vss.t2239 15.2696
R12280 vss.n2353 vss.t2245 15.2696
R12281 vss.n2352 vss.t2291 15.2696
R12282 vss.n2530 vss.t2293 15.2696
R12283 vss.n2529 vss.t2295 15.2696
R12284 vss.n2520 vss.t2297 15.2696
R12285 vss.n2519 vss.t2299 15.2696
R12286 vss.n2511 vss.t2301 15.2696
R12287 vss.n2510 vss.t2303 15.2696
R12288 vss.n2501 vss.t2305 15.2696
R12289 vss.n2500 vss.t2307 15.2696
R12290 vss.n2494 vss.t2309 15.2696
R12291 vss.n2493 vss.t2311 15.2696
R12292 vss.n2545 vss.t2317 15.2696
R12293 vss.n2544 vss.t2324 15.2696
R12294 vss.n2483 vss.t2330 15.2696
R12295 vss.n2482 vss.t2336 15.2696
R12296 vss.n2476 vss.t2364 15.2696
R12297 vss.n2475 vss.t2366 15.2696
R12298 vss.n2596 vss.t2368 15.2696
R12299 vss.n2595 vss.t2370 15.2696
R12300 vss.n2559 vss.t2372 15.2696
R12301 vss.n2558 vss.t2375 15.2696
R12302 vss.n6246 vss.t2347 15.2696
R12303 vss.n6245 vss.t2351 15.2696
R12304 vss.n6244 vss.t2346 15.2696
R12305 vss.n6243 vss.t2350 15.2696
R12306 vss.n6268 vss.t2355 15.2696
R12307 vss.n6267 vss.t2359 15.2696
R12308 vss.n6266 vss.t2354 15.2696
R12309 vss.n6265 vss.t2358 15.2696
R12310 vss.n5035 vss.t2167 15.2696
R12311 vss.n5471 vss.t2165 15.2696
R12312 vss.n5463 vss.t2163 15.2696
R12313 vss.n5448 vss.t2161 15.2696
R12314 vss.n5446 vss.t2159 15.2696
R12315 vss.n5442 vss.t2157 15.2696
R12316 vss.n5353 vss.t2146 15.2696
R12317 vss.n5351 vss.t2148 15.2696
R12318 vss.n5349 vss.t2150 15.2696
R12319 vss.n5347 vss.t2152 15.2696
R12320 vss.n5345 vss.t2154 15.2696
R12321 vss.n5343 vss.t2156 15.2696
R12322 vss.n5363 vss.t2172 15.2696
R12323 vss.n5362 vss.t2171 15.2696
R12324 vss.n3971 vss.t2184 15.2696
R12325 vss.n3970 vss.t2192 15.2696
R12326 vss.n3968 vss.t2183 15.2696
R12327 vss.n3962 vss.t2191 15.2696
R12328 vss.n3991 vss.t2198 15.2696
R12329 vss.n3990 vss.t2202 15.2696
R12330 vss.n3988 vss.t2197 15.2696
R12331 vss.n3981 vss.t2201 15.2696
R12332 vss.n3929 vss.t2206 15.2696
R12333 vss.n3928 vss.t2216 15.2696
R12334 vss.n3927 vss.t2205 15.2696
R12335 vss.n3926 vss.t2215 15.2696
R12336 vss.n3245 vss.t2222 15.2696
R12337 vss.n3244 vss.t2221 15.2696
R12338 vss.n3896 vss.t2228 15.2696
R12339 vss.n3895 vss.t2227 15.2696
R12340 vss.n3914 vss.t2236 15.2696
R12341 vss.n3908 vss.t2235 15.2696
R12342 vss.n3869 vss.t2242 15.2696
R12343 vss.n3868 vss.t2248 15.2696
R12344 vss.n3866 vss.t2241 15.2696
R12345 vss.n3860 vss.t2247 15.2696
R12346 vss.n3762 vss.t2252 15.2696
R12347 vss.n3761 vss.t2256 15.2696
R12348 vss.n3759 vss.t2251 15.2696
R12349 vss.n3753 vss.t2255 15.2696
R12350 vss.n3845 vss.t2260 15.2696
R12351 vss.n3844 vss.t2264 15.2696
R12352 vss.n3842 vss.t2259 15.2696
R12353 vss.n3836 vss.t2263 15.2696
R12354 vss.n3773 vss.t2268 15.2696
R12355 vss.n3772 vss.t2272 15.2696
R12356 vss.n3770 vss.t2267 15.2696
R12357 vss.n3764 vss.t2271 15.2696
R12358 vss.n3826 vss.t2276 15.2696
R12359 vss.n3825 vss.t2280 15.2696
R12360 vss.n3823 vss.t2275 15.2696
R12361 vss.n3817 vss.t2279 15.2696
R12362 vss.n3809 vss.t2284 15.2696
R12363 vss.n3808 vss.t2288 15.2696
R12364 vss.n3806 vss.t2283 15.2696
R12365 vss.n3800 vss.t2287 15.2696
R12366 vss.n3948 vss.t2180 15.2696
R12367 vss.n3947 vss.t2179 15.2696
R12368 vss.n5481 vss.t2169 15.2596
R12369 vss.n5355 vss.t2144 15.2596
R12370 vss.t29 vss.n770 15.2041
R12371 vss.n759 vss.t387 15.2041
R12372 vss.t403 vss.n779 15.2041
R12373 vss.t644 vss.n750 15.2041
R12374 vss.n3694 vss.t1308 15.1153
R12375 vss.n3697 vss.t671 15.1153
R12376 vss.n3689 vss.t214 15.1153
R12377 vss.n3686 vss.t1226 15.1153
R12378 vss.n3622 vss.t2070 15.1153
R12379 vss.n3644 vss.t1264 15.1153
R12380 vss.n3594 vss.t1377 15.1153
R12381 vss.n3616 vss.t1193 15.1153
R12382 vss.n3082 vss.t42 15.0339
R12383 vss.n6093 vss.t2085 15.0339
R12384 vss.n1437 vss.t884 15.0005
R12385 vss.n5014 vss.t438 15.0005
R12386 vss.n5538 vss.t435 15.0005
R12387 vss.n2853 vss.t309 15.0005
R12388 vss.t309 vss.n2852 15.0005
R12389 vss.t397 vss.n5235 15.0005
R12390 vss.n5236 vss.t397 15.0005
R12391 vss.n5230 vss.t384 15.0005
R12392 vss.t384 vss.n5229 15.0005
R12393 vss.t384 vss.n5227 15.0005
R12394 vss.t384 vss.n5176 15.0005
R12395 vss.t366 vss.n5214 15.0005
R12396 vss.n5215 vss.t366 15.0005
R12397 vss.n6169 vss.t303 15.0005
R12398 vss.t303 vss.n6168 15.0005
R12399 vss.n3672 vss.t871 15.0005
R12400 vss.n3673 vss.t528 15.0005
R12401 vss.n3674 vss.t1051 15.0005
R12402 vss.n3675 vss.t1262 15.0005
R12403 vss.n3394 vss.t1186 15.0005
R12404 vss.n3396 vss.t695 15.0005
R12405 vss.n3397 vss.t1224 15.0005
R12406 vss.n3398 vss.t1246 15.0005
R12407 vss.n3694 vss.t1245 15.0005
R12408 vss.n3696 vss.t694 15.0005
R12409 vss.n3695 vss.t1223 15.0005
R12410 vss.n3697 vss.t1185 15.0005
R12411 vss.n3689 vss.t1263 15.0005
R12412 vss.n3687 vss.t529 15.0005
R12413 vss.n3688 vss.t1052 15.0005
R12414 vss.n3686 vss.t872 15.0005
R12415 vss.n3622 vss.t1353 15.0005
R12416 vss.n3623 vss.t817 15.0005
R12417 vss.n3624 vss.t706 15.0005
R12418 vss.n3625 vss.t807 15.0005
R12419 vss.n3626 vss.t658 15.0005
R12420 vss.n3627 vss.t562 15.0005
R12421 vss.n3628 vss.t2089 15.0005
R12422 vss.n3629 vss.t803 15.0005
R12423 vss.n3630 vss.t820 15.0005
R12424 vss.n3631 vss.t1168 15.0005
R12425 vss.n3632 vss.t656 15.0005
R12426 vss.n3633 vss.t789 15.0005
R12427 vss.n3634 vss.t1303 15.0005
R12428 vss.n3635 vss.t1259 15.0005
R12429 vss.n3636 vss.t533 15.0005
R12430 vss.n3637 vss.t1300 15.0005
R12431 vss.n3638 vss.t1001 15.0005
R12432 vss.n3639 vss.t1156 15.0005
R12433 vss.n3640 vss.t858 15.0005
R12434 vss.n3641 vss.t1275 15.0005
R12435 vss.n3642 vss.t1048 15.0005
R12436 vss.n3643 vss.t1347 15.0005
R12437 vss.n3644 vss.t692 15.0005
R12438 vss.n3647 vss.t691 15.0005
R12439 vss.n3668 vss.t816 15.0005
R12440 vss.n3667 vss.t705 15.0005
R12441 vss.n3666 vss.t806 15.0005
R12442 vss.n3665 vss.t657 15.0005
R12443 vss.n3664 vss.t561 15.0005
R12444 vss.n3663 vss.t2088 15.0005
R12445 vss.n3662 vss.t802 15.0005
R12446 vss.n3661 vss.t819 15.0005
R12447 vss.n3660 vss.t1167 15.0005
R12448 vss.n3659 vss.t655 15.0005
R12449 vss.n3658 vss.t788 15.0005
R12450 vss.n3657 vss.t1302 15.0005
R12451 vss.n3656 vss.t1258 15.0005
R12452 vss.n3655 vss.t532 15.0005
R12453 vss.n3654 vss.t1299 15.0005
R12454 vss.n3653 vss.t1000 15.0005
R12455 vss.n3652 vss.t1155 15.0005
R12456 vss.n3651 vss.t857 15.0005
R12457 vss.n3650 vss.t1274 15.0005
R12458 vss.n3649 vss.t1047 15.0005
R12459 vss.n3648 vss.t1346 15.0005
R12460 vss.n3669 vss.t1352 15.0005
R12461 vss.n3502 vss.t1267 15.0005
R12462 vss.n3503 vss.t1321 15.0005
R12463 vss.n3504 vss.t2138 15.0005
R12464 vss.n3505 vss.t1273 15.0005
R12465 vss.n3506 vss.t1379 15.0005
R12466 vss.n3507 vss.t1174 15.0005
R12467 vss.n3508 vss.t1261 15.0005
R12468 vss.n3509 vss.t647 15.0005
R12469 vss.n3510 vss.t210 15.0005
R12470 vss.n3511 vss.t1330 15.0005
R12471 vss.n3512 vss.t2073 15.0005
R12472 vss.n3513 vss.t809 15.0005
R12473 vss.n3514 vss.t1388 15.0005
R12474 vss.n3515 vss.t1281 15.0005
R12475 vss.n3516 vss.t1327 15.0005
R12476 vss.n3517 vss.t1166 15.0005
R12477 vss.n3518 vss.t732 15.0005
R12478 vss.n3519 vss.t1158 15.0005
R12479 vss.n3520 vss.t41 15.0005
R12480 vss.n3521 vss.t1345 15.0005
R12481 vss.n3522 vss.t801 15.0005
R12482 vss.n3523 vss.t1269 15.0005
R12483 vss.n3524 vss.t2132 15.0005
R12484 vss.n3594 vss.t2131 15.0005
R12485 vss.n3615 vss.t1320 15.0005
R12486 vss.n3614 vss.t2137 15.0005
R12487 vss.n3613 vss.t1272 15.0005
R12488 vss.n3612 vss.t1378 15.0005
R12489 vss.n3611 vss.t1173 15.0005
R12490 vss.n3610 vss.t1260 15.0005
R12491 vss.n3609 vss.t646 15.0005
R12492 vss.n3608 vss.t209 15.0005
R12493 vss.n3607 vss.t1329 15.0005
R12494 vss.n3606 vss.t2072 15.0005
R12495 vss.n3605 vss.t808 15.0005
R12496 vss.n3604 vss.t1387 15.0005
R12497 vss.n3603 vss.t1280 15.0005
R12498 vss.n3602 vss.t1326 15.0005
R12499 vss.n3601 vss.t1165 15.0005
R12500 vss.n3600 vss.t731 15.0005
R12501 vss.n3599 vss.t1157 15.0005
R12502 vss.n3598 vss.t40 15.0005
R12503 vss.n3597 vss.t1344 15.0005
R12504 vss.n3596 vss.t800 15.0005
R12505 vss.n3595 vss.t1268 15.0005
R12506 vss.n3616 vss.t1266 15.0005
R12507 vss.n5524 vss.n4618 14.8302
R12508 vss.n5520 vss.n4622 14.8302
R12509 vss.n4533 vss.n524 14.8208
R12510 vss.n3747 vss.n525 14.802
R12511 vss.n5361 vss.n3254 14.6671
R12512 vss.n4599 vss.n524 14.5063
R12513 vss.n6383 vss.n2321 14.4987
R12514 vss.n6393 vss.n2319 14.4987
R12515 vss.n6379 vss.n2326 14.4987
R12516 vss.n6382 vss.n2325 14.4987
R12517 vss.n6382 vss.n2324 14.4987
R12518 vss.n2320 vss.n2319 14.4987
R12519 vss.n3907 vss.n3906 14.4987
R12520 vss.n3887 vss.n3880 14.4987
R12521 vss.n3880 vss.n404 14.4987
R12522 vss.n3882 vss.n3879 14.4987
R12523 vss.n3881 vss.n3878 14.4987
R12524 vss.n3890 vss.n408 28.997
R12525 vss.n3900 vss.n3889 14.4987
R12526 vss.n3901 vss.n3891 14.4987
R12527 vss.n3902 vss.n3892 14.4987
R12528 vss.n3906 vss.n3888 14.4987
R12529 vss.t637 vss.n4189 14.4933
R12530 vss.n4533 vss.n525 14.4885
R12531 vss.n4244 vss.n4226 14.4583
R12532 vss.n4250 vss.t1381 14.4583
R12533 vss.n4251 vss.n4220 14.4583
R12534 vss.n4234 vss.n4212 14.4583
R12535 vss.n4231 vss.n4206 14.4583
R12536 vss.n5288 vss.n5277 14.401
R12537 vss.n3893 vss.n1855 14.2767
R12538 vss.n6144 vss.n6143 14.1712
R12539 vss.n4274 vss.n4198 14.1181
R12540 vss.n4278 vss.n4194 14.1181
R12541 vss.n5190 vss.t617 14.1181
R12542 vss.n5174 vss.t451 14.1181
R12543 vss.n3544 vss.n3543 14.1139
R12544 vss.n6344 vss.n6342 14.1055
R12545 vss.n5272 vss.t824 14.0103
R12546 vss.n4471 vss.n4288 13.9865
R12547 vss.t155 vss.n4351 13.8894
R12548 vss.n6174 vss.t304 13.8462
R12549 vss.t306 vss.n6178 13.8462
R12550 vss.n6182 vss.t308 13.8462
R12551 vss.t310 vss.n6186 13.8462
R12552 vss.n1337 vss.t885 13.8163
R12553 vss.t2136 vss.n2752 13.5323
R12554 vss.n2568 vss.t745 13.5323
R12555 vss.t1254 vss.n902 13.5323
R12556 vss.n631 vss.n1475 13.5005
R12557 vss.n6344 vss.n6343 13.5005
R12558 vss.n6346 vss.n6345 13.5005
R12559 vss.n6348 vss.n6347 13.5005
R12560 vss.n6350 vss.n6349 13.5005
R12561 vss.n6352 vss.n6351 13.5005
R12562 vss.n6354 vss.n6353 13.5005
R12563 vss.n6341 vss.n6340 13.5005
R12564 vss.n6336 vss.n2427 13.5005
R12565 vss.n6334 vss.n6333 13.5005
R12566 vss.n6332 vss.n6331 13.5005
R12567 vss.n6328 vss.n2429 13.5005
R12568 vss.n6324 vss.n6323 13.5005
R12569 vss.n6313 vss.n6312 13.5005
R12570 vss.n6322 vss.n6321 13.5005
R12571 vss.n3541 vss.n3540 13.4005
R12572 vss.n3539 vss.n3538 13.4005
R12573 vss.t663 vss.n2289 13.3635
R12574 vss.t1036 vss.t217 13.3635
R12575 vss.t832 vss.n3222 13.3635
R12576 vss.n2696 vss.n2227 13.2543
R12577 vss.t617 vss.n1183 13.0322
R12578 vss.n1292 vss.t31 13.0322
R12579 vss.n1281 vss.t401 13.0322
R12580 vss.n1420 vss.t642 13.0322
R12581 vss.t451 vss.n1075 13.0322
R12582 vss.n6395 vss.n2048 12.9735
R12583 vss.n3543 vss.n3542 12.8695
R12584 vss.n2816 vss.n192 12.8538
R12585 vss.n3448 vss.n3429 12.7573
R12586 vss.n5705 vss.t497 12.7124
R12587 vss.n5883 vss.t550 12.7124
R12588 vss.n5732 vss.t612 12.7124
R12589 vss.n5851 vss.t843 12.7124
R12590 vss.n5765 vss.t863 12.7124
R12591 vss.n5813 vss.t648 12.7124
R12592 vss.n2800 vss.n2568 12.6032
R12593 vss.n2807 vss.n2575 12.6032
R12594 vss.n2794 vss.n2561 12.6032
R12595 vss.n2795 vss.n2563 12.6032
R12596 vss.n2802 vss.n2570 12.6032
R12597 vss.n2806 vss.n2573 12.6032
R12598 vss.n2805 vss.n2572 12.6032
R12599 vss.n2801 vss.n2569 12.6032
R12600 vss.n2799 vss.n2567 12.6032
R12601 vss.n2797 vss.n2565 12.6032
R12602 vss.n2796 vss.n2564 12.6032
R12603 vss.n2793 vss.n2561 12.6032
R12604 vss.t699 vss.n5596 12.5005
R12605 vss.t1291 vss.n5588 12.5005
R12606 vss.t2100 vss.n5580 12.5005
R12607 vss.t227 vss.n5571 12.5005
R12608 vss.t1159 vss.n5563 12.5005
R12609 vss.n6362 vss.n6361 12.2697
R12610 vss.n6366 vss.t467 12.2697
R12611 vss.n5186 vss.n5184 12.2313
R12612 vss.n2802 vss.t106 12.1791
R12613 vss.n5048 vss.n5047 12.0194
R12614 vss.n727 vss.n734 6.39117
R12615 vss.n5174 vss.n788 11.9462
R12616 vss.n1350 vss.t917 11.8426
R12617 vss.n1352 vss.t919 11.8426
R12618 vss.n1161 vss.t921 11.8426
R12619 vss.t1233 vss.n1145 11.8426
R12620 vss.n6091 vss.t1161 11.6932
R12621 vss.t1433 vss.n2162 11.6932
R12622 vss.n6306 vss.n6305 11.6434
R12623 vss.n1 vss.t371 7.45873
R12624 vss.n1270 vss.t6 11.4032
R12625 vss.n2049 vss.n1855 11.2652
R12626 vss.t952 vss.t45 11.1345
R12627 vss.t457 vss.t804 11.1345
R12628 vss.n4806 vss.n4174 11.0191
R12629 vss.n4805 vss.n4012 11.0191
R12630 vss.n4807 vss.n4175 11.0191
R12631 vss.n4997 vss.n4011 11.0191
R12632 vss.n4998 vss.n4176 11.0191
R12633 vss.n4996 vss.n4010 11.0191
R12634 vss.n4999 vss.n4177 11.0191
R12635 vss.n4995 vss.n4009 11.0191
R12636 vss.n5000 vss.n4178 11.0191
R12637 vss.n4994 vss.n4008 11.0191
R12638 vss.n5001 vss.n4179 11.0191
R12639 vss.n4993 vss.n4007 11.0191
R12640 vss.n5002 vss.n4180 11.0191
R12641 vss.n4992 vss.n4006 11.0191
R12642 vss.n5003 vss.n4181 11.0191
R12643 vss.n4991 vss.n4005 11.0191
R12644 vss.n5004 vss.n4182 11.0191
R12645 vss.n4990 vss.n4004 11.0191
R12646 vss.t167 vss.n4183 11.0191
R12647 vss.n4989 vss.n4003 11.0191
R12648 vss.n5005 vss.n4184 11.0191
R12649 vss.n4988 vss.n4002 11.0191
R12650 vss.n5006 vss.n4185 11.0191
R12651 vss.n4987 vss.n4001 11.0191
R12652 vss.n5007 vss.n4186 11.0191
R12653 vss.n4986 vss.n4000 11.0191
R12654 vss.n5008 vss.n4187 11.0191
R12655 vss.n4985 vss.n3999 11.0191
R12656 vss.n5009 vss.n4188 11.0191
R12657 vss.n6020 vss.n3998 11.0191
R12658 vss.n6021 vss.n1024 11.0191
R12659 vss.n955 vss.n4456 10.9343
R12660 vss.t377 vss.n767 10.8602
R12661 vss.t382 vss.n766 10.8602
R12662 vss.t410 vss.n786 10.8602
R12663 vss.t407 vss.n747 10.8602
R12664 vss.n4270 vss.t661 10.8439
R12665 vss.n6305 vss.n6304 10.7883
R12666 vss.n954 vss.n4422 38.0925
R12667 vss.n4532 vss.n4531 10.5755
R12668 vss.n4492 vss.n4428 10.49
R12669 vss.t165 vss.n4331 10.49
R12670 vss.n4472 vss.n4465 10.49
R12671 vss.t886 vss.n737 10.3172
R12672 vss.t937 vss.n762 10.3172
R12673 vss.t2109 vss.n782 10.3172
R12674 vss.t465 vss.n791 10.3172
R12675 vss.n6165 vss.n2701 10.307
R12676 vss.n2702 vss.n2701 10.307
R12677 vss.n832 vss.t1403 4.09428
R12678 vss.n833 vss.t1406 4.09428
R12679 vss.n834 vss.t83 4.09428
R12680 vss.n835 vss.t1413 4.09428
R12681 vss.n836 vss.t1415 4.09428
R12682 vss.n6362 vss.t1554 10.2248
R12683 vss.n0 vss.n1724 10.1421
R12684 vss.n5047 vss 10.0476
R12685 vss.n3142 vss.t1323 10.0228
R12686 vss.n3077 vss.t563 10.0228
R12687 vss.n3068 vss.t861 10.0228
R12688 vss.n3182 vss.t255 10.0228
R12689 vss.n3055 vss.t798 10.0228
R12690 vss.n6073 vss.n3052 10.0228
R12691 vss.n6079 vss.n3201 10.0228
R12692 vss.n6047 vss.t1304 10.0228
R12693 vss.t1306 vss.n3014 10.0228
R12694 vss.n6100 vss.t726 10.0228
R12695 vss.n6045 vss.n3013 10.0228
R12696 vss.n6407 vss.n6406 9.77741
R12697 vss.n5031 vss.n5030 9.77741
R12698 vss.n1288 vss.t132 9.77426
R12699 vss.n6165 vss.n6164 9.76988
R12700 vss.n6164 vss.n2702 9.76988
R12701 vss.n6402 vss.n6401 9.73692
R12702 vss.n6295 vss.n2041 9.73023
R12703 vss.n2809 vss.n2578 9.7194
R12704 vss.n2811 vss.n2580 9.7194
R12705 vss.n2812 vss.n2581 9.7194
R12706 vss.n2810 vss.n2579 9.7194
R12707 vss.n2815 vss.n2584 9.7194
R12708 vss.n2808 vss.n2576 9.7194
R12709 vss.t170 vss.n4787 9.67792
R12710 vss.n5267 vss.t44 9.67445
R12711 vss.t335 vss.n3528 9.6039
R12712 vss.n3529 vss.t335 9.6039
R12713 vss.n3568 vss.t349 9.6039
R12714 vss.n3533 vss.t352 9.6039
R12715 vss.n3558 vss.t355 9.6039
R12716 vss.n3535 vss.t363 9.6039
R12717 vss.n3549 vss.t360 9.6039
R12718 vss.n3578 vss.t346 9.58112
R12719 vss.n2966 vss.n2965 9.56421
R12720 vss.n2954 vss.n2705 9.56421
R12721 vss.n2961 vss.n2960 9.55756
R12722 vss.n2959 vss.n2958 9.55756
R12723 vss.n6146 vss.n6145 9.43517
R12724 vss.n2947 vss.n2946 9.41025
R12725 vss.n2877 vss.n2876 9.41025
R12726 vss.n5516 vss.n5515 9.3293
R12727 vss.n2448 vss.n1858 9.28843
R12728 vss.n2442 vss.n1862 9.28843
R12729 vss.t683 vss.t57 9.26561
R12730 vss.n5508 vss.n5507 9.24636
R12731 vss.n1304 vss.t886 9.23127
R12732 vss.n1401 vss.t937 9.23127
R12733 vss.n1274 vss.t2109 9.23127
R12734 vss.n1432 vss.t465 9.23127
R12735 vss.n3255 vss.n1725 9.19129
R12736 vss.n3323 vss.n1789 9.19129
R12737 vss.n5258 vss.n5256 9.13819
R12738 vss.n5259 vss.n5258 9.13612
R12739 vss vss.n5530 9.12621
R12740 vss vss.n5487 9.12621
R12741 vss.n5194 vss.n1080 9.09349
R12742 vss.n5193 vss.n1091 9.09349
R12743 vss.n5192 vss.n1094 9.09349
R12744 vss.n5191 vss.n1105 9.09349
R12745 vss.n5191 vss.n1186 9.09349
R12746 vss.n5192 vss.n1196 9.09349
R12747 vss.n5193 vss.n1200 9.09349
R12748 vss.n5194 vss.n1206 9.09349
R12749 vss.n5486 vss.n5485 9.09206
R12750 vss.n5382 vss.n1470 9.09172
R12751 vss.n2874 vss.n2873 9.05507
R12752 vss.n2944 vss.n2943 9.03878
R12753 vss.n2855 vss.n2854 9.03878
R12754 vss.n6167 vss.n6166 9.03878
R12755 vss.n2969 vss.n2968 9.01005
R12756 vss.n2665 vss.n1473 9.0005
R12757 vss.n6404 vss.n6403 9.0005
R12758 vss.n5532 vss.n5531 9.0005
R12759 vss.n5518 vss.n5517 9.0005
R12760 vss.n6018 vss.n6017 9.0005
R12761 vss.n5551 vss.n5550 9.0005
R12762 vss.n6164 vss.n6163 9.0005
R12763 vss.n5186 vss.n5185 9.0005
R12764 vss.n5250 vss.n5249 9.0005
R12765 vss.n5258 vss.n5257 9.0005
R12766 vss.n3114 vss.t252 8.89662
R12767 vss.n5806 vss.t989 8.83966
R12768 vss.n5635 vss.t1284 8.83966
R12769 vss.n5606 vss.t953 8.83866
R12770 vss.n4243 vss.t25 8.8286
R12771 vss.n5501 vss.n3252 8.82343
R12772 vss.n5798 vss.t729 8.81586
R12773 vss.n3016 vss.t1305 8.80385
R12774 vss.n5136 vss.t2068 8.80285
R12775 vss.n4253 vss.t1382 8.78351
R12776 vss.n3216 vss.t1162 8.7673
R12777 vss.n3211 vss.t514 8.7673
R12778 vss.n3132 vss.t1250 8.7673
R12779 vss.n3113 vss.t254 8.7673
R12780 vss.n5527 vss.t2126 8.76678
R12781 vss.n5092 vss.t2097 8.7663
R12782 vss.n5096 vss.t793 8.7663
R12783 vss.n5428 vss.t588 8.76054
R12784 vss.n5418 vss.t134 8.76054
R12785 vss.n1277 vss.t183 8.75731
R12786 vss.n1414 vss.t621 8.75731
R12787 vss.n1284 vss.t890 8.75731
R12788 vss.n4342 vss.t2124 8.75731
R12789 vss.n4352 vss.t156 8.75731
R12790 vss.n4392 vss.t154 8.75731
R12791 vss.n4386 vss.t1418 8.75731
R12792 vss.n4380 vss.t506 8.75731
R12793 vss.n4375 vss.t538 8.75731
R12794 vss.n3019 vss.t834 8.75731
R12795 vss.n3028 vss.t2086 8.75731
R12796 vss.n3215 vss.t916 8.75731
R12797 vss.n3038 vss.t512 8.75731
R12798 vss.n3204 vss.t869 8.75731
R12799 vss.n3203 vss.t218 8.75731
R12800 vss.n3047 vss.t216 8.75731
R12801 vss.n3198 vss.t1020 8.75731
R12802 vss.n3197 vss.t1392 8.75731
R12803 vss.n3194 vss.t1390 8.75731
R12804 vss.n3191 vss.t734 8.75731
R12805 vss.n3180 vss.t51 8.75731
R12806 vss.n3173 vss.t567 8.75731
R12807 vss.n3172 vss.t565 8.75731
R12808 vss.n3168 vss.t1029 8.75731
R12809 vss.n3164 vss.t862 8.75731
R12810 vss.n3072 vss.t860 8.75731
R12811 vss.n3144 vss.t719 8.75731
R12812 vss.n3133 vss.t471 8.75731
R12813 vss.n3127 vss.t973 8.75731
R12814 vss.n5794 vss.t460 8.75731
R12815 vss.n5797 vss.t456 8.75731
R12816 vss.n5604 vss.t2087 8.75731
R12817 vss.n5629 vss.t1241 8.75731
R12818 vss.n5626 vss.t1279 8.75731
R12819 vss.n5623 vss.t1242 8.75731
R12820 vss.n5622 vss.t2066 8.75731
R12821 vss.n5619 vss.t1278 8.75731
R12822 vss.n5617 vss.t674 8.75731
R12823 vss.n5615 vss.t665 8.75731
R12824 vss.n2397 vss.t468 8.75731
R12825 vss.n2400 vss.t839 8.75731
R12826 vss.n2404 vss.t1160 8.75731
R12827 vss.n2392 vss.t1301 8.75731
R12828 vss.n2409 vss.t1225 8.75731
R12829 vss.n2388 vss.t701 8.75731
R12830 vss.n2414 vss.t818 8.75731
R12831 vss.n5089 vss.t2096 8.75631
R12832 vss.n5094 vss.t865 8.75631
R12833 vss.n5097 vss.t1 8.75631
R12834 vss.n5298 vss.t1437 8.75631
R12835 vss.n5299 vss.t1079 8.75631
R12836 vss.n5291 vss.t826 8.75631
R12837 vss.n5101 vss.t93 8.75631
R12838 vss.n5107 vss.t97 8.75631
R12839 vss.n5109 vss.t1296 8.75631
R12840 vss.n5113 vss.t1298 8.75631
R12841 vss.n5123 vss.t592 8.75631
R12842 vss.n5132 vss.t38 8.75631
R12843 vss.n5143 vss.t1206 8.75631
R12844 vss.n5159 vss.t1151 8.75631
R12845 vss.n5163 vss.t1153 8.75631
R12846 vss.n5165 vss.t1204 8.75631
R12847 vss.n5255 vss.t2093 8.75631
R12848 vss.n5261 vss.t856 8.75631
R12849 vss.n5610 vss.t1328 8.75631
R12850 vss.n5614 vss.t675 8.75631
R12851 vss.n5618 vss.t458 8.75631
R12852 vss.n5440 vss.t1192 8.75631
R12853 vss.n5438 vss.t586 8.75631
R12854 vss.n5436 vss.t629 8.75631
R12855 vss.n5434 vss.t140 8.75631
R12856 vss.n5426 vss.t136 8.75631
R12857 vss.n5420 vss.t1439 8.75631
R12858 vss.n5412 vss.t454 8.75631
R12859 vss.n5410 vss.t1386 8.75631
R12860 vss.n5408 vss.t716 8.75631
R12861 vss.n5406 vss.t474 8.75631
R12862 vss.n5933 vss.t235 8.74885
R12863 vss.n5941 vss.t14 8.74885
R12864 vss.n5737 vss.t569 8.74885
R12865 vss.n5845 vss.t1332 8.74885
R12866 vss.n5830 vss.t951 8.74885
R12867 vss.n5807 vss.t1209 8.74885
R12868 vss.n5985 vss.t1145 8.74885
R12869 vss.n5962 vss.t10 8.74885
R12870 vss.n5684 vss.t128 8.74885
R12871 vss.n5661 vss.t697 8.74885
R12872 vss.n5638 vss.t1200 8.74885
R12873 vss.n4263 vss.t160 8.74785
R12874 vss.n5605 vss.t791 8.74785
R12875 vss.n5649 vss.t1283 8.74785
R12876 vss.n5672 vss.t704 8.74785
R12877 vss.n5693 vss.t481 8.74785
R12878 vss.n5973 vss.t547 8.74785
R12879 vss.n5996 vss.t237 8.74785
R12880 vss.n2346 vss.t1557 8.73764
R12881 vss.n5073 vss.n1386 8.68828
R12882 vss.n736 vss.t940 8.68828
R12883 vss.n763 vss.t891 8.68828
R12884 vss.t623 vss.n783 8.68828
R12885 vss.t895 vss.n792 8.68828
R12886 vss.n5611 vss.n5610 8.59589
R12887 vss.t765 vss.n275 8.58081
R12888 vss.n484 vss.n5553 8.57339
R12889 vss.n484 vss.n6011 8.50175
R12890 vss.n6361 vss.n2378 8.50125
R12891 vss.n468 vss.n466 4.20468
R12892 vss.n1037 vss.n1036 1.53662
R12893 vss.n1021 vss.n5496 3.40102
R12894 vss.n5454 vss.n435 8.501
R12895 vss.n5449 vss.n462 0.0793054
R12896 vss.n5464 vss.n437 8.501
R12897 vss.n4599 vss.n20 1.1328
R12898 vss.n544 vss.n545 0.00170812
R12899 vss.n545 vss.n546 0.00166658
R12900 vss.n548 vss.n547 0.00216959
R12901 vss.n547 vss.n549 0.00170812
R12902 vss.n549 vss.n550 0.00166658
R12903 vss.n552 vss.n551 0.00216959
R12904 vss.n551 vss.n553 0.00170812
R12905 vss.n553 vss.n554 0.00166658
R12906 vss.n556 vss.n555 0.00216959
R12907 vss.n555 vss.n557 0.00170812
R12908 vss.n557 vss.n558 0.00166658
R12909 vss.n560 vss.n559 0.00216959
R12910 vss.n559 vss.n561 0.00170812
R12911 vss.n561 vss.n562 0.00166658
R12912 vss.n564 vss.n563 0.00216959
R12913 vss.n563 vss.n565 0.00170812
R12914 vss.n565 vss.n566 0.00166658
R12915 vss.n568 vss.n567 0.00216959
R12916 vss.n567 vss.n569 0.00170812
R12917 vss.n569 vss.n570 0.00166658
R12918 vss.n4599 vss.n539 3.40102
R12919 vss.n572 vss.n571 0.00216959
R12920 vss.n571 vss.n573 0.00170812
R12921 vss.n573 vss.n574 0.00166658
R12922 vss.n576 vss.n575 0.00216959
R12923 vss.n575 vss.n577 0.00170812
R12924 vss.n577 vss.n578 0.00166658
R12925 vss.n580 vss.n579 0.00216959
R12926 vss.n579 vss.n581 0.00170812
R12927 vss.n581 vss.n582 0.00166658
R12928 vss.n584 vss.n583 0.00216959
R12929 vss.n583 vss.n585 0.00170812
R12930 vss.n585 vss.n586 0.00166658
R12931 vss.n588 vss.n587 0.00216959
R12932 vss.n587 vss.n589 0.00170812
R12933 vss.n589 vss.n590 0.00166658
R12934 vss.n592 vss.n591 0.00216959
R12935 vss.n591 vss.n593 0.00170812
R12936 vss.n593 vss.n594 0.00166658
R12937 vss.n596 vss.n595 0.00216959
R12938 vss.n595 vss.n597 0.00170812
R12939 vss.n597 vss.n598 0.00166658
R12940 vss.n4599 vss.n536 3.40102
R12941 vss.n600 vss.n599 0.00216959
R12942 vss.n599 vss.n601 0.00170812
R12943 vss.n601 vss.n602 0.00166658
R12944 vss.n604 vss.n603 0.00216959
R12945 vss.n603 vss.n605 0.00170812
R12946 vss.n605 vss.n606 0.00166658
R12947 vss.n608 vss.n607 0.00216959
R12948 vss.n607 vss.n609 0.00170812
R12949 vss.n609 vss.n610 0.00166658
R12950 vss.n612 vss.n611 0.00216959
R12951 vss.n611 vss.n613 0.00170812
R12952 vss.n613 vss.n614 0.00166658
R12953 vss.n616 vss.n615 0.00216959
R12954 vss.n615 vss.n617 0.00170812
R12955 vss.n617 vss.n618 0.00166658
R12956 vss.n620 vss.n619 0.00216959
R12957 vss.n619 vss.n621 0.00170812
R12958 vss.n621 vss.n622 0.00166658
R12959 vss.n624 vss.n623 0.00216959
R12960 vss.n623 vss.n625 0.00170812
R12961 vss.n625 vss.n626 0.00166658
R12962 vss.n4599 vss.n533 3.40102
R12963 vss.n4599 vss.n627 1.88985
R12964 vss.n629 vss.n531 0.00149997
R12965 vss.n995 vss.n996 0.00172462
R12966 vss.n996 vss.n997 0.00170812
R12967 vss.n997 vss.n998 0.00166658
R12968 vss.n1000 vss.n999 0.00216959
R12969 vss.n999 vss.n1001 0.00170812
R12970 vss.n1001 vss.n1002 0.00166658
R12971 vss.n1004 vss.n1003 0.00216959
R12972 vss.n1003 vss.n1005 0.00170812
R12973 vss.n1005 vss.n1006 0.00166658
R12974 vss.n3747 vss.n1007 3.40102
R12975 vss.n1010 vss.n1009 0.00216959
R12976 vss.n1009 vss.n1011 0.00170812
R12977 vss.n1011 vss.n1012 0.00166658
R12978 vss.n1014 vss.n1013 0.00216959
R12979 vss.n1013 vss.n1015 0.00170812
R12980 vss.n1015 vss.n1016 0.00166658
R12981 vss.n1018 vss.n1017 0.00216959
R12982 vss.n1017 vss.n1019 0.00170812
R12983 vss.n1019 vss.n1020 0.00166658
R12984 vss.n3 vss.n970 0.00170812
R12985 vss.n970 vss.n971 0.00166658
R12986 vss.n973 vss.n972 0.00216959
R12987 vss.n972 vss.n974 0.00170812
R12988 vss.n974 vss.n975 0.00166658
R12989 vss.n977 vss.n976 0.00216959
R12990 vss.n976 vss.n978 0.00170812
R12991 vss.n978 vss.n979 0.00166658
R12992 vss.n3747 vss.n980 3.40102
R12993 vss.n983 vss.n982 0.00216959
R12994 vss.n982 vss.n984 0.00170812
R12995 vss.n984 vss.n985 0.00166658
R12996 vss.n987 vss.n986 0.00216959
R12997 vss.n986 vss.n988 0.00170812
R12998 vss.n988 vss.n989 0.00166658
R12999 vss.n991 vss.n990 0.00216959
R13000 vss.n990 vss.n992 0.00170812
R13001 vss.n992 vss.n993 0.00166658
R13002 vss.n3747 vss.n994 1.54642
R13003 vss.n155 vss.n968 0.00169993
R13004 vss.n969 vss.n4515 2.83428
R13005 vss.n969 vss.n157 0.00158329
R13006 vss.n961 vss.n962 1.22651
R13007 vss.n4502 vss.n965 2.83417
R13008 vss.n965 vss.n964 0.00166658
R13009 vss.n964 vss.n159 0.00149997
R13010 vss.n958 vss.n4493 2.42951
R13011 vss.n958 vss.n161 0.00271416
R13012 vss.n4493 vss.n957 4.25113
R13013 vss.n954 vss.n4485 2.65
R13014 vss.n4478 vss.n165 2.83417
R13015 vss.n4478 vss.n950 3.40102
R13016 vss.n4532 vss.n182 1.70201
R13017 vss.n683 vss.n6190 1.54642
R13018 vss.n685 vss.n633 0.00158329
R13019 vss.n6190 vss.n686 3.40102
R13020 vss.n6190 vss.n688 1.54642
R13021 vss.n689 vss.n636 0.00158329
R13022 vss.n6190 vss.n691 1.54642
R13023 vss.n692 vss.n639 0.00158329
R13024 vss.n6190 vss.n693 3.40102
R13025 vss.n6190 vss.n694 3.40102
R13026 vss.n6190 vss.n696 1.54642
R13027 vss.n697 vss.n642 0.00158329
R13028 vss.n6190 vss.n698 3.40102
R13029 vss.n6190 vss.n699 3.40102
R13030 vss.n6190 vss.n701 2.4296
R13031 vss.n496 vss.n702 0.00214918
R13032 vss.n702 vss.n703 0.00172539
R13033 vss.n703 vss.n704 0.00171613
R13034 vss.n704 vss.n705 0.00169968
R13035 vss.n705 vss.n706 0.00166651
R13036 vss.n706 vss.n645 0.00158329
R13037 vss.n6190 vss.n707 3.40102
R13038 vss.n6190 vss.n708 3.40102
R13039 vss.n5364 vss.n370 0.0793054
R13040 vss.n374 vss.n373 4.20468
R13041 vss.t100 vss.n907 7.33397
R13042 vss.n6220 vss.n709 1.88985
R13043 vss.n712 vss.n711 0.00216959
R13044 vss.n711 vss.n713 0.00170812
R13045 vss.n6220 vss.n489 3.40102
R13046 vss.n6220 vss.n714 1.88985
R13047 vss.n717 vss.n716 0.00216959
R13048 vss.n716 vss.n718 0.00170812
R13049 vss.n6220 vss.n719 1.54642
R13050 vss.n721 vss.n649 0.00158329
R13051 vss.n723 vss.n722 0.00216959
R13052 vss.n722 vss.n724 0.00170812
R13053 vss.n724 vss.n725 0.00166658
R13054 vss.n725 vss.n364 0.00149997
R13055 vss.n2747 vss.n267 8.501
R13056 vss.n512 vss.n511 4.20468
R13057 vss.n3784 vss.n517 0.0793054
R13058 vss.n522 vss.n521 4.20468
R13059 vss.n5197 vss.n794 0.0273933
R13060 vss.n488 vss.n787 0.486391
R13061 vss.n727 vss.n5190 1.06624
R13062 vss.n728 vss.n730 0.00249968
R13063 vss.n5190 vss.n728 2.12597
R13064 vss.n836 vss.t1414 2126.44
R13065 vss.n5988 vss.t521 8.501
R13066 vss.n835 vss.t1412 2126.44
R13067 vss.n5965 vss.t55 8.501
R13068 vss.n834 vss.t82 2126.44
R13069 vss.n5687 vss.t224 8.501
R13070 vss.n833 vss.t1405 2126.44
R13071 vss.n5664 vss.t796 8.501
R13072 vss.n832 vss.t1402 2126.44
R13073 vss.n5641 vss.t823 8.501
R13074 vss.t47 vss.n185 1.70056
R13075 vss.n827 vss.t47 0.00172462
R13076 vss.n828 vss.n827 0.00170812
R13077 vss.n829 vss.n830 0.00216959
R13078 vss.n831 vss.n829 0.00170812
R13079 vss.n186 vss.n831 0.00166658
R13080 vss.n838 vss.n531 0.00149997
R13081 vss.n837 vss.n838 0.00166658
R13082 vss.n478 vss.n837 0.00205508
R13083 vss.n4172 vss.n66 2.83433
R13084 vss.n839 vss.n841 4.20468
R13085 vss.n846 vss.n844 4.20468
R13086 vss.n849 vss.n851 4.20468
R13087 vss.n855 vss.n854 4.20468
R13088 vss.n861 vss.n860 4.20468
R13089 vss.n867 vss.n866 4.20468
R13090 vss.n871 vss.n870 4.20468
R13091 vss.n877 vss.n876 4.20468
R13092 vss.n881 vss.n880 4.20468
R13093 vss.n885 vss.n884 4.20468
R13094 vss.n891 vss.n890 4.20468
R13095 vss.n895 vss.n894 4.20468
R13096 vss.n901 vss.n900 4.20468
R13097 vss.n6247 vss.n477 0.0793054
R13098 vss.n6269 vss.n471 0.0793054
R13099 vss.n5383 vss.n914 0.0296542
R13100 vss.n5384 vss.n431 8.501
R13101 vss.n5387 vss.n913 0.0793054
R13102 vss.n5388 vss.n429 8.501
R13103 vss.n5391 vss.n912 0.0793054
R13104 vss.n5392 vss.n433 8.501
R13105 vss.n5395 vss.n911 0.0793054
R13106 vss.n5396 vss.n453 0.0362711
R13107 vss.n5398 vss.n910 0.0793054
R13108 vss.n5399 vss.n455 0.0362711
R13109 vss.n5401 vss.n909 0.0793054
R13110 vss.n5402 vss.n457 0.0362711
R13111 vss.n5404 vss.n908 0.0793054
R13112 vss.n915 vss.n917 5.64438
R13113 vss.n3969 vss.n919 0.0793054
R13114 vss.n3972 vss.n428 0.0793054
R13115 vss.n423 vss.n3992 0.0793054
R13116 vss.n3930 vss.n417 0.0793054
R13117 vss.n3246 vss.n413 0.0793054
R13118 vss.n405 vss.n406 4.20468
R13119 vss.n3897 vss.n409 0.0793054
R13120 vss.n920 vss.n922 5.64438
R13121 vss.n3867 vss.n924 0.0793054
R13122 vss.n3870 vss.n403 0.0793054
R13123 vss.n925 vss.n927 5.64438
R13124 vss.n3760 vss.n929 0.0793054
R13125 vss.n3763 vss.n398 0.0793054
R13126 vss.n930 vss.n932 5.64438
R13127 vss.n3843 vss.n934 0.0793054
R13128 vss.n3846 vss.n393 0.0793054
R13129 vss.n935 vss.n937 5.64438
R13130 vss.n3771 vss.n939 0.0793054
R13131 vss.n3774 vss.n389 0.0793054
R13132 vss.n940 vss.n942 5.64438
R13133 vss.n3824 vss.n944 0.0793054
R13134 vss.n3827 vss.n385 0.0793054
R13135 vss.n945 vss.n947 5.64438
R13136 vss.n3807 vss.n949 0.0793054
R13137 vss.n3810 vss.n380 0.0793054
R13138 vss.n6412 vss.n1049 8.5005
R13139 vss.n6412 vss.n1135 8.5005
R13140 vss.n1022 vss.n4807 8.5005
R13141 vss.n1022 vss.n4806 8.5005
R13142 vss.n1022 vss.n4805 8.5005
R13143 vss.n4514 vss.n968 8.5005
R13144 vss.n968 vss.n4513 8.5005
R13145 vss.n968 vss.n4512 8.5005
R13146 vss.n968 vss.n4511 8.5005
R13147 vss.n968 vss.n4508 8.5005
R13148 vss.n968 vss.n4509 8.5005
R13149 vss.n968 vss.n4510 8.5005
R13150 vss.n4433 vss.n962 58.4976
R13151 vss.n961 vss.n4500 8.5005
R13152 vss.n961 vss.n4499 8.5005
R13153 vss.n961 vss.n4497 8.5005
R13154 vss.n961 vss.n4498 8.5005
R13155 vss.n957 vss.n4492 8.5005
R13156 vss.n957 vss.n4491 8.5005
R13157 vss.n957 vss.n4490 8.5005
R13158 vss.n957 vss.n4488 8.5005
R13159 vss.n957 vss.n4489 8.5005
R13160 vss.n953 vss.n4482 8.5005
R13161 vss.n953 vss.n4481 8.5005
R13162 vss.n953 vss.n4479 8.5005
R13163 vss.n953 vss.n4480 8.5005
R13164 vss.n168 vss.n4477 8.5005
R13165 vss.n168 vss.n4476 8.5005
R13166 vss.n168 vss.n4475 8.5005
R13167 vss.n168 vss.n4474 8.5005
R13168 vss.n168 vss.n4471 8.5005
R13169 vss.n168 vss.n167 8.5005
R13170 vss.n168 vss.n4472 8.5005
R13171 vss.n168 vss.n4473 8.5005
R13172 vss.n181 vss.n4530 8.5005
R13173 vss.n181 vss.n4529 8.5005
R13174 vss.n181 vss.n4527 8.5005
R13175 vss.n181 vss.n4528 8.5005
R13176 vss.n287 vss.n2748 8.5005
R13177 vss.n287 vss.n2749 8.5005
R13178 vss.n287 vss.n2750 8.5005
R13179 vss.n287 vss.n2751 8.5005
R13180 vss.n287 vss.n2752 8.5005
R13181 vss.n267 vss.n2636 8.5005
R13182 vss.n267 vss.n6295 8.5005
R13183 vss.n6357 vss.n2424 8.49808
R13184 vss.n6316 vss.n2379 8.49774
R13185 vss.n6357 vss.n2398 8.49636
R13186 vss.n6357 vss.n2401 8.49499
R13187 vss.n6171 vss.n6167 8.49415
R13188 vss.n2854 vss.n2695 8.49415
R13189 vss.n2943 vss.n2939 8.49415
R13190 vss.n6412 vss.n1041 8.49262
R13191 vss.n6412 vss.n1043 8.49262
R13192 vss.n6412 vss.n1045 8.49262
R13193 vss.n6412 vss.n1047 8.49262
R13194 vss.n6412 vss.n1050 8.49262
R13195 vss.n6412 vss.n1053 8.49262
R13196 vss.n6412 vss.n1055 8.49262
R13197 vss.n6412 vss.n1057 8.49262
R13198 vss.n6412 vss.n1059 8.49262
R13199 vss.n6412 vss.n1064 8.49262
R13200 vss.n6412 vss.n1067 8.49262
R13201 vss.n6412 vss.n1069 8.49262
R13202 vss.n6412 vss.n1071 8.49262
R13203 vss.n6412 vss.n1073 8.49262
R13204 vss.n6412 vss.n1076 8.49262
R13205 vss.n6412 vss.n1078 8.49262
R13206 vss.n6412 vss.n1081 8.49262
R13207 vss.n6412 vss.n1083 8.49262
R13208 vss.n6412 vss.n1085 8.49262
R13209 vss.n6412 vss.n1087 8.49262
R13210 vss.n6412 vss.n1089 8.49262
R13211 vss.n6412 vss.n1099 8.49262
R13212 vss.n6412 vss.n1101 8.49262
R13213 vss.n6412 vss.n1103 8.49262
R13214 vss.n6412 vss.n1106 8.49262
R13215 vss.n6412 vss.n1108 8.49262
R13216 vss.n6412 vss.n1110 8.49262
R13217 vss.n6412 vss.n1113 8.49262
R13218 vss.n6412 vss.n1115 8.49262
R13219 vss.n6412 vss.n1117 8.49262
R13220 vss.n6412 vss.n1119 8.49262
R13221 vss.n6412 vss.n1122 8.49262
R13222 vss.n6412 vss.n1127 8.49262
R13223 vss.n6412 vss.n1129 8.49262
R13224 vss.n6412 vss.n1131 8.49262
R13225 vss.n6412 vss.n1133 8.49262
R13226 vss.n6412 vss.n1136 8.49262
R13227 vss.n6412 vss.n1140 8.49262
R13228 vss.n6412 vss.n1144 8.49262
R13229 vss.n6412 vss.n1148 8.49262
R13230 vss.n6412 vss.n1152 8.49262
R13231 vss.n5200 vss.n488 8.48914
R13232 vss.n5202 vss.n488 8.48914
R13233 vss.n6037 vss.n3240 8.47856
R13234 vss.n6037 vss.n3231 8.47856
R13235 vss.n488 vss.n794 4.23245
R13236 vss.n726 vss.n5182 8.47856
R13237 vss.n5786 vss.t988 8.47508
R13238 vss.n466 vss.n5467 8.47452
R13239 vss.n967 vss.n4507 8.47359
R13240 vss.n158 vss.n157 4.18309
R13241 vss.n4504 vss.n4503 8.47359
R13242 vss.n964 vss.n963 8.47359
R13243 vss.n160 vss.n159 3.31465
R13244 vss.n164 vss.n4495 0.230088
R13245 vss.n162 vss.n161 4.18309
R13246 vss.n542 vss.n189 3.31465
R13247 vss.n188 vss.n4484 8.47359
R13248 vss.n184 vss.n169 2.47568
R13249 vss.n4470 vss.n183 0.788756
R13250 vss.n543 vss.n181 0.56303
R13251 vss.n287 vss.n2950 8.47303
R13252 vss.n5528 vss.n5525 8.47111
R13253 vss.n5453 vss.n437 8.47111
R13254 vss.n437 vss.n462 4.20468
R13255 vss.n466 vss.n5465 8.47111
R13256 vss.n466 vss.n5473 8.47111
R13257 vss.n4405 vss.n4404 8.47111
R13258 vss.n4404 vss.n4346 8.47111
R13259 vss.n4404 vss.n4350 8.47111
R13260 vss.n4404 vss.n4355 8.47111
R13261 vss.n4404 vss.n4360 8.47111
R13262 vss.n4404 vss.n4364 8.47111
R13263 vss.n4404 vss.n4382 8.47111
R13264 vss.t638 vss.n4267 8.47111
R13265 vss.t638 vss.n4281 8.47111
R13266 vss.n369 vss.n370 4.20468
R13267 vss.n516 vss.n517 4.20468
R13268 vss.n5301 vss.n5100 8.47111
R13269 vss.n5301 vss.n5292 8.47111
R13270 vss.n6131 vss.n3017 8.47111
R13271 vss.n6131 vss.n3020 8.47111
R13272 vss.n6131 vss.n3023 8.47111
R13273 vss.n6131 vss.n3026 8.47111
R13274 vss.n6131 vss.n3039 8.47111
R13275 vss.n6131 vss.n3045 8.47111
R13276 vss.n6131 vss.n3199 8.47111
R13277 vss.n6131 vss.n3195 8.47111
R13278 vss.n6131 vss.n3174 8.47111
R13279 vss.n6131 vss.n3169 8.47111
R13280 vss.n6131 vss.n3070 8.47111
R13281 vss.n6131 vss.n3084 8.47111
R13282 vss.n5301 vss.n5251 8.47111
R13283 vss.n5301 vss.n5164 8.47111
R13284 vss.n5301 vss.n5160 8.47111
R13285 vss.n5301 vss.n5148 8.47111
R13286 vss.n5301 vss.n5144 8.47111
R13287 vss.n5301 vss.n5137 8.47111
R13288 vss.n5301 vss.n5133 8.47111
R13289 vss.n5301 vss.n5130 8.47111
R13290 vss.n5301 vss.n5126 8.47111
R13291 vss.n5301 vss.n5124 8.47111
R13292 vss.n5301 vss.n5120 8.47111
R13293 vss.n5301 vss.n5116 8.47111
R13294 vss.n5301 vss.n5114 8.47111
R13295 vss.n5301 vss.n5110 8.47111
R13296 vss.n5301 vss.n5108 8.47111
R13297 vss.n5301 vss.n5105 8.47111
R13298 vss.n5928 vss.t143 8.47111
R13299 vss.n5936 vss.t143 8.47111
R13300 vss.n5944 vss.t143 8.47111
R13301 vss.t143 vss.n5862 8.47111
R13302 vss.t143 vss.n5756 8.47111
R13303 vss.t143 vss.n5824 8.47111
R13304 vss.t143 vss.n5795 8.47111
R13305 vss.t1415 vss.n483 8.47111
R13306 vss.t1415 vss.n485 3.30696
R13307 vss.n5998 vss.t1415 8.47111
R13308 vss.n5999 vss.n797 0.189575
R13309 vss.n800 vss.t521 3.30688
R13310 vss.t521 vss.n5993 8.47111
R13311 vss.t521 vss.n5566 8.47111
R13312 vss.n5976 vss.t1413 8.47111
R13313 vss.n5977 vss.n803 0.189575
R13314 vss.t55 vss.n5970 8.47111
R13315 vss.t55 vss.n5574 8.47111
R13316 vss.n5953 vss.t83 8.47111
R13317 vss.n5954 vss.n809 0.189575
R13318 vss.t224 vss.n5692 8.47111
R13319 vss.t224 vss.n5583 8.47111
R13320 vss.n5675 vss.t1406 8.47111
R13321 vss.n5676 vss.n815 0.189575
R13322 vss.t796 vss.n5669 8.47111
R13323 vss.t796 vss.n5591 8.47111
R13324 vss.n5652 vss.t1403 8.47111
R13325 vss.n5653 vss.n821 0.189575
R13326 vss.t823 vss.n5646 8.47111
R13327 vss.t823 vss.n5599 8.47111
R13328 vss.n828 vss.n5632 8.47111
R13329 vss.n170 vss.n171 5.61485
R13330 vss.n170 vss.n5627 8.47111
R13331 vss.n831 vss.n5624 8.47111
R13332 vss.n187 vss.n5616 8.47111
R13333 vss.n5613 vss.n5612 8.47111
R13334 vss.n5327 vss.n841 0.139319
R13335 vss.n846 vss.n2332 0.139319
R13336 vss.n2351 vss.n851 0.139319
R13337 vss.n855 vss.n2532 0.139319
R13338 vss.n861 vss.n2518 0.139319
R13339 vss.n867 vss.n2509 0.139319
R13340 vss.n871 vss.n2503 0.139319
R13341 vss.n877 vss.n2492 0.139319
R13342 vss.n881 vss.n2547 0.139319
R13343 vss.n885 vss.n2485 0.139319
R13344 vss.n891 vss.n2474 0.139319
R13345 vss.n895 vss.n2598 0.139319
R13346 vss.n901 vss.n2557 0.139319
R13347 vss.n475 vss.n477 4.20468
R13348 vss.n470 vss.n471 4.20468
R13349 vss.n435 vss.n5444 8.47111
R13350 vss.n913 vss.n429 4.20468
R13351 vss.n912 vss.n433 4.20468
R13352 vss.n911 vss.n435 4.20468
R13353 vss.n910 vss.n435 4.20468
R13354 vss.n909 vss.n435 4.20468
R13355 vss.n908 vss.n435 4.20468
R13356 vss.n435 vss.n5405 8.47111
R13357 vss.n435 vss.n5417 8.47111
R13358 vss.n435 vss.n5429 8.47111
R13359 vss.n915 vss.n919 4.20468
R13360 vss.n426 vss.n428 4.20468
R13361 vss.n421 vss.n423 4.20468
R13362 vss.n416 vss.n417 4.20468
R13363 vss.n411 vss.n413 4.20468
R13364 vss.n407 vss.n409 4.20468
R13365 vss.n920 vss.n924 4.20468
R13366 vss.n401 vss.n403 4.20468
R13367 vss.n925 vss.n929 4.20468
R13368 vss.n396 vss.n398 4.20468
R13369 vss.n930 vss.n934 4.20468
R13370 vss.n391 vss.n393 4.20468
R13371 vss.n935 vss.n939 4.20468
R13372 vss.n387 vss.n389 4.20468
R13373 vss.n940 vss.n944 4.20468
R13374 vss.n383 vss.n385 4.20468
R13375 vss.n945 vss.n949 4.20468
R13376 vss.n378 vss.n380 4.20468
R13377 vss.n1036 vss.n5018 8.47018
R13378 vss.n1036 vss.n5029 8.47018
R13379 vss.n5498 vss.n1022 8.47018
R13380 vss.n5497 vss.n1023 8.47018
R13381 vss.n4536 vss.n544 8.47018
R13382 vss.n4537 vss.n545 8.47018
R13383 vss.n4538 vss.n546 8.47018
R13384 vss.n4538 vss.n90 0.431241
R13385 vss.n4539 vss.n547 8.47018
R13386 vss.n4540 vss.n549 8.47018
R13387 vss.n4541 vss.n550 8.47018
R13388 vss.n4541 vss.n92 0.431241
R13389 vss.n4542 vss.n551 8.47018
R13390 vss.n4543 vss.n553 8.47018
R13391 vss.n4544 vss.n554 8.47018
R13392 vss.n4544 vss.n94 0.431241
R13393 vss.n4545 vss.n555 8.47018
R13394 vss.n4546 vss.n557 8.47018
R13395 vss.n4547 vss.n558 8.47018
R13396 vss.n4547 vss.n96 0.431241
R13397 vss.n4548 vss.n559 8.47018
R13398 vss.n4549 vss.n561 8.47018
R13399 vss.n4550 vss.n562 8.47018
R13400 vss.n4550 vss.n98 0.431241
R13401 vss.n4551 vss.n563 8.47018
R13402 vss.n4552 vss.n565 8.47018
R13403 vss.n4553 vss.n566 8.47018
R13404 vss.n4553 vss.n100 0.431241
R13405 vss.n4554 vss.n567 8.47018
R13406 vss.n4555 vss.n569 8.47018
R13407 vss.n4556 vss.n570 8.47018
R13408 vss.n4556 vss.n102 0.431241
R13409 vss.n102 vss.n541 0.614346
R13410 vss.n4557 vss.n571 8.47018
R13411 vss.n4558 vss.n573 8.47018
R13412 vss.n4559 vss.n574 8.47018
R13413 vss.n4559 vss.n104 0.431241
R13414 vss.n4560 vss.n575 8.47018
R13415 vss.n4561 vss.n577 8.47018
R13416 vss.n4562 vss.n578 8.47018
R13417 vss.n4562 vss.n106 0.431241
R13418 vss.n4563 vss.n579 8.47018
R13419 vss.n4564 vss.n581 8.47018
R13420 vss.n4565 vss.n582 8.47018
R13421 vss.n4565 vss.n108 0.431241
R13422 vss.n4566 vss.n583 8.47018
R13423 vss.n4567 vss.n585 8.47018
R13424 vss.n4568 vss.n586 8.47018
R13425 vss.n4568 vss.n110 0.431241
R13426 vss.n4569 vss.n587 8.47018
R13427 vss.n4570 vss.n589 8.47018
R13428 vss.n4571 vss.n590 8.47018
R13429 vss.n4571 vss.n112 0.431241
R13430 vss.n4572 vss.n591 8.47018
R13431 vss.n4573 vss.n593 8.47018
R13432 vss.n4574 vss.n594 8.47018
R13433 vss.n4574 vss.n114 0.431241
R13434 vss.n4575 vss.n595 8.47018
R13435 vss.n4576 vss.n597 8.47018
R13436 vss.n4577 vss.n598 8.47018
R13437 vss.n4577 vss.n116 0.431241
R13438 vss.n116 vss.n538 0.614346
R13439 vss.n4578 vss.n599 8.47018
R13440 vss.n4579 vss.n601 8.47018
R13441 vss.n4580 vss.n602 8.47018
R13442 vss.n4580 vss.n118 0.431241
R13443 vss.n4581 vss.n603 8.47018
R13444 vss.n4582 vss.n605 8.47018
R13445 vss.n4583 vss.n606 8.47018
R13446 vss.n4583 vss.n120 0.431241
R13447 vss.n4584 vss.n607 8.47018
R13448 vss.n4585 vss.n609 8.47018
R13449 vss.n4586 vss.n610 8.47018
R13450 vss.n4586 vss.n122 0.431241
R13451 vss.n4587 vss.n611 8.47018
R13452 vss.n4588 vss.n613 8.47018
R13453 vss.n4589 vss.n614 8.47018
R13454 vss.n4589 vss.n124 0.431241
R13455 vss.n4590 vss.n615 8.47018
R13456 vss.n4591 vss.n617 8.47018
R13457 vss.n4592 vss.n618 8.47018
R13458 vss.n4592 vss.n126 0.431241
R13459 vss.n4593 vss.n619 8.47018
R13460 vss.n4594 vss.n621 8.47018
R13461 vss.n4595 vss.n622 8.47018
R13462 vss.n4595 vss.n128 0.431241
R13463 vss.n4596 vss.n623 8.47018
R13464 vss.n4597 vss.n625 8.47018
R13465 vss.n4598 vss.n626 8.47018
R13466 vss.n4598 vss.n130 0.431241
R13467 vss.n130 vss.n535 0.614346
R13468 vss.n4535 vss.n628 8.47018
R13469 vss.n4534 vss.n629 8.47018
R13470 vss.n532 vss.n531 0.00599353
R13471 vss.n3704 vss.n995 8.47018
R13472 vss.n3705 vss.n996 8.47018
R13473 vss.n3706 vss.n997 8.47018
R13474 vss.n3707 vss.n998 8.47018
R13475 vss.n3707 vss.n132 0.431241
R13476 vss.n3708 vss.n999 8.47018
R13477 vss.n3709 vss.n1001 8.47018
R13478 vss.n3710 vss.n1002 8.47018
R13479 vss.n3710 vss.n134 0.431241
R13480 vss.n3711 vss.n1003 8.47018
R13481 vss.n3712 vss.n1005 8.47018
R13482 vss.n3713 vss.n1006 8.47018
R13483 vss.n3713 vss.n136 0.431241
R13484 vss.n3714 vss.n1008 8.47018
R13485 vss.n3716 vss.n1009 8.47018
R13486 vss.n3717 vss.n1011 8.47018
R13487 vss.n3718 vss.n1012 8.47018
R13488 vss.n3718 vss.n138 0.431241
R13489 vss.n3719 vss.n1013 8.47018
R13490 vss.n3720 vss.n1015 8.47018
R13491 vss.n3721 vss.n1016 8.47018
R13492 vss.n3721 vss.n140 0.431241
R13493 vss.n3722 vss.n1017 8.47018
R13494 vss.n3723 vss.n1019 8.47018
R13495 vss.n3724 vss.n1020 8.47018
R13496 vss.n3724 vss.n142 0.431241
R13497 vss.n142 vss.n9 1.2825
R13498 vss.n4 vss.n9 0.600854
R13499 vss.n7 vss.n4 0.010683
R13500 vss.n7 vss.n3726 1.32658
R13501 vss.n3727 vss.n3 8.47018
R13502 vss.n3728 vss.n970 8.47018
R13503 vss.n3729 vss.n971 8.47018
R13504 vss.n3729 vss.n144 0.431241
R13505 vss.n3730 vss.n972 8.47018
R13506 vss.n3731 vss.n974 8.47018
R13507 vss.n3732 vss.n975 8.47018
R13508 vss.n3732 vss.n146 0.431241
R13509 vss.n3733 vss.n976 8.47018
R13510 vss.n3734 vss.n978 8.47018
R13511 vss.n3735 vss.n979 8.47018
R13512 vss.n3735 vss.n148 0.431241
R13513 vss.n3736 vss.n981 8.47018
R13514 vss.n3738 vss.n982 8.47018
R13515 vss.n3739 vss.n984 8.47018
R13516 vss.n3740 vss.n985 8.47018
R13517 vss.n3740 vss.n150 0.431241
R13518 vss.n3741 vss.n986 8.47018
R13519 vss.n3742 vss.n988 8.47018
R13520 vss.n3743 vss.n989 8.47018
R13521 vss.n3743 vss.n152 0.431241
R13522 vss.n3744 vss.n990 8.47018
R13523 vss.n3745 vss.n992 8.47018
R13524 vss.n3746 vss.n993 8.47018
R13525 vss.n3746 vss.n154 0.431241
R13526 vss.n4 vss.n5 0.0239405
R13527 vss.n6191 vss.n684 8.47018
R13528 vss.n6192 vss.n685 8.47018
R13529 vss.n634 vss.n633 4.17472
R13530 vss.n6193 vss.n508 0.493112
R13531 vss.n6194 vss.n687 8.47018
R13532 vss.n6195 vss.n689 8.47018
R13533 vss.n637 vss.n636 4.17472
R13534 vss.n6197 vss.n690 8.47018
R13535 vss.n6198 vss.n692 8.47018
R13536 vss.n640 vss.n639 4.17472
R13537 vss.n6199 vss.n506 0.493112
R13538 vss.n506 vss.n504 0.614346
R13539 vss.n6200 vss.n695 8.47018
R13540 vss.n6201 vss.n697 8.47018
R13541 vss.n643 vss.n642 4.17472
R13542 vss.n6202 vss.n502 0.493112
R13543 vss.n502 vss.n500 0.614346
R13544 vss.n6203 vss.n700 8.47018
R13545 vss.n6203 vss.n498 0.431241
R13546 vss.n6204 vss.n702 8.47018
R13547 vss.n6205 vss.n703 8.47018
R13548 vss.n6206 vss.n704 8.47018
R13549 vss.n6207 vss.n705 8.47018
R13550 vss.n6208 vss.n706 8.47018
R13551 vss.n646 vss.n645 4.17472
R13552 vss.n6209 vss.n495 0.493112
R13553 vss.n493 vss.n492 3.30408
R13554 vss.n6211 vss.n710 8.47018
R13555 vss.n6211 vss.n179 0.547989
R13556 vss.n6212 vss.n711 8.47018
R13557 vss.n6213 vss.n713 8.47018
R13558 vss.n6213 vss.n177 0.547989
R13559 vss.n177 vss.n491 0.731446
R13560 vss.n6214 vss.n715 8.47018
R13561 vss.n6214 vss.n175 0.547989
R13562 vss.n6215 vss.n716 8.47018
R13563 vss.n6216 vss.n718 8.47018
R13564 vss.n6216 vss.n173 0.547989
R13565 vss.n6217 vss.n720 8.47018
R13566 vss.n6218 vss.n721 8.47018
R13567 vss.n650 vss.n649 4.17472
R13568 vss.n2692 vss.n722 8.47018
R13569 vss.n2691 vss.n724 8.47018
R13570 vss.n2690 vss.n725 8.47018
R13571 vss.n651 vss.n364 0.00153795
R13572 vss.n4170 vss.n838 8.47018
R13573 vss.n479 vss.n480 4.17472
R13574 vss.n738 vss.n726 5.6096
R13575 vss.n5205 vss.n744 8.46813
R13576 vss.n731 vss.n730 4.16971
R13577 vss.n5206 vss.n729 8.46813
R13578 vss.n5207 vss.n746 8.46813
R13579 vss.n5208 vss.n745 8.46813
R13580 vss.n6037 vss.n3237 8.468
R13581 vss.n5081 vss.n5080 8.35239
R13582 vss.t995 vss.n2272 8.35239
R13583 vss.n6077 vss.t1019 8.35239
R13584 vss.n2851 vss.t307 8.24377
R13585 vss.n6170 vss.t305 8.23366
R13586 vss.n2745 vss.t73 8.07613
R13587 vss.n2967 vss.n2700 8.0296
R13588 vss.n2856 vss.n2704 8.0296
R13589 vss.n3451 vss.n3450 8.0205
R13590 vss.n6016 vss.n6015 7.92957
R13591 vss.n6358 vss.n2359 7.80816
R13592 vss.n5249 vss.n5168 7.73131
R13593 vss.n3485 vss.t271 7.73085
R13594 vss.t271 vss.n3484 7.73085
R13595 vss.n3494 vss.t311 7.73085
R13596 vss.t275 vss.n3470 7.72984
R13597 vss.n3471 vss.t275 7.72984
R13598 vss.n3457 vss.t314 7.72984
R13599 vss.n4 vss.n6 0.113513
R13600 vss.t1554 vss.n2358 7.62226
R13601 vss.n5201 vss.t427 7.61757
R13602 vss.t710 vss.n1259 7.60231
R13603 vss.n2942 vss.t291 7.59033
R13604 vss.n2942 vss.t299 7.59033
R13605 vss.n2940 vss.t293 7.59033
R13606 vss.n2940 vss.t300 7.59033
R13607 vss.n2872 vss.t297 7.59033
R13608 vss.n2872 vss.t302 7.59033
R13609 vss.n2871 vss.t295 7.59033
R13610 vss.n2871 vss.t301 7.59033
R13611 vss.n5196 vss.t431 7.5005
R13612 vss.n5195 vss.t416 7.5005
R13613 vss.n5511 vss.t370 7.5005
R13614 vss.n5240 vss.t419 7.48707
R13615 vss.n5219 vss.t379 7.48707
R13616 vss.n3439 vss.t261 7.4689
R13617 vss.n3441 vss.t261 7.4689
R13618 vss.n3443 vss.t261 7.4689
R13619 vss.n3445 vss.t261 7.4689
R13620 vss.t323 vss.n3415 7.4689
R13621 vss.t323 vss.n3409 7.4689
R13622 vss.t323 vss.n3405 7.4689
R13623 vss.n3416 vss.t323 7.4689
R13624 vss.n955 vss.n4326 7.43845
R13625 vss.n5601 vss.n5600 7.1604
R13626 vss.n3254 vss.t206 7.15406
R13627 vss.n2876 vss.n2875 7.06466
R13628 vss.n2946 vss.n2945 7.06366
R13629 vss.t998 vss.n4434 6.99351
R13630 vss.n4476 vss.n4337 6.99351
R13631 vss.n3118 vss.n3117 6.68201
R13632 vss.n3112 vss.n3111 6.68201
R13633 vss.n3124 vss.n3123 6.68201
R13634 vss.n3105 vss.n3104 6.68201
R13635 vss.n3151 vss.n3150 6.68201
R13636 vss.t42 vss.n2260 6.68201
R13637 vss.n3153 vss.t530 6.68201
R13638 vss.n3080 vss.n3079 6.68201
R13639 vss.n3157 vss.n3156 6.68201
R13640 vss.n3161 vss.t859 6.68201
R13641 vss.n3069 vss.n3068 6.68201
R13642 vss.n3063 vss.t564 6.68201
R13643 vss.n3178 vss.n3177 6.68201
R13644 vss.t1391 vss.n3196 6.68201
R13645 vss.n6079 vss.t215 6.68201
R13646 vss.t217 vss.n3044 6.68201
R13647 vss.n3221 vss.t828 6.68201
R13648 vss.n4370 vss.t1164 6.66883
R13649 vss.n5087 vss.t1436 6.56772
R13650 vss.n1386 vss.n1183 6.51634
R13651 vss.n1308 vss.n734 6.51634
R13652 vss.n1306 vss.n736 6.51634
R13653 vss.t367 vss.n732 6.51634
R13654 vss.n1391 vss.n732 6.51634
R13655 vss.n1393 vss.n1186 6.51634
R13656 vss.n1302 vss.n1105 6.51634
R13657 vss.n1299 vss.n765 6.51634
R13658 vss.n765 vss.t28 6.51634
R13659 vss.t28 vss.t2106 6.51634
R13660 vss.n1397 vss.n769 6.51634
R13661 vss.n1399 vss.n763 6.51634
R13662 vss.n1292 vss.n761 6.51634
R13663 vss.n1403 vss.n773 6.51634
R13664 vss.n1407 vss.n775 6.51634
R13665 vss.n1407 vss.t619 6.51634
R13666 vss.t389 vss.n776 6.51634
R13667 vss.n1409 vss.n1196 6.51634
R13668 vss.n1286 vss.n1094 6.51634
R13669 vss.n1283 vss.n1200 6.51634
R13670 vss.n1413 vss.n1091 6.51634
R13671 vss.t401 vss.n756 6.51634
R13672 vss.n1416 vss.n755 6.51634
R13673 vss.n1279 vss.n779 6.51634
R13674 vss.n1276 vss.n753 6.51634
R13675 vss.n1420 vss.n781 6.51634
R13676 vss.n1272 vss.n783 6.51634
R13677 vss.n1270 vss.n749 6.51634
R13678 vss.t2108 vss.t645 6.51634
R13679 vss.t645 vss.n785 6.51634
R13680 vss.n1428 vss.n785 6.51634
R13681 vss.n1430 vss.n1206 6.51634
R13682 vss.n1266 vss.n1080 6.51634
R13683 vss.t609 vss.n790 6.51634
R13684 vss.n790 vss.t398 6.51634
R13685 vss.n1434 vss.n792 6.51634
R13686 vss.n1436 vss.n788 6.51634
R13687 vss.n1259 vss.n1075 6.51634
R13688 vss.n2957 vss.t185 6.48116
R13689 vss.n2955 vss.t900 6.48116
R13690 vss.n2964 vss.t906 6.48073
R13691 vss.n2962 vss.t193 6.48073
R13692 vss.n5268 vss.t1087 6.4498
R13693 vss.n2380 vss.t1424 6.42396
R13694 vss.n6141 vss.t1003 6.41573
R13695 vss.n6122 vss.t1017 6.41384
R13696 vss.n4371 vss.t1351 6.39823
R13697 vss.n5088 vss.t736 6.39823
R13698 vss.n3232 vss.t1862 6.39823
R13699 vss.n3234 vss.t1863 6.39823
R13700 vss.n3238 vss.t1865 6.39823
R13701 vss.n3239 vss.t1866 6.39823
R13702 vss.n6315 vss.t1425 6.39823
R13703 vss.n6317 vss.t1427 6.39823
R13704 vss.n6326 vss.t1429 6.39823
R13705 vss.n6330 vss.t961 6.39823
R13706 vss.n2425 vss.t33 6.39823
R13707 vss.n2423 vss.t690 6.39823
R13708 vss.n2421 vss.t2130 6.39823
R13709 vss.n2417 vss.t725 6.39823
R13710 vss.n2418 vss.t815 6.39823
R13711 vss.n2385 vss.t924 6.39823
R13712 vss.n2413 vss.t1143 6.39823
R13713 vss.n2411 vss.t1141 6.39823
R13714 vss.n2408 vss.t1139 6.39823
R13715 vss.n2406 vss.t1058 6.39823
R13716 vss.n2402 vss.t854 6.39823
R13717 vss.n2395 vss.t1046 6.39823
R13718 vss.n2945 vss.n2944 6.30604
R13719 vss.n2875 vss.n2874 6.30604
R13720 vss.n3577 vss.n3576 6.30009
R13721 vss.n3571 vss.n3570 6.30009
R13722 vss.n3565 vss.n3564 6.30009
R13723 vss.n3557 vss.n3556 6.30009
R13724 vss.n3548 vss.n3547 6.30009
R13725 vss.n5496 vss.n5495 6.16787
R13726 vss.n5474 vss.t1992 6.15435
R13727 vss.t1030 vss.n2310 6.13129
R13728 vss.t1037 vss.n2144 6.13129
R13729 vss.n6126 vss.t1039 6.03185
R13730 vss.n6137 vss.t1032 6.03185
R13731 vss.n743 vss.n6123 6.02988
R13732 vss.n6143 vss.n6142 6.02988
R13733 vss.n6148 vss.n6147 6.01774
R13734 vss.n6149 vss.n6148 6.01774
R13735 vss.n6121 vss.t1016 5.90366
R13736 vss.n6140 vss.t1004 5.90366
R13737 vss.n4 vss.n3252 5.87963
R13738 vss.n4 vss.n8 3.88264
R13739 vss.n4 vss.n3254 5.85852
R13740 vss.t143 vss.n5905 5.75293
R13741 vss.n3618 vss.n3617 5.69319
R13742 vss.n3593 vss.n3592 5.69319
R13743 vss.n654 vss.n653 0.516229
R13744 vss.n5611 vss.n185 5.66842
R13745 vss.n995 vss.n4 0.00844063
R13746 vss.n20 vss.n544 0.00467453
R13747 vss.n4599 vss.n548 1.54575
R13748 vss.n4599 vss.n552 1.54575
R13749 vss.n4599 vss.n556 1.54575
R13750 vss.n4599 vss.n560 1.54575
R13751 vss.n4599 vss.n564 1.54575
R13752 vss.n4599 vss.n568 1.54575
R13753 vss.n539 vss.n101 0.00229996
R13754 vss.n4599 vss.n572 1.54575
R13755 vss.n4599 vss.n576 1.54575
R13756 vss.n4599 vss.n580 1.54575
R13757 vss.n4599 vss.n584 1.54575
R13758 vss.n4599 vss.n588 1.54575
R13759 vss.n4599 vss.n592 1.54575
R13760 vss.n4599 vss.n596 1.54575
R13761 vss.n536 vss.n115 0.00229996
R13762 vss.n4599 vss.n600 1.54575
R13763 vss.n4599 vss.n604 1.54575
R13764 vss.n4599 vss.n608 1.54575
R13765 vss.n4599 vss.n612 1.54575
R13766 vss.n4599 vss.n616 1.54575
R13767 vss.n4599 vss.n620 1.54575
R13768 vss.n4599 vss.n624 1.54575
R13769 vss.n533 vss.n129 0.00229996
R13770 vss.n627 vss.n534 0.00261099
R13771 vss.n3747 vss.n1000 1.54575
R13772 vss.n3747 vss.n1004 1.54575
R13773 vss.n1007 vss.n135 0.00229996
R13774 vss.n3747 vss.n1010 1.54575
R13775 vss.n3747 vss.n1014 1.54575
R13776 vss.n3747 vss.n1018 1.54575
R13777 vss.n4 vss.n141 0.0239323
R13778 vss.n3747 vss.n973 1.54575
R13779 vss.n3747 vss.n977 1.54575
R13780 vss.n980 vss.n147 0.00229996
R13781 vss.n3747 vss.n983 1.54575
R13782 vss.n3747 vss.n987 1.54575
R13783 vss.n3747 vss.n991 1.54575
R13784 vss.n994 vss.n153 0.00268168
R13785 vss.n3747 vss.n6 0.0255416
R13786 vss.n15 vss.n14 0.00100008
R13787 vss.n4515 vss.n155 3.40102
R13788 vss.n4502 vss.n4501 5.66778
R13789 vss.n958 vss.n163 0.00228546
R13790 vss.n4485 vss.n4483 5.66778
R13791 vss.n4485 vss.n189 5.66778
R13792 vss.n950 vss.n184 0.00229996
R13793 vss.n683 vss.n364 0.00268168
R13794 vss.n686 vss.n632 0.00229996
R13795 vss.n688 vss.n507 0.00268168
R13796 vss.n691 vss.n635 0.00268168
R13797 vss.n693 vss.n638 0.00229996
R13798 vss.n694 vss.n505 0.00229996
R13799 vss.n696 vss.n503 0.00268168
R13800 vss.n698 vss.n641 0.00229996
R13801 vss.n699 vss.n501 0.00229996
R13802 vss.n701 vss.n499 0.0024999
R13803 vss.n6190 vss.n496 1
R13804 vss.n707 vss.n644 0.00229996
R13805 vss.n708 vss.n494 0.00229996
R13806 vss.n709 vss.n2693 0.00261099
R13807 vss.n6220 vss.n712 1.54575
R13808 vss.n489 vss.n176 0.00229996
R13809 vss.n714 vss.n490 0.00261099
R13810 vss.n6220 vss.n717 1.54575
R13811 vss.n719 vss.n172 0.00268168
R13812 vss.n6220 vss.n723 1.54575
R13813 vss.n6003 vss.n796 2.12576
R13814 vss.n5981 vss.n802 2.12576
R13815 vss.n5958 vss.n808 2.12576
R13816 vss.n5680 vss.n814 2.12576
R13817 vss.n5657 vss.n820 2.12576
R13818 vss.n830 vss.n185 1.54575
R13819 vss.n187 vss.n185 5.66778
R13820 vss.n4172 vss.n478 1.8894
R13821 vss.n4 vss.n3 0.00751577
R13822 vss.n796 vss.n795 0.00192479
R13823 vss.n802 vss.n801 0.00192479
R13824 vss.n808 vss.n807 0.00192479
R13825 vss.n814 vss.n813 0.00192479
R13826 vss.n820 vss.n819 0.00192479
R13827 vss.n6409 vss.n1450 5.66717
R13828 vss.n6409 vss.n1321 5.66717
R13829 vss.n4 vss.n3325 5.66717
R13830 vss.n4 vss.n3334 5.66717
R13831 vss.n4 vss.n3349 5.66717
R13832 vss.n4 vss.n3365 5.66717
R13833 vss.n4 vss.n3370 5.66717
R13834 vss.n4 vss.n3382 5.66717
R13835 vss.n4 vss.n3387 5.66717
R13836 vss.n4 vss.n3389 5.66717
R13837 vss.t638 vss.n4283 5.66717
R13838 vss.n6357 vss.n2383 5.6568
R13839 vss.n6357 vss.n2396 5.6568
R13840 vss.n6357 vss.n2390 5.6568
R13841 vss.n2873 vss.n653 5.65409
R13842 vss.n6357 vss.n2389 5.65314
R13843 vss.n3406 vss.t325 5.64998
R13844 vss.n3438 vss.t270 5.64953
R13845 vss.n3434 vss.t268 5.64953
R13846 vss.n3433 vss.t266 5.64953
R13847 vss.n3432 vss.t263 5.64953
R13848 vss.n3446 vss.t264 5.64953
R13849 vss.n3418 vss.t324 5.64953
R13850 vss.n3407 vss.t328 5.64953
R13851 vss.n3411 vss.t331 5.64953
R13852 vss.n3414 vss.t334 5.64953
R13853 vss.n466 vss.n5470 5.64895
R13854 vss.n5483 vss.n466 5.64857
R13855 vss.n6367 vss.n2360 5.64619
R13856 vss.n5479 vss.n466 5.64427
R13857 vss.n5451 vss.n437 5.64427
R13858 vss.n5461 vss.n437 5.64427
R13859 vss.n369 vss.n5360 5.64427
R13860 vss.n3957 vss.n373 5.64427
R13861 vss.n511 vss.n2673 5.64427
R13862 vss.n3794 vss.n516 5.64427
R13863 vss.n6236 vss.n521 5.64427
R13864 vss.n6257 vss.n475 5.64427
R13865 vss.n470 vss.n6264 5.64427
R13866 vss.n421 vss.n3980 5.64427
R13867 vss.n3940 vss.n416 5.64427
R13868 vss.n411 vss.n3243 5.64427
R13869 vss.n405 vss.n3886 5.64427
R13870 vss.n3917 vss.n407 5.64427
R13871 vss.t638 vss.n4243 5.64416
R13872 vss.n5053 vss.n5036 5.64415
R13873 vss.n466 vss.n5476 5.64415
R13874 vss.n435 vss.n5457 5.64415
R13875 vss.n6367 vss.n2375 5.64415
R13876 vss.n6392 vss.n6391 5.64415
R13877 vss.n6385 vss.n6384 5.64415
R13878 vss.n369 vss.n5370 5.64415
R13879 vss.n373 vss.n3954 5.64415
R13880 vss.n511 vss.n2685 5.64415
R13881 vss.n516 vss.n3791 5.64415
R13882 vss.n521 vss.n6233 5.64415
R13883 vss.n5067 vss.n5066 5.64415
R13884 vss.n2343 vss.n2341 5.64415
R13885 vss.n6367 vss.n2369 5.64415
R13886 vss.n2468 vss.n2466 5.64415
R13887 vss.n2469 vss.n2468 5.64415
R13888 vss.n2468 vss.n2450 5.64415
R13889 vss.n6399 vss.n6398 5.64415
R13890 vss.n6398 vss.n1719 5.64415
R13891 vss.n6398 vss.n1704 5.64415
R13892 vss.n6398 vss.n1699 5.64415
R13893 vss.n6398 vss.n1684 5.64415
R13894 vss.n6398 vss.n1504 5.64415
R13895 vss.n6398 vss.n1670 5.64415
R13896 vss.n6398 vss.n1664 5.64415
R13897 vss.n6398 vss.n1649 5.64415
R13898 vss.n6398 vss.n1525 5.64415
R13899 vss.n6398 vss.n1634 5.64415
R13900 vss.n6398 vss.n1538 5.64415
R13901 vss.n6398 vss.n1620 5.64415
R13902 vss.n6398 vss.n1551 5.64415
R13903 vss.n6398 vss.n1605 5.64415
R13904 vss.n6398 vss.n1564 5.64415
R13905 vss.n6398 vss.n1590 5.64415
R13906 vss.n6398 vss.n1584 5.64415
R13907 vss.n5321 vss.n5320 5.64415
R13908 vss.n5326 vss.n839 5.64415
R13909 vss.n6375 vss.n844 5.64415
R13910 vss.n2350 vss.n849 5.64415
R13911 vss.n854 vss.n2528 5.64415
R13912 vss.n2522 vss.n860 5.64415
R13913 vss.n2513 vss.n866 5.64415
R13914 vss.n870 vss.n2499 5.64415
R13915 vss.n2537 vss.n876 5.64415
R13916 vss.n880 vss.n2543 5.64415
R13917 vss.n884 vss.n2481 5.64415
R13918 vss.n2551 vss.n890 5.64415
R13919 vss.n894 vss.n2594 5.64415
R13920 vss.n6301 vss.n900 5.64415
R13921 vss.n475 vss.n6254 5.64415
R13922 vss.n470 vss.n6276 5.64415
R13923 vss.n3973 vss.n426 5.64415
R13924 vss.n3985 vss.n421 5.64415
R13925 vss.n416 vss.n3937 5.64415
R13926 vss.n411 vss.n3251 5.64415
R13927 vss.n3910 vss.n405 5.64415
R13928 vss.n407 vss.n3905 5.64415
R13929 vss.n3872 vss.n401 5.64415
R13930 vss.n3854 vss.n396 5.64415
R13931 vss.n391 vss.n3851 5.64415
R13932 vss.n387 vss.n3834 5.64415
R13933 vss.n3828 vss.n383 5.64415
R13934 vss.n3811 vss.n378 5.64415
R13935 vss.n3256 vss.n1725 5.63828
R13936 vss.n3324 vss.n1853 5.63766
R13937 vss.n3258 vss.n1852 5.63766
R13938 vss.n3259 vss.n1851 5.63766
R13939 vss.n3260 vss.n1728 5.63766
R13940 vss.n3327 vss.n1850 5.63766
R13941 vss.n3261 vss.n1729 5.63766
R13942 vss.n3328 vss.n1849 5.63766
R13943 vss.n3329 vss.n1730 5.63766
R13944 vss.n3262 vss.n1848 5.63766
R13945 vss.n3330 vss.n1731 5.63766
R13946 vss.n3331 vss.n1847 5.63766
R13947 vss.n3263 vss.n1732 5.63766
R13948 vss.n3332 vss.n1846 5.63766
R13949 vss.n3264 vss.n1733 5.63766
R13950 vss.n3265 vss.n1845 5.63766
R13951 vss.n3333 vss.n1734 5.63766
R13952 vss.n3266 vss.n1844 5.63766
R13953 vss.n3335 vss.n1843 5.63766
R13954 vss.n3268 vss.n1736 5.63766
R13955 vss.n3336 vss.n1842 5.63766
R13956 vss.n3269 vss.n1737 5.63766
R13957 vss.n3270 vss.n1841 5.63766
R13958 vss.n3337 vss.n1738 5.63766
R13959 vss.n3271 vss.n1840 5.63766
R13960 vss.n3272 vss.n1739 5.63766
R13961 vss.n3338 vss.n1839 5.63766
R13962 vss.n3273 vss.n1740 5.63766
R13963 vss.n3339 vss.n1838 5.63766
R13964 vss.n3340 vss.n1741 5.63766
R13965 vss.n3274 vss.n1837 5.63766
R13966 vss.n3341 vss.n1742 5.63766
R13967 vss.n3275 vss.n1836 5.63766
R13968 vss.n3276 vss.n1743 5.63766
R13969 vss.n3342 vss.n1835 5.63766
R13970 vss.n3277 vss.n1744 5.63766
R13971 vss.n3278 vss.n1834 5.63766
R13972 vss.n3343 vss.n1745 5.63766
R13973 vss.n3279 vss.n1833 5.63766
R13974 vss.n3344 vss.n1746 5.63766
R13975 vss.n3345 vss.n1832 5.63766
R13976 vss.n3280 vss.n1747 5.63766
R13977 vss.n3346 vss.n1831 5.63766
R13978 vss.n3281 vss.n1748 5.63766
R13979 vss.n3347 vss.n1830 5.63766
R13980 vss.n3348 vss.n1749 5.63766
R13981 vss.n3283 vss.n1750 5.63766
R13982 vss.n3350 vss.n1828 5.63766
R13983 vss.n3284 vss.n1751 5.63766
R13984 vss.n3351 vss.n1827 5.63766
R13985 vss.n3352 vss.n1752 5.63766
R13986 vss.n3285 vss.n1826 5.63766
R13987 vss.n3353 vss.n1753 5.63766
R13988 vss.n3286 vss.n1825 5.63766
R13989 vss.n3354 vss.n1754 5.63766
R13990 vss.n3355 vss.n1824 5.63766
R13991 vss.n3287 vss.n1755 5.63766
R13992 vss.n3288 vss.n1823 5.63766
R13993 vss.n3356 vss.n1756 5.63766
R13994 vss.n3289 vss.n1822 5.63766
R13995 vss.n3357 vss.n1757 5.63766
R13996 vss.n3290 vss.n1821 5.63766
R13997 vss.n3291 vss.n1758 5.63766
R13998 vss.n3358 vss.n1820 5.63766
R13999 vss.n3292 vss.n1759 5.63766
R14000 vss.n3359 vss.n1819 5.63766
R14001 vss.n3360 vss.n1760 5.63766
R14002 vss.n3293 vss.n1818 5.63766
R14003 vss.n3294 vss.n1761 5.63766
R14004 vss.n3361 vss.n1817 5.63766
R14005 vss.n3295 vss.n1762 5.63766
R14006 vss.n3362 vss.n1816 5.63766
R14007 vss.n3296 vss.n1763 5.63766
R14008 vss.n3297 vss.n1815 5.63766
R14009 vss.n3298 vss.n1814 5.63766
R14010 vss.n3364 vss.n1765 5.63766
R14011 vss.n3300 vss.n1766 5.63766
R14012 vss.n3366 vss.n1812 5.63766
R14013 vss.n3367 vss.n1767 5.63766
R14014 vss.n3301 vss.n1811 5.63766
R14015 vss.n3368 vss.n1768 5.63766
R14016 vss.n3302 vss.n1810 5.63766
R14017 vss.n3303 vss.n1769 5.63766
R14018 vss.n3369 vss.n1809 5.63766
R14019 vss.n3371 vss.n1808 5.63766
R14020 vss.n3372 vss.n1771 5.63766
R14021 vss.n3305 vss.n1807 5.63766
R14022 vss.n3373 vss.n1772 5.63766
R14023 vss.n3374 vss.n1806 5.63766
R14024 vss.n3306 vss.n1773 5.63766
R14025 vss.n3375 vss.n1805 5.63766
R14026 vss.n3307 vss.n1774 5.63766
R14027 vss.n3308 vss.n1804 5.63766
R14028 vss.n3376 vss.n1775 5.63766
R14029 vss.n3309 vss.n1803 5.63766
R14030 vss.n3377 vss.n1776 5.63766
R14031 vss.n3378 vss.n1802 5.63766
R14032 vss.n3310 vss.n1777 5.63766
R14033 vss.n3379 vss.n1801 5.63766
R14034 vss.n3311 vss.n1778 5.63766
R14035 vss.n3312 vss.n1800 5.63766
R14036 vss.n3380 vss.n1779 5.63766
R14037 vss.n3313 vss.n1799 5.63766
R14038 vss.n3314 vss.n1780 5.63766
R14039 vss.n3381 vss.n1798 5.63766
R14040 vss.n3383 vss.n1797 5.63766
R14041 vss.n3384 vss.n1782 5.63766
R14042 vss.n3316 vss.n1796 5.63766
R14043 vss.n3385 vss.n1783 5.63766
R14044 vss.n3317 vss.n1795 5.63766
R14045 vss.n3318 vss.n1784 5.63766
R14046 vss.n3386 vss.n1794 5.63766
R14047 vss.n3319 vss.n1785 5.63766
R14048 vss.n3388 vss.n1786 5.63766
R14049 vss.n3390 vss.n1787 5.63766
R14050 vss.n3391 vss.n1791 5.63766
R14051 vss.n3322 vss.n1788 5.63766
R14052 vss.n431 vss.n5382 5.6293
R14053 vss.n5485 vss.n466 5.6293
R14054 vss.n4372 vss.n3995 5.62801
R14055 vss.n6037 vss.n3235 5.62801
R14056 vss.n5247 vss.n488 5.62801
R14057 vss.n726 vss.n5189 5.62801
R14058 vss.n4516 vss.n156 5.61923
R14059 vss.n164 vss.n163 3.31465
R14060 vss.n4404 vss.n4400 5.61485
R14061 vss.n4404 vss.n4367 5.61485
R14062 vss.n5301 vss.n5090 5.61485
R14063 vss.n5301 vss.n5095 5.61485
R14064 vss.n5301 vss.n5093 5.61485
R14065 vss.n5301 vss.n5300 5.61485
R14066 vss.n5301 vss.n5262 5.61485
R14067 vss.n5301 vss.n5266 5.61485
R14068 vss.n6131 vss.n3029 5.61485
R14069 vss.n6131 vss.n3212 5.61485
R14070 vss.n6131 vss.n3048 5.61485
R14071 vss.n6131 vss.n3192 5.61485
R14072 vss.n6131 vss.n3054 5.61485
R14073 vss.n6131 vss.n3181 5.61485
R14074 vss.n6131 vss.n3060 5.61485
R14075 vss.n6131 vss.n3165 5.61485
R14076 vss.n6131 vss.n3088 5.61485
R14077 vss.n6131 vss.n3145 5.61485
R14078 vss.n6131 vss.n3128 5.61485
R14079 vss.n5301 vss.n5166 5.61485
R14080 vss.n5301 vss.n5151 5.61485
R14081 vss.t143 vss.n5808 5.61485
R14082 vss.n800 vss.n5996 0.319558
R14083 vss.n5974 vss.t1413 5.61485
R14084 vss.t55 vss.n806 3.30688
R14085 vss.n5951 vss.t83 5.61485
R14086 vss.t224 vss.n5957 5.61485
R14087 vss.t224 vss.n812 3.30688
R14088 vss.n5673 vss.t1406 5.61485
R14089 vss.t796 vss.n818 3.30688
R14090 vss.n5650 vss.t1403 5.61485
R14091 vss.t823 vss.n825 3.30688
R14092 vss.t47 vss.n5602 5.61485
R14093 vss.n435 vss.n5407 5.61485
R14094 vss.n435 vss.n5409 5.61485
R14095 vss.n435 vss.n5411 5.61485
R14096 vss.n435 vss.n5413 5.61485
R14097 vss.n435 vss.n5419 5.61485
R14098 vss.n435 vss.n5421 5.61485
R14099 vss.n435 vss.n5427 5.61485
R14100 vss.n435 vss.n5433 5.61485
R14101 vss.n435 vss.n5435 5.61485
R14102 vss.n435 vss.n5437 5.61485
R14103 vss.n435 vss.n5439 5.61485
R14104 vss.n1036 vss.n5010 5.61321
R14105 vss.n18 vss.n20 0.00651514
R14106 vss.n90 vss.n89 3.30408
R14107 vss.n92 vss.n91 3.30408
R14108 vss.n94 vss.n93 3.30408
R14109 vss.n96 vss.n95 3.30408
R14110 vss.n98 vss.n97 3.30408
R14111 vss.n100 vss.n99 3.30408
R14112 vss.n102 vss.n101 3.30408
R14113 vss.n541 vss.n540 3.30408
R14114 vss.n104 vss.n103 3.30408
R14115 vss.n106 vss.n105 3.30408
R14116 vss.n108 vss.n107 3.30408
R14117 vss.n110 vss.n109 3.30408
R14118 vss.n112 vss.n111 3.30408
R14119 vss.n114 vss.n113 3.30408
R14120 vss.n116 vss.n115 3.30408
R14121 vss.n538 vss.n537 3.30408
R14122 vss.n118 vss.n117 3.30408
R14123 vss.n120 vss.n119 3.30408
R14124 vss.n122 vss.n121 3.30408
R14125 vss.n124 vss.n123 3.30408
R14126 vss.n126 vss.n125 3.30408
R14127 vss.n128 vss.n127 3.30408
R14128 vss.n130 vss.n129 3.30408
R14129 vss.n534 vss.n535 3.30408
R14130 vss.n132 vss.n131 3.30408
R14131 vss.n134 vss.n133 3.30408
R14132 vss.n136 vss.n135 3.30408
R14133 vss.n3715 vss.n3703 5.61321
R14134 vss.n138 vss.n137 3.30408
R14135 vss.n140 vss.n139 3.30408
R14136 vss.n142 vss.n141 3.30408
R14137 vss.n144 vss.n143 3.30408
R14138 vss.n146 vss.n145 3.30408
R14139 vss.n148 vss.n147 3.30408
R14140 vss.n3737 vss.n3725 5.61321
R14141 vss.n150 vss.n149 3.30408
R14142 vss.n152 vss.n151 3.30408
R14143 vss.n154 vss.n153 3.30408
R14144 vss.n6193 vss.n632 5.61321
R14145 vss.n508 vss.n507 3.30408
R14146 vss.n6196 vss.n635 5.61321
R14147 vss.n6199 vss.n638 5.61321
R14148 vss.n506 vss.n505 3.30408
R14149 vss.n504 vss.n503 3.30408
R14150 vss.n6202 vss.n641 5.61321
R14151 vss.n502 vss.n501 3.30408
R14152 vss.n500 vss.n499 3.30408
R14153 vss.n498 vss.n497 3.30408
R14154 vss.n6209 vss.n644 5.61321
R14155 vss.n495 vss.n494 3.30408
R14156 vss.n179 vss.n178 2.29371
R14157 vss.n177 vss.n176 2.29371
R14158 vss.n491 vss.n490 3.30408
R14159 vss.n175 vss.n174 2.29371
R14160 vss.n173 vss.n172 2.29371
R14161 vss.n648 vss.n6219 5.61321
R14162 vss.n4171 vss.n837 5.61321
R14163 vss.n5540 vss.n1022 5.61321
R14164 vss.n4524 vss.n4339 5.60367
R14165 vss.t273 vss.n3483 5.5889
R14166 vss.n3458 vss.t315 5.5885
R14167 vss.n3495 vss.t313 5.58531
R14168 vss.t318 vss.n3421 5.58523
R14169 vss.t289 vss.n3469 5.5852
R14170 vss.t286 vss.n3425 5.58512
R14171 vss.t277 vss.n3428 5.58488
R14172 vss.t321 vss.n3456 5.58411
R14173 vss.t467 vss.n2358 5.5774
R14174 vss.n3453 vss.t1373 5.54159
R14175 vss.n3487 vss.t280 5.54157
R14176 vss.n3423 vss.t1368 5.54156
R14177 vss.n3467 vss.t1365 5.54156
R14178 vss.n3456 vss.t322 5.54156
R14179 vss.n3425 vss.t287 5.54154
R14180 vss.n3427 vss.t1359 5.54153
R14181 vss.n3466 vss.t1364 5.54136
R14182 vss.n3424 vss.t1363 5.54127
R14183 vss.n3495 vss.t312 5.54123
R14184 vss.n3474 vss.t1361 5.54121
R14185 vss.n3469 vss.t290 5.5412
R14186 vss.n3454 vss.t1374 5.54118
R14187 vss.n3483 vss.t274 5.54118
R14188 vss.n3479 vss.t1356 5.54116
R14189 vss.n3481 vss.t1354 5.54116
R14190 vss.n3480 vss.t1355 5.54116
R14191 vss.n3460 vss.t1370 5.54114
R14192 vss.n3420 vss.t1372 5.54113
R14193 vss.n3472 vss.t284 5.54113
R14194 vss.n3421 vss.t319 5.54103
R14195 vss.n3459 vss.t1369 5.54103
R14196 vss.n3473 vss.t1360 5.54103
R14197 vss.n3428 vss.t278 5.54103
R14198 vss.n3458 vss.t316 5.54099
R14199 vss.n5495 vss.n1022 5.41757
R14200 vss.n3487 vss.n3486 5.34544
R14201 vss.n3472 vss.n3465 5.34531
R14202 vss.n6161 vss.n2969 5.31981
R14203 vss.n3699 vss.n3394 5.19084
R14204 vss.n3672 vss.n3402 5.19084
R14205 vss.n3676 vss.n3675 5.19084
R14206 vss.n3399 vss.n3398 5.19084
R14207 vss.n3502 vss.n3501 5.18933
R14208 vss.n3670 vss.n3669 5.18933
R14209 vss.n3647 vss.n3646 5.18933
R14210 vss.n3591 vss.n3524 5.18933
R14211 vss.n5173 vss.t434 5.17294
R14212 vss.n5188 vss.t418 5.17294
R14213 vss.n2967 vss.n2966 5.14988
R14214 vss.n2960 vss.n2704 5.14988
R14215 vss.n4521 vss.n4327 5.11841
R14216 vss.n3122 vss.t253 5.01164
R14217 vss.n3110 vss.t663 5.01164
R14218 vss.n3103 vss.t1249 5.01164
R14219 vss.n3131 vss.t955 5.01164
R14220 vss.t718 vss.n3089 5.01164
R14221 vss.t201 vss.n2252 5.01164
R14222 vss.t1028 vss.n3166 5.01164
R14223 vss.t1389 vss.n2217 5.01164
R14224 vss.t911 vss.n2201 5.01164
R14225 vss.n3209 vss.t982 5.01164
R14226 vss.n3034 vss.t513 5.01164
R14227 vss.n3031 vss.t978 5.01164
R14228 vss.t1161 vss.n3218 5.01164
R14229 vss.t833 vss.n2170 5.01164
R14230 vss.t790 vss.t457 4.94895
R14231 vss.n6406 vss.n6405 4.94637
R14232 vss.n5048 vss.n5031 4.94637
R14233 vss.n2959 vss.n2707 4.83737
R14234 vss.n2923 vss.n2705 4.83737
R14235 vss.n5211 vss.n5209 4.81912
R14236 vss.n5246 vss.n5245 4.81912
R14237 vss.n5226 vss.n5225 4.78877
R14238 vss.n5224 vss.n5223 4.78805
R14239 vss.n5228 vss.n5175 4.78805
R14240 vss.n5245 vss.n5244 4.78779
R14241 vss.n5232 vss.n5231 4.78779
R14242 vss.n5211 vss.n5210 4.78779
R14243 vss.n3406 vss.n3403 4.78602
R14244 vss.n3438 vss.n3437 4.78602
R14245 vss.n3447 vss.n3446 4.78602
R14246 vss.n3414 vss.n3413 4.78602
R14247 vss.n3349 vss.t265 4.75436
R14248 vss.n3389 vss.t276 4.75436
R14249 vss.n5196 vss.t432 4.73685
R14250 vss.n5195 vss.t417 4.73685
R14251 vss.n3584 vss.n3529 4.73112
R14252 vss.n3588 vss.n3528 4.73112
R14253 vss.n3569 vss.n3568 4.73112
R14254 vss.n3563 vss.n3533 4.73112
R14255 vss.n6179 vss.n6171 4.6633
R14256 vss.n6173 vss.n6171 4.6633
R14257 vss.n6187 vss.n2695 4.6633
R14258 vss.n6181 vss.n2695 4.6633
R14259 vss.n743 vss.n6127 4.64616
R14260 vss.n6143 vss.n6138 4.64616
R14261 vss.n3256 vss.n1853 4.62688
R14262 vss.n3324 vss.n1726 4.62656
R14263 vss.n3258 vss.n1727 4.62656
R14264 vss.n3326 vss.n1851 4.62656
R14265 vss.n3260 vss.n1850 4.62656
R14266 vss.n3327 vss.n1729 4.62656
R14267 vss.n3261 vss.n1849 4.62656
R14268 vss.n3328 vss.n1730 4.62656
R14269 vss.n3329 vss.n1848 4.62656
R14270 vss.n3262 vss.n1731 4.62656
R14271 vss.n3330 vss.n1847 4.62656
R14272 vss.n3331 vss.n1732 4.62656
R14273 vss.n3332 vss.n1733 4.62656
R14274 vss.n3264 vss.n1845 4.62656
R14275 vss.n3265 vss.n1734 4.62656
R14276 vss.n3333 vss.n1844 4.62656
R14277 vss.n3266 vss.n1735 4.62656
R14278 vss.n3335 vss.n1736 4.62656
R14279 vss.n3268 vss.n1842 4.62656
R14280 vss.n3336 vss.n1737 4.62656
R14281 vss.n3269 vss.n1841 4.62656
R14282 vss.n3270 vss.n1738 4.62656
R14283 vss.n3337 vss.n1840 4.62656
R14284 vss.n3271 vss.n1739 4.62656
R14285 vss.n3272 vss.n1839 4.62656
R14286 vss.n3338 vss.n1740 4.62656
R14287 vss.n3273 vss.n1838 4.62656
R14288 vss.n3339 vss.n1741 4.62656
R14289 vss.n3340 vss.n1837 4.62656
R14290 vss.n3274 vss.n1742 4.62656
R14291 vss.n3341 vss.n1836 4.62656
R14292 vss.n3275 vss.n1743 4.62656
R14293 vss.n3342 vss.n1744 4.62656
R14294 vss.n3277 vss.n1834 4.62656
R14295 vss.n3278 vss.n1745 4.62656
R14296 vss.n3343 vss.n1833 4.62656
R14297 vss.n3279 vss.n1746 4.62656
R14298 vss.n3344 vss.n1832 4.62656
R14299 vss.n3345 vss.n1747 4.62656
R14300 vss.n3280 vss.n1831 4.62656
R14301 vss.n3281 vss.n1830 4.62656
R14302 vss.n3347 vss.n1749 4.62656
R14303 vss.n3348 vss.n1829 4.62656
R14304 vss.n3283 vss.n1828 4.62656
R14305 vss.n3350 vss.n1751 4.62656
R14306 vss.n3284 vss.n1827 4.62656
R14307 vss.n3351 vss.n1752 4.62656
R14308 vss.n3352 vss.n1826 4.62656
R14309 vss.n3285 vss.n1753 4.62656
R14310 vss.n3353 vss.n1825 4.62656
R14311 vss.n3286 vss.n1754 4.62656
R14312 vss.n3354 vss.n1824 4.62656
R14313 vss.n3355 vss.n1755 4.62656
R14314 vss.n3287 vss.n1823 4.62656
R14315 vss.n3288 vss.n1756 4.62656
R14316 vss.n3356 vss.n1822 4.62656
R14317 vss.n3289 vss.n1757 4.62656
R14318 vss.n3357 vss.n1821 4.62656
R14319 vss.n3290 vss.n1758 4.62656
R14320 vss.n3291 vss.n1820 4.62656
R14321 vss.n3358 vss.n1759 4.62656
R14322 vss.n3292 vss.n1819 4.62656
R14323 vss.n3359 vss.n1760 4.62656
R14324 vss.n3360 vss.n1818 4.62656
R14325 vss.n3293 vss.n1761 4.62656
R14326 vss.n3294 vss.n1817 4.62656
R14327 vss.n3361 vss.n1762 4.62656
R14328 vss.n3295 vss.n1816 4.62656
R14329 vss.n3362 vss.n1763 4.62656
R14330 vss.n3296 vss.n1815 4.62656
R14331 vss.n3297 vss.n1764 4.62656
R14332 vss.n3363 vss.n1814 4.62656
R14333 vss.n3298 vss.n1765 4.62656
R14334 vss.n3364 vss.n1813 4.62656
R14335 vss.n3300 vss.n1812 4.62656
R14336 vss.n3366 vss.n1767 4.62656
R14337 vss.n3367 vss.n1811 4.62656
R14338 vss.n3301 vss.n1768 4.62656
R14339 vss.n3368 vss.n1810 4.62656
R14340 vss.n3302 vss.n1769 4.62656
R14341 vss.n3303 vss.n1809 4.62656
R14342 vss.n3369 vss.n1770 4.62656
R14343 vss.n3371 vss.n1771 4.62656
R14344 vss.n3372 vss.n1807 4.62656
R14345 vss.n3305 vss.n1772 4.62656
R14346 vss.n3373 vss.n1806 4.62656
R14347 vss.n3374 vss.n1773 4.62656
R14348 vss.n3306 vss.n1805 4.62656
R14349 vss.n3375 vss.n1774 4.62656
R14350 vss.n3307 vss.n1804 4.62656
R14351 vss.n3308 vss.n1775 4.62656
R14352 vss.n3376 vss.n1803 4.62656
R14353 vss.n3309 vss.n1776 4.62656
R14354 vss.n3377 vss.n1802 4.62656
R14355 vss.n3378 vss.n1777 4.62656
R14356 vss.n3310 vss.n1801 4.62656
R14357 vss.n3379 vss.n1778 4.62656
R14358 vss.n3312 vss.n1779 4.62656
R14359 vss.n3380 vss.n1799 4.62656
R14360 vss.n3313 vss.n1780 4.62656
R14361 vss.n3314 vss.n1798 4.62656
R14362 vss.n3381 vss.n1781 4.62656
R14363 vss.n3383 vss.n1782 4.62656
R14364 vss.n3384 vss.n1796 4.62656
R14365 vss.n3316 vss.n1783 4.62656
R14366 vss.n3385 vss.n1795 4.62656
R14367 vss.n3317 vss.n1784 4.62656
R14368 vss.n3318 vss.n1794 4.62656
R14369 vss.n3386 vss.n1785 4.62656
R14370 vss.n3319 vss.n1793 4.62656
R14371 vss.n3388 vss.n1792 4.62656
R14372 vss.n3391 vss.n1788 4.62656
R14373 vss.n3322 vss.n1790 4.62656
R14374 vss.n3671 vss.n3498 4.62206
R14375 vss.n3620 vss.n3619 4.60078
R14376 vss.n3621 vss.n3500 4.60078
R14377 vss.n3698 vss.n3697 4.56573
R14378 vss.n3686 vss.n3685 4.56573
R14379 vss.n3645 vss.n3644 4.56573
R14380 vss.n3617 vss.n3616 4.56573
R14381 vss.n3694 vss.n3693 4.56572
R14382 vss.n3690 vss.n3689 4.56572
R14383 vss.n3622 vss.n3499 4.56572
R14384 vss.n3594 vss.n3593 4.56572
R14385 vss.n2785 vss.t958 4.55631
R14386 vss.n2759 vss.t597 4.55631
R14387 vss.n3436 vss.n3434 4.5554
R14388 vss.n3435 vss.n3433 4.5554
R14389 vss.n3432 vss.n3431 4.5554
R14390 vss.n3419 vss.n3418 4.5554
R14391 vss.n3407 vss.n3404 4.5554
R14392 vss.n3412 vss.n3411 4.5554
R14393 vss.n4523 vss.n4522 4.5005
R14394 vss.n5493 vss.n5492 4.5005
R14395 vss.n5491 vss.n5490 4.5005
R14396 vss.n5494 vss.n5493 4.5005
R14397 vss.n5547 vss.n5546 4.5005
R14398 vss.n5543 vss.n5536 4.5005
R14399 vss.n5546 vss.n5545 4.5005
R14400 vss.n6149 vss.n2980 4.5005
R14401 vss.n6151 vss.n6150 4.5005
R14402 vss.n6152 vss.n2975 4.5005
R14403 vss.n6154 vss.n6153 4.5005
R14404 vss.n6155 vss.n2974 4.5005
R14405 vss.n6157 vss.n6156 4.5005
R14406 vss.n6158 vss.n2970 4.5005
R14407 vss.n6160 vss.n6159 4.5005
R14408 vss.n6162 vss.n6161 4.5005
R14409 vss.n6147 vss.n2980 4.5005
R14410 vss.n6151 vss.n2979 4.5005
R14411 vss.n6152 vss.n2978 4.5005
R14412 vss.n6153 vss.n2977 4.5005
R14413 vss.n2976 vss.n2974 4.5005
R14414 vss.n6157 vss.n2973 4.5005
R14415 vss.n6158 vss.n2972 4.5005
R14416 vss.n6159 vss.n2971 4.5005
R14417 vss.n5168 vss.n5167 4.5005
R14418 vss.n5217 vss.n5212 4.5005
R14419 vss.n5222 vss.n5221 4.5005
R14420 vss.n5238 vss.n5233 4.5005
R14421 vss.n5243 vss.n5242 4.5005
R14422 vss.n3450 vss.n3449 4.5005
R14423 vss.n3478 vss.n3477 4.5005
R14424 vss.n3476 vss.n3475 4.5005
R14425 vss.n3468 vss.n3464 4.5005
R14426 vss.n3462 vss.n3461 4.5005
R14427 vss.n3455 vss.n3452 4.5005
R14428 vss.n3413 vss.n3392 4.5005
R14429 vss.n3700 vss.n3699 4.5005
R14430 vss.n3399 vss.n3393 4.5005
R14431 vss.n3525 vss.n3501 4.5005
R14432 vss.n3591 vss.n3590 4.5005
R14433 vss.n3589 vss.n3588 4.5005
R14434 vss.n3575 vss.n3574 4.5005
R14435 vss.n3573 vss.n3572 4.5005
R14436 vss.n3567 vss.n3566 4.5005
R14437 vss.n3555 vss.n3532 4.5005
R14438 vss.n3546 vss.n3545 4.5005
R14439 vss.n3552 vss.n3551 4.5005
R14440 vss.n3561 vss.n3560 4.5005
R14441 vss.n3563 vss.n3562 4.5005
R14442 vss.n3569 vss.n3530 4.5005
R14443 vss.n3581 vss.n3580 4.5005
R14444 vss.n3584 vss.n3583 4.5005
R14445 vss.n3646 vss.n3498 4.5005
R14446 vss.n3671 vss.n3670 4.5005
R14447 vss.n3677 vss.n3676 4.5005
R14448 vss.n3678 vss.n3402 4.5005
R14449 vss.n3679 vss.n3403 4.5005
R14450 vss.n3681 vss.n3680 4.5005
R14451 vss.n3497 vss.n3496 4.5005
R14452 vss.n3491 vss.n3490 4.5005
R14453 vss.n3489 vss.n3488 4.5005
R14454 vss.n3482 vss.n3426 4.5005
R14455 vss.n3448 vss.n3447 4.5005
R14456 vss.n3437 vss.n3429 4.5005
R14457 vss.n3559 vss.n3558 4.5005
R14458 vss.n3550 vss.n3549 4.5005
R14459 vss.n3536 vss.n3535 4.5005
R14460 vss.n5511 vss.t373 4.47695
R14461 vss.n185 vss.n2359 4.46202
R14462 vss.n5512 vss.t372 4.43084
R14463 vss.n3526 vss.n3525 4.40965
R14464 vss.n3326 vss.t272 4.36997
R14465 vss.n3363 vss.t267 4.36997
R14466 vss.n1297 vss.t29 4.34439
R14467 vss.n1294 vss.t30 4.34439
R14468 vss.n1286 vss.t391 4.34439
R14469 vss.n1283 vss.t394 4.34439
R14470 vss.n1423 vss.t643 4.34439
R14471 vss.n1425 vss.t644 4.34439
R14472 vss.t39 vss.n3320 4.27897
R14473 vss.n6190 vss.n6189 4.25119
R14474 vss.n823 vss.n5601 4.251
R14475 vss.n6412 vss.n1062 4.2505
R14476 vss.n6412 vss.n1121 4.2505
R14477 vss.n6359 vss.n2380 4.24151
R14478 vss.t143 vss.n5798 4.2387
R14479 vss.n5907 vss.n5804 4.23779
R14480 vss.n87 vss.t728 9.99785
R14481 vss.n6355 vss.n2379 4.23577
R14482 vss.n2430 vss.n2379 4.23571
R14483 vss.n6357 vss.n2391 4.23558
R14484 vss.n6357 vss.n2386 4.23481
R14485 vss.n6357 vss.n2393 4.23131
R14486 vss.n6037 vss.n3229 4.21709
R14487 vss.n5051 vss.n5036 4.20468
R14488 vss.n6392 vss.n2323 4.20468
R14489 vss.n6384 vss.n6381 4.20468
R14490 vss.n369 vss.n5366 4.20468
R14491 vss.n373 vss.n3951 4.20468
R14492 vss.n511 vss.n2680 4.20468
R14493 vss.n516 vss.n3786 4.20468
R14494 vss.n521 vss.n6228 4.20468
R14495 vss.n5067 vss.n5061 4.20468
R14496 vss.n2343 vss.n2336 4.20468
R14497 vss.n6367 vss.n2362 4.20468
R14498 vss.n6367 vss.n2373 4.20468
R14499 vss.n2468 vss.n2431 4.20468
R14500 vss.n2468 vss.n2458 4.20468
R14501 vss.n2468 vss.n2445 4.20468
R14502 vss.n6398 vss.n1480 4.20468
R14503 vss.n6398 vss.n1712 4.20468
R14504 vss.n6398 vss.n1488 4.20468
R14505 vss.n6398 vss.n1692 4.20468
R14506 vss.n6398 vss.n1496 4.20468
R14507 vss.n6398 vss.n1678 4.20468
R14508 vss.n6398 vss.n1509 4.20468
R14509 vss.n6398 vss.n1657 4.20468
R14510 vss.n6398 vss.n1517 4.20468
R14511 vss.n6398 vss.n1643 4.20468
R14512 vss.n6398 vss.n1530 4.20468
R14513 vss.n6398 vss.n1628 4.20468
R14514 vss.n6398 vss.n1543 4.20468
R14515 vss.n6398 vss.n1613 4.20468
R14516 vss.n6398 vss.n1556 4.20468
R14517 vss.n6398 vss.n1598 4.20468
R14518 vss.n6398 vss.n1569 4.20468
R14519 vss.n6398 vss.n1577 4.20468
R14520 vss.n5320 vss.n5318 4.20468
R14521 vss.n475 vss.n6249 4.20468
R14522 vss.n470 vss.n6271 4.20468
R14523 vss.n3987 vss.n421 4.20468
R14524 vss.n416 vss.n3932 4.20468
R14525 vss.n411 vss.n3248 4.20468
R14526 vss.n3912 vss.n405 4.20468
R14527 vss.n407 vss.n3899 4.20468
R14528 vss.n435 vss.n5441 4.20302
R14529 vss.n6367 vss.n6365 4.20241
R14530 vss.n1036 vss.n5012 4.19617
R14531 vss.n5304 vss.n5303 4.1955
R14532 vss.n4412 vss.n4411 4.19347
R14533 vss.n6131 vss.n3114 4.1907
R14534 vss.t638 vss.n4285 4.18399
R14535 vss.t638 vss.n4264 4.17719
R14536 vss.t638 vss.n4260 4.17719
R14537 vss.t638 vss.n4249 4.17719
R14538 vss.n5301 vss.n5098 4.17719
R14539 vss.n5301 vss.n5091 4.17719
R14540 vss.n6131 vss.n3217 4.17719
R14541 vss.n6131 vss.n3035 4.17719
R14542 vss.n6131 vss.n3205 4.17719
R14543 vss.n6131 vss.n3073 4.17719
R14544 vss.n6131 vss.n3078 4.17719
R14545 vss.n6131 vss.n3134 4.17719
R14546 vss.n6131 vss.n3108 4.17719
R14547 vss.n5948 vss.t143 4.17719
R14548 vss.t143 vss.n5787 4.17719
R14549 vss.t143 vss.n5791 4.17719
R14550 vss.t1415 vss.n5555 4.17719
R14551 vss.t521 vss.n6002 4.17719
R14552 vss.t55 vss.n5980 4.17719
R14553 vss.t796 vss.n5679 4.17719
R14554 vss.t823 vss.n5656 4.17719
R14555 vss.n5301 vss.n5280 4.17712
R14556 vss.n5301 vss.n5139 4.17712
R14557 vss.n435 vss.n5425 4.17712
R14558 vss.t638 vss.n4275 4.177
R14559 vss.n5301 vss.n5271 4.177
R14560 vss.n6210 vss.n2693 4.17491
R14561 vss.n2956 vss.n2953 4.15497
R14562 vss.n2963 vss.n2706 4.15497
R14563 vss.t34 vss.n3304 4.12051
R14564 vss.n5657 vss.n5592 4.09327
R14565 vss.n5680 vss.n5584 4.09327
R14566 vss.n5958 vss.n5575 4.09327
R14567 vss.n5981 vss.n5567 4.09327
R14568 vss.n6003 vss.n5559 4.09327
R14569 vss.n3311 vss.t269 3.99271
R14570 vss.n3893 vss.n1724 3.96205
R14571 vss.n488 vss.n5194 3.95476
R14572 vss.n488 vss.n5193 3.95476
R14573 vss.n488 vss.n5192 3.95476
R14574 vss.n488 vss.n5191 3.95476
R14575 vss.n5494 vss.n5489 3.95006
R14576 vss.n5547 vss.n5535 3.94991
R14577 vss.n6038 vss.n6037 3.94671
R14578 vss.n2971 vss.n2703 3.93392
R14579 vss.n1395 vss.t935 3.8014
R14580 vss.n1268 vss.t495 3.8014
R14581 vss.n6 vss.n1789 5.09737
R14582 vss.n6124 vss.t1008 3.79442
R14583 vss.n6135 vss.t1005 3.79253
R14584 vss.n364 vss.n2137 3.77978
R14585 vss.n3685 vss.n3401 3.71319
R14586 vss.n3698 vss.n3395 3.71319
R14587 vss.n3691 vss.n3690 3.71319
R14588 vss.n3693 vss.n3692 3.71319
R14589 vss.n3390 vss.t1169 3.67579
R14590 vss.t693 vss.n3315 3.64512
R14591 vss.n287 vss.n2808 3.6418
R14592 vss.n287 vss.n2809 3.6418
R14593 vss.n287 vss.n2811 3.6418
R14594 vss.n287 vss.n2812 3.6418
R14595 vss.n287 vss.n2813 3.6418
R14596 vss.n287 vss.n2814 3.6418
R14597 vss.n267 vss.n2577 3.6418
R14598 vss.n267 vss.n2579 3.6418
R14599 vss.n267 vss.n2582 3.6418
R14600 vss.n267 vss.n2583 3.6418
R14601 vss.n267 vss.n2584 3.6418
R14602 vss.t157 vss.n4217 3.61496
R14603 vss.n4265 vss.t162 3.61496
R14604 vss.n2923 vss.n2707 3.60547
R14605 vss.n1895 vss.t1450 3.51338
R14606 vss.n1918 vss.t1465 3.51338
R14607 vss.n1941 vss.t1480 3.51338
R14608 vss.n1964 vss.t1495 3.51338
R14609 vss.n1987 vss.t1510 3.51338
R14610 vss.n2010 vss.t1525 3.51338
R14611 vss.n5514 vss.t1212 3.51025
R14612 vss.n4603 vss.n12 3.497
R14613 vss.n4442 vss.n4311 3.497
R14614 vss.n4441 vss.n4312 3.497
R14615 vss.n4443 vss.n4310 3.497
R14616 vss.n4440 vss.n4313 3.497
R14617 vss.n4444 vss.n4309 3.497
R14618 vss.n4439 vss.n4314 3.497
R14619 vss.n4445 vss.n4308 3.497
R14620 vss.n4438 vss.n4315 3.497
R14621 vss.n4446 vss.n4307 3.497
R14622 vss.n4437 vss.n4316 3.497
R14623 vss.n4447 vss.n4306 3.497
R14624 vss.n4436 vss.n4317 3.497
R14625 vss.n4448 vss.n4305 3.497
R14626 vss.n4435 vss.n4318 3.497
R14627 vss.n4449 vss.n4304 3.497
R14628 vss.n4434 vss.n4319 3.497
R14629 vss.n4450 vss.n4303 3.497
R14630 vss.n4433 vss.n4320 3.497
R14631 vss.n4451 vss.n4302 3.497
R14632 vss.n4432 vss.n4321 3.497
R14633 vss.n4452 vss.n4301 3.497
R14634 vss.n4431 vss.n4322 3.497
R14635 vss.n4453 vss.n4300 3.497
R14636 vss.n4430 vss.n4323 3.497
R14637 vss.n4454 vss.n4299 3.497
R14638 vss.n4429 vss.n4324 3.497
R14639 vss.n4455 vss.n4298 3.497
R14640 vss.n4428 vss.n4325 3.497
R14641 vss.n4456 vss.n4297 3.497
R14642 vss.n4427 vss.n4326 3.497
R14643 vss.n4457 vss.n4296 3.497
R14644 vss.n4426 vss.n4328 3.497
R14645 vss.n4458 vss.n4295 3.497
R14646 vss.n4425 vss.n4329 3.497
R14647 vss.n4459 vss.n4294 3.497
R14648 vss.n4424 vss.n4330 3.497
R14649 vss.n4460 vss.n4293 3.497
R14650 vss.n4423 vss.n4331 3.497
R14651 vss.n4461 vss.n4292 3.497
R14652 vss.n4422 vss.n4332 3.497
R14653 vss.n4462 vss.n4291 3.497
R14654 vss.n4421 vss.n4333 3.497
R14655 vss.n4463 vss.n4290 3.497
R14656 vss.n4420 vss.n4334 3.497
R14657 vss.n4464 vss.n166 3.497
R14658 vss.n4419 vss.n4335 3.497
R14659 vss.n4465 vss.n4289 3.497
R14660 vss.n4418 vss.n4336 3.497
R14661 vss.n4475 vss.n4418 3.497
R14662 vss.n4466 vss.n167 3.497
R14663 vss.n4417 vss.n4337 3.497
R14664 vss.n4467 vss.n4288 3.497
R14665 vss.n4416 vss.n4338 3.497
R14666 vss.n4478 vss.n4416 3.497
R14667 vss.n4600 vss.n4287 3.497
R14668 vss.n3325 vss.n1852 3.48666
R14669 vss.n3334 vss.n1843 3.48666
R14670 vss.n3349 vss.n1750 3.48666
R14671 vss.n3365 vss.n1766 3.48666
R14672 vss.n3370 vss.n1808 3.48666
R14673 vss.n3382 vss.n1797 3.48666
R14674 vss.n3387 vss.n1786 3.48666
R14675 vss.n3389 vss.n1787 3.48666
R14676 vss.t505 vss.n4368 3.47272
R14677 vss.t1417 vss.n4356 3.47272
R14678 vss.t2123 vss.n4343 3.47272
R14679 vss.n2960 vss.n2959 3.46742
R14680 vss.n2966 vss.n2705 3.46742
R14681 vss.n6120 vss.t1007 3.40944
R14682 vss.n6139 vss.t1006 3.40944
R14683 vss.n6131 vss.n3015 3.40608
R14684 vss.n2945 vss.n2923 3.40519
R14685 vss.n2875 vss.n2707 3.40519
R14686 vss.n2601 vss.n2055 3.40186
R14687 vss.n6300 vss.n2076 3.40186
R14688 vss.n6242 vss.n2104 3.40186
R14689 vss.n6280 vss.n2125 3.40186
R14690 vss.n6361 vss.n6360 3.40096
R14691 vss.n6359 vss.n6358 3.4005
R14692 vss.n6395 vss.n364 3.4005
R14693 vss.n4 vss.n3256 3.39667
R14694 vss.n4 vss.n3324 3.39645
R14695 vss.n4 vss.n3326 3.39645
R14696 vss.n4 vss.n3327 3.39645
R14697 vss.n4 vss.n3328 3.39645
R14698 vss.n4 vss.n3329 3.39645
R14699 vss.n4 vss.n3330 3.39645
R14700 vss.n4 vss.n3331 3.39645
R14701 vss.n4 vss.n3332 3.39645
R14702 vss.n4 vss.n3333 3.39645
R14703 vss.n4 vss.n3335 3.39645
R14704 vss.n4 vss.n3336 3.39645
R14705 vss.n4 vss.n3337 3.39645
R14706 vss.n4 vss.n3338 3.39645
R14707 vss.n4 vss.n3339 3.39645
R14708 vss.n4 vss.n3340 3.39645
R14709 vss.n4 vss.n3341 3.39645
R14710 vss.n4 vss.n3342 3.39645
R14711 vss.n4 vss.n3343 3.39645
R14712 vss.n4 vss.n3344 3.39645
R14713 vss.n4 vss.n3345 3.39645
R14714 vss.n4 vss.n3346 3.39645
R14715 vss.n4 vss.n3347 3.39645
R14716 vss.n4 vss.n3348 3.39645
R14717 vss.n4 vss.n3350 3.39645
R14718 vss.n4 vss.n3351 3.39645
R14719 vss.n4 vss.n3352 3.39645
R14720 vss.n4 vss.n3353 3.39645
R14721 vss.n4 vss.n3354 3.39645
R14722 vss.n4 vss.n3355 3.39645
R14723 vss.n4 vss.n3356 3.39645
R14724 vss.n4 vss.n3357 3.39645
R14725 vss.n4 vss.n3358 3.39645
R14726 vss.n4 vss.n3359 3.39645
R14727 vss.n4 vss.n3360 3.39645
R14728 vss.n4 vss.n3361 3.39645
R14729 vss.n4 vss.n3362 3.39645
R14730 vss.n4 vss.n3363 3.39645
R14731 vss.n4 vss.n3364 3.39645
R14732 vss.n4 vss.n3366 3.39645
R14733 vss.n4 vss.n3367 3.39645
R14734 vss.n4 vss.n3368 3.39645
R14735 vss.n4 vss.n3369 3.39645
R14736 vss.n4 vss.n3371 3.39645
R14737 vss.n4 vss.n3372 3.39645
R14738 vss.n4 vss.n3373 3.39645
R14739 vss.n4 vss.n3374 3.39645
R14740 vss.n4 vss.n3375 3.39645
R14741 vss.n4 vss.n3376 3.39645
R14742 vss.n4 vss.n3377 3.39645
R14743 vss.n4 vss.n3378 3.39645
R14744 vss.n4 vss.n3379 3.39645
R14745 vss.n4 vss.n3380 3.39645
R14746 vss.n4 vss.n3381 3.39645
R14747 vss.n4 vss.n3383 3.39645
R14748 vss.n4 vss.n3384 3.39645
R14749 vss.n4 vss.n3385 3.39645
R14750 vss.n4 vss.n3386 3.39645
R14751 vss.n4 vss.n3388 3.39645
R14752 vss.n4 vss.n3390 3.39645
R14753 vss.n4 vss.n3391 3.39645
R14754 vss.n4 vss.n3322 3.39645
R14755 vss.n4 vss.n3319 3.39645
R14756 vss.n4 vss.n3318 3.39645
R14757 vss.n4 vss.n3317 3.39645
R14758 vss.n4 vss.n3316 3.39645
R14759 vss.n4 vss.n3314 3.39645
R14760 vss.n4 vss.n3313 3.39645
R14761 vss.n4 vss.n3312 3.39645
R14762 vss.n4 vss.n3311 3.39645
R14763 vss.n4 vss.n3310 3.39645
R14764 vss.n4 vss.n3309 3.39645
R14765 vss.n4 vss.n3308 3.39645
R14766 vss.n4 vss.n3307 3.39645
R14767 vss.n4 vss.n3306 3.39645
R14768 vss.n4 vss.n3305 3.39645
R14769 vss.n4 vss.n3303 3.39645
R14770 vss.n4 vss.n3302 3.39645
R14771 vss.n4 vss.n3301 3.39645
R14772 vss.n4 vss.n3300 3.39645
R14773 vss.n4 vss.n3298 3.39645
R14774 vss.n4 vss.n3297 3.39645
R14775 vss.n4 vss.n3296 3.39645
R14776 vss.n4 vss.n3295 3.39645
R14777 vss.n4 vss.n3294 3.39645
R14778 vss.n4 vss.n3293 3.39645
R14779 vss.n4 vss.n3292 3.39645
R14780 vss.n4 vss.n3291 3.39645
R14781 vss.n4 vss.n3290 3.39645
R14782 vss.n4 vss.n3289 3.39645
R14783 vss.n4 vss.n3288 3.39645
R14784 vss.n4 vss.n3287 3.39645
R14785 vss.n4 vss.n3286 3.39645
R14786 vss.n4 vss.n3285 3.39645
R14787 vss.n4 vss.n3284 3.39645
R14788 vss.n4 vss.n3283 3.39645
R14789 vss.n4 vss.n3281 3.39645
R14790 vss.n4 vss.n3280 3.39645
R14791 vss.n4 vss.n3279 3.39645
R14792 vss.n4 vss.n3278 3.39645
R14793 vss.n4 vss.n3277 3.39645
R14794 vss.n4 vss.n3276 3.39645
R14795 vss.n4 vss.n3275 3.39645
R14796 vss.n4 vss.n3274 3.39645
R14797 vss.n4 vss.n3273 3.39645
R14798 vss.n4 vss.n3272 3.39645
R14799 vss.n4 vss.n3271 3.39645
R14800 vss.n4 vss.n3270 3.39645
R14801 vss.n4 vss.n3269 3.39645
R14802 vss.n4 vss.n3268 3.39645
R14803 vss.n4 vss.n3266 3.39645
R14804 vss.n4 vss.n3265 3.39645
R14805 vss.n4 vss.n3264 3.39645
R14806 vss.n4 vss.n3263 3.39645
R14807 vss.n4 vss.n3262 3.39645
R14808 vss.n4 vss.n3261 3.39645
R14809 vss.n4 vss.n3260 3.39645
R14810 vss.n4 vss.n3259 3.39645
R14811 vss.n4 vss.n3258 3.39645
R14812 vss.n5526 vss.n5525 3.38694
R14813 vss.n6357 vss.n2407 3.37989
R14814 vss.n6357 vss.n2387 3.37989
R14815 vss.n6357 vss.n2405 3.37988
R14816 vss.n6359 vss.n2381 3.37961
R14817 vss.n6357 vss.n2384 3.37948
R14818 vss.n6357 vss.n2412 3.37885
R14819 vss.n5301 vss.n5272 3.37739
R14820 vss.n3346 vss.t212 3.35886
R14821 vss.n3120 vss.t198 3.34126
R14822 vss.n3155 vss.t1232 3.34126
R14823 vss.n6075 vss.t1391 3.34126
R14824 vss.n6086 vss.n3209 3.34126
R14825 vss.n6088 vss.n3033 3.34126
R14826 vss.t830 vss.n3021 3.34126
R14827 vss.t2075 vss.t830 3.34126
R14828 vss.t49 vss.n3299 3.3282
R14829 vss.n6131 vss.n3095 3.30723
R14830 vss.n5932 vss.t143 3.30723
R14831 vss.n5934 vss.t143 3.30723
R14832 vss.n5940 vss.t143 3.30723
R14833 vss.n5942 vss.t143 3.30723
R14834 vss.t143 vss.n5738 3.30723
R14835 vss.t143 vss.n5750 3.30723
R14836 vss.t143 vss.n5846 3.30723
R14837 vss.t143 vss.n5832 3.30723
R14838 vss.t143 vss.n5770 3.30723
R14839 vss.t143 vss.n5782 3.30723
R14840 vss.t521 vss.n5986 3.30723
R14841 vss.t55 vss.n5963 3.30723
R14842 vss.t224 vss.n5685 3.30723
R14843 vss.t796 vss.n5662 3.30723
R14844 vss.t823 vss.n5639 3.30723
R14845 vss.n5301 vss.n5297 3.30706
R14846 vss.n5301 vss.n5264 3.30688
R14847 vss.n5301 vss.n5274 3.30688
R14848 vss.n5301 vss.n5158 3.30688
R14849 vss.n6403 vss.n6402 3.29757
R14850 vss.n6125 vss.t1027 3.28126
R14851 vss.n6136 vss.t1026 3.28126
R14852 vss.n1290 vss.t492 3.25842
R14853 vss.t492 vss.n759 3.25842
R14854 vss.t132 vss.t389 3.25842
R14855 vss.n5218 vss.t380 3.21132
R14856 vss.t422 vss.n5234 3.20642
R14857 vss.t413 vss.n5213 3.20642
R14858 vss.n5237 vss.t420 3.20624
R14859 vss.n3263 vss.t527 3.2004
R14860 vss.t1171 vss.n3257 3.16974
R14861 vss.n3477 vss.n3476 3.16551
R14862 vss.n3476 vss.n3464 3.16551
R14863 vss.n3462 vss.n3452 3.16551
R14864 vss.n3680 vss.n3497 3.16551
R14865 vss.n3490 vss.n3489 3.16551
R14866 vss.n3489 vss.n3426 3.16551
R14867 vss.n3435 vss.n3431 3.15029
R14868 vss.n3436 vss.n3435 3.15029
R14869 vss.n3481 vss.n3480 3.15029
R14870 vss.n3480 vss.n3479 3.15029
R14871 vss.n3473 vss.n3427 3.15029
R14872 vss.n3474 vss.n3473 3.15029
R14873 vss.n3459 vss.n3423 3.15029
R14874 vss.n3460 vss.n3459 3.15029
R14875 vss.n3419 vss.n3404 3.15029
R14876 vss.n3412 vss.n3404 3.15029
R14877 vss.n3453 vss.n3420 3.15029
R14878 vss.n3454 vss.n3453 3.15029
R14879 vss.n3466 vss.n3424 3.15029
R14880 vss.n3467 vss.n3466 3.15029
R14881 vss.n3586 vss.n3585 3.15029
R14882 vss.n3587 vss.n3586 3.15029
R14883 vss.n4526 vss.n4525 3.0667
R14884 vss.n4496 vss.n4495 3.0667
R14885 vss.n4496 vss.n4487 3.0667
R14886 vss.n4519 vss.n4518 3.0667
R14887 vss.n4519 vss.n4506 3.0667
R14888 vss.n5539 vss.t2062 2.92599
R14889 vss.n5015 vss.t2065 2.92598
R14890 vss.n3447 vss.n3431 2.91967
R14891 vss.n3437 vss.n3436 2.91967
R14892 vss.n3479 vss.n3478 2.91967
R14893 vss.n3475 vss.n3474 2.91967
R14894 vss.n3461 vss.n3460 2.91967
R14895 vss.n3413 vss.n3412 2.91967
R14896 vss.n3455 vss.n3454 2.91967
R14897 vss.n3468 vss.n3467 2.91967
R14898 vss.n3585 vss.n3584 2.91967
R14899 vss.n3588 vss.n3587 2.91967
R14900 vss.n3580 vss.n3577 2.91967
R14901 vss.n3576 vss.n3575 2.91967
R14902 vss.n3570 vss.n3569 2.91967
R14903 vss.n3572 vss.n3571 2.91967
R14904 vss.n3564 vss.n3563 2.91967
R14905 vss.n3566 vss.n3565 2.91967
R14906 vss.n3560 vss.n3557 2.91967
R14907 vss.n3556 vss.n3555 2.91967
R14908 vss.n3551 vss.n3548 2.91967
R14909 vss.n3547 vss.n3546 2.91967
R14910 vss.n5017 vss.t2064 2.9089
R14911 vss.n6019 vss.t2061 2.90844
R14912 vss.n2395 vss.n2394 2.89974
R14913 vss.t262 vss.n3267 2.85281
R14914 vss.n3334 vss.t262 2.85281
R14915 vss.n5179 vss.t1917 2.84758
R14916 vss.n5170 vss.t2092 2.84758
R14917 vss.n5178 vss.t1916 2.8454
R14918 vss.n5180 vss.t1919 2.8454
R14919 vss.n5171 vss.t2091 2.8454
R14920 vss.n5169 vss.t2095 2.8454
R14921 vss.n6367 vss.n2361 2.83383
R14922 vss.n5541 vss.n5535 2.81969
R14923 vss.n5489 vss.n5488 2.81891
R14924 vss.n6357 vss.n2399 2.80551
R14925 vss.n531 vss.n1855 2.77216
R14926 vss.n5507 vss.n5502 2.73102
R14927 vss.n3276 vss.t207 2.72502
R14928 vss.t638 vss.n4254 2.72142
R14929 vss.n6131 vss.n3187 2.72142
R14930 vss.n5513 vss.n5510 2.71798
R14931 vss.n2944 vss.n2700 2.65569
R14932 vss.n2874 vss.n2856 2.65569
R14933 vss.n3430 vss.n1473 2.65389
R14934 vss.n5241 vss.t422 2.61972
R14935 vss.n5220 vss.t413 2.61972
R14936 vss.n5239 vss.t420 2.61948
R14937 vss.n5216 vss.t380 2.61519
R14938 vss.n2898 vss.n2844 2.59238
R14939 vss.n2917 vss.n2916 2.59238
R14940 vss.n3259 vss.t531 2.56656
R14941 vss.n5019 vss.t179 2.56632
R14942 vss.n5027 vss.t171 2.56422
R14943 vss.n5026 vss.t173 2.56421
R14944 vss.n5028 vss.t168 2.56373
R14945 vss.n5025 vss.t175 2.56323
R14946 vss.n5020 vss.t177 2.56303
R14947 vss.n3325 vss.t1171 2.53589
R14948 vss.n836 vss.n6005 7.34731
R14949 vss.n835 vss.n5983 7.34731
R14950 vss.n834 vss.n5960 7.34731
R14951 vss.n833 vss.n5682 7.34731
R14952 vss.n832 vss.n5659 7.34731
R14953 vss.n3482 vss.n3481 2.5092
R14954 vss.n3488 vss.n3427 2.50738
R14955 vss.n3580 vss.n3579 2.46664
R14956 vss.n3575 vss.n3531 2.46664
R14957 vss.n6357 vss.n6356 2.39825
R14958 vss.n6357 vss.n2403 2.39739
R14959 vss.n6357 vss.n2416 2.39649
R14960 vss.n3365 vss.t49 2.37743
R14961 vss.n2915 vss.n2914 2.32425
R14962 vss.n2914 vss.n2913 2.32425
R14963 vss.n2913 vss.n2912 2.32425
R14964 vss.n2912 vss.n2911 2.32425
R14965 vss.n2911 vss.n2910 2.32425
R14966 vss.n2909 vss.n2908 2.32425
R14967 vss.n2908 vss.n2907 2.32425
R14968 vss.n2907 vss.n2906 2.32425
R14969 vss.n2906 vss.n2905 2.32425
R14970 vss.n2904 vss.n2903 2.32425
R14971 vss.n2903 vss.n2902 2.32425
R14972 vss.n2902 vss.n2901 2.32425
R14973 vss.n2901 vss.n2900 2.32425
R14974 vss.n2900 vss.n2899 2.32425
R14975 vss.t1543 vss.n1876 2.32248
R14976 vss.n5534 vss.n1022 2.29364
R14977 vss.n3439 vss.n3438 2.25344
R14978 vss.n3446 vss.n3445 2.25344
R14979 vss.n3415 vss.n3414 2.25344
R14980 vss.n3416 vss.n3406 2.25343
R14981 vss.n3255 vss.n1854 2.21897
R14982 vss.n3257 vss.n1726 2.21897
R14983 vss.n3267 vss.n1735 2.21897
R14984 vss.n3282 vss.n1829 2.21897
R14985 vss.n3299 vss.n1813 2.21897
R14986 vss.n3304 vss.n1770 2.21897
R14987 vss.n3315 vss.n1781 2.21897
R14988 vss.n3320 vss.n1793 2.21897
R14989 vss.n3321 vss.n1792 2.21897
R14990 vss.n3323 vss.n1790 2.21897
R14991 vss.n5503 vss.n5502 2.21664
R14992 vss.n287 vss.n2796 2.19991
R14993 vss.n287 vss.n2797 2.19991
R14994 vss.n287 vss.n2798 2.19991
R14995 vss.n287 vss.n2800 2.19991
R14996 vss.n287 vss.n2803 2.19991
R14997 vss.n287 vss.n2804 2.19991
R14998 vss.n287 vss.n2806 2.19991
R14999 vss.n287 vss.n2807 2.19991
R15000 vss.n267 vss.n2561 2.19991
R15001 vss.n267 vss.n2563 2.19991
R15002 vss.n267 vss.n2566 2.19991
R15003 vss.n267 vss.n2567 2.19991
R15004 vss.n267 vss.n2569 2.19991
R15005 vss.n267 vss.n2570 2.19991
R15006 vss.n267 vss.n2571 2.19991
R15007 vss.n267 vss.n2572 2.19991
R15008 vss.n267 vss.n2574 2.19991
R15009 vss.t30 vss.n771 2.17245
R15010 vss.t4 vss.n773 2.17245
R15011 vss.t385 vss.n760 2.17245
R15012 vss.t405 vss.n780 2.17245
R15013 vss.n753 vss.t219 2.17245
R15014 vss.t643 vss.n751 2.17245
R15015 vss.n3699 vss.n3698 2.16257
R15016 vss.n3693 vss.n3399 2.16257
R15017 vss.n6017 vss.n5486 2.1477
R15018 vss.n954 vss.n953 0.537761
R15019 vss.n4531 vss.n181 2.14328
R15020 vss.n3253 vss.t1190 2.10621
R15021 vss.t206 vss.t683 2.10621
R15022 vss.n3959 vss.n1471 2.09861
R15023 vss.n5323 vss.n5055 2.09861
R15024 vss.n3531 vss.t1170 2.08341
R15025 vss.n3579 vss.t1172 2.08341
R15026 vss.n5013 vss.t440 2.0696
R15027 vss.n5537 vss.t437 2.06938
R15028 vss.n5537 vss.t169 2.06868
R15029 vss.n5013 vss.t181 2.06831
R15030 vss.t531 vss.n1728 2.0605
R15031 vss.n3382 vss.t693 2.0605
R15032 vss.n6367 vss.n2376 2.04906
R15033 vss.n4505 vss.n961 1.98134
R15034 vss.n181 vss.n4470 1.98134
R15035 vss.n3465 vss.n3470 1.97919
R15036 vss.n3486 vss.n3484 1.97869
R15037 vss.t917 vss.t925 1.97418
R15038 vss.n1037 vss.n6018 0.579014
R15039 vss.n22 vss.n3702 0.880951
R15040 vss.n4 vss.n3422 9.68897
R15041 vss.n4 vss.n21 0.741151
R15042 vss.n3445 vss.n3444 1.96934
R15043 vss.n3444 vss.n3443 1.96934
R15044 vss.n3443 vss.n3442 1.96934
R15045 vss.n3442 vss.n3441 1.96934
R15046 vss.n3441 vss.n3440 1.96934
R15047 vss.n3440 vss.n3439 1.96934
R15048 vss.n3417 vss.n3416 1.96934
R15049 vss.n3417 vss.n3405 1.96934
R15050 vss.n3408 vss.n3405 1.96934
R15051 vss.n3409 vss.n3408 1.96934
R15052 vss.n3410 vss.n3409 1.96934
R15053 vss.n3415 vss.n3410 1.96934
R15054 vss.t207 vss.n1835 1.90204
R15055 vss.t57 vss.n3253 1.89564
R15056 vss.n364 vss.n2221 1.87437
R15057 vss.n364 vss.n2224 1.87437
R15058 vss.n364 vss.n2227 1.87437
R15059 vss.n364 vss.n2230 1.87437
R15060 vss.n364 vss.n2233 1.87437
R15061 vss.n4534 vss.n532 1.77157
R15062 vss.n487 vss.n5246 1.8517
R15063 vss.n2426 vss.n2379 1.84966
R15064 vss.n6357 vss.n2415 1.84701
R15065 vss.n6357 vss.n2420 1.84683
R15066 vss.n6357 vss.n2410 1.84668
R15067 vss.n5209 vss.n5177 1.82841
R15068 vss.n3452 vss.n3392 1.80303
R15069 vss.n3680 vss.n3679 1.80303
R15070 vss.n6261 vss.n2665 1.78829
R15071 vss.n3464 vss.n3463 1.75447
R15072 vss.n3463 vss.n3462 1.75447
R15073 vss.n3497 vss.n3422 1.75447
R15074 vss.n3490 vss.n3422 1.75447
R15075 vss.n3976 vss.n3959 1.75124
R15076 vss.n3977 vss.n3976 1.75124
R15077 vss.n3977 vss.n3943 1.75124
R15078 vss.n3923 vss.n3920 1.75124
R15079 vss.n3876 vss.n3875 1.75124
R15080 vss.n3875 vss.n3857 1.75124
R15081 vss.n3857 vss.n3750 1.75124
R15082 vss.n3832 vss.n3750 1.75124
R15083 vss.n3832 vss.n3831 1.75124
R15084 vss.n3831 vss.n3814 1.75124
R15085 vss.n3814 vss.n3797 1.75124
R15086 vss.n3797 vss.n2666 1.75124
R15087 vss.n6239 vss.n2666 1.75124
R15088 vss.n6260 vss.n6239 1.75124
R15089 vss.n6261 vss.n6260 1.75124
R15090 vss.n5324 vss.n5323 1.75124
R15091 vss.n5324 vss.n5046 1.75124
R15092 vss.n5046 vss.n2330 1.75124
R15093 vss.n6388 vss.n6377 1.75124
R15094 vss.n6389 vss.n2329 1.75124
R15095 vss.n2526 vss.n2329 1.75124
R15096 vss.n2526 vss.n2525 1.75124
R15097 vss.n2525 vss.n2516 1.75124
R15098 vss.n2516 vss.n2490 1.75124
R15099 vss.n2540 vss.n2490 1.75124
R15100 vss.n2541 vss.n2540 1.75124
R15101 vss.n2541 vss.n2472 1.75124
R15102 vss.n2554 vss.n2472 1.75124
R15103 vss.n2555 vss.n2554 1.75124
R15104 vss.n6304 vss.n2555 1.75124
R15105 vss.n3457 vss.t321 1.74205
R15106 vss.n2968 vss.n2967 1.74078
R15107 vss.n2968 vss.n2704 1.74078
R15108 vss.n3485 vss.t286 1.73964
R15109 vss.n3494 vss.t318 1.73943
R15110 vss.n3471 vss.t289 1.7392
R15111 vss.t313 vss.n3494 1.73527
R15112 vss.n3470 vss.t277 1.73523
R15113 vss.t315 vss.n3457 1.73349
R15114 vss.n3484 vss.t273 1.73333
R15115 vss.n4486 vss.n953 1.72775
R15116 vss.n1036 vss.n5016 1.72677
R15117 vss.n4373 vss.n4372 1.67185
R15118 vss.t976 vss.n2297 1.67088
R15119 vss.n3116 vss.t251 1.67088
R15120 vss.n3126 vss.t972 1.67088
R15121 vss.n3102 vss.n2282 1.67088
R15122 vss.n2999 vss.n2281 1.67088
R15123 vss.n3130 vss.n2280 1.67088
R15124 vss.n3100 vss.n2279 1.67088
R15125 vss.n3135 vss.n2278 1.67088
R15126 vss.n3000 vss.n2277 1.67088
R15127 vss.n3098 vss.n2276 1.67088
R15128 vss.n3099 vss.t470 1.67088
R15129 vss.n3137 vss.n2275 1.67088
R15130 vss.n3096 vss.n2274 1.67088
R15131 vss.n3001 vss.n2273 1.67088
R15132 vss.n3139 vss.n2272 1.67088
R15133 vss.n3093 vss.n2271 1.67088
R15134 vss.n3141 vss.n2270 1.67088
R15135 vss.n3002 vss.n2269 1.67088
R15136 vss.n3091 vss.n2268 1.67088
R15137 vss.n3146 vss.n2267 1.67088
R15138 vss.n3090 vss.t718 1.67088
R15139 vss.t375 vss.n2253 1.67088
R15140 vss.n3167 vss.t1028 1.67088
R15141 vss.t1034 vss.n2239 1.67088
R15142 vss.t566 vss.n2237 1.67088
R15143 vss.n6132 vss.t50 1.67088
R15144 vss.n3190 vss.t733 1.67088
R15145 vss.t1035 vss.n2214 1.67088
R15146 vss.t1019 vss.n3049 1.67088
R15147 vss.t868 vss.n3206 1.67088
R15148 vss.n6082 vss.t868 1.67088
R15149 vss.t511 vss.n3037 1.67088
R15150 vss.n6084 vss.t511 1.67088
R15151 vss.n3213 vss.t915 1.67088
R15152 vss.n6089 vss.n2186 1.67088
R15153 vss.n6056 vss.n2185 1.67088
R15154 vss.n6090 vss.n2184 1.67088
R15155 vss.n6055 vss.n2183 1.67088
R15156 vss.n6091 vss.n2182 1.67088
R15157 vss.n6054 vss.n2181 1.67088
R15158 vss.n6092 vss.n2180 1.67088
R15159 vss.n6053 vss.n2179 1.67088
R15160 vss.t2085 vss.n3027 1.67088
R15161 vss.n6093 vss.n2178 1.67088
R15162 vss.n6052 vss.n2177 1.67088
R15163 vss.n6094 vss.n2176 1.67088
R15164 vss.n6051 vss.n2175 1.67088
R15165 vss.n6095 vss.n2174 1.67088
R15166 vss.n6050 vss.n2173 1.67088
R15167 vss.n6096 vss.n2172 1.67088
R15168 vss.n6049 vss.n2171 1.67088
R15169 vss.n6042 vss.n2157 1.67088
R15170 vss.t605 vss.n2156 1.67088
R15171 vss.n529 vss.n631 1.40837
R15172 vss.n3493 vss.n3423 1.64519
R15173 vss.n3683 vss.n3419 1.64519
R15174 vss.n3682 vss.n3420 1.64519
R15175 vss.n3492 vss.n3424 1.64519
R15176 vss.n480 vss.n26 1.75483
R15177 vss.n5304 vss.n5087 1.62296
R15178 vss.n5224 vss.n5222 1.60271
R15179 vss.n5233 vss.n5232 1.60271
R15180 vss.n364 vss.n2138 1.59646
R15181 vss.n364 vss.n366 1.54784
R15182 vss.n2690 vss.n651 1.59123
R15183 vss.n3370 vss.t34 1.58512
R15184 vss.n191 vss.n190 3.00834
R15185 vss.n168 vss.n166 1.54595
R15186 vss.t283 vss.n3471 1.5213
R15187 vss.t281 vss.n3485 1.5213
R15188 vss.n6147 vss.n2979 1.51774
R15189 vss.n2979 vss.n2978 1.51774
R15190 vss.n2978 vss.n2977 1.51774
R15191 vss.n2977 vss.n2976 1.51774
R15192 vss.n2976 vss.n2973 1.51774
R15193 vss.n2973 vss.n2972 1.51774
R15194 vss.n2972 vss.n2971 1.51774
R15195 vss.n6150 vss.n6149 1.51774
R15196 vss.n6150 vss.n2975 1.51774
R15197 vss.n6154 vss.n2975 1.51774
R15198 vss.n6155 vss.n6154 1.51774
R15199 vss.n6156 vss.n6155 1.51774
R15200 vss.n6156 vss.n2970 1.51774
R15201 vss.n6160 vss.n2970 1.51774
R15202 vss.n6161 vss.n6160 1.51774
R15203 vss.n2949 vss.n268 1.50631
R15204 vss.n6144 vss.n6134 1.50582
R15205 vss.n5505 vss.n5504 1.49728
R15206 vss.n5487 vss.n26 1.49725
R15207 vss.n6357 vss.n2382 1.49302
R15208 vss.n2950 vss.n191 1.57677
R15209 vss.n3463 vss.n21 9.17884
R15210 vss.n22 vss.n4 0.740716
R15211 vss.n5530 vss.n85 1.4643
R15212 vss.n5529 vss.n5518 1.46381
R15213 vss.n17 vss.n4 0.339605
R15214 vss.n287 vss.n2769 1.46053
R15215 vss.n287 vss.n2775 1.46053
R15216 vss.n2746 vss.n267 1.45584
R15217 vss.n5550 vss.n5533 1.45157
R15218 vss.n2890 vss.n268 1.44755
R15219 vss.n5244 vss.t424 1.44153
R15220 vss.n5231 vss.t970 1.44153
R15221 vss.n5210 vss.t381 1.44153
R15222 vss.n5223 vss.t964 1.44132
R15223 vss.n5228 vss.t968 1.44132
R15224 vss.n5226 vss.t966 1.44095
R15225 vss.n5533 vss.n5532 1.43851
R15226 vss.n531 vss.n1865 1.43751
R15227 vss.n531 vss.n1868 1.43751
R15228 vss.n531 vss.n1871 1.43751
R15229 vss.n531 vss.n1874 1.43751
R15230 vss.n531 vss.n1877 1.43751
R15231 vss.n2746 vss.n190 1.42943
R15232 vss.t527 vss.n1846 1.42666
R15233 vss.n3387 vss.t39 1.42666
R15234 vss.n5487 vss.n85 1.42579
R15235 vss.n277 vss.n2746 1.42229
R15236 vss.n5506 vss.n5505 1.41667
R15237 vss.n4370 vss.n3995 1.41508
R15238 vss.n4520 vss 1.3947
R15239 vss.n4523 vss.n4521 1.37912
R15240 vss.n4524 vss.n4523 1.37912
R15241 vss.n3477 vss.n3451 1.36606
R15242 vss.n3449 vss.n3426 1.36606
R15243 vss.n6318 vss.n2379 1.36454
R15244 vss.n6320 vss.n2379 1.36415
R15245 vss.n6017 vss.n6016 1.35696
R15246 vss.n5499 vss.n5494 1.33662
R15247 vss.n5548 vss.n5547 1.33662
R15248 vss.n2890 vss.n277 1.33573
R15249 vss.n4517 vss.n4516 1.33216
R15250 vss.n5530 vss.n72 1.31987
R15251 vss.n5301 vss.n5290 1.30819
R15252 vss.n4494 vss.n162 1.38643
R15253 vss.n168 vss.n169 0.844853
R15254 vss.n5026 vss.n1028 1.27234
R15255 vss.n5027 vss.n1027 1.27046
R15256 vss.n0 vss.n1854 1.26819
R15257 vss.t272 vss.n1727 1.26819
R15258 vss.t212 vss.n1748 1.26819
R15259 vss.t267 vss.n1764 1.26819
R15260 vss.n4246 vss.n72 1.26652
R15261 vss.n1028 vss.n5025 1.26459
R15262 vss.n1031 vss.n5020 1.26252
R15263 vss.t780 vss.n905 1.261
R15264 vss.n2815 vss.t739 1.261
R15265 vss.n2748 vss.t1325 1.261
R15266 vss.n3450 vss.n3430 1.25811
R15267 vss.n4522 vss.n4327 1.25705
R15268 vss.n6392 vss.n2321 1.25213
R15269 vss.n6384 vss.n2319 1.25213
R15270 vss.n6384 vss.n6379 1.25213
R15271 vss.n6384 vss.n6382 1.25213
R15272 vss.n405 vss.n3891 1.25213
R15273 vss.n405 vss.n3890 1.25213
R15274 vss.n3906 vss.n407 1.25213
R15275 vss.n407 vss.n3902 1.25213
R15276 vss.n407 vss.n3900 1.25213
R15277 vss.n407 vss.n3880 1.25213
R15278 vss.n5028 vss.n1026 1.24962
R15279 vss.n6357 vss.n2422 1.24784
R15280 vss.n6357 vss.n2419 1.24707
R15281 vss.n6029 vss.n3995 1.24385
R15282 vss.n6027 vss.n3995 1.24385
R15283 vss.n1032 vss.n5019 1.24171
R15284 vss.n5231 vss.n5230 1.24087
R15285 vss.n5227 vss.n5226 1.24062
R15286 vss.n5223 vss.n5176 1.24046
R15287 vss.n5229 vss.n5228 1.24046
R15288 vss.n5600 vss.n185 1.23761
R15289 vss.n2884 vss.n2883 1.23731
R15290 vss.n2823 vss.n2822 1.23731
R15291 vss.n5190 vss.n5177 1.21845
R15292 vss.t638 vss.n4612 1.21711
R15293 vss.n6409 vss.n1460 1.21479
R15294 vss.n6409 vss.n1250 1.21479
R15295 vss.n6409 vss.n1310 1.21479
R15296 vss.n6409 vss.n1374 1.21479
R15297 vss.n5301 vss.n5099 1.21479
R15298 vss.n5020 vss.n1032 1.20859
R15299 vss.n4495 vss.n4494 1.20442
R15300 vss.n4518 vss.n4517 1.20442
R15301 vss.n1026 vss.n5027 1.20064
R15302 vss.n5542 vss.n1022 1.19871
R15303 vss.n1036 vss.n5011 1.19843
R15304 vss.n5025 vss.n1031 1.18774
R15305 vss.n1027 vss.n5026 1.17983
R15306 vss.n287 vss.n2745 1.15959
R15307 vss.n3955 vss.n373 1.153
R15308 vss.n373 vss.n3946 1.153
R15309 vss.n5320 vss.n5316 1.153
R15310 vss.n5320 vss.n5042 1.153
R15311 vss.n6410 vss.n6409 1.13383
R15312 vss.n3943 vss.n3923 1.12597
R15313 vss.n6377 vss.n2330 1.12597
R15314 vss.n6361 vss.n185 1.11588
R15315 vss.n5287 vss.t710 1.08647
R15316 vss.n86 vss.n4618 1.08641
R15317 vss.n86 vss.n4622 1.08641
R15318 vss.n4522 vss.n4339 1.08021
R15319 vss.n5549 vss.n1022 1.07714
R15320 vss.n5500 vss.n1022 1.07577
R15321 vss.n6339 vss.n2379 1.06717
R15322 vss.n5216 vss.n5215 1.04519
R15323 vss.n5017 vss.n1033 1.03196
R15324 vss.n160 vss.n960 1.13809
R15325 vss.n1025 vss.n6019 1.02551
R15326 vss.n6170 vss.n6169 1.02271
R15327 vss.n6145 vss.n3012 1.01501
R15328 vss.n2852 vss.n2851 1.01266
R15329 vss.n531 vss.n1880 1.00822
R15330 vss.n531 vss.n1883 1.00822
R15331 vss.n531 vss.n1894 1.00822
R15332 vss.n531 vss.n1897 1.00822
R15333 vss.n531 vss.n1900 1.00822
R15334 vss.n531 vss.n1903 1.00822
R15335 vss.n531 vss.n1906 1.00822
R15336 vss.n531 vss.n1917 1.00822
R15337 vss.n531 vss.n1920 1.00822
R15338 vss.n531 vss.n1923 1.00822
R15339 vss.n531 vss.n1926 1.00822
R15340 vss.n531 vss.n1929 1.00822
R15341 vss.n531 vss.n1940 1.00822
R15342 vss.n531 vss.n1943 1.00822
R15343 vss.n531 vss.n1946 1.00822
R15344 vss.n531 vss.n1949 1.00822
R15345 vss.n531 vss.n1952 1.00822
R15346 vss.n531 vss.n1963 1.00822
R15347 vss.n531 vss.n1966 1.00822
R15348 vss.n531 vss.n1969 1.00822
R15349 vss.n531 vss.n1972 1.00822
R15350 vss.n531 vss.n1975 1.00822
R15351 vss.n531 vss.n1986 1.00822
R15352 vss.n531 vss.n1989 1.00822
R15353 vss.n531 vss.n1992 1.00822
R15354 vss.n531 vss.n1995 1.00822
R15355 vss.n531 vss.n1998 1.00822
R15356 vss.n531 vss.n2009 1.00822
R15357 vss.n531 vss.n2012 1.00822
R15358 vss.n531 vss.n630 1.00822
R15359 vss.n4484 vss.n951 1.00465
R15360 vss.n543 vss.n183 1.27607
R15361 vss.n86 vss.n4191 1.00406
R15362 vss.n5301 vss.n5072 1.0005
R15363 vss.n86 vss.n77 0.983188
R15364 vss.n86 vss.n79 0.983188
R15365 vss.n86 vss.n80 0.983188
R15366 vss.n86 vss.n82 0.983188
R15367 vss.n86 vss.n83 0.983188
R15368 vss.n86 vss.n73 0.981239
R15369 vss.n86 vss.n75 0.981094
R15370 vss.n2962 vss.n2961 0.978106
R15371 vss.n2958 vss.n2957 0.978106
R15372 vss.n5266 vss.n3233 0.977986
R15373 vss.n86 vss.n81 0.972536
R15374 vss.n86 vss.n78 0.972535
R15375 vss.n86 vss.n74 0.972082
R15376 vss.n86 vss.n76 0.972022
R15377 vss.n2965 vss.n2964 0.971494
R15378 vss.n2955 vss.n2954 0.971494
R15379 vss.n5544 vss.n1022 0.969355
R15380 vss.n1036 vss.n1034 0.96862
R15381 vss.n3621 vss.n3620 0.9685
R15382 vss.n1025 vss.n6018 0.96649
R15383 vss.n5517 vss.n1033 0.958495
R15384 vss.t265 vss.n3282 0.951271
R15385 vss.t276 vss.n3321 0.951271
R15386 vss.t1169 vss.n1791 0.951271
R15387 vss.n5235 vss.n5234 0.947265
R15388 vss.n5214 vss.n5213 0.947265
R15389 vss.n5237 vss.n5236 0.946934
R15390 vss.n6412 vss.n1065 0.944944
R15391 vss.n6412 vss.n1111 0.944944
R15392 vss.n653 vss.n652 0.93099
R15393 vss.n2858 vss.n653 0.93049
R15394 vss.n2939 vss.n2931 0.93049
R15395 vss.n2939 vss.n2938 0.93049
R15396 vss.n2948 vss.n2947 0.93
R15397 vss.n2828 vss.n2827 0.93
R15398 vss.n2825 vss.n2824 0.93
R15399 vss.n2888 vss.n2887 0.93
R15400 vss.n2889 vss.n2888 0.93
R15401 vss.n2891 vss.n2877 0.93
R15402 vss.n4 vss.n1 0.298581
R15403 vss.n2942 vss.n2941 0.922078
R15404 vss.n654 vss.n2871 0.719838
R15405 vss.n739 vss.n742 25.7031
R15406 vss.n5301 vss.n5156 0.900121
R15407 vss.n5301 vss.n5146 0.900121
R15408 vss.n5301 vss.n5142 0.900121
R15409 vss.n5301 vss.n5128 0.900121
R15410 vss.n5301 vss.n5122 0.900121
R15411 vss.n5301 vss.n5118 0.900121
R15412 vss.n5301 vss.n5112 0.900121
R15413 vss.n6412 vss.n6411 0.895237
R15414 vss.n5515 vss.n5514 0.888831
R15415 vss.n3685 vss.n3684 0.888086
R15416 vss.n3690 vss.n3400 0.888086
R15417 vss.n5246 vss.n486 0.885621
R15418 vss.n5930 vss.t143 0.884415
R15419 vss.n5938 vss.t143 0.884415
R15420 vss.n5946 vss.t143 0.884415
R15421 vss.t143 vss.n5858 0.884415
R15422 vss.t143 vss.n5759 0.884415
R15423 vss.t143 vss.n5820 0.884415
R15424 vss.n3920 vss.n3876 0.882816
R15425 vss.n6389 vss.n6388 0.882816
R15426 vss.n486 vss.n5172 0.875598
R15427 vss.n6314 vss.n2379 0.867012
R15428 vss.n2895 vss.n2894 0.86675
R15429 vss.n2847 vss.n2846 0.86675
R15430 vss.n2832 vss.n2831 0.86675
R15431 vss.n2920 vss.n2919 0.86675
R15432 vss.n488 vss.n486 0.862153
R15433 vss.n5204 vss.n787 0.7318
R15434 vss.n86 vss.n65 0.853294
R15435 vss.n86 vss.n64 0.853294
R15436 vss.n86 vss.n63 0.853294
R15437 vss.n86 vss.n62 0.853294
R15438 vss.n86 vss.n61 0.853294
R15439 vss.n86 vss.n60 0.853294
R15440 vss.n86 vss.n59 0.853294
R15441 vss.n86 vss.n58 0.853294
R15442 vss.n86 vss.n57 0.853294
R15443 vss.n86 vss.n56 0.853294
R15444 vss.n86 vss.n55 0.853294
R15445 vss.n86 vss.n54 0.853294
R15446 vss.n86 vss.n53 0.853294
R15447 vss.n86 vss.n52 0.853294
R15448 vss.n86 vss.n51 0.853294
R15449 vss.n86 vss.n50 0.853294
R15450 vss.n86 vss.n49 0.853294
R15451 vss.n86 vss.n48 0.853294
R15452 vss.n86 vss.n47 0.853294
R15453 vss.n86 vss.n46 0.853294
R15454 vss.n86 vss.n45 0.853294
R15455 vss.n86 vss.n44 0.853294
R15456 vss.n86 vss.n43 0.853294
R15457 vss.n86 vss.n42 0.853294
R15458 vss.n86 vss.n41 0.853294
R15459 vss.n86 vss.n40 0.853294
R15460 vss.n86 vss.n39 0.853294
R15461 vss.n86 vss.n38 0.853294
R15462 vss.n86 vss.n37 0.853294
R15463 vss.n86 vss.n36 0.853294
R15464 vss.n86 vss.n35 0.853294
R15465 vss.n86 vss.n34 0.853294
R15466 vss.n86 vss.n33 0.853294
R15467 vss.n86 vss.n32 0.853294
R15468 vss.n86 vss.n31 0.853294
R15469 vss.n86 vss.n30 0.853294
R15470 vss.n86 vss.n29 0.853294
R15471 vss.n86 vss.n28 0.853294
R15472 vss.n6412 vss.n1051 0.8505
R15473 vss.n6412 vss.n1124 0.8505
R15474 vss.n3492 vss.n3491 0.850155
R15475 vss.n3496 vss.n3493 0.850155
R15476 vss.n3682 vss.n3681 0.850155
R15477 vss.n3683 vss.n3403 0.850155
R15478 vss.n3684 vss.n3402 0.850155
R15479 vss.n3676 vss.n3400 0.850155
R15480 vss.n5198 vss.n5197 0.842584
R15481 vss.n5931 vss.n5930 0.830459
R15482 vss.n5939 vss.n5938 0.830459
R15483 vss.n5947 vss.n5946 0.830459
R15484 vss.n5858 vss.n5857 0.830459
R15485 vss.n5831 vss.n5759 0.830459
R15486 vss.n5820 vss.n5819 0.830459
R15487 vss.n4487 vss.n951 0.822528
R15488 vss.n278 vss.n2747 0.810431
R15489 vss.n5930 vss.n5929 0.809765
R15490 vss.n5938 vss.n5937 0.809765
R15491 vss.n5946 vss.n5945 0.809765
R15492 vss.n5860 vss.n5858 0.809765
R15493 vss.n5759 vss.n5758 0.809765
R15494 vss.n5822 vss.n5820 0.809765
R15495 vss.n2868 vss.n2706 0.791055
R15496 vss.n2928 vss.n2706 0.791055
R15497 vss.n5518 vss.n5516 0.789986
R15498 vss.n4404 vss.n4345 0.787751
R15499 vss.n4404 vss.n4359 0.787751
R15500 vss.n4404 vss.n4377 0.787751
R15501 vss.n4506 vss.n960 0.786703
R15502 vss.n5199 vss.n5198 0.783314
R15503 vss.n5545 vss.n5544 0.777062
R15504 vss.n6145 vss.n6144 0.776789
R15505 vss.n5490 vss.n1034 0.775734
R15506 vss.n5492 vss.n1034 0.775239
R15507 vss.n5544 vss.n5543 0.774536
R15508 vss.n369 vss.n25 0.764545
R15509 vss.n5371 vss.n369 0.764545
R15510 vss.n5532 vss.n5500 0.757118
R15511 vss.n5550 vss.n5549 0.753472
R15512 vss.n2954 vss.n2953 0.752638
R15513 vss.n2965 vss.n2706 0.752638
R15514 vss.n2958 vss.n2953 0.751705
R15515 vss.n2961 vss.n2706 0.751705
R15516 vss.n3493 vss.n3492 0.7485
R15517 vss.n2916 vss.n2915 0.746438
R15518 vss.n2899 vss.n2898 0.746438
R15519 vss.n2910 vss.n2909 0.743
R15520 vss.n2905 vss.n2904 0.743
R15521 vss.n2941 vss.n2940 0.741129
R15522 vss.n5516 vss.n5508 0.7397
R15523 vss.n961 vss.n960 0.739127
R15524 vss.n6311 vss.n6306 0.7232
R15525 vss.n2883 vss.n2882 0.7155
R15526 vss.n2881 vss.n2880 0.7155
R15527 vss.n2879 vss.n2878 0.7155
R15528 vss.n2893 vss.n2892 0.7155
R15529 vss.n2896 vss.n2895 0.7155
R15530 vss.n2849 vss.n2848 0.7155
R15531 vss.n2846 vss.n2845 0.7155
R15532 vss.n2830 vss.n2829 0.7155
R15533 vss.n2833 vss.n2832 0.7155
R15534 vss.n2922 vss.n2921 0.7155
R15535 vss.n2919 vss.n2918 0.7155
R15536 vss.n2818 vss.n2817 0.7155
R15537 vss.n2820 vss.n2819 0.7155
R15538 vss.n2822 vss.n2821 0.7155
R15539 vss.n4257 vss.n81 0.713376
R15540 vss.n5303 vss.n5302 0.707928
R15541 vss.n2885 vss.n2881 0.705187
R15542 vss.n2888 vss.n2879 0.705187
R15543 vss.n2892 vss.n2891 0.705187
R15544 vss.n2877 vss.n2849 0.705187
R15545 vss.n2948 vss.n2829 0.705187
R15546 vss.n2947 vss.n2922 0.705187
R15547 vss.n2827 vss.n2818 0.705187
R15548 vss.n2824 vss.n2820 0.705187
R15549 vss.n4610 vss.n74 0.703687
R15550 vss.n5488 vss.n5011 0.703224
R15551 vss.n5542 vss.n5541 0.702412
R15552 vss.n4608 vss.n78 0.702251
R15553 vss.n5301 vss.n5269 0.699222
R15554 vss.n5301 vss.n5275 0.699222
R15555 vss.n5301 vss.n5277 0.699222
R15556 vss.n5543 vss.n5542 0.697453
R15557 vss.n5490 vss.n5011 0.696378
R15558 vss.n4608 vss.n76 0.692619
R15559 vss.n5515 vss.n5510 0.69256
R15560 vss.n4610 vss.n76 0.692044
R15561 vss.n5549 vss.n5548 0.688691
R15562 vss.n2894 vss.n2893 0.688
R15563 vss.n2897 vss.n2896 0.688
R15564 vss.n2848 vss.n2847 0.688
R15565 vss.n2845 vss.n2844 0.688
R15566 vss.n2842 vss.n2841 0.688
R15567 vss.n2840 vss.n2839 0.688
R15568 vss.n2838 vss.n2837 0.688
R15569 vss.n2836 vss.n2835 0.688
R15570 vss.n2831 vss.n2830 0.688
R15571 vss.n2834 vss.n2833 0.688
R15572 vss.n2921 vss.n2920 0.688
R15573 vss.n2918 vss.n2917 0.688
R15574 vss.n5500 vss.n5499 0.684498
R15575 vss.n4257 vss.n78 0.682471
R15576 vss.n10 vss.n74 0.681021
R15577 vss.n953 vss.n951 0.673797
R15578 vss.n543 vss.n4526 0.889635
R15579 vss.n4246 vss.n81 0.671294
R15580 vss.n3620 vss.n3499 0.668086
R15581 vss.n3645 vss.n3621 0.668086
R15582 vss.t1415 vss.n481 0.666899
R15583 vss.t1415 vss.n482 0.666899
R15584 vss.t521 vss.n799 0.666899
R15585 vss.t521 vss.n798 0.666899
R15586 vss.t55 vss.n805 0.666899
R15587 vss.t55 vss.n804 0.666899
R15588 vss.t224 vss.n811 0.666899
R15589 vss.t224 vss.n810 0.666899
R15590 vss.t796 vss.n817 0.666899
R15591 vss.t796 vss.n816 0.666899
R15592 vss.t823 vss.n824 0.666899
R15593 vss.t823 vss.n822 0.666899
R15594 vss.n2872 vss.n654 0.993314
R15595 vss.n2686 vss.n511 0.649813
R15596 vss.n2688 vss.n511 0.649813
R15597 vss.n3792 vss.n516 0.649813
R15598 vss.n516 vss.n515 0.649813
R15599 vss.n6234 vss.n521 0.649813
R15600 vss.n521 vss.n520 0.649813
R15601 vss.n5071 vss.n5067 0.649813
R15602 vss.n5069 vss.n5067 0.649813
R15603 vss.n2343 vss.n2317 0.649813
R15604 vss.n2344 vss.n2343 0.649813
R15605 vss.n849 vss.n848 0.649813
R15606 vss.n2534 vss.n854 0.649813
R15607 vss.n860 vss.n859 0.649813
R15608 vss.n866 vss.n865 0.649813
R15609 vss.n2505 vss.n870 0.649813
R15610 vss.n876 vss.n875 0.649813
R15611 vss.n2549 vss.n880 0.649813
R15612 vss.n2487 vss.n884 0.649813
R15613 vss.n890 vss.n889 0.649813
R15614 vss.n2600 vss.n894 0.649813
R15615 vss.n900 vss.n899 0.649813
R15616 vss.n6255 vss.n475 0.649813
R15617 vss.n475 vss.n474 0.649813
R15618 vss.n6277 vss.n470 0.649813
R15619 vss.n6279 vss.n470 0.649813
R15620 vss.n426 vss.n424 0.649813
R15621 vss.n24 vss.n421 0.649813
R15622 vss.n421 vss.n420 0.649813
R15623 vss.n3938 vss.n416 0.649813
R15624 vss.n416 vss.n415 0.649813
R15625 vss.n401 vss.n399 0.649813
R15626 vss.n396 vss.n394 0.649813
R15627 vss.n3852 vss.n391 0.649813
R15628 vss.n3835 vss.n387 0.649813
R15629 vss.n383 vss.n381 0.649813
R15630 vss.n378 vss.n376 0.649813
R15631 vss.n6325 vss.n2379 0.64383
R15632 vss.n4 vss.n16 9.68362
R15633 vss.n5238 vss.n5237 0.639047
R15634 vss.n5242 vss.n5234 0.638746
R15635 vss.n5221 vss.n5213 0.638746
R15636 vss.n5240 vss.n5239 0.636771
R15637 vss.n5241 vss.n5240 0.636433
R15638 vss.n5220 vss.n5219 0.636433
R15639 vss.t269 vss.n1800 0.634347
R15640 vss.n5218 vss.n5217 0.633389
R15641 vss.n6333 vss.n6332 0.633
R15642 vss.n6323 vss.n6322 0.633
R15643 vss.n5510 vss.n5509 0.63013
R15644 vss.n6121 vss.n6120 0.623153
R15645 vss.n6126 vss.n6125 0.623153
R15646 vss.n6137 vss.n6136 0.623153
R15647 vss.n6140 vss.n6139 0.623153
R15648 vss.n739 vss.n743 14.5258
R15649 vss.n5508 vss.n1470 0.619014
R15650 vss.n487 vss.n5174 0.61023
R15651 vss.n6335 vss.n2379 0.60976
R15652 vss.n6348 vss.n6346 0.6055
R15653 vss.n3430 vss.n1472 0.604655
R15654 vss.n1036 vss.n1025 0.600527
R15655 vss.n1036 vss.n1033 0.598877
R15656 vss.n3700 vss.n3393 0.586199
R15657 vss.n3678 vss.n3677 0.586199
R15658 vss.n6329 vss.n2379 0.578028
R15659 vss.n6346 vss.n6344 0.578
R15660 vss.n6337 vss.n2379 0.577845
R15661 vss.n4505 vss.n4504 0.572901
R15662 vss.n5198 vss.n488 0.566931
R15663 vss.n5203 vss.n787 0.821781
R15664 vss.n4487 vss.n4486 0.56063
R15665 vss.n531 vss.n524 0.558648
R15666 vss.n17 vss.n3544 9.3968
R15667 vss.n3589 vss.n3527 0.555854
R15668 vss.n3537 vss.n3532 0.555854
R15669 vss.n3561 vss.n3553 0.555854
R15670 vss.n3583 vss.n3582 0.555854
R15671 vss.n6350 vss.n6348 0.5505
R15672 vss.n6352 vss.n6350 0.5505
R15673 vss.n6353 vss.n6352 0.5505
R15674 vss.n6353 vss.n6341 0.5505
R15675 vss.n6341 vss.n2427 0.5505
R15676 vss.n6333 vss.n2427 0.5505
R15677 vss.n6332 vss.n2429 0.5505
R15678 vss.n6323 vss.n2429 0.5505
R15679 vss.n6322 vss.n6313 0.5505
R15680 vss.n5517 vss.n5016 0.544728
R15681 vss.n364 vss.n360 0.544544
R15682 vss.n364 vss.n359 0.544544
R15683 vss.n364 vss.n358 0.544544
R15684 vss.n364 vss.n357 0.544544
R15685 vss.n364 vss.n356 0.544544
R15686 vss.n364 vss.n355 0.544544
R15687 vss.n364 vss.n354 0.544544
R15688 vss.n364 vss.n353 0.544544
R15689 vss.n364 vss.n352 0.544544
R15690 vss.n364 vss.n351 0.544544
R15691 vss.n364 vss.n350 0.544544
R15692 vss.n364 vss.n349 0.544544
R15693 vss.n364 vss.n348 0.544544
R15694 vss.n364 vss.n347 0.544544
R15695 vss.n364 vss.n346 0.544544
R15696 vss.n364 vss.n345 0.544544
R15697 vss.n364 vss.n344 0.544544
R15698 vss.n364 vss.n343 0.544544
R15699 vss.n364 vss.n342 0.544544
R15700 vss.n364 vss.n341 0.544544
R15701 vss.n364 vss.n340 0.544544
R15702 vss.n364 vss.n339 0.544544
R15703 vss.n364 vss.n338 0.544544
R15704 vss.n364 vss.n337 0.544544
R15705 vss.n364 vss.n336 0.544544
R15706 vss.n364 vss.n335 0.544544
R15707 vss.n364 vss.n334 0.544544
R15708 vss.n364 vss.n333 0.544544
R15709 vss.n364 vss.n332 0.544544
R15710 vss.n364 vss.n331 0.544544
R15711 vss.n364 vss.n330 0.544544
R15712 vss.n364 vss.n329 0.544544
R15713 vss.n364 vss.n328 0.544544
R15714 vss.n364 vss.n327 0.544544
R15715 vss.n364 vss.n326 0.544544
R15716 vss.n364 vss.n325 0.544544
R15717 vss.n364 vss.n324 0.544544
R15718 vss.n364 vss.n323 0.544544
R15719 vss.n364 vss.n322 0.544544
R15720 vss.n364 vss.n321 0.544544
R15721 vss.n364 vss.n320 0.544544
R15722 vss.n364 vss.n319 0.544544
R15723 vss.n364 vss.n318 0.544544
R15724 vss.n364 vss.n317 0.544544
R15725 vss.n364 vss.n316 0.544544
R15726 vss.n364 vss.n315 0.544544
R15727 vss.n364 vss.n314 0.544544
R15728 vss.n364 vss.n313 0.544544
R15729 vss.n364 vss.n312 0.544544
R15730 vss.n364 vss.n311 0.544544
R15731 vss.n364 vss.n310 0.544544
R15732 vss.n364 vss.n309 0.544544
R15733 vss.n364 vss.n308 0.544544
R15734 vss.n364 vss.n307 0.544544
R15735 vss.n364 vss.n306 0.544544
R15736 vss.n364 vss.n305 0.544544
R15737 vss.n364 vss.n304 0.544544
R15738 vss.n364 vss.n303 0.544544
R15739 vss.n364 vss.n302 0.544544
R15740 vss.n364 vss.n301 0.544544
R15741 vss.n364 vss.n300 0.544544
R15742 vss.n364 vss.n299 0.544544
R15743 vss.n364 vss.n298 0.544544
R15744 vss.n364 vss.n297 0.544544
R15745 vss.n364 vss.n296 0.544544
R15746 vss.n364 vss.n295 0.544544
R15747 vss.n364 vss.n294 0.544544
R15748 vss.n364 vss.n293 0.544544
R15749 vss.n364 vss.n292 0.544544
R15750 vss.n364 vss.n291 0.544544
R15751 vss.n364 vss.n290 0.544544
R15752 vss.n364 vss.n289 0.544544
R15753 vss.n267 vss.n266 0.544544
R15754 vss.n267 vss.n265 0.544544
R15755 vss.n267 vss.n264 0.544544
R15756 vss.n267 vss.n263 0.544544
R15757 vss.n267 vss.n262 0.544544
R15758 vss.n267 vss.n261 0.544544
R15759 vss.n267 vss.n260 0.544544
R15760 vss.n267 vss.n259 0.544544
R15761 vss.n267 vss.n258 0.544544
R15762 vss.n267 vss.n257 0.544544
R15763 vss.n267 vss.n256 0.544544
R15764 vss.n267 vss.n255 0.544544
R15765 vss.n267 vss.n254 0.544544
R15766 vss.n267 vss.n253 0.544544
R15767 vss.n267 vss.n252 0.544544
R15768 vss.n267 vss.n251 0.544544
R15769 vss.n267 vss.n250 0.544544
R15770 vss.n267 vss.n249 0.544544
R15771 vss.n267 vss.n248 0.544544
R15772 vss.n267 vss.n247 0.544544
R15773 vss.n267 vss.n246 0.544544
R15774 vss.n267 vss.n245 0.544544
R15775 vss.n267 vss.n244 0.544544
R15776 vss.n267 vss.n243 0.544544
R15777 vss.n267 vss.n242 0.544544
R15778 vss.n267 vss.n241 0.544544
R15779 vss.n267 vss.n240 0.544544
R15780 vss.n267 vss.n239 0.544544
R15781 vss.n267 vss.n238 0.544544
R15782 vss.n267 vss.n237 0.544544
R15783 vss.n267 vss.n236 0.544544
R15784 vss.n267 vss.n235 0.544544
R15785 vss.n267 vss.n234 0.544544
R15786 vss.n267 vss.n233 0.544544
R15787 vss.n267 vss.n232 0.544544
R15788 vss.n267 vss.n231 0.544544
R15789 vss.n267 vss.n230 0.544544
R15790 vss.n267 vss.n229 0.544544
R15791 vss.n267 vss.n228 0.544544
R15792 vss.n267 vss.n227 0.544544
R15793 vss.n267 vss.n226 0.544544
R15794 vss.n267 vss.n225 0.544544
R15795 vss.n267 vss.n224 0.544544
R15796 vss.n267 vss.n223 0.544544
R15797 vss.n267 vss.n222 0.544544
R15798 vss.n267 vss.n221 0.544544
R15799 vss.n267 vss.n220 0.544544
R15800 vss.n267 vss.n219 0.544544
R15801 vss.n267 vss.n218 0.544544
R15802 vss.n267 vss.n217 0.544544
R15803 vss.n267 vss.n216 0.544544
R15804 vss.n267 vss.n215 0.544544
R15805 vss.n267 vss.n214 0.544544
R15806 vss.n267 vss.n213 0.544544
R15807 vss.n267 vss.n212 0.544544
R15808 vss.n267 vss.n211 0.544544
R15809 vss.n267 vss.n210 0.544544
R15810 vss.n267 vss.n209 0.544544
R15811 vss.n267 vss.n208 0.544544
R15812 vss.n267 vss.n207 0.544544
R15813 vss.n267 vss.n206 0.544544
R15814 vss.n267 vss.n205 0.544544
R15815 vss.n267 vss.n204 0.544544
R15816 vss.n267 vss.n203 0.544544
R15817 vss.n267 vss.n202 0.544544
R15818 vss.n267 vss.n201 0.544544
R15819 vss.n267 vss.n200 0.544544
R15820 vss.n267 vss.n199 0.544544
R15821 vss.n267 vss.n198 0.544544
R15822 vss.n267 vss.n197 0.544544
R15823 vss.n267 vss.n196 0.544544
R15824 vss.n267 vss.n195 0.544544
R15825 vss.n1411 vss.t889 0.543486
R15826 vss.n1281 vss.t620 0.543486
R15827 vss.n1418 vss.t182 0.543486
R15828 vss.n5219 vss.n5218 0.539061
R15829 vss.n5225 vss.n5224 0.534569
R15830 vss.n5225 vss.n5175 0.534569
R15831 vss.n5232 vss.n5175 0.534569
R15832 vss.n957 vss.n955 0.533072
R15833 vss.n2826 vss.n2825 0.532625
R15834 vss.n2886 vss.n2885 0.532625
R15835 vss.n6166 vss.n6165 0.528522
R15836 vss.n2855 vss.n2702 0.528522
R15837 vss.n4612 vss.n4611 0.526463
R15838 vss.n5217 vss.n5216 0.522209
R15839 vss.n5242 vss.n5241 0.517842
R15840 vss.n5221 vss.n5220 0.517842
R15841 vss.n5239 vss.n5238 0.517478
R15842 vss.n2851 vss.n2695 0.515351
R15843 vss.n6171 vss.n6170 0.514592
R15844 vss.n4612 vss.n4609 0.51226
R15845 vss.n4526 vss.n4470 0.508122
R15846 vss.n4506 vss.n4505 0.508122
R15847 vss.n2949 vss.n2948 0.502375
R15848 vss.n2891 vss.n2890 0.502375
R15849 vss.n2428 vss.n2379 0.495445
R15850 vss.n5513 vss.n5512 0.480098
R15851 vss.n2941 vss.n2939 0.475217
R15852 vss.n432 vss.n431 0.0142276
R15853 vss.n434 vss.n429 0.0142276
R15854 vss.n436 vss.n433 0.0142276
R15855 vss.n435 vss.n442 0.474771
R15856 vss.n435 vss.n445 0.474771
R15857 vss.n435 vss.n447 0.474771
R15858 vss.n22 vss.n3701 9.17884
R15859 vss.n21 vss.n3726 0.881018
R15860 vss.n3534 vss.n4 9.69033
R15861 vss.n4371 vss.n4370 0.468426
R15862 vss.n844 vss.n843 0.464019
R15863 vss.n6031 vss.n411 0.464019
R15864 vss.n6033 vss.n411 0.464019
R15865 vss.n740 vss.n739 0.461291
R15866 vss.n3465 vss.t283 0.454785
R15867 vss.t281 vss.n3486 0.454667
R15868 vss.n4602 vss.n4339 0.451592
R15869 vss.n1438 vss.n1437 0.444731
R15870 vss.n5539 vss.n1037 0.346649
R15871 vss.n5548 vss.n5534 0.43832
R15872 vss.n6210 vss.n493 0.554009
R15873 vss.n5545 vss.n5534 0.430971
R15874 vss.n2949 vss.n2828 0.428125
R15875 vss.n2890 vss.n2889 0.428125
R15876 vss.n6367 vss.n2370 0.420725
R15877 vss.n5312 vss.n839 0.413964
R15878 vss.n6178 vss.n6171 0.413839
R15879 vss.n6177 vss.n6171 0.413839
R15880 vss.n6176 vss.n6171 0.413839
R15881 vss.n6175 vss.n6171 0.413839
R15882 vss.n6174 vss.n6171 0.413839
R15883 vss.n6186 vss.n2695 0.413839
R15884 vss.n6185 vss.n2695 0.413839
R15885 vss.n6184 vss.n2695 0.413839
R15886 vss.n6183 vss.n2695 0.413839
R15887 vss.n6182 vss.n2695 0.413839
R15888 vss.n5313 vss.n839 0.413464
R15889 vss.n3590 vss.n3589 0.410199
R15890 vss.n3583 vss.n3498 0.410199
R15891 vss.n3574 vss.n3573 0.40413
R15892 vss.n3573 vss.n3567 0.40413
R15893 vss.n3567 vss.n3532 0.40413
R15894 vss.n3562 vss.n3561 0.40413
R15895 vss.n3562 vss.n3530 0.40413
R15896 vss.n3581 vss.n3530 0.40413
R15897 vss.n2827 vss.n2826 0.397875
R15898 vss.n2824 vss.n2823 0.397875
R15899 vss.n2885 vss.n2884 0.397875
R15900 vss.n2887 vss.n2886 0.397875
R15901 vss.n3701 vss.n3392 0.388957
R15902 vss.n3679 vss.n16 0.388957
R15903 vss.n3401 vss.n3395 0.388914
R15904 vss.n3692 vss.n3691 0.388914
R15905 vss.n3619 vss.n3618 0.388914
R15906 vss.n3592 vss.n3500 0.388914
R15907 vss.n5016 vss.n5015 0.388771
R15908 vss.n5088 vss.n5087 0.387971
R15909 vss.n6401 vss.n1475 0.387237
R15910 vss.n3449 vss.n3448 0.385923
R15911 vss.n3451 vss.n3429 0.385923
R15912 vss.n3683 vss.n3682 0.384557
R15913 vss.n6211 vss.n6210 0.371673
R15914 vss.n6334 vss.n2428 0.368314
R15915 vss.n3540 vss.n3539 0.367716
R15916 vss.n6330 vss.n2428 0.366079
R15917 vss.n5507 vss.n5506 0.358241
R15918 vss.n4254 vss.n4253 0.354092
R15919 vss.n4409 vss.n4340 0.351125
R15920 vss.n4373 vss.n4369 0.351125
R15921 vss.n4379 vss.n4378 0.351125
R15922 vss.n4388 vss.n4387 0.351125
R15923 vss.n4398 vss.n4397 0.351125
R15924 vss.n4406 vss.n4341 0.351125
R15925 vss.n3525 vss.n3393 0.349509
R15926 vss.n3677 vss.n3671 0.349509
R15927 vss.n968 vss.n966 0.346828
R15928 vss.n957 vss.n956 0.346828
R15929 vss.n5179 vss.n5178 0.3455
R15930 vss.n5180 vss.n5179 0.3455
R15931 vss.n5171 vss.n5170 0.3455
R15932 vss.n5170 vss.n5169 0.3455
R15933 vss.n3187 vss.n3185 0.345342
R15934 vss.n3187 vss.n3186 0.343611
R15935 vss.n4409 vss.n4408 0.340149
R15936 vss.n6331 vss.n6329 0.336115
R15937 vss.n4408 vss.n4407 0.333022
R15938 vss.n6336 vss.n6335 0.331936
R15939 vss.n6337 vss.n6336 0.331604
R15940 vss.n5514 vss.n5513 0.329562
R15941 vss.n6305 vss.n1474 0.329033
R15942 vss.n6403 vss.n1473 0.329033
R15943 vss.n6335 vss.n6334 0.328472
R15944 vss.n5493 vss.n5491 0.327638
R15945 vss.n5546 vss.n5536 0.327638
R15946 vss.n1022 vss.n4804 0.327594
R15947 vss.n4258 vss.n4254 0.327361
R15948 vss.n6340 vss.n6337 0.323582
R15949 vss.n6314 vss.n2381 0.320838
R15950 vss.n6329 vss.n6328 0.319047
R15951 vss.n5934 vss.n5933 0.318945
R15952 vss.n5942 vss.n5941 0.318945
R15953 vss.n5738 vss.n5737 0.318945
R15954 vss.n5846 vss.n5845 0.318945
R15955 vss.n5830 vss.n5770 0.318945
R15956 vss.n6404 vss.n1472 0.316374
R15957 vss.n6326 vss.n6325 0.313621
R15958 vss.n3545 vss.n3544 0.313095
R15959 vss.n3552 vss.n3534 0.313095
R15960 vss.n5497 vss.n5010 0.310423
R15961 vss.n4536 vss.n18 1.58131
R15962 vss.n4539 vss.n90 0.431656
R15963 vss.n4542 vss.n92 0.431656
R15964 vss.n4545 vss.n94 0.431656
R15965 vss.n4548 vss.n96 0.431656
R15966 vss.n4551 vss.n98 0.431656
R15967 vss.n4554 vss.n100 0.431656
R15968 vss.n4557 vss.n541 0.431656
R15969 vss.n4560 vss.n104 0.431656
R15970 vss.n4563 vss.n106 0.431656
R15971 vss.n4566 vss.n108 0.431656
R15972 vss.n4569 vss.n110 0.431656
R15973 vss.n4572 vss.n112 0.431656
R15974 vss.n4575 vss.n114 0.431656
R15975 vss.n4578 vss.n538 0.431656
R15976 vss.n4581 vss.n118 0.431656
R15977 vss.n4584 vss.n120 0.431656
R15978 vss.n4587 vss.n122 0.431656
R15979 vss.n4590 vss.n124 0.431656
R15980 vss.n4593 vss.n126 0.431656
R15981 vss.n4596 vss.n128 0.431656
R15982 vss.n535 vss.n4535 0.431656
R15983 vss.n6194 vss.n508 0.431656
R15984 vss.n6197 vss.n6196 0.310423
R15985 vss.n6200 vss.n504 0.431656
R15986 vss.n6203 vss.n500 0.431656
R15987 vss.n6204 vss.n498 0.431656
R15988 vss.n6212 vss.n179 0.548757
R15989 vss.n6214 vss.n491 0.431656
R15990 vss.n6215 vss.n175 0.548757
R15991 vss.n6217 vss.n173 0.548757
R15992 vss.n6219 vss.n2692 0.310423
R15993 vss.n3730 vss.n144 0.431656
R15994 vss.n3733 vss.n146 0.431656
R15995 vss.n3736 vss.n148 0.431656
R15996 vss.n3738 vss.n3737 0.310423
R15997 vss.n3741 vss.n150 0.431656
R15998 vss.n3744 vss.n152 0.431656
R15999 vss.n7 vss.n3702 1.48507
R16000 vss.n3708 vss.n132 0.431656
R16001 vss.n3711 vss.n134 0.431656
R16002 vss.n3714 vss.n136 0.431656
R16003 vss.n3716 vss.n3715 0.310423
R16004 vss.n3719 vss.n138 0.431656
R16005 vss.n3722 vss.n140 0.431656
R16006 vss.n6193 vss.n634 0.432818
R16007 vss.n6196 vss.n637 0.432818
R16008 vss.n6199 vss.n640 0.432818
R16009 vss.n6202 vss.n643 0.432818
R16010 vss.n6209 vss.n646 0.432818
R16011 vss.n493 vss.n495 0.614346
R16012 vss.n6219 vss.n650 0.432818
R16013 vss.n4171 vss.n4170 0.310083
R16014 vss.n3737 vss.n3736 0.310083
R16015 vss.n3715 vss.n3714 0.310083
R16016 vss.n10 vss.n4412 0.3085
R16017 vss.n4611 vss.n4610 0.3085
R16018 vss.n4609 vss.n4608 0.3085
R16019 vss.n6325 vss.n6324 0.304696
R16020 vss.n5279 vss.n5264 0.304549
R16021 vss.n5274 vss.n5273 0.304549
R16022 vss.n3133 vss.n3095 0.303933
R16023 vss.n5299 vss.n5297 0.303618
R16024 vss.n5973 vss.n806 0.319558
R16025 vss.n5693 vss.n812 0.319558
R16026 vss.n5672 vss.n818 0.319558
R16027 vss.n5649 vss.n825 0.319558
R16028 vss.n485 vss.n5558 0.315603
R16029 vss.n5974 vss.n5566 0.300775
R16030 vss.n5951 vss.n5574 0.300775
R16031 vss.n5673 vss.n5583 0.300775
R16032 vss.n5650 vss.n5591 0.300775
R16033 vss.n6002 vss.n6001 0.299511
R16034 vss.n5980 vss.n5979 0.299511
R16035 vss.n5679 vss.n5678 0.299511
R16036 vss.n5656 vss.n5655 0.299511
R16037 vss.n3674 vss.n3673 0.296654
R16038 vss.n3397 vss.n3396 0.296654
R16039 vss.n3696 vss.n3695 0.296654
R16040 vss.n3688 vss.n3687 0.296654
R16041 vss.n3643 vss.n3642 0.296654
R16042 vss.n3642 vss.n3641 0.296654
R16043 vss.n3641 vss.n3640 0.296654
R16044 vss.n3640 vss.n3639 0.296654
R16045 vss.n3639 vss.n3638 0.296654
R16046 vss.n3638 vss.n3637 0.296654
R16047 vss.n3637 vss.n3636 0.296654
R16048 vss.n3636 vss.n3635 0.296654
R16049 vss.n3635 vss.n3634 0.296654
R16050 vss.n3634 vss.n3633 0.296654
R16051 vss.n3633 vss.n3632 0.296654
R16052 vss.n3632 vss.n3631 0.296654
R16053 vss.n3631 vss.n3630 0.296654
R16054 vss.n3630 vss.n3629 0.296654
R16055 vss.n3629 vss.n3628 0.296654
R16056 vss.n3628 vss.n3627 0.296654
R16057 vss.n3627 vss.n3626 0.296654
R16058 vss.n3626 vss.n3625 0.296654
R16059 vss.n3625 vss.n3624 0.296654
R16060 vss.n3624 vss.n3623 0.296654
R16061 vss.n3649 vss.n3648 0.296654
R16062 vss.n3650 vss.n3649 0.296654
R16063 vss.n3651 vss.n3650 0.296654
R16064 vss.n3652 vss.n3651 0.296654
R16065 vss.n3653 vss.n3652 0.296654
R16066 vss.n3654 vss.n3653 0.296654
R16067 vss.n3655 vss.n3654 0.296654
R16068 vss.n3656 vss.n3655 0.296654
R16069 vss.n3657 vss.n3656 0.296654
R16070 vss.n3658 vss.n3657 0.296654
R16071 vss.n3659 vss.n3658 0.296654
R16072 vss.n3660 vss.n3659 0.296654
R16073 vss.n3661 vss.n3660 0.296654
R16074 vss.n3662 vss.n3661 0.296654
R16075 vss.n3663 vss.n3662 0.296654
R16076 vss.n3664 vss.n3663 0.296654
R16077 vss.n3665 vss.n3664 0.296654
R16078 vss.n3666 vss.n3665 0.296654
R16079 vss.n3667 vss.n3666 0.296654
R16080 vss.n3668 vss.n3667 0.296654
R16081 vss.n3523 vss.n3522 0.296654
R16082 vss.n3522 vss.n3521 0.296654
R16083 vss.n3521 vss.n3520 0.296654
R16084 vss.n3520 vss.n3519 0.296654
R16085 vss.n3519 vss.n3518 0.296654
R16086 vss.n3518 vss.n3517 0.296654
R16087 vss.n3517 vss.n3516 0.296654
R16088 vss.n3516 vss.n3515 0.296654
R16089 vss.n3515 vss.n3514 0.296654
R16090 vss.n3514 vss.n3513 0.296654
R16091 vss.n3513 vss.n3512 0.296654
R16092 vss.n3512 vss.n3511 0.296654
R16093 vss.n3511 vss.n3510 0.296654
R16094 vss.n3510 vss.n3509 0.296654
R16095 vss.n3509 vss.n3508 0.296654
R16096 vss.n3508 vss.n3507 0.296654
R16097 vss.n3507 vss.n3506 0.296654
R16098 vss.n3506 vss.n3505 0.296654
R16099 vss.n3505 vss.n3504 0.296654
R16100 vss.n3504 vss.n3503 0.296654
R16101 vss.n3596 vss.n3595 0.296654
R16102 vss.n3597 vss.n3596 0.296654
R16103 vss.n3598 vss.n3597 0.296654
R16104 vss.n3599 vss.n3598 0.296654
R16105 vss.n3600 vss.n3599 0.296654
R16106 vss.n3601 vss.n3600 0.296654
R16107 vss.n3602 vss.n3601 0.296654
R16108 vss.n3603 vss.n3602 0.296654
R16109 vss.n3604 vss.n3603 0.296654
R16110 vss.n3605 vss.n3604 0.296654
R16111 vss.n3606 vss.n3605 0.296654
R16112 vss.n3607 vss.n3606 0.296654
R16113 vss.n3608 vss.n3607 0.296654
R16114 vss.n3609 vss.n3608 0.296654
R16115 vss.n3610 vss.n3609 0.296654
R16116 vss.n3611 vss.n3610 0.296654
R16117 vss.n3612 vss.n3611 0.296654
R16118 vss.n3613 vss.n3612 0.296654
R16119 vss.n3614 vss.n3613 0.296654
R16120 vss.n3615 vss.n3614 0.296654
R16121 vss.n5158 vss.n5157 0.293299
R16122 vss.n4263 vss.n4260 0.288261
R16123 vss.n6405 vss.n1471 0.28704
R16124 vss.n5055 vss.n5048 0.28704
R16125 vss.n3143 vss.n3095 0.286445
R16126 vss.n3440 vss.n3434 0.284593
R16127 vss.n3442 vss.n3433 0.284593
R16128 vss.n3444 vss.n3432 0.284593
R16129 vss.n3418 vss.n3417 0.284593
R16130 vss.n3408 vss.n3407 0.284593
R16131 vss.n3411 vss.n3410 0.284593
R16132 vss.n5159 vss.n5158 0.282058
R16133 vss.n5949 vss.n5948 0.28028
R16134 vss.n5933 vss.n5932 0.277683
R16135 vss.n5941 vss.n5940 0.277683
R16136 vss.n5845 vss.n5750 0.277683
R16137 vss.n5832 vss.n5830 0.277683
R16138 vss.n5807 vss.n5782 0.277683
R16139 vss.n5986 vss.n5985 0.277683
R16140 vss.n5963 vss.n5962 0.277683
R16141 vss.n5685 vss.n5684 0.277683
R16142 vss.n5662 vss.n5661 0.277683
R16143 vss.n5639 vss.n5638 0.277683
R16144 vss.n4484 vss.n542 0.384502
R16145 vss.n4486 vss.n542 0.780632
R16146 vss.n4516 vss.n158 0.385347
R16147 vss.n160 vss.n963 0.384088
R16148 vss.n5932 vss.n5931 0.275195
R16149 vss.n5940 vss.n5939 0.275195
R16150 vss.n5857 vss.n5750 0.275195
R16151 vss.n5832 vss.n5831 0.275195
R16152 vss.n5819 vss.n5782 0.275195
R16153 vss.n5991 vss.n5986 0.275195
R16154 vss.n5968 vss.n5963 0.275195
R16155 vss.n5690 vss.n5685 0.275195
R16156 vss.n5667 vss.n5662 0.275195
R16157 vss.n5644 vss.n5639 0.275195
R16158 vss.n5264 vss.n5263 0.273308
R16159 vss.n5278 vss.n5274 0.273308
R16160 vss.n1036 vss.n1028 0.270477
R16161 vss.n6315 vss.n6314 0.270221
R16162 vss.n2898 vss.n2897 0.268625
R16163 vss.n2905 vss.n2843 0.268625
R16164 vss.n2906 vss.n2842 0.268625
R16165 vss.n2907 vss.n2840 0.268625
R16166 vss.n2908 vss.n2838 0.268625
R16167 vss.n2909 vss.n2836 0.268625
R16168 vss.n2916 vss.n2834 0.268625
R16169 vss.n5212 vss.n5211 0.267534
R16170 vss.n5222 vss.n5212 0.267534
R16171 vss.n5243 vss.n5233 0.267534
R16172 vss.n5245 vss.n5243 0.267534
R16173 vss.n4517 vss.n968 0.266234
R16174 vss.n4494 vss.n957 0.266234
R16175 vss.n4525 vss.n169 3.19891
R16176 vss.n5205 vss.n738 0.330894
R16177 vss.n731 vss.n5205 0.395701
R16178 vss.n5206 vss.n731 0.395701
R16179 vss.n5207 vss.n5206 0.26499
R16180 vss.n5208 vss.n5207 0.26499
R16181 vss.n5280 vss.n5278 0.264761
R16182 vss.n2964 vss.n2963 0.263465
R16183 vss.n2956 vss.n2955 0.263465
R16184 vss.n4602 vss.n4327 0.263104
R16185 vss.n2963 vss.n2962 0.262691
R16186 vss.n2957 vss.n2956 0.262691
R16187 vss.n4611 vss.n4275 0.262394
R16188 vss.n4259 vss.n4257 0.2601
R16189 vss.n4247 vss.n4246 0.2601
R16190 vss.n5297 vss.n5296 0.259246
R16191 vss.n3673 vss.n3672 0.258093
R16192 vss.n3675 vss.n3674 0.258093
R16193 vss.n3396 vss.n3394 0.258093
R16194 vss.n3398 vss.n3397 0.258093
R16195 vss.n3648 vss.n3647 0.258093
R16196 vss.n3669 vss.n3668 0.258093
R16197 vss.n3503 vss.n3502 0.258093
R16198 vss.n3524 vss.n3523 0.258093
R16199 vss.n5935 vss.n5934 0.257683
R16200 vss.n5943 vss.n5942 0.257683
R16201 vss.n5861 vss.n5738 0.257683
R16202 vss.n5846 vss.n5844 0.257683
R16203 vss.n5823 vss.n5770 0.257683
R16204 vss.n6007 vss.n5555 0.257011
R16205 vss.n364 vss.n288 0.254231
R16206 vss.n961 vss.n959 0.253888
R16207 vss.n953 vss.n952 0.253888
R16208 vss.n181 vss.n180 0.253888
R16209 vss.n5794 vss.n5791 0.25278
R16210 vss.n3574 vss.n3527 0.252405
R16211 vss.n3545 vss.n3537 0.252405
R16212 vss.n3553 vss.n3552 0.252405
R16213 vss.n3582 vss.n3581 0.252405
R16214 vss.n531 vss.n525 0.252244
R16215 vss.n5271 vss.n5270 0.251144
R16216 vss.n4280 vss.n4275 0.248644
R16217 vss.n4537 vss.n4536 0.248551
R16218 vss.n4538 vss.n4537 0.248551
R16219 vss.n4540 vss.n4539 0.248551
R16220 vss.n4541 vss.n4540 0.248551
R16221 vss.n4543 vss.n4542 0.248551
R16222 vss.n4544 vss.n4543 0.248551
R16223 vss.n4546 vss.n4545 0.248551
R16224 vss.n4547 vss.n4546 0.248551
R16225 vss.n4549 vss.n4548 0.248551
R16226 vss.n4550 vss.n4549 0.248551
R16227 vss.n4552 vss.n4551 0.248551
R16228 vss.n4553 vss.n4552 0.248551
R16229 vss.n4555 vss.n4554 0.248551
R16230 vss.n4556 vss.n4555 0.248551
R16231 vss.n4558 vss.n4557 0.248551
R16232 vss.n4559 vss.n4558 0.248551
R16233 vss.n4561 vss.n4560 0.248551
R16234 vss.n4562 vss.n4561 0.248551
R16235 vss.n4564 vss.n4563 0.248551
R16236 vss.n4565 vss.n4564 0.248551
R16237 vss.n4567 vss.n4566 0.248551
R16238 vss.n4568 vss.n4567 0.248551
R16239 vss.n4570 vss.n4569 0.248551
R16240 vss.n4571 vss.n4570 0.248551
R16241 vss.n4573 vss.n4572 0.248551
R16242 vss.n4574 vss.n4573 0.248551
R16243 vss.n4576 vss.n4575 0.248551
R16244 vss.n4577 vss.n4576 0.248551
R16245 vss.n4579 vss.n4578 0.248551
R16246 vss.n4580 vss.n4579 0.248551
R16247 vss.n4582 vss.n4581 0.248551
R16248 vss.n4583 vss.n4582 0.248551
R16249 vss.n4585 vss.n4584 0.248551
R16250 vss.n4586 vss.n4585 0.248551
R16251 vss.n4588 vss.n4587 0.248551
R16252 vss.n4589 vss.n4588 0.248551
R16253 vss.n4591 vss.n4590 0.248551
R16254 vss.n4592 vss.n4591 0.248551
R16255 vss.n4594 vss.n4593 0.248551
R16256 vss.n4595 vss.n4594 0.248551
R16257 vss.n4597 vss.n4596 0.248551
R16258 vss.n4598 vss.n4597 0.248551
R16259 vss.n4535 vss.n4534 0.248551
R16260 vss.n5498 vss.n5497 0.248551
R16261 vss.n6192 vss.n6191 0.248551
R16262 vss.n634 vss.n6192 0.371287
R16263 vss.n6195 vss.n6194 0.248551
R16264 vss.n637 vss.n6195 0.371287
R16265 vss.n6198 vss.n6197 0.248551
R16266 vss.n640 vss.n6198 0.371287
R16267 vss.n6201 vss.n6200 0.248551
R16268 vss.n643 vss.n6201 0.371287
R16269 vss.n6205 vss.n6204 0.248551
R16270 vss.n6206 vss.n6205 0.248551
R16271 vss.n6207 vss.n6206 0.248551
R16272 vss.n6208 vss.n6207 0.248551
R16273 vss.n646 vss.n6208 0.371287
R16274 vss.n6213 vss.n6212 0.248551
R16275 vss.n6216 vss.n6215 0.248551
R16276 vss.n6218 vss.n6217 0.248551
R16277 vss.n650 vss.n6218 0.371287
R16278 vss.n2692 vss.n2691 0.248551
R16279 vss.n2691 vss.n2690 0.248551
R16280 vss.n4171 vss.n480 0.433158
R16281 vss.n4170 vss.n529 1.62834
R16282 vss.n3728 vss.n3727 0.248551
R16283 vss.n3729 vss.n3728 0.248551
R16284 vss.n3731 vss.n3730 0.248551
R16285 vss.n3732 vss.n3731 0.248551
R16286 vss.n3734 vss.n3733 0.248551
R16287 vss.n3735 vss.n3734 0.248551
R16288 vss.n3739 vss.n3738 0.248551
R16289 vss.n3740 vss.n3739 0.248551
R16290 vss.n3742 vss.n3741 0.248551
R16291 vss.n3743 vss.n3742 0.248551
R16292 vss.n3745 vss.n3744 0.248551
R16293 vss.n3746 vss.n3745 0.248551
R16294 vss.n5 vss.n154 1.75539
R16295 vss.n3705 vss.n3704 0.248551
R16296 vss.n3706 vss.n3705 0.248551
R16297 vss.n3707 vss.n3706 0.248551
R16298 vss.n3709 vss.n3708 0.248551
R16299 vss.n3710 vss.n3709 0.248551
R16300 vss.n3712 vss.n3711 0.248551
R16301 vss.n3713 vss.n3712 0.248551
R16302 vss.n3717 vss.n3716 0.248551
R16303 vss.n3718 vss.n3717 0.248551
R16304 vss.n3720 vss.n3719 0.248551
R16305 vss.n3721 vss.n3720 0.248551
R16306 vss.n3723 vss.n3722 0.248551
R16307 vss.n3724 vss.n3723 0.248551
R16308 vss.n1036 vss.n1032 0.248252
R16309 vss.n1036 vss.n1027 0.248252
R16310 vss.n1036 vss.n1031 0.248037
R16311 vss.n1036 vss.n1026 0.248037
R16312 vss.n3113 vss.n3108 0.24778
R16313 vss.n3134 vss.n3132 0.24778
R16314 vss.n5092 vss.n5091 0.24778
R16315 vss.n5098 vss.n5096 0.24778
R16316 vss.n3211 vss.n3035 0.247011
R16317 vss.n3217 vss.n3216 0.247011
R16318 vss.n5806 vss.n5787 0.247011
R16319 vss.n5184 vss.n3078 0.245761
R16320 vss.n3205 vss.n3204 0.244511
R16321 vss.n4266 vss.n4264 0.242011
R16322 vss.n4253 vss.n4249 0.242011
R16323 vss.n6146 vss 0.241763
R16324 vss.n3205 vss.n3203 0.24153
R16325 vss.n5634 vss.n5602 0.240825
R16326 vss.n3073 vss.n3072 0.240761
R16327 vss.n5791 vss.n5790 0.240761
R16328 vss.n5957 vss.n5956 0.240486
R16329 vss.n3083 vss.n3078 0.23903
R16330 vss.n5790 vss.n5787 0.23903
R16331 vss.n6365 vss.n6364 0.238685
R16332 vss.n3701 vss.n3700 0.237233
R16333 vss.n16 vss.n3678 0.237233
R16334 vss.n3038 vss.n3035 0.23528
R16335 vss.n3217 vss.n3215 0.23528
R16336 vss.n5426 vss.n5425 0.235023
R16337 vss.n3127 vss.n3108 0.234511
R16338 vss.n3134 vss.n3133 0.234511
R16339 vss.n5094 vss.n5091 0.234511
R16340 vss.n5098 vss.n5097 0.234511
R16341 vss.n5280 vss.n5279 0.233773
R16342 vss.n5273 vss.n5271 0.233644
R16343 vss.n3483 vss.n3482 0.231121
R16344 vss.n3478 vss.n3428 0.231121
R16345 vss.n3475 vss.n3472 0.231121
R16346 vss.n3488 vss.n3487 0.231121
R16347 vss.n3491 vss.n3425 0.231121
R16348 vss.n3461 vss.n3458 0.231121
R16349 vss.n3496 vss.n3495 0.231121
R16350 vss.n3681 vss.n3421 0.231121
R16351 vss.n3456 vss.n3455 0.231121
R16352 vss.n3469 vss.n3468 0.231121
R16353 vss.n3560 vss.n3559 0.231121
R16354 vss.n3555 vss.n3554 0.231121
R16355 vss.n3551 vss.n3550 0.231121
R16356 vss.n3546 vss.n3536 0.231121
R16357 vss.n6340 vss.n6339 0.229974
R16358 vss.n5051 vss.n5050 0.229157
R16359 vss.n2323 vss.n2322 0.229157
R16360 vss.n6381 vss.n6380 0.229157
R16361 vss.n2373 vss.n2371 0.229157
R16362 vss.n2445 vss.n2444 0.229157
R16363 vss.n1577 vss.n1576 0.229157
R16364 vss.n5318 vss.n5317 0.229157
R16365 vss.n5183 vss.n3073 0.22903
R16366 vss.n5139 vss.n5138 0.228773
R16367 vss.n5425 vss.n5424 0.228511
R16368 vss.n5143 vss.n5139 0.227261
R16369 vss.n5504 vss.n5503 0.225799
R16370 vss.n5558 vss.n5555 0.22278
R16371 vss.n162 vss.n164 0.493906
R16372 vss.n158 vss.n4507 0.33055
R16373 vss.n4504 vss.n963 0.221145
R16374 vss.n5957 vss.n5950 0.220825
R16375 vss.n6002 vss.n5996 0.21903
R16376 vss.n5980 vss.n5973 0.21903
R16377 vss.n5679 vss.n5672 0.21903
R16378 vss.n5656 vss.n5649 0.21903
R16379 vss.n3114 vss.n3113 0.218502
R16380 vss.n5948 vss.n5947 0.217011
R16381 vss.n6313 vss.n6311 0.215
R16382 vss.n5024 vss.t2063 0.211071
R16383 vss.n6339 vss.n6338 0.210486
R16384 vss.n9 vss.n3702 0.852376
R16385 vss.n5441 vss.n5440 0.207383
R16386 vss.n5263 vss.n5262 0.205486
R16387 vss.n6358 vss.n6357 0.205319
R16388 vss.n3016 vss.n3015 0.202498
R16389 vss.n5808 vss.n5807 0.201736
R16390 vss.n3695 vss.n3694 0.199346
R16391 vss.n3697 vss.n3696 0.199346
R16392 vss.n3689 vss.n3688 0.199346
R16393 vss.n3687 vss.n3686 0.199346
R16394 vss.n3644 vss.n3643 0.199346
R16395 vss.n3623 vss.n3622 0.199346
R16396 vss.n3595 vss.n3594 0.199346
R16397 vss.n3616 vss.n3615 0.199346
R16398 vss.n1036 vss.n1029 0.199004
R16399 vss.n2423 vss.n2422 0.198068
R16400 vss.n4249 vss.n4248 0.19653
R16401 vss.n4411 vss.n4409 0.195412
R16402 vss.n6318 vss.n6317 0.193449
R16403 vss.n5536 vss.n5535 0.193061
R16404 vss.n5491 vss.n5489 0.193035
R16405 vss.n5492 vss.n5010 0.192932
R16406 vss.n2419 vss.n2417 0.192581
R16407 vss.n3145 vss.n3143 0.192075
R16408 vss.n3186 vss.n3054 0.192075
R16409 vss.n3185 vss.n3181 0.191736
R16410 vss.n5424 vss.n5421 0.191736
R16411 vss.n6233 vss.n6229 0.191539
R16412 vss.n3791 vss.n3787 0.191539
R16413 vss.n2685 vss.n2681 0.191539
R16414 vss.n1584 vss.n1583 0.191539
R16415 vss.n1590 vss.n1589 0.191539
R16416 vss.n1597 vss.n1564 0.191539
R16417 vss.n1605 vss.n1604 0.191539
R16418 vss.n1612 vss.n1551 0.191539
R16419 vss.n1620 vss.n1619 0.191539
R16420 vss.n1627 vss.n1538 0.191539
R16421 vss.n1634 vss.n1633 0.191539
R16422 vss.n1642 vss.n1525 0.191539
R16423 vss.n1649 vss.n1648 0.191539
R16424 vss.n1664 vss.n1663 0.191539
R16425 vss.n1670 vss.n1669 0.191539
R16426 vss.n1677 vss.n1504 0.191539
R16427 vss.n1684 vss.n1683 0.191539
R16428 vss.n1699 vss.n1698 0.191539
R16429 vss.n1704 vss.n1703 0.191539
R16430 vss.n1719 vss.n1718 0.191539
R16431 vss.n6399 vss.n1477 0.191539
R16432 vss.n2450 vss.n2449 0.191539
R16433 vss.n2469 vss.n2434 0.191539
R16434 vss.n2466 vss.n2465 0.191539
R16435 vss.n2372 vss.n2369 0.191539
R16436 vss.n2375 vss.n2374 0.191539
R16437 vss.n5321 vss.n5057 0.191539
R16438 vss.n5053 vss.n5052 0.191539
R16439 vss.n5327 vss.n5326 0.191539
R16440 vss.n5066 vss.n5062 0.191539
R16441 vss.n2341 vss.n2337 0.191539
R16442 vss.n6375 vss.n2332 0.191539
R16443 vss.n6385 vss.n6378 0.191539
R16444 vss.n6391 vss.n2327 0.191539
R16445 vss.n2351 vss.n2350 0.191539
R16446 vss.n2532 vss.n2528 0.191539
R16447 vss.n2522 vss.n2518 0.191539
R16448 vss.n2513 vss.n2509 0.191539
R16449 vss.n2503 vss.n2499 0.191539
R16450 vss.n2537 vss.n2492 0.191539
R16451 vss.n2547 vss.n2543 0.191539
R16452 vss.n2485 vss.n2481 0.191539
R16453 vss.n2551 vss.n2474 0.191539
R16454 vss.n2598 vss.n2594 0.191539
R16455 vss.n6301 vss.n2557 0.191539
R16456 vss.n6254 vss.n6250 0.191539
R16457 vss.n6276 vss.n6272 0.191539
R16458 vss.n5370 vss.n5368 0.191539
R16459 vss.n3986 vss.n3985 0.191539
R16460 vss.n3937 vss.n3933 0.191539
R16461 vss.n3251 vss.n3249 0.191539
R16462 vss.n3905 vss.n3904 0.191539
R16463 vss.n3911 vss.n3910 0.191539
R16464 vss.n3954 vss.n3952 0.191539
R16465 vss.n4264 vss.n4263 0.19153
R16466 vss.n2466 vss.n2464 0.191352
R16467 vss.n5370 vss.n5369 0.191352
R16468 vss.n3251 vss.n3250 0.191352
R16469 vss.n3905 vss.n3903 0.191352
R16470 vss.n3910 vss.n3909 0.191352
R16471 vss.n3954 vss.n3953 0.191352
R16472 vss.n5479 vss.n5478 0.190956
R16473 vss.n5452 vss.n5451 0.190956
R16474 vss.n5461 vss.n5341 0.190956
R16475 vss.n5360 vss.n5357 0.190956
R16476 vss.n3957 vss.n3945 0.190956
R16477 vss.n2673 vss.n2669 0.190956
R16478 vss.n3794 vss.n3779 0.190956
R16479 vss.n6236 vss.n2668 0.190956
R16480 vss.n6257 vss.n6241 0.190956
R16481 vss.n6264 vss.n2663 0.190956
R16482 vss.n3980 vss.n3748 0.190956
R16483 vss.n3940 vss.n3925 0.190956
R16484 vss.n3243 vss.n3242 0.190956
R16485 vss.n3886 vss.n3883 0.190956
R16486 vss.n3917 vss.n3877 0.190956
R16487 vss.n5476 vss.n5475 0.190289
R16488 vss.n5457 vss.n5456 0.190289
R16489 vss.n3973 vss.n3961 0.190289
R16490 vss.n3872 vss.n3859 0.190289
R16491 vss.n3854 vss.n3752 0.190289
R16492 vss.n3851 vss.n3847 0.190289
R16493 vss.n3834 vss.n3775 0.190289
R16494 vss.n3828 vss.n3816 0.190289
R16495 vss.n3811 vss.n3799 0.190289
R16496 vss.n4285 vss.n4284 0.189642
R16497 vss.n5527 vss.n5526 0.189136
R16498 vss.n5635 vss.n5602 0.187986
R16499 vss.n6016 vss.n5551 0.187814
R16500 vss.n6356 vss.n6355 0.187812
R16501 vss.n5428 vss.n5427 0.187075
R16502 vss.n5419 vss.n5418 0.186736
R16503 vss.n6363 vss.n2360 0.186419
R16504 vss.n4380 vss.n4367 0.185825
R16505 vss.n3128 vss.n3127 0.185825
R16506 vss.n3144 vss.n3088 0.185825
R16507 vss.n3192 vss.n3191 0.185825
R16508 vss.n3198 vss.n3048 0.185825
R16509 vss.n5157 vss.n5151 0.185825
R16510 vss.n5093 vss.n5089 0.185825
R16511 vss.n5095 vss.n5094 0.185825
R16512 vss.n5437 vss.n5436 0.185825
R16513 vss.n5420 vss.n5419 0.185825
R16514 vss.n5412 vss.n5411 0.185825
R16515 vss.n5408 vss.n5407 0.185825
R16516 vss.n3168 vss.n3165 0.185486
R16517 vss.n3180 vss.n3060 0.185486
R16518 vss.n3215 vss.n3212 0.185486
R16519 vss.n3029 vss.n3028 0.185486
R16520 vss.n5097 vss.n5090 0.185486
R16521 vss.n5300 vss.n5298 0.185486
R16522 vss.n5166 vss.n5165 0.185486
R16523 vss.n5439 vss.n5438 0.185486
R16524 vss.n5435 vss.n5434 0.185486
R16525 vss.n5427 vss.n5426 0.185486
R16526 vss.n5410 vss.n5409 0.185486
R16527 vss.n4260 vss.n4259 0.18528
R16528 vss.n3617 vss.n3501 0.182569
R16529 vss.n3670 vss.n3499 0.182569
R16530 vss.n3646 vss.n3645 0.182569
R16531 vss.n3593 vss.n3591 0.182569
R16532 vss.n6319 vss.n6318 0.181765
R16533 vss.n2419 vss.n2418 0.180839
R16534 vss.n5636 vss.n5599 0.180789
R16535 vss.n5632 vss.n5603 0.180789
R16536 vss.n4400 vss.n4399 0.179575
R16537 vss.n6166 vss.n2700 0.179556
R16538 vss.n2856 vss.n2855 0.179556
R16539 vss.n6351 vss.n2382 0.1787
R16540 vss.n4407 vss.n4406 0.178
R16541 vss.n5300 vss.n5299 0.175825
R16542 vss.n3181 vss.n3180 0.175825
R16543 vss.n5298 vss.n5090 0.175825
R16544 vss.n5262 vss.n5261 0.175825
R16545 vss.n5409 vss.n5408 0.175825
R16546 vss.n5440 vss.n5439 0.175825
R16547 vss.n5436 vss.n5435 0.175825
R16548 vss.n5421 vss.n5420 0.175825
R16549 vss.n5413 vss.n5412 0.175825
R16550 vss.n4400 vss.n4342 0.175486
R16551 vss.n3145 vss.n3144 0.175486
R16552 vss.n3191 vss.n3054 0.175486
R16553 vss.n5438 vss.n5437 0.175486
R16554 vss.n5434 vss.n5433 0.175486
R16555 vss.n5411 vss.n5410 0.175486
R16556 vss.n5407 vss.n5406 0.175486
R16557 vss.n2422 vss.n2421 0.175314
R16558 vss.n6406 vss.n1470 0.173986
R16559 vss.n5486 vss.n5031 0.173986
R16560 vss.n5502 vss.n5501 0.173969
R16561 vss.n3212 vss.n3211 0.173325
R16562 vss.n3216 vss.n3029 0.173325
R16563 vss.n5808 vss.n5806 0.173325
R16564 vss.n3132 vss.n3128 0.172986
R16565 vss.n5093 vss.n5092 0.172986
R16566 vss.n5096 vss.n5095 0.172986
R16567 vss.n5467 vss.n5466 0.17271
R16568 vss.n5484 vss.n5483 0.170806
R16569 vss.n4366 vss.n4364 0.170789
R16570 vss.n5270 vss.n5266 0.169575
R16571 vss.n5488 vss.n5012 0.167171
R16572 vss.n6151 vss.n2980 0.166538
R16573 vss.n6152 vss.n6151 0.166538
R16574 vss.n6153 vss.n6152 0.166538
R16575 vss.n6153 vss.n2974 0.166538
R16576 vss.n6157 vss.n2974 0.166538
R16577 vss.n6158 vss.n6157 0.166538
R16578 vss.n6159 vss.n6158 0.166538
R16579 vss.n5303 vss.n5088 0.166192
R16580 vss.n3165 vss.n3164 0.164575
R16581 vss.n3173 vss.n3060 0.164575
R16582 vss.n5405 vss.n5404 0.164539
R16583 vss.n6321 vss.n6320 0.164293
R16584 vss.n3194 vss.n3192 0.164236
R16585 vss.n3048 vss.n3047 0.164236
R16586 vss.n4609 vss.n4267 0.163289
R16587 vss.n5151 vss.n5150 0.162986
R16588 vss.n6320 vss.n6319 0.162703
R16589 vss.n267 vss.n193 0.16227
R16590 vss.n4284 vss.n4281 0.162039
R16591 vss.n5936 vss.n5935 0.162039
R16592 vss.n5944 vss.n5943 0.162039
R16593 vss.n5862 vss.n5861 0.162039
R16594 vss.n5844 vss.n5756 0.162039
R16595 vss.n5824 vss.n5823 0.162039
R16596 vss.n5998 vss.n5997 0.162039
R16597 vss.n5993 vss.n5562 0.162039
R16598 vss.n5976 vss.n5975 0.162039
R16599 vss.n5970 vss.n5570 0.162039
R16600 vss.n5953 vss.n5952 0.162039
R16601 vss.n5692 vss.n5579 0.162039
R16602 vss.n5675 vss.n5674 0.162039
R16603 vss.n5669 vss.n5587 0.162039
R16604 vss.n5652 vss.n5651 0.162039
R16605 vss.n5646 vss.n5595 0.162039
R16606 vss.n287 vss.n280 0.161895
R16607 vss.n287 vss.n279 0.161895
R16608 vss.n3590 vss.n3526 0.161371
R16609 vss.n5167 vss.n3039 0.159539
R16610 vss.n5251 vss.n5250 0.159539
R16611 vss.n364 vss.n361 0.159379
R16612 vss.n2425 vss.n2382 0.159056
R16613 vss.n3542 vss.n3541 0.158336
R16614 vss.n3542 vss.n3538 0.158336
R16615 vss.n4388 vss.n4360 0.158289
R16616 vss.n6226 vss.n522 0.0793054
R16617 vss.n2678 vss.n512 0.0793054
R16618 vss.n5330 vss.n841 0.0793054
R16619 vss.n846 vss.n6374 0.228282
R16620 vss.n2354 vss.n851 0.0793054
R16621 vss.n855 vss.n2531 0.0793054
R16622 vss.n861 vss.n2521 0.0793054
R16623 vss.n867 vss.n2512 0.0793054
R16624 vss.n871 vss.n2502 0.0793054
R16625 vss.n877 vss.n2495 0.0793054
R16626 vss.n881 vss.n2546 0.0793054
R16627 vss.n885 vss.n2484 0.0793054
R16628 vss.n891 vss.n2477 0.0793054
R16629 vss.n895 vss.n2597 0.0793054
R16630 vss.n901 vss.n2560 0.0793054
R16631 vss.n468 vss.n5477 0.0793054
R16632 vss.n5473 vss.n5472 0.158289
R16633 vss.n5465 vss.n5464 0.158289
R16634 vss.n5454 vss.n5453 0.158289
R16635 vss.n5444 vss.n5443 0.158289
R16636 vss.n913 vss.n5386 0.139319
R16637 vss.n912 vss.n5390 0.139319
R16638 vss.n911 vss.n5394 0.139319
R16639 vss.n910 vss.n5397 0.139319
R16640 vss.n909 vss.n5400 0.139319
R16641 vss.n908 vss.n5403 0.139319
R16642 vss.n3961 vss.n428 0.140569
R16643 vss.n919 vss.n918 0.139319
R16644 vss.n3915 vss.n406 0.0793054
R16645 vss.n3859 vss.n403 0.140569
R16646 vss.n924 vss.n923 0.139319
R16647 vss.n3752 vss.n398 0.140569
R16648 vss.n929 vss.n928 0.139319
R16649 vss.n3847 vss.n393 0.140569
R16650 vss.n934 vss.n933 0.139319
R16651 vss.n3775 vss.n389 0.140569
R16652 vss.n939 vss.n938 0.139319
R16653 vss.n3816 vss.n385 0.140569
R16654 vss.n944 vss.n943 0.139319
R16655 vss.n3799 vss.n380 0.140569
R16656 vss.n949 vss.n948 0.139319
R16657 vss.n3949 vss.n374 0.0793054
R16658 vss.n3088 vss.n3087 0.157986
R16659 vss.n3727 vss.n3726 0.157182
R16660 vss.n5432 vss.n5429 0.157039
R16661 vss.n5417 vss.n5416 0.157039
R16662 vss.n4247 vss.n4243 0.15618
R16663 vss.n3958 vss.n3944 0.155582
R16664 vss.n6238 vss.n6237 0.155582
R16665 vss.n6238 vss.n2667 0.155582
R16666 vss.n6232 vss.n6231 0.155582
R16667 vss.n6232 vss.n6230 0.155582
R16668 vss.n3796 vss.n3795 0.155582
R16669 vss.n3796 vss.n3778 0.155582
R16670 vss.n3790 vss.n3789 0.155582
R16671 vss.n3790 vss.n3788 0.155582
R16672 vss.n2672 vss.n2671 0.155582
R16673 vss.n2672 vss.n2670 0.155582
R16674 vss.n2684 vss.n2683 0.155582
R16675 vss.n2684 vss.n2682 0.155582
R16676 vss.n1582 vss.n1581 0.155582
R16677 vss.n1595 vss.n1594 0.155582
R16678 vss.n1563 vss.n1562 0.155582
R16679 vss.n1610 vss.n1609 0.155582
R16680 vss.n1550 vss.n1549 0.155582
R16681 vss.n1625 vss.n1624 0.155582
R16682 vss.n1537 vss.n1536 0.155582
R16683 vss.n1640 vss.n1639 0.155582
R16684 vss.n1524 vss.n1523 0.155582
R16685 vss.n1655 vss.n1654 0.155582
R16686 vss.n1662 vss.n1661 0.155582
R16687 vss.n1675 vss.n1674 0.155582
R16688 vss.n1503 vss.n1502 0.155582
R16689 vss.n1690 vss.n1689 0.155582
R16690 vss.n1697 vss.n1696 0.155582
R16691 vss.n1710 vss.n1709 0.155582
R16692 vss.n1717 vss.n1716 0.155582
R16693 vss.n6400 vss.n1476 0.155582
R16694 vss.n2456 vss.n2455 0.155582
R16695 vss.n2470 vss.n2433 0.155582
R16696 vss.n2368 vss.n2367 0.155582
R16697 vss.n6309 vss.n6308 0.155582
R16698 vss.n5322 vss.n5056 0.155582
R16699 vss.n5054 vss.n5049 0.155582
R16700 vss.n5325 vss.n5045 0.155582
R16701 vss.n5325 vss.n5044 0.155582
R16702 vss.n5065 vss.n5064 0.155582
R16703 vss.n5065 vss.n5063 0.155582
R16704 vss.n2340 vss.n2339 0.155582
R16705 vss.n2340 vss.n2338 0.155582
R16706 vss.n6376 vss.n2331 0.155582
R16707 vss.n6387 vss.n6386 0.155582
R16708 vss.n6390 vss.n2328 0.155582
R16709 vss.n2349 vss.n2348 0.155582
R16710 vss.n2349 vss.n2347 0.155582
R16711 vss.n2527 vss.n2507 0.155582
R16712 vss.n2527 vss.n2506 0.155582
R16713 vss.n2524 vss.n2523 0.155582
R16714 vss.n2524 vss.n2517 0.155582
R16715 vss.n2515 vss.n2514 0.155582
R16716 vss.n2515 vss.n2508 0.155582
R16717 vss.n2498 vss.n2497 0.155582
R16718 vss.n2498 vss.n2496 0.155582
R16719 vss.n2539 vss.n2538 0.155582
R16720 vss.n2539 vss.n2491 0.155582
R16721 vss.n2542 vss.n2489 0.155582
R16722 vss.n2542 vss.n2488 0.155582
R16723 vss.n2480 vss.n2479 0.155582
R16724 vss.n2480 vss.n2478 0.155582
R16725 vss.n2553 vss.n2552 0.155582
R16726 vss.n2553 vss.n2473 0.155582
R16727 vss.n2593 vss.n2592 0.155582
R16728 vss.n2593 vss.n2591 0.155582
R16729 vss.n6303 vss.n6302 0.155582
R16730 vss.n6303 vss.n2556 0.155582
R16731 vss.n6259 vss.n6258 0.155582
R16732 vss.n6259 vss.n6240 0.155582
R16733 vss.n6253 vss.n6252 0.155582
R16734 vss.n6253 vss.n6251 0.155582
R16735 vss.n6263 vss.n6262 0.155582
R16736 vss.n6263 vss.n2664 0.155582
R16737 vss.n6275 vss.n6274 0.155582
R16738 vss.n6275 vss.n6273 0.155582
R16739 vss.n5480 vss.n5032 0.155582
R16740 vss.n5034 vss.n5033 0.155582
R16741 vss.n5469 vss.n5468 0.155582
R16742 vss.n5462 vss.n5340 0.155582
R16743 vss.n5450 vss.n5447 0.155582
R16744 vss.n5455 vss.n5445 0.155582
R16745 vss.n5384 vss.n5354 0.155582
R16746 vss.n5388 vss.n5352 0.155582
R16747 vss.n5392 vss.n5350 0.155582
R16748 vss.n5396 vss.n5348 0.155582
R16749 vss.n5399 vss.n5346 0.155582
R16750 vss.n5402 vss.n5344 0.155582
R16751 vss.n5359 vss.n5358 0.155582
R16752 vss.n3975 vss.n3974 0.155582
R16753 vss.n3975 vss.n3960 0.155582
R16754 vss.n3965 vss.n3964 0.155582
R16755 vss.n3965 vss.n3963 0.155582
R16756 vss.n3979 vss.n3978 0.155582
R16757 vss.n3979 vss.n3749 0.155582
R16758 vss.n3984 vss.n3983 0.155582
R16759 vss.n3984 vss.n3982 0.155582
R16760 vss.n3942 vss.n3941 0.155582
R16761 vss.n3942 vss.n3924 0.155582
R16762 vss.n3936 vss.n3935 0.155582
R16763 vss.n3936 vss.n3934 0.155582
R16764 vss.n3922 vss.n3921 0.155582
R16765 vss.n3919 vss.n3918 0.155582
R16766 vss.n3885 vss.n3884 0.155582
R16767 vss.n3874 vss.n3873 0.155582
R16768 vss.n3874 vss.n3858 0.155582
R16769 vss.n3863 vss.n3862 0.155582
R16770 vss.n3863 vss.n3861 0.155582
R16771 vss.n3856 vss.n3855 0.155582
R16772 vss.n3856 vss.n3751 0.155582
R16773 vss.n3756 vss.n3755 0.155582
R16774 vss.n3756 vss.n3754 0.155582
R16775 vss.n3850 vss.n3849 0.155582
R16776 vss.n3850 vss.n3848 0.155582
R16777 vss.n3839 vss.n3838 0.155582
R16778 vss.n3839 vss.n3837 0.155582
R16779 vss.n3833 vss.n3777 0.155582
R16780 vss.n3833 vss.n3776 0.155582
R16781 vss.n3767 vss.n3766 0.155582
R16782 vss.n3767 vss.n3765 0.155582
R16783 vss.n3830 vss.n3829 0.155582
R16784 vss.n3830 vss.n3815 0.155582
R16785 vss.n3820 vss.n3819 0.155582
R16786 vss.n3820 vss.n3818 0.155582
R16787 vss.n3813 vss.n3812 0.155582
R16788 vss.n3813 vss.n3798 0.155582
R16789 vss.n3803 vss.n3802 0.155582
R16790 vss.n3803 vss.n3801 0.155582
R16791 vss.n3237 vss.n3236 0.154493
R16792 vss.n2421 vss.n2420 0.152228
R16793 vss.n4412 vss.n4285 0.152115
R16794 vss.n5295 vss.n5292 0.152039
R16795 vss.n3684 vss.n3683 0.151357
R16796 vss.n4372 vss.n4371 0.151192
R16797 vss.n5037 vss.n5036 0.151185
R16798 vss.n5338 vss.n466 0.151185
R16799 vss.n3579 vss.n3578 0.150767
R16800 vss.n5798 vss.n5797 0.15025
R16801 vss.n2410 vss.n2409 0.149914
R16802 vss.n5528 vss.n5527 0.149539
R16803 vss.n6226 vss.n6225 0.149476
R16804 vss.n6226 vss.n6224 0.149476
R16805 vss.n6227 vss.n6223 0.149476
R16806 vss.n6227 vss.n6222 0.149476
R16807 vss.n3784 vss.n3783 0.149476
R16808 vss.n3784 vss.n3782 0.149476
R16809 vss.n3785 vss.n3781 0.149476
R16810 vss.n3785 vss.n3780 0.149476
R16811 vss.n2678 vss.n2677 0.149476
R16812 vss.n2678 vss.n2676 0.149476
R16813 vss.n2679 vss.n2675 0.149476
R16814 vss.n2679 vss.n2674 0.149476
R16815 vss.n1580 vss.n1579 0.149476
R16816 vss.n1596 vss.n1593 0.149476
R16817 vss.n1561 vss.n1560 0.149476
R16818 vss.n1611 vss.n1608 0.149476
R16819 vss.n1548 vss.n1547 0.149476
R16820 vss.n1626 vss.n1623 0.149476
R16821 vss.n1535 vss.n1534 0.149476
R16822 vss.n1641 vss.n1638 0.149476
R16823 vss.n1522 vss.n1521 0.149476
R16824 vss.n1656 vss.n1653 0.149476
R16825 vss.n1660 vss.n1659 0.149476
R16826 vss.n1676 vss.n1673 0.149476
R16827 vss.n1501 vss.n1500 0.149476
R16828 vss.n1691 vss.n1688 0.149476
R16829 vss.n1695 vss.n1694 0.149476
R16830 vss.n1711 vss.n1708 0.149476
R16831 vss.n1715 vss.n1714 0.149476
R16832 vss.n2457 vss.n2454 0.149476
R16833 vss.n2471 vss.n2432 0.149476
R16834 vss.n2366 vss.n2365 0.149476
R16835 vss.n6310 vss.n6307 0.149476
R16836 vss.n5330 vss.n5329 0.149476
R16837 vss.n5330 vss.n5328 0.149476
R16838 vss.n5060 vss.n5059 0.149476
R16839 vss.n5060 vss.n5058 0.149476
R16840 vss.n2335 vss.n2334 0.149476
R16841 vss.n2335 vss.n2333 0.149476
R16842 vss.n2354 vss.n2353 0.149476
R16843 vss.n2354 vss.n2352 0.149476
R16844 vss.n2531 vss.n2530 0.149476
R16845 vss.n2531 vss.n2529 0.149476
R16846 vss.n2521 vss.n2520 0.149476
R16847 vss.n2521 vss.n2519 0.149476
R16848 vss.n2512 vss.n2511 0.149476
R16849 vss.n2512 vss.n2510 0.149476
R16850 vss.n2502 vss.n2501 0.149476
R16851 vss.n2502 vss.n2500 0.149476
R16852 vss.n2495 vss.n2494 0.149476
R16853 vss.n2495 vss.n2493 0.149476
R16854 vss.n2546 vss.n2545 0.149476
R16855 vss.n2546 vss.n2544 0.149476
R16856 vss.n2484 vss.n2483 0.149476
R16857 vss.n2484 vss.n2482 0.149476
R16858 vss.n2477 vss.n2476 0.149476
R16859 vss.n2477 vss.n2475 0.149476
R16860 vss.n2597 vss.n2596 0.149476
R16861 vss.n2597 vss.n2595 0.149476
R16862 vss.n2560 vss.n2559 0.149476
R16863 vss.n2560 vss.n2558 0.149476
R16864 vss.n6247 vss.n6246 0.149476
R16865 vss.n6247 vss.n6245 0.149476
R16866 vss.n6248 vss.n6244 0.149476
R16867 vss.n6248 vss.n6243 0.149476
R16868 vss.n6269 vss.n6268 0.149476
R16869 vss.n6269 vss.n6267 0.149476
R16870 vss.n6270 vss.n6266 0.149476
R16871 vss.n6270 vss.n6265 0.149476
R16872 vss.n5477 vss.n5035 0.149476
R16873 vss.n5472 vss.n5471 0.149476
R16874 vss.n5464 vss.n5463 0.149476
R16875 vss.n5449 vss.n5448 0.149476
R16876 vss.n5454 vss.n5446 0.149476
R16877 vss.n5443 vss.n5442 0.149476
R16878 vss.n5387 vss.n5353 0.149476
R16879 vss.n5391 vss.n5351 0.149476
R16880 vss.n5395 vss.n5349 0.149476
R16881 vss.n5398 vss.n5347 0.149476
R16882 vss.n5401 vss.n5345 0.149476
R16883 vss.n5404 vss.n5343 0.149476
R16884 vss.n5364 vss.n5363 0.149476
R16885 vss.n5365 vss.n5362 0.149476
R16886 vss.n3972 vss.n3971 0.149476
R16887 vss.n3972 vss.n3970 0.149476
R16888 vss.n3969 vss.n3968 0.149476
R16889 vss.n3969 vss.n3962 0.149476
R16890 vss.n3992 vss.n3991 0.149476
R16891 vss.n3992 vss.n3990 0.149476
R16892 vss.n3989 vss.n3988 0.149476
R16893 vss.n3989 vss.n3981 0.149476
R16894 vss.n3930 vss.n3929 0.149476
R16895 vss.n3930 vss.n3928 0.149476
R16896 vss.n3931 vss.n3927 0.149476
R16897 vss.n3931 vss.n3926 0.149476
R16898 vss.n3246 vss.n3245 0.149476
R16899 vss.n3247 vss.n3244 0.149476
R16900 vss.n3897 vss.n3896 0.149476
R16901 vss.n3898 vss.n3895 0.149476
R16902 vss.n3915 vss.n3914 0.149476
R16903 vss.n3913 vss.n3908 0.149476
R16904 vss.n3870 vss.n3869 0.149476
R16905 vss.n3870 vss.n3868 0.149476
R16906 vss.n3867 vss.n3866 0.149476
R16907 vss.n3867 vss.n3860 0.149476
R16908 vss.n3763 vss.n3762 0.149476
R16909 vss.n3763 vss.n3761 0.149476
R16910 vss.n3760 vss.n3759 0.149476
R16911 vss.n3760 vss.n3753 0.149476
R16912 vss.n3846 vss.n3845 0.149476
R16913 vss.n3846 vss.n3844 0.149476
R16914 vss.n3843 vss.n3842 0.149476
R16915 vss.n3843 vss.n3836 0.149476
R16916 vss.n3774 vss.n3773 0.149476
R16917 vss.n3774 vss.n3772 0.149476
R16918 vss.n3771 vss.n3770 0.149476
R16919 vss.n3771 vss.n3764 0.149476
R16920 vss.n3827 vss.n3826 0.149476
R16921 vss.n3827 vss.n3825 0.149476
R16922 vss.n3824 vss.n3823 0.149476
R16923 vss.n3824 vss.n3817 0.149476
R16924 vss.n3810 vss.n3809 0.149476
R16925 vss.n3810 vss.n3808 0.149476
R16926 vss.n3807 vss.n3806 0.149476
R16927 vss.n3807 vss.n3800 0.149476
R16928 vss.n3949 vss.n3948 0.149476
R16929 vss.n3950 vss.n3947 0.149476
R16930 vss.n86 vss.n72 0.148588
R16931 vss.n6358 vss.n2379 0.148326
R16932 vss.n5101 vss.n5100 0.148289
R16933 vss.n5797 vss.n5795 0.148289
R16934 vss.n5247 vss.n5173 0.146192
R16935 vss.n5189 vss.n5188 0.145854
R16936 vss.n5209 vss.n5208 0.145578
R16937 vss.n3239 vss.n3229 0.144603
R16938 vss.n5433 vss.n5432 0.144575
R16939 vss.n5416 vss.n5413 0.144236
R16940 vss.n6365 vss.n6363 0.143606
R16941 vss.n3087 vss.n3084 0.143289
R16942 vss.n5928 vss.n5552 0.143289
R16943 vss.n6014 vss.n483 0.143289
R16944 vss.n5632 vss.n5631 0.143289
R16945 vss.n2415 vss.n2414 0.142292
R16946 vss.n5250 vss.n5166 0.142075
R16947 vss.n3020 vss.n3019 0.142039
R16948 vss.n5985 vss.n5566 0.142039
R16949 vss.n5962 vss.n5574 0.142039
R16950 vss.n5684 vss.n5583 0.142039
R16951 vss.n5661 vss.n5591 0.142039
R16952 vss.n5638 vss.n5599 0.142039
R16953 vss.n5627 vss.n5605 0.142039
R16954 vss.n5997 vss.n485 0.257268
R16955 vss.n5975 vss.n5974 0.139575
R16956 vss.n5952 vss.n5951 0.139575
R16957 vss.n5674 vss.n5673 0.139575
R16958 vss.n5651 vss.n5650 0.139575
R16959 vss.n5052 vss.n5051 0.139432
R16960 vss.n2327 vss.n2323 0.139432
R16961 vss.n6381 vss.n6378 0.139432
R16962 vss.n5368 vss.n5366 0.139432
R16963 vss.n3952 vss.n3951 0.139432
R16964 vss.n2681 vss.n2680 0.139432
R16965 vss.n3787 vss.n3786 0.139432
R16966 vss.n6229 vss.n6228 0.139432
R16967 vss.n5062 vss.n5061 0.139432
R16968 vss.n2337 vss.n2336 0.139432
R16969 vss.n2374 vss.n2362 0.139432
R16970 vss.n2373 vss.n2372 0.139432
R16971 vss.n2465 vss.n2431 0.139432
R16972 vss.n2458 vss.n2434 0.139432
R16973 vss.n2449 vss.n2445 0.139432
R16974 vss.n1480 vss.n1477 0.139432
R16975 vss.n1718 vss.n1712 0.139432
R16976 vss.n1703 vss.n1488 0.139432
R16977 vss.n1698 vss.n1692 0.139432
R16978 vss.n1683 vss.n1496 0.139432
R16979 vss.n1678 vss.n1677 0.139432
R16980 vss.n1669 vss.n1509 0.139432
R16981 vss.n1663 vss.n1657 0.139432
R16982 vss.n1648 vss.n1517 0.139432
R16983 vss.n1643 vss.n1642 0.139432
R16984 vss.n1633 vss.n1530 0.139432
R16985 vss.n1628 vss.n1627 0.139432
R16986 vss.n1619 vss.n1543 0.139432
R16987 vss.n1613 vss.n1612 0.139432
R16988 vss.n1604 vss.n1556 0.139432
R16989 vss.n1598 vss.n1597 0.139432
R16990 vss.n1589 vss.n1569 0.139432
R16991 vss.n1583 vss.n1577 0.139432
R16992 vss.n5318 vss.n5057 0.139432
R16993 vss.n6250 vss.n6249 0.139432
R16994 vss.n6272 vss.n6271 0.139432
R16995 vss.n3987 vss.n3986 0.139432
R16996 vss.n3933 vss.n3932 0.139432
R16997 vss.n3249 vss.n3248 0.139432
R16998 vss.n3912 vss.n3911 0.139432
R16999 vss.n3904 vss.n3899 0.139432
R17000 vss.n86 vss.n70 0.138914
R17001 vss.n86 vss.n69 0.138914
R17002 vss.n4382 vss.n4379 0.138289
R17003 vss.n5116 vss.n5115 0.138289
R17004 vss.n5126 vss.n5125 0.138289
R17005 vss.n5150 vss.n5148 0.138289
R17006 vss.n5499 vss.n5498 0.138276
R17007 vss.n3164 vss.n3070 0.137039
R17008 vss.n3174 vss.n3173 0.137039
R17009 vss.n3195 vss.n3194 0.137039
R17010 vss.n3047 vss.n3045 0.137039
R17011 vss.n5113 vss.n5110 0.137039
R17012 vss.n5160 vss.n5159 0.137039
R17013 vss.n5541 vss.n5540 0.134495
R17014 vss.n6349 vss.n2420 0.133993
R17015 vss.n6163 vss.n2701 0.133538
R17016 vss.n5292 vss.n5291 0.133289
R17017 vss.n5123 vss.n5120 0.133289
R17018 vss.n5132 vss.n5130 0.133289
R17019 vss.n5144 vss.n5143 0.133289
R17020 vss.n5627 vss.n5626 0.133289
R17021 vss.n6338 vss.n2426 0.133101
R17022 vss.n2410 vss.n2408 0.132963
R17023 vss.n3684 vss.n3400 0.1325
R17024 vss.n5138 vss.n5137 0.132039
R17025 vss.n5540 vss.n5539 0.131397
R17026 vss.n4367 vss.n4366 0.130486
R17027 vss.n3025 vss.n3023 0.129539
R17028 vss.n4348 vss.n4346 0.128289
R17029 vss.n5181 vss.n5180 0.128
R17030 vss.n5172 vss.n5171 0.128
R17031 vss.n287 vss.n285 0.12728
R17032 vss.n287 vss.n286 0.12728
R17033 vss.n4525 vss.n4524 0.12722
R17034 vss.n4523 vss.n4496 0.12722
R17035 vss.n4521 vss.n4519 0.12722
R17036 vss.n3023 vss.n3022 0.127039
R17037 vss.n2415 vss.n2413 0.12689
R17038 vss.n4405 vss.n4342 0.125789
R17039 vss.n3039 vss.n3038 0.125789
R17040 vss.n5107 vss.n5105 0.125789
R17041 vss.n5406 vss.n5405 0.125789
R17042 vss.n5137 vss.n5136 0.124539
R17043 vss.n5120 vss.n5119 0.123289
R17044 vss.n5130 vss.n5129 0.123289
R17045 vss.n5147 vss.n5144 0.123289
R17046 vss.n2404 vss.n2403 0.123027
R17047 vss.n4352 vss.n4350 0.122039
R17048 vss.n3084 vss.n3083 0.122039
R17049 vss.n3172 vss.n3169 0.122039
R17050 vss.n3199 vss.n3197 0.122039
R17051 vss.n5109 vss.n5108 0.122039
R17052 vss.n5164 vss.n5163 0.122039
R17053 vss.n6354 vss.n2426 0.121929
R17054 vss.n5482 vss.n5481 0.121879
R17055 vss.n5383 vss.n5355 0.121879
R17056 vss.n3235 vss.n3234 0.121192
R17057 vss.n5620 vss.n5609 0.1205
R17058 vss.n826 vss.n5619 0.108289
R17059 vss.n5386 vss.n5385 0.1205
R17060 vss.n5390 vss.n5389 0.1205
R17061 vss.n5394 vss.n5393 0.1205
R17062 vss.n917 vss.n918 0.191538
R17063 vss.n922 vss.n923 0.191538
R17064 vss.n927 vss.n928 0.191538
R17065 vss.n932 vss.n933 0.191538
R17066 vss.n937 vss.n938 0.191538
R17067 vss.n942 vss.n943 0.191538
R17068 vss.n947 vss.n948 0.191538
R17069 vss.n3072 vss.n3070 0.119539
R17070 vss.n3174 vss.n3172 0.119539
R17071 vss.n3197 vss.n3195 0.119539
R17072 vss.n3203 vss.n3045 0.119539
R17073 vss.n5110 vss.n5109 0.119539
R17074 vss.n5163 vss.n5160 0.119539
R17075 vss.n4267 vss.n4266 0.118289
R17076 vss.n5119 vss.n5116 0.118289
R17077 vss.n5129 vss.n5126 0.118289
R17078 vss.n5148 vss.n5147 0.118289
R17079 vss.n6347 vss.n2416 0.117627
R17080 vss.n5197 vss.n5196 0.117571
R17081 vss.n5204 vss.n5195 0.117571
R17082 vss.n3017 vss.n3016 0.117039
R17083 vss.n5136 vss.n5133 0.117039
R17084 vss.n5304 vss.n5086 0.116146
R17085 vss.n2418 vss.n2416 0.11613
R17086 vss.n3169 vss.n3168 0.115789
R17087 vss.n3199 vss.n3198 0.115789
R17088 vss.n3028 vss.n3026 0.115789
R17089 vss.n5108 vss.n5107 0.115789
R17090 vss.n5165 vss.n5164 0.115789
R17091 vss.n171 vss.n5629 0.175825
R17092 vss.n5624 vss.n5622 0.115789
R17093 vss.n5616 vss.n5615 0.115789
R17094 vss.n5613 vss.n5610 0.115789
R17095 vss.n3022 vss.n3020 0.114539
R17096 vss.n5185 vss.n5105 0.114539
R17097 vss.n5429 vss.n5428 0.114539
R17098 vss.n5418 vss.n5417 0.114539
R17099 vss.n5029 vss.n5028 0.114213
R17100 vss.n5019 vss.n5018 0.114213
R17101 vss.n5382 vss.n5356 0.113878
R17102 vss.n5189 vss.n5187 0.113692
R17103 vss.n5485 vss.n5484 0.113539
R17104 vss.n5248 vss.n5247 0.113354
R17105 vss.n914 vss.n5356 0.170805
R17106 vss.n6361 vss.n2377 0.112572
R17107 vss.n4281 vss.n4280 0.112039
R17108 vss.n3026 vss.n3025 0.112039
R17109 vss.n5929 vss.n5928 0.112039
R17110 vss.n5937 vss.n5936 0.112039
R17111 vss.n5945 vss.n5944 0.112039
R17112 vss.n5862 vss.n5860 0.112039
R17113 vss.n5758 vss.n5756 0.112039
R17114 vss.n5824 vss.n5822 0.112039
R17115 vss.n6008 vss.n483 0.112039
R17116 vss.n5999 vss.n5998 0.112039
R17117 vss.n5993 vss.n5992 0.112039
R17118 vss.n5977 vss.n5976 0.112039
R17119 vss.n5970 vss.n5969 0.112039
R17120 vss.n5954 vss.n5953 0.112039
R17121 vss.n5692 vss.n5691 0.112039
R17122 vss.n5676 vss.n5675 0.112039
R17123 vss.n5669 vss.n5668 0.112039
R17124 vss.n5653 vss.n5652 0.112039
R17125 vss.n5646 vss.n5645 0.112039
R17126 vss.n4364 vss.n4363 0.109539
R17127 vss.n3704 vss.n17 0.51362
R17128 vss.n5291 vss.n5100 0.108289
R17129 vss.n5124 vss.n5123 0.108289
R17130 vss.n5133 vss.n5132 0.108289
R17131 vss.n5795 vss.n5794 0.108289
R17132 vss.n2403 vss.n2402 0.107398
R17133 vss.n6356 vss.n2425 0.107325
R17134 vss.n5385 vss.n5384 0.10675
R17135 vss.n5389 vss.n5388 0.10675
R17136 vss.n5393 vss.n5392 0.10675
R17137 vss.n5397 vss.n453 0.191538
R17138 vss.n5400 vss.n455 0.191538
R17139 vss.n5403 vss.n457 0.191538
R17140 vss.n3965 vss.n917 0.0362711
R17141 vss.n3863 vss.n922 0.0362711
R17142 vss.n3756 vss.n927 0.0362711
R17143 vss.n3839 vss.n932 0.0362711
R17144 vss.n3767 vss.n937 0.0362711
R17145 vss.n3820 vss.n942 0.0362711
R17146 vss.n3803 vss.n947 0.0362711
R17147 vss.n3234 vss.n3231 0.105881
R17148 vss.n3240 vss.n3239 0.105881
R17149 vss.n6342 vss.n2399 0.1055
R17150 vss.n4392 vss.n4355 0.104539
R17151 vss.n5114 vss.n5113 0.104539
R17152 vss.n2400 vss.n2399 0.103697
R17153 vss.n3232 vss.n3231 0.103381
R17154 vss.n3240 vss.n3238 0.103381
R17155 vss.n4357 vss.n4355 0.103289
R17156 vss.n5115 vss.n5114 0.103289
R17157 vss.n5125 vss.n5124 0.103289
R17158 vss.n3019 vss.n3017 0.099539
R17159 vss.n3238 vss.n3237 0.0994928
R17160 vss.n5015 vss.n5012 0.0989663
R17161 vss.n4350 vss.n4349 0.098289
R17162 vss.n5200 vss.n5199 0.0972169
R17163 vss.n5203 vss.n5202 0.0972169
R17164 vss.n5256 vss.n5251 0.097039
R17165 vss.n6148 vss.n742 0.0957642
R17166 vss.n3236 vss.n3235 0.0933544
R17167 vss.n4398 vss.n4346 0.093289
R17168 vss.n5624 vss.n5623 0.093289
R17169 vss.n5617 vss.n5616 0.093289
R17170 vss.n5614 vss.n5613 0.093289
R17171 vss.n6227 vss.n6226 0.088
R17172 vss.n3785 vss.n3784 0.088
R17173 vss.n2679 vss.n2678 0.088
R17174 vss.n5623 vss.n5607 0.088
R17175 vss.n6248 vss.n6247 0.088
R17176 vss.n6270 vss.n6269 0.088
R17177 vss.n5365 vss.n5364 0.088
R17178 vss.n3972 vss.n3969 0.088
R17179 vss.n3992 vss.n3989 0.088
R17180 vss.n3931 vss.n3930 0.088
R17181 vss.n3247 vss.n3246 0.088
R17182 vss.n3898 vss.n3897 0.088
R17183 vss.n3915 vss.n3913 0.088
R17184 vss.n3870 vss.n3867 0.088
R17185 vss.n3763 vss.n3760 0.088
R17186 vss.n3846 vss.n3843 0.088
R17187 vss.n3774 vss.n3771 0.088
R17188 vss.n3827 vss.n3824 0.088
R17189 vss.n3810 vss.n3807 0.088
R17190 vss.n3950 vss.n3949 0.088
R17191 vss.n23 vss.n5024 12.6222
R17192 vss.n6343 vss.n2407 0.0855861
R17193 vss.n6414 vss 0.0855
R17194 vss.n1582 vss.n1580 0.0855
R17195 vss.n1596 vss.n1595 0.0855
R17196 vss.n1563 vss.n1561 0.0855
R17197 vss.n1611 vss.n1610 0.0855
R17198 vss.n1550 vss.n1548 0.0855
R17199 vss.n1626 vss.n1625 0.0855
R17200 vss.n1537 vss.n1535 0.0855
R17201 vss.n1641 vss.n1640 0.0855
R17202 vss.n1524 vss.n1522 0.0855
R17203 vss.n1656 vss.n1655 0.0855
R17204 vss.n1662 vss.n1660 0.0855
R17205 vss.n1676 vss.n1675 0.0855
R17206 vss.n1503 vss.n1501 0.0855
R17207 vss.n1691 vss.n1690 0.0855
R17208 vss.n1697 vss.n1695 0.0855
R17209 vss.n1711 vss.n1710 0.0855
R17210 vss.n1717 vss.n1715 0.0855
R17211 vss.n2457 vss.n2456 0.0855
R17212 vss.n2471 vss.n2470 0.0855
R17213 vss.n2368 vss.n2366 0.0855
R17214 vss.n6310 vss.n6309 0.0855
R17215 vss.n5477 vss.n5034 0.0855
R17216 vss.n5464 vss.n5462 0.0855
R17217 vss.n5450 vss.n5449 0.0855
R17218 vss.n5455 vss.n5454 0.0855
R17219 vss.n5388 vss.n5387 0.0855
R17220 vss.n5392 vss.n5391 0.0855
R17221 vss.n5396 vss.n5395 0.0855
R17222 vss.n5399 vss.n5398 0.0855
R17223 vss.n5402 vss.n5401 0.0855
R17224 vss.n2406 vss.n2405 0.0845109
R17225 vss.n3620 vss.n3400 0.0834714
R17226 vss.n4382 vss.n4381 0.083289
R17227 vss.n4259 vss.n4258 0.083
R17228 vss.n6000 vss.n797 0.202986
R17229 vss.n5978 vss.n803 0.202986
R17230 vss.n5955 vss.n809 0.202986
R17231 vss.n5677 vss.n815 0.202986
R17232 vss.n5654 vss.n821 0.202986
R17233 vss.n5443 vss.n5441 0.082375
R17234 vss.n287 vss.n277 0.0819387
R17235 vss.n5015 vss.n5014 0.0816111
R17236 vss.n5539 vss.n5538 0.0816111
R17237 vss.n5531 vss.n5529 0.0809571
R17238 vss.n2950 vss.n2949 0.0809403
R17239 vss.n5188 vss.n5182 0.0808812
R17240 vss.n5366 vss.n5365 0.0801811
R17241 vss.n3951 vss.n3950 0.0801811
R17242 vss.n2680 vss.n2679 0.0801811
R17243 vss.n3786 vss.n3785 0.0801811
R17244 vss.n6228 vss.n6227 0.0801811
R17245 vss.n5061 vss.n5060 0.0801811
R17246 vss.n2336 vss.n2335 0.0801811
R17247 vss.n2366 vss.n2362 0.0801811
R17248 vss.n2471 vss.n2431 0.0801811
R17249 vss.n2458 vss.n2457 0.0801811
R17250 vss.n1715 vss.n1480 0.0801811
R17251 vss.n1712 vss.n1711 0.0801811
R17252 vss.n1695 vss.n1488 0.0801811
R17253 vss.n1692 vss.n1691 0.0801811
R17254 vss.n1501 vss.n1496 0.0801811
R17255 vss.n1678 vss.n1676 0.0801811
R17256 vss.n1660 vss.n1509 0.0801811
R17257 vss.n1657 vss.n1656 0.0801811
R17258 vss.n1522 vss.n1517 0.0801811
R17259 vss.n1643 vss.n1641 0.0801811
R17260 vss.n1535 vss.n1530 0.0801811
R17261 vss.n1628 vss.n1626 0.0801811
R17262 vss.n1548 vss.n1543 0.0801811
R17263 vss.n1613 vss.n1611 0.0801811
R17264 vss.n1561 vss.n1556 0.0801811
R17265 vss.n1598 vss.n1596 0.0801811
R17266 vss.n1580 vss.n1569 0.0801811
R17267 vss.n6249 vss.n6248 0.0801811
R17268 vss.n6271 vss.n6270 0.0801811
R17269 vss.n3989 vss.n3987 0.0801811
R17270 vss.n3932 vss.n3931 0.0801811
R17271 vss.n3248 vss.n3247 0.0801811
R17272 vss.n3913 vss.n3912 0.0801811
R17273 vss.n3899 vss.n3898 0.0801811
R17274 vss.n2413 vss.n2387 0.079567
R17275 vss.n800 vss.n5562 0.257049
R17276 vss.n806 vss.n5570 0.257049
R17277 vss.n812 vss.n5579 0.257049
R17278 vss.n818 vss.n5587 0.257049
R17279 vss.n825 vss.n5595 0.257049
R17280 vss.n3956 vss.n373 0.0794592
R17281 vss.n375 vss.n373 0.00637541
R17282 vss.n5320 vss.n5319 0.0794592
R17283 vss.n6312 vss.n2380 0.0780256
R17284 vss.n4358 vss.n4357 0.078
R17285 vss.n6012 vss.n5553 0.078
R17286 vss.n2385 vss.n2384 0.0775292
R17287 vss.n4393 vss.n4392 0.07675
R17288 vss.n5257 vss.n5254 0.07675
R17289 vss.n6019 vss.n5029 0.0746819
R17290 vss.n5018 vss.n5017 0.0746819
R17291 vss.n5482 vss.n5480 0.07425
R17292 vss.n5384 vss.n5383 0.07425
R17293 vss.n6345 vss.n2412 0.0731895
R17294 vss.n5620 vss.n5619 0.073
R17295 vss.n826 vss.n5618 0.133289
R17296 vss.n5294 vss.n5293 0.07175
R17297 vss.n742 vss.n2980 0.0712736
R17298 vss.n2389 vss.n2388 0.0711601
R17299 vss.n2665 vss.n1472 0.0699737
R17300 vss.n4363 vss.n4362 0.06925
R17301 vss.n5260 vss.n5259 0.06925
R17302 vss.n6009 vss.n6008 0.06925
R17303 vss.n6347 vss.n2384 0.0686303
R17304 vss.n6355 vss.n6354 0.0685567
R17305 vss.n5607 vss.n5606 0.068
R17306 vss.n2854 vss.n2853 0.0673212
R17307 vss.n6168 vss.n6167 0.0673212
R17308 vss.n4518 vss.n4507 0.0671462
R17309 vss.n4 vss.n0 0.0669062
R17310 vss.n5185 vss.n5102 0.06675
R17311 vss.n738 vss.n5181 0.198309
R17312 vss.n4376 vss.n4375 0.0655
R17313 vss.n4386 vss.n4358 0.0655
R17314 vss.n4393 vss.n4391 0.0655
R17315 vss.n5261 vss.n5260 0.0655
R17316 vss.n171 vss.n5604 0.185486
R17317 vss.n5629 vss.n5628 0.0655
R17318 vss.n5622 vss.n5621 0.0655
R17319 vss.n2405 vss.n2404 0.0651195
R17320 vss.n2392 vss.n2391 0.0641177
R17321 vss.n6123 vss.n6120 0.0640556
R17322 vss.n6127 vss.n6126 0.0640556
R17323 vss.n6138 vss.n6137 0.0640556
R17324 vss.n6142 vss.n6139 0.0640556
R17325 vss.n4362 vss.n4360 0.063289
R17326 vss.n6324 vss.n2430 0.0626087
R17327 vss.n522 vss.n2668 0.140569
R17328 vss.n517 vss.n3779 0.140569
R17329 vss.n2669 vss.n512 0.140569
R17330 vss.n477 vss.n6241 0.140569
R17331 vss.n2663 vss.n471 0.140569
R17332 vss.n5478 vss.n468 0.140569
R17333 vss.n5475 vss.n5473 0.062039
R17334 vss.n5466 vss.n5465 0.062039
R17335 vss.n462 vss.n5341 0.140569
R17336 vss.n5453 vss.n5452 0.062039
R17337 vss.n5456 vss.n5444 0.062039
R17338 vss.n5357 vss.n370 0.140569
R17339 vss.n3748 vss.n423 0.140569
R17340 vss.n417 vss.n3925 0.140569
R17341 vss.n3242 vss.n413 0.140569
R17342 vss.n409 vss.n3877 0.140569
R17343 vss.n3883 vss.n406 0.140569
R17344 vss.n374 vss.n3945 0.140569
R17345 vss.n2407 vss.n2406 0.0619634
R17346 vss.n5633 vss.n5603 0.06175
R17347 vss.n5609 vss.n5608 0.06175
R17348 vss.n2393 vss.n2392 0.0609629
R17349 vss.n4406 vss.n4405 0.060789
R17350 vss.n2411 vss.n2390 0.0606465
R17351 vss.n6037 vss.n6036 0.0597761
R17352 vss.n4353 vss.n4352 0.05925
R17353 vss.n5634 vss.n5633 0.05925
R17354 vss.n5621 vss.n5608 0.05925
R17355 vss.n2408 vss.n2391 0.0586132
R17356 vss.n5470 vss.n5469 0.0581448
R17357 vss.n4374 vss.n4373 0.058
R17358 vss.n2414 vss.n2386 0.0579325
R17359 vss.n2388 vss.n2387 0.0576772
R17360 vss.n2412 vss.n2411 0.0564402
R17361 vss.n4375 vss.n4374 0.0555
R17362 vss.n4389 vss.n4386 0.0555
R17363 vss.n4391 vss.n4353 0.0555
R17364 vss.n3204 vss.n3041 0.0555
R17365 vss.n5302 vss.n5089 0.0555
R17366 vss.n5255 vss.n5253 0.0555
R17367 vss.n5630 vss.n5604 0.0555
R17368 vss.n5469 vss.n5467 0.0539595
R17369 vss.n5204 vss.n5182 0.0533812
R17370 vss.n794 vss.n5173 0.107705
R17371 vss.n5636 vss.n5635 0.053
R17372 vss.n5625 vss.n5606 0.053
R17373 vss.n2386 vss.n2385 0.0524113
R17374 vss.n5259 vss.n5254 0.05175
R17375 vss.n4411 vss.n4410 0.0512692
R17376 vss.n6343 vss.n2393 0.0506614
R17377 vss.n6349 vss.n2383 0.0491922
R17378 vss.n2969 vss.n2703 0.0491313
R17379 vss.n2943 vss.n2942 0.0489879
R17380 vss.n5301 vss.n5162 0.0487138
R17381 vss.n5301 vss.n5152 0.0487138
R17382 vss.n5301 vss.n5134 0.0487138
R17383 vss.n5301 vss.n5106 0.0487138
R17384 vss.n5301 vss.n5104 0.0487138
R17385 vss.n287 vss.n282 0.0482062
R17386 vss.n287 vss.n283 0.0482062
R17387 vss.n5626 vss.n5625 0.048
R17388 vss.n6312 vss.n2381 0.047937
R17389 vss.n5458 vss.n435 0.0471866
R17390 vss.n5460 vss.n437 0.0471866
R17391 vss.t2007 vss.n461 177.697
R17392 vss.n437 vss.n459 0.0471866
R17393 vss.n437 vss.n460 0.0471866
R17394 vss.n466 vss.n465 0.0471866
R17395 vss.n466 vss.n463 0.0471866
R17396 vss.n5512 vss.n5511 0.0466111
R17397 vss.n6123 vss.n6122 0.0445
R17398 vss.n6127 vss.n6124 0.0445
R17399 vss.n6138 vss.n6135 0.0445
R17400 vss.n6142 vss.n6141 0.0445
R17401 vss.n5257 vss.n5253 0.04425
R17402 vss.n6345 vss.n2389 0.043772
R17403 vss.n2417 vss.n2383 0.0431093
R17404 vss.n4379 vss.n4376 0.043
R17405 vss.n6009 vss.n6007 0.043
R17406 vss.n6162 vss.n2703 0.0417178
R17407 vss.n2398 vss.n2397 0.0405262
R17408 vss.n6317 vss.n2430 0.0401843
R17409 vss.n4248 vss.n4247 0.03925
R17410 vss.n5737 vss.n5696 0.03925
R17411 vss.n5693 vss.n5577 0.03925
R17412 vss.n5628 vss.n5605 0.03925
R17413 vss.n2396 vss.n2395 0.0391133
R17414 vss.n6001 vss.n6000 0.038
R17415 vss.n5979 vss.n5978 0.038
R17416 vss.n5956 vss.n5955 0.038
R17417 vss.n5678 vss.n5677 0.038
R17418 vss.n5655 vss.n5654 0.038
R17419 vss.n5631 vss.n5630 0.038
R17420 vss.n5480 vss.n5479 0.0366013
R17421 vss.n5451 vss.n5450 0.0366013
R17422 vss.n5462 vss.n5461 0.0366013
R17423 vss.n5360 vss.n5359 0.0366013
R17424 vss.n3958 vss.n3957 0.0366013
R17425 vss.n2673 vss.n2672 0.0366013
R17426 vss.n3796 vss.n3794 0.0366013
R17427 vss.n6238 vss.n6236 0.0366013
R17428 vss.n6259 vss.n6257 0.0366013
R17429 vss.n6264 vss.n6263 0.0366013
R17430 vss.n3980 vss.n3979 0.0366013
R17431 vss.n3942 vss.n3940 0.0366013
R17432 vss.n3922 vss.n3243 0.0366013
R17433 vss.n3886 vss.n3885 0.0366013
R17434 vss.n3919 vss.n3917 0.0366013
R17435 vss.n5054 vss.n5053 0.0362697
R17436 vss.n6391 vss.n6390 0.0362697
R17437 vss.n6387 vss.n6385 0.0362697
R17438 vss.n2685 vss.n2684 0.0362697
R17439 vss.n3791 vss.n3790 0.0362697
R17440 vss.n6233 vss.n6232 0.0362697
R17441 vss.n5066 vss.n5065 0.0362697
R17442 vss.n2341 vss.n2340 0.0362697
R17443 vss.n2369 vss.n2368 0.0362697
R17444 vss.n2456 vss.n2450 0.0362697
R17445 vss.n1710 vss.n1704 0.0362697
R17446 vss.n1690 vss.n1684 0.0362697
R17447 vss.n1504 vss.n1503 0.0362697
R17448 vss.n1655 vss.n1649 0.0362697
R17449 vss.n1525 vss.n1524 0.0362697
R17450 vss.n1640 vss.n1634 0.0362697
R17451 vss.n1538 vss.n1537 0.0362697
R17452 vss.n1551 vss.n1550 0.0362697
R17453 vss.n1564 vss.n1563 0.0362697
R17454 vss.n1584 vss.n1582 0.0362697
R17455 vss.n1595 vss.n1590 0.0362697
R17456 vss.n1610 vss.n1605 0.0362697
R17457 vss.n1625 vss.n1620 0.0362697
R17458 vss.n1664 vss.n1662 0.0362697
R17459 vss.n1675 vss.n1670 0.0362697
R17460 vss.n1699 vss.n1697 0.0362697
R17461 vss.n1719 vss.n1717 0.0362697
R17462 vss.n6400 vss.n6399 0.0362697
R17463 vss.n2470 vss.n2469 0.0362697
R17464 vss.n6309 vss.n2375 0.0362697
R17465 vss.n5322 vss.n5321 0.0362697
R17466 vss.n5326 vss.n5325 0.0362697
R17467 vss.n6376 vss.n6375 0.0362697
R17468 vss.n2350 vss.n2349 0.0362697
R17469 vss.n2528 vss.n2527 0.0362697
R17470 vss.n2524 vss.n2522 0.0362697
R17471 vss.n2515 vss.n2513 0.0362697
R17472 vss.n2499 vss.n2498 0.0362697
R17473 vss.n2539 vss.n2537 0.0362697
R17474 vss.n2543 vss.n2542 0.0362697
R17475 vss.n2481 vss.n2480 0.0362697
R17476 vss.n2553 vss.n2551 0.0362697
R17477 vss.n2594 vss.n2593 0.0362697
R17478 vss.n6303 vss.n6301 0.0362697
R17479 vss.n6254 vss.n6253 0.0362697
R17480 vss.n6276 vss.n6275 0.0362697
R17481 vss.n5476 vss.n5034 0.0362697
R17482 vss.n5457 vss.n5455 0.0362697
R17483 vss.n3975 vss.n3973 0.0362697
R17484 vss.n3985 vss.n3984 0.0362697
R17485 vss.n3937 vss.n3936 0.0362697
R17486 vss.n3874 vss.n3872 0.0362697
R17487 vss.n3856 vss.n3854 0.0362697
R17488 vss.n3851 vss.n3850 0.0362697
R17489 vss.n3834 vss.n3833 0.0362697
R17490 vss.n3830 vss.n3828 0.0362697
R17491 vss.n3813 vss.n3811 0.0362697
R17492 vss.n369 vss.n367 0.0353859
R17493 vss.n2409 vss.n2390 0.0350916
R17494 vss.n6321 vss.n6316 0.0343412
R17495 vss.n6310 vss.n2360 0.0337079
R17496 vss.n2873 vss.n2872 0.0336067
R17497 vss.n6328 vss.n6327 0.0335
R17498 vss.n5531 vss 0.0331857
R17499 vss.n5551 vss 0.0331857
R17500 vss.n4381 vss.n4380 0.033
R17501 vss.n5102 vss.n5101 0.033
R17502 vss.n3233 vss.n3232 0.033
R17503 vss.n5615 vss.n5614 0.033
R17504 vss vss.n6414 0.0321949
R17505 vss.n5992 vss.n5991 0.03175
R17506 vss.n5969 vss.n5968 0.03175
R17507 vss.n5691 vss.n5690 0.03175
R17508 vss.n5668 vss.n5667 0.03175
R17509 vss.n5645 vss.n5644 0.03175
R17510 vss.n1176 vss.n1175 0.0317288
R17511 vss.n1216 vss.n1061 0.0317288
R17512 vss.n2397 vss.n2396 0.0304968
R17513 vss.n5483 vss.n5482 0.0296531
R17514 vss.n5472 vss.n5470 0.0295711
R17515 vss.n4399 vss.n4398 0.02925
R17516 vss.n5295 vss.n5293 0.02925
R17517 vss.n5256 vss.n5255 0.02925
R17518 vss.n6159 vss.n2701 0.028934
R17519 vss.n2853 vss.n2850 0.0287051
R17520 vss.n6168 vss.n2699 0.0287051
R17521 vss.n1351 vss.n1159 0.0284661
R17522 vss.n1353 vss.n1150 0.0284661
R17523 vss.n1340 vss.n1146 0.0284661
R17524 vss.n1357 vss.n1165 0.0284661
R17525 vss.n1336 vss.n1168 0.0284661
R17526 vss.n1334 vss.n1138 0.0284661
R17527 vss.n1366 vss.n1134 0.0284661
R17528 vss.n1331 vss.n1170 0.0284661
R17529 vss.n1368 vss.n1171 0.0284661
R17530 vss.n1369 vss.n1130 0.0284661
R17531 vss.n1325 vss.n1128 0.0284661
R17532 vss.n1371 vss.n1173 0.0284661
R17533 vss.n1323 vss.n1177 0.0284661
R17534 vss.n1322 vss.n1123 0.0284661
R17535 vss.n1378 vss.n1120 0.0284661
R17536 vss.n1319 vss.n1179 0.0284661
R17537 vss.n1380 vss.n1180 0.0284661
R17538 vss.n1381 vss.n1116 0.0284661
R17539 vss.n1313 vss.n1114 0.0284661
R17540 vss.n1383 vss.n1182 0.0284661
R17541 vss.n1309 vss.n1184 0.0284661
R17542 vss.n1307 vss.n1109 0.0284661
R17543 vss.n1392 vss.n1107 0.0284661
R17544 vss.n1303 vss.n1187 0.0284661
R17545 vss.n1396 vss.n1188 0.0284661
R17546 vss.n1398 vss.n1102 0.0284661
R17547 vss.n1293 vss.n1100 0.0284661
R17548 vss.n1402 vss.n1190 0.0284661
R17549 vss.n1291 vss.n1098 0.0284661
R17550 vss.n1406 vss.n1193 0.0284661
R17551 vss.n1408 vss.n1096 0.0284661
R17552 vss.n1287 vss.n1197 0.0284661
R17553 vss.n1412 vss.n1201 0.0284661
R17554 vss.n1280 vss.n1202 0.0284661
R17555 vss.n1419 vss.n1203 0.0284661
R17556 vss.n1273 vss.n1204 0.0284661
R17557 vss.n1271 vss.n1084 0.0284661
R17558 vss.n1429 vss.n1082 0.0284661
R17559 vss.n1267 vss.n1207 0.0284661
R17560 vss.n1433 vss.n1208 0.0284661
R17561 vss.n1435 vss.n1077 0.0284661
R17562 vss.n1258 vss.n1074 0.0284661
R17563 vss.n1440 vss.n1210 0.0284661
R17564 vss.n1256 vss.n1211 0.0284661
R17565 vss.n1255 vss.n1070 0.0284661
R17566 vss.n1446 vss.n1068 0.0284661
R17567 vss.n1253 vss.n1213 0.0284661
R17568 vss.n1448 vss.n1214 0.0284661
R17569 vss.n1449 vss.n1063 0.0284661
R17570 vss.n1246 vss.n1060 0.0284661
R17571 vss.n1452 vss.n1219 0.0284661
R17572 vss.n1244 vss.n1220 0.0284661
R17573 vss.n1243 vss.n1056 0.0284661
R17574 vss.n1458 vss.n1054 0.0284661
R17575 vss.n1241 vss.n1222 0.0284661
R17576 vss.n1461 vss.n1223 0.0284661
R17577 vss.n1462 vss.n1048 0.0284661
R17578 vss.n1234 vss.n1046 0.0284661
R17579 vss.n1464 vss.n1225 0.0284661
R17580 vss.n1232 vss.n1226 0.0284661
R17581 vss.n1231 vss.n1042 0.0284661
R17582 vss.n5296 vss.n5294 0.028
R17583 vss.n1194 vss.n1095 0.0275339
R17584 vss.n1199 vss.n1198 0.0275339
R17585 vss.n900 vss.n898 0.0263175
R17586 vss.n2599 vss.n894 0.0263175
R17587 vss.n890 vss.n888 0.0263175
R17588 vss.n2486 vss.n884 0.0263175
R17589 vss.n2548 vss.n880 0.0263175
R17590 vss.n876 vss.n874 0.0263175
R17591 vss.n2504 vss.n870 0.0263175
R17592 vss.n866 vss.n864 0.0263175
R17593 vss.n860 vss.n858 0.0263175
R17594 vss.n2533 vss.n854 0.0263175
R17595 vss.n849 vss.n847 0.0263175
R17596 vss.n2687 vss.n511 0.0258175
R17597 vss.t1648 vss.n513 252.065
R17598 vss.n3793 vss.n516 0.0258175
R17599 vss.n518 vss.n516 0.00196766
R17600 vss.n6235 vss.n521 0.0258175
R17601 vss.t1622 vss.n523 252.065
R17602 vss.n5070 vss.n5067 0.0258175
R17603 vss.n2343 vss.n2342 0.0258175
R17604 vss.n6256 vss.n475 0.0258175
R17605 vss.t1605 vss.n476 252.065
R17606 vss.n6278 vss.n470 0.0258175
R17607 vss.t1588 vss.n472 252.065
R17608 vss.n3966 vss.n915 0.0258175
R17609 vss.n426 vss.n425 0.0258175
R17610 vss.n3993 vss.n421 0.0258175
R17611 vss.n422 vss.n421 0.00196766
R17612 vss.n3939 vss.n416 0.0258175
R17613 vss.n418 vss.n416 0.00196766
R17614 vss.n3864 vss.n920 0.0258175
R17615 vss.n401 vss.n400 0.0258175
R17616 vss.n3757 vss.n925 0.0258175
R17617 vss.n396 vss.n395 0.0258175
R17618 vss.n3840 vss.n930 0.0258175
R17619 vss.n391 vss.n390 0.0258175
R17620 vss.n3768 vss.n935 0.0258175
R17621 vss.n387 vss.n386 0.0258175
R17622 vss.n3821 vss.n940 0.0258175
R17623 vss.n383 vss.n382 0.0258175
R17624 vss.n3804 vss.n945 0.0258175
R17625 vss.n378 vss.n377 0.0258175
R17626 vss.n1347 vss.n1346 0.0252034
R17627 vss.n1360 vss.n1359 0.0252034
R17628 vss.n1330 vss.n1329 0.0252034
R17629 vss.n1373 vss.n1372 0.0252034
R17630 vss.n1318 vss.n1317 0.0252034
R17631 vss.n1385 vss.n1384 0.0252034
R17632 vss.n1301 vss.n1300 0.0252034
R17633 vss.n1427 vss.n1426 0.0252034
R17634 vss.n1261 vss.n1260 0.0252034
R17635 vss.n1445 vss.n1444 0.0252034
R17636 vss.n1248 vss.n1247 0.0252034
R17637 vss.n1457 vss.n1456 0.0252034
R17638 vss.n1236 vss.n1235 0.0252034
R17639 vss.n1469 vss.n1468 0.0252034
R17640 vss.n5201 vss.n5200 0.0247169
R17641 vss.n5202 vss.n5201 0.0247169
R17642 vss.n287 vss.n281 0.0233889
R17643 vss.n1347 vss.n1152 0.0233563
R17644 vss.n1351 vss.n1152 0.0233563
R17645 vss.n1353 vss.n1148 0.0233563
R17646 vss.n1343 vss.n1148 0.0233563
R17647 vss.n1340 vss.n1144 0.0233563
R17648 vss.n1357 vss.n1144 0.0233563
R17649 vss.n1360 vss.n1140 0.0233563
R17650 vss.n1336 vss.n1140 0.0233563
R17651 vss.n1334 vss.n1136 0.0233563
R17652 vss.n1365 vss.n1136 0.0233563
R17653 vss.n1366 vss.n1133 0.0233563
R17654 vss.n1331 vss.n1133 0.0233563
R17655 vss.n1330 vss.n1131 0.0233563
R17656 vss.n1368 vss.n1131 0.0233563
R17657 vss.n1369 vss.n1129 0.0233563
R17658 vss.n1327 vss.n1129 0.0233563
R17659 vss.n1325 vss.n1127 0.0233563
R17660 vss.n1371 vss.n1127 0.0233563
R17661 vss.n1322 vss.n1122 0.0233563
R17662 vss.n1377 vss.n1122 0.0233563
R17663 vss.n1378 vss.n1119 0.0233563
R17664 vss.n1319 vss.n1119 0.0233563
R17665 vss.n1318 vss.n1117 0.0233563
R17666 vss.n1380 vss.n1117 0.0233563
R17667 vss.n1381 vss.n1115 0.0233563
R17668 vss.n1315 vss.n1115 0.0233563
R17669 vss.n1313 vss.n1113 0.0233563
R17670 vss.n1383 vss.n1113 0.0233563
R17671 vss.n1385 vss.n1110 0.0233563
R17672 vss.n1309 vss.n1110 0.0233563
R17673 vss.n1307 vss.n1108 0.0233563
R17674 vss.n1390 vss.n1108 0.0233563
R17675 vss.n1392 vss.n1106 0.0233563
R17676 vss.n1303 vss.n1106 0.0233563
R17677 vss.n1301 vss.n1103 0.0233563
R17678 vss.n1396 vss.n1103 0.0233563
R17679 vss.n1398 vss.n1101 0.0233563
R17680 vss.n1296 vss.n1101 0.0233563
R17681 vss.n1293 vss.n1099 0.0233563
R17682 vss.n1402 vss.n1099 0.0233563
R17683 vss.n1415 vss.n1089 0.0233563
R17684 vss.n1280 vss.n1089 0.0233563
R17685 vss.n1278 vss.n1087 0.0233563
R17686 vss.n1419 vss.n1087 0.0233563
R17687 vss.n1422 vss.n1085 0.0233563
R17688 vss.n1273 vss.n1085 0.0233563
R17689 vss.n1271 vss.n1083 0.0233563
R17690 vss.n1427 vss.n1083 0.0233563
R17691 vss.n1429 vss.n1081 0.0233563
R17692 vss.n1267 vss.n1081 0.0233563
R17693 vss.n1265 vss.n1078 0.0233563
R17694 vss.n1433 vss.n1078 0.0233563
R17695 vss.n1435 vss.n1076 0.0233563
R17696 vss.n1261 vss.n1076 0.0233563
R17697 vss.n1258 vss.n1073 0.0233563
R17698 vss.n1440 vss.n1073 0.0233563
R17699 vss.n1442 vss.n1071 0.0233563
R17700 vss.n1256 vss.n1071 0.0233563
R17701 vss.n1255 vss.n1069 0.0233563
R17702 vss.n1445 vss.n1069 0.0233563
R17703 vss.n1446 vss.n1067 0.0233563
R17704 vss.n1253 vss.n1067 0.0233563
R17705 vss.n1252 vss.n1064 0.0233563
R17706 vss.n1448 vss.n1064 0.0233563
R17707 vss.n1246 vss.n1059 0.0233563
R17708 vss.n1452 vss.n1059 0.0233563
R17709 vss.n1454 vss.n1057 0.0233563
R17710 vss.n1244 vss.n1057 0.0233563
R17711 vss.n1243 vss.n1055 0.0233563
R17712 vss.n1457 vss.n1055 0.0233563
R17713 vss.n1458 vss.n1053 0.0233563
R17714 vss.n1241 vss.n1053 0.0233563
R17715 vss.n1240 vss.n1050 0.0233563
R17716 vss.n1461 vss.n1050 0.0233563
R17717 vss.n1462 vss.n1047 0.0233563
R17718 vss.n1236 vss.n1047 0.0233563
R17719 vss.n1234 vss.n1045 0.0233563
R17720 vss.n1464 vss.n1045 0.0233563
R17721 vss.n1466 vss.n1043 0.0233563
R17722 vss.n1232 vss.n1043 0.0233563
R17723 vss.n1231 vss.n1041 0.0233563
R17724 vss.n1469 vss.n1041 0.0233563
R17725 vss.n2424 vss.n2423 0.0233417
R17726 vss.n5305 vss.n5304 0.0231524
R17727 vss.n5304 vss.n2318 0.0231524
R17728 vss.n4389 vss.n4388 0.023
R17729 vss.n2402 vss.n2401 0.0219602
R17730 vss.n14 vss.n11 0.0219233
R17731 vss.n5167 vss.n3041 0.02175
R17732 vss.n1192 vss.n1191 0.0214746
R17733 vss.n6342 vss.n2398 0.0212762
R17734 vss.n1285 vss.n1284 0.0210085
R17735 vss.n1415 vss.n1414 0.0210085
R17736 vss.n1278 vss.n1277 0.0210085
R17737 vss.n5949 vss.n5696 0.0205
R17738 vss.n5950 vss.n5577 0.0205
R17739 vss.n2852 vss.n2850 0.0202436
R17740 vss.n6169 vss.n2699 0.0202436
R17741 vss.n5905 vss.n5552 0.01925
R17742 vss.n6013 vss.n6012 0.01925
R17743 vss.n6014 vss.n6013 0.01925
R17744 vss.n2401 vss.n2400 0.0192102
R17745 vss.n1349 vss.n1156 0.0172797
R17746 vss.n1349 vss.n1154 0.0172797
R17747 vss.n1345 vss.n1159 0.0172797
R17748 vss.n1345 vss.n1150 0.0172797
R17749 vss.n1355 vss.n1162 0.0172797
R17750 vss.n1355 vss.n1146 0.0172797
R17751 vss.n1338 vss.n1165 0.0172797
R17752 vss.n1338 vss.n1142 0.0172797
R17753 vss.n1362 vss.n1168 0.0172797
R17754 vss.n1362 vss.n1138 0.0172797
R17755 vss.n1332 vss.n1169 0.0172797
R17756 vss.n1332 vss.n1134 0.0172797
R17757 vss.n1367 vss.n1170 0.0172797
R17758 vss.n1367 vss.n1132 0.0172797
R17759 vss.n1328 vss.n1171 0.0172797
R17760 vss.n1328 vss.n1130 0.0172797
R17761 vss.n1370 vss.n1172 0.0172797
R17762 vss.n1370 vss.n1128 0.0172797
R17763 vss.n1324 vss.n1173 0.0172797
R17764 vss.n1324 vss.n1126 0.0172797
R17765 vss.n1375 vss.n1177 0.0172797
R17766 vss.n1375 vss.n1123 0.0172797
R17767 vss.n1320 vss.n1178 0.0172797
R17768 vss.n1320 vss.n1120 0.0172797
R17769 vss.n1379 vss.n1179 0.0172797
R17770 vss.n1379 vss.n1118 0.0172797
R17771 vss.n1316 vss.n1180 0.0172797
R17772 vss.n1316 vss.n1116 0.0172797
R17773 vss.n1382 vss.n1181 0.0172797
R17774 vss.n1382 vss.n1114 0.0172797
R17775 vss.n1312 vss.n1182 0.0172797
R17776 vss.n1387 vss.n1184 0.0172797
R17777 vss.n1387 vss.n1109 0.0172797
R17778 vss.n1305 vss.n1185 0.0172797
R17779 vss.n1305 vss.n1107 0.0172797
R17780 vss.n1394 vss.n1187 0.0172797
R17781 vss.n1394 vss.n1104 0.0172797
R17782 vss.n1298 vss.n1188 0.0172797
R17783 vss.n1298 vss.n1102 0.0172797
R17784 vss.n1400 vss.n1189 0.0172797
R17785 vss.n1400 vss.n1100 0.0172797
R17786 vss.n1404 vss.n1190 0.0172797
R17787 vss.n1404 vss.n1098 0.0172797
R17788 vss.n1289 vss.n1193 0.0172797
R17789 vss.n1289 vss.n1096 0.0172797
R17790 vss.n1410 vss.n1197 0.0172797
R17791 vss.n1410 vss.n1093 0.0172797
R17792 vss.n1282 vss.n1201 0.0172797
R17793 vss.n1282 vss.n1090 0.0172797
R17794 vss.n1417 vss.n1202 0.0172797
R17795 vss.n1417 vss.n1088 0.0172797
R17796 vss.n1275 vss.n1203 0.0172797
R17797 vss.n1275 vss.n1086 0.0172797
R17798 vss.n1424 vss.n1204 0.0172797
R17799 vss.n1424 vss.n1084 0.0172797
R17800 vss.n1269 vss.n1205 0.0172797
R17801 vss.n1269 vss.n1082 0.0172797
R17802 vss.n1431 vss.n1207 0.0172797
R17803 vss.n1431 vss.n1079 0.0172797
R17804 vss.n1263 vss.n1208 0.0172797
R17805 vss.n1263 vss.n1077 0.0172797
R17806 vss.n1439 vss.n1074 0.0172797
R17807 vss.n1257 vss.n1210 0.0172797
R17808 vss.n1257 vss.n1072 0.0172797
R17809 vss.n1443 vss.n1211 0.0172797
R17810 vss.n1443 vss.n1070 0.0172797
R17811 vss.n1254 vss.n1212 0.0172797
R17812 vss.n1254 vss.n1068 0.0172797
R17813 vss.n1447 vss.n1213 0.0172797
R17814 vss.n1447 vss.n1066 0.0172797
R17815 vss.n1249 vss.n1214 0.0172797
R17816 vss.n1249 vss.n1063 0.0172797
R17817 vss.n1451 vss.n1218 0.0172797
R17818 vss.n1451 vss.n1060 0.0172797
R17819 vss.n1245 vss.n1219 0.0172797
R17820 vss.n1245 vss.n1058 0.0172797
R17821 vss.n1455 vss.n1220 0.0172797
R17822 vss.n1455 vss.n1056 0.0172797
R17823 vss.n1242 vss.n1221 0.0172797
R17824 vss.n1242 vss.n1054 0.0172797
R17825 vss.n1459 vss.n1222 0.0172797
R17826 vss.n1459 vss.n1052 0.0172797
R17827 vss.n1237 vss.n1223 0.0172797
R17828 vss.n1237 vss.n1048 0.0172797
R17829 vss.n1463 vss.n1224 0.0172797
R17830 vss.n1463 vss.n1046 0.0172797
R17831 vss.n1233 vss.n1225 0.0172797
R17832 vss.n1233 vss.n1044 0.0172797
R17833 vss.n1467 vss.n1226 0.0172797
R17834 vss.n1467 vss.n1042 0.0172797
R17835 vss.n1230 vss.n1227 0.0172797
R17836 vss.n1230 vss.n1040 0.0172797
R17837 vss.n5014 vss.n5013 0.0171667
R17838 vss.n5538 vss.n5537 0.0171667
R17839 vss.n6414 vss.n6413 0.0168136
R17840 vss.n5030 vss.n1039 0.0168136
R17841 vss.n6408 vss.n6407 0.0168136
R17842 vss.n267 vss.n191 0.001328
R17843 vss.n6351 vss.n2424 0.0157792
R17844 vss.n6316 vss.n6315 0.0157787
R17845 vss.n4349 vss.n4348 0.0155
R17846 vss.n5618 vss.n5617 0.0155
R17847 vss.n1342 vss.n1162 0.0154153
R17848 vss.n1364 vss.n1169 0.0154153
R17849 vss.n1326 vss.n1172 0.0154153
R17850 vss.n1376 vss.n1178 0.0154153
R17851 vss.n1314 vss.n1181 0.0154153
R17852 vss.n1389 vss.n1185 0.0154153
R17853 vss.n1295 vss.n1189 0.0154153
R17854 vss.n1421 vss.n1086 0.0154153
R17855 vss.n1264 vss.n1079 0.0154153
R17856 vss.n1441 vss.n1072 0.0154153
R17857 vss.n1251 vss.n1066 0.0154153
R17858 vss.n1453 vss.n1058 0.0154153
R17859 vss.n1239 vss.n1052 0.0154153
R17860 vss.n1465 vss.n1044 0.0154153
R17861 vss.n5335 vss.n5036 0.0151816
R17862 vss.n5337 vss.n466 0.0151816
R17863 vss.n5336 vss.n466 0.0151816
R17864 vss.n6327 vss.n6326 0.01425
R17865 vss.n435 vss.n438 0.0142276
R17866 vss.n5380 vss.n429 0.0142276
R17867 vss.n5378 vss.n433 0.0142276
R17868 vss.n5376 vss.n435 0.0142276
R17869 vss.n5375 vss.n435 0.0142276
R17870 vss.n5374 vss.n435 0.0142276
R17871 vss.n5373 vss.n435 0.0142276
R17872 vss.n435 vss.n439 0.0142276
R17873 vss.n435 vss.n440 0.0142276
R17874 vss.n435 vss.n441 0.0142276
R17875 vss.n435 vss.n444 0.0142276
R17876 vss.n435 vss.n448 0.0142276
R17877 vss.n435 vss.n449 0.0142276
R17878 vss.n435 vss.n450 0.0142276
R17879 vss.n844 vss.n842 0.014134
R17880 vss.n6122 vss.n6121 0.0137759
R17881 vss.n6136 vss.n6135 0.0137759
R17882 vss.n6032 vss.n411 0.013634
R17883 vss.n412 vss.n411 0.00135799
R17884 vss.n1343 vss.n1342 0.0135508
R17885 vss.n1365 vss.n1364 0.0135508
R17886 vss.n1327 vss.n1326 0.0135508
R17887 vss.n1377 vss.n1376 0.0135508
R17888 vss.n1315 vss.n1314 0.0135508
R17889 vss.n1390 vss.n1389 0.0135508
R17890 vss.n1296 vss.n1295 0.0135508
R17891 vss.n1422 vss.n1421 0.0135508
R17892 vss.n1265 vss.n1264 0.0135508
R17893 vss.n1442 vss.n1441 0.0135508
R17894 vss.n1252 vss.n1251 0.0135508
R17895 vss.n1454 vss.n1453 0.0135508
R17896 vss.n1240 vss.n1239 0.0135508
R17897 vss.n1466 vss.n1465 0.0135508
R17898 vss.n1191 vss.n1097 0.0130847
R17899 vss.n5030 vss.n1156 0.0121525
R17900 vss.n6407 vss.n1040 0.0121525
R17901 vss.n6368 vss.n6367 0.0119721
R17902 vss.n6125 vss.n6124 0.0118793
R17903 vss.n6141 vss.n6140 0.0118793
R17904 vss.n531 vss.n527 0.0114518
R17905 vss.n6367 vss.n2364 0.0113816
R17906 vss.n4 vss.n2 0.0108526
R17907 vss.n1311 vss.n1112 0.00982203
R17908 vss.n1438 vss.n1209 0.00982203
R17909 vss.n5505 vss.n5502 0.00907745
R17910 vss.n14 vss.n10 1.46008
R17911 vss.n1312 vss.n1311 0.00795763
R17912 vss.n1284 vss.n1093 0.00795763
R17913 vss.n1414 vss.n1090 0.00795763
R17914 vss.n1277 vss.n1088 0.00795763
R17915 vss.n1439 vss.n1438 0.00795763
R17916 vss.n488 vss.n487 0.00772326
R17917 vss.n1195 vss.n1194 0.00702542
R17918 vss.n1198 vss.n1092 0.00702542
R17919 vss.n497 vss.n496 0.0071972
R17920 vss.n287 vss.n190 0.00681299
R17921 vss.n532 vss.n631 1.50568
R17922 vss.n86 vss.n26 0.00655946
R17923 vss.n6413 vss.n1039 0.00609322
R17924 vss.n1373 vss.n1176 0.00609322
R17925 vss.n1323 vss.n1125 0.00609322
R17926 vss.n1291 vss.n1192 0.00609322
R17927 vss.n1406 vss.n1097 0.00609322
R17928 vss.n1408 vss.n1195 0.00609322
R17929 vss.n1287 vss.n1095 0.00609322
R17930 vss.n1285 vss.n1199 0.00609322
R17931 vss.n1412 vss.n1092 0.00609322
R17932 vss.n1449 vss.n1217 0.00609322
R17933 vss.n1248 vss.n1061 0.00609322
R17934 vss.n6408 vss.n1228 0.00609322
R17935 vss.n6331 vss.n6330 0.006
R17936 vss.n745 vss.n5177 0.00581859
R17937 vss.n5184 vss.n5183 0.0055
R17938 vss.n5187 vss.n5181 0.0055
R17939 vss.n5248 vss.n5172 0.0055
R17940 vss.n6163 vss.n6162 0.00506604
R17941 vss.n1018 vss.n139 0.00495229
R17942 vss.n1014 vss.n137 0.00495229
R17943 vss.n1010 vss.n3703 0.00495229
R17944 vss.n1004 vss.n133 0.00495229
R17945 vss.n1000 vss.n131 0.00495229
R17946 vss.n991 vss.n151 0.00495229
R17947 vss.n987 vss.n149 0.00495229
R17948 vss.n983 vss.n3725 0.00495229
R17949 vss.n977 vss.n145 0.00495229
R17950 vss.n973 vss.n143 0.00495229
R17951 vss.n6037 vss.n3230 0.0038944
R17952 vss.n2860 vss.n653 0.00379837
R17953 vss.n2861 vss.n653 0.00379837
R17954 vss.n2862 vss.n653 0.00379837
R17955 vss.n2863 vss.n653 0.00379837
R17956 vss.n2939 vss.n2932 0.00379837
R17957 vss.n2939 vss.n2933 0.00379837
R17958 vss.n2939 vss.n2934 0.00379837
R17959 vss.n2939 vss.n2935 0.00379837
R17960 vss.n2939 vss.n2936 0.00379837
R17961 vss.n1346 vss.n1154 0.00376271
R17962 vss.n1359 vss.n1142 0.00376271
R17963 vss.n1329 vss.n1132 0.00376271
R17964 vss.n1372 vss.n1126 0.00376271
R17965 vss.n1317 vss.n1118 0.00376271
R17966 vss.n1384 vss.n1112 0.00376271
R17967 vss.n1300 vss.n1104 0.00376271
R17968 vss.n1426 vss.n1205 0.00376271
R17969 vss.n1260 vss.n1209 0.00376271
R17970 vss.n1444 vss.n1212 0.00376271
R17971 vss.n1247 vss.n1218 0.00376271
R17972 vss.n1456 vss.n1221 0.00376271
R17973 vss.n1235 vss.n1224 0.00376271
R17974 vss.n1468 vss.n1227 0.00376271
R17975 vss.n5301 vss.n5252 0.00355716
R17976 vss.n287 vss.n268 0.00348976
R17977 vss.n466 vss.n464 0.00343609
R17978 vss.n1175 vss.n1125 0.00283051
R17979 vss.n1217 vss.n1216 0.00283051
R17980 vss.n2867 vss.n2706 0.00271594
R17981 vss.n2866 vss.n2706 0.00271594
R17982 vss.n2865 vss.n2706 0.00271594
R17983 vss.n2925 vss.n2706 0.00271594
R17984 vss.n2926 vss.n2706 0.00271594
R17985 vss.n2927 vss.n2706 0.00271594
R17986 vss.n823 vss.t47 0.00514838
R17987 vss.n830 vss.n170 0.00495229
R17988 vss.n723 vss.n648 0.00495229
R17989 vss.n717 vss.n174 0.00495229
R17990 vss.n712 vss.n178 0.00495229
R17991 vss.n720 vss.n721 0.00466584
R17992 vss.n695 vss.n697 0.00466584
R17993 vss.n690 vss.n692 0.00466584
R17994 vss.n687 vss.n689 0.00466584
R17995 vss.n684 vss.n685 0.00466584
R17996 vss.n2859 vss.n653 0.00429837
R17997 vss.n4483 vss.n953 0.00283329
R17998 vss.n86 vss.n85 0.00236218
R17999 vss.n5533 vss.n1022 0.00236218
R18000 vss.n6357 vss.n2377 0.00234337
R18001 vss.n2864 vss.n2706 0.00203499
R18002 vss.n2924 vss.n2706 0.00203499
R18003 vss.n531 vss.n526 0.00193213
R18004 vss.n267 vss.n192 0.00188942
R18005 vss.n6134 vss.n3012 0.00187231
R18006 vss.n6360 vss.n2379 0.0018
R18007 vss.n628 vss.n627 0.00138884
R18008 vss.n710 vss.n709 0.00138884
R18009 vss.n684 vss.n683 0.00131814
R18010 vss.n688 vss.n687 0.00131814
R18011 vss.n691 vss.n690 0.00131814
R18012 vss.n696 vss.n695 0.00131814
R18013 vss.n701 vss.n700 0.00149995
R18014 vss.n708 vss.n492 0.00169993
R18015 vss.n715 vss.n714 0.00138884
R18016 vss.n720 vss.n719 0.00131814
R18017 vss.n5612 vss.n187 0.00166667
R18018 vss.n479 vss.n478 0.00427681
R18019 vss.n820 vss.t1403 0.00337451
R18020 vss.n814 vss.t1406 0.00337451
R18021 vss.n808 vss.t83 0.00337451
R18022 vss.n802 vss.t1413 0.00337451
R18023 vss.n796 vss.t1415 0.00337451
R18024 vss.n189 vss.n188 0.00166667
R18025 vss.n188 vss.n4483 0.00166667
R18026 vss.n4501 vss.n961 0.00166667
R18027 vss.n156 vss.n155 0.00229996
R18028 vss.n981 vss.n980 0.00169993
R18029 vss.n5 vss.n994 0.0202367
R18030 vss.n1008 vss.n1007 0.00169993
R18031 vss.n1023 vss.n1021 0.00169993
R18032 vss.n2379 vss.n2377 0.00165176
R18033 vss.n531 vss.n528 0.00163776
R18034 vss.n86 vss.n13 0.00163627
R18035 vss.n6189 vss.n2693 0.00162501
R18036 vss.n2394 vss.n2378 0.00158429
R18037 vss.n1023 vss.n1022 0.0015
R18038 vss.n1038 vss.n1022 0.00149998
R18039 vss.n86 vss.n67 0.00146738
R18040 vss.n287 vss.n276 0.00143786
R18041 vss.n6357 vss.n2394 0.0014157
R18042 vss.n14 vss.n13 0.00136372
R18043 vss.n287 vss.n278 0.00134047
R18044 vss.n1036 vss.n1021 0.00229996
R18045 vss.n969 vss.n967 0.00266647
R18046 vss.n965 vss.n4503 0.00283308
R18047 vss.n168 vss.n165 0.00283308
R18048 vss.n182 vss.n181 0.0016332
R18049 vss.t823 vss.n823 0.00275
R18050 vss.n729 vss.n746 0.00274987
R18051 vss.n726 vss.n744 0.00274987
R18052 vss.t796 vss.t1403 0.0025
R18053 vss.t224 vss.t1406 0.0025
R18054 vss.t55 vss.t83 0.0025
R18055 vss.t521 vss.t1413 0.0025
R18056 vss.n729 vss.n728 0.00149996
R18057 vss.n746 vss.n745 0.00224999
R18058 vss.n744 vss.n730 0.00224999
R18059 vss.n795 vss.t521 0.0022
R18060 vss.n801 vss.t55 0.0022
R18061 vss.n807 vss.t224 0.0022
R18062 vss.n813 vss.t796 0.0022
R18063 vss.n819 vss.t823 0.0022
R18064 vss.n3703 vss.n1008 0.0015
R18065 vss.n3725 vss.n981 0.0015
R18066 vss.n968 vss.n967 0.0015
R18067 vss.n4503 vss.n961 0.0015
R18068 vss.n287 vss.n284 0.0012838
R18069 vss.n86 vss.n66 0.00216663
R18070 vss.n5612 vss.n5611 0.00124911
R18071 vss.n6360 vss.n6359 0.00119999
R18072 vss.n1036 vss.n1030 0.00114338
R18073 vss.n651 vss.n6191 1.58454
R18074 vss.n649 vss.n648 0.00224999
R18075 vss.n287 vss.n275 0.00113532
R18076 vss.n287 vss.n269 0.00104128
R18077 vss.n287 vss.n274 0.00104128
R18078 vss.n531 vss.n529 0.00145136
R18079 vss.n287 vss.n271 0.00107169
R18080 vss.n647 vss.t749 225.197
R18081 vss.n407 vss.n3878 1.25313
R18082 vss.n405 vss.n3882 1.25313
R18083 vss.n373 vss.n372 0.0804592
R18084 vss.n369 vss.n368 0.0363859
R18085 vss.n521 vss.n519 0.0268175
R18086 vss.n516 vss.n514 0.0268175
R18087 vss.n511 vss.n510 0.0268175
R18088 vss.n475 vss.n473 0.0268175
R18089 vss.n470 vss.n469 0.0268175
R18090 vss.n421 vss.n419 0.0268175
R18091 vss.n416 vss.n414 0.0268175
R18092 vss.n411 vss.n410 0.014634
R18093 vss.n624 vss.n127 0.00495229
R18094 vss.n620 vss.n125 0.00495229
R18095 vss.n616 vss.n123 0.00495229
R18096 vss.n612 vss.n121 0.00495229
R18097 vss.n608 vss.n119 0.00495229
R18098 vss.n604 vss.n117 0.00495229
R18099 vss.n600 vss.n537 0.00495229
R18100 vss.n596 vss.n113 0.00495229
R18101 vss.n592 vss.n111 0.00495229
R18102 vss.n588 vss.n109 0.00495229
R18103 vss.n584 vss.n107 0.00495229
R18104 vss.n580 vss.n105 0.00495229
R18105 vss.n576 vss.n103 0.00495229
R18106 vss.n572 vss.n540 0.00495229
R18107 vss.n568 vss.n99 0.00495229
R18108 vss.n564 vss.n97 0.00495229
R18109 vss.n560 vss.n95 0.00495229
R18110 vss.n556 vss.n93 0.00495229
R18111 vss.n552 vss.n91 0.00495229
R18112 vss.n548 vss.n89 0.00495229
R18113 vss.n628 vss.n629 0.00399966
R18114 vss.n726 vss.n488 0.0035
R18115 vss.n700 vss.n497 0.00349999
R18116 vss.n915 vss.n426 0.003
R18117 vss.n920 vss.n401 0.003
R18118 vss.n925 vss.n396 0.003
R18119 vss.n930 vss.n391 0.003
R18120 vss.n935 vss.n387 0.003
R18121 vss.n940 vss.n383 0.003
R18122 vss.n945 vss.n378 0.003
R18123 vss.n479 vss.n66 0.00283324
R18124 vss.n540 vss.n539 0.00269993
R18125 vss.n537 vss.n536 0.00269993
R18126 vss.n534 vss.n533 0.00269993
R18127 vss.n686 vss.n507 0.00269993
R18128 vss.n693 vss.n505 0.00269993
R18129 vss.n694 vss.n503 0.00269993
R18130 vss.n698 vss.n501 0.00269993
R18131 vss.n699 vss.n499 0.00269993
R18132 vss.n707 vss.n494 0.00269993
R18133 vss.n490 vss.n489 0.00269993
R18134 vss.n466 vss.n437 0.0025
R18135 vss.n435 vss.n437 0.0025
R18136 vss.n433 vss.n435 0.0025
R18137 vss.n429 vss.n433 0.0025
R18138 vss.n431 vss.n429 0.0025
R18139 vss.n645 vss.n644 0.00224999
R18140 vss.n642 vss.n641 0.00224999
R18141 vss.n639 vss.n638 0.00224999
R18142 vss.n636 vss.n635 0.00224999
R18143 vss.n633 vss.n632 0.00224999
R18144 vss.n458 vss.n435 0.00238287
R18145 vss.n456 vss.n435 0.00238287
R18146 vss.n435 vss.n446 0.00238287
R18147 vss.n454 vss.n435 0.00238287
R18148 vss.n431 vss.n430 0.00238287
R18149 vss.n6189 vss.n492 0.00237498
R18150 vss.n435 vss.n451 0.00236931
R18151 vss.n435 vss.n443 0.00236931
R18152 vss.t1415 vss.n484 0.00224911
R18153 vss.n531 vss.n530 0.00206448
R18154 vss.n267 vss.n194 0.00204032
R18155 vss.n364 vss.n363 0.0020003
R18156 vss.n287 vss.n273 0.00117543
R18157 vss.n86 vss.n84 0.00102042
R18158 vss.n86 vss.n27 0.00101595
R18159 vss.n364 vss.n362 0.00101326
R18160 vss.n365 vss.n2535 519.457
R18161 vss.n182 vss.n183 2.73198
R18162 vss.n710 vss.n178 0.00549963
R18163 vss.n715 vss.n174 0.00549963
R18164 vss.n957 vss.n161 0.00324999
R18165 vss.n184 vss.n165 0.00316655
R18166 vss.n713 vss.n176 0.00316655
R18167 vss.n718 vss.n172 0.00316655
R18168 vss.n170 vss.n828 0.00316655
R18169 vss.n953 vss.n189 0.00283329
R18170 vss.n187 vss.n186 0.00283329
R18171 vss.n957 vss.n163 0.00274999
R18172 vss.n950 vss.n168 0.00269993
R18173 vss.n267 vss.n509 0.00258329
R18174 vss.n157 vss.n156 0.00224999
R18175 vss.n287 vss.n272 0.00200426
R18176 vss.n993 vss.n153 0.00199997
R18177 vss.n989 vss.n151 0.00199997
R18178 vss.n985 vss.n149 0.00199997
R18179 vss.n979 vss.n147 0.00199997
R18180 vss.n975 vss.n145 0.00199997
R18181 vss.n971 vss.n143 0.00199997
R18182 vss.n1020 vss.n141 0.00199997
R18183 vss.n1016 vss.n139 0.00199997
R18184 vss.n1012 vss.n137 0.00199997
R18185 vss.n1006 vss.n135 0.00199997
R18186 vss.n1002 vss.n133 0.00199997
R18187 vss.n998 vss.n131 0.00199997
R18188 vss.n626 vss.n129 0.00199997
R18189 vss.n622 vss.n127 0.00199997
R18190 vss.n618 vss.n125 0.00199997
R18191 vss.n614 vss.n123 0.00199997
R18192 vss.n610 vss.n121 0.00199997
R18193 vss.n606 vss.n119 0.00199997
R18194 vss.n602 vss.n117 0.00199997
R18195 vss.n598 vss.n115 0.00199997
R18196 vss.n594 vss.n113 0.00199997
R18197 vss.n590 vss.n111 0.00199997
R18198 vss.n586 vss.n109 0.00199997
R18199 vss.n582 vss.n107 0.00199997
R18200 vss.n578 vss.n105 0.00199997
R18201 vss.n574 vss.n103 0.00199997
R18202 vss.n570 vss.n101 0.00199997
R18203 vss.n566 vss.n99 0.00199997
R18204 vss.n562 vss.n97 0.00199997
R18205 vss.n558 vss.n95 0.00199997
R18206 vss.n554 vss.n93 0.00199997
R18207 vss.n550 vss.n91 0.00199997
R18208 vss.n546 vss.n89 0.00199997
R18209 vss.n4501 vss.n159 0.00183332
R18210 vss.n86 vss.n68 0.00150051
R18211 vss.n1036 vss.n1035 0.00100467
R18212 vss.n6028 vss.n3995 0.00100272
R18213 vss.n88 vss.n4173 150.542
R18214 dsm2_osc_0.ibias_pad dsm2_osc_0.ibias_pad.t0 17.4426
R18215 dsm2_osc_0.ibias_pad dsm2_osc_0.ibias_pad.t1 9.53317
R18216 dsm2_osc_0.ibias_pad dsm2_osc_0.ibias_pad.t2 3.26285
R18217 dsm2_osc_0.ibias_pad dsm2_osc_0.ibias_pad.t3 1.95437
R18218 a_21554_2052.n0 a_21554_2052.t1 26.0005
R18219 a_21554_2052.n1 a_21554_2052.t10 24.3363
R18220 a_21554_2052.n2 a_21554_2052.t7 24.3363
R18221 a_21554_2052.n0 a_21554_2052.t6 24.1508
R18222 a_21554_2052.n0 a_21554_2052.t2 24.1082
R18223 a_21554_2052.n1 a_21554_2052.t9 24.0005
R18224 a_21554_2052.n2 a_21554_2052.t8 24.0005
R18225 a_21554_2052.n0 a_21554_2052.t0 24.0005
R18226 a_21554_2052.n0 a_21554_2052.n3 20.5531
R18227 a_21554_2052.n0 a_21554_2052.t5 19.6564
R18228 a_21554_2052.n4 a_21554_2052.t3 17.0864
R18229 a_21554_2052.n3 a_21554_2052.n1 10.9088
R18230 a_21554_2052.n4 a_21554_2052.n0 10.3622
R18231 a_21554_2052.n3 a_21554_2052.n2 9.84969
R18232 a_21554_2052.t4 a_21554_2052.n4 6.53895
R18233 dsm2_osc_0.dsm2_io_rx_0.di_b.n0 dsm2_osc_0.dsm2_io_rx_0.di_b.t4 39.4236
R18234 dsm2_osc_0.dsm2_io_rx_0.di_b.n1 dsm2_osc_0.dsm2_io_rx_0.di_b.t5 33.9238
R18235 dsm2_osc_0.dsm2_io_rx_0.di_b.n2 dsm2_osc_0.dsm2_io_rx_0.di_b.t6 24.988
R18236 dsm2_osc_0.dsm2_io_rx_0.di_b dsm2_osc_0.dsm2_io_rx_0.di_b.t1 21.54
R18237 dsm2_osc_0.dsm2_io_rx_0.di_b.n0 dsm2_osc_0.dsm2_io_rx_0.di_b.t2 21.0298
R18238 dsm2_osc_0.dsm2_io_rx_0.di_b dsm2_osc_0.dsm2_io_rx_0.di_b.t3 15.0005
R18239 dsm2_osc_0.dsm2_io_rx_0.di_b.n2 dsm2_osc_0.dsm2_io_rx_0.di_b.n1 11.1709
R18240 dsm2_osc_0.dsm2_io_rx_0.di_b dsm2_osc_0.dsm2_io_rx_0.di_b.t0 10.1976
R18241 dsm2_osc_0.dsm2_io_rx_0.di_b.n3 dsm2_osc_0.dsm2_io_rx_0.di_b 9.09037
R18242 dsm2_osc_0.dsm2_io_rx_0.di_b.n1 dsm2_osc_0.dsm2_io_rx_0.di_b.n0 6.90977
R18243 dsm2_osc_0.dsm2_io_rx_0.di_b.n3 dsm2_osc_0.dsm2_io_rx_0.di_b.n2 5.61491
R18244 dsm2_osc_0.dsm2_io_rx_0.di_b dsm2_osc_0.dsm2_io_rx_0.di_b.n3 2.82591
R18245 a_21452_2308.n2 a_21452_2308.t6 46.9507
R18246 a_21452_2308.n2 a_21452_2308.t4 30.7069
R18247 a_21452_2308.n0 a_21452_2308.t5 24.5118
R18248 a_21452_2308.n3 a_21452_2308.t3 17.7602
R18249 a_21452_2308.n1 a_21452_2308.t0 17.7602
R18250 a_21452_2308.t2 a_21452_2308.n3 17.0005
R18251 a_21452_2308.n1 a_21452_2308.t1 17.0005
R18252 a_21452_2308.n0 a_21452_2308.n2 10.4096
R18253 a_21452_2308.n0 a_21452_2308.n1 9.22657
R18254 a_21452_2308.n3 a_21452_2308.n0 9.08395
R18255 dsm2_osc_0.sg13cmos5l_dfrbp_1_0.RESET_B.n4 dsm2_osc_0.sg13cmos5l_dfrbp_1_0.RESET_B.t11 40.2743
R18256 dsm2_osc_0.sg13cmos5l_dfrbp_1_0.RESET_B.n5 dsm2_osc_0.sg13cmos5l_dfrbp_1_0.RESET_B.t10 35.4339
R18257 dsm2_osc_0.sg13cmos5l_dfrbp_1_0.RESET_B.t2 dsm2_osc_0.sg13cmos5l_dfrbp_1_0.RESET_B.t3 33.4028
R18258 dsm2_osc_0.sg13cmos5l_dfrbp_1_0.RESET_B dsm2_osc_0.sg13cmos5l_dfrbp_1_0.RESET_B.n6 28.3233
R18259 dsm2_osc_0.sg13cmos5l_dfrbp_1_0.RESET_B.n4 dsm2_osc_0.sg13cmos5l_dfrbp_1_0.RESET_B.t9 24.1781
R18260 dsm2_osc_0.sg13cmos5l_dfrbp_1_0.RESET_B.n2 dsm2_osc_0.sg13cmos5l_dfrbp_1_0.RESET_B.t5 24.1682
R18261 dsm2_osc_0.sg13cmos5l_dfrbp_1_0.RESET_B.n0 dsm2_osc_0.sg13cmos5l_dfrbp_1_0.RESET_B.n4 16.1829
R18262 dsm2_osc_0.sg13cmos5l_dfrbp_1_0.RESET_B.n1 dsm2_osc_0.sg13cmos5l_dfrbp_1_0.RESET_B.t7 15.6135
R18263 dsm2_osc_0.sg13cmos5l_dfrbp_1_0.RESET_B dsm2_osc_0.sg13cmos5l_dfrbp_1_0.RESET_B.t8 15.0157
R18264 dsm2_osc_0.sg13cmos5l_dfrbp_1_0.RESET_B dsm2_osc_0.sg13cmos5l_dfrbp_1_0.RESET_B.t6 15.0102
R18265 dsm2_osc_0.sg13cmos5l_dfrbp_1_0.RESET_B.n1 dsm2_osc_0.sg13cmos5l_dfrbp_1_0.RESET_B.t4 15.0005
R18266 dsm2_osc_0.sg13cmos5l_dfrbp_1_0.RESET_B dsm2_osc_0.sg13cmos5l_dfrbp_1_0.RESET_B.t2 15.0005
R18267 dsm2_osc_0.sg13cmos5l_dfrbp_1_0.RESET_B.n5 dsm2_osc_0.sg13cmos5l_dfrbp_1_0.RESET_B 13.6399
R18268 dsm2_osc_0.sg13cmos5l_dfrbp_1_0.RESET_B.n0 dsm2_osc_0.sg13cmos5l_dfrbp_1_0.RESET_B.n3 11.5971
R18269 dsm2_osc_0.sg13cmos5l_dfrbp_1_0.RESET_B.n3 dsm2_osc_0.sg13cmos5l_dfrbp_1_0.RESET_B.n2 11.1021
R18270 dsm2_osc_0.sg13cmos5l_dfrbp_1_0.RESET_B.n0 dsm2_osc_0.sg13cmos5l_dfrbp_1_0.RESET_B 9.18363
R18271 dsm2_osc_0.sg13cmos5l_dfrbp_1_0.RESET_B.n3 dsm2_osc_0.sg13cmos5l_dfrbp_1_0.RESET_B 9.05248
R18272 dsm2_osc_0.sg13cmos5l_dfrbp_1_0.RESET_B.n2 dsm2_osc_0.sg13cmos5l_dfrbp_1_0.RESET_B.n1 9.04879
R18273 dsm2_osc_0.sg13cmos5l_dfrbp_1_0.RESET_B dsm2_osc_0.sg13cmos5l_dfrbp_1_0.RESET_B.t0 8.97618
R18274 dsm2_osc_0.sg13cmos5l_dfrbp_1_0.RESET_B dsm2_osc_0.sg13cmos5l_dfrbp_1_0.RESET_B.t1 5.93783
R18275 dsm2_osc_0.sg13cmos5l_dfrbp_1_0.RESET_B.n6 dsm2_osc_0.sg13cmos5l_dfrbp_1_0.RESET_B.n5 5.06491
R18276 dsm2_osc_0.sg13cmos5l_dfrbp_1_0.RESET_B.n6 dsm2_osc_0.sg13cmos5l_dfrbp_1_0.RESET_B.n0 2.50896
R18277 dsm2_osc_0.ibias_in.n1 dsm2_osc_0.ibias_in.t3 24.7656
R18278 dsm2_osc_0.ibias_in.n0 dsm2_osc_0.ibias_in.t1 24.2654
R18279 dsm2_osc_0.ibias_in.n2 dsm2_osc_0.ibias_in.t5 21.5005
R18280 dsm2_osc_0.ibias_in.n1 dsm2_osc_0.ibias_in.t4 21.5005
R18281 dsm2_osc_0.ibias_in dsm2_osc_0.ibias_in.n2 12.8027
R18282 dsm2_osc_0.ibias_in dsm2_osc_0.ibias_in.n0 10.5606
R18283 dsm2_osc_0.ibias_in.n0 dsm2_osc_0.ibias_in.t2 6.58499
R18284 dsm2_osc_0.ibias_in.n0 dsm2_osc_0.ibias_in.t0 5.74501
R18285 dsm2_osc_0.ibias_in.n2 dsm2_osc_0.ibias_in.n1 3.2656
R18286 quantizer2_lfsr_0.sg13cmos5l_dfrbpq_1_11.Q.n0 quantizer2_lfsr_0.sg13cmos5l_dfrbpq_1_11.Q 33.3747
R18287 quantizer2_lfsr_0.sg13cmos5l_dfrbpq_1_11.Q quantizer2_lfsr_0.sg13cmos5l_dfrbpq_1_11.Q.n0 27.7177
R18288 quantizer2_lfsr_0.sg13cmos5l_dfrbpq_1_11.Q quantizer2_lfsr_0.sg13cmos5l_dfrbpq_1_11.Q.t2 15.0122
R18289 quantizer2_lfsr_0.sg13cmos5l_dfrbpq_1_11.Q quantizer2_lfsr_0.sg13cmos5l_dfrbpq_1_11.Q.t3 15.0005
R18290 quantizer2_lfsr_0.sg13cmos5l_dfrbpq_1_11.Q quantizer2_lfsr_0.sg13cmos5l_dfrbpq_1_11.Q.t0 9.11567
R18291 quantizer2_lfsr_0.sg13cmos5l_dfrbpq_1_11.Q.n0 quantizer2_lfsr_0.sg13cmos5l_dfrbpq_1_11.Q 9.04036
R18292 quantizer2_lfsr_0.sg13cmos5l_dfrbpq_1_11.Q quantizer2_lfsr_0.sg13cmos5l_dfrbpq_1_11.Q.t1 5.67423
R18293 xvcm_vcf_t.n2 xvcm_vcf_t.t1 18.8703
R18294 xvcm_vcf_t.n1 xvcm_vcf_t.t0 17.5947
R18295 xvcm_vcf_t.n0 xvcm_vcf_t.n1 7.49264
R18296 xvcm_vcf_t.n2 xvcm_vcf_t.n0 7.49264
R18297 xvcm_vcf_t xvcm_vcf_t.n2 5.29573
R18298 xvcm_vcf_t.n1 xvcm_vcf_t 5.29573
R18299 xvcm_vcf_t xvcm_vcf_t.n0 2.73089
R18300 xvcm_vcf_b.n0 xvcm_vcf_b.t0 12.1135
R18301 xvcm_vcf_b.n1 xvcm_vcf_b.t1 11.8601
R18302 xvcm_vcf_b.n0 xvcm_vcf_b.n1 7.49264
R18303 xvcm_vcf_b xvcm_vcf_b.n0 2.45037
R18304 xvcm_vcf_b.n1 xvcm_vcf_b 2.45037
R18305 quantizer2_lfsr_0.sg13cmos5l_dfrbpq_1_2.Q.n0 quantizer2_lfsr_0.sg13cmos5l_dfrbpq_1_2.Q 25.9895
R18306 quantizer2_lfsr_0.sg13cmos5l_dfrbpq_1_2.Q.n0 quantizer2_lfsr_0.sg13cmos5l_dfrbpq_1_2.Q 18.5802
R18307 quantizer2_lfsr_0.sg13cmos5l_dfrbpq_1_2.Q quantizer2_lfsr_0.sg13cmos5l_dfrbpq_1_2.Q.t3 15.0404
R18308 quantizer2_lfsr_0.sg13cmos5l_dfrbpq_1_2.Q quantizer2_lfsr_0.sg13cmos5l_dfrbpq_1_2.Q.t2 15.0122
R18309 quantizer2_lfsr_0.sg13cmos5l_dfrbpq_1_2.Q quantizer2_lfsr_0.sg13cmos5l_dfrbpq_1_2.Q.n0 13.5329
R18310 quantizer2_lfsr_0.sg13cmos5l_dfrbpq_1_2.Q quantizer2_lfsr_0.sg13cmos5l_dfrbpq_1_2.Q.t0 9.02886
R18311 quantizer2_lfsr_0.sg13cmos5l_dfrbpq_1_2.Q quantizer2_lfsr_0.sg13cmos5l_dfrbpq_1_2.Q.t1 5.76004
R18312 clk_noverlap_0.di_clk clk_noverlap_0.di_clk.t1 17.1528
R18313 clk_noverlap_0.di_clk clk_noverlap_0.di_clk.t0 8.69163
R18314 clk_noverlap_0.di_clk clk_noverlap_0.di_clk.t2 7.50545
R18315 clk_noverlap_0.sg13cmos5l_dlygate4sd3_1_0.A clk_noverlap_0.sg13cmos5l_dlygate4sd3_1_0.A.t2 15.0311
R18316 clk_noverlap_0.sg13cmos5l_dlygate4sd3_1_0.A clk_noverlap_0.sg13cmos5l_dlygate4sd3_1_0.A.t0 9.13233
R18317 clk_noverlap_0.sg13cmos5l_dlygate4sd3_1_0.A clk_noverlap_0.sg13cmos5l_dlygate4sd3_1_0.A.t1 5.71924
R18318 a_6249_9100.n12 a_6249_9100.n8 57.4199
R18319 a_6249_9100.n3 a_6249_9100.n2 27.9326
R18320 a_6249_9100.n13 a_6249_9100.n12 22.9299
R18321 a_6249_9100.n4 a_6249_9100.n0 18.4294
R18322 a_6249_9100.n8 a_6249_9100.n7 18.4097
R18323 a_6249_9100.n13 a_6249_9100.t9 17.8969
R18324 a_6249_9100.n1 a_6249_9100.t14 17.8969
R18325 a_6249_9100.n2 a_6249_9100.t5 17.8969
R18326 a_6249_9100.n0 a_6249_9100.t10 17.8969
R18327 a_6249_9100.n6 a_6249_9100.t8 17.8969
R18328 a_6249_9100.n5 a_6249_9100.t12 17.8969
R18329 a_6249_9100.n9 a_6249_9100.t1 17.8969
R18330 a_6249_9100.n10 a_6249_9100.t15 17.8969
R18331 a_6249_9100.t0 a_6249_9100.n13 17.0005
R18332 a_6249_9100.n1 a_6249_9100.t7 17.0005
R18333 a_6249_9100.n2 a_6249_9100.t6 17.0005
R18334 a_6249_9100.n0 a_6249_9100.t2 17.0005
R18335 a_6249_9100.n6 a_6249_9100.t3 17.0005
R18336 a_6249_9100.n5 a_6249_9100.t11 17.0005
R18337 a_6249_9100.n9 a_6249_9100.t13 17.0005
R18338 a_6249_9100.n10 a_6249_9100.t4 17.0005
R18339 a_6249_9100.n12 a_6249_9100.n11 14.8441
R18340 a_6249_9100.n8 a_6249_9100.n4 10.5317
R18341 a_6249_9100.n4 a_6249_9100.n3 9.7463
R18342 a_6249_9100.n3 a_6249_9100.n1 9.57356
R18343 a_6249_9100.n7 a_6249_9100.n6 9.39122
R18344 a_6249_9100.n11 a_6249_9100.n9 9.39122
R18345 a_6249_9100.n7 a_6249_9100.n5 9.07788
R18346 a_6249_9100.n11 a_6249_9100.n10 9.07788
R18347 a_5892_8400.n11 a_5892_8400.n5 64.2421
R18348 a_5892_8400.n5 a_5892_8400.n3 29.2775
R18349 a_5892_8400.n9 a_5892_8400.n7 27.9326
R18350 a_5892_8400.n5 a_5892_8400.n4 18.4294
R18351 a_5892_8400.n10 a_5892_8400.n6 18.4294
R18352 a_5892_8400.n12 a_5892_8400.n11 18.4097
R18353 a_5892_8400.t0 a_5892_8400.n13 17.8969
R18354 a_5892_8400.n0 a_5892_8400.t3 17.8969
R18355 a_5892_8400.n4 a_5892_8400.t7 17.8969
R18356 a_5892_8400.n2 a_5892_8400.t14 17.8969
R18357 a_5892_8400.n1 a_5892_8400.t15 17.8969
R18358 a_5892_8400.n7 a_5892_8400.t4 17.8969
R18359 a_5892_8400.n8 a_5892_8400.t13 17.8969
R18360 a_5892_8400.n6 a_5892_8400.t10 17.8969
R18361 a_5892_8400.n13 a_5892_8400.t11 17.0005
R18362 a_5892_8400.n0 a_5892_8400.t2 17.0005
R18363 a_5892_8400.n4 a_5892_8400.t8 17.0005
R18364 a_5892_8400.n2 a_5892_8400.t12 17.0005
R18365 a_5892_8400.n1 a_5892_8400.t9 17.0005
R18366 a_5892_8400.n7 a_5892_8400.t5 17.0005
R18367 a_5892_8400.n8 a_5892_8400.t6 17.0005
R18368 a_5892_8400.n6 a_5892_8400.t1 17.0005
R18369 a_5892_8400.n11 a_5892_8400.n10 10.5317
R18370 a_5892_8400.n10 a_5892_8400.n9 9.7463
R18371 a_5892_8400.n9 a_5892_8400.n8 9.57356
R18372 a_5892_8400.n12 a_5892_8400.n0 9.39122
R18373 a_5892_8400.n3 a_5892_8400.n2 9.39122
R18374 a_5892_8400.n13 a_5892_8400.n12 9.07788
R18375 a_5892_8400.n3 a_5892_8400.n1 9.07788
R18376 a_13211_9308.n1 a_13211_9308.n0 61.6894
R18377 a_13211_9308.t2 a_13211_9308.n1 17.8969
R18378 a_13211_9308.n1 a_13211_9308.t3 17.0005
R18379 a_13211_9308.n0 a_13211_9308.t0 15.3813
R18380 a_13211_9308.n0 a_13211_9308.t1 15.0005
R18381 a_12075_9488.n1 a_12075_9488.n0 64.7581
R18382 a_12075_9488.n1 a_12075_9488.t3 17.8969
R18383 a_12075_9488.t2 a_12075_9488.n1 17.0005
R18384 a_12075_9488.n0 a_12075_9488.t1 15.1248
R18385 a_12075_9488.n0 a_12075_9488.t0 15.1248
R18386 a_5798_8400.n1 a_5798_8400.n0 64.7581
R18387 a_5798_8400.n1 a_5798_8400.t3 17.8969
R18388 a_5798_8400.t2 a_5798_8400.n1 17.0005
R18389 a_5798_8400.n0 a_5798_8400.t0 15.1248
R18390 a_5798_8400.n0 a_5798_8400.t1 15.1248
R18391 a_6257_8400.n1 a_6257_8400.n0 61.6894
R18392 a_6257_8400.t2 a_6257_8400.n1 17.8969
R18393 a_6257_8400.n1 a_6257_8400.t3 17.0005
R18394 a_6257_8400.n0 a_6257_8400.t0 15.3813
R18395 a_6257_8400.n0 a_6257_8400.t1 15.0005
R18396 a_12075_9628.n1 a_12075_9628.n0 45.5784
R18397 a_12075_9628.t1 a_12075_9628.n1 17.8969
R18398 a_12075_9628.n1 a_12075_9628.t2 17.0005
R18399 a_12075_9628.n0 a_12075_9628.t3 15.1248
R18400 a_12075_9628.n0 a_12075_9628.t0 15.1248
R18401 a_11173_9488.n1 a_11173_9488.n0 66.8545
R18402 a_11173_9488.t2 a_11173_9488.n1 17.8969
R18403 a_11173_9488.n1 a_11173_9488.t3 17.0005
R18404 a_11173_9488.n0 a_11173_9488.t0 15.2967
R18405 a_11173_9488.n0 a_11173_9488.t1 15.0005
R18406 a_5994_8400.n1 a_5994_8400.n0 66.8545
R18407 a_5994_8400.t2 a_5994_8400.n1 17.8969
R18408 a_5994_8400.n1 a_5994_8400.t3 17.0005
R18409 a_5994_8400.n0 a_5994_8400.t0 15.2967
R18410 a_5994_8400.n0 a_5994_8400.t1 15.0005
R18411 a_6453_8400.n1 a_6453_8400.n0 45.5784
R18412 a_6453_8400.t0 a_6453_8400.n1 17.8969
R18413 a_6453_8400.n1 a_6453_8400.t2 17.0005
R18414 a_6453_8400.n0 a_6453_8400.t3 15.1248
R18415 a_6453_8400.n0 a_6453_8400.t1 15.1248
R18416 xq_dith_v_bp.n17 xq_dith_v_bp.n2 13.8272
R18417 xq_dith_v_bp xq_dith_v_bp.n17 9.92492
R18418 xq_dith_v_bp.n13 xq_dith_v_bp.t7 8.60148
R18419 xq_dith_v_bp.n1 xq_dith_v_bp.n9 5.44657
R18420 xq_dith_v_bp.n2 xq_dith_v_bp.n16 5.13705
R18421 xq_dith_v_bp.n2 xq_dith_v_bp.n15 5.13705
R18422 xq_dith_v_bp.n2 xq_dith_v_bp.n14 5.13705
R18423 xq_dith_v_bp.n1 xq_dith_v_bp.n11 5.13705
R18424 xq_dith_v_bp.n1 xq_dith_v_bp.n10 5.13705
R18425 xq_dith_v_bp.n2 xq_dith_v_bp.n13 4.5005
R18426 xq_dith_v_bp.n9 xq_dith_v_bp.t11 4.08359
R18427 xq_dith_v_bp.n15 xq_dith_v_bp.t0 4.08356
R18428 xq_dith_v_bp.n14 xq_dith_v_bp.t3 4.08356
R18429 xq_dith_v_bp.n11 xq_dith_v_bp.t13 4.08356
R18430 xq_dith_v_bp.n10 xq_dith_v_bp.t12 4.08356
R18431 xq_dith_v_bp.n16 xq_dith_v_bp.t1 4.08138
R18432 xq_dith_v_bp.n12 xq_dith_v_bp.t2 3.94692
R18433 xq_dith_v_bp.t7 xq_dith_v_bp.n12 1.84129
R18434 xq_dith_v_bp.n7 xq_dith_v_bp 1.97624
R18435 xq_dith_v_bp.n0 xq_dith_v_bp 1.97624
R18436 xq_dith_v_bp xq_dith_v_bp.n3 0.71438
R18437 xq_dith_v_bp xq_dith_v_bp.n5 0.71438
R18438 xq_dith_v_bp.n16 xq_dith_v_bp.t10 1.40511
R18439 xq_dith_v_bp.n15 xq_dith_v_bp.t9 1.40511
R18440 xq_dith_v_bp.n14 xq_dith_v_bp.t8 1.40511
R18441 xq_dith_v_bp.n11 xq_dith_v_bp.t6 1.40511
R18442 xq_dith_v_bp.n10 xq_dith_v_bp.t5 1.40511
R18443 xq_dith_v_bp.n9 xq_dith_v_bp.t4 1.40511
R18444 xq_dith_v_bp.n6 xq_dith_v_bp.n5 0.296255
R18445 xq_dith_v_bp.n8 xq_dith_v_bp 1.15333
R18446 xq_dith_v_bp.n13 xq_dith_v_bp.n12 0.834365
R18447 xq_dith_v_bp.n4 xq_dith_v_bp.n7 0.560125
R18448 xq_dith_v_bp.n6 xq_dith_v_bp.n8 0.457434
R18449 xq_dith_v_bp.n8 xq_dith_v_bp 1.15335
R18450 xq_dith_v_bp.n5 xq_dith_v_bp.n7 0.365926
R18451 xq_dith_v_bp.n4 xq_dith_v_bp.n3 0.253045
R18452 xq_dith_v_bp.n17 xq_dith_v_bp.n0 4.60283
R18453 xq_dith_v_bp.n0 xq_dith_v_bp 0.724161
R18454 xq_dith_v_bp.n4 xq_dith_v_bp 1.55594
R18455 xq_dith_v_bp.n2 xq_dith_v_bp.n1 1.52231
R18456 xq_dith_v_bp.n6 xq_dith_v_bp 1.52194
R18457 xq_dith_v_bp.n3 xq_dith_v_bp.n0 1.33458
R18458 xq_dith_v_bp.n0 xq_dith_v_bp 1.03318
R18459 a_4362_8188.n6 a_4362_8188.n5 66.1669
R18460 a_4362_8188.n0 a_4362_8188.n6 46.8107
R18461 a_4362_8188.n5 a_4362_8188.t6 44.0685
R18462 a_4362_8188.n5 a_4362_8188.n1 25.6532
R18463 a_4362_8188.n6 a_4362_8188.t7 24.0005
R18464 a_4362_8188.n9 a_4362_8188.n0 5.05772
R18465 a_4362_8188.n0 a_4362_8188.n8 5.03985
R18466 a_4362_8188.n1 a_4362_8188.n2 4.95536
R18467 a_4362_8188.n1 a_4362_8188.n4 4.94758
R18468 a_4362_8188.n1 a_4362_8188.n3 4.7503
R18469 a_4362_8188.n0 a_4362_8188.n7 4.7503
R18470 a_4362_8188.n2 a_4362_8188.t3 3.8397
R18471 a_4362_8188.n4 a_4362_8188.t5 3.83967
R18472 a_4362_8188.n3 a_4362_8188.t4 3.83967
R18473 a_4362_8188.n8 a_4362_8188.t1 3.83967
R18474 a_4362_8188.n7 a_4362_8188.t0 3.83967
R18475 a_4362_8188.t2 a_4362_8188.n9 3.83535
R18476 a_4362_8188.n2 a_4362_8188.t8 1.61221
R18477 a_4362_8188.n4 a_4362_8188.t9 1.61221
R18478 a_4362_8188.n3 a_4362_8188.t10 1.61221
R18479 a_4362_8188.n8 a_4362_8188.t12 1.61221
R18480 a_4362_8188.n7 a_4362_8188.t11 1.61221
R18481 a_4362_8188.n9 a_4362_8188.t13 1.61207
R18482 xq_dith_v_bq.n36 xq_dith_v_bq.n33 13.8272
R18483 xq_dith_v_bq xq_dith_v_bq.n36 9.92495
R18484 xq_dith_v_bq.n23 xq_dith_v_bq.n21 5.44657
R18485 xq_dith_v_bq.n27 xq_dith_v_bq.n26 5.13806
R18486 xq_dith_v_bq.n33 xq_dith_v_bq.n32 5.13705
R18487 xq_dith_v_bq.n23 xq_dith_v_bq.n22 5.13705
R18488 xq_dith_v_bq.n25 xq_dith_v_bq.n24 5.13705
R18489 xq_dith_v_bq.n29 xq_dith_v_bq.n28 5.13705
R18490 xq_dith_v_bq.n31 xq_dith_v_bq.n30 5.13705
R18491 xq_dith_v_bq.n32 xq_dith_v_bq.t0 4.08359
R18492 xq_dith_v_bq.n22 xq_dith_v_bq.t5 4.08356
R18493 xq_dith_v_bq.n24 xq_dith_v_bq.t4 4.08356
R18494 xq_dith_v_bq.n28 xq_dith_v_bq.t2 4.08356
R18495 xq_dith_v_bq.n30 xq_dith_v_bq.t1 4.08356
R18496 xq_dith_v_bq.n21 xq_dith_v_bq.t6 4.08138
R18497 xq_dith_v_bq.n26 xq_dith_v_bq.t3 4.07875
R18498 xq_dith_v_bq.n34 xq_dith_v_bq.n0 1.82655
R18499 xq_dith_v_bq.n35 xq_dith_v_bq.n8 1.82655
R18500 xq_dith_v_bq.n5 xq_dith_v_bq.n20 2.03313
R18501 xq_dith_v_bq.n7 xq_dith_v_bq.n18 1.97673
R18502 xq_dith_v_bq.n4 xq_dith_v_bq.n3 0.269779
R18503 xq_dith_v_bq.n1 xq_dith_v_bq.n16 1.93417
R18504 xq_dith_v_bq.n19 xq_dith_v_bq.n18 1.45208
R18505 xq_dith_v_bq.n4 xq_dith_v_bq 0.940727
R18506 xq_dith_v_bq.n17 xq_dith_v_bq.n16 1.45208
R18507 xq_dith_v_bq.n2 xq_dith_v_bq.n20 1.4517
R18508 xq_dith_v_bq.n9 xq_dith_v_bq.n34 1.4517
R18509 xq_dith_v_bq.n12 xq_dith_v_bq.n35 1.4517
R18510 xq_dith_v_bq.n32 xq_dith_v_bq.t7 1.40511
R18511 xq_dith_v_bq.n21 xq_dith_v_bq.t13 1.40511
R18512 xq_dith_v_bq.n22 xq_dith_v_bq.t12 1.40511
R18513 xq_dith_v_bq.n24 xq_dith_v_bq.t11 1.40511
R18514 xq_dith_v_bq.n28 xq_dith_v_bq.t9 1.40511
R18515 xq_dith_v_bq.n30 xq_dith_v_bq.t8 1.40511
R18516 xq_dith_v_bq.n26 xq_dith_v_bq.t10 1.40437
R18517 xq_dith_v_bq.n19 xq_dith_v_bq.n14 0.784119
R18518 xq_dith_v_bq xq_dith_v_bq.n13 1.15296
R18519 xq_dith_v_bq.n10 xq_dith_v_bq.n5 0.2332
R18520 xq_dith_v_bq.n5 xq_dith_v_bq.n3 0.207077
R18521 xq_dith_v_bq.n8 xq_dith_v_bq.n7 0.150718
R18522 xq_dith_v_bq.n10 xq_dith_v_bq.n9 0.608119
R18523 xq_dith_v_bq.n14 xq_dith_v_bq.n13 0.782277
R18524 xq_dith_v_bq.n7 xq_dith_v_bq.n6 0.550267
R18525 xq_dith_v_bq.n14 xq_dith_v_bq.n12 0.608119
R18526 xq_dith_v_bq.n11 xq_dith_v_bq.n17 0.106645
R18527 xq_dith_v_bq.n4 xq_dith_v_bq.n6 0.338476
R18528 xq_dith_v_bq.n15 xq_dith_v_bq.n19 0.106645
R18529 xq_dith_v_bq.n3 xq_dith_v_bq.n2 0.566214
R18530 xq_dith_v_bq.n31 xq_dith_v_bq.n29 0.310017
R18531 xq_dith_v_bq.n29 xq_dith_v_bq.n27 0.310017
R18532 xq_dith_v_bq.n27 xq_dith_v_bq.n25 0.310017
R18533 xq_dith_v_bq.n25 xq_dith_v_bq.n23 0.310017
R18534 xq_dith_v_bq.n33 xq_dith_v_bq.n31 0.284246
R18535 xq_dith_v_bq.n15 xq_dith_v_bq.n12 0.106645
R18536 xq_dith_v_bq.n6 xq_dith_v_bq.n2 0.0966152
R18537 xq_dith_v_bq.n11 xq_dith_v_bq.n9 0.106645
R18538 xq_dith_v_bq.n18 xq_dith_v_bq 0.25056
R18539 xq_dith_v_bq.n16 xq_dith_v_bq 0.25056
R18540 xq_dith_v_bq.n35 xq_dith_v_bq 0.25051
R18541 xq_dith_v_bq.n34 xq_dith_v_bq 0.25051
R18542 xq_dith_v_bq.n20 xq_dith_v_bq 0.25051
R18543 xq_dith_v_bq xq_dith_v_bq.n13 1.15277
R18544 xq_dith_v_bq.n17 xq_dith_v_bq.n10 0.784119
R18545 xq_dith_v_bq.n15 xq_dith_v_bq.n8 0.440558
R18546 xq_dith_v_bq.n11 xq_dith_v_bq.n0 0.440558
R18547 xq_dith_v_bq.n1 xq_dith_v_bq.n0 0.108161
R18548 xq_dith_v_bq.n36 xq_dith_v_bq.n1 4.56808
R18549 xq_vg_p_2_.n0 xq_vg_p_2_.t3 46.757
R18550 xq_vg_p_2_.n0 xq_vg_p_2_.t2 35.279
R18551 xq_vg_p_2_.n2 xq_vg_p_2_.n0 21.2961
R18552 xq_vg_p_2_.n2 xq_vg_p_2_.n1 18.0202
R18553 xq_vg_p_2_.n1 xq_vg_p_2_.t1 17.8969
R18554 xq_vg_p_2_.n1 xq_vg_p_2_.t0 17.0005
R18555 xq_vg_p_2_ xq_vg_p_2_.n2 5.7711
R18556 xq_vg_p_1_.n0 xq_vg_p_1_.t0 44.6538
R18557 xq_vg_p_1_.n0 xq_vg_p_1_.t3 38.5345
R18558 xq_vg_p_1_.n2 xq_vg_p_1_.n1 27.678
R18559 xq_vg_p_1_.n1 xq_vg_p_1_.t2 17.8969
R18560 xq_vg_p_1_.n1 xq_vg_p_1_.t1 17.0005
R18561 xq_vg_p_1_ xq_vg_p_1_.n2 15.0499
R18562 xq_vg_p_1_.n2 xq_vg_p_1_.n0 2.4293
R18563 xq_vg_p_0_.n0 xq_vg_p_0_.t3 58.3051
R18564 xq_vg_p_0_.n0 xq_vg_p_0_.t1 26.4922
R18565 xq_vg_p_0_.n1 xq_vg_p_0_.t2 17.8969
R18566 xq_vg_p_0_.n1 xq_vg_p_0_.t0 17.0005
R18567 xq_vg_p_0_ xq_vg_p_0_.n2 16.6678
R18568 xq_vg_p_0_.n2 xq_vg_p_0_.n1 9.17536
R18569 xq_vg_p_0_.n2 xq_vg_p_0_.n0 2.7857
R18570 xq_vg_q_0_.n1 xq_vg_q_0_.t3 58.3051
R18571 xq_vg_q_0_.n1 xq_vg_q_0_.t0 26.4922
R18572 xq_vg_q_0_.n0 xq_vg_q_0_.t2 17.8969
R18573 xq_vg_q_0_.n0 xq_vg_q_0_.t1 17.0005
R18574 xq_vg_q_0_ xq_vg_q_0_.n2 16.6678
R18575 xq_vg_q_0_.n2 xq_vg_q_0_.n0 9.17536
R18576 xq_vg_q_0_.n2 xq_vg_q_0_.n1 2.7857
R18577 xq_vg_q_1_.n0 xq_vg_q_1_.t1 44.6538
R18578 xq_vg_q_1_.n0 xq_vg_q_1_.t3 38.5345
R18579 xq_vg_q_1_.n2 xq_vg_q_1_.n1 27.678
R18580 xq_vg_q_1_.n1 xq_vg_q_1_.t0 17.8969
R18581 xq_vg_q_1_.n1 xq_vg_q_1_.t2 17.0005
R18582 xq_vg_q_1_ xq_vg_q_1_.n2 15.0499
R18583 xq_vg_q_1_.n2 xq_vg_q_1_.n0 2.4293
R18584 xq_vg_q_2_.n0 xq_vg_q_2_.t3 46.757
R18585 xq_vg_q_2_.n0 xq_vg_q_2_.t2 35.279
R18586 xq_vg_q_2_.n2 xq_vg_q_2_.n0 21.2961
R18587 xq_vg_q_2_.n2 xq_vg_q_2_.n1 18.0202
R18588 xq_vg_q_2_.n1 xq_vg_q_2_.t1 17.8969
R18589 xq_vg_q_2_.n1 xq_vg_q_2_.t0 17.0005
R18590 xq_vg_q_2_ xq_vg_q_2_.n2 5.7711
R18591 a_9357_11104.n1 a_9357_11104.n7 0.507945
R18592 a_9357_11104.n4 a_9357_11104.n7 4.73835
R18593 a_9357_11104.n5 a_9357_11104.t5 9.40721
R18594 a_9357_11104.n3 a_9357_11104.t4 9.40721
R18595 a_9357_11104.n5 a_9357_11104.t19 8.87314
R18596 a_9357_11104.n5 a_9357_11104.t18 8.87314
R18597 a_9357_11104.n6 a_9357_11104.t16 8.87314
R18598 a_9357_11104.n4 a_9357_11104.t10 8.87314
R18599 a_9357_11104.n3 a_9357_11104.t9 8.87314
R18600 a_9357_11104.n3 a_9357_11104.t17 8.87314
R18601 a_9357_11104.n0 a_9357_11104.t2 6.89086
R18602 a_9357_11104.n2 a_9357_11104.t3 6.88999
R18603 a_9357_11104.t11 a_9357_11104.n2 6.35712
R18604 a_9357_11104.n2 a_9357_11104.t12 6.35592
R18605 a_9357_11104.n1 a_9357_11104.t15 6.35592
R18606 a_9357_11104.n0 a_9357_11104.t14 6.35592
R18607 a_9357_11104.n0 a_9357_11104.t13 6.35592
R18608 a_9357_11104.n0 a_9357_11104.t1 6.35592
R18609 a_9357_11104.n0 a_9357_11104.t0 6.35592
R18610 a_9357_11104.n8 a_9357_11104.n4 1.55875
R18611 a_9357_11104.n8 a_9357_11104.t7 4.35847
R18612 a_9357_11104.n8 a_9357_11104.t8 4.35847
R18613 a_9357_11104.n8 a_9357_11104.t6 4.51989
R18614 a_9357_11104.n4 a_9357_11104.n3 1.60271
R18615 a_9357_11104.n7 a_9357_11104.n0 1.57608
R18616 a_9357_11104.n6 a_9357_11104.n5 1.06864
R18617 a_9357_11104.n2 a_9357_11104.n1 1.06864
R18618 a_9357_11104.n4 a_9357_11104.n6 1.03259
R18619 a_11293_11104.n4 a_11293_11104.t3 18.1862
R18620 a_11293_11104.n1 a_11293_11104.t4 18.0259
R18621 a_11293_11104.n0 a_11293_11104.t9 9.408
R18622 a_11293_11104.n0 a_11293_11104.t0 9.14097
R18623 a_11293_11104.n2 a_11293_11104.t6 9.08512
R18624 a_11293_11104.n2 a_11293_11104.t5 9.08512
R18625 a_11293_11104.n0 a_11293_11104.t8 8.87393
R18626 a_11293_11104.n0 a_11293_11104.t7 8.87393
R18627 a_11293_11104.n3 a_11293_11104.n2 6.70657
R18628 a_11293_11104.n3 a_11293_11104.n0 6.6474
R18629 a_11293_11104.n5 a_11293_11104.n3 5.03457
R18630 a_11293_11104.n1 a_11293_11104.n5 5.03457
R18631 a_11293_11104.n5 a_11293_11104.n4 4.57918
R18632 a_11293_11104.t2 a_11293_11104.n1 1.93881
R18633 a_11293_11104.n4 a_11293_11104.t1 1.77867
R18634 a_9533_11104.n4 a_9533_11104.t8 18.1862
R18635 a_9533_11104.n1 a_9533_11104.t9 18.0259
R18636 a_9533_11104.n0 a_9533_11104.t6 9.408
R18637 a_9533_11104.n0 a_9533_11104.t2 9.14097
R18638 a_9533_11104.n2 a_9533_11104.t5 9.08512
R18639 a_9533_11104.n2 a_9533_11104.t4 9.08512
R18640 a_9533_11104.n0 a_9533_11104.t3 8.87393
R18641 a_9533_11104.n0 a_9533_11104.t7 8.87393
R18642 a_9533_11104.n3 a_9533_11104.n2 6.70657
R18643 a_9533_11104.n3 a_9533_11104.n0 6.6474
R18644 a_9533_11104.n5 a_9533_11104.n4 5.11325
R18645 a_9533_11104.n5 a_9533_11104.n3 5.03457
R18646 a_9533_11104.n1 a_9533_11104.n5 4.5005
R18647 a_9533_11104.t1 a_9533_11104.n1 1.93881
R18648 a_9533_11104.n4 a_9533_11104.t0 1.77864
R18649 sg13cmos5l_and2_2_1.X.n1 sg13cmos5l_and2_2_1.X.t2 20.1423
R18650 sg13cmos5l_and2_2_1.X sg13cmos5l_and2_2_1.X.n1 16.0007
R18651 sg13cmos5l_and2_2_1.X.n0 sg13cmos5l_and2_2_1.X.t4 13.3679
R18652 sg13cmos5l_and2_2_1.X.n0 sg13cmos5l_and2_2_1.X.t3 13.3679
R18653 sg13cmos5l_and2_2_1.X sg13cmos5l_and2_2_1.X.t0 9.10821
R18654 sg13cmos5l_and2_2_1.X sg13cmos5l_and2_2_1.X.t1 5.77485
R18655 sg13cmos5l_and2_2_1.X.n1 sg13cmos5l_and2_2_1.X.n0 4.5005
R18656 sg13cmos5l_inv_1_14.A sg13cmos5l_inv_1_14.A.n1 22.3322
R18657 sg13cmos5l_inv_1_14.A.n7 sg13cmos5l_inv_1_14.A.t2 17.5045
R18658 sg13cmos5l_inv_1_14.A.n5 sg13cmos5l_inv_1_14.A.t5 17.5045
R18659 sg13cmos5l_inv_1_14.A.n3 sg13cmos5l_inv_1_14.A.t1 17.5045
R18660 sg13cmos5l_inv_1_14.A.n2 sg13cmos5l_inv_1_14.A.t0 17.5045
R18661 sg13cmos5l_inv_1_14.A sg13cmos5l_inv_1_14.A.t11 15.0022
R18662 sg13cmos5l_inv_1_14.A.n0 sg13cmos5l_inv_1_14.A.t10 8.18445
R18663 sg13cmos5l_inv_1_14.A.n4 sg13cmos5l_inv_1_14.A.t3 5.61908
R18664 sg13cmos5l_inv_1_14.A.n6 sg13cmos5l_inv_1_14.A.t4 5.61733
R18665 sg13cmos5l_inv_1_14.A.n3 sg13cmos5l_inv_1_14.A.t6 5.19555
R18666 sg13cmos5l_inv_1_14.A.n2 sg13cmos5l_inv_1_14.A.t9 5.19555
R18667 sg13cmos5l_inv_1_14.A.n1 sg13cmos5l_inv_1_14.A.n7 4.5005
R18668 sg13cmos5l_inv_1_14.A.n0 sg13cmos5l_inv_1_14.A.n2 4.5005
R18669 sg13cmos5l_inv_1_14.A.n0 sg13cmos5l_inv_1_14.A.n3 4.5005
R18670 sg13cmos5l_inv_1_14.A.n1 sg13cmos5l_inv_1_14.A.n5 4.5005
R18671 sg13cmos5l_inv_1_14.A.n6 sg13cmos5l_inv_1_14.A.t8 4.08428
R18672 sg13cmos5l_inv_1_14.A.n4 sg13cmos5l_inv_1_14.A.t7 4.08428
R18673 sg13cmos5l_inv_1_14.A.n1 sg13cmos5l_inv_1_14.A.n0 1.60271
R18674 sg13cmos5l_inv_1_14.A.n7 sg13cmos5l_inv_1_14.A.n6 1.11201
R18675 sg13cmos5l_inv_1_14.A.n5 sg13cmos5l_inv_1_14.A.n4 1.11201
R18676 sg13cmos5l_inv_1_2.A sg13cmos5l_inv_1_2.A.n1 26.8322
R18677 sg13cmos5l_inv_1_2.A.n5 sg13cmos5l_inv_1_2.A.t5 17.5045
R18678 sg13cmos5l_inv_1_2.A.n2 sg13cmos5l_inv_1_2.A.t2 17.5045
R18679 sg13cmos5l_inv_1_2.A.n3 sg13cmos5l_inv_1_2.A.t1 17.5045
R18680 sg13cmos5l_inv_1_2.A.n7 sg13cmos5l_inv_1_2.A.t0 17.5045
R18681 sg13cmos5l_inv_1_2.A.n0 sg13cmos5l_inv_1_2.A.t10 17.3688
R18682 sg13cmos5l_inv_1_2.A sg13cmos5l_inv_1_2.A.t11 15.0005
R18683 sg13cmos5l_inv_1_2.A.n6 sg13cmos5l_inv_1_2.A.t3 5.61908
R18684 sg13cmos5l_inv_1_2.A.n4 sg13cmos5l_inv_1_2.A.t4 5.61733
R18685 sg13cmos5l_inv_1_2.A.n2 sg13cmos5l_inv_1_2.A.t9 5.19555
R18686 sg13cmos5l_inv_1_2.A.n3 sg13cmos5l_inv_1_2.A.t8 5.19555
R18687 sg13cmos5l_inv_1_2.A.n1 sg13cmos5l_inv_1_2.A.n5 4.5005
R18688 sg13cmos5l_inv_1_2.A.n1 sg13cmos5l_inv_1_2.A.n7 4.5005
R18689 sg13cmos5l_inv_1_2.A.n0 sg13cmos5l_inv_1_2.A.n3 4.5005
R18690 sg13cmos5l_inv_1_2.A.n0 sg13cmos5l_inv_1_2.A.n2 4.5005
R18691 sg13cmos5l_inv_1_2.A.n4 sg13cmos5l_inv_1_2.A.t7 4.08428
R18692 sg13cmos5l_inv_1_2.A.n6 sg13cmos5l_inv_1_2.A.t6 4.08428
R18693 sg13cmos5l_inv_1_2.A.n1 sg13cmos5l_inv_1_2.A.n0 1.60271
R18694 sg13cmos5l_inv_1_2.A.n5 sg13cmos5l_inv_1_2.A.n4 1.11201
R18695 sg13cmos5l_inv_1_2.A.n7 sg13cmos5l_inv_1_2.A.n6 1.11201
R18696 sg13cmos5l_and2_1_5.B sg13cmos5l_and2_1_5.B.n0 60.6365
R18697 sg13cmos5l_and2_1_5.B sg13cmos5l_and2_1_5.B.t2 15.0005
R18698 sg13cmos5l_and2_1_5.B sg13cmos5l_and2_1_5.B.t3 15.0005
R18699 sg13cmos5l_and2_1_5.B.n0 sg13cmos5l_and2_1_5.B 9.85624
R18700 sg13cmos5l_and2_1_5.B.n0 sg13cmos5l_and2_1_5.B 9.57904
R18701 sg13cmos5l_and2_1_5.B sg13cmos5l_and2_1_5.B.t0 8.9509
R18702 sg13cmos5l_and2_1_5.B sg13cmos5l_and2_1_5.B.t1 5.80809
R18703 sg13cmos5l_and2_1_5.A.n1 sg13cmos5l_and2_1_5.A.n0 49.5804
R18704 sg13cmos5l_and2_1_5.A.n1 sg13cmos5l_and2_1_5.A 30.6107
R18705 sg13cmos5l_and2_1_5.A.n0 sg13cmos5l_and2_1_5.A 28.2844
R18706 sg13cmos5l_and2_1_5.A sg13cmos5l_and2_1_5.A.t3 15.0072
R18707 sg13cmos5l_and2_1_5.A sg13cmos5l_and2_1_5.A.t2 15.0005
R18708 sg13cmos5l_and2_1_5.A.n0 sg13cmos5l_and2_1_5.A 9.19499
R18709 sg13cmos5l_and2_1_5.A sg13cmos5l_and2_1_5.A.n1 9.1012
R18710 sg13cmos5l_and2_1_5.A sg13cmos5l_and2_1_5.A.t0 8.9509
R18711 sg13cmos5l_and2_1_5.A sg13cmos5l_and2_1_5.A.t4 7.5292
R18712 sg13cmos5l_and2_1_5.A sg13cmos5l_and2_1_5.A.t1 5.80843
R18713 sg13cmos5l_inv_1_18.Y sg13cmos5l_inv_1_18.Y.t2 88.1627
R18714 sg13cmos5l_inv_1_18.Y sg13cmos5l_inv_1_18.Y.t0 8.46054
R18715 sg13cmos5l_inv_1_18.Y sg13cmos5l_inv_1_18.Y.t1 6.45447
R18716 sg13cmos5l_inv_1_17.Y.n0 sg13cmos5l_inv_1_17.Y.t2 81.9494
R18717 sg13cmos5l_inv_1_17.Y.n0 sg13cmos5l_inv_1_17.Y.t3 80.8274
R18718 sg13cmos5l_inv_1_17.Y sg13cmos5l_inv_1_17.Y.n0 54.4946
R18719 sg13cmos5l_inv_1_17.Y sg13cmos5l_inv_1_17.Y.t0 8.46054
R18720 sg13cmos5l_inv_1_17.Y sg13cmos5l_inv_1_17.Y.t1 6.45447
R18721 sg13cmos5l_inv_1_17.A.n0 sg13cmos5l_inv_1_17.A.t2 82.2172
R18722 sg13cmos5l_inv_1_17.A.n0 sg13cmos5l_inv_1_17.A.t3 74.5876
R18723 sg13cmos5l_inv_1_17.A.n1 sg13cmos5l_inv_1_17.A.n0 60.3438
R18724 sg13cmos5l_inv_1_17.A sg13cmos5l_inv_1_17.A.n1 28.1815
R18725 sg13cmos5l_inv_1_17.A sg13cmos5l_inv_1_17.A.t4 15.0205
R18726 sg13cmos5l_inv_1_17.A.n1 sg13cmos5l_inv_1_17.A 9.0005
R18727 sg13cmos5l_inv_1_17.A sg13cmos5l_inv_1_17.A.t1 8.7848
R18728 sg13cmos5l_inv_1_17.A sg13cmos5l_inv_1_17.A.t0 6.12191
R18729 sg13cmos5l_inv_1_16.Y.n0 sg13cmos5l_inv_1_16.Y.t2 85.1488
R18730 sg13cmos5l_inv_1_16.Y.n0 sg13cmos5l_inv_1_16.Y.t3 84.0247
R18731 sg13cmos5l_inv_1_16.Y sg13cmos5l_inv_1_16.Y.n0 55.7408
R18732 sg13cmos5l_inv_1_16.Y sg13cmos5l_inv_1_16.Y.t0 8.46054
R18733 sg13cmos5l_inv_1_16.Y sg13cmos5l_inv_1_16.Y.t1 6.45447
R18734 sg13cmos5l_inv_1_16.A.n0 sg13cmos5l_inv_1_16.A.t2 83.788
R18735 sg13cmos5l_inv_1_16.A.n0 sg13cmos5l_inv_1_16.A.t3 75.7095
R18736 sg13cmos5l_inv_1_16.A.n1 sg13cmos5l_inv_1_16.A.n0 43.6215
R18737 sg13cmos5l_inv_1_16.A sg13cmos5l_inv_1_16.A.t4 15.0005
R18738 sg13cmos5l_inv_1_16.A sg13cmos5l_inv_1_16.A.n1 10.0481
R18739 sg13cmos5l_inv_1_16.A.n1 sg13cmos5l_inv_1_16.A 9.01447
R18740 sg13cmos5l_inv_1_16.A sg13cmos5l_inv_1_16.A.t0 8.7848
R18741 sg13cmos5l_inv_1_16.A sg13cmos5l_inv_1_16.A.t1 6.12191
R18742 quantizer2_lfsr_0.sg13cmos5l_dfrbpq_1_0.D quantizer2_lfsr_0.sg13cmos5l_dfrbpq_1_0.D.t1 17.0005
R18743 quantizer2_lfsr_0.sg13cmos5l_dfrbpq_1_0.D quantizer2_lfsr_0.sg13cmos5l_dfrbpq_1_0.D.t2 15.0404
R18744 quantizer2_lfsr_0.sg13cmos5l_dfrbpq_1_0.D quantizer2_lfsr_0.sg13cmos5l_dfrbpq_1_0.D.t0 9.52909
R18745 quantizer2_lfsr_0.sg13cmos5l_dfrbpq_1_0.D.t1 quantizer2_lfsr_0.sg13cmos5l_dfrbpq_1_0.D 8.7064
R18746 sg13cmos5l_nor2_2_0.B sg13cmos5l_nor2_2_0.B.t4 15.0005
R18747 sg13cmos5l_nor2_2_0.B sg13cmos5l_nor2_2_0.B.t1 9.07996
R18748 sg13cmos5l_nor2_2_0.B sg13cmos5l_nor2_2_0.B.t0 8.55846
R18749 sg13cmos5l_nor2_2_0.B sg13cmos5l_nor2_2_0.B.t2 6.44919
R18750 sg13cmos5l_nor2_2_0.B sg13cmos5l_nor2_2_0.B.t3 6.2747
R18751 sg13cmos5l_inv_1_20.Y.n0 sg13cmos5l_inv_1_20.Y.t3 88.8923
R18752 sg13cmos5l_inv_1_20.Y.n0 sg13cmos5l_inv_1_20.Y.t2 76.6383
R18753 sg13cmos5l_inv_1_20.Y sg13cmos5l_inv_1_20.Y.n0 49.3037
R18754 sg13cmos5l_inv_1_20.Y sg13cmos5l_inv_1_20.Y.t0 9.23794
R18755 sg13cmos5l_inv_1_20.Y sg13cmos5l_inv_1_20.Y.t1 5.67707
R18756 sg13cmos5l_inv_1_13.Y.n0 sg13cmos5l_inv_1_13.Y.t3 91.7225
R18757 sg13cmos5l_inv_1_13.Y.n0 sg13cmos5l_inv_1_13.Y.t2 79.5932
R18758 sg13cmos5l_inv_1_13.Y sg13cmos5l_inv_1_13.Y.n0 28.9687
R18759 sg13cmos5l_inv_1_13.Y sg13cmos5l_inv_1_13.Y.t1 17.0005
R18760 sg13cmos5l_inv_1_13.Y sg13cmos5l_inv_1_13.Y.t0 9.23794
R18761 sg13cmos5l_inv_1_13.Y.t1 sg13cmos5l_inv_1_13.Y 8.70457
R18762 sg13cmos5l_inv_1_9.Y.n0 sg13cmos5l_inv_1_9.Y.t3 92.6655
R18763 sg13cmos5l_inv_1_9.Y sg13cmos5l_inv_1_9.Y.n0 62.5851
R18764 sg13cmos5l_inv_1_9.Y.n0 sg13cmos5l_inv_1_9.Y.t2 34.5987
R18765 sg13cmos5l_inv_1_9.Y sg13cmos5l_inv_1_9.Y.t0 9.30079
R18766 sg13cmos5l_inv_1_9.Y sg13cmos5l_inv_1_9.Y.t1 5.73403
R18767 sg13cmos5l_nand2_2_0.B.n0 sg13cmos5l_nand2_2_0.B 53.6971
R18768 sg13cmos5l_nand2_2_0.B.n0 sg13cmos5l_nand2_2_0.B 28.071
R18769 sg13cmos5l_nand2_2_0.B sg13cmos5l_nand2_2_0.B.t2 15.0555
R18770 sg13cmos5l_nand2_2_0.B sg13cmos5l_nand2_2_0.B.t0 9.26529
R18771 sg13cmos5l_nand2_2_0.B sg13cmos5l_nand2_2_0.B.n0 9.23549
R18772 sg13cmos5l_nand2_2_0.B sg13cmos5l_nand2_2_0.B.t1 5.73951
R18773 sg13cmos5l_nand2_2_0.B sg13cmos5l_nand2_2_0.B.t3 3.69044
R18774 sg13cmos5l_nand2_1_2.Y.n0 sg13cmos5l_nand2_1_2.Y.t3 78.6683
R18775 sg13cmos5l_nand2_1_2.Y.n1 sg13cmos5l_nand2_1_2.Y.n0 49.3941
R18776 sg13cmos5l_nand2_1_2.Y.n0 sg13cmos5l_nand2_1_2.Y.t2 47.6354
R18777 sg13cmos5l_nand2_1_2.Y.n1 sg13cmos5l_nand2_1_2.Y 28.4929
R18778 sg13cmos5l_nand2_1_2.Y sg13cmos5l_nand2_1_2.Y.t4 15.0005
R18779 sg13cmos5l_nand2_1_2.Y sg13cmos5l_nand2_1_2.Y.n1 9.13705
R18780 sg13cmos5l_nand2_1_2.Y sg13cmos5l_nand2_1_2.Y.t0 9.31311
R18781 sg13cmos5l_nand2_1_2.Y sg13cmos5l_nand2_1_2.Y.t1 5.76129
R18782 sg13cmos5l_inv_1_13.A.n0 sg13cmos5l_inv_1_13.A.t3 87.5614
R18783 sg13cmos5l_inv_1_13.A.n0 sg13cmos5l_inv_1_13.A.t2 38.753
R18784 sg13cmos5l_inv_1_13.A.n1 sg13cmos5l_inv_1_13.A.n0 21.2925
R18785 sg13cmos5l_inv_1_13.A sg13cmos5l_inv_1_13.A.t4 15.0215
R18786 sg13cmos5l_inv_1_13.A.n1 sg13cmos5l_inv_1_13.A 10.1996
R18787 sg13cmos5l_inv_1_13.A sg13cmos5l_inv_1_13.A.n1 9.00101
R18788 sg13cmos5l_inv_1_13.A sg13cmos5l_inv_1_13.A.t1 9.31311
R18789 sg13cmos5l_inv_1_13.A sg13cmos5l_inv_1_13.A.t0 5.76129
R18790 sg13cmos5l_or2_1_0.X.n0 sg13cmos5l_or2_1_0.X.t2 73.8809
R18791 sg13cmos5l_or2_1_0.X.n1 sg13cmos5l_or2_1_0.X.n0 66.4513
R18792 sg13cmos5l_or2_1_0.X.n1 sg13cmos5l_or2_1_0.X 56.0459
R18793 sg13cmos5l_or2_1_0.X.n0 sg13cmos5l_or2_1_0.X.t3 26.5241
R18794 sg13cmos5l_or2_1_0.X sg13cmos5l_or2_1_0.X.t4 15.0215
R18795 sg13cmos5l_or2_1_0.X sg13cmos5l_or2_1_0.X.n1 9.0005
R18796 sg13cmos5l_or2_1_0.X sg13cmos5l_or2_1_0.X.t0 9.42032
R18797 sg13cmos5l_or2_1_0.X sg13cmos5l_or2_1_0.X.t1 5.72555
R18798 sg13cmos5l_inv_1_3.Y.n0 sg13cmos5l_inv_1_3.Y.t2 127.924
R18799 sg13cmos5l_inv_1_3.Y sg13cmos5l_inv_1_3.Y.n0 63.2737
R18800 sg13cmos5l_inv_1_3.Y.n0 sg13cmos5l_inv_1_3.Y.t3 12.6189
R18801 sg13cmos5l_inv_1_3.Y sg13cmos5l_inv_1_3.Y.t0 9.23794
R18802 sg13cmos5l_inv_1_3.Y sg13cmos5l_inv_1_3.Y.t1 5.67707
R18803 inv_en_0.di_b inv_en_0.di_b.t0 10.198
R18804 inv_en_0.di_b inv_en_0.di_b.t1 8.82668
R18805 inv_en_0.di_b inv_en_0.di_b.t2 7.48419
R18806 sg13cmos5l_and2_1_5.X.n0 sg13cmos5l_and2_1_5.X 63.978
R18807 sg13cmos5l_and2_1_5.X sg13cmos5l_and2_1_5.X.n0 28.3921
R18808 sg13cmos5l_and2_1_5.X sg13cmos5l_and2_1_5.X.t3 15.0703
R18809 sg13cmos5l_and2_1_5.X.n0 sg13cmos5l_and2_1_5.X 9.0005
R18810 sg13cmos5l_and2_1_5.X sg13cmos5l_and2_1_5.X.t0 8.93259
R18811 sg13cmos5l_and2_1_5.X sg13cmos5l_and2_1_5.X.t2 7.48419
R18812 sg13cmos5l_and2_1_5.X sg13cmos5l_and2_1_5.X.t1 5.75619
R18813 sg13cmos5l_inv_1_19.Y.n4 sg13cmos5l_inv_1_19.Y.n3 96.1255
R18814 sg13cmos5l_inv_1_19.Y.n5 sg13cmos5l_inv_1_19.Y.n4 29.3349
R18815 sg13cmos5l_inv_1_19.Y.n1 sg13cmos5l_inv_1_19.Y.t5 24.0132
R18816 sg13cmos5l_inv_1_19.Y.n3 sg13cmos5l_inv_1_19.Y.t4 24.0132
R18817 sg13cmos5l_inv_1_19.Y.n5 sg13cmos5l_inv_1_19.Y 19.1997
R18818 sg13cmos5l_inv_1_19.Y sg13cmos5l_inv_1_19.Y.n5 18.7716
R18819 sg13cmos5l_inv_1_19.Y.n0 sg13cmos5l_inv_1_19.Y.t6 15.2163
R18820 sg13cmos5l_inv_1_19.Y.n2 sg13cmos5l_inv_1_19.Y.t3 15.2163
R18821 sg13cmos5l_inv_1_19.Y sg13cmos5l_inv_1_19.Y.t8 15.0319
R18822 sg13cmos5l_inv_1_19.Y.n0 sg13cmos5l_inv_1_19.Y.t7 15.0005
R18823 sg13cmos5l_inv_1_19.Y.n2 sg13cmos5l_inv_1_19.Y.t2 15.0005
R18824 sg13cmos5l_inv_1_19.Y.n4 sg13cmos5l_inv_1_19.Y.n1 13.6315
R18825 sg13cmos5l_inv_1_19.Y.n1 sg13cmos5l_inv_1_19.Y.n0 9.96637
R18826 sg13cmos5l_inv_1_19.Y.n3 sg13cmos5l_inv_1_19.Y.n2 9.96637
R18827 sg13cmos5l_inv_1_19.Y sg13cmos5l_inv_1_19.Y.t0 8.46054
R18828 sg13cmos5l_inv_1_19.Y sg13cmos5l_inv_1_19.Y.t1 6.45413
R18829 sg13cmos5l_inv_1_3.A.n0 sg13cmos5l_inv_1_3.A.t2 69.482
R18830 sg13cmos5l_inv_1_3.A.n1 sg13cmos5l_inv_1_3.A.n0 53.1133
R18831 sg13cmos5l_inv_1_3.A.n0 sg13cmos5l_inv_1_3.A.t3 26.1644
R18832 sg13cmos5l_inv_1_3.A.n1 sg13cmos5l_inv_1_3.A 18.6735
R18833 sg13cmos5l_inv_1_3.A sg13cmos5l_inv_1_3.A.n1 18.0937
R18834 sg13cmos5l_inv_1_3.A sg13cmos5l_inv_1_3.A.t4 15.0072
R18835 sg13cmos5l_inv_1_3.A sg13cmos5l_inv_1_3.A.t0 9.05443
R18836 sg13cmos5l_inv_1_3.A sg13cmos5l_inv_1_3.A.t1 5.71549
R18837 sg13cmos5l_inv_1_4.Y.n0 sg13cmos5l_inv_1_4.Y.t2 69.7961
R18838 sg13cmos5l_inv_1_4.Y.n0 sg13cmos5l_inv_1_4.Y.t3 58.576
R18839 sg13cmos5l_inv_1_4.Y sg13cmos5l_inv_1_4.Y.n0 49.59
R18840 sg13cmos5l_inv_1_4.Y sg13cmos5l_inv_1_4.Y.t0 9.31642
R18841 sg13cmos5l_inv_1_4.Y sg13cmos5l_inv_1_4.Y.t1 5.755
R18842 sg13cmos5l_inv_1_6.Y.n0 sg13cmos5l_inv_1_6.Y.t2 84.8226
R18843 sg13cmos5l_inv_1_6.Y.n0 sg13cmos5l_inv_1_6.Y.t3 78.0906
R18844 sg13cmos5l_inv_1_6.Y sg13cmos5l_inv_1_6.Y.n0 56.0897
R18845 sg13cmos5l_inv_1_6.Y sg13cmos5l_inv_1_6.Y.t1 17.0005
R18846 sg13cmos5l_inv_1_6.Y sg13cmos5l_inv_1_6.Y.t0 9.23794
R18847 sg13cmos5l_inv_1_6.Y.t1 sg13cmos5l_inv_1_6.Y 8.70457
R18848 sg13cmos5l_inv_1_4.A.n0 sg13cmos5l_inv_1_4.A.t2 106.055
R18849 sg13cmos5l_inv_1_4.A.n0 sg13cmos5l_inv_1_4.A.t3 56.7986
R18850 sg13cmos5l_inv_1_4.A.n1 sg13cmos5l_inv_1_4.A.n0 51.1827
R18851 sg13cmos5l_inv_1_4.A.n1 sg13cmos5l_inv_1_4.A 18.7244
R18852 sg13cmos5l_inv_1_4.A sg13cmos5l_inv_1_4.A.n1 18.3679
R18853 sg13cmos5l_inv_1_4.A sg13cmos5l_inv_1_4.A.t4 15.0005
R18854 sg13cmos5l_inv_1_4.A sg13cmos5l_inv_1_4.A.t0 9.31311
R18855 sg13cmos5l_inv_1_4.A sg13cmos5l_inv_1_4.A.t1 5.76129
R18856 sg13cmos5l_inv_1_6.A.n0 sg13cmos5l_inv_1_6.A.t2 140.436
R18857 sg13cmos5l_inv_1_6.A.n0 sg13cmos5l_inv_1_6.A.t3 57.4935
R18858 sg13cmos5l_inv_1_6.A.n1 sg13cmos5l_inv_1_6.A.n0 33.3122
R18859 sg13cmos5l_inv_1_6.A.n1 sg13cmos5l_inv_1_6.A 18.667
R18860 sg13cmos5l_inv_1_6.A sg13cmos5l_inv_1_6.A.n1 18.3877
R18861 sg13cmos5l_inv_1_6.A sg13cmos5l_inv_1_6.A.t4 15.0005
R18862 sg13cmos5l_inv_1_6.A sg13cmos5l_inv_1_6.A.t1 9.31311
R18863 sg13cmos5l_inv_1_6.A sg13cmos5l_inv_1_6.A.t0 5.76129
R18864 sg13cmos5l_nand2_1_5.A.n3 sg13cmos5l_nand2_1_5.A.n2 78.2496
R18865 sg13cmos5l_nand2_1_5.A sg13cmos5l_nand2_1_5.A.n4 31.3796
R18866 sg13cmos5l_nand2_1_5.A.n4 sg13cmos5l_nand2_1_5.A 27.1747
R18867 sg13cmos5l_nand2_1_5.A.n0 sg13cmos5l_nand2_1_5.A 19.8726
R18868 sg13cmos5l_nand2_1_5.A.n1 sg13cmos5l_nand2_1_5.A.n0 19.4969
R18869 sg13cmos5l_nand2_1_5.A.n4 sg13cmos5l_nand2_1_5.A.n3 19.3539
R18870 sg13cmos5l_nand2_1_5.A.n1 sg13cmos5l_nand2_1_5.A 18.1452
R18871 sg13cmos5l_nand2_1_5.A.n2 sg13cmos5l_nand2_1_5.A 18.0987
R18872 sg13cmos5l_nand2_1_5.A.n0 sg13cmos5l_nand2_1_5.A 18.007
R18873 sg13cmos5l_nand2_1_5.A sg13cmos5l_nand2_1_5.A.t5 15.0638
R18874 sg13cmos5l_nand2_1_5.A sg13cmos5l_nand2_1_5.A.t7 15.0338
R18875 sg13cmos5l_nand2_1_5.A sg13cmos5l_nand2_1_5.A.t3 15.0005
R18876 sg13cmos5l_nand2_1_5.A sg13cmos5l_nand2_1_5.A.t2 15.0005
R18877 sg13cmos5l_nand2_1_5.A sg13cmos5l_nand2_1_5.A.t4 15.0005
R18878 sg13cmos5l_nand2_1_5.A sg13cmos5l_nand2_1_5.A.t6 15.0005
R18879 sg13cmos5l_nand2_1_5.A.n3 sg13cmos5l_nand2_1_5.A 9.00445
R18880 sg13cmos5l_nand2_1_5.A sg13cmos5l_nand2_1_5.A.t0 8.93259
R18881 sg13cmos5l_nand2_1_5.A sg13cmos5l_nand2_1_5.A.t1 5.75575
R18882 sg13cmos5l_nand2_1_5.A.n2 sg13cmos5l_nand2_1_5.A.n1 1.7561
R18883 quantizer2_lfsr_0.sg13cmos5l_dfrbpq_1_13.D.n0 quantizer2_lfsr_0.sg13cmos5l_dfrbpq_1_13.D 24.3841
R18884 quantizer2_lfsr_0.sg13cmos5l_dfrbpq_1_13.D quantizer2_lfsr_0.sg13cmos5l_dfrbpq_1_13.D.n0 18.8156
R18885 quantizer2_lfsr_0.sg13cmos5l_dfrbpq_1_13.D.n0 quantizer2_lfsr_0.sg13cmos5l_dfrbpq_1_13.D 18.0596
R18886 quantizer2_lfsr_0.sg13cmos5l_dfrbpq_1_13.D quantizer2_lfsr_0.sg13cmos5l_dfrbpq_1_13.D.t3 15.0166
R18887 quantizer2_lfsr_0.sg13cmos5l_dfrbpq_1_13.D quantizer2_lfsr_0.sg13cmos5l_dfrbpq_1_13.D.t2 15.0005
R18888 quantizer2_lfsr_0.sg13cmos5l_dfrbpq_1_13.D quantizer2_lfsr_0.sg13cmos5l_dfrbpq_1_13.D.t0 9.11567
R18889 quantizer2_lfsr_0.sg13cmos5l_dfrbpq_1_13.D quantizer2_lfsr_0.sg13cmos5l_dfrbpq_1_13.D.t1 5.67423
R18890 quantizer2_lfsr_0.sg13cmos5l_dfrbpq_1_1.D.n0 quantizer2_lfsr_0.sg13cmos5l_dfrbpq_1_1.D 24.4613
R18891 quantizer2_lfsr_0.sg13cmos5l_dfrbpq_1_1.D quantizer2_lfsr_0.sg13cmos5l_dfrbpq_1_1.D.n0 18.9894
R18892 quantizer2_lfsr_0.sg13cmos5l_dfrbpq_1_1.D.n0 quantizer2_lfsr_0.sg13cmos5l_dfrbpq_1_1.D 18.0552
R18893 quantizer2_lfsr_0.sg13cmos5l_dfrbpq_1_1.D quantizer2_lfsr_0.sg13cmos5l_dfrbpq_1_1.D.t2 15.0404
R18894 quantizer2_lfsr_0.sg13cmos5l_dfrbpq_1_1.D quantizer2_lfsr_0.sg13cmos5l_dfrbpq_1_1.D.t3 15.0166
R18895 quantizer2_lfsr_0.sg13cmos5l_dfrbpq_1_1.D quantizer2_lfsr_0.sg13cmos5l_dfrbpq_1_1.D.t0 9.02886
R18896 quantizer2_lfsr_0.sg13cmos5l_dfrbpq_1_1.D quantizer2_lfsr_0.sg13cmos5l_dfrbpq_1_1.D.t1 5.76004
R18897 quantizer2_lfsr_0.sg13cmos5l_dfrbpq_1_2.D quantizer2_lfsr_0.sg13cmos5l_dfrbpq_1_2.D.t2 15.0404
R18898 quantizer2_lfsr_0.sg13cmos5l_dfrbpq_1_2.D quantizer2_lfsr_0.sg13cmos5l_dfrbpq_1_2.D.t1 9.70483
R18899 quantizer2_lfsr_0.sg13cmos5l_dfrbpq_1_2.D.t0 quantizer2_lfsr_0.sg13cmos5l_dfrbpq_1_2.D 5.67454
R18900 quantizer2_lfsr_0.sg13cmos5l_dfrbpq_1_11.D quantizer2_lfsr_0.sg13cmos5l_dfrbpq_1_11.D.t1 17.0005
R18901 quantizer2_lfsr_0.sg13cmos5l_dfrbpq_1_11.D quantizer2_lfsr_0.sg13cmos5l_dfrbpq_1_11.D.t2 15.0005
R18902 quantizer2_lfsr_0.sg13cmos5l_dfrbpq_1_11.D quantizer2_lfsr_0.sg13cmos5l_dfrbpq_1_11.D.t0 9.52909
R18903 quantizer2_lfsr_0.sg13cmos5l_dfrbpq_1_11.D.t1 quantizer2_lfsr_0.sg13cmos5l_dfrbpq_1_11.D 8.7064
R18904 dsm2_osc_0.d_btest_or dsm2_osc_0.d_btest_or.n0 27.5988
R18905 dsm2_osc_0.d_btest_or.n0 dsm2_osc_0.d_btest_or.t2 21.2696
R18906 dsm2_osc_0.d_btest_or.t1 dsm2_osc_0.d_btest_or 17.0005
R18907 dsm2_osc_0.d_btest_or.n0 dsm2_osc_0.d_btest_or.t3 14.6459
R18908 dsm2_osc_0.d_btest_or dsm2_osc_0.d_btest_or.t0 9.29077
R18909 dsm2_osc_0.d_btest_or dsm2_osc_0.d_btest_or.t1 8.68714
R18910 bias_gm_0.bias_trim_0.vz.n21 bias_gm_0.bias_trim_0.vz.t18 30.5156
R18911 bias_gm_0.bias_trim_0.vz.n18 bias_gm_0.bias_trim_0.vz.t21 29.2564
R18912 bias_gm_0.bias_trim_0.vz.n15 bias_gm_0.bias_trim_0.vz.t1 26.5193
R18913 bias_gm_0.bias_trim_0.vz.n20 bias_gm_0.bias_trim_0.vz.t19 26.3817
R18914 bias_gm_0.bias_trim_0.vz.n0 bias_gm_0.bias_trim_0.vz.t16 26.2673
R18915 bias_gm_0.bias_trim_0.vz.n0 bias_gm_0.bias_trim_0.vz.t13 26.2673
R18916 bias_gm_0.bias_trim_0.vz.n14 bias_gm_0.bias_trim_0.vz.t10 26.2673
R18917 bias_gm_0.bias_trim_0.vz.n14 bias_gm_0.bias_trim_0.vz.t7 26.2673
R18918 bias_gm_0.bias_trim_0.vz.n15 bias_gm_0.bias_trim_0.vz.t4 26.2673
R18919 bias_gm_0.bias_trim_0.vz.n1 bias_gm_0.bias_trim_0.vz.t29 18.3322
R18920 bias_gm_0.bias_trim_0.vz.n3 bias_gm_0.bias_trim_0.vz.t30 18.3322
R18921 bias_gm_0.bias_trim_0.vz.n6 bias_gm_0.bias_trim_0.vz.t42 18.3322
R18922 bias_gm_0.bias_trim_0.vz.n9 bias_gm_0.bias_trim_0.vz.t41 18.3322
R18923 bias_gm_0.bias_trim_0.vz.n20 bias_gm_0.bias_trim_0.vz.t20 17.8888
R18924 bias_gm_0.bias_trim_0.vz.n1 bias_gm_0.bias_trim_0.vz.t27 16.6996
R18925 bias_gm_0.bias_trim_0.vz.n2 bias_gm_0.bias_trim_0.vz.t31 16.6996
R18926 bias_gm_0.bias_trim_0.vz.n3 bias_gm_0.bias_trim_0.vz.t32 16.6996
R18927 bias_gm_0.bias_trim_0.vz.n4 bias_gm_0.bias_trim_0.vz.t28 16.6996
R18928 bias_gm_0.bias_trim_0.vz.n6 bias_gm_0.bias_trim_0.vz.t44 16.6996
R18929 bias_gm_0.bias_trim_0.vz.n7 bias_gm_0.bias_trim_0.vz.t40 16.6996
R18930 bias_gm_0.bias_trim_0.vz.n9 bias_gm_0.bias_trim_0.vz.t39 16.6996
R18931 bias_gm_0.bias_trim_0.vz.n9 bias_gm_0.bias_trim_0.vz.t43 16.6996
R18932 bias_gm_0.bias_trim_0.vz.n7 bias_gm_0.bias_trim_0.vz.n50 7.86382
R18933 bias_gm_0.bias_trim_0.vz.n42 bias_gm_0.bias_trim_0.vz.n3 7.86382
R18934 bias_gm_0.bias_trim_0.vz.n50 bias_gm_0.bias_trim_0.vz.n8 7.8613
R18935 bias_gm_0.bias_trim_0.vz.n2 bias_gm_0.bias_trim_0.vz.n42 7.8613
R18936 bias_gm_0.bias_trim_0.vz.n18 bias_gm_0.bias_trim_0.vz.n23 7.46019
R18937 bias_gm_0.bias_trim_0.vz.n5 bias_gm_0.bias_trim_0.vz.n29 7.46019
R18938 bias_gm_0.bias_trim_0.vz bias_gm_0.bias_trim_0.vz.n36 7.46019
R18939 bias_gm_0.bias_trim_0.vz.n35 bias_gm_0.bias_trim_0.vz 7.46019
R18940 bias_gm_0.bias_trim_0.vz bias_gm_0.bias_trim_0.vz.n49 7.46019
R18941 bias_gm_0.bias_trim_0.vz.n46 bias_gm_0.bias_trim_0.vz.n4 7.46019
R18942 bias_gm_0.bias_trim_0.vz.n4 bias_gm_0.bias_trim_0.vz.n45 7.46019
R18943 bias_gm_0.bias_trim_0.vz.n3 bias_gm_0.bias_trim_0.vz.n44 7.46019
R18944 bias_gm_0.bias_trim_0.vz.n43 bias_gm_0.bias_trim_0.vz.n3 7.46019
R18945 bias_gm_0.bias_trim_0.vz.n57 bias_gm_0.bias_trim_0.vz.n17 7.46019
R18946 bias_gm_0.bias_trim_0.vz.n6 bias_gm_0.bias_trim_0.vz.n54 7.46019
R18947 bias_gm_0.bias_trim_0.vz.n53 bias_gm_0.bias_trim_0.vz.n6 7.46019
R18948 bias_gm_0.bias_trim_0.vz.n52 bias_gm_0.bias_trim_0.vz.n7 7.46019
R18949 bias_gm_0.bias_trim_0.vz.n7 bias_gm_0.bias_trim_0.vz.n51 7.46019
R18950 bias_gm_0.bias_trim_0.vz.n23 bias_gm_0.bias_trim_0.vz.n13 7.45767
R18951 bias_gm_0.bias_trim_0.vz.n29 bias_gm_0.bias_trim_0.vz.n12 7.45767
R18952 bias_gm_0.bias_trim_0.vz.n36 bias_gm_0.bias_trim_0.vz.n10 7.45767
R18953 bias_gm_0.bias_trim_0.vz.n10 bias_gm_0.bias_trim_0.vz.n35 7.45767
R18954 bias_gm_0.bias_trim_0.vz.n49 bias_gm_0.bias_trim_0.vz 7.45767
R18955 bias_gm_0.bias_trim_0.vz bias_gm_0.bias_trim_0.vz.n46 7.45767
R18956 bias_gm_0.bias_trim_0.vz.n45 bias_gm_0.bias_trim_0.vz 7.45767
R18957 bias_gm_0.bias_trim_0.vz.n44 bias_gm_0.bias_trim_0.vz.n2 7.45767
R18958 bias_gm_0.bias_trim_0.vz.n2 bias_gm_0.bias_trim_0.vz.n43 7.45767
R18959 bias_gm_0.bias_trim_0.vz.n11 bias_gm_0.bias_trim_0.vz.n57 7.45767
R18960 bias_gm_0.bias_trim_0.vz.n54 bias_gm_0.bias_trim_0.vz.n11 7.45767
R18961 bias_gm_0.bias_trim_0.vz.n9 bias_gm_0.bias_trim_0.vz.n53 7.45767
R18962 bias_gm_0.bias_trim_0.vz.n8 bias_gm_0.bias_trim_0.vz.n52 7.45767
R18963 bias_gm_0.bias_trim_0.vz.n51 bias_gm_0.bias_trim_0.vz.n8 7.45767
R18964 bias_gm_0.bias_trim_0.vz.n48 bias_gm_0.bias_trim_0.vz.n47 6.42799
R18965 bias_gm_0.bias_trim_0.vz.n56 bias_gm_0.bias_trim_0.vz.n55 6.42799
R18966 bias_gm_0.bias_trim_0.vz.n13 bias_gm_0.bias_trim_0.vz.n21 6.15447
R18967 bias_gm_0.bias_trim_0.vz.n24 bias_gm_0.bias_trim_0.vz.n18 6.10607
R18968 bias_gm_0.bias_trim_0.vz bias_gm_0.bias_trim_0.vz.n41 6.10607
R18969 bias_gm_0.bias_trim_0.vz.n37 bias_gm_0.bias_trim_0.vz 6.10607
R18970 bias_gm_0.bias_trim_0.vz.n33 bias_gm_0.bias_trim_0.vz.n5 6.10607
R18971 bias_gm_0.bias_trim_0.vz.n30 bias_gm_0.bias_trim_0.vz.n5 6.10607
R18972 bias_gm_0.bias_trim_0.vz.n27 bias_gm_0.bias_trim_0.vz.n5 6.10607
R18973 bias_gm_0.bias_trim_0.vz.n22 bias_gm_0.bias_trim_0.vz.n13 6.10563
R18974 bias_gm_0.bias_trim_0.vz.n40 bias_gm_0.bias_trim_0.vz.n10 6.10563
R18975 bias_gm_0.bias_trim_0.vz.n10 bias_gm_0.bias_trim_0.vz.n16 6.10563
R18976 bias_gm_0.bias_trim_0.vz.n12 bias_gm_0.bias_trim_0.vz.n34 6.10563
R18977 bias_gm_0.bias_trim_0.vz.n19 bias_gm_0.bias_trim_0.vz.n12 6.10563
R18978 bias_gm_0.bias_trim_0.vz.n12 bias_gm_0.bias_trim_0.vz.n28 6.10563
R18979 bias_gm_0.bias_trim_0.vz.n21 bias_gm_0.bias_trim_0.vz.n20 5.81447
R18980 bias_gm_0.bias_trim_0.vz.n48 bias_gm_0.bias_trim_0.vz.t23 5.63491
R18981 bias_gm_0.bias_trim_0.vz.n47 bias_gm_0.bias_trim_0.vz.t24 5.63491
R18982 bias_gm_0.bias_trim_0.vz.n55 bias_gm_0.bias_trim_0.vz.t47 5.63491
R18983 bias_gm_0.bias_trim_0.vz.n56 bias_gm_0.bias_trim_0.vz.t48 5.63491
R18984 bias_gm_0.bias_trim_0.vz.n47 bias_gm_0.bias_trim_0.vz.n4 5.43231
R18985 bias_gm_0.bias_trim_0.vz bias_gm_0.bias_trim_0.vz.n48 5.43231
R18986 bias_gm_0.bias_trim_0.vz.n17 bias_gm_0.bias_trim_0.vz.n56 5.43231
R18987 bias_gm_0.bias_trim_0.vz.n55 bias_gm_0.bias_trim_0.vz.n11 5.43231
R18988 bias_gm_0.bias_trim_0.vz.n39 bias_gm_0.bias_trim_0.vz.n0 4.75241
R18989 bias_gm_0.bias_trim_0.vz.n15 bias_gm_0.bias_trim_0.vz.n25 4.5005
R18990 bias_gm_0.bias_trim_0.vz.n26 bias_gm_0.bias_trim_0.vz.n15 4.5005
R18991 bias_gm_0.bias_trim_0.vz.n14 bias_gm_0.bias_trim_0.vz.n31 4.5005
R18992 bias_gm_0.bias_trim_0.vz.n32 bias_gm_0.bias_trim_0.vz.n0 4.5005
R18993 bias_gm_0.bias_trim_0.vz.n0 bias_gm_0.bias_trim_0.vz.n38 4.5005
R18994 bias_gm_0.bias_trim_0.vz.t15 bias_gm_0.bias_trim_0.vz.n40 3.3799
R18995 bias_gm_0.bias_trim_0.vz.n41 bias_gm_0.bias_trim_0.vz.t15 3.3799
R18996 bias_gm_0.bias_trim_0.vz.t12 bias_gm_0.bias_trim_0.vz.n16 3.3799
R18997 bias_gm_0.bias_trim_0.vz.n37 bias_gm_0.bias_trim_0.vz.t12 3.3799
R18998 bias_gm_0.bias_trim_0.vz.n34 bias_gm_0.bias_trim_0.vz.t9 3.3799
R18999 bias_gm_0.bias_trim_0.vz.t9 bias_gm_0.bias_trim_0.vz.n33 3.3799
R19000 bias_gm_0.bias_trim_0.vz.t6 bias_gm_0.bias_trim_0.vz.n19 3.3799
R19001 bias_gm_0.bias_trim_0.vz.n30 bias_gm_0.bias_trim_0.vz.t6 3.3799
R19002 bias_gm_0.bias_trim_0.vz.n28 bias_gm_0.bias_trim_0.vz.t3 3.3799
R19003 bias_gm_0.bias_trim_0.vz.t3 bias_gm_0.bias_trim_0.vz.n27 3.3799
R19004 bias_gm_0.bias_trim_0.vz.t0 bias_gm_0.bias_trim_0.vz.n22 3.3799
R19005 bias_gm_0.bias_trim_0.vz.n24 bias_gm_0.bias_trim_0.vz.t0 3.3799
R19006 bias_gm_0.bias_trim_0.vz.n4 bias_gm_0.bias_trim_0.vz.n3 2.42228
R19007 bias_gm_0.bias_trim_0.vz.n25 bias_gm_0.bias_trim_0.vz.n22 2.25545
R19008 bias_gm_0.bias_trim_0.vz.n40 bias_gm_0.bias_trim_0.vz.n39 2.25545
R19009 bias_gm_0.bias_trim_0.vz.n38 bias_gm_0.bias_trim_0.vz.n16 2.25545
R19010 bias_gm_0.bias_trim_0.vz.n34 bias_gm_0.bias_trim_0.vz.n32 2.25545
R19011 bias_gm_0.bias_trim_0.vz.n31 bias_gm_0.bias_trim_0.vz.n19 2.25545
R19012 bias_gm_0.bias_trim_0.vz.n28 bias_gm_0.bias_trim_0.vz.n26 2.25545
R19013 bias_gm_0.bias_trim_0.vz.n25 bias_gm_0.bias_trim_0.vz.n24 2.25501
R19014 bias_gm_0.bias_trim_0.vz.n41 bias_gm_0.bias_trim_0.vz.n39 2.25501
R19015 bias_gm_0.bias_trim_0.vz.n38 bias_gm_0.bias_trim_0.vz.n37 2.25501
R19016 bias_gm_0.bias_trim_0.vz.n33 bias_gm_0.bias_trim_0.vz.n32 2.25501
R19017 bias_gm_0.bias_trim_0.vz.n31 bias_gm_0.bias_trim_0.vz.n30 2.25501
R19018 bias_gm_0.bias_trim_0.vz.n27 bias_gm_0.bias_trim_0.vz.n26 2.25501
R19019 bias_gm_0.bias_trim_0.vz.n0 bias_gm_0.bias_trim_0.vz.n14 1.9671
R19020 bias_gm_0.bias_trim_0.vz.n11 bias_gm_0.bias_trim_0.vz.n10 1.66656
R19021 bias_gm_0.bias_trim_0.vz.n1 bias_gm_0.bias_trim_0.vz 1.61502
R19022 bias_gm_0.bias_trim_0.vz.n10 bias_gm_0.bias_trim_0.vz.n12 1.61502
R19023 bias_gm_0.bias_trim_0.vz.n11 bias_gm_0.bias_trim_0.vz.n9 1.61502
R19024 bias_gm_0.bias_trim_0.vz.n9 bias_gm_0.bias_trim_0.vz.n8 1.61502
R19025 bias_gm_0.bias_trim_0.vz.n7 bias_gm_0.bias_trim_0.vz.n6 1.61502
R19026 bias_gm_0.bias_trim_0.vz.n17 bias_gm_0.bias_trim_0.vz.n6 1.61502
R19027 bias_gm_0.bias_trim_0.vz bias_gm_0.bias_trim_0.vz.n5 1.61502
R19028 bias_gm_0.bias_trim_0.vz.n18 bias_gm_0.bias_trim_0.vz.n5 1.61502
R19029 bias_gm_0.bias_trim_0.vz.n2 bias_gm_0.bias_trim_0.vz.n1 1.61502
R19030 bias_gm_0.bias_trim_0.vz bias_gm_0.bias_trim_0.vz.n4 1.43895
R19031 bias_gm_0.bias_trim_0.vz.n15 bias_gm_0.bias_trim_0.vz.n14 1.36311
R19032 bias_gm_0.bias_trim_0.vz.n12 bias_gm_0.bias_trim_0.vz.n13 1.21139
R19033 bias_gm_0.bias_trim_0.vz.n17 bias_gm_0.bias_trim_0.vz 1.19316
R19034 bias_gm_0.bias_trim_0.vz.n23 bias_gm_0.bias_trim_0.vz.t53 1.0149
R19035 bias_gm_0.bias_trim_0.vz.n29 bias_gm_0.bias_trim_0.vz.t52 1.0149
R19036 bias_gm_0.bias_trim_0.vz.n36 bias_gm_0.bias_trim_0.vz.t51 1.0149
R19037 bias_gm_0.bias_trim_0.vz.n35 bias_gm_0.bias_trim_0.vz.t50 1.0149
R19038 bias_gm_0.bias_trim_0.vz.n49 bias_gm_0.bias_trim_0.vz.t22 1.0149
R19039 bias_gm_0.bias_trim_0.vz.n46 bias_gm_0.bias_trim_0.vz.t25 1.0149
R19040 bias_gm_0.bias_trim_0.vz.n45 bias_gm_0.bias_trim_0.vz.t26 1.0149
R19041 bias_gm_0.bias_trim_0.vz.n44 bias_gm_0.bias_trim_0.vz.t33 1.0149
R19042 bias_gm_0.bias_trim_0.vz.n43 bias_gm_0.bias_trim_0.vz.t34 1.0149
R19043 bias_gm_0.bias_trim_0.vz.n42 bias_gm_0.bias_trim_0.vz.t35 1.0149
R19044 bias_gm_0.bias_trim_0.vz.n57 bias_gm_0.bias_trim_0.vz.t49 1.0149
R19045 bias_gm_0.bias_trim_0.vz.n54 bias_gm_0.bias_trim_0.vz.t46 1.0149
R19046 bias_gm_0.bias_trim_0.vz.n53 bias_gm_0.bias_trim_0.vz.t45 1.0149
R19047 bias_gm_0.bias_trim_0.vz.n52 bias_gm_0.bias_trim_0.vz.t38 1.0149
R19048 bias_gm_0.bias_trim_0.vz.n51 bias_gm_0.bias_trim_0.vz.t37 1.0149
R19049 bias_gm_0.bias_trim_0.vz.n50 bias_gm_0.bias_trim_0.vz.t36 1.0149
R19050 sw_tgate_8.m.n8 sw_tgate_8.m.n7 19.7682
R19051 sw_tgate_8.m.n4 sw_tgate_8.m.t8 6.42711
R19052 sw_tgate_8.m.n3 sw_tgate_8.m.t1 6.41384
R19053 sw_tgate_8.m.n4 sw_tgate_8.m.t9 5.90366
R19054 sw_tgate_8.m.n3 sw_tgate_8.m.t0 5.90366
R19055 sw_tgate_8.m.n7 sw_tgate_8.m.n6 4.63103
R19056 sw_tgate_8.m.n5 sw_tgate_8.m.t7 3.8058
R19057 sw_tgate_8.m.n0 sw_tgate_8.m.t3 3.79442
R19058 sw_tgate_8.m.n2 sw_tgate_8.m.t2 3.46316
R19059 sw_tgate_8.m.n0 sw_tgate_8.m.t5 3.28226
R19060 sw_tgate_8.m.n6 sw_tgate_8.m.t6 2.78927
R19061 sw_tgate_8.m.n1 sw_tgate_8.m.n0 0.0474976
R19062 sw_tgate_8.m.n3 sw_tgate_8.m.n2 0.0489674
R19063 sw_tgate_8.m.n6 sw_tgate_8.m.n5 0.441831
R19064 sw_tgate_8.m.n5 sw_tgate_8.m.n4 0.12425
R19065 sw_tgate_8.m.n7 sw_tgate_8.m 0.106707
R19066 sw_tgate_8.m.n1 sw_tgate_8.m.t4 6.08571
R19067 sw_tgate_8.m sw_tgate_8.m.n1 4.50575
R19068 sw_tgate_8.m.n8 sw_tgate_8.m.n2 4.63941
R19069 sw_tgate_8.m sw_tgate_8.m.n8 1.54202
R19070 xsc_vc1l_n.n3 xsc_vc1l_n 28.868
R19071 xsc_vc1l_n.n5 xsc_vc1l_n 17.0399
R19072 xsc_vc1l_n xsc_vc1l_n.n5 9.27514
R19073 xsc_vc1l_n.n4 xsc_vc1l_n 9.27514
R19074 xsc_vc1l_n.n3 xsc_vc1l_n 9.27514
R19075 xsc_vc1l_n.n2 xsc_vc1l_n.t8 6.42711
R19076 xsc_vc1l_n.n0 xsc_vc1l_n.t2 6.42711
R19077 xsc_vc1l_n.n1 xsc_vc1l_n.t4 6.42711
R19078 xsc_vc1l_n.n2 xsc_vc1l_n.t9 5.90366
R19079 xsc_vc1l_n.n0 xsc_vc1l_n.t3 5.90366
R19080 xsc_vc1l_n.n1 xsc_vc1l_n.t5 5.90366
R19081 xsc_vc1l_n xsc_vc1l_n.n2 4.63172
R19082 xsc_vc1l_n xsc_vc1l_n.n1 4.63104
R19083 xsc_vc1l_n xsc_vc1l_n.n0 4.63103
R19084 xsc_vc1l_n.n2 xsc_vc1l_n.t11 3.8058
R19085 xsc_vc1l_n.n0 xsc_vc1l_n.t0 3.8058
R19086 xsc_vc1l_n.n1 xsc_vc1l_n.t6 3.8058
R19087 xsc_vc1l_n.n1 xsc_vc1l_n.t7 3.35445
R19088 xsc_vc1l_n.n0 xsc_vc1l_n.t1 3.35435
R19089 xsc_vc1l_n.n2 xsc_vc1l_n.t10 3.35395
R19090 xsc_vc1l_n.n4 xsc_vc1l_n.n3 1.83333
R19091 xsc_vc1l_n.n5 xsc_vc1l_n.n4 1.83333
R19092 sw_tgate_6.p.n8 sw_tgate_6.p.n7 21.1762
R19093 sw_tgate_6.p.n4 sw_tgate_6.p.t8 6.42711
R19094 sw_tgate_6.p.n3 sw_tgate_6.p.t3 6.41384
R19095 sw_tgate_6.p.n4 sw_tgate_6.p.t9 5.90366
R19096 sw_tgate_6.p.n3 sw_tgate_6.p.t2 5.90366
R19097 sw_tgate_6.p.n7 sw_tgate_6.p.n6 4.63104
R19098 sw_tgate_6.p.n5 sw_tgate_6.p.t6 3.8058
R19099 sw_tgate_6.p.n0 sw_tgate_6.p.t0 3.79442
R19100 sw_tgate_6.p.n2 sw_tgate_6.p.t1 3.46316
R19101 sw_tgate_6.p.n0 sw_tgate_6.p.t5 3.27987
R19102 sw_tgate_6.p.n6 sw_tgate_6.p.t7 2.78937
R19103 sw_tgate_6.p.n1 sw_tgate_6.p.n0 0.0474976
R19104 sw_tgate_6.p.n3 sw_tgate_6.p.n2 0.0489674
R19105 sw_tgate_6.p.n6 sw_tgate_6.p.n5 0.441827
R19106 sw_tgate_6.p.n5 sw_tgate_6.p.n4 0.12425
R19107 sw_tgate_6.p.n7 sw_tgate_6.p 0.106707
R19108 sw_tgate_6.p.n1 sw_tgate_6.p.t4 6.08571
R19109 sw_tgate_6.p sw_tgate_6.p.n1 4.50575
R19110 sw_tgate_6.p.n8 sw_tgate_6.p.n2 4.63941
R19111 sw_tgate_6.p sw_tgate_6.p.n8 1.54202
R19112 sw_tgate_12.m sw_tgate_12.m.n7 21.1762
R19113 sw_tgate_12.m.n4 sw_tgate_12.m.t7 6.42711
R19114 sw_tgate_12.m.n3 sw_tgate_12.m.t3 6.41573
R19115 sw_tgate_12.m.n4 sw_tgate_12.m.t6 5.90366
R19116 sw_tgate_12.m.n3 sw_tgate_12.m.t9 5.90366
R19117 sw_tgate_12.m.n7 sw_tgate_12.m.n6 4.63103
R19118 sw_tgate_12.m.n5 sw_tgate_12.m.t4 3.8058
R19119 sw_tgate_12.m.n0 sw_tgate_12.m.t0 3.79005
R19120 sw_tgate_12.m.n2 sw_tgate_12.m.t8 3.46449
R19121 sw_tgate_12.m.n0 sw_tgate_12.m.t1 3.28126
R19122 sw_tgate_12.m.n6 sw_tgate_12.m.t5 2.78927
R19123 sw_tgate_12.m.n1 sw_tgate_12.m.n0 0.0489674
R19124 sw_tgate_12.m.n3 sw_tgate_12.m.n2 0.0474976
R19125 sw_tgate_12.m.n6 sw_tgate_12.m.n5 0.441831
R19126 sw_tgate_12.m.n5 sw_tgate_12.m.n4 0.12425
R19127 sw_tgate_12.m.n7 sw_tgate_12.m 0.106707
R19128 sw_tgate_12.m.n1 sw_tgate_12.m.t2 6.08557
R19129 sw_tgate_12.m sw_tgate_12.m.n1 6.04741
R19130 sw_tgate_12.m sw_tgate_12.m.n2 4.63926
R19131 xsc_vc1l_p.n5 xsc_vc1l_p 28.8689
R19132 xsc_vc1l_p.n3 xsc_vc1l_p 17.0407
R19133 xsc_vc1l_p xsc_vc1l_p.n5 9.27514
R19134 xsc_vc1l_p.n4 xsc_vc1l_p 9.27514
R19135 xsc_vc1l_p.n3 xsc_vc1l_p 9.27514
R19136 xsc_vc1l_p.n1 xsc_vc1l_p.t8 6.42711
R19137 xsc_vc1l_p.n0 xsc_vc1l_p.t7 6.42711
R19138 xsc_vc1l_p.n2 xsc_vc1l_p.t5 6.42711
R19139 xsc_vc1l_p.n1 xsc_vc1l_p.t9 5.90366
R19140 xsc_vc1l_p.n0 xsc_vc1l_p.t6 5.90366
R19141 xsc_vc1l_p.n2 xsc_vc1l_p.t4 5.90366
R19142 xsc_vc1l_p xsc_vc1l_p.n2 4.6313
R19143 xsc_vc1l_p xsc_vc1l_p.n0 4.63103
R19144 xsc_vc1l_p xsc_vc1l_p.n1 4.63103
R19145 xsc_vc1l_p.n0 xsc_vc1l_p.t0 3.8059
R19146 xsc_vc1l_p.n1 xsc_vc1l_p.t10 3.8058
R19147 xsc_vc1l_p.n2 xsc_vc1l_p.t2 3.80332
R19148 xsc_vc1l_p.n1 xsc_vc1l_p.t11 3.35435
R19149 xsc_vc1l_p.n0 xsc_vc1l_p.t1 3.35435
R19150 xsc_vc1l_p.n2 xsc_vc1l_p.t3 3.35428
R19151 xsc_vc1l_p.n4 xsc_vc1l_p.n3 1.83333
R19152 xsc_vc1l_p.n5 xsc_vc1l_p.n4 1.83333
R19153 sw_tgate_10.p sw_tgate_10.p.n7 19.7682
R19154 sw_tgate_10.p.n4 sw_tgate_10.p.t8 6.42711
R19155 sw_tgate_10.p.n3 sw_tgate_10.p.t0 6.41573
R19156 sw_tgate_10.p.n4 sw_tgate_10.p.t9 5.90366
R19157 sw_tgate_10.p.n3 sw_tgate_10.p.t5 5.90366
R19158 sw_tgate_10.p.n7 sw_tgate_10.p.n6 4.63103
R19159 sw_tgate_10.p.n5 sw_tgate_10.p.t6 3.8059
R19160 sw_tgate_10.p.n0 sw_tgate_10.p.t2 3.79005
R19161 sw_tgate_10.p.n2 sw_tgate_10.p.t4 3.4633
R19162 sw_tgate_10.p.n0 sw_tgate_10.p.t3 3.28126
R19163 sw_tgate_10.p.n6 sw_tgate_10.p.t7 2.78927
R19164 sw_tgate_10.p.n1 sw_tgate_10.p.n0 0.0489674
R19165 sw_tgate_10.p.n3 sw_tgate_10.p.n2 0.0474976
R19166 sw_tgate_10.p.n6 sw_tgate_10.p.n5 0.441831
R19167 sw_tgate_10.p.n5 sw_tgate_10.p.n4 0.12425
R19168 sw_tgate_10.p.n7 sw_tgate_10.p 0.106707
R19169 sw_tgate_10.p.n1 sw_tgate_10.p.t1 6.08557
R19170 sw_tgate_10.p sw_tgate_10.p.n1 6.04741
R19171 sw_tgate_10.p sw_tgate_10.p.n2 4.63926
R19172 dsm2_io_vcmg_0.di_vcm_ext dsm2_io_vcmg_0.di_vcm_ext.t2 15.028
R19173 dsm2_io_vcmg_0.di_vcm_ext dsm2_io_vcmg_0.di_vcm_ext.t1 5.60969
R19174 dsm2_io_vcmg_0.di_vcm_ext dsm2_io_vcmg_0.di_vcm_ext.t0 8.46054
R19175 dsm2_io_vcmg_0.di_vcm_ext_b dsm2_io_vcmg_0.di_vcm_ext_b.t1 21.5621
R19176 dsm2_io_vcmg_0.di_vcm_ext_b dsm2_io_vcmg_0.di_vcm_ext_b.t2 15.0245
R19177 dsm2_io_vcmg_0.di_vcm_ext_b dsm2_io_vcmg_0.di_vcm_ext_b.t3 15.0005
R19178 dsm2_io_vcmg_0.di_vcm_ext_b.n1 dsm2_io_vcmg_0.di_vcm_ext_b.t0 10.1966
R19179 dsm2_io_vcmg_0.di_vcm_ext_b.n0 dsm2_io_vcmg_0.di_vcm_ext_b 9.35402
R19180 dsm2_io_vcmg_0.di_vcm_ext_b.n0 dsm2_io_vcmg_0.di_vcm_ext_b 4.94612
R19181 dsm2_io_vcmg_0.di_vcm_ext_b dsm2_io_vcmg_0.di_vcm_ext_b.n1 1.2325
R19182 dsm2_io_vcmg_0.di_vcm_ext_b.n1 dsm2_io_vcmg_0.di_vcm_ext_b.n0 1.05802
R19183 quantizer2_lfsr_0.di_dith_amp[1] quantizer2_lfsr_0.di_dith_amp[1].t1 5.60969
R19184 quantizer2_lfsr_0.di_dith_amp[1] quantizer2_lfsr_0.di_dith_amp[1].t3 15.0005
R19185 quantizer2_lfsr_0.di_dith_amp[1] quantizer2_lfsr_0.di_dith_amp[1].t4 15.0005
R19186 quantizer2_lfsr_0.di_dith_amp[1] quantizer2_lfsr_0.di_dith_amp[1].t2 15.0005
R19187 quantizer2_lfsr_0.di_dith_amp[1] quantizer2_lfsr_0.di_dith_amp[1].t0 8.46054
R19188 quantizer2_lfsr_0.di_dith_amp[0].n0 quantizer2_lfsr_0.di_dith_amp[0] 28.6393
R19189 quantizer2_lfsr_0.di_dith_amp[0] quantizer2_lfsr_0.di_dith_amp[0].t1 5.60969
R19190 quantizer2_lfsr_0.di_dith_amp[0] quantizer2_lfsr_0.di_dith_amp[0].t2 15.0005
R19191 quantizer2_lfsr_0.di_dith_amp[0] quantizer2_lfsr_0.di_dith_amp[0].t4 15.0005
R19192 quantizer2_lfsr_0.di_dith_amp[0] quantizer2_lfsr_0.di_dith_amp[0].t3 15.0005
R19193 quantizer2_lfsr_0.di_dith_amp[0].n0 quantizer2_lfsr_0.di_dith_amp[0] 9.0005
R19194 quantizer2_lfsr_0.di_dith_amp[0] quantizer2_lfsr_0.di_dith_amp[0].t0 8.46054
R19195 quantizer2_lfsr_0.di_dith_amp[0] quantizer2_lfsr_0.di_dith_amp[0].n0 3.91756
R19196 dsm2_io_0.do_btest_en dsm2_io_0.do_btest_en.t2 15.0703
R19197 dsm2_io_0.do_btest_en dsm2_io_0.do_btest_en.t1 5.60969
R19198 dsm2_io_0.do_btest_en dsm2_io_0.do_btest_en.t0 8.46054
R19199 dsm2_io_0.do_trim_b[3].n0 dsm2_io_0.do_trim_b[3].t2 22.1755
R19200 dsm2_io_0.do_trim_b[3].n1 dsm2_io_0.do_trim_b[3].t3 22.1755
R19201 dsm2_io_0.do_trim_b[3] dsm2_io_0.do_trim_b[3].t1 21.5621
R19202 dsm2_io_0.do_trim_b[3].n2 dsm2_io_0.do_trim_b[3].t0 10.1966
R19203 dsm2_io_0.do_trim_b[3].n1 dsm2_io_0.do_trim_b[3].n0 9.70151
R19204 dsm2_io_0.do_trim_b[3].n2 dsm2_io_0.do_trim_b[3] 6.06777
R19205 dsm2_io_0.do_trim_b[3] dsm2_io_0.do_trim_b[3].n1 2.53126
R19206 dsm2_io_0.do_trim_b[3].n0 dsm2_io_0.do_trim_b[3] 2.10188
R19207 dsm2_io_0.do_trim_b[3] dsm2_io_0.do_trim_b[3].n2 1.2325
R19208 dsm2_io_0.do_trim_b[2].n1 dsm2_io_0.do_trim_b[2].t3 28.6949
R19209 dsm2_io_0.do_trim_b[2].n0 dsm2_io_0.do_trim_b[2].t5 28.6949
R19210 dsm2_io_0.do_trim_b[2].n1 dsm2_io_0.do_trim_b[2].t2 23.4755
R19211 dsm2_io_0.do_trim_b[2].n0 dsm2_io_0.do_trim_b[2].t4 23.4755
R19212 dsm2_io_0.do_trim_b[2] dsm2_io_0.do_trim_b[2].t1 21.5621
R19213 dsm2_io_0.do_trim_b[2].n3 dsm2_io_0.do_trim_b[2].n2 10.3084
R19214 dsm2_io_0.do_trim_b[2].n4 dsm2_io_0.do_trim_b[2].t0 10.1966
R19215 dsm2_io_0.do_trim_b[2].n4 dsm2_io_0.do_trim_b[2] 6.00477
R19216 dsm2_io_0.do_trim_b[2] dsm2_io_0.do_trim_b[2].n3 2.30367
R19217 dsm2_io_0.do_trim_b[2].n3 dsm2_io_0.do_trim_b[2].n0 2.24602
R19218 dsm2_io_0.do_trim_b[2].n2 dsm2_io_0.do_trim_b[2].n1 2.24602
R19219 dsm2_io_0.do_trim_b[2].n2 dsm2_io_0.do_trim_b[2] 1.87429
R19220 dsm2_io_0.do_trim_b[2] dsm2_io_0.do_trim_b[2].n4 1.2325
R19221 dsm2_io_0.do_trim_b[1].n0 dsm2_io_0.do_trim_b[1].t2 24.3759
R19222 dsm2_io_0.do_trim_b[1].n1 dsm2_io_0.do_trim_b[1].t3 24.3759
R19223 dsm2_io_0.do_trim_b[1] dsm2_io_0.do_trim_b[1].t1 21.5621
R19224 dsm2_io_0.do_trim_b[1].n1 dsm2_io_0.do_trim_b[1].n0 10.9153
R19225 dsm2_io_0.do_trim_b[1].n2 dsm2_io_0.do_trim_b[1].t0 10.1966
R19226 dsm2_io_0.do_trim_b[1].n2 dsm2_io_0.do_trim_b[1] 6.00224
R19227 dsm2_io_0.do_trim_b[1] dsm2_io_0.do_trim_b[1].n1 2.07609
R19228 dsm2_io_0.do_trim_b[1].n0 dsm2_io_0.do_trim_b[1] 1.64671
R19229 dsm2_io_0.do_trim_b[1] dsm2_io_0.do_trim_b[1].n2 1.2325
R19230 dsm2_io_0.do_trim_b[0].n0 dsm2_io_0.do_trim_b[0].t2 22.9345
R19231 dsm2_io_0.do_trim_b[0].n1 dsm2_io_0.do_trim_b[0].t3 22.9345
R19232 dsm2_io_0.do_trim_b[0] dsm2_io_0.do_trim_b[0].t1 21.5621
R19233 dsm2_io_0.do_trim_b[0].n1 dsm2_io_0.do_trim_b[0].n0 11.5222
R19234 dsm2_io_0.do_trim_b[0].n2 dsm2_io_0.do_trim_b[0].t0 10.1966
R19235 dsm2_io_0.do_trim_b[0].n2 dsm2_io_0.do_trim_b[0] 5.9995
R19236 dsm2_io_0.do_trim_b[0] dsm2_io_0.do_trim_b[0].n1 1.8485
R19237 dsm2_io_0.do_trim_b[0].n0 dsm2_io_0.do_trim_b[0] 1.41912
R19238 dsm2_io_0.do_trim_b[0] dsm2_io_0.do_trim_b[0].n2 1.2325
R19239 xsc_xcmfb1_vsw_vbias.n12 xsc_xcmfb1_vsw_vbias.n2 20.0626
R19240 xsc_xcmfb1_vsw_vbias.n8 xsc_xcmfb1_vsw_vbias.n4 19.7197
R19241 xsc_xcmfb1_vsw_vbias.n5 xsc_xcmfb1_vsw_vbias.t9 17.6958
R19242 xsc_xcmfb1_vsw_vbias.n0 xsc_xcmfb1_vsw_vbias.t6 17.686
R19243 xsc_xcmfb1_vsw_vbias.n1 xsc_xcmfb1_vsw_vbias.t5 17.6825
R19244 xsc_xcmfb1_vsw_vbias.n1 xsc_xcmfb1_vsw_vbias.t0 17.6879
R19245 xsc_xcmfb1_vsw_vbias.n0 xsc_xcmfb1_vsw_vbias.t3 17.1829
R19246 xsc_xcmfb1_vsw_vbias.n5 xsc_xcmfb1_vsw_vbias.t10 17.1724
R19247 xsc_xcmfb1_vsw_vbias.n1 xsc_xcmfb1_vsw_vbias.t4 17.1724
R19248 xsc_xcmfb1_vsw_vbias.n9 xsc_xcmfb1_vsw_vbias.n3 12.9651
R19249 xsc_xcmfb1_vsw_vbias.n11 xsc_xcmfb1_vsw_vbias.n10 12.9651
R19250 xsc_xcmfb1_vsw_vbias.n11 xsc_xcmfb1_vsw_vbias.n9 9.98698
R19251 xsc_xcmfb1_vsw_vbias.n9 xsc_xcmfb1_vsw_vbias.n8 6.59278
R19252 xsc_xcmfb1_vsw_vbias.n12 xsc_xcmfb1_vsw_vbias.n11 6.24988
R19253 xsc_xcmfb1_vsw_vbias xsc_xcmfb1_vsw_vbias.n0 6.17553
R19254 xsc_xcmfb1_vsw_vbias.n8 xsc_xcmfb1_vsw_vbias 5.56257
R19255 xsc_xcmfb1_vsw_vbias.n6 xsc_xcmfb1_vsw_vbias.t7 5.11376
R19256 xsc_xcmfb1_vsw_vbias.n0 xsc_xcmfb1_vsw_vbias.t13 5.10063
R19257 xsc_xcmfb1_vsw_vbias.n1 xsc_xcmfb1_vsw_vbias.t12 5.1005
R19258 xsc_xcmfb1_vsw_vbias xsc_xcmfb1_vsw_vbias.n12 4.68105
R19259 xsc_xcmfb1_vsw_vbias.n1 xsc_xcmfb1_vsw_vbias.t11 4.60244
R19260 xsc_xcmfb1_vsw_vbias.n7 xsc_xcmfb1_vsw_vbias.t8 4.22285
R19261 xsc_xcmfb1_vsw_vbias.n4 xsc_xcmfb1_vsw_vbias 1.47667
R19262 xsc_xcmfb1_vsw_vbias.n2 xsc_xcmfb1_vsw_vbias 1.47667
R19263 xsc_xcmfb1_vsw_vbias.n3 xsc_xcmfb1_vsw_vbias 1.47637
R19264 xsc_xcmfb1_vsw_vbias.n10 xsc_xcmfb1_vsw_vbias 1.47637
R19265 xsc_xcmfb1_vsw_vbias.n3 xsc_xcmfb1_vsw_vbias 1.47637
R19266 xsc_xcmfb1_vsw_vbias.n10 xsc_xcmfb1_vsw_vbias 1.47637
R19267 xsc_xcmfb1_vsw_vbias.n4 xsc_xcmfb1_vsw_vbias 1.4759
R19268 xsc_xcmfb1_vsw_vbias.n2 xsc_xcmfb1_vsw_vbias 1.4759
R19269 xsc_xcmfb1_vsw_vbias.n7 xsc_xcmfb1_vsw_vbias.n6 0.311148
R19270 xsc_xcmfb1_vsw_vbias.n6 xsc_xcmfb1_vsw_vbias.n5 0.12425
R19271 xsc_xcmfb1_vsw_vbias.n0 xsc_xcmfb1_vsw_vbias.t2 5.10397
R19272 xsc_xcmfb1_vsw_vbias.n0 xsc_xcmfb1_vsw_vbias.t1 4.66504
R19273 xsc_xcmfb1_vsw_vbias xsc_xcmfb1_vsw_vbias.n1 4.62082
R19274 xsc_xcmfb1_vsw_vbias xsc_xcmfb1_vsw_vbias.n7 4.59599
R19275 sw_tgate_9.gb.n3 sw_tgate_9.gb.n2 52.2115
R19276 sw_tgate_9.gb sw_tgate_9.gb.n3 15.6034
R19277 sw_tgate_9.gb.n3 sw_tgate_9.gb 15.4005
R19278 sw_tgate_9.gb.n2 sw_tgate_9.gb 14.5157
R19279 sw_tgate_9.gb.n1 sw_tgate_9.gb 13.0409
R19280 sw_tgate_9.gb sw_tgate_9.gb.t5 12.0327
R19281 sw_tgate_9.gb sw_tgate_9.gb.t3 12.0327
R19282 sw_tgate_9.gb sw_tgate_9.gb.t4 12.0327
R19283 sw_tgate_9.gb sw_tgate_9.gb.t2 12.0327
R19284 sw_tgate_9.gb sw_tgate_9.gb.t6 12.0327
R19285 sw_tgate_9.gb.n1 sw_tgate_9.gb 9.37528
R19286 sw_tgate_9.gb.n0 sw_tgate_9.gb.t0 6.74274
R19287 sw_tgate_9.gb.n0 sw_tgate_9.gb.t1 2.85241
R19288 sw_tgate_9.gb.n3 sw_tgate_9.gb 4.83733
R19289 sw_tgate_9.gb sw_tgate_9.gb.n0 4.76058
R19290 sw_tgate_9.gb.n2 sw_tgate_9.gb.n1 4.60078
R19291 xsc_xcmfb1_vsw_cm_n.n3 xsc_xcmfb1_vsw_cm_n.t9 17.6958
R19292 xsc_xcmfb1_vsw_cm_n.n0 xsc_xcmfb1_vsw_cm_n.t6 17.6844
R19293 xsc_xcmfb1_vsw_cm_n.n1 xsc_xcmfb1_vsw_cm_n.t4 17.6843
R19294 xsc_xcmfb1_vsw_cm_n.n1 xsc_xcmfb1_vsw_cm_n.t0 17.1845
R19295 xsc_xcmfb1_vsw_cm_n.n0 xsc_xcmfb1_vsw_cm_n.t5 17.1724
R19296 xsc_xcmfb1_vsw_cm_n.n3 xsc_xcmfb1_vsw_cm_n.t10 17.1724
R19297 xsc_xcmfb1_vsw_cm_n.n8 xsc_xcmfb1_vsw_cm_n.n7 9.95043
R19298 xsc_xcmfb1_vsw_cm_n.n7 xsc_xcmfb1_vsw_cm_n 7.16147
R19299 xsc_xcmfb1_vsw_cm_n.n6 xsc_xcmfb1_vsw_cm_n.n2 6.52467
R19300 xsc_xcmfb1_vsw_cm_n.n7 xsc_xcmfb1_vsw_cm_n 5.63632
R19301 xsc_xcmfb1_vsw_cm_n.n6 xsc_xcmfb1_vsw_cm_n 5.41084
R19302 xsc_xcmfb1_vsw_cm_n.n4 xsc_xcmfb1_vsw_cm_n.t8 5.11376
R19303 xsc_xcmfb1_vsw_cm_n.n0 xsc_xcmfb1_vsw_cm_n.t13 5.10379
R19304 xsc_xcmfb1_vsw_cm_n.n1 xsc_xcmfb1_vsw_cm_n.t12 5.1003
R19305 xsc_xcmfb1_vsw_cm_n.n1 xsc_xcmfb1_vsw_cm_n.t3 5.1061
R19306 xsc_xcmfb1_vsw_cm_n.n0 xsc_xcmfb1_vsw_cm_n.t11 4.60163
R19307 xsc_xcmfb1_vsw_cm_n.n1 xsc_xcmfb1_vsw_cm_n.t2 4.59055
R19308 xsc_xcmfb1_vsw_cm_n xsc_xcmfb1_vsw_cm_n.n8 4.53067
R19309 xsc_xcmfb1_vsw_cm_n.n5 xsc_xcmfb1_vsw_cm_n.t7 4.22285
R19310 xsc_xcmfb1_vsw_cm_n.n2 xsc_xcmfb1_vsw_cm_n 2.80109
R19311 xsc_xcmfb1_vsw_cm_n.n8 xsc_xcmfb1_vsw_cm_n.n6 1.48436
R19312 xsc_xcmfb1_vsw_cm_n.n2 xsc_xcmfb1_vsw_cm_n 0.416672
R19313 xsc_xcmfb1_vsw_cm_n.n5 xsc_xcmfb1_vsw_cm_n.n4 0.311148
R19314 xsc_xcmfb1_vsw_cm_n.n4 xsc_xcmfb1_vsw_cm_n.n3 0.12425
R19315 xsc_xcmfb1_vsw_cm_n.n0 xsc_xcmfb1_vsw_cm_n.t1 17.686
R19316 xsc_xcmfb1_vsw_cm_n xsc_xcmfb1_vsw_cm_n.n5 4.59599
R19317 xsc_xcmfb1_vsw_cm_n xsc_xcmfb1_vsw_cm_n.n0 4.57698
R19318 xsc_xcmfb1_vsw_cm_n xsc_xcmfb1_vsw_cm_n.n1 4.57682
R19319 xsc_vc1r_n.n2 xsc_vc1r_n 23.2105
R19320 xsc_vc1r_n.n2 xsc_vc1r_n 18.7771
R19321 xsc_vc1r_n.n3 xsc_vc1r_n 6.67016
R19322 xsc_vc1r_n.n3 xsc_vc1r_n.n2 6.5776
R19323 xsc_vc1r_n.n1 xsc_vc1r_n.t0 6.42711
R19324 xsc_vc1r_n.n0 xsc_vc1r_n.t6 6.42668
R19325 xsc_vc1r_n.n0 xsc_vc1r_n.t7 5.90366
R19326 xsc_vc1r_n.n1 xsc_vc1r_n.t1 5.90366
R19327 xsc_vc1r_n xsc_vc1r_n.n3 5.4594
R19328 xsc_vc1r_n xsc_vc1r_n.n1 4.6313
R19329 xsc_vc1r_n xsc_vc1r_n.n0 4.63086
R19330 xsc_vc1r_n.n0 xsc_vc1r_n.t4 3.80628
R19331 xsc_vc1r_n.n1 xsc_vc1r_n.t2 3.80332
R19332 xsc_vc1r_n.n0 xsc_vc1r_n.t5 3.35457
R19333 xsc_vc1r_n.n1 xsc_vc1r_n.t3 3.35428
R19334 sw_tgate_cmfb2_1.gb.n2 sw_tgate_cmfb2_1.gb 13.2448
R19335 sw_tgate_cmfb2_1.gb.n1 sw_tgate_cmfb2_1.gb 13.0045
R19336 sw_tgate_cmfb2_1.gb sw_tgate_cmfb2_1.gb.t4 12.0327
R19337 sw_tgate_cmfb2_1.gb sw_tgate_cmfb2_1.gb.t2 12.0327
R19338 sw_tgate_cmfb2_1.gb sw_tgate_cmfb2_1.gb.t3 12.0327
R19339 sw_tgate_cmfb2_1.gb.n1 sw_tgate_cmfb2_1.gb 10.3317
R19340 sw_tgate_cmfb2_1.gb sw_tgate_cmfb2_1.gb.n2 9.32367
R19341 sw_tgate_cmfb2_1.gb.n0 sw_tgate_cmfb2_1.gb.t0 6.74309
R19342 sw_tgate_cmfb2_1.gb.n0 sw_tgate_cmfb2_1.gb.t1 2.85226
R19343 sw_tgate_cmfb2_1.gb sw_tgate_cmfb2_1.gb.n0 4.76024
R19344 sw_tgate_cmfb2_1.gb.n2 sw_tgate_cmfb2_1.gb.n1 2.95002
R19345 xsc_vc1r_p.n2 xsc_vc1r_p 22.9343
R19346 xsc_vc1r_p.n2 xsc_vc1r_p 18.7498
R19347 xsc_vc1r_p.n3 xsc_vc1r_p.n2 6.72933
R19348 xsc_vc1r_p.n3 xsc_vc1r_p 6.62616
R19349 xsc_vc1r_p.n1 xsc_vc1r_p.t3 6.42711
R19350 xsc_vc1r_p.n0 xsc_vc1r_p.t4 6.42711
R19351 xsc_vc1r_p.n1 xsc_vc1r_p.t0 5.90366
R19352 xsc_vc1r_p.n0 xsc_vc1r_p.t5 5.90323
R19353 xsc_vc1r_p xsc_vc1r_p.n3 5.4154
R19354 xsc_vc1r_p xsc_vc1r_p.n1 4.63172
R19355 xsc_vc1r_p xsc_vc1r_p.n0 4.63086
R19356 xsc_vc1r_p.n0 xsc_vc1r_p.t7 3.80628
R19357 xsc_vc1r_p.n1 xsc_vc1r_p.t2 3.8058
R19358 xsc_vc1r_p.n0 xsc_vc1r_p.t6 3.35457
R19359 xsc_vc1r_p.n1 xsc_vc1r_p.t1 3.35395
R19360 xsc_xcmfb1_vsw_cm_p.n3 xsc_xcmfb1_vsw_cm_p.t9 17.6958
R19361 xsc_xcmfb1_vsw_cm_p.n0 xsc_xcmfb1_vsw_cm_p.t6 17.686
R19362 xsc_xcmfb1_vsw_cm_p.n1 xsc_xcmfb1_vsw_cm_p.t4 17.6825
R19363 xsc_xcmfb1_vsw_cm_p.n1 xsc_xcmfb1_vsw_cm_p.t0 17.6879
R19364 xsc_xcmfb1_vsw_cm_p.n0 xsc_xcmfb1_vsw_cm_p.t1 17.1829
R19365 xsc_xcmfb1_vsw_cm_p.n3 xsc_xcmfb1_vsw_cm_p.t8 17.1724
R19366 xsc_xcmfb1_vsw_cm_p.n1 xsc_xcmfb1_vsw_cm_p.t5 17.1724
R19367 xsc_xcmfb1_vsw_cm_p.n8 xsc_xcmfb1_vsw_cm_p.n7 9.95043
R19368 xsc_xcmfb1_vsw_cm_p.n7 xsc_xcmfb1_vsw_cm_p 7.16266
R19369 xsc_xcmfb1_vsw_cm_p.n6 xsc_xcmfb1_vsw_cm_p.n2 6.52467
R19370 xsc_xcmfb1_vsw_cm_p xsc_xcmfb1_vsw_cm_p.n0 6.13153
R19371 xsc_xcmfb1_vsw_cm_p.n7 xsc_xcmfb1_vsw_cm_p 5.63513
R19372 xsc_xcmfb1_vsw_cm_p.n6 xsc_xcmfb1_vsw_cm_p 5.36684
R19373 xsc_xcmfb1_vsw_cm_p.n4 xsc_xcmfb1_vsw_cm_p.t10 5.114
R19374 xsc_xcmfb1_vsw_cm_p.n0 xsc_xcmfb1_vsw_cm_p.t13 5.1022
R19375 xsc_xcmfb1_vsw_cm_p.n1 xsc_xcmfb1_vsw_cm_p.t12 5.10207
R19376 xsc_xcmfb1_vsw_cm_p.n1 xsc_xcmfb1_vsw_cm_p.t7 4.60267
R19377 xsc_xcmfb1_vsw_cm_p.n5 xsc_xcmfb1_vsw_cm_p.t11 4.22285
R19378 xsc_xcmfb1_vsw_cm_p.n2 xsc_xcmfb1_vsw_cm_p 2.8021
R19379 xsc_xcmfb1_vsw_cm_p.n8 xsc_xcmfb1_vsw_cm_p.n6 1.48436
R19380 xsc_xcmfb1_vsw_cm_p.n2 xsc_xcmfb1_vsw_cm_p 0.416658
R19381 xsc_xcmfb1_vsw_cm_p.n5 xsc_xcmfb1_vsw_cm_p.n4 0.311148
R19382 xsc_xcmfb1_vsw_cm_p.n4 xsc_xcmfb1_vsw_cm_p.n3 0.12425
R19383 xsc_xcmfb1_vsw_cm_p.n0 xsc_xcmfb1_vsw_cm_p.t3 5.10421
R19384 xsc_xcmfb1_vsw_cm_p.n0 xsc_xcmfb1_vsw_cm_p.t2 4.66761
R19385 xsc_xcmfb1_vsw_cm_p xsc_xcmfb1_vsw_cm_p.n5 4.59599
R19386 xsc_xcmfb1_vsw_cm_p xsc_xcmfb1_vsw_cm_p.n1 4.57682
R19387 xsc_xcmfb1_vsw_cm_p xsc_xcmfb1_vsw_cm_p.n8 4.51244
R19388 sw_tgate_11.gb.n3 sw_tgate_11.gb.n2 53.662
R19389 sw_tgate_11.gb.n0 sw_tgate_11.gb 15.4017
R19390 sw_tgate_11.gb sw_tgate_11.gb.n3 14.3926
R19391 sw_tgate_11.gb.n2 sw_tgate_11.gb 14.364
R19392 sw_tgate_11.gb.n1 sw_tgate_11.gb 12.8892
R19393 sw_tgate_11.gb sw_tgate_11.gb.t3 12.0327
R19394 sw_tgate_11.gb sw_tgate_11.gb.t6 12.0327
R19395 sw_tgate_11.gb sw_tgate_11.gb.t5 12.0327
R19396 sw_tgate_11.gb sw_tgate_11.gb.t4 12.0327
R19397 sw_tgate_11.gb sw_tgate_11.gb.t2 12.0327
R19398 sw_tgate_11.gb.n1 sw_tgate_11.gb 9.22356
R19399 sw_tgate_11.gb.n4 sw_tgate_11.gb.t0 6.86683
R19400 sw_tgate_11.gb.n0 sw_tgate_11.gb 4.82519
R19401 sw_tgate_11.gb sw_tgate_11.gb.n4 4.63172
R19402 sw_tgate_11.gb.n2 sw_tgate_11.gb.n1 4.60078
R19403 sw_tgate_11.gb.n4 sw_tgate_11.gb.t1 2.78953
R19404 sw_tgate_11.gb.n3 sw_tgate_11.gb.n0 2.13073
R19405 sw_tgate_cmfb2_3.gb.n2 sw_tgate_cmfb2_3.gb 13.399
R19406 sw_tgate_cmfb2_3.gb.n1 sw_tgate_cmfb2_3.gb 13.3777
R19407 sw_tgate_cmfb2_3.gb sw_tgate_cmfb2_3.gb.t2 12.1389
R19408 sw_tgate_cmfb2_3.gb sw_tgate_cmfb2_3.gb.t3 12.0327
R19409 sw_tgate_cmfb2_3.gb sw_tgate_cmfb2_3.gb.t4 12.0327
R19410 sw_tgate_cmfb2_3.gb.n1 sw_tgate_cmfb2_3.gb 10.5466
R19411 sw_tgate_cmfb2_3.gb sw_tgate_cmfb2_3.gb.n2 9.17347
R19412 sw_tgate_cmfb2_3.gb.n0 sw_tgate_cmfb2_3.gb.t0 6.74309
R19413 sw_tgate_cmfb2_3.gb.n0 sw_tgate_cmfb2_3.gb.t1 2.85226
R19414 sw_tgate_cmfb2_3.gb sw_tgate_cmfb2_3.gb.n0 4.76024
R19415 sw_tgate_cmfb2_3.gb.n2 sw_tgate_cmfb2_3.gb.n1 3.01071
R19416 dsm2_io_0.dsm2_io_rx_9.di_b dsm2_io_0.dsm2_io_rx_9.di_b.t1 21.5621
R19417 dsm2_io_0.dsm2_io_rx_9.di_b.n0 dsm2_io_0.dsm2_io_rx_9.di_b.t3 17.0184
R19418 dsm2_io_0.dsm2_io_rx_9.di_b.n0 dsm2_io_0.dsm2_io_rx_9.di_b.t2 12.3058
R19419 dsm2_io_0.dsm2_io_rx_9.di_b dsm2_io_0.dsm2_io_rx_9.di_b.t0 10.8945
R19420 dsm2_io_0.dsm2_io_rx_9.di_b dsm2_io_0.dsm2_io_rx_9.di_b.n0 2.97278
R19421 xsc_vvg_n.n19 xsc_vvg_n.n5 19.8639
R19422 xsc_vvg_n.n5 xsc_vvg_n.t6 16.5327
R19423 xsc_vvg_n.n18 xsc_vvg_n.n11 13.7466
R19424 xsc_vvg_n.n19 xsc_vvg_n.n18 10.891
R19425 xsc_vvg_n.n18 xsc_vvg_n.n17 9.24947
R19426 xsc_vvg_n.n1 xsc_vvg_n.t3 6.41384
R19427 xsc_vvg_n xsc_vvg_n.n10 6.08332
R19428 xsc_vvg_n xsc_vvg_n.n16 6.08332
R19429 xsc_vvg_n.n11 xsc_vvg_n.n8 5.95176
R19430 xsc_vvg_n.n7 xsc_vvg_n.n6 5.95176
R19431 xsc_vvg_n.n17 xsc_vvg_n.n14 5.95176
R19432 xsc_vvg_n.n13 xsc_vvg_n.n12 5.95176
R19433 xsc_vvg_n.n1 xsc_vvg_n.t4 5.90366
R19434 xsc_vvg_n.n5 xsc_vvg_n 4.60671
R19435 xsc_vvg_n.n10 xsc_vvg_n.n9 4.05199
R19436 xsc_vvg_n.n16 xsc_vvg_n.n15 4.05199
R19437 xsc_vvg_n.n2 xsc_vvg_n.t1 3.79442
R19438 xsc_vvg_n.n0 xsc_vvg_n.t5 3.46316
R19439 xsc_vvg_n.n2 xsc_vvg_n.t0 3.27987
R19440 xsc_vvg_n.n14 xsc_vvg_n.n13 1.08828
R19441 xsc_vvg_n.n8 xsc_vvg_n.n7 1.08828
R19442 xsc_vvg_n.n9 xsc_vvg_n 1.00728
R19443 xsc_vvg_n.n15 xsc_vvg_n 1.00728
R19444 xsc_vvg_n.n10 xsc_vvg_n.n6 0.986707
R19445 xsc_vvg_n.n11 xsc_vvg_n.n6 0.986707
R19446 xsc_vvg_n.n16 xsc_vvg_n.n12 0.986707
R19447 xsc_vvg_n.n17 xsc_vvg_n.n12 0.986707
R19448 xsc_vvg_n.n7 xsc_vvg_n 0.956455
R19449 xsc_vvg_n.n13 xsc_vvg_n 0.956455
R19450 xsc_vvg_n.n9 xsc_vvg_n 0.910498
R19451 xsc_vvg_n.n15 xsc_vvg_n 0.910498
R19452 xsc_vvg_n.n3 xsc_vvg_n.n2 0.0474976
R19453 xsc_vvg_n.n1 xsc_vvg_n.n0 0.0489674
R19454 xsc_vvg_n.n19 xsc_vvg_n.n4 0.384362
R19455 xsc_vvg_n.n8 xsc_vvg_n 0.132329
R19456 xsc_vvg_n.n14 xsc_vvg_n 0.132329
R19457 xsc_vvg_n.n3 xsc_vvg_n.t2 6.08571
R19458 xsc_vvg_n.n4 xsc_vvg_n.n3 4.50575
R19459 xsc_vvg_n.n4 xsc_vvg_n.n0 6.18093
R19460 xsc_vvg_p.n18 xsc_vvg_p.n4 20.782
R19461 xsc_vvg_p.n4 xsc_vvg_p.t6 16.5327
R19462 xsc_vvg_p.n17 xsc_vvg_p.n16 14.3262
R19463 xsc_vvg_p.n18 xsc_vvg_p.n17 10.4358
R19464 xsc_vvg_p.n17 xsc_vvg_p.n10 9.58022
R19465 xsc_vvg_p.n3 xsc_vvg_p.t2 6.41573
R19466 xsc_vvg_p xsc_vvg_p.n9 6.08413
R19467 xsc_vvg_p xsc_vvg_p.n15 6.08413
R19468 xsc_vvg_p.n6 xsc_vvg_p.n5 5.95233
R19469 xsc_vvg_p.n10 xsc_vvg_p.n7 5.95233
R19470 xsc_vvg_p.n12 xsc_vvg_p.n11 5.95233
R19471 xsc_vvg_p.n16 xsc_vvg_p.n13 5.95233
R19472 xsc_vvg_p.n3 xsc_vvg_p.t4 5.90366
R19473 xsc_vvg_p.n4 xsc_vvg_p 4.60671
R19474 xsc_vvg_p.n9 xsc_vvg_p.n8 4.05221
R19475 xsc_vvg_p.n15 xsc_vvg_p.n14 4.05221
R19476 xsc_vvg_p.n1 xsc_vvg_p.t0 3.79005
R19477 xsc_vvg_p.n0 xsc_vvg_p.t5 3.4633
R19478 xsc_vvg_p.n1 xsc_vvg_p.t1 3.28126
R19479 xsc_vvg_p.n13 xsc_vvg_p.n12 1.08836
R19480 xsc_vvg_p.n7 xsc_vvg_p.n6 1.08836
R19481 xsc_vvg_p.n8 xsc_vvg_p 1.00722
R19482 xsc_vvg_p.n14 xsc_vvg_p 1.00722
R19483 xsc_vvg_p.n9 xsc_vvg_p.n5 0.986707
R19484 xsc_vvg_p.n10 xsc_vvg_p.n5 0.986707
R19485 xsc_vvg_p.n15 xsc_vvg_p.n11 0.986707
R19486 xsc_vvg_p.n16 xsc_vvg_p.n11 0.986707
R19487 xsc_vvg_p.n6 xsc_vvg_p 0.956287
R19488 xsc_vvg_p.n12 xsc_vvg_p 0.956287
R19489 xsc_vvg_p.n8 xsc_vvg_p 0.910749
R19490 xsc_vvg_p.n14 xsc_vvg_p 0.910749
R19491 xsc_vvg_p.n2 xsc_vvg_p.n1 0.0489674
R19492 xsc_vvg_p.n3 xsc_vvg_p.n0 0.0474976
R19493 xsc_vvg_p.n19 xsc_vvg_p.n18 0.384362
R19494 xsc_vvg_p.n7 xsc_vvg_p 0.132568
R19495 xsc_vvg_p.n13 xsc_vvg_p 0.132568
R19496 xsc_vvg_p.n2 xsc_vvg_p.t3 6.08557
R19497 xsc_vvg_p xsc_vvg_p.n0 4.50575
R19498 xsc_vvg_p.n19 xsc_vvg_p.n2 4.5059
R19499 xsc_vvg_p xsc_vvg_p.n19 1.67553
R19500 xsc_vfb.n5 xsc_vfb.t8 27.3976
R19501 xsc_vfb.n0 xsc_vfb.t2 17.6844
R19502 xsc_vfb.n1 xsc_vfb.t1 17.6843
R19503 xsc_vfb.n1 xsc_vfb.t0 17.1845
R19504 xsc_vfb.n0 xsc_vfb.t3 17.1724
R19505 xsc_vfb.n6 xsc_vfb.n3 15.9658
R19506 xsc_vfb.n4 xsc_vfb.t12 13.9889
R19507 xsc_vfb.n4 xsc_vfb.t11 9.79392
R19508 xsc_vfb.n7 xsc_vfb.n6 9.53321
R19509 xsc_vfb xsc_vfb.n7 6.07641
R19510 xsc_vfb.n10 xsc_vfb.n9 5.94458
R19511 xsc_vfb.n8 xsc_vfb.n2 5.94458
R19512 xsc_vfb.n11 xsc_vfb.n10 5.73705
R19513 xsc_vfb.n6 xsc_vfb.n5 5.51342
R19514 xsc_vfb.n0 xsc_vfb.t10 5.10222
R19515 xsc_vfb.n1 xsc_vfb.t9 5.09873
R19516 xsc_vfb.n1 xsc_vfb.t4 5.10587
R19517 xsc_vfb.n5 xsc_vfb 4.60671
R19518 xsc_vfb.n0 xsc_vfb.t5 4.59907
R19519 xsc_vfb.n1 xsc_vfb.t7 4.59031
R19520 xsc_vfb.n5 xsc_vfb.n4 4.5005
R19521 xsc_vfb xsc_vfb.n3 1.16255
R19522 xsc_vfb.n9 xsc_vfb.n8 1.08784
R19523 xsc_vfb.n10 xsc_vfb.n2 0.986707
R19524 xsc_vfb.n7 xsc_vfb.n2 0.986707
R19525 xsc_vfb.n8 xsc_vfb 0.954859
R19526 xsc_vfb.n3 xsc_vfb 0.754601
R19527 xsc_vfb.n9 xsc_vfb 0.133483
R19528 xsc_vfb.n0 xsc_vfb.t6 17.686
R19529 xsc_vfb.n11 xsc_vfb.n0 4.57698
R19530 xsc_vfb xsc_vfb.n1 4.57682
R19531 xsc_vfb xsc_vfb.n11 1.67553
R19532 sw_tgate_cmfb2_1.p sw_tgate_cmfb2_1.p.t6 28.0882
R19533 sw_tgate_cmfb2_1.p.n2 sw_tgate_cmfb2_1.p.t1 27.4556
R19534 sw_tgate_cmfb2_1.p.n4 sw_tgate_cmfb2_1.p.t13 22.3543
R19535 sw_tgate_cmfb2_1.p.n6 sw_tgate_cmfb2_1.p.t11 21.972
R19536 sw_tgate_cmfb2_1.p.n5 sw_tgate_cmfb2_1.p.t9 21.972
R19537 sw_tgate_cmfb2_1.p.n2 sw_tgate_cmfb2_1.p.t0 17.8361
R19538 sw_tgate_cmfb2_1.p.n0 sw_tgate_cmfb2_1.p.t5 17.6958
R19539 sw_tgate_cmfb2_1.p.n0 sw_tgate_cmfb2_1.p.t4 17.1724
R19540 sw_tgate_cmfb2_1.p.n7 sw_tgate_cmfb2_1.p.t12 17.1012
R19541 sw_tgate_cmfb2_1.p.n3 sw_tgate_cmfb2_1.p.t8 17.1012
R19542 sw_tgate_cmfb2_1.p.n7 sw_tgate_cmfb2_1.p.t10 16.5327
R19543 sw_tgate_cmfb2_1.p.n3 sw_tgate_cmfb2_1.p.t7 16.5327
R19544 sw_tgate_cmfb2_1.p.n4 sw_tgate_cmfb2_1.p.n3 8.58799
R19545 sw_tgate_cmfb2_1.p sw_tgate_cmfb2_1.p.n8 5.98284
R19546 sw_tgate_cmfb2_1.p.n6 sw_tgate_cmfb2_1.p.n5 5.84491
R19547 sw_tgate_cmfb2_1.p.n0 sw_tgate_cmfb2_1.p.t2 5.11201
R19548 sw_tgate_cmfb2_1.p.n8 sw_tgate_cmfb2_1.p.n7 4.82068
R19549 sw_tgate_cmfb2_1.p.n0 sw_tgate_cmfb2_1.p.t3 4.657
R19550 sw_tgate_cmfb2_1.p sw_tgate_cmfb2_1.p.n0 4.59599
R19551 sw_tgate_cmfb2_1.p.n2 sw_tgate_cmfb2_1.p.n1 2.251
R19552 sw_tgate_cmfb2_1.p.n8 sw_tgate_cmfb2_1.p.n1 3.89879
R19553 sw_tgate_cmfb2_1.p.n5 sw_tgate_cmfb2_1.p.n4 1.66036
R19554 sw_tgate_cmfb2_1.p.n1 sw_tgate_cmfb2_1.p.n6 1.52323
R19555 a_7804_29739.n2 a_7804_29739.t4 32.5518
R19556 a_7804_29739.n2 a_7804_29739.t3 30.5005
R19557 a_7804_29739.n3 a_7804_29739.t2 30.5005
R19558 a_7804_29739.n1 a_7804_29739.t7 17.3952
R19559 a_7804_29739.n4 a_7804_29739.t6 17.2281
R19560 a_7804_29739.n4 a_7804_29739.t5 17.1676
R19561 a_7804_29739.n5 a_7804_29739.n4 17.0038
R19562 a_7804_29739.n1 a_7804_29739.t8 17.0005
R19563 a_7804_29739.n0 a_7804_29739.n1 16.769
R19564 a_7804_29739.t0 a_7804_29739.n5 16.5367
R19565 a_7804_29739.n0 a_7804_29739.t1 16.4144
R19566 a_7804_29739.n5 a_7804_29739.n0 11.7168
R19567 a_7804_29739.n0 a_7804_29739.n3 11.111
R19568 a_7804_29739.n3 a_7804_29739.n2 2.05181
R19569 a_6452_29739.n3 a_6452_29739.t0 32.5518
R19570 a_6452_29739.n4 a_6452_29739.t2 30.5005
R19571 a_6452_29739.n3 a_6452_29739.t1 30.5005
R19572 a_6452_29739.n0 a_6452_29739.n1 19.8926
R19573 a_6452_29739.n5 a_6452_29739.n2 18.7926
R19574 a_6452_29739.n2 a_6452_29739.t5 17.5236
R19575 a_6452_29739.n1 a_6452_29739.t8 17.3255
R19576 a_6452_29739.n1 a_6452_29739.t7 17.1986
R19577 a_6452_29739.n2 a_6452_29739.t6 17.0005
R19578 a_6452_29739.t4 a_6452_29739.n0 16.5367
R19579 a_6452_29739.n0 a_6452_29739.t3 16.4144
R19580 a_6452_29739.n5 a_6452_29739.n4 10.8288
R19581 a_6452_29739.n0 a_6452_29739.n5 2.08974
R19582 a_6452_29739.n4 a_6452_29739.n3 2.05181
R19583 w_9407_29481.n5 w_9407_29481.t0 6.71343
R19584 w_9407_29481.n6 w_9407_29481.n5 0.566914
R19585 w_9407_29481.n5 w_9407_29481.t13 7.72984
R19586 w_9407_29481.n4 w_9407_29481.t15 7.72984
R19587 w_9407_29481.t4 w_9407_29481.n2 7.52184
R19588 w_9407_29481.n1 w_9407_29481.t3 7.52152
R19589 w_9407_29481.n1 w_9407_29481.t6 7.52152
R19590 w_9407_29481.n0 w_9407_29481.t2 7.52152
R19591 w_9407_29481.n7 w_9407_29481.t1 7.52152
R19592 w_9407_29481.n1 w_9407_29481.n8 7.40604
R19593 w_9407_29481.n0 w_9407_29481.n21 7.40604
R19594 w_9407_29481.t0 w_9407_29481.n4 6.71237
R19595 w_9407_29481.n14 w_9407_29481.n10 6.66038
R19596 w_9407_29481.n19 w_9407_29481.n16 6.6602
R19597 w_9407_29481.n17 w_9407_29481.n16 6.46323
R19598 w_9407_29481.n12 w_9407_29481.n10 6.46306
R19599 w_9407_29481.n14 w_9407_29481.n13 5.2979
R19600 w_9407_29481.n19 w_9407_29481.n18 5.2979
R19601 w_9407_29481.n11 w_9407_29481.n8 5.20758
R19602 w_9407_29481.n21 w_9407_29481.n9 5.20758
R19603 w_9407_29481.n13 w_9407_29481.n12 5.10057
R19604 w_9407_29481.n18 w_9407_29481.n17 5.10057
R19605 w_9407_29481.n4 w_9407_29481.n3 0.566891
R19606 w_9407_29481.n3 w_9407_29481.n2 2.17855
R19607 w_9407_29481.n7 w_9407_29481.n6 2.17856
R19608 w_9407_29481.n15 w_9407_29481.n8 4.5005
R19609 w_9407_29481.n21 w_9407_29481.n20 4.5005
R19610 w_9407_29481.n17 w_9407_29481.n9 4.08036
R19611 w_9407_29481.n12 w_9407_29481.n11 4.08036
R19612 w_9407_29481.n20 w_9407_29481.n19 4.08036
R19613 w_9407_29481.n15 w_9407_29481.n14 4.08036
R19614 w_9407_29481.n6 w_9407_29481.t14 3.21131
R19615 w_9407_29481.n11 w_9407_29481.n9 1.67553
R19616 w_9407_29481.n20 w_9407_29481.n15 1.67553
R19617 w_9407_29481.n16 w_9407_29481.t9 1.42108
R19618 w_9407_29481.n10 w_9407_29481.t12 1.42089
R19619 w_9407_29481.n13 w_9407_29481.t11 1.42089
R19620 w_9407_29481.n18 w_9407_29481.t10 1.42089
R19621 w_9407_29481.n3 w_9407_29481.t17 3.21119
R19622 w_9407_29481.n1 w_9407_29481.n0 1.67553
R19623 w_9407_29481.n2 w_9407_29481.n1 1.17484
R19624 w_9407_29481.n0 w_9407_29481.n7 1.17484
C4786 ibias_test vss 1.80406f
C4787 vcm vss 1.47412f
C4788 vi vss 2.24166f
C4789 di_clk vss 0.18152f
C4790 do_clk_osc vss 0.767341f
C4791 do_osc_oe vss 0.297388f
C4792 di_clk_sel vss 4.38018f
C4793 di_osc_en vss 2.3704f
C4794 d_vcm_phi2 vss 1.17395f
C4795 d_vcm_phi1_b vss 0.813678f
C4796 d_qclk vss 2.85333f
C4797 d_dith[2] vss 1.32225f
C4798 d_dith[0] vss 2.12333f
C4799 do_q_dec vss 4.09109f
C4800 do_q vss 2.87536f
C4801 do_q_b vss 3.72308f
C4802 d_dith[1] vss 0.888116f
C4803 d_amp_s[2] vss 0.409355f
C4804 d_amp_s_b[2] vss 0.517458f
C4805 d_amp_s[3] vss 0.521694f
C4806 d_amp_s_b[3] vss 1.89091f
C4807 d_amp_s[1] vss 0.523119f
C4808 d_amp_s_b[1] vss 0.433581f
C4809 d_amp_s[0] vss 0.957819f
C4810 d_amp_s_b[0] vss 0.705174f
C4811 vi_esd vss 1.45023f
C4812 d_qi vss 1.06905f
C4813 d_qi_b vss 1.62317f
C4814 di_vcm_ext vss 0.66464f
C4815 d_qout_en vss 0.869315f
C4816 di_qout_en vss 0.61394f
C4817 d_rst_b vss 0.672798f
C4818 di_rst_b vss 0.61427f
C4819 d_dith_en vss 2.2464f
C4820 di_dith_en vss 0.61403f
C4821 di_dith_amp[1] vss 0.61294f
C4822 di_dith_amp[0] vss 0.61262f
C4823 di_btest_en vss 0.61496f
C4824 di_trim[3] vss 0.61043f
C4825 di_trim[2] vss 0.60895f
C4826 di_trim[1] vss 0.6116f
C4827 di_trim[0] vss 0.60469f
C4828 di_ena vss 0.63954f
C4829 vcm_esd vss 92.6544f
C4830 d_phi2 vss 4.2838f
C4831 d_phi1 vss 4.47488f
C4832 ibias_200n vss 13.8951f
C4833 vo_n vss 6.82787f
C4834 vo_p vss 6.7977f
C4835 d_ena vss 14.6787f
C4837 m3_9560_28731# vss 0.09651f
C4838 m2_10908_16655# vss 1.66104f
C4839 m2_10908_16863# vss 2.87499f
C4840 m2_6409_30900# vss 0.27049f
C4841 a_24164_726# vss 0.08198f
C4842 a_22258_594# vss 0.06776f ; **FLOATING
C4843 a_23150_752# vss 0.03735f ; **FLOATING
C4844 a_23289_752# vss 0.08487f ; **FLOATING
C4845 a_23195_985# vss 0.14576f ; **FLOATING
C4846 a_22368_558# vss 1.0122f ; **FLOATING
C4847 a_22347_812# vss 0.19891f ; **FLOATING
C4848 a_22000_594# vss 0.19913f ; **FLOATING
C4849 a_22499_864# vss 0.46841f ; **FLOATING
C4850 dsm2_osc_0.sg13cmos5l_dfrbp_1_0.Q_N vss 0.56665f ; **FLOATING
C4851 a_21617_558# vss 0.38682f ; **FLOATING
C4852 a_21498_769# vss 0.19856f ; **FLOATING
C4853 a_20770_598# vss 0.37317f ; **FLOATING
C4854 a_20447_636# vss 0.13673f ; **FLOATING
C4855 dsm2_osc_0.sg13cmos5l_buf_2_0.A vss 0.1815f ; **FLOATING
C4856 a_19949_784# vss 0.33174f ; **FLOATING
C4857 a_19576_826# vss 0.06185f
C4858 dsm2_osc_0.di_clk_ext vss 0.34958f ; **FLOATING
C4859 a_19000_826# vss 0.085f
C4860 a_19105_884# vss 0.3575f ; **FLOATING
C4861 dsm2_osc_0.ibias_pad vss 6.91873f ; **FLOATING
C4862 dsm2_osc_0.sg13cmos5l_dfrbp_1_0.CLK vss 0.23097f ; **FLOATING
C4863 a_22836_1332# vss 0.30367f ; **FLOATING
C4864 dsm2_osc_0.sg13cmos5l_inv_1_2.Y vss 0.31071f ; **FLOATING
C4865 dsm2_osc_0.sg13cmos5l_inv_1_2.A vss 0.23875f ; **FLOATING
C4866 a_21681_1704# vss 0.0985f ; **FLOATING
C4867 dsm2_osc_0.sg13cmos5l_mux2_1_0.A1 vss 0.56259f ; **FLOATING
C4868 a_23674_2344# vss 0.05148f ; **FLOATING
C4869 a_23294_2344# vss 0.06666f ; **FLOATING
C4870 a_22738_2088# vss 0.10266f ; **FLOATING
C4871 a_22386_2344# vss 0.10308f ; **FLOATING
C4872 a_21830_2088# vss 0.10266f ; **FLOATING
C4873 a_21478_2344# vss 0.10308f ; **FLOATING
C4874 a_23674_2578# vss 0.03538f ; **FLOATING
C4875 dsm2_osc_0.dsm2_io_rx_1.di_b vss 0.57656f ; **FLOATING
C4876 dsm2_osc_0.dsm2_io_rx_0.di_b vss 0.647246f ; **FLOATING
C4877 dsm2_osc_0.sg13cmos5l_inv_1_3.A vss 0.41527f ; **FLOATING
C4878 a_22644_2344# vss 0.41887f ; **FLOATING
C4879 a_22184_2052# vss 0.44039f ; **FLOATING
C4880 a_21736_2344# vss 0.38798f ; **FLOATING
C4881 a_21276_2052# vss 0.51479f ; **FLOATING
C4882 dsm2_osc_0.sg13cmos5l_dfrbp_1_0.RESET_B vss 0.25313f ; **FLOATING
C4883 a_21554_2798# vss 0.31453f ; **FLOATING
C4884 a_2034_698# vss 0.21149f ; **FLOATING
C4885 a_2034_1082# vss 0.16323f ; **FLOATING
C4886 a_2034_1466# vss 0.15922f ; **FLOATING
C4887 a_1288_778# vss 0.08777f ; **FLOATING
C4888 a_1367_1349# vss 0.14866f ; **FLOATING
C4889 a_1600_1349# vss 0.03691f ; **FLOATING
C4890 a_567_786# vss 0.08736f ; **FLOATING
C4891 a_558_518# vss 0.15123f ; **FLOATING
C4892 a_571_1092# vss 0.03877f ; **FLOATING
C4893 a_1286_1655# vss 0.44744f ; **FLOATING
C4894 a_1324_804# vss 1.02107f ; **FLOATING
C4895 a_537_1221# vss 0.46467f ; **FLOATING
C4896 a_1322_1586# vss 0.19138f ; **FLOATING
C4897 a_1681_1969# vss 0.06804f ; **FLOATING
C4898 a_2079_1938# vss 0.08793f ; **FLOATING
C4899 a_2070_1670# vss 0.1282f ; **FLOATING
C4900 a_2083_2244# vss 0.03749f ; **FLOATING
C4901 a_533_2144# vss 0.1991f ; **FLOATING
C4902 a_522_2184# vss 1.02242f ; **FLOATING
C4903 a_558_2286# vss 0.06776f ; **FLOATING
C4904 a_1407_2354# vss 0.1519f ; **FLOATING
C4905 a_1284_2799# vss 0.26401f ; **FLOATING
C4906 a_522_2354# vss 0.1535f ; **FLOATING
C4907 dsm2_osc_0.ibias_in vss 4.86609f ; **FLOATING
C4908 bias_gm_0.bias_trim_0.iout vss 0.53098f ; **FLOATING
C4909 a_24404_4674# vss 0.0339f ; **FLOATING
C4910 a_22252_5274# vss 0.37144f ; **FLOATING
C4911 a_22252_4074# vss 0.22052f ; **FLOATING
C4912 a_22252_4374# vss 0.44453f ; **FLOATING
C4913 a_522_2518# vss 0.27908f ; **FLOATING
C4914 a_1284_2901# vss 0.1964f ; **FLOATING
C4915 a_522_2901# vss 0.19695f ; **FLOATING
C4916 a_2049_2373# vss 0.45403f ; **FLOATING
C4917 quantizer2_lfsr_0.sg13cmos5l_dfrbpq_1_11.Q vss 0.206297f ; **FLOATING
C4918 a_2045_3296# vss 0.19781f ; **FLOATING
C4919 a_2034_3336# vss 1.011f ; **FLOATING
C4920 a_2070_3438# vss 0.06815f ; **FLOATING
C4921 quantizer2_lfsr_0.sg13cmos5l_dfrbpq_1_0.Q vss 0.47916f ; **FLOATING
C4922 a_2034_3506# vss 0.15311f ; **FLOATING
C4923 a_2034_3670# vss 0.27849f ; **FLOATING
C4924 a_2034_4053# vss 0.19933f ; **FLOATING
C4925 xvcm_vcf_t vss 7.14473f ; **FLOATING
C4926 xvcm_vcf_b vss 9.93137f ; **FLOATING
C4927 a_1288_3370# vss 0.08207f ; **FLOATING
C4928 a_1367_3941# vss 0.1242f ; **FLOATING
C4929 a_1600_3941# vss 0.03706f ; **FLOATING
C4930 a_567_3378# vss 0.08176f ; **FLOATING
C4931 a_558_3110# vss 0.12383f ; **FLOATING
C4932 a_571_3684# vss 0.03666f ; **FLOATING
C4933 quantizer2_lfsr_0.sg13cmos5l_dfrbpq_1_2.Q vss 0.199146f ; **FLOATING
C4934 a_1286_4247# vss 0.44694f ; **FLOATING
C4935 a_1324_3396# vss 1.00634f ; **FLOATING
C4936 a_537_3813# vss 0.46298f ; **FLOATING
C4937 a_1322_4178# vss 0.19144f ; **FLOATING
C4938 a_1681_4561# vss 0.06804f ; **FLOATING
C4939 a_2079_4530# vss 0.08842f ; **FLOATING
C4940 a_2070_4262# vss 0.12786f ; **FLOATING
C4941 a_2083_4836# vss 0.03723f ; **FLOATING
C4942 a_17416_5586# vss 0.25809f
C4943 a_533_4736# vss 0.19654f ; **FLOATING
C4944 a_522_4776# vss 1.00859f ; **FLOATING
C4945 a_558_4878# vss 0.06776f ; **FLOATING
C4946 a_1407_4946# vss 0.15173f ; **FLOATING
C4947 a_16832_5586# vss 0.03874f
C4948 a_16648_5586# vss 0.07698f
C4949 a_16264_5586# vss 0.18396f
C4950 a_15496_5586# vss 0.39312f
C4951 a_14728_5586# vss 0.3942f
C4952 a_13960_5586# vss 0.39314f
C4953 a_13192_5586# vss 0.39337f
C4954 a_12424_5586# vss 0.39826f
C4955 a_11656_5586# vss 0.39695f
C4956 a_10888_5586# vss 0.3985f
C4957 a_10120_5586# vss 0.39752f
C4958 a_9352_5586# vss 0.40319f
C4959 a_16941_5500# vss 0.11492f ; **FLOATING
C4960 a_8768_5586# vss 0.03936f
C4961 a_8392_5586# vss 0.22209f
C4962 a_1284_5391# vss 0.26373f ; **FLOATING
C4963 a_522_4946# vss 0.1535f ; **FLOATING
C4964 a_522_5110# vss 0.27908f ; **FLOATING
C4965 a_1284_5493# vss 0.19588f ; **FLOATING
C4966 a_522_5493# vss 0.19695f ; **FLOATING
C4967 a_2049_4965# vss 0.45246f ; **FLOATING
C4968 quantizer2_lfsr_0.sg13cmos5l_dfrbpq_1_12.Q vss 0.24098f ; **FLOATING
C4969 a_8880_5832# vss 0.33406f ; **FLOATING
C4970 a_2045_5888# vss 0.19563f ; **FLOATING
C4971 a_2034_5928# vss 1.00968f ; **FLOATING
C4972 a_2070_6030# vss 0.06805f ; **FLOATING
C4973 quantizer2_lfsr_0.sg13cmos5l_dfrbpq_1_9.D vss 0.2679f ; **FLOATING
C4974 a_17595_6570# vss 0.15057f
C4975 clk_noverlap_0.do_phi2_b vss 0.46041f ; **FLOATING
C4976 clk_noverlap_0.sg13cmos5l_inv_1_8.A vss 0.25135f ; **FLOATING
C4977 clk_noverlap_0.sg13cmos5l_inv_1_9.A vss 0.25105f ; **FLOATING
C4978 clk_noverlap_0.sg13cmos5l_inv_1_10.A vss 0.38436f ; **FLOATING
C4979 a_10784_6484# vss 0.10274f ; **FLOATING
C4980 clk_noverlap_0.di_clk vss 2.5475f ; **FLOATING
C4981 clk_noverlap_0.sg13cmos5l_inv_1_0.Y vss 0.25196f ; **FLOATING
C4982 clk_noverlap_0.sg13cmos5l_inv_1_11.Y vss 0.25877f ; **FLOATING
C4983 a_2034_6098# vss 0.15409f ; **FLOATING
C4984 a_4251_6570# vss 0.15525f
C4985 a_2034_6262# vss 0.28061f ; **FLOATING
C4986 a_2034_6645# vss 0.19966f ; **FLOATING
C4987 clk_noverlap_0.sg13cmos5l_inv_1_1.A vss 0.38436f ; **FLOATING
C4988 clk_noverlap_0.sg13cmos5l_inv_1_1.Y vss 0.24953f ; **FLOATING
C4989 clk_noverlap_0.sg13cmos5l_inv_1_3.Y vss 0.25316f ; **FLOATING
C4990 dsm2_io_vcmg_0.di_phi1_b vss 0.65654f ; **FLOATING
C4991 a_24404_8546# vss 0.02645f ; **FLOATING
C4992 a_22252_7946# vss 0.44546f ; **FLOATING
C4993 a_22252_8546# vss 0.49517f ; **FLOATING
C4994 a_22252_8246# vss 0.22033f ; **FLOATING
C4995 a_28746_14846# vss 0.01267f ; **FLOATING
C4996 a_20070_14846# vss 0.01275f ; **FLOATING
C4997 a_28746_15446# vss 0.01305f ; **FLOATING
C4998 a_20070_15446# vss 0.01305f ; **FLOATING
C4999 a_28746_16046# vss 0.01385f ; **FLOATING
C5000 a_20070_16046# vss 0.01385f ; **FLOATING
C5001 a_20138_14766# vss 0.98895f ; **FLOATING
C5002 a_17140_7466# vss 0.1717f ; **FLOATING
C5003 a_16276_7466# vss 0.18378f ; **FLOATING
C5004 a_15412_7466# vss 0.1774f ; **FLOATING
C5005 a_14548_7466# vss 0.18823f ; **FLOATING
C5006 a_13684_7466# vss 0.17772f ; **FLOATING
C5007 a_12820_7466# vss 0.16908f ; **FLOATING
C5008 a_11956_7466# vss 0.16908f ; **FLOATING
C5009 a_17421_7164# vss 0.31105f ; **FLOATING
C5010 a_17025_7467# vss 0.16729f ; **FLOATING
C5011 clk_noverlap_0.sg13cmos5l_dlygate4sd3_1_12.A vss 0.2051f ; **FLOATING
C5012 a_16557_7164# vss 0.25936f ; **FLOATING
C5013 a_16161_7467# vss 0.16419f ; **FLOATING
C5014 clk_noverlap_0.sg13cmos5l_dlygate4sd3_1_10.A vss 0.20296f ; **FLOATING
C5015 a_15693_7164# vss 0.26113f ; **FLOATING
C5016 a_15297_7467# vss 0.1681f ; **FLOATING
C5017 clk_noverlap_0.sg13cmos5l_dlygate4sd3_1_9.A vss 0.20614f ; **FLOATING
C5018 a_14829_7164# vss 0.26589f ; **FLOATING
C5019 a_14433_7467# vss 0.16815f ; **FLOATING
C5020 clk_noverlap_0.sg13cmos5l_dlygate4sd3_1_7.A vss 0.20694f ; **FLOATING
C5021 a_13965_7164# vss 0.26955f ; **FLOATING
C5022 a_13569_7467# vss 0.16811f ; **FLOATING
C5023 clk_noverlap_0.sg13cmos5l_dlygate4sd3_1_7.X vss 0.20824f ; **FLOATING
C5024 a_13101_7164# vss 0.25617f ; **FLOATING
C5025 a_12705_7467# vss 0.16095f ; **FLOATING
C5026 clk_noverlap_0.sg13cmos5l_dlygate4sd3_1_8.X vss 0.19912f ; **FLOATING
C5027 a_12237_7164# vss 0.25444f ; **FLOATING
C5028 a_11841_7467# vss 0.16041f ; **FLOATING
C5029 clk_noverlap_0.sg13cmos5l_inv_1_6.A vss 0.2533f ; **FLOATING
C5030 clk_noverlap_0.sg13cmos5l_inv_1_5.A vss 0.25961f ; **FLOATING
C5031 clk_noverlap_0.sg13cmos5l_inv_1_5.Y vss 0.18165f ; **FLOATING
C5032 a_10291_7286# vss 0.04477f
C5033 a_10483_7459# vss 0.09768f ; **FLOATING
C5034 clk_noverlap_0.sg13cmos5l_inv_1_0.A vss 0.75961f ; **FLOATING
C5035 clk_noverlap_0.sg13cmos5l_nor3_1_0.C vss 0.23379f ; **FLOATING
C5036 a_9721_7200# vss 0.16908f ; **FLOATING
C5037 a_8857_7200# vss 0.16955f ; **FLOATING
C5038 a_7993_7200# vss 0.17936f ; **FLOATING
C5039 a_7129_7200# vss 0.19058f ; **FLOATING
C5040 a_1288_5962# vss 0.08185f ; **FLOATING
C5041 a_1367_6533# vss 0.12417f ; **FLOATING
C5042 a_1600_6533# vss 0.0373f ; **FLOATING
C5043 a_567_5970# vss 0.08181f ; **FLOATING
C5044 a_558_5702# vss 0.12391f ; **FLOATING
C5045 a_571_6276# vss 0.03685f ; **FLOATING
C5046 quantizer2_lfsr_0.sg13cmos5l_dfrbpq_1_3.Q vss 0.26559f ; **FLOATING
C5047 a_6265_7200# vss 0.1774f ; **FLOATING
C5048 a_5401_7200# vss 0.18398f ; **FLOATING
C5049 a_4537_7200# vss 0.17274f ; **FLOATING
C5050 a_9833_7224# vss 0.15986f ; **FLOATING
C5051 a_9451_7241# vss 0.25444f ; **FLOATING
C5052 clk_noverlap_0.sg13cmos5l_dlygate4sd3_1_4.X vss 0.19912f ; **FLOATING
C5053 a_8969_7224# vss 0.16151f ; **FLOATING
C5054 a_8587_7241# vss 0.25604f ; **FLOATING
C5055 clk_noverlap_0.sg13cmos5l_dlygate4sd3_1_4.A vss 0.20696f ; **FLOATING
C5056 a_8105_7224# vss 0.16811f ; **FLOATING
C5057 a_7723_7241# vss 0.26965f ; **FLOATING
C5058 clk_noverlap_0.sg13cmos5l_dlygate4sd3_1_3.X vss 0.20791f ; **FLOATING
C5059 a_7241_7224# vss 0.17065f ; **FLOATING
C5060 a_6859_7241# vss 0.26655f ; **FLOATING
C5061 clk_noverlap_0.sg13cmos5l_dlygate4sd3_1_2.X vss 0.20486f ; **FLOATING
C5062 a_6377_7224# vss 0.1681f ; **FLOATING
C5063 a_5995_7241# vss 0.26213f ; **FLOATING
C5064 clk_noverlap_0.sg13cmos5l_dlygate4sd3_1_1.X vss 0.20386f ; **FLOATING
C5065 a_5513_7224# vss 0.16419f ; **FLOATING
C5066 a_5131_7241# vss 0.2597f ; **FLOATING
C5067 clk_noverlap_0.sg13cmos5l_dlygate4sd3_1_0.X vss 0.20382f ; **FLOATING
C5068 a_4649_7224# vss 0.16734f ; **FLOATING
C5069 a_4267_7241# vss 0.30609f ; **FLOATING
C5070 clk_noverlap_0.sg13cmos5l_dlygate4sd3_1_0.A vss 0.606904f ; **FLOATING
C5071 a_1286_6839# vss 0.44726f ; **FLOATING
C5072 a_1324_5988# vss 1.00965f ; **FLOATING
C5073 a_537_6405# vss 0.46508f ; **FLOATING
C5074 a_1322_6770# vss 0.19321f ; **FLOATING
C5075 a_1681_7153# vss 0.06973f ; **FLOATING
C5076 a_2079_7122# vss 0.08721f ; **FLOATING
C5077 a_2070_6854# vss 0.12795f ; **FLOATING
C5078 a_2083_7428# vss 0.03774f ; **FLOATING
C5079 a_533_7328# vss 0.1984f ; **FLOATING
C5080 a_522_7368# vss 1.01128f ; **FLOATING
C5081 a_558_7470# vss 0.06914f ; **FLOATING
C5082 a_1407_7538# vss 0.16266f ; **FLOATING
C5083 a_11115_8328# vss 0.83909f ; **FLOATING
C5084 a_10757_8328# vss 0.82902f ; **FLOATING
C5085 a_13211_8468# vss 0.85027f ; **FLOATING
C5086 a_8661_8468# vss 0.80495f ; **FLOATING
C5087 a_11115_8608# vss 0.76908f ; **FLOATING
C5088 a_10757_8608# vss 0.76923f ; **FLOATING
C5089 a_6884_8680# vss 0.64851f ; **FLOATING
C5090 a_13211_8748# vss 0.79873f ; **FLOATING
C5091 a_1284_7983# vss 0.28207f ; **FLOATING
C5092 a_522_7538# vss 0.16425f ; **FLOATING
C5093 a_522_7702# vss 0.29687f ; **FLOATING
C5094 a_1284_8085# vss 0.25911f ; **FLOATING
C5095 a_522_8085# vss 0.26045f ; **FLOATING
C5096 a_2049_7557# vss 0.45957f ; **FLOATING
C5097 quantizer2_lfsr_0.sg13cmos5l_dfrbpq_1_15.D vss 0.32772f ; **FLOATING
C5098 a_2045_8480# vss 0.19912f ; **FLOATING
C5099 a_2034_8520# vss 1.01387f ; **FLOATING
C5100 a_2070_8622# vss 0.06851f ; **FLOATING
C5101 a_8661_8748# vss 0.79768f ; **FLOATING
C5102 a_11115_8888# vss 0.77082f ; **FLOATING
C5103 a_10757_8888# vss 0.76892f ; **FLOATING
C5104 a_13211_9028# vss 0.78809f ; **FLOATING
C5105 a_8661_9028# vss 0.78704f ; **FLOATING
C5106 a_11115_9168# vss 0.8271f ; **FLOATING
C5107 a_10757_9168# vss 0.8271f ; **FLOATING
C5108 xq_dith_v_bp vss 9.83329f ; **FLOATING
C5109 quantizer2_lfsr_0.sg13cmos5l_dfrbpq_1_8.D vss 0.35989f ; **FLOATING
C5110 a_2034_8690# vss 0.15252f ; **FLOATING
C5111 a_2034_8854# vss 0.27703f ; **FLOATING
C5112 a_2034_9237# vss 0.19824f ; **FLOATING
C5113 xq_dith_v_bq vss 6.532f ; **FLOATING
C5114 a_10757_9808# vss 2.02857f ; **FLOATING
C5115 a_1288_8554# vss 0.08197f ; **FLOATING
C5116 a_1367_9125# vss 0.12626f ; **FLOATING
C5117 a_1600_9125# vss 0.03722f ; **FLOATING
C5118 a_567_8562# vss 0.08222f ; **FLOATING
C5119 a_558_8294# vss 0.12668f ; **FLOATING
C5120 a_571_8868# vss 0.03715f ; **FLOATING
C5121 quantizer2_lfsr_0.sg13cmos5l_dfrbpq_1_4.Q vss 0.24673f ; **FLOATING
C5122 a_1286_9431# vss 0.43949f ; **FLOATING
C5123 a_1324_8580# vss 1.00733f ; **FLOATING
C5124 a_537_8997# vss 0.46317f ; **FLOATING
C5125 a_1322_9362# vss 0.19177f ; **FLOATING
C5126 a_1681_9745# vss 0.06835f ; **FLOATING
C5127 a_2079_9714# vss 0.08767f ; **FLOATING
C5128 a_2070_9446# vss 0.12793f ; **FLOATING
C5129 a_2083_10020# vss 0.03774f ; **FLOATING
C5130 a_533_9920# vss 0.1967f ; **FLOATING
C5131 a_522_9960# vss 1.00992f ; **FLOATING
C5132 a_558_10062# vss 0.06776f ; **FLOATING
C5133 a_1407_10130# vss 0.15191f ; **FLOATING
C5134 a_1284_10575# vss 0.26444f ; **FLOATING
C5135 a_522_10130# vss 0.1535f ; **FLOATING
C5136 xq_vg_p_2_ vss 9.01588f ; **FLOATING
C5137 xq_vg_p_1_ vss 3.62092f ; **FLOATING
C5138 xq_vg_p_0_ vss 2.62933f ; **FLOATING
C5139 xq_vg_q_0_ vss 2.05536f ; **FLOATING
C5140 xq_vg_q_1_ vss 4.74955f ; **FLOATING
C5141 xq_vg_q_2_ vss 6.59786f ; **FLOATING
C5142 a_522_10294# vss 0.27908f ; **FLOATING
C5143 a_1284_10677# vss 0.19639f ; **FLOATING
C5144 a_522_10677# vss 0.19695f ; **FLOATING
C5145 a_2049_10149# vss 0.44861f ; **FLOATING
C5146 quantizer2_lfsr_0.sg13cmos5l_dfrbpq_1_14.D vss 0.23997f ; **FLOATING
C5147 a_2045_11072# vss 0.20012f ; **FLOATING
C5148 a_2034_11112# vss 1.01236f ; **FLOATING
C5149 a_2070_11214# vss 0.06856f ; **FLOATING
C5150 quantizer2_lfsr_0.sg13cmos5l_dfrbpq_1_7.D vss 0.26845f ; **FLOATING
C5151 a_2034_11282# vss 0.15296f ; **FLOATING
C5152 a_2034_11446# vss 0.27919f ; **FLOATING
C5153 a_2034_11829# vss 0.1991f ; **FLOATING
C5154 a_1288_11146# vss 0.08197f ; **FLOATING
C5155 a_1367_11717# vss 0.12456f ; **FLOATING
C5156 a_1600_11717# vss 0.0373f ; **FLOATING
C5157 a_567_11154# vss 0.08176f ; **FLOATING
C5158 a_558_10886# vss 0.12383f ; **FLOATING
C5159 a_571_11460# vss 0.03666f ; **FLOATING
C5160 a_1286_12023# vss 0.43963f ; **FLOATING
C5161 a_1324_11172# vss 1.00743f ; **FLOATING
C5162 a_537_11589# vss 0.46298f ; **FLOATING
C5163 a_1322_11954# vss 0.19177f ; **FLOATING
C5164 a_1681_12337# vss 0.06835f ; **FLOATING
C5165 a_2079_12306# vss 0.08763f ; **FLOATING
C5166 a_2070_12038# vss 0.12757f ; **FLOATING
C5167 a_2083_12612# vss 0.03774f ; **FLOATING
C5168 a_533_12512# vss 0.19654f ; **FLOATING
C5169 a_522_12552# vss 1.00859f ; **FLOATING
C5170 a_558_12654# vss 0.06776f ; **FLOATING
C5171 a_1407_12722# vss 0.15191f ; **FLOATING
C5172 a_1284_13167# vss 0.26444f ; **FLOATING
C5173 a_522_12722# vss 0.1535f ; **FLOATING
C5174 a_522_12886# vss 0.27908f ; **FLOATING
C5175 a_1284_13269# vss 0.19622f ; **FLOATING
C5176 a_522_13269# vss 0.19695f ; **FLOATING
C5177 a_2049_12741# vss 0.44935f ; **FLOATING
C5178 a_2045_13664# vss 0.19798f ; **FLOATING
C5179 a_2034_13704# vss 1.01204f ; **FLOATING
C5180 a_2070_13806# vss 0.06856f ; **FLOATING
C5181 a_2034_13874# vss 0.1539f ; **FLOATING
C5182 a_2034_14038# vss 0.27864f ; **FLOATING
C5183 a_2034_14421# vss 0.20019f ; **FLOATING
C5184 a_1288_13738# vss 0.0819f ; **FLOATING
C5185 a_1367_14309# vss 0.12448f ; **FLOATING
C5186 a_1600_14309# vss 0.03724f ; **FLOATING
C5187 a_567_13746# vss 0.08176f ; **FLOATING
C5188 a_558_13478# vss 0.12383f ; **FLOATING
C5189 a_571_14052# vss 0.03666f ; **FLOATING
C5190 a_15584_15091# vss 0.13273f ; **FLOATING
C5191 a_15130_14856# vss 0.25311f ; **FLOATING
C5192 a_14849_15078# vss 0.17193f ; **FLOATING
C5193 a_14734_15077# vss 0.16641f ; **FLOATING
C5194 a_14266_14856# vss 0.2563f ; **FLOATING
C5195 a_13985_15078# vss 0.1719f ; **FLOATING
C5196 a_13870_15077# vss 0.16304f ; **FLOATING
C5197 sg13cmos5l_inv_1_0.Y vss 0.23423f ; **FLOATING
C5198 a_13088_15020# vss 0.05115f
C5199 a_11865_14889# vss 0.30487f ; **FLOATING
C5200 a_6202_14892# vss 0.0102f ; **FLOATING
C5201 a_11284_15186# vss 0.01442f ; **FLOATING
C5202 sg13cmos5l_and2_2_1.X vss 1.18071f ; **FLOATING
C5203 a_10132_15186# vss 0.01442f ; **FLOATING
C5204 a_9556_15186# vss 0.01442f ; **FLOATING
C5205 sg13cmos5l_inv_1_0.A vss 0.23409f ; **FLOATING
C5206 sg13cmos5l_inv_1_1.A vss 4.02554f ; **FLOATING
C5207 sg13cmos5l_inv_1_14.A vss 0.78005f ; **FLOATING
C5208 sg13cmos5l_inv_2_5.A vss 0.34487f ; **FLOATING
C5209 sg13cmos5l_inv_2_5.Y vss 0.30429f ; **FLOATING
C5210 sg13cmos5l_nor2_2_2.A vss 0.27782f ; **FLOATING
C5211 a_10787_14878# vss 0.17247f ; **FLOATING
C5212 sg13cmos5l_nor2_2_0.Y vss 0.44744f ; **FLOATING
C5213 sg13cmos5l_inv_2_0.Y vss 0.34277f ; **FLOATING
C5214 sg13cmos5l_inv_1_2.Y vss 0.35576f ; **FLOATING
C5215 sg13cmos5l_inv_1_2.A vss 0.707196f ; **FLOATING
C5216 a_8013_14934# vss 0.10004f ; **FLOATING
C5217 sg13cmos5l_and2_1_5.B vss 0.156348f ; **FLOATING
C5218 sg13cmos5l_and2_1_5.A vss 0.223065f ; **FLOATING
C5219 sg13cmos5l_inv_1_18.Y vss 1.044f ; **FLOATING
C5220 sg13cmos5l_inv_1_17.Y vss 0.27462f ; **FLOATING
C5221 sg13cmos5l_inv_1_17.A vss 0.544445f ; **FLOATING
C5222 sg13cmos5l_inv_1_16.Y vss 0.332761f ; **FLOATING
C5223 quantizer2_lfsr_0.sg13cmos5l_dfrbpq_1_5.Q vss 0.57751f ; **FLOATING
C5224 sg13cmos5l_inv_1_16.A vss 0.120751f ; **FLOATING
C5225 sg13cmos5l_inv_1_15.Y vss 0.3734f ; **FLOATING
C5226 a_1286_14615# vss 0.44163f ; **FLOATING
C5227 quantizer2_lfsr_0.sg13cmos5l_dfrbpq_1_6.Q vss 0.31616f ; **FLOATING
C5228 a_2074_14933# vss 0.09562f ; **FLOATING
C5229 a_1324_13764# vss 1.00723f ; **FLOATING
C5230 a_537_14181# vss 0.46298f ; **FLOATING
C5231 a_1322_14546# vss 0.19317f ; **FLOATING
C5232 a_2038_15217# vss 0.20687f ; **FLOATING
C5233 quantizer2_lfsr_0.sg13cmos5l_dfrbpq_1_0.D vss 0.465625f ; **FLOATING
C5234 a_1681_14929# vss 0.06833f ; **FLOATING
C5235 a_533_15104# vss 0.19654f ; **FLOATING
C5236 a_522_15144# vss 1.00859f ; **FLOATING
C5237 a_558_15246# vss 0.06776f ; **FLOATING
C5238 a_15491_15614# vss 0.18192f ; **FLOATING
C5239 sg13cmos5l_nor2_2_0.B vss 0.483909f ; **FLOATING
C5240 sg13cmos5l_inv_1_20.Y vss 0.185339f ; **FLOATING
C5241 sg13cmos5l_inv_1_13.Y vss 0.246969f ; **FLOATING
C5242 a_13594_16020# vss 0.01024f ; **FLOATING
C5243 a_12800_15736# vss 0.04632f
C5244 sg13cmos5l_inv_1_9.Y vss 0.476134f ; **FLOATING
C5245 sg13cmos5l_nand2_2_0.B vss 0.295787f ; **FLOATING
C5246 sg13cmos5l_nand2_1_2.Y vss 0.477968f ; **FLOATING
C5247 sg13cmos5l_inv_1_10.Y vss 0.52551f ; **FLOATING
C5248 sg13cmos5l_inv_1_13.A vss 0.201569f ; **FLOATING
C5249 sg13cmos5l_inv_1_7.Y vss 0.34814f ; **FLOATING
C5250 sg13cmos5l_inv_1_5.Y vss 0.35282f ; **FLOATING
C5251 sg13cmos5l_and2_1_2.X vss 0.29352f ; **FLOATING
C5252 a_10989_15998# vss 0.10272f ; **FLOATING
C5253 a_10592_15909# vss 0.10262f ; **FLOATING
C5254 a_8905_15998# vss 0.01379f ; **FLOATING
C5255 sg13cmos5l_inv_1_12.A vss 0.24727f ; **FLOATING
C5256 sg13cmos5l_inv_1_12.Y vss 0.32203f ; **FLOATING
C5257 sg13cmos5l_inv_1_11.Y vss 0.32023f ; **FLOATING
C5258 sg13cmos5l_and2_1_4.X vss 0.10207f ; **FLOATING
C5259 a_8768_15909# vss 0.30646f ; **FLOATING
C5260 sg13cmos5l_or2_1_0.X vss 0.791173f ; **FLOATING
C5261 sg13cmos5l_inv_1_3.Y vss 0.443138f ; **FLOATING
C5262 a_1407_15314# vss 0.1525f ; **FLOATING
C5263 inv_en_0.di_b vss 0.782825f ; **FLOATING
C5264 a_1284_15759# vss 0.27278f ; **FLOATING
C5265 a_522_15314# vss 0.1535f ; **FLOATING
C5266 sg13cmos5l_inv_2_4.Y vss 0.77366f ; **FLOATING
C5267 a_8208_15626# vss 0.29843f ; **FLOATING
C5268 sg13cmos5l_and2_1_5.X vss 0.438318f ; **FLOATING
C5269 sg13cmos5l_inv_1_19.Y vss 0.371637f ; **FLOATING
C5270 sg13cmos5l_inv_1_3.A vss 0.793595f ; **FLOATING
C5271 a_7437_15998# vss 0.09975f ; **FLOATING
C5272 sg13cmos5l_inv_1_4.Y vss 0.15339f ; **FLOATING
C5273 sg13cmos5l_inv_1_6.Y vss 0.220441f ; **FLOATING
C5274 inv_en_0.di vss 0.61133f ; **FLOATING
C5275 a_522_15478# vss 0.27908f ; **FLOATING
C5276 a_1284_15861# vss 0.19851f ; **FLOATING
C5277 a_522_15861# vss 0.19919f ; **FLOATING
C5278 sg13cmos5l_nor2_1_0.Y vss 1.36483f ; **FLOATING
C5279 sg13cmos5l_inv_1_4.A vss 0.510851f ; **FLOATING
C5280 sg13cmos5l_inv_1_8.Y vss 0.25462f ; **FLOATING
C5281 sg13cmos5l_inv_1_6.A vss 0.388835f ; **FLOATING
C5282 sg13cmos5l_nand2_1_5.A vss 0.340732f ; **FLOATING
C5283 quantizer2_lfsr_0.sg13cmos5l_dfrbpq_1_13.D vss 0.242057f ; **FLOATING
C5284 quantizer2_lfsr_0.sg13cmos5l_dfrbpq_1_1.D vss 0.249717f ; **FLOATING
C5285 quantizer2_lfsr_0.sg13cmos5l_dfrbpq_1_13.Q vss 0.28502f ; **FLOATING
C5286 a_1690_16373# vss 0.09542f ; **FLOATING
C5287 quantizer2_lfsr_0.sg13cmos5l_dfrbpq_1_1.Q vss 0.28892f ; **FLOATING
C5288 quantizer2_lfsr_0.sg13cmos5l_nor2_1_0.A vss 0.45577f ; **FLOATING
C5289 a_1284_16630# vss 0.20231f ; **FLOATING
C5290 quantizer2_lfsr_0.sg13cmos5l_dfrbpq_1_2.D vss 0.54674f ; **FLOATING
C5291 a_562_16373# vss 0.09483f ; **FLOATING
C5292 a_526_16657# vss 0.20335f ; **FLOATING
C5293 a_21252_3394# vss 2.60726f ; **FLOATING
C5294 quantizer2_lfsr_0.sg13cmos5l_dfrbpq_1_11.D vss 0.408734f ; **FLOATING
C5295 dsm2_osc_0.d_btest_or vss 15.6459f ; **FLOATING
C5296 quantizer2_lfsr_0.sg13cmos5l_nor2_1_1.B vss 0.62326f ; **FLOATING
C5297 a_19904_17646# vss 3.0691f ; **FLOATING
C5298 a_19984_17824# vss 22.5186f ; **FLOATING
C5299 bias_gm_0.bias_trim_0.vz vss 0.392377f ; **FLOATING
C5300 sw_tgate_8.m vss 0.297828f ; **FLOATING
C5301 xsc_vc1l_n vss 3.63746f ; **FLOATING
C5302 sw_tgate_6.p vss 0.0327023f ; **FLOATING
C5303 sw_tgate_12.m vss 0.0802288f ; **FLOATING
C5304 xsc_vc1l_p vss 3.64326f ; **FLOATING
C5305 sw_tgate_10.p vss 0.414739f ; **FLOATING
C5306 a_2208_17741# vss 0.11915f
C5307 dsm2_io_vcmg_0.di_vcm_ext vss 2.50147f ; **FLOATING
C5308 dsm2_io_vcmg_0.di_vcm_ext_b vss 1.77879f ; **FLOATING
C5309 a_19964_18216# vss 3.95038f ; **FLOATING
C5310 a_20260_17236# vss 8.79015f ; **FLOATING
C5311 a_24540_19480# vss 1.38817f ; **FLOATING
C5312 a_24258_19480# vss 1.39471f ; **FLOATING
C5313 a_28126_19620# vss 1.48043f ; **FLOATING
C5314 a_20672_19620# vss 1.45997f ; **FLOATING
C5315 a_24540_19760# vss 1.27042f ; **FLOATING
C5316 a_24258_19760# vss 1.30348f ; **FLOATING
C5317 a_28126_19900# vss 1.39147f ; **FLOATING
C5318 a_20672_19900# vss 1.43014f ; **FLOATING
C5319 a_24540_20040# vss 1.24482f ; **FLOATING
C5320 a_24258_20040# vss 1.28181f ; **FLOATING
C5321 a_28126_20180# vss 1.37412f ; **FLOATING
C5322 a_20672_20180# vss 1.41676f ; **FLOATING
C5323 a_24540_20320# vss 1.23366f ; **FLOATING
C5324 a_24258_20320# vss 1.27224f ; **FLOATING
C5325 a_28126_20460# vss 1.36602f ; **FLOATING
C5326 a_20672_20460# vss 1.41027f ; **FLOATING
C5327 a_24540_20600# vss 1.22772f ; **FLOATING
C5328 a_24258_20600# vss 1.26706f ; **FLOATING
C5329 a_28126_20740# vss 1.36517f ; **FLOATING
C5330 a_20672_20740# vss 1.40994f ; **FLOATING
C5331 a_24540_20880# vss 1.22956f ; **FLOATING
C5332 a_24258_20880# vss 1.26907f ; **FLOATING
C5333 a_28126_21020# vss 1.36341f ; **FLOATING
C5334 a_20672_21020# vss 1.40901f ; **FLOATING
C5335 a_24540_21160# vss 1.22992f ; **FLOATING
C5336 a_24258_21160# vss 1.26972f ; **FLOATING
C5337 a_28126_21300# vss 1.36849f ; **FLOATING
C5338 a_20672_21300# vss 1.41393f ; **FLOATING
C5339 a_24540_21440# vss 1.23732f ; **FLOATING
C5340 a_24258_21440# vss 1.27657f ; **FLOATING
C5341 a_28126_21580# vss 1.38041f ; **FLOATING
C5342 a_20672_21580# vss 1.4251f ; **FLOATING
C5343 a_24540_21720# vss 1.25612f ; **FLOATING
C5344 a_24258_21720# vss 1.29427f ; **FLOATING
C5345 a_28126_21860# vss 1.40657f ; **FLOATING
C5346 a_20672_21860# vss 1.44955f ; **FLOATING
C5347 a_24540_22000# vss 1.29417f ; **FLOATING
C5348 a_24258_22000# vss 1.32977f ; **FLOATING
C5349 a_28126_22140# vss 1.50294f ; **FLOATING
C5350 a_24258_22280# vss 1.53949f ; **FLOATING
C5351 a_20672_22140# vss 1.54264f ; **FLOATING
C5352 a_22252_11246# vss 9.36071f ; **FLOATING
C5353 a_24258_22824# vss 1.06978f ; **FLOATING
C5354 a_24258_22964# vss 1.1141f ; **FLOATING
C5355 a_21977_22824# vss 1.19143f ; **FLOATING
C5356 a_2208_18213# vss 0.04733f
C5357 dsm2_io_0.sg13cmos5l_inv_1_1.A vss 0.58926f ; **FLOATING
C5358 a_2208_18597# vss 0.04528f
C5359 a_2208_18981# vss 0.03813f
C5360 a_2208_19085# vss 0.08862f
C5361 dsm2_io_0.sg13cmos5l_inv_1_6.A vss 0.60167f ; **FLOATING
C5362 a_2208_19557# vss 0.03908f
C5363 dsm2_io_0.sg13cmos5l_inv_1_0.A vss 0.59511f ; **FLOATING
C5364 a_2208_19661# vss 0.08688f
C5365 quantizer2_lfsr_0.di_dith_amp[1] vss 1.03733f ; **FLOATING
C5366 a_2208_20141# vss 0.09035f
C5367 dsm2_io_0.sg13cmos5l_inv_1_3.A vss 0.58641f ; **FLOATING
C5368 quantizer2_lfsr_0.di_dith_amp[0] vss 1.0273f ; **FLOATING
C5369 a_2208_20613# vss 0.03805f
C5370 a_2208_20717# vss 0.08945f
C5371 dsm2_io_0.sg13cmos5l_inv_1_4.A vss 0.59572f ; **FLOATING
C5372 dsm2_io_0.do_btest_en vss 6.257f ; **FLOATING
C5373 a_2208_21189# vss 0.03974f
C5374 dsm2_io_0.sg13cmos5l_inv_1_5.A vss 0.58904f ; **FLOATING
C5375 a_2208_21293# vss 0.08401f
C5376 a_2208_21485# vss 0.41659f
C5377 dsm2_io_0.do_trim_b[3] vss 14.5294f ; **FLOATING
C5378 a_2208_22253# vss 0.42905f
C5379 dsm2_io_0.do_trim_b[2] vss 8.90877f ; **FLOATING
C5380 dsm2_io_0.do_trim_b[1] vss 5.84009f ; **FLOATING
C5381 a_2208_23021# vss 0.42834f
C5382 dsm2_io_0.do_trim_b[0] vss 5.94872f ; **FLOATING
C5383 a_2208_23789# vss 0.41801f
C5384 a_2208_24557# vss 0.39633f
C5385 a_2208_25325# vss 0.3988f
C5386 xsc_xcmfb1_vsw_vbias vss 8.63708f ; **FLOATING
C5387 a_2208_26093# vss 0.39927f
C5388 a_670_25288# vss 0.04437f ; **FLOATING
C5389 a_1502_26288# vss 0.02064f ; **FLOATING
C5390 sw_tgate_9.gb vss 4.14134f ; **FLOATING
C5391 a_2208_26861# vss 0.39817f
C5392 xsc_xcmfb1_vsw_cm_n vss 2.68248f ; **FLOATING
C5393 xsc_vc1r_n vss 3.39235f ; **FLOATING
C5394 sw_tgate_cmfb2_1.gb vss 1.15679f ; **FLOATING
C5395 xsc_vc1r_p vss 3.43935f ; **FLOATING
C5396 xsc_xcmfb1_vsw_cm_p vss 2.67988f ; **FLOATING
C5397 a_2208_27629# vss 0.38663f
C5398 sw_tgate_11.gb vss 3.98104f ; **FLOATING
C5399 sw_tgate_cmfb2_3.gb vss 1.12504f ; **FLOATING
C5400 a_2208_28397# vss 0.40171f
C5401 a_1502_28364# vss 0.05667f ; **FLOATING
C5402 dsm2_io_0.dsm2_io_rx_9.di_b vss 1.14663f ; **FLOATING
C5403 xsc_vvg_n vss 17.1472f ; **FLOATING
C5404 xsc_vvg_p vss 16.983f ; **FLOATING
C5405 xsc_vfb vss 8.73596f ; **FLOATING
C5406 a_13189_30111# vss 0.71286f ; **FLOATING
C5407 sw_tgate_cmfb2_1.p vss 10.9711f ; **FLOATING
C5408 a_5176_30111# vss 20.2198f ; **FLOATING
C5409 a_7224_31505# vss 0.08965f ; **FLOATING
C5410 a_12445_30191# vss 0.96495f ; **FLOATING
C5411 a_5176_31469# vss 0.58635f ; **FLOATING
C5412 a_5176_31117# vss 1.96345f ; **FLOATING
C5413 a_6817_30111# vss 3.95078f ; **FLOATING
C5414 a_2208_29165# vss 0.4002f
C5415 a_2208_29933# vss 0.39516f
C5416 a_2208_30701# vss 0.41661f
C5417 a_2208_31469# vss 0.41941f
C5418 a_2208_32237# vss 0.47868f
C5419 a_20328_23820# vss 237.29f ; **FLOATING
C5456 a_6452_29739.n0 vss 0.280089f ; **FLOATING
C5457 a_6452_29739.t7 vss 0.00686622f ; **FLOATING
C5458 a_6452_29739.t8 vss 0.00700208f ; **FLOATING
C5459 a_6452_29739.n1 vss 0.065984f ; **FLOATING
C5460 a_6452_29739.t5 vss 0.00707532f ; **FLOATING
C5461 a_6452_29739.t6 vss 0.00683786f ; **FLOATING
C5462 a_6452_29739.n2 vss 0.055596f ; **FLOATING
C5463 a_6452_29739.t0 vss 0.0173109f ; **FLOATING
C5464 a_6452_29739.t1 vss 0.0138411f ; **FLOATING
C5465 a_6452_29739.n3 vss 0.138265f ; **FLOATING
C5466 a_6452_29739.t2 vss 0.0131217f ; **FLOATING
C5467 a_6452_29739.n4 vss 0.10439f ; **FLOATING
C5468 a_6452_29739.n5 vss 0.209969f ; **FLOATING
C5469 a_6452_29739.t3 vss 0.0492496f ; **FLOATING
C5470 a_6452_29739.t4 vss 0.0491929f ; **FLOATING
C5471 a_7804_29739.n0 vss 0.285831f ; **FLOATING
C5472 a_7804_29739.t7 vss 0.00714105f ; **FLOATING
C5473 a_7804_29739.t8 vss 0.00699679f ; **FLOATING
C5474 a_7804_29739.n1 vss 0.0520311f ; **FLOATING
C5475 a_7804_29739.t4 vss 0.0177108f ; **FLOATING
C5476 a_7804_29739.t3 vss 0.0141619f ; **FLOATING
C5477 a_7804_29739.n2 vss 0.141467f ; **FLOATING
C5478 a_7804_29739.t2 vss 0.0134249f ; **FLOATING
C5479 a_7804_29739.n3 vss 0.106807f ; **FLOATING
C5480 a_7804_29739.t1 vss 0.0503889f ; **FLOATING
C5481 a_7804_29739.t5 vss 0.00702805f ; **FLOATING
C5482 a_7804_29739.t6 vss 0.00710619f ; **FLOATING
C5483 a_7804_29739.n4 vss 0.0551063f ; **FLOATING
C5484 a_7804_29739.n5 vss 0.255477f ; **FLOATING
C5485 a_7804_29739.t0 vss 0.0503324f ; **FLOATING
C5486 sw_tgate_cmfb2_1.p.n0 vss 0.11599f ; **FLOATING
C5487 sw_tgate_cmfb2_1.p.n1 vss 0.190931f ; **FLOATING
C5488 sw_tgate_cmfb2_1.p.n2 vss 0.286291f ; **FLOATING
C5489 sw_tgate_cmfb2_1.p.t6 vss 0.0290353f ; **FLOATING
C5490 sw_tgate_cmfb2_1.p.t8 vss 0.425479f ; **FLOATING
C5491 sw_tgate_cmfb2_1.p.t7 vss 1.48799f ; **FLOATING
C5492 sw_tgate_cmfb2_1.p.n3 vss 0.196622f ; **FLOATING
C5493 sw_tgate_cmfb2_1.p.t13 vss 0.283634f ; **FLOATING
C5494 sw_tgate_cmfb2_1.p.n4 vss 0.376695f ; **FLOATING
C5495 sw_tgate_cmfb2_1.p.t9 vss 0.449319f ; **FLOATING
C5496 sw_tgate_cmfb2_1.p.n5 vss 0.35018f ; **FLOATING
C5497 sw_tgate_cmfb2_1.p.t11 vss 0.449319f ; **FLOATING
C5498 sw_tgate_cmfb2_1.p.n6 vss 0.345739f ; **FLOATING
C5499 sw_tgate_cmfb2_1.p.t0 vss 0.256845f ; **FLOATING
C5500 sw_tgate_cmfb2_1.p.t1 vss 0.027346f ; **FLOATING
C5501 sw_tgate_cmfb2_1.p.t12 vss 0.425479f ; **FLOATING
C5502 sw_tgate_cmfb2_1.p.t10 vss 1.48799f ; **FLOATING
C5503 sw_tgate_cmfb2_1.p.n7 vss 0.134366f ; **FLOATING
C5504 sw_tgate_cmfb2_1.p.n8 vss 0.197991f ; **FLOATING
C5505 sw_tgate_cmfb2_1.p.t3 vss 0.0421775f ; **FLOATING
C5506 sw_tgate_cmfb2_1.p.t4 vss 0.0140576f ; **FLOATING
C5507 sw_tgate_cmfb2_1.p.t5 vss 0.0147182f ; **FLOATING
C5508 sw_tgate_cmfb2_1.p.t2 vss 0.0466982f ; **FLOATING
C5509 xsc_vfb.n0 vss 0.104622f ; **FLOATING
C5510 xsc_vfb.n1 vss 0.110312f ; **FLOATING
C5511 xsc_vfb.t6 vss 0.010514f ; **FLOATING
C5512 xsc_vfb.n2 vss 0.258675f ; **FLOATING
C5513 xsc_vfb.n3 vss 1.70748f ; **FLOATING
C5514 xsc_vfb.t8 vss 0.0188559f ; **FLOATING
C5515 xsc_vfb.t11 vss 1.28517f ; **FLOATING
C5516 xsc_vfb.t12 vss 1.38713f ; **FLOATING
C5517 xsc_vfb.n4 vss 0.584121f ; **FLOATING
C5518 xsc_vfb.n5 vss 0.134245f ; **FLOATING
C5519 xsc_vfb.n6 vss 0.560993f ; **FLOATING
C5520 xsc_vfb.n7 vss 0.38435f ; **FLOATING
C5521 xsc_vfb.n8 vss 1.8818f ; **FLOATING
C5522 xsc_vfb.n9 vss 1.59754f ; **FLOATING
C5523 xsc_vfb.n10 vss 0.262311f ; **FLOATING
C5524 xsc_vfb.t5 vss 0.0310265f ; **FLOATING
C5525 xsc_vfb.t10 vss 0.0301779f ; **FLOATING
C5526 xsc_vfb.t2 vss 0.00945542f ; **FLOATING
C5527 xsc_vfb.t3 vss 0.010055f ; **FLOATING
C5528 xsc_vfb.n11 vss 0.0961887f ; **FLOATING
C5529 xsc_vfb.t4 vss 0.0333582f ; **FLOATING
C5530 xsc_vfb.t0 vss 0.0100596f ; **FLOATING
C5531 xsc_vfb.t1 vss 0.00945542f ; **FLOATING
C5532 xsc_vfb.t7 vss 0.0309974f ; **FLOATING
C5533 xsc_vfb.t9 vss 0.0301565f ; **FLOATING
C5534 xsc_vvg_p.n0 vss 0.0227887f ; **FLOATING
C5535 xsc_vvg_p.n1 vss 0.0575952f ; **FLOATING
C5536 xsc_vvg_p.n2 vss 0.0160897f ; **FLOATING
C5537 xsc_vvg_p.n3 vss 0.045085f ; **FLOATING
C5538 xsc_vvg_p.t6 vss 0.809867f ; **FLOATING
C5539 xsc_vvg_p.n4 vss 0.263785f ; **FLOATING
C5540 xsc_vvg_p.n5 vss 0.262726f ; **FLOATING
C5541 xsc_vvg_p.n6 vss 1.93706f ; **FLOATING
C5542 xsc_vvg_p.n7 vss 1.64312f ; **FLOATING
C5543 xsc_vvg_p.n8 vss 1.3779f ; **FLOATING
C5544 xsc_vvg_p.n9 vss 0.672555f ; **FLOATING
C5545 xsc_vvg_p.n10 vss 0.405807f ; **FLOATING
C5546 xsc_vvg_p.n11 vss 0.262726f ; **FLOATING
C5547 xsc_vvg_p.n12 vss 1.93706f ; **FLOATING
C5548 xsc_vvg_p.n13 vss 1.64312f ; **FLOATING
C5549 xsc_vvg_p.n14 vss 1.3779f ; **FLOATING
C5550 xsc_vvg_p.n15 vss 0.672555f ; **FLOATING
C5551 xsc_vvg_p.n16 vss 0.495218f ; **FLOATING
C5552 xsc_vvg_p.n17 vss 0.46445f ; **FLOATING
C5553 xsc_vvg_p.n18 vss 0.331367f ; **FLOATING
C5554 xsc_vvg_p.t0 vss 0.0520929f ; **FLOATING
C5555 xsc_vvg_p.t1 vss 0.0433153f ; **FLOATING
C5556 xsc_vvg_p.t3 vss 0.0210887f ; **FLOATING
C5557 xsc_vvg_p.n19 vss 0.066037f ; **FLOATING
C5558 xsc_vvg_p.t5 vss 0.0443319f ; **FLOATING
C5559 xsc_vvg_p.t2 vss 0.024908f ; **FLOATING
C5560 xsc_vvg_p.t4 vss 0.0207311f ; **FLOATING
C5561 xsc_vvg_n.n0 vss 0.0388344f ; **FLOATING
C5562 xsc_vvg_n.n1 vss 0.0456137f ; **FLOATING
C5563 xsc_vvg_n.n2 vss 0.0582389f ; **FLOATING
C5564 xsc_vvg_n.n3 vss 0.0162748f ; **FLOATING
C5565 xsc_vvg_n.t5 vss 0.0448414f ; **FLOATING
C5566 xsc_vvg_n.t4 vss 0.0209697f ; **FLOATING
C5567 xsc_vvg_n.t3 vss 0.0251852f ; **FLOATING
C5568 xsc_vvg_n.t1 vss 0.0527147f ; **FLOATING
C5569 xsc_vvg_n.t0 vss 0.0438105f ; **FLOATING
C5570 xsc_vvg_n.t2 vss 0.0213318f ; **FLOATING
C5571 xsc_vvg_n.n4 vss 0.109248f ; **FLOATING
C5572 xsc_vvg_n.t6 vss 0.819185f ; **FLOATING
C5573 xsc_vvg_n.n5 vss 0.272392f ; **FLOATING
C5574 xsc_vvg_n.n6 vss 0.265535f ; **FLOATING
C5575 xsc_vvg_n.n7 vss 1.95981f ; **FLOATING
C5576 xsc_vvg_n.n8 vss 1.66324f ; **FLOATING
C5577 xsc_vvg_n.n9 vss 1.39336f ; **FLOATING
C5578 xsc_vvg_n.n10 vss 0.679738f ; **FLOATING
C5579 xsc_vvg_n.n11 vss 0.479787f ; **FLOATING
C5580 xsc_vvg_n.n12 vss 0.265535f ; **FLOATING
C5581 xsc_vvg_n.n13 vss 1.95981f ; **FLOATING
C5582 xsc_vvg_n.n14 vss 1.66324f ; **FLOATING
C5583 xsc_vvg_n.n15 vss 1.39336f ; **FLOATING
C5584 xsc_vvg_n.n16 vss 0.679738f ; **FLOATING
C5585 xsc_vvg_n.n17 vss 0.393666f ; **FLOATING
C5586 xsc_vvg_n.n18 vss 0.459023f ; **FLOATING
C5587 xsc_vvg_n.n19 vss 0.349f ; **FLOATING
C5588 dsm2_io_0.dsm2_io_rx_9.di_b.t1 vss 0.0167513f ; **FLOATING
C5589 dsm2_io_0.dsm2_io_rx_9.di_b.t3 vss 0.135938f ; **FLOATING
C5590 dsm2_io_0.dsm2_io_rx_9.di_b.t2 vss 0.0757324f ; **FLOATING
C5591 dsm2_io_0.dsm2_io_rx_9.di_b.n0 vss 0.466117f ; **FLOATING
C5592 dsm2_io_0.dsm2_io_rx_9.di_b.t0 vss 0.0382681f ; **FLOATING
C5593 sw_tgate_cmfb2_3.gb.n0 vss 0.0397465f ; **FLOATING
C5594 sw_tgate_cmfb2_3.gb.t3 vss 0.477418f ; **FLOATING
C5595 sw_tgate_cmfb2_3.gb.t2 vss 0.477568f ; **FLOATING
C5596 sw_tgate_cmfb2_3.gb.n1 vss 0.300266f ; **FLOATING
C5597 sw_tgate_cmfb2_3.gb.t4 vss 0.477418f ; **FLOATING
C5598 sw_tgate_cmfb2_3.gb.n2 vss 0.328234f ; **FLOATING
C5599 sw_tgate_cmfb2_3.gb.t0 vss 0.0231271f ; **FLOATING
C5600 sw_tgate_cmfb2_3.gb.t1 vss 0.0418919f ; **FLOATING
C5601 sw_tgate_11.gb.t5 vss 0.975923f ; **FLOATING
C5602 sw_tgate_11.gb.t6 vss 0.975923f ; **FLOATING
C5603 sw_tgate_11.gb.n0 vss 0.301408f ; **FLOATING
C5604 sw_tgate_11.gb.t2 vss 0.975923f ; **FLOATING
C5605 sw_tgate_11.gb.t3 vss 0.975923f ; **FLOATING
C5606 sw_tgate_11.gb.n1 vss 0.727748f ; **FLOATING
C5607 sw_tgate_11.gb.t4 vss 0.975923f ; **FLOATING
C5608 sw_tgate_11.gb.n2 vss 1.37771f ; **FLOATING
C5609 sw_tgate_11.gb.n3 vss 0.815641f ; **FLOATING
C5610 sw_tgate_11.gb.t1 vss 0.0681655f ; **FLOATING
C5611 sw_tgate_11.gb.t0 vss 0.0382642f ; **FLOATING
C5612 sw_tgate_11.gb.n4 vss 0.0632045f ; **FLOATING
C5613 xsc_xcmfb1_vsw_cm_p.n0 vss 0.119303f ; **FLOATING
C5614 xsc_xcmfb1_vsw_cm_p.n1 vss 0.101064f ; **FLOATING
C5615 xsc_xcmfb1_vsw_cm_p.t3 vss 0.0322114f ; **FLOATING
C5616 xsc_xcmfb1_vsw_cm_p.n2 vss 0.648756f ; **FLOATING
C5617 xsc_xcmfb1_vsw_cm_p.t11 vss 0.029145f ; **FLOATING
C5618 xsc_xcmfb1_vsw_cm_p.t8 vss 0.0097129f ; **FLOATING
C5619 xsc_xcmfb1_vsw_cm_p.t9 vss 0.0101693f ; **FLOATING
C5620 xsc_xcmfb1_vsw_cm_p.n3 vss 0.0311283f ; **FLOATING
C5621 xsc_xcmfb1_vsw_cm_p.t10 vss 0.0322678f ; **FLOATING
C5622 xsc_xcmfb1_vsw_cm_p.n4 vss 0.035059f ; **FLOATING
C5623 xsc_xcmfb1_vsw_cm_p.n5 vss 0.0139572f ; **FLOATING
C5624 xsc_xcmfb1_vsw_cm_p.n6 vss 0.0859245f ; **FLOATING
C5625 xsc_xcmfb1_vsw_cm_p.n7 vss 0.31479f ; **FLOATING
C5626 xsc_xcmfb1_vsw_cm_p.n8 vss 0.185277f ; **FLOATING
C5627 xsc_xcmfb1_vsw_cm_p.t0 vss 0.0101584f ; **FLOATING
C5628 xsc_xcmfb1_vsw_cm_p.t7 vss 0.0299778f ; **FLOATING
C5629 xsc_xcmfb1_vsw_cm_p.t12 vss 0.0291418f ; **FLOATING
C5630 xsc_xcmfb1_vsw_cm_p.t5 vss 0.0097129f ; **FLOATING
C5631 xsc_xcmfb1_vsw_cm_p.t4 vss 0.00913099f ; **FLOATING
C5632 xsc_xcmfb1_vsw_cm_p.t1 vss 0.00971682f ; **FLOATING
C5633 xsc_xcmfb1_vsw_cm_p.t6 vss 0.00913648f ; **FLOATING
C5634 xsc_xcmfb1_vsw_cm_p.t13 vss 0.0291426f ; **FLOATING
C5635 xsc_xcmfb1_vsw_cm_p.t2 vss 0.0299433f ; **FLOATING
C5636 xsc_vc1r_p.n0 vss 0.0719267f ; **FLOATING
C5637 xsc_vc1r_p.n1 vss 0.0719254f ; **FLOATING
C5638 xsc_vc1r_p.t1 vss 0.0304843f ; **FLOATING
C5639 xsc_vc1r_p.t0 vss 0.0153927f ; **FLOATING
C5640 xsc_vc1r_p.t3 vss 0.0166171f ; **FLOATING
C5641 xsc_vc1r_p.t2 vss 0.0347626f ; **FLOATING
C5642 xsc_vc1r_p.t5 vss 0.0153927f ; **FLOATING
C5643 xsc_vc1r_p.t4 vss 0.0166171f ; **FLOATING
C5644 xsc_vc1r_p.t7 vss 0.0347626f ; **FLOATING
C5645 xsc_vc1r_p.t6 vss 0.0304848f ; **FLOATING
C5646 xsc_vc1r_p.n2 vss 0.61168f ; **FLOATING
C5647 xsc_vc1r_p.n3 vss 0.12764f ; **FLOATING
C5648 sw_tgate_cmfb2_1.gb.n0 vss 0.0413998f ; **FLOATING
C5649 sw_tgate_cmfb2_1.gb.t3 vss 0.497273f ; **FLOATING
C5650 sw_tgate_cmfb2_1.gb.t4 vss 0.497273f ; **FLOATING
C5651 sw_tgate_cmfb2_1.gb.t2 vss 0.497273f ; **FLOATING
C5652 sw_tgate_cmfb2_1.gb.n1 vss 0.29389f ; **FLOATING
C5653 sw_tgate_cmfb2_1.gb.n2 vss 0.338179f ; **FLOATING
C5654 sw_tgate_cmfb2_1.gb.t0 vss 0.0240891f ; **FLOATING
C5655 sw_tgate_cmfb2_1.gb.t1 vss 0.043636f ; **FLOATING
C5656 xsc_vc1r_n.n0 vss 0.0708798f ; **FLOATING
C5657 xsc_vc1r_n.n1 vss 0.0708811f ; **FLOATING
C5658 xsc_vc1r_n.t7 vss 0.0151688f ; **FLOATING
C5659 xsc_vc1r_n.t6 vss 0.0163754f ; **FLOATING
C5660 xsc_vc1r_n.t4 vss 0.0342565f ; **FLOATING
C5661 xsc_vc1r_n.t5 vss 0.0300413f ; **FLOATING
C5662 xsc_vc1r_n.n2 vss 0.605706f ; **FLOATING
C5663 xsc_vc1r_n.n3 vss 0.122315f ; **FLOATING
C5664 xsc_vc1r_n.t1 vss 0.0151688f ; **FLOATING
C5665 xsc_vc1r_n.t0 vss 0.0163754f ; **FLOATING
C5666 xsc_vc1r_n.t2 vss 0.0342547f ; **FLOATING
C5667 xsc_vc1r_n.t3 vss 0.0300409f ; **FLOATING
C5668 xsc_xcmfb1_vsw_cm_n.n0 vss 0.100746f ; **FLOATING
C5669 xsc_xcmfb1_vsw_cm_n.n1 vss 0.106229f ; **FLOATING
C5670 xsc_xcmfb1_vsw_cm_n.t1 vss 0.0101248f ; **FLOATING
C5671 xsc_xcmfb1_vsw_cm_n.t3 vss 0.0321232f ; **FLOATING
C5672 xsc_xcmfb1_vsw_cm_n.t4 vss 0.00910541f ; **FLOATING
C5673 xsc_xcmfb1_vsw_cm_n.t0 vss 0.00968733f ; **FLOATING
C5674 xsc_xcmfb1_vsw_cm_n.t2 vss 0.0298501f ; **FLOATING
C5675 xsc_xcmfb1_vsw_cm_n.t12 vss 0.0290417f ; **FLOATING
C5676 xsc_xcmfb1_vsw_cm_n.n2 vss 0.646608f ; **FLOATING
C5677 xsc_xcmfb1_vsw_cm_n.t7 vss 0.029055f ; **FLOATING
C5678 xsc_xcmfb1_vsw_cm_n.t10 vss 0.00968265f ; **FLOATING
C5679 xsc_xcmfb1_vsw_cm_n.t9 vss 0.010138f ; **FLOATING
C5680 xsc_xcmfb1_vsw_cm_n.n3 vss 0.031032f ; **FLOATING
C5681 xsc_xcmfb1_vsw_cm_n.t8 vss 0.0321685f ; **FLOATING
C5682 xsc_xcmfb1_vsw_cm_n.n4 vss 0.03495f ; **FLOATING
C5683 xsc_xcmfb1_vsw_cm_n.n5 vss 0.0139139f ; **FLOATING
C5684 xsc_xcmfb1_vsw_cm_n.n6 vss 0.0860378f ; **FLOATING
C5685 xsc_xcmfb1_vsw_cm_n.n7 vss 0.313825f ; **FLOATING
C5686 xsc_xcmfb1_vsw_cm_n.n8 vss 0.184749f ; **FLOATING
C5687 xsc_xcmfb1_vsw_cm_n.t11 vss 0.0298814f ; **FLOATING
C5688 xsc_xcmfb1_vsw_cm_n.t13 vss 0.029062f ; **FLOATING
C5689 xsc_xcmfb1_vsw_cm_n.t6 vss 0.00910619f ; **FLOATING
C5690 xsc_xcmfb1_vsw_cm_n.t5 vss 0.00968265f ; **FLOATING
C5691 sw_tgate_9.gb.n0 vss 0.0655235f ; **FLOATING
C5692 sw_tgate_9.gb.t2 vss 0.988722f ; **FLOATING
C5693 sw_tgate_9.gb.t4 vss 0.988722f ; **FLOATING
C5694 sw_tgate_9.gb.t3 vss 0.988722f ; **FLOATING
C5695 sw_tgate_9.gb.n1 vss 0.751359f ; **FLOATING
C5696 sw_tgate_9.gb.n2 vss 1.37693f ; **FLOATING
C5697 sw_tgate_9.gb.t5 vss 0.988722f ; **FLOATING
C5698 sw_tgate_9.gb.t6 vss 0.988722f ; **FLOATING
C5699 sw_tgate_9.gb.n3 vss 0.920962f ; **FLOATING
C5700 sw_tgate_9.gb.t1 vss 0.0690596f ; **FLOATING
C5701 sw_tgate_9.gb.t0 vss 0.0381236f ; **FLOATING
C5702 xsc_xcmfb1_vsw_vbias.n0 vss 0.189534f ; **FLOATING
C5703 xsc_xcmfb1_vsw_vbias.n1 vss 0.159831f ; **FLOATING
C5704 xsc_xcmfb1_vsw_vbias.t2 vss 0.0509416f ; **FLOATING
C5705 xsc_xcmfb1_vsw_vbias.t3 vss 0.0153659f ; **FLOATING
C5706 xsc_xcmfb1_vsw_vbias.t6 vss 0.0144481f ; **FLOATING
C5707 xsc_xcmfb1_vsw_vbias.t13 vss 0.0460852f ; **FLOATING
C5708 xsc_xcmfb1_vsw_vbias.t1 vss 0.0473498f ; **FLOATING
C5709 xsc_xcmfb1_vsw_vbias.t0 vss 0.0160657f ; **FLOATING
C5710 xsc_xcmfb1_vsw_vbias.t12 vss 0.0460852f ; **FLOATING
C5711 xsc_xcmfb1_vsw_vbias.t11 vss 0.047409f ; **FLOATING
C5712 xsc_xcmfb1_vsw_vbias.t4 vss 0.0153609f ; **FLOATING
C5713 xsc_xcmfb1_vsw_vbias.t5 vss 0.0144406f ; **FLOATING
C5714 xsc_xcmfb1_vsw_vbias.n2 vss 1.01f ; **FLOATING
C5715 xsc_xcmfb1_vsw_vbias.n3 vss 0.947021f ; **FLOATING
C5716 xsc_xcmfb1_vsw_vbias.n4 vss 1.00327f ; **FLOATING
C5717 xsc_xcmfb1_vsw_vbias.t8 vss 0.0460915f ; **FLOATING
C5718 xsc_xcmfb1_vsw_vbias.t10 vss 0.0153609f ; **FLOATING
C5719 xsc_xcmfb1_vsw_vbias.t9 vss 0.0160821f ; **FLOATING
C5720 xsc_xcmfb1_vsw_vbias.n5 vss 0.0492283f ; **FLOATING
C5721 xsc_xcmfb1_vsw_vbias.t7 vss 0.0510299f ; **FLOATING
C5722 xsc_xcmfb1_vsw_vbias.n6 vss 0.0554437f ; **FLOATING
C5723 xsc_xcmfb1_vsw_vbias.n7 vss 0.0220718f ; **FLOATING
C5724 xsc_xcmfb1_vsw_vbias.n8 vss 0.5342f ; **FLOATING
C5725 xsc_xcmfb1_vsw_vbias.n9 vss 0.655814f ; **FLOATING
C5726 xsc_xcmfb1_vsw_vbias.n10 vss 0.947021f ; **FLOATING
C5727 xsc_xcmfb1_vsw_vbias.n11 vss 0.648664f ; **FLOATING
C5728 xsc_xcmfb1_vsw_vbias.n12 vss 0.525104f ; **FLOATING
C5729 dsm2_io_0.do_trim_b[0].t1 vss 0.0141088f ; **FLOATING
C5730 dsm2_io_0.do_trim_b[0].t3 vss 0.938147f ; **FLOATING
C5731 dsm2_io_0.do_trim_b[0].t2 vss 0.938147f ; **FLOATING
C5732 dsm2_io_0.do_trim_b[0].n0 vss 0.568605f ; **FLOATING
C5733 dsm2_io_0.do_trim_b[0].n1 vss 0.568605f ; **FLOATING
C5734 dsm2_io_0.do_trim_b[0].t0 vss 0.0298004f ; **FLOATING
C5735 dsm2_io_0.do_trim_b[0].n2 vss 0.129838f ; **FLOATING
C5736 dsm2_io_0.do_trim_b[1].t3 vss 0.969909f ; **FLOATING
C5737 dsm2_io_0.do_trim_b[1].t2 vss 0.969909f ; **FLOATING
C5738 dsm2_io_0.do_trim_b[1].n0 vss 0.592271f ; **FLOATING
C5739 dsm2_io_0.do_trim_b[1].n1 vss 0.592271f ; **FLOATING
C5740 dsm2_io_0.do_trim_b[1].t1 vss 0.0138989f ; **FLOATING
C5741 dsm2_io_0.do_trim_b[1].t0 vss 0.0293582f ; **FLOATING
C5742 dsm2_io_0.do_trim_b[1].n2 vss 0.127933f ; **FLOATING
C5743 dsm2_io_0.do_trim_b[2].t1 vss 0.0180113f ; **FLOATING
C5744 dsm2_io_0.do_trim_b[2].t5 vss 0.606224f ; **FLOATING
C5745 dsm2_io_0.do_trim_b[2].t4 vss 0.532908f ; **FLOATING
C5746 dsm2_io_0.do_trim_b[2].n0 vss 0.814699f ; **FLOATING
C5747 dsm2_io_0.do_trim_b[2].t3 vss 0.606224f ; **FLOATING
C5748 dsm2_io_0.do_trim_b[2].t2 vss 0.532908f ; **FLOATING
C5749 dsm2_io_0.do_trim_b[2].n1 vss 0.814699f ; **FLOATING
C5750 dsm2_io_0.do_trim_b[2].n2 vss 0.234175f ; **FLOATING
C5751 dsm2_io_0.do_trim_b[2].n3 vss 0.234175f ; **FLOATING
C5752 dsm2_io_0.do_trim_b[2].t0 vss 0.0380401f ; **FLOATING
C5753 dsm2_io_0.do_trim_b[2].n4 vss 0.165771f ; **FLOATING
C5754 dsm2_io_0.do_trim_b[3].t1 vss 0.025122f ; **FLOATING
C5755 dsm2_io_0.do_trim_b[3].t3 vss 1.64938f ; **FLOATING
C5756 dsm2_io_0.do_trim_b[3].t2 vss 1.64938f ; **FLOATING
C5757 dsm2_io_0.do_trim_b[3].n0 vss 0.882251f ; **FLOATING
C5758 dsm2_io_0.do_trim_b[3].n1 vss 0.882251f ; **FLOATING
C5759 dsm2_io_0.do_trim_b[3].t0 vss 0.0530605f ; **FLOATING
C5760 dsm2_io_0.do_trim_b[3].n2 vss 0.231439f ; **FLOATING
C5761 dsm2_io_0.do_btest_en.t2 vss 0.054482f ; **FLOATING
C5762 dsm2_io_0.do_btest_en.t0 vss 0.028505f ; **FLOATING
C5763 dsm2_io_0.do_btest_en.t1 vss 0.0431405f ; **FLOATING
C5764 quantizer2_lfsr_0.di_dith_amp[0].t0 vss 0.016478f ; **FLOATING
C5765 quantizer2_lfsr_0.di_dith_amp[0].t3 vss 0.0326807f ; **FLOATING
C5766 quantizer2_lfsr_0.di_dith_amp[0].t2 vss 0.0325928f ; **FLOATING
C5767 quantizer2_lfsr_0.di_dith_amp[0].n0 vss 0.0959446f ; **FLOATING
C5768 quantizer2_lfsr_0.di_dith_amp[0].t4 vss 0.0326807f ; **FLOATING
C5769 quantizer2_lfsr_0.di_dith_amp[0].t1 vss 0.0249402f ; **FLOATING
C5770 quantizer2_lfsr_0.di_dith_amp[1].t0 vss 0.0185774f ; **FLOATING
C5771 quantizer2_lfsr_0.di_dith_amp[1].t3 vss 0.0373302f ; **FLOATING
C5772 quantizer2_lfsr_0.di_dith_amp[1].t2 vss 0.0367435f ; **FLOATING
C5773 quantizer2_lfsr_0.di_dith_amp[1].t4 vss 0.0373302f ; **FLOATING
C5774 quantizer2_lfsr_0.di_dith_amp[1].t1 vss 0.0281167f ; **FLOATING
C5775 dsm2_io_vcmg_0.di_vcm_ext_b.t2 vss 0.0187241f ; **FLOATING
C5776 dsm2_io_vcmg_0.di_vcm_ext_b.t1 vss 0.0097173f ; **FLOATING
C5777 dsm2_io_vcmg_0.di_vcm_ext_b.t3 vss 0.0226269f ; **FLOATING
C5778 dsm2_io_vcmg_0.di_vcm_ext_b.n0 vss 0.0573997f ; **FLOATING
C5779 dsm2_io_vcmg_0.di_vcm_ext_b.t0 vss 0.0205248f ; **FLOATING
C5780 dsm2_io_vcmg_0.di_vcm_ext_b.n1 vss 0.0560875f ; **FLOATING
C5781 dsm2_io_vcmg_0.di_vcm_ext.t0 vss 0.0198468f ; **FLOATING
C5782 dsm2_io_vcmg_0.di_vcm_ext.t2 vss 0.0385774f ; **FLOATING
C5783 dsm2_io_vcmg_0.di_vcm_ext.t1 vss 0.0300375f ; **FLOATING
C5784 sw_tgate_10.p.t1 vss 0.018937f ; **FLOATING
C5785 sw_tgate_10.p.n0 vss 0.0517199f ; **FLOATING
C5786 sw_tgate_10.p.n1 vss 0.0267526f ; **FLOATING
C5787 sw_tgate_10.p.n2 vss 0.020464f ; **FLOATING
C5788 sw_tgate_10.p.n3 vss 0.0404873f ; **FLOATING
C5789 sw_tgate_10.p.t2 vss 0.0467803f ; **FLOATING
C5790 sw_tgate_10.p.t3 vss 0.0388979f ; **FLOATING
C5791 sw_tgate_10.p.t7 vss 0.0411284f ; **FLOATING
C5792 sw_tgate_10.p.t9 vss 0.0207668f ; **FLOATING
C5793 sw_tgate_10.p.t8 vss 0.0224185f ; **FLOATING
C5794 sw_tgate_10.p.n4 vss 0.0396815f ; **FLOATING
C5795 sw_tgate_10.p.t6 vss 0.0468983f ; **FLOATING
C5796 sw_tgate_10.p.n5 vss 0.0394922f ; **FLOATING
C5797 sw_tgate_10.p.n6 vss 0.0178662f ; **FLOATING
C5798 sw_tgate_10.p.n7 vss 0.0716964f ; **FLOATING
C5799 sw_tgate_10.p.t4 vss 0.0398106f ; **FLOATING
C5800 sw_tgate_10.p.t0 vss 0.0223673f ; **FLOATING
C5801 sw_tgate_10.p.t5 vss 0.0186164f ; **FLOATING
C5802 xsc_vc1l_p.n0 vss 0.0703531f ; **FLOATING
C5803 xsc_vc1l_p.n1 vss 0.070352f ; **FLOATING
C5804 xsc_vc1l_p.n2 vss 0.0703541f ; **FLOATING
C5805 xsc_vc1l_p.t1 vss 0.0298177f ; **FLOATING
C5806 xsc_vc1l_p.t6 vss 0.0150563f ; **FLOATING
C5807 xsc_vc1l_p.t7 vss 0.0162536f ; **FLOATING
C5808 xsc_vc1l_p.t0 vss 0.0340011f ; **FLOATING
C5809 xsc_vc1l_p.n3 vss 0.25915f ; **FLOATING
C5810 xsc_vc1l_p.t11 vss 0.0298177f ; **FLOATING
C5811 xsc_vc1l_p.t9 vss 0.0150563f ; **FLOATING
C5812 xsc_vc1l_p.t8 vss 0.0162536f ; **FLOATING
C5813 xsc_vc1l_p.t10 vss 0.0340021f ; **FLOATING
C5814 xsc_vc1l_p.n4 vss 0.0790462f ; **FLOATING
C5815 xsc_vc1l_p.n5 vss 0.299708f ; **FLOATING
C5816 xsc_vc1l_p.t4 vss 0.0150563f ; **FLOATING
C5817 xsc_vc1l_p.t5 vss 0.0162536f ; **FLOATING
C5818 xsc_vc1l_p.t2 vss 0.034f ; **FLOATING
C5819 xsc_vc1l_p.t3 vss 0.0298177f ; **FLOATING
C5820 sw_tgate_12.m.t2 vss 0.00579147f ; **FLOATING
C5821 sw_tgate_12.m.n0 vss 0.0158168f ; **FLOATING
C5822 sw_tgate_12.m.n1 vss 0.00818154f ; **FLOATING
C5823 sw_tgate_12.m.n2 vss 0.00625799f ; **FLOATING
C5824 sw_tgate_12.m.n3 vss 0.0123813f ; **FLOATING
C5825 sw_tgate_12.m.t0 vss 0.0143059f ; **FLOATING
C5826 sw_tgate_12.m.t1 vss 0.0118955f ; **FLOATING
C5827 sw_tgate_12.m.t5 vss 0.012578f ; **FLOATING
C5828 sw_tgate_12.m.t6 vss 0.006351f ; **FLOATING
C5829 sw_tgate_12.m.t7 vss 0.00685615f ; **FLOATING
C5830 sw_tgate_12.m.n4 vss 0.0121353f ; **FLOATING
C5831 sw_tgate_12.m.t4 vss 0.014343f ; **FLOATING
C5832 sw_tgate_12.m.n5 vss 0.0120774f ; **FLOATING
C5833 sw_tgate_12.m.n6 vss 0.00546418f ; **FLOATING
C5834 sw_tgate_12.m.n7 vss 0.033057f ; **FLOATING
C5835 sw_tgate_12.m.t8 vss 0.012175f ; **FLOATING
C5836 sw_tgate_12.m.t3 vss 0.00684039f ; **FLOATING
C5837 sw_tgate_12.m.t9 vss 0.00569338f ; **FLOATING
C5838 sw_tgate_6.p.t4 vss 0.00570664f ; **FLOATING
C5839 sw_tgate_6.p.n0 vss 0.0155804f ; **FLOATING
C5840 sw_tgate_6.p.n1 vss 0.00435372f ; **FLOATING
C5841 sw_tgate_6.p.n2 vss 0.00627157f ; **FLOATING
C5842 sw_tgate_6.p.n3 vss 0.0122028f ; **FLOATING
C5843 sw_tgate_6.p.t1 vss 0.0119962f ; **FLOATING
C5844 sw_tgate_6.p.t2 vss 0.00560983f ; **FLOATING
C5845 sw_tgate_6.p.t3 vss 0.00673768f ; **FLOATING
C5846 sw_tgate_6.p.t7 vss 0.0123934f ; **FLOATING
C5847 sw_tgate_6.p.t9 vss 0.00625809f ; **FLOATING
C5848 sw_tgate_6.p.t8 vss 0.00675565f ; **FLOATING
C5849 sw_tgate_6.p.n4 vss 0.0119572f ; **FLOATING
C5850 sw_tgate_6.p.t6 vss 0.0141326f ; **FLOATING
C5851 sw_tgate_6.p.n5 vss 0.0119004f ; **FLOATING
C5852 sw_tgate_6.p.n6 vss 0.00538376f ; **FLOATING
C5853 sw_tgate_6.p.n7 vss 0.0325725f ; **FLOATING
C5854 sw_tgate_6.p.n8 vss 0.049673f ; **FLOATING
C5855 sw_tgate_6.p.t0 vss 0.0141022f ; **FLOATING
C5856 sw_tgate_6.p.t5 vss 0.0117202f ; **FLOATING
C5857 xsc_vc1l_n.n0 vss 0.0702596f ; **FLOATING
C5858 xsc_vc1l_n.n1 vss 0.0702591f ; **FLOATING
C5859 xsc_vc1l_n.n2 vss 0.0702586f ; **FLOATING
C5860 xsc_vc1l_n.t7 vss 0.0297785f ; **FLOATING
C5861 xsc_vc1l_n.t5 vss 0.0150365f ; **FLOATING
C5862 xsc_vc1l_n.t4 vss 0.016232f ; **FLOATING
C5863 xsc_vc1l_n.t6 vss 0.0339571f ; **FLOATING
C5864 xsc_vc1l_n.n3 vss 0.299531f ; **FLOATING
C5865 xsc_vc1l_n.t1 vss 0.0297785f ; **FLOATING
C5866 xsc_vc1l_n.t3 vss 0.0150365f ; **FLOATING
C5867 xsc_vc1l_n.t2 vss 0.016232f ; **FLOATING
C5868 xsc_vc1l_n.t0 vss 0.0339571f ; **FLOATING
C5869 xsc_vc1l_n.n4 vss 0.0789421f ; **FLOATING
C5870 xsc_vc1l_n.n5 vss 0.258748f ; **FLOATING
C5871 xsc_vc1l_n.t10 vss 0.029778f ; **FLOATING
C5872 xsc_vc1l_n.t9 vss 0.0150365f ; **FLOATING
C5873 xsc_vc1l_n.t8 vss 0.016232f ; **FLOATING
C5874 xsc_vc1l_n.t11 vss 0.0339571f ; **FLOATING
C5875 sw_tgate_8.m.t4 vss 0.0189826f ; **FLOATING
C5876 sw_tgate_8.m.n0 vss 0.0518251f ; **FLOATING
C5877 sw_tgate_8.m.n1 vss 0.0144819f ; **FLOATING
C5878 sw_tgate_8.m.n2 vss 0.020862f ; **FLOATING
C5879 sw_tgate_8.m.n3 vss 0.040591f ; **FLOATING
C5880 sw_tgate_8.m.t2 vss 0.0399046f ; **FLOATING
C5881 sw_tgate_8.m.t0 vss 0.0186605f ; **FLOATING
C5882 sw_tgate_8.m.t1 vss 0.0224126f ; **FLOATING
C5883 sw_tgate_8.m.t6 vss 0.0412264f ; **FLOATING
C5884 sw_tgate_8.m.t9 vss 0.0208176f ; **FLOATING
C5885 sw_tgate_8.m.t8 vss 0.0224726f ; **FLOATING
C5886 sw_tgate_8.m.n4 vss 0.0397757f ; **FLOATING
C5887 sw_tgate_8.m.t7 vss 0.0470111f ; **FLOATING
C5888 sw_tgate_8.m.n5 vss 0.0395847f ; **FLOATING
C5889 sw_tgate_8.m.n6 vss 0.0179096f ; **FLOATING
C5890 sw_tgate_8.m.n7 vss 0.0718673f ; **FLOATING
C5891 sw_tgate_8.m.n8 vss 0.129186f ; **FLOATING
C5892 sw_tgate_8.m.t3 vss 0.0469111f ; **FLOATING
C5893 sw_tgate_8.m.t5 vss 0.0389893f ; **FLOATING
C5894 bias_gm_0.bias_trim_0.vz.n0 vss 0.0223579f ; **FLOATING
C5895 bias_gm_0.bias_trim_0.vz.n1 vss 0.0200571f ; **FLOATING
C5896 bias_gm_0.bias_trim_0.vz.n2 vss 0.0399951f ; **FLOATING
C5897 bias_gm_0.bias_trim_0.vz.n3 vss 0.0537873f ; **FLOATING
C5898 bias_gm_0.bias_trim_0.vz.n4 vss 0.0349405f ; **FLOATING
C5899 bias_gm_0.bias_trim_0.vz.n5 vss 0.0317533f ; **FLOATING
C5900 bias_gm_0.bias_trim_0.vz.n6 vss 0.0437158f ; **FLOATING
C5901 bias_gm_0.bias_trim_0.vz.n7 vss 0.0400079f ; **FLOATING
C5902 bias_gm_0.bias_trim_0.vz.n8 vss 0.0337174f ; **FLOATING
C5903 bias_gm_0.bias_trim_0.vz.n9 vss 0.0381597f ; **FLOATING
C5904 bias_gm_0.bias_trim_0.vz.n10 vss 0.0384356f ; **FLOATING
C5905 bias_gm_0.bias_trim_0.vz.n11 vss 0.0301575f ; **FLOATING
C5906 bias_gm_0.bias_trim_0.vz.n12 vss 0.0317484f ; **FLOATING
C5907 bias_gm_0.bias_trim_0.vz.n13 vss 0.03746f ; **FLOATING
C5908 bias_gm_0.bias_trim_0.vz.n14 vss 0.0135194f ; **FLOATING
C5909 bias_gm_0.bias_trim_0.vz.n15 vss 0.018597f ; **FLOATING
C5910 bias_gm_0.bias_trim_0.vz.n16 vss 0.0177928f ; **FLOATING
C5911 bias_gm_0.bias_trim_0.vz.n17 vss 0.0176454f ; **FLOATING
C5912 bias_gm_0.bias_trim_0.vz.n18 vss 0.0371249f ; **FLOATING
C5913 bias_gm_0.bias_trim_0.vz.t13 vss 0.00226919f ; **FLOATING
C5914 bias_gm_0.bias_trim_0.vz.t7 vss 0.00226919f ; **FLOATING
C5915 bias_gm_0.bias_trim_0.vz.n19 vss 0.0177928f ; **FLOATING
C5916 bias_gm_0.bias_trim_0.vz.t1 vss 0.00231304f ; **FLOATING
C5917 bias_gm_0.bias_trim_0.vz.t20 vss 0.0172004f ; **FLOATING
C5918 bias_gm_0.bias_trim_0.vz.t19 vss 0.0321062f ; **FLOATING
C5919 bias_gm_0.bias_trim_0.vz.n20 vss 0.0789233f ; **FLOATING
C5920 bias_gm_0.bias_trim_0.vz.t18 vss 0.00861454f ; **FLOATING
C5921 bias_gm_0.bias_trim_0.vz.n21 vss 0.054421f ; **FLOATING
C5922 bias_gm_0.bias_trim_0.vz.n22 vss 0.0177928f ; **FLOATING
C5923 bias_gm_0.bias_trim_0.vz.t21 vss 0.00569204f ; **FLOATING
C5924 bias_gm_0.bias_trim_0.vz.t53 vss 0.231071f ; **FLOATING
C5925 bias_gm_0.bias_trim_0.vz.n23 vss 0.0467897f ; **FLOATING
C5926 bias_gm_0.bias_trim_0.vz.t0 vss 0.231071f ; **FLOATING
C5927 bias_gm_0.bias_trim_0.vz.n24 vss 0.0177923f ; **FLOATING
C5928 bias_gm_0.bias_trim_0.vz.n25 vss 0.0215761f ; **FLOATING
C5929 bias_gm_0.bias_trim_0.vz.t4 vss 0.00226919f ; **FLOATING
C5930 bias_gm_0.bias_trim_0.vz.n26 vss 0.0215761f ; **FLOATING
C5931 bias_gm_0.bias_trim_0.vz.n27 vss 0.0177923f ; **FLOATING
C5932 bias_gm_0.bias_trim_0.vz.t3 vss 0.231071f ; **FLOATING
C5933 bias_gm_0.bias_trim_0.vz.n28 vss 0.0177928f ; **FLOATING
C5934 bias_gm_0.bias_trim_0.vz.t52 vss 0.231071f ; **FLOATING
C5935 bias_gm_0.bias_trim_0.vz.n29 vss 0.0467897f ; **FLOATING
C5936 bias_gm_0.bias_trim_0.vz.t6 vss 0.231071f ; **FLOATING
C5937 bias_gm_0.bias_trim_0.vz.n30 vss 0.0177923f ; **FLOATING
C5938 bias_gm_0.bias_trim_0.vz.n31 vss 0.0215761f ; **FLOATING
C5939 bias_gm_0.bias_trim_0.vz.t10 vss 0.00226919f ; **FLOATING
C5940 bias_gm_0.bias_trim_0.vz.n32 vss 0.0215761f ; **FLOATING
C5941 bias_gm_0.bias_trim_0.vz.n33 vss 0.0177923f ; **FLOATING
C5942 bias_gm_0.bias_trim_0.vz.t9 vss 0.231071f ; **FLOATING
C5943 bias_gm_0.bias_trim_0.vz.n34 vss 0.0177928f ; **FLOATING
C5944 bias_gm_0.bias_trim_0.vz.t50 vss 0.231071f ; **FLOATING
C5945 bias_gm_0.bias_trim_0.vz.n35 vss 0.0467897f ; **FLOATING
C5946 bias_gm_0.bias_trim_0.vz.t51 vss 0.231071f ; **FLOATING
C5947 bias_gm_0.bias_trim_0.vz.n36 vss 0.0467897f ; **FLOATING
C5948 bias_gm_0.bias_trim_0.vz.t12 vss 0.231071f ; **FLOATING
C5949 bias_gm_0.bias_trim_0.vz.n37 vss 0.0177923f ; **FLOATING
C5950 bias_gm_0.bias_trim_0.vz.n38 vss 0.0215761f ; **FLOATING
C5951 bias_gm_0.bias_trim_0.vz.t16 vss 0.00226919f ; **FLOATING
C5952 bias_gm_0.bias_trim_0.vz.n39 vss 0.0216881f ; **FLOATING
C5953 bias_gm_0.bias_trim_0.vz.n40 vss 0.0177928f ; **FLOATING
C5954 bias_gm_0.bias_trim_0.vz.t15 vss 0.231071f ; **FLOATING
C5955 bias_gm_0.bias_trim_0.vz.n41 vss 0.0177923f ; **FLOATING
C5956 bias_gm_0.bias_trim_0.vz.t35 vss 0.231071f ; **FLOATING
C5957 bias_gm_0.bias_trim_0.vz.n42 vss 0.0478794f ; **FLOATING
C5958 bias_gm_0.bias_trim_0.vz.t34 vss 0.231071f ; **FLOATING
C5959 bias_gm_0.bias_trim_0.vz.n43 vss 0.0467897f ; **FLOATING
C5960 bias_gm_0.bias_trim_0.vz.t27 vss 0.0387877f ; **FLOATING
C5961 bias_gm_0.bias_trim_0.vz.t29 vss 0.0420709f ; **FLOATING
C5962 bias_gm_0.bias_trim_0.vz.t31 vss 0.0387877f ; **FLOATING
C5963 bias_gm_0.bias_trim_0.vz.t33 vss 0.231071f ; **FLOATING
C5964 bias_gm_0.bias_trim_0.vz.n44 vss 0.0467897f ; **FLOATING
C5965 bias_gm_0.bias_trim_0.vz.t32 vss 0.0387877f ; **FLOATING
C5966 bias_gm_0.bias_trim_0.vz.t30 vss 0.0420709f ; **FLOATING
C5967 bias_gm_0.bias_trim_0.vz.t28 vss 0.0387877f ; **FLOATING
C5968 bias_gm_0.bias_trim_0.vz.t26 vss 0.231071f ; **FLOATING
C5969 bias_gm_0.bias_trim_0.vz.n45 vss 0.0467897f ; **FLOATING
C5970 bias_gm_0.bias_trim_0.vz.t25 vss 0.231071f ; **FLOATING
C5971 bias_gm_0.bias_trim_0.vz.n46 vss 0.0467897f ; **FLOATING
C5972 bias_gm_0.bias_trim_0.vz.t24 vss 0.0764983f ; **FLOATING
C5973 bias_gm_0.bias_trim_0.vz.n47 vss 0.0293424f ; **FLOATING
C5974 bias_gm_0.bias_trim_0.vz.t23 vss 0.0764983f ; **FLOATING
C5975 bias_gm_0.bias_trim_0.vz.n48 vss 0.0293424f ; **FLOATING
C5976 bias_gm_0.bias_trim_0.vz.t22 vss 0.231071f ; **FLOATING
C5977 bias_gm_0.bias_trim_0.vz.n49 vss 0.0467897f ; **FLOATING
C5978 bias_gm_0.bias_trim_0.vz.t44 vss 0.0387877f ; **FLOATING
C5979 bias_gm_0.bias_trim_0.vz.t42 vss 0.0420709f ; **FLOATING
C5980 bias_gm_0.bias_trim_0.vz.t40 vss 0.0387877f ; **FLOATING
C5981 bias_gm_0.bias_trim_0.vz.t36 vss 0.231071f ; **FLOATING
C5982 bias_gm_0.bias_trim_0.vz.n50 vss 0.0478794f ; **FLOATING
C5983 bias_gm_0.bias_trim_0.vz.t37 vss 0.231071f ; **FLOATING
C5984 bias_gm_0.bias_trim_0.vz.n51 vss 0.0467897f ; **FLOATING
C5985 bias_gm_0.bias_trim_0.vz.t38 vss 0.231071f ; **FLOATING
C5986 bias_gm_0.bias_trim_0.vz.n52 vss 0.0467897f ; **FLOATING
C5987 bias_gm_0.bias_trim_0.vz.t39 vss 0.0387877f ; **FLOATING
C5988 bias_gm_0.bias_trim_0.vz.t41 vss 0.0420709f ; **FLOATING
C5989 bias_gm_0.bias_trim_0.vz.t43 vss 0.0387877f ; **FLOATING
C5990 bias_gm_0.bias_trim_0.vz.t45 vss 0.231071f ; **FLOATING
C5991 bias_gm_0.bias_trim_0.vz.n53 vss 0.0467897f ; **FLOATING
C5992 bias_gm_0.bias_trim_0.vz.t46 vss 0.231071f ; **FLOATING
C5993 bias_gm_0.bias_trim_0.vz.n54 vss 0.0467897f ; **FLOATING
C5994 bias_gm_0.bias_trim_0.vz.t47 vss 0.0764983f ; **FLOATING
C5995 bias_gm_0.bias_trim_0.vz.n55 vss 0.0293424f ; **FLOATING
C5996 bias_gm_0.bias_trim_0.vz.t48 vss 0.0764983f ; **FLOATING
C5997 bias_gm_0.bias_trim_0.vz.n56 vss 0.0293424f ; **FLOATING
C5998 bias_gm_0.bias_trim_0.vz.t49 vss 0.231071f ; **FLOATING
C5999 bias_gm_0.bias_trim_0.vz.n57 vss 0.0467897f ; **FLOATING
C6000 dsm2_osc_0.d_btest_or.t2 vss 0.696297f ; **FLOATING
C6001 dsm2_osc_0.d_btest_or.t3 vss 2.79446f ; **FLOATING
C6002 dsm2_osc_0.d_btest_or.n0 vss 2.31183f ; **FLOATING
C6003 dsm2_osc_0.d_btest_or.t0 vss 0.0307179f ; **FLOATING
C6004 dsm2_osc_0.d_btest_or.t1 vss 0.0439569f ; **FLOATING
C6005 quantizer2_lfsr_0.sg13cmos5l_dfrbpq_1_11.D.t0 vss 0.00605301f ; **FLOATING
C6006 quantizer2_lfsr_0.sg13cmos5l_dfrbpq_1_11.D.t2 vss 0.00860262f ; **FLOATING
C6007 quantizer2_lfsr_0.sg13cmos5l_dfrbpq_1_11.D.t1 vss 0.0104708f ; **FLOATING
C6008 quantizer2_lfsr_0.sg13cmos5l_dfrbpq_1_2.D.t2 vss 0.0116723f ; **FLOATING
C6009 quantizer2_lfsr_0.sg13cmos5l_dfrbpq_1_2.D.t1 vss 0.00845429f ; **FLOATING
C6010 quantizer2_lfsr_0.sg13cmos5l_dfrbpq_1_2.D.t0 vss 0.014163f ; **FLOATING
C6011 quantizer2_lfsr_0.sg13cmos5l_dfrbpq_1_1.D.t0 vss 0.0195081f ; **FLOATING
C6012 quantizer2_lfsr_0.sg13cmos5l_dfrbpq_1_1.D.t1 vss 0.0273957f ; **FLOATING
C6013 quantizer2_lfsr_0.sg13cmos5l_dfrbpq_1_1.D.t3 vss 0.074147f ; **FLOATING
C6014 quantizer2_lfsr_0.sg13cmos5l_dfrbpq_1_1.D.t2 vss 0.0284924f ; **FLOATING
C6015 quantizer2_lfsr_0.sg13cmos5l_dfrbpq_1_1.D.n0 vss 0.2346f ; **FLOATING
C6016 quantizer2_lfsr_0.sg13cmos5l_dfrbpq_1_13.D.t3 vss 0.0715825f ; **FLOATING
C6017 quantizer2_lfsr_0.sg13cmos5l_dfrbpq_1_13.D.t2 vss 0.0274857f ; **FLOATING
C6018 quantizer2_lfsr_0.sg13cmos5l_dfrbpq_1_13.D.n0 vss 0.223529f ; **FLOATING
C6019 quantizer2_lfsr_0.sg13cmos5l_dfrbpq_1_13.D.t0 vss 0.0191753f ; **FLOATING
C6020 quantizer2_lfsr_0.sg13cmos5l_dfrbpq_1_13.D.t1 vss 0.0263906f ; **FLOATING
C6021 sg13cmos5l_nand2_1_5.A.t0 vss 0.0176981f ; **FLOATING
C6022 sg13cmos5l_nand2_1_5.A.t1 vss 0.0250151f ; **FLOATING
C6023 sg13cmos5l_nand2_1_5.A.t5 vss 0.0306493f ; **FLOATING
C6024 sg13cmos5l_nand2_1_5.A.t7 vss 0.0306378f ; **FLOATING
C6025 sg13cmos5l_nand2_1_5.A.t3 vss 0.0306294f ; **FLOATING
C6026 sg13cmos5l_nand2_1_5.A.n0 vss 0.0958188f ; **FLOATING
C6027 sg13cmos5l_nand2_1_5.A.t2 vss 0.0306294f ; **FLOATING
C6028 sg13cmos5l_nand2_1_5.A.n1 vss 0.0657158f ; **FLOATING
C6029 sg13cmos5l_nand2_1_5.A.t6 vss 0.0306294f ; **FLOATING
C6030 sg13cmos5l_nand2_1_5.A.n2 vss 0.266906f ; **FLOATING
C6031 sg13cmos5l_nand2_1_5.A.n3 vss 0.303187f ; **FLOATING
C6032 sg13cmos5l_nand2_1_5.A.t4 vss 0.0306294f ; **FLOATING
C6033 sg13cmos5l_nand2_1_5.A.n4 vss 0.176913f ; **FLOATING
C6034 sg13cmos5l_inv_1_6.A.t4 vss 0.0418081f ; **FLOATING
C6035 sg13cmos5l_inv_1_6.A.t3 vss 0.10207f ; **FLOATING
C6036 sg13cmos5l_inv_1_6.A.t2 vss 0.378439f ; **FLOATING
C6037 sg13cmos5l_inv_1_6.A.n0 vss 1.00117f ; **FLOATING
C6038 sg13cmos5l_inv_1_6.A.n1 vss 0.307295f ; **FLOATING
C6039 sg13cmos5l_inv_1_6.A.t1 vss 0.023864f ; **FLOATING
C6040 sg13cmos5l_inv_1_6.A.t0 vss 0.035754f ; **FLOATING
C6041 sg13cmos5l_inv_1_4.A.t4 vss 0.0488439f ; **FLOATING
C6042 sg13cmos5l_inv_1_4.A.t3 vss 0.0997701f ; **FLOATING
C6043 sg13cmos5l_inv_1_4.A.t2 vss 0.394604f ; **FLOATING
C6044 sg13cmos5l_inv_1_4.A.n0 vss 1.41917f ; **FLOATING
C6045 sg13cmos5l_inv_1_4.A.n1 vss 0.260516f ; **FLOATING
C6046 sg13cmos5l_inv_1_4.A.t0 vss 0.0278807f ; **FLOATING
C6047 sg13cmos5l_inv_1_4.A.t1 vss 0.041772f ; **FLOATING
C6048 sg13cmos5l_inv_1_6.Y.t2 vss 0.144915f ; **FLOATING
C6049 sg13cmos5l_inv_1_6.Y.t3 vss 0.114221f ; **FLOATING
C6050 sg13cmos5l_inv_1_6.Y.n0 vss 0.899242f ; **FLOATING
C6051 sg13cmos5l_inv_1_6.Y.t0 vss 0.0128028f ; **FLOATING
C6052 sg13cmos5l_inv_1_6.Y.t1 vss 0.0178488f ; **FLOATING
C6053 sg13cmos5l_inv_1_4.Y.t3 vss 0.0784892f ; **FLOATING
C6054 sg13cmos5l_inv_1_4.Y.t2 vss 0.144116f ; **FLOATING
C6055 sg13cmos5l_inv_1_4.Y.n0 vss 0.809337f ; **FLOATING
C6056 sg13cmos5l_inv_1_4.Y.t0 vss 0.0125214f ; **FLOATING
C6057 sg13cmos5l_inv_1_4.Y.t1 vss 0.0172065f ; **FLOATING
C6058 sg13cmos5l_inv_1_3.A.t0 vss 0.0245906f ; **FLOATING
C6059 sg13cmos5l_inv_1_3.A.t1 vss 0.0335841f ; **FLOATING
C6060 sg13cmos5l_inv_1_3.A.t4 vss 0.0438919f ; **FLOATING
C6061 sg13cmos5l_inv_1_3.A.t3 vss 0.446588f ; **FLOATING
C6062 sg13cmos5l_inv_1_3.A.t2 vss 0.9276f ; **FLOATING
C6063 sg13cmos5l_inv_1_3.A.n0 vss 1.37982f ; **FLOATING
C6064 sg13cmos5l_inv_1_3.A.n1 vss 0.418926f ; **FLOATING
C6065 sg13cmos5l_inv_1_19.Y.t1 vss 0.0329161f ; **FLOATING
C6066 sg13cmos5l_inv_1_19.Y.t8 vss 0.0422779f ; **FLOATING
C6067 sg13cmos5l_inv_1_19.Y.t6 vss 0.017933f ; **FLOATING
C6068 sg13cmos5l_inv_1_19.Y.t7 vss 0.0177786f ; **FLOATING
C6069 sg13cmos5l_inv_1_19.Y.n0 vss 0.0240578f ; **FLOATING
C6070 sg13cmos5l_inv_1_19.Y.t5 vss 0.0208132f ; **FLOATING
C6071 sg13cmos5l_inv_1_19.Y.n1 vss 0.116349f ; **FLOATING
C6072 sg13cmos5l_inv_1_19.Y.t2 vss 0.0177786f ; **FLOATING
C6073 sg13cmos5l_inv_1_19.Y.t3 vss 0.017933f ; **FLOATING
C6074 sg13cmos5l_inv_1_19.Y.n2 vss 0.0240578f ; **FLOATING
C6075 sg13cmos5l_inv_1_19.Y.t4 vss 0.0208132f ; **FLOATING
C6076 sg13cmos5l_inv_1_19.Y.n3 vss 0.455506f ; **FLOATING
C6077 sg13cmos5l_inv_1_19.Y.n4 vss 0.782724f ; **FLOATING
C6078 sg13cmos5l_inv_1_19.Y.n5 vss 0.189319f ; **FLOATING
C6079 sg13cmos5l_inv_1_19.Y.t0 vss 0.0217455f ; **FLOATING
C6080 sg13cmos5l_and2_1_5.X.t0 vss 0.0164318f ; **FLOATING
C6081 sg13cmos5l_and2_1_5.X.t1 vss 0.0231672f ; **FLOATING
C6082 sg13cmos5l_and2_1_5.X.t2 vss 0.03384f ; **FLOATING
C6083 sg13cmos5l_and2_1_5.X.t3 vss 0.0292532f ; **FLOATING
C6084 sg13cmos5l_and2_1_5.X.n0 vss 0.3538f ; **FLOATING
C6085 inv_en_0.di_b.t2 vss 0.0350535f ; **FLOATING
C6086 inv_en_0.di_b.t0 vss 0.0284454f ; **FLOATING
C6087 inv_en_0.di_b.t1 vss 0.0467164f ; **FLOATING
C6088 sg13cmos5l_inv_1_3.Y.t3 vss 0.228412f ; **FLOATING
C6089 sg13cmos5l_inv_1_3.Y.t2 vss 0.843085f ; **FLOATING
C6090 sg13cmos5l_inv_1_3.Y.n0 vss 0.861138f ; **FLOATING
C6091 sg13cmos5l_inv_1_3.Y.t0 vss 0.0134061f ; **FLOATING
C6092 sg13cmos5l_inv_1_3.Y.t1 vss 0.0186909f ; **FLOATING
C6093 sg13cmos5l_or2_1_0.X.t4 vss 0.0370205f ; **FLOATING
C6094 sg13cmos5l_or2_1_0.X.t3 vss 0.386257f ; **FLOATING
C6095 sg13cmos5l_or2_1_0.X.t2 vss 0.858166f ; **FLOATING
C6096 sg13cmos5l_or2_1_0.X.n0 vss 1.3956f ; **FLOATING
C6097 sg13cmos5l_or2_1_0.X.n1 vss 0.578585f ; **FLOATING
C6098 sg13cmos5l_or2_1_0.X.t0 vss 0.0211953f ; **FLOATING
C6099 sg13cmos5l_or2_1_0.X.t1 vss 0.0295727f ; **FLOATING
C6100 sg13cmos5l_inv_1_13.A.t4 vss 0.0325332f ; **FLOATING
C6101 sg13cmos5l_inv_1_13.A.t2 vss 0.0660016f ; **FLOATING
C6102 sg13cmos5l_inv_1_13.A.t3 vss 0.284875f ; **FLOATING
C6103 sg13cmos5l_inv_1_13.A.n0 vss 0.780847f ; **FLOATING
C6104 sg13cmos5l_inv_1_13.A.n1 vss 0.160678f ; **FLOATING
C6105 sg13cmos5l_inv_1_13.A.t1 vss 0.0185679f ; **FLOATING
C6106 sg13cmos5l_inv_1_13.A.t0 vss 0.0278185f ; **FLOATING
C6107 sg13cmos5l_nand2_1_2.Y.t2 vss 0.0595969f ; **FLOATING
C6108 sg13cmos5l_nand2_1_2.Y.t3 vss 0.30201f ; **FLOATING
C6109 sg13cmos5l_nand2_1_2.Y.n0 vss 1.24828f ; **FLOATING
C6110 sg13cmos5l_nand2_1_2.Y.t4 vss 0.0467979f ; **FLOATING
C6111 sg13cmos5l_nand2_1_2.Y.n1 vss 0.354871f ; **FLOATING
C6112 sg13cmos5l_nand2_1_2.Y.t0 vss 0.0267129f ; **FLOATING
C6113 sg13cmos5l_nand2_1_2.Y.t1 vss 0.0400224f ; **FLOATING
C6114 sg13cmos5l_nand2_2_0.B.t0 vss 0.0180638f ; **FLOATING
C6115 sg13cmos5l_nand2_2_0.B.t1 vss 0.0250554f ; **FLOATING
C6116 sg13cmos5l_nand2_2_0.B.t3 vss 0.112454f ; **FLOATING
C6117 sg13cmos5l_nand2_2_0.B.t2 vss 0.052333f ; **FLOATING
C6118 sg13cmos5l_nand2_2_0.B.n0 vss 0.189367f ; **FLOATING
C6119 sg13cmos5l_inv_1_9.Y.t2 vss 0.325633f ; **FLOATING
C6120 sg13cmos5l_inv_1_9.Y.t3 vss 0.607205f ; **FLOATING
C6121 sg13cmos5l_inv_1_9.Y.n0 vss 0.932642f ; **FLOATING
C6122 sg13cmos5l_inv_1_9.Y.t0 vss 0.0164201f ; **FLOATING
C6123 sg13cmos5l_inv_1_9.Y.t1 vss 0.0226358f ; **FLOATING
C6124 sg13cmos5l_inv_1_13.Y.t2 vss 0.173433f ; **FLOATING
C6125 sg13cmos5l_inv_1_13.Y.t3 vss 0.253396f ; **FLOATING
C6126 sg13cmos5l_inv_1_13.Y.n0 vss 1.17659f ; **FLOATING
C6127 sg13cmos5l_inv_1_13.Y.t0 vss 0.0168771f ; **FLOATING
C6128 sg13cmos5l_inv_1_13.Y.t1 vss 0.0235301f ; **FLOATING
C6129 sg13cmos5l_inv_1_20.Y.t3 vss 0.184093f ; **FLOATING
C6130 sg13cmos5l_inv_1_20.Y.t2 vss 0.120725f ; **FLOATING
C6131 sg13cmos5l_inv_1_20.Y.n0 vss 0.919217f ; **FLOATING
C6132 sg13cmos5l_inv_1_20.Y.t0 vss 0.0139657f ; **FLOATING
C6133 sg13cmos5l_inv_1_20.Y.t1 vss 0.0194709f ; **FLOATING
C6134 sg13cmos5l_nor2_2_0.B.t1 vss 0.0151757f ; **FLOATING
C6135 sg13cmos5l_nor2_2_0.B.t0 vss 0.014536f ; **FLOATING
C6136 sg13cmos5l_nor2_2_0.B.t4 vss 0.0455799f ; **FLOATING
C6137 sg13cmos5l_nor2_2_0.B.t2 vss 0.0221719f ; **FLOATING
C6138 sg13cmos5l_nor2_2_0.B.t3 vss 0.0234478f ; **FLOATING
C6139 quantizer2_lfsr_0.sg13cmos5l_dfrbpq_1_0.D.t0 vss 0.0070771f ; **FLOATING
C6140 quantizer2_lfsr_0.sg13cmos5l_dfrbpq_1_0.D.t2 vss 0.0100659f ; **FLOATING
C6141 quantizer2_lfsr_0.sg13cmos5l_dfrbpq_1_0.D.t1 vss 0.0122416f ; **FLOATING
C6142 sg13cmos5l_inv_1_16.A.t1 vss 0.0203824f ; **FLOATING
C6143 sg13cmos5l_inv_1_16.A.t2 vss 0.136539f ; **FLOATING
C6144 sg13cmos5l_inv_1_16.A.t3 vss 0.100683f ; **FLOATING
C6145 sg13cmos5l_inv_1_16.A.n0 vss 0.808965f ; **FLOATING
C6146 sg13cmos5l_inv_1_16.A.t4 vss 0.02382f ; **FLOATING
C6147 sg13cmos5l_inv_1_16.A.n1 vss 0.115847f ; **FLOATING
C6148 sg13cmos5l_inv_1_16.A.t0 vss 0.0123627f ; **FLOATING
C6149 sg13cmos5l_inv_1_16.Y.t1 vss 0.0217994f ; **FLOATING
C6150 sg13cmos5l_inv_1_16.Y.t2 vss 0.179599f ; **FLOATING
C6151 sg13cmos5l_inv_1_16.Y.t3 vss 0.172701f ; **FLOATING
C6152 sg13cmos5l_inv_1_16.Y.n0 vss 1.21028f ; **FLOATING
C6153 sg13cmos5l_inv_1_16.Y.t0 vss 0.0143891f ; **FLOATING
C6154 sg13cmos5l_inv_1_17.A.t0 vss 0.0402324f ; **FLOATING
C6155 sg13cmos5l_inv_1_17.A.t2 vss 0.27229f ; **FLOATING
C6156 sg13cmos5l_inv_1_17.A.t3 vss 0.210547f ; **FLOATING
C6157 sg13cmos5l_inv_1_17.A.n0 vss 1.45583f ; **FLOATING
C6158 sg13cmos5l_inv_1_17.A.t4 vss 0.0470428f ; **FLOATING
C6159 sg13cmos5l_inv_1_17.A.n1 vss 0.212981f ; **FLOATING
C6160 sg13cmos5l_inv_1_17.A.t1 vss 0.0244108f ; **FLOATING
C6161 sg13cmos5l_inv_1_17.Y.t1 vss 0.021168f ; **FLOATING
C6162 sg13cmos5l_inv_1_17.Y.t2 vss 0.156749f ; **FLOATING
C6163 sg13cmos5l_inv_1_17.Y.t3 vss 0.150725f ; **FLOATING
C6164 sg13cmos5l_inv_1_17.Y.n0 vss 1.01803f ; **FLOATING
C6165 sg13cmos5l_inv_1_17.Y.t0 vss 0.0139719f ; **FLOATING
C6166 sg13cmos5l_inv_1_18.Y.t1 vss 0.0436921f ; **FLOATING
C6167 sg13cmos5l_inv_1_18.Y.t2 vss 0.585945f ; **FLOATING
C6168 sg13cmos5l_inv_1_18.Y.t0 vss 0.0288551f ; **FLOATING
C6169 sg13cmos5l_and2_1_5.A.t0 vss 0.01477f ; **FLOATING
C6170 sg13cmos5l_and2_1_5.A.t1 vss 0.0232757f ; **FLOATING
C6171 sg13cmos5l_and2_1_5.A.t2 vss 0.0231244f ; **FLOATING
C6172 sg13cmos5l_and2_1_5.A.t3 vss 0.0276517f ; **FLOATING
C6173 sg13cmos5l_and2_1_5.A.t4 vss 0.0304948f ; **FLOATING
C6174 sg13cmos5l_and2_1_5.A.n0 vss 0.218501f ; **FLOATING
C6175 sg13cmos5l_and2_1_5.A.n1 vss 0.259897f ; **FLOATING
C6176 sg13cmos5l_and2_1_5.B.t0 vss 0.00858116f ; **FLOATING
C6177 sg13cmos5l_and2_1_5.B.t1 vss 0.0135368f ; **FLOATING
C6178 sg13cmos5l_and2_1_5.B.t2 vss 0.0158547f ; **FLOATING
C6179 sg13cmos5l_and2_1_5.B.t3 vss 0.0130806f ; **FLOATING
C6180 sg13cmos5l_and2_1_5.B.n0 vss 0.166879f ; **FLOATING
C6181 sg13cmos5l_inv_1_2.A.n0 vss 0.186436f ; **FLOATING
C6182 sg13cmos5l_inv_1_2.A.n1 vss 0.295134f ; **FLOATING
C6183 sg13cmos5l_inv_1_2.A.t11 vss 0.0320567f ; **FLOATING
C6184 sg13cmos5l_inv_1_2.A.t10 vss 0.745505f ; **FLOATING
C6185 sg13cmos5l_inv_1_2.A.t9 vss 0.0405898f ; **FLOATING
C6186 sg13cmos5l_inv_1_2.A.t2 vss 0.0124394f ; **FLOATING
C6187 sg13cmos5l_inv_1_2.A.n2 vss 0.049042f ; **FLOATING
C6188 sg13cmos5l_inv_1_2.A.t8 vss 0.0405898f ; **FLOATING
C6189 sg13cmos5l_inv_1_2.A.t1 vss 0.0124394f ; **FLOATING
C6190 sg13cmos5l_inv_1_2.A.n3 vss 0.049042f ; **FLOATING
C6191 sg13cmos5l_inv_1_2.A.t7 vss 0.0367164f ; **FLOATING
C6192 sg13cmos5l_inv_1_2.A.t4 vss 0.0420082f ; **FLOATING
C6193 sg13cmos5l_inv_1_2.A.n4 vss 0.0360995f ; **FLOATING
C6194 sg13cmos5l_inv_1_2.A.t5 vss 0.0124394f ; **FLOATING
C6195 sg13cmos5l_inv_1_2.A.n5 vss 0.0348151f ; **FLOATING
C6196 sg13cmos5l_inv_1_2.A.t6 vss 0.0367164f ; **FLOATING
C6197 sg13cmos5l_inv_1_2.A.t3 vss 0.0420107f ; **FLOATING
C6198 sg13cmos5l_inv_1_2.A.n6 vss 0.0360995f ; **FLOATING
C6199 sg13cmos5l_inv_1_2.A.t0 vss 0.0124394f ; **FLOATING
C6200 sg13cmos5l_inv_1_2.A.n7 vss 0.0348151f ; **FLOATING
C6201 sg13cmos5l_inv_1_14.A.n0 vss 0.264885f ; **FLOATING
C6202 sg13cmos5l_inv_1_14.A.n1 vss 0.291652f ; **FLOATING
C6203 sg13cmos5l_inv_1_14.A.t11 vss 0.0321622f ; **FLOATING
C6204 sg13cmos5l_inv_1_14.A.t10 vss 0.670181f ; **FLOATING
C6205 sg13cmos5l_inv_1_14.A.t9 vss 0.0407237f ; **FLOATING
C6206 sg13cmos5l_inv_1_14.A.t0 vss 0.0124799f ; **FLOATING
C6207 sg13cmos5l_inv_1_14.A.n2 vss 0.0492056f ; **FLOATING
C6208 sg13cmos5l_inv_1_14.A.t6 vss 0.0407237f ; **FLOATING
C6209 sg13cmos5l_inv_1_14.A.t1 vss 0.0124799f ; **FLOATING
C6210 sg13cmos5l_inv_1_14.A.n3 vss 0.0492056f ; **FLOATING
C6211 sg13cmos5l_inv_1_14.A.t7 vss 0.0368398f ; **FLOATING
C6212 sg13cmos5l_inv_1_14.A.t3 vss 0.0421493f ; **FLOATING
C6213 sg13cmos5l_inv_1_14.A.n4 vss 0.0362186f ; **FLOATING
C6214 sg13cmos5l_inv_1_14.A.t5 vss 0.0124799f ; **FLOATING
C6215 sg13cmos5l_inv_1_14.A.n5 vss 0.0349311f ; **FLOATING
C6216 sg13cmos5l_inv_1_14.A.t8 vss 0.0368398f ; **FLOATING
C6217 sg13cmos5l_inv_1_14.A.t4 vss 0.0421493f ; **FLOATING
C6218 sg13cmos5l_inv_1_14.A.n6 vss 0.0362213f ; **FLOATING
C6219 sg13cmos5l_inv_1_14.A.t2 vss 0.0124799f ; **FLOATING
C6220 sg13cmos5l_inv_1_14.A.n7 vss 0.0349311f ; **FLOATING
C6221 sg13cmos5l_and2_2_1.X.t0 vss 0.0165917f ; **FLOATING
C6222 sg13cmos5l_and2_2_1.X.t1 vss 0.0236029f ; **FLOATING
C6223 sg13cmos5l_and2_2_1.X.t2 vss 1.12032f ; **FLOATING
C6224 sg13cmos5l_and2_2_1.X.t3 vss 0.625488f ; **FLOATING
C6225 sg13cmos5l_and2_2_1.X.t4 vss 0.625488f ; **FLOATING
C6226 sg13cmos5l_and2_2_1.X.n0 vss 0.163831f ; **FLOATING
C6227 sg13cmos5l_and2_2_1.X.n1 vss 0.320244f ; **FLOATING
C6228 a_9533_11104.n0 vss 0.106312f ; **FLOATING
C6229 a_9533_11104.n1 vss 0.0317175f ; **FLOATING
C6230 a_9533_11104.t5 vss 0.0291492f ; **FLOATING
C6231 a_9533_11104.t4 vss 0.0291492f ; **FLOATING
C6232 a_9533_11104.n2 vss 0.0628359f ; **FLOATING
C6233 a_9533_11104.t2 vss 0.0304122f ; **FLOATING
C6234 a_9533_11104.t6 vss 0.0311412f ; **FLOATING
C6235 a_9533_11104.t7 vss 0.0299365f ; **FLOATING
C6236 a_9533_11104.t3 vss 0.0299365f ; **FLOATING
C6237 a_9533_11104.n3 vss 0.119457f ; **FLOATING
C6238 a_9533_11104.t8 vss 0.0078072f ; **FLOATING
C6239 a_9533_11104.t0 vss 0.0627353f ; **FLOATING
C6240 a_9533_11104.n4 vss 0.0329903f ; **FLOATING
C6241 a_9533_11104.n5 vss 0.0534263f ; **FLOATING
C6242 a_9533_11104.t9 vss 0.00770493f ; **FLOATING
C6243 a_9533_11104.t1 vss 0.0627385f ; **FLOATING
C6244 a_11293_11104.n0 vss 0.106423f ; **FLOATING
C6245 a_11293_11104.n1 vss 0.0334598f ; **FLOATING
C6246 a_11293_11104.t6 vss 0.0291789f ; **FLOATING
C6247 a_11293_11104.t5 vss 0.0291789f ; **FLOATING
C6248 a_11293_11104.n2 vss 0.0629018f ; **FLOATING
C6249 a_11293_11104.t9 vss 0.0311738f ; **FLOATING
C6250 a_11293_11104.t8 vss 0.0299683f ; **FLOATING
C6251 a_11293_11104.t7 vss 0.0299683f ; **FLOATING
C6252 a_11293_11104.t0 vss 0.0304436f ; **FLOATING
C6253 a_11293_11104.n3 vss 0.119582f ; **FLOATING
C6254 a_11293_11104.t3 vss 0.00781524f ; **FLOATING
C6255 a_11293_11104.t1 vss 0.0628015f ; **FLOATING
C6256 a_11293_11104.n4 vss 0.0313054f ; **FLOATING
C6257 a_11293_11104.n5 vss 0.0534929f ; **FLOATING
C6258 a_11293_11104.t4 vss 0.00771327f ; **FLOATING
C6259 a_11293_11104.t2 vss 0.0628031f ; **FLOATING
C6260 a_9357_11104.n0 vss 0.390089f ; **FLOATING
C6261 a_9357_11104.n1 vss 0.145719f ; **FLOATING
C6262 a_9357_11104.n2 vss 0.194605f ; **FLOATING
C6263 a_9357_11104.n3 vss 0.172066f ; **FLOATING
C6264 a_9357_11104.n4 vss 0.277601f ; **FLOATING
C6265 a_9357_11104.n5 vss 0.172066f ; **FLOATING
C6266 a_9357_11104.n6 vss 0.0628721f ; **FLOATING
C6267 a_9357_11104.n8 vss 0.112953f ; **FLOATING
C6268 a_9357_11104.t3 vss 0.189271f ; **FLOATING
C6269 a_9357_11104.t12 vss 0.185122f ; **FLOATING
C6270 a_9357_11104.t14 vss 0.185122f ; **FLOATING
C6271 a_9357_11104.t5 vss 0.0720795f ; **FLOATING
C6272 a_9357_11104.t19 vss 0.0692903f ; **FLOATING
C6273 a_9357_11104.t18 vss 0.0692903f ; **FLOATING
C6274 a_9357_11104.t16 vss 0.0692903f ; **FLOATING
C6275 a_9357_11104.t6 vss 0.05284f ; **FLOATING
C6276 a_9357_11104.t2 vss 0.189266f ; **FLOATING
C6277 a_9357_11104.t0 vss 0.185122f ; **FLOATING
C6278 a_9357_11104.t1 vss 0.185122f ; **FLOATING
C6279 a_9357_11104.t13 vss 0.185122f ; **FLOATING
C6280 a_9357_11104.t4 vss 0.0720795f ; **FLOATING
C6281 a_9357_11104.t17 vss 0.0692903f ; **FLOATING
C6282 a_9357_11104.t9 vss 0.0692903f ; **FLOATING
C6283 a_9357_11104.t10 vss 0.0692903f ; **FLOATING
C6284 a_9357_11104.t8 vss 0.0515103f ; **FLOATING
C6285 a_9357_11104.t7 vss 0.0515103f ; **FLOATING
C6286 a_9357_11104.t15 vss 0.185122f ; **FLOATING
C6287 a_9357_11104.t11 vss 0.185117f ; **FLOATING
C6288 xq_vg_q_2_.t3 vss 0.295768f ; **FLOATING
C6289 xq_vg_q_2_.t2 vss 0.014909f ; **FLOATING
C6290 xq_vg_q_2_.n0 vss 0.188902f ; **FLOATING
C6291 xq_vg_q_2_.t1 vss 0.00914922f ; **FLOATING
C6292 xq_vg_q_2_.t0 vss 0.00880847f ; **FLOATING
C6293 xq_vg_q_2_.n1 vss 0.0194327f ; **FLOATING
C6294 xq_vg_q_2_.n2 vss 0.111871f ; **FLOATING
C6295 xq_vg_q_1_.t3 vss 0.22948f ; **FLOATING
C6296 xq_vg_q_1_.t1 vss 0.0250078f ; **FLOATING
C6297 xq_vg_q_1_.n0 vss 0.278153f ; **FLOATING
C6298 xq_vg_q_1_.t0 vss 0.0124031f ; **FLOATING
C6299 xq_vg_q_1_.t2 vss 0.0119415f ; **FLOATING
C6300 xq_vg_q_1_.n1 vss 0.0378421f ; **FLOATING
C6301 xq_vg_q_1_.n2 vss 0.118342f ; **FLOATING
C6302 xq_vg_q_0_.t2 vss 0.0106514f ; **FLOATING
C6303 xq_vg_q_0_.t1 vss 0.0102551f ; **FLOATING
C6304 xq_vg_q_0_.n0 vss 0.0188561f ; **FLOATING
C6305 xq_vg_q_0_.t0 vss 0.0119232f ; **FLOATING
C6306 xq_vg_q_0_.t3 vss 0.205188f ; **FLOATING
C6307 xq_vg_q_0_.n1 vss 0.223988f ; **FLOATING
C6308 xq_vg_q_0_.n2 vss 0.120133f ; **FLOATING
C6309 xq_vg_p_0_.t1 vss 0.014865f ; **FLOATING
C6310 xq_vg_p_0_.t3 vss 0.255823f ; **FLOATING
C6311 xq_vg_p_0_.n0 vss 0.279262f ; **FLOATING
C6312 xq_vg_p_0_.t2 vss 0.0132797f ; **FLOATING
C6313 xq_vg_p_0_.t0 vss 0.0127852f ; **FLOATING
C6314 xq_vg_p_0_.n1 vss 0.0235094f ; **FLOATING
C6315 xq_vg_p_0_.n2 vss 0.149778f ; **FLOATING
C6316 xq_vg_p_1_.t3 vss 0.178732f ; **FLOATING
C6317 xq_vg_p_1_.t0 vss 0.0194775f ; **FLOATING
C6318 xq_vg_p_1_.n0 vss 0.216641f ; **FLOATING
C6319 xq_vg_p_1_.t2 vss 0.00966026f ; **FLOATING
C6320 xq_vg_p_1_.t1 vss 0.00930077f ; **FLOATING
C6321 xq_vg_p_1_.n1 vss 0.0294734f ; **FLOATING
C6322 xq_vg_p_1_.n2 vss 0.0921715f ; **FLOATING
C6323 xq_vg_p_2_.t3 vss 0.394855f ; **FLOATING
C6324 xq_vg_p_2_.t2 vss 0.0199034f ; **FLOATING
C6325 xq_vg_p_2_.n0 vss 0.252187f ; **FLOATING
C6326 xq_vg_p_2_.t1 vss 0.0122142f ; **FLOATING
C6327 xq_vg_p_2_.t0 vss 0.0117596f ; **FLOATING
C6328 xq_vg_p_2_.n1 vss 0.0259431f ; **FLOATING
C6329 xq_vg_p_2_.n2 vss 0.14935f ; **FLOATING
C6330 xq_dith_v_bq.n0 vss 0.168356f ; **FLOATING
C6331 xq_dith_v_bq.n1 vss 0.151329f ; **FLOATING
C6332 xq_dith_v_bq.n2 vss 0.349459f ; **FLOATING
C6333 xq_dith_v_bq.n3 vss 0.1715f ; **FLOATING
C6334 xq_dith_v_bq.n4 vss 0.240211f ; **FLOATING
C6335 xq_dith_v_bq.n5 vss 0.137359f ; **FLOATING
C6336 xq_dith_v_bq.n6 vss 0.235091f ; **FLOATING
C6337 xq_dith_v_bq.n7 vss 0.156307f ; **FLOATING
C6338 xq_dith_v_bq.n8 vss 0.171507f ; **FLOATING
C6339 xq_dith_v_bq.n9 vss 0.349459f ; **FLOATING
C6340 xq_dith_v_bq.n10 vss 0.0286186f ; **FLOATING
C6341 xq_dith_v_bq.n12 vss 0.349459f ; **FLOATING
C6342 xq_dith_v_bq.n13 vss 1.06482f ; **FLOATING
C6343 xq_dith_v_bq.n14 vss 0.0899264f ; **FLOATING
C6344 xq_dith_v_bq.n16 vss 0.430035f ; **FLOATING
C6345 xq_dith_v_bq.n17 vss 0.349568f ; **FLOATING
C6346 xq_dith_v_bq.n18 vss 0.43332f ; **FLOATING
C6347 xq_dith_v_bq.n19 vss 0.349568f ; **FLOATING
C6348 xq_dith_v_bq.n20 vss 0.437277f ; **FLOATING
C6349 xq_dith_v_bq.t6 vss 0.0637704f ; **FLOATING
C6350 xq_dith_v_bq.t13 vss 0.0473228f ; **FLOATING
C6351 xq_dith_v_bq.n21 vss 0.0363223f ; **FLOATING
C6352 xq_dith_v_bq.t5 vss 0.0693298f ; **FLOATING
C6353 xq_dith_v_bq.t12 vss 0.052884f ; **FLOATING
C6354 xq_dith_v_bq.n22 vss 0.0355273f ; **FLOATING
C6355 xq_dith_v_bq.n23 vss 0.0314212f ; **FLOATING
C6356 xq_dith_v_bq.t4 vss 0.0693298f ; **FLOATING
C6357 xq_dith_v_bq.t11 vss 0.052884f ; **FLOATING
C6358 xq_dith_v_bq.n24 vss 0.0355273f ; **FLOATING
C6359 xq_dith_v_bq.n25 vss 0.018211f ; **FLOATING
C6360 xq_dith_v_bq.t10 vss 0.052884f ; **FLOATING
C6361 xq_dith_v_bq.t3 vss 0.0693251f ; **FLOATING
C6362 xq_dith_v_bq.n26 vss 0.0355309f ; **FLOATING
C6363 xq_dith_v_bq.n27 vss 0.0182116f ; **FLOATING
C6364 xq_dith_v_bq.t2 vss 0.0693298f ; **FLOATING
C6365 xq_dith_v_bq.t9 vss 0.052884f ; **FLOATING
C6366 xq_dith_v_bq.n28 vss 0.0355273f ; **FLOATING
C6367 xq_dith_v_bq.n29 vss 0.018211f ; **FLOATING
C6368 xq_dith_v_bq.t1 vss 0.0693298f ; **FLOATING
C6369 xq_dith_v_bq.t8 vss 0.052884f ; **FLOATING
C6370 xq_dith_v_bq.n30 vss 0.0355273f ; **FLOATING
C6371 xq_dith_v_bq.n31 vss 0.017829f ; **FLOATING
C6372 xq_dith_v_bq.t0 vss 0.0637663f ; **FLOATING
C6373 xq_dith_v_bq.t7 vss 0.0473228f ; **FLOATING
C6374 xq_dith_v_bq.n32 vss 0.0355303f ; **FLOATING
C6375 xq_dith_v_bq.n33 vss 0.0876074f ; **FLOATING
C6376 xq_dith_v_bq.n34 vss 0.421737f ; **FLOATING
C6377 xq_dith_v_bq.n35 vss 0.421737f ; **FLOATING
C6378 xq_dith_v_bq.n36 vss 0.239225f ; **FLOATING
C6379 a_4362_8188.n0 vss 0.1195f ; **FLOATING
C6380 a_4362_8188.n1 vss 0.123206f ; **FLOATING
C6381 a_4362_8188.t3 vss 0.0512473f ; **FLOATING
C6382 a_4362_8188.t8 vss 0.0406741f ; **FLOATING
C6383 a_4362_8188.n2 vss 0.0284362f ; **FLOATING
C6384 a_4362_8188.t4 vss 0.0512497f ; **FLOATING
C6385 a_4362_8188.t10 vss 0.0406741f ; **FLOATING
C6386 a_4362_8188.n3 vss 0.0279564f ; **FLOATING
C6387 a_4362_8188.t5 vss 0.0512497f ; **FLOATING
C6388 a_4362_8188.t9 vss 0.0406741f ; **FLOATING
C6389 a_4362_8188.n4 vss 0.0279564f ; **FLOATING
C6390 a_4362_8188.t6 vss 0.0551324f ; **FLOATING
C6391 a_4362_8188.n5 vss 0.24929f ; **FLOATING
C6392 a_4362_8188.t7 vss 0.0165279f ; **FLOATING
C6393 a_4362_8188.n6 vss 0.158304f ; **FLOATING
C6394 a_4362_8188.t0 vss 0.0512497f ; **FLOATING
C6395 a_4362_8188.t11 vss 0.0406741f ; **FLOATING
C6396 a_4362_8188.n7 vss 0.0279564f ; **FLOATING
C6397 a_4362_8188.t1 vss 0.0512497f ; **FLOATING
C6398 a_4362_8188.t12 vss 0.0406741f ; **FLOATING
C6399 a_4362_8188.n8 vss 0.0279564f ; **FLOATING
C6400 a_4362_8188.t13 vss 0.0406741f ; **FLOATING
C6401 a_4362_8188.n9 vss 0.0285612f ; **FLOATING
C6402 a_4362_8188.t2 vss 0.0512473f ; **FLOATING
C6403 xq_dith_v_bp.n0 vss 1.5354f ; **FLOATING
C6404 xq_dith_v_bp.n1 vss 0.0551417f ; **FLOATING
C6405 xq_dith_v_bp.n2 vss 0.155675f ; **FLOATING
C6406 xq_dith_v_bp.n3 vss 0.202509f ; **FLOATING
C6407 xq_dith_v_bp.n4 vss 0.641053f ; **FLOATING
C6408 xq_dith_v_bp.n5 vss 0.241065f ; **FLOATING
C6409 xq_dith_v_bp.n6 vss 0.595673f ; **FLOATING
C6410 xq_dith_v_bp.n7 vss 0.286388f ; **FLOATING
C6411 xq_dith_v_bp.n8 vss 1.28265f ; **FLOATING
C6412 xq_dith_v_bp.t11 vss 0.0708453f ; **FLOATING
C6413 xq_dith_v_bp.t4 vss 0.0525766f ; **FLOATING
C6414 xq_dith_v_bp.n9 vss 0.0403587f ; **FLOATING
C6415 xq_dith_v_bp.t12 vss 0.0770264f ; **FLOATING
C6416 xq_dith_v_bp.t5 vss 0.058755f ; **FLOATING
C6417 xq_dith_v_bp.n10 vss 0.0394715f ; **FLOATING
C6418 xq_dith_v_bp.t13 vss 0.0770264f ; **FLOATING
C6419 xq_dith_v_bp.t6 vss 0.058755f ; **FLOATING
C6420 xq_dith_v_bp.n11 vss 0.0394715f ; **FLOATING
C6421 xq_dith_v_bp.t2 vss 0.0761326f ; **FLOATING
C6422 xq_dith_v_bp.n12 vss 0.0267115f ; **FLOATING
C6423 xq_dith_v_bp.t7 vss 0.058755f ; **FLOATING
C6424 xq_dith_v_bp.n13 vss 0.0155859f ; **FLOATING
C6425 xq_dith_v_bp.t3 vss 0.0770264f ; **FLOATING
C6426 xq_dith_v_bp.t8 vss 0.058755f ; **FLOATING
C6427 xq_dith_v_bp.n14 vss 0.0394715f ; **FLOATING
C6428 xq_dith_v_bp.t0 vss 0.0770264f ; **FLOATING
C6429 xq_dith_v_bp.t9 vss 0.058755f ; **FLOATING
C6430 xq_dith_v_bp.n15 vss 0.0394715f ; **FLOATING
C6431 xq_dith_v_bp.t1 vss 0.0708499f ; **FLOATING
C6432 xq_dith_v_bp.t10 vss 0.0525766f ; **FLOATING
C6433 xq_dith_v_bp.n16 vss 0.0394702f ; **FLOATING
C6434 xq_dith_v_bp.n17 vss 0.265879f ; **FLOATING
C6435 a_6453_8400.t3 vss 0.0537803f ; **FLOATING
C6436 a_6453_8400.t1 vss 0.0537803f ; **FLOATING
C6437 a_6453_8400.n0 vss 0.26903f ; **FLOATING
C6438 a_6453_8400.t2 vss 0.0187948f ; **FLOATING
C6439 a_6453_8400.n1 vss 0.371008f ; **FLOATING
C6440 a_6453_8400.t0 vss 0.0196064f ; **FLOATING
C6441 a_5994_8400.t1 vss 0.0315966f ; **FLOATING
C6442 a_5994_8400.t0 vss 0.0318445f ; **FLOATING
C6443 a_5994_8400.n0 vss 0.269259f ; **FLOATING
C6444 a_5994_8400.t3 vss 0.012979f ; **FLOATING
C6445 a_5994_8400.n1 vss 0.282201f ; **FLOATING
C6446 a_5994_8400.t2 vss 0.0135399f ; **FLOATING
C6447 a_11173_9488.t1 vss 0.0365041f ; **FLOATING
C6448 a_11173_9488.t0 vss 0.0367559f ; **FLOATING
C6449 a_11173_9488.n0 vss 0.289129f ; **FLOATING
C6450 a_11173_9488.t3 vss 0.0139371f ; **FLOATING
C6451 a_11173_9488.n1 vss 0.303026f ; **FLOATING
C6452 a_11173_9488.t2 vss 0.0145385f ; **FLOATING
C6453 a_12075_9628.t3 vss 0.0684404f ; **FLOATING
C6454 a_12075_9628.t0 vss 0.0684903f ; **FLOATING
C6455 a_12075_9628.n0 vss 0.292086f ; **FLOATING
C6456 a_12075_9628.t2 vss 0.0204067f ; **FLOATING
C6457 a_12075_9628.n1 vss 0.402799f ; **FLOATING
C6458 a_12075_9628.t1 vss 0.0212879f ; **FLOATING
C6459 a_6257_8400.t1 vss 0.0644825f ; **FLOATING
C6460 a_6257_8400.t0 vss 0.117179f ; **FLOATING
C6461 a_6257_8400.n0 vss 0.370703f ; **FLOATING
C6462 a_6257_8400.t3 vss 0.0237973f ; **FLOATING
C6463 a_6257_8400.n1 vss 0.310672f ; **FLOATING
C6464 a_6257_8400.t2 vss 0.0248258f ; **FLOATING
C6465 a_5798_8400.t3 vss 0.0139256f ; **FLOATING
C6466 a_5798_8400.t0 vss 0.0332599f ; **FLOATING
C6467 a_5798_8400.t1 vss 0.0332599f ; **FLOATING
C6468 a_5798_8400.n0 vss 0.260213f ; **FLOATING
C6469 a_5798_8400.n1 vss 0.250583f ; **FLOATING
C6470 a_5798_8400.t2 vss 0.0133482f ; **FLOATING
C6471 a_12075_9488.t3 vss 0.0142695f ; **FLOATING
C6472 a_12075_9488.t1 vss 0.0350719f ; **FLOATING
C6473 a_12075_9488.t0 vss 0.0350756f ; **FLOATING
C6474 a_12075_9488.n0 vss 0.266632f ; **FLOATING
C6475 a_12075_9488.n1 vss 0.256763f ; **FLOATING
C6476 a_12075_9488.t2 vss 0.013678f ; **FLOATING
C6477 a_13211_9308.t1 vss 0.0703849f ; **FLOATING
C6478 a_13211_9308.t0 vss 0.12958f ; **FLOATING
C6479 a_13211_9308.n0 vss 0.390855f ; **FLOATING
C6480 a_13211_9308.t3 vss 0.0250921f ; **FLOATING
C6481 a_13211_9308.n1 vss 0.327562f ; **FLOATING
C6482 a_13211_9308.t2 vss 0.0261761f ; **FLOATING
C6483 a_5892_8400.t3 vss 0.00622261f ; **FLOATING
C6484 a_5892_8400.t2 vss 0.00596496f ; **FLOATING
C6485 a_5892_8400.n0 vss 0.0124861f ; **FLOATING
C6486 a_5892_8400.t15 vss 0.00622261f ; **FLOATING
C6487 a_5892_8400.t9 vss 0.00596496f ; **FLOATING
C6488 a_5892_8400.n1 vss 0.0122047f ; **FLOATING
C6489 a_5892_8400.t14 vss 0.00622261f ; **FLOATING
C6490 a_5892_8400.t12 vss 0.00596496f ; **FLOATING
C6491 a_5892_8400.n2 vss 0.0124861f ; **FLOATING
C6492 a_5892_8400.n3 vss 0.0367193f ; **FLOATING
C6493 a_5892_8400.t7 vss 0.00622261f ; **FLOATING
C6494 a_5892_8400.t8 vss 0.00596496f ; **FLOATING
C6495 a_5892_8400.n4 vss 0.0148859f ; **FLOATING
C6496 a_5892_8400.n5 vss 0.176587f ; **FLOATING
C6497 a_5892_8400.t10 vss 0.00622261f ; **FLOATING
C6498 a_5892_8400.t1 vss 0.00596496f ; **FLOATING
C6499 a_5892_8400.n6 vss 0.0148859f ; **FLOATING
C6500 a_5892_8400.t4 vss 0.00692434f ; **FLOATING
C6501 a_5892_8400.t5 vss 0.00666669f ; **FLOATING
C6502 a_5892_8400.n7 vss 0.0190109f ; **FLOATING
C6503 a_5892_8400.t13 vss 0.00692434f ; **FLOATING
C6504 a_5892_8400.t6 vss 0.00666669f ; **FLOATING
C6505 a_5892_8400.n8 vss 0.0126882f ; **FLOATING
C6506 a_5892_8400.n9 vss 0.0351966f ; **FLOATING
C6507 a_5892_8400.n10 vss 0.0283056f ; **FLOATING
C6508 a_5892_8400.n11 vss 0.222881f ; **FLOATING
C6509 a_5892_8400.n12 vss 0.0230394f ; **FLOATING
C6510 a_5892_8400.t11 vss 0.00596496f ; **FLOATING
C6511 a_5892_8400.n13 vss 0.0122047f ; **FLOATING
C6512 a_5892_8400.t0 vss 0.00622261f ; **FLOATING
C6513 a_6249_9100.t9 vss 0.00608057f ; **FLOATING
C6514 a_6249_9100.t10 vss 0.00608057f ; **FLOATING
C6515 a_6249_9100.t2 vss 0.00582883f ; **FLOATING
C6516 a_6249_9100.n0 vss 0.0145465f ; **FLOATING
C6517 a_6249_9100.t14 vss 0.0067662f ; **FLOATING
C6518 a_6249_9100.t7 vss 0.00651446f ; **FLOATING
C6519 a_6249_9100.n1 vss 0.0123986f ; **FLOATING
C6520 a_6249_9100.t5 vss 0.0067662f ; **FLOATING
C6521 a_6249_9100.t6 vss 0.00651446f ; **FLOATING
C6522 a_6249_9100.n2 vss 0.0185769f ; **FLOATING
C6523 a_6249_9100.n3 vss 0.0343933f ; **FLOATING
C6524 a_6249_9100.n4 vss 0.0276598f ; **FLOATING
C6525 a_6249_9100.t12 vss 0.00608057f ; **FLOATING
C6526 a_6249_9100.t11 vss 0.00582883f ; **FLOATING
C6527 a_6249_9100.n5 vss 0.0119263f ; **FLOATING
C6528 a_6249_9100.t8 vss 0.00608057f ; **FLOATING
C6529 a_6249_9100.t3 vss 0.00582883f ; **FLOATING
C6530 a_6249_9100.n6 vss 0.0122011f ; **FLOATING
C6531 a_6249_9100.n7 vss 0.0225136f ; **FLOATING
C6532 a_6249_9100.n8 vss 0.202418f ; **FLOATING
C6533 a_6249_9100.t1 vss 0.00608057f ; **FLOATING
C6534 a_6249_9100.t13 vss 0.00582883f ; **FLOATING
C6535 a_6249_9100.n9 vss 0.0122011f ; **FLOATING
C6536 a_6249_9100.t15 vss 0.00608057f ; **FLOATING
C6537 a_6249_9100.t4 vss 0.00582883f ; **FLOATING
C6538 a_6249_9100.n10 vss 0.0119263f ; **FLOATING
C6539 a_6249_9100.n11 vss 0.0284069f ; **FLOATING
C6540 a_6249_9100.n12 vss 0.216692f ; **FLOATING
C6541 a_6249_9100.n13 vss 0.0204025f ; **FLOATING
C6542 a_6249_9100.t0 vss 0.00582883f ; **FLOATING
C6543 clk_noverlap_0.sg13cmos5l_dlygate4sd3_1_0.A.t2 vss 0.0234654f ; **FLOATING
C6544 clk_noverlap_0.sg13cmos5l_dlygate4sd3_1_0.A.t0 vss 0.01561f ; **FLOATING
C6545 clk_noverlap_0.sg13cmos5l_dlygate4sd3_1_0.A.t1 vss 0.0236005f ; **FLOATING
C6546 clk_noverlap_0.di_clk.t0 vss 0.0217817f ; **FLOATING
C6547 clk_noverlap_0.di_clk.t1 vss 0.0325421f ; **FLOATING
C6548 clk_noverlap_0.di_clk.t2 vss 0.0424971f ; **FLOATING
C6549 quantizer2_lfsr_0.sg13cmos5l_dfrbpq_1_2.Q.t0 vss 0.0157313f ; **FLOATING
C6550 quantizer2_lfsr_0.sg13cmos5l_dfrbpq_1_2.Q.t1 vss 0.0220924f ; **FLOATING
C6551 quantizer2_lfsr_0.sg13cmos5l_dfrbpq_1_2.Q.t2 vss 0.0239614f ; **FLOATING
C6552 quantizer2_lfsr_0.sg13cmos5l_dfrbpq_1_2.Q.t3 vss 0.0229762f ; **FLOATING
C6553 quantizer2_lfsr_0.sg13cmos5l_dfrbpq_1_2.Q.n0 vss 0.223673f ; **FLOATING
C6554 xvcm_vcf_b.n0 vss 0.777554f ; **FLOATING
C6555 xvcm_vcf_b.n1 vss 0.745282f ; **FLOATING
C6556 xvcm_vcf_b.t1 vss 0.1628f ; **FLOATING
C6557 xvcm_vcf_b.t0 vss 0.22239f ; **FLOATING
C6558 xvcm_vcf_t.n0 vss 0.256038f ; **FLOATING
C6559 xvcm_vcf_t.t1 vss 0.0702627f ; **FLOATING
C6560 xvcm_vcf_t.t0 vss 0.0637252f ; **FLOATING
C6561 xvcm_vcf_t.n1 vss 0.202137f ; **FLOATING
C6562 xvcm_vcf_t.n2 vss 0.233117f ; **FLOATING
C6563 quantizer2_lfsr_0.sg13cmos5l_dfrbpq_1_11.Q.t2 vss 0.023894f ; **FLOATING
C6564 quantizer2_lfsr_0.sg13cmos5l_dfrbpq_1_11.Q.t3 vss 0.022893f ; **FLOATING
C6565 quantizer2_lfsr_0.sg13cmos5l_dfrbpq_1_11.Q.n0 vss 0.152213f ; **FLOATING
C6566 quantizer2_lfsr_0.sg13cmos5l_dfrbpq_1_11.Q.t0 vss 0.0159718f ; **FLOATING
C6567 quantizer2_lfsr_0.sg13cmos5l_dfrbpq_1_11.Q.t1 vss 0.0219813f ; **FLOATING
C6568 dsm2_osc_0.ibias_in.n0 vss 0.150025f ; **FLOATING
C6569 dsm2_osc_0.ibias_in.t3 vss 0.0521659f ; **FLOATING
C6570 dsm2_osc_0.ibias_in.t4 vss 0.0258553f ; **FLOATING
C6571 dsm2_osc_0.ibias_in.n1 vss 0.530272f ; **FLOATING
C6572 dsm2_osc_0.ibias_in.t5 vss 0.0258553f ; **FLOATING
C6573 dsm2_osc_0.ibias_in.n2 vss 0.32224f ; **FLOATING
C6574 dsm2_osc_0.ibias_in.t0 vss 0.0369416f ; **FLOATING
C6575 dsm2_osc_0.ibias_in.t1 vss 0.0775515f ; **FLOATING
C6576 dsm2_osc_0.ibias_in.t2 vss 0.0368517f ; **FLOATING
C6577 dsm2_osc_0.sg13cmos5l_dfrbp_1_0.RESET_B.n0 vss 0.159272f ; **FLOATING
C6578 dsm2_osc_0.sg13cmos5l_dfrbp_1_0.RESET_B.t0 vss 0.0159593f ; **FLOATING
C6579 dsm2_osc_0.sg13cmos5l_dfrbp_1_0.RESET_B.t7 vss 0.0411754f ; **FLOATING
C6580 dsm2_osc_0.sg13cmos5l_dfrbp_1_0.RESET_B.t4 vss 0.0448016f ; **FLOATING
C6581 dsm2_osc_0.sg13cmos5l_dfrbp_1_0.RESET_B.n1 vss 0.026465f ; **FLOATING
C6582 dsm2_osc_0.sg13cmos5l_dfrbp_1_0.RESET_B.t5 vss 0.0470763f ; **FLOATING
C6583 dsm2_osc_0.sg13cmos5l_dfrbp_1_0.RESET_B.n2 vss 0.0638884f ; **FLOATING
C6584 dsm2_osc_0.sg13cmos5l_dfrbp_1_0.RESET_B.t3 vss 0.0534812f ; **FLOATING
C6585 dsm2_osc_0.sg13cmos5l_dfrbp_1_0.RESET_B.t2 vss 0.113952f ; **FLOATING
C6586 dsm2_osc_0.sg13cmos5l_dfrbp_1_0.RESET_B.n3 vss 0.128491f ; **FLOATING
C6587 dsm2_osc_0.sg13cmos5l_dfrbp_1_0.RESET_B.t6 vss 0.0297288f ; **FLOATING
C6588 dsm2_osc_0.sg13cmos5l_dfrbp_1_0.RESET_B.t9 vss 0.0164014f ; **FLOATING
C6589 dsm2_osc_0.sg13cmos5l_dfrbp_1_0.RESET_B.t11 vss 0.0487894f ; **FLOATING
C6590 dsm2_osc_0.sg13cmos5l_dfrbp_1_0.RESET_B.n4 vss 0.15707f ; **FLOATING
C6591 dsm2_osc_0.sg13cmos5l_dfrbp_1_0.RESET_B.t10 vss 0.0285228f ; **FLOATING
C6592 dsm2_osc_0.sg13cmos5l_dfrbp_1_0.RESET_B.t8 vss 0.0250317f ; **FLOATING
C6593 dsm2_osc_0.sg13cmos5l_dfrbp_1_0.RESET_B.n5 vss 0.112449f ; **FLOATING
C6594 dsm2_osc_0.sg13cmos5l_dfrbp_1_0.RESET_B.n6 vss 0.0819547f ; **FLOATING
C6595 dsm2_osc_0.sg13cmos5l_dfrbp_1_0.RESET_B.t1 vss 0.0231489f ; **FLOATING
C6596 a_21452_2308.n0 vss 0.167878f ; **FLOATING
C6597 a_21452_2308.t5 vss 0.23135f ; **FLOATING
C6598 a_21452_2308.t1 vss 0.0179797f ; **FLOATING
C6599 a_21452_2308.t0 vss 0.0206807f ; **FLOATING
C6600 a_21452_2308.n1 vss 0.0320517f ; **FLOATING
C6601 a_21452_2308.t6 vss 0.115798f ; **FLOATING
C6602 a_21452_2308.t4 vss 0.104425f ; **FLOATING
C6603 a_21452_2308.n2 vss 0.47722f ; **FLOATING
C6604 a_21452_2308.t3 vss 0.0185654f ; **FLOATING
C6605 a_21452_2308.n3 vss 0.031662f ; **FLOATING
C6606 a_21452_2308.t2 vss 0.0179797f ; **FLOATING
C6607 dsm2_osc_0.dsm2_io_rx_0.di_b.t3 vss 0.0468668f ; **FLOATING
C6608 dsm2_osc_0.dsm2_io_rx_0.di_b.t6 vss 0.0472313f ; **FLOATING
C6609 dsm2_osc_0.dsm2_io_rx_0.di_b.t5 vss 0.0418732f ; **FLOATING
C6610 dsm2_osc_0.dsm2_io_rx_0.di_b.t2 vss 0.0548063f ; **FLOATING
C6611 dsm2_osc_0.dsm2_io_rx_0.di_b.t4 vss 0.056763f ; **FLOATING
C6612 dsm2_osc_0.dsm2_io_rx_0.di_b.n0 vss 0.286824f ; **FLOATING
C6613 dsm2_osc_0.dsm2_io_rx_0.di_b.n1 vss 0.183571f ; **FLOATING
C6614 dsm2_osc_0.dsm2_io_rx_0.di_b.n2 vss 0.215199f ; **FLOATING
C6615 dsm2_osc_0.dsm2_io_rx_0.di_b.n3 vss 0.0917553f ; **FLOATING
C6616 dsm2_osc_0.dsm2_io_rx_0.di_b.t1 vss 0.0201112f ; **FLOATING
C6617 dsm2_osc_0.dsm2_io_rx_0.di_b.t0 vss 0.0425131f ; **FLOATING
C6618 a_21554_2052.n0 vss 0.42781f ; **FLOATING
C6619 a_21554_2052.t3 vss 0.0301115f ; **FLOATING
C6620 a_21554_2052.t2 vss 0.0926475f ; **FLOATING
C6621 a_21554_2052.t6 vss 0.0926988f ; **FLOATING
C6622 a_21554_2052.t10 vss 0.0930485f ; **FLOATING
C6623 a_21554_2052.t9 vss 0.0925029f ; **FLOATING
C6624 a_21554_2052.n1 vss 0.188471f ; **FLOATING
C6625 a_21554_2052.t7 vss 0.0930252f ; **FLOATING
C6626 a_21554_2052.t8 vss 0.0925029f ; **FLOATING
C6627 a_21554_2052.n2 vss 0.184721f ; **FLOATING
C6628 a_21554_2052.n3 vss 0.416575f ; **FLOATING
C6629 a_21554_2052.t5 vss 0.0950305f ; **FLOATING
C6630 a_21554_2052.t0 vss 0.0925029f ; **FLOATING
C6631 a_21554_2052.t1 vss 0.0408093f ; **FLOATING
C6632 a_21554_2052.n4 vss 0.075337f ; **FLOATING
C6633 a_21554_2052.t4 vss 0.0651661f ; **FLOATING
C6634 dsm2_osc_0.ibias_pad.t3 vss 0.341051f ; **FLOATING
C6635 dsm2_osc_0.ibias_pad.t2 vss 0.231043f ; **FLOATING
C6636 dsm2_osc_0.ibias_pad.t1 vss 0.191216f ; **FLOATING
C6637 dsm2_osc_0.ibias_pad.t0 vss 0.100644f ; **FLOATING
C6638 vss.t484 vss 0.54993f ; **FLOATING
C6639 vss.t883 vss 0.55182f ; **FLOATING
C6640 vss.t483 vss 0.54993f ; **FLOATING
C6641 vss.t930 vss 0.34034f ; **FLOATING
C6642 vss.t884 vss 0.55182f ; **FLOATING
C6643 vss.t1186 vss 0.62001f ; **FLOATING
C6644 vss.t672 vss 0.71541f ; **FLOATING
C6645 vss.t1185 vss 0.62001f ; **FLOATING
C6646 vss.t671 vss 0.71541f ; **FLOATING
C6647 vss.t695 vss 0.38914f ; **FLOATING
C6648 vss.t1224 vss 0.38145f ; **FLOATING
C6649 vss.t1246 vss 0.48125f ; **FLOATING
C6650 vss.t1226 vss 0.71981f ; **FLOATING
C6651 vss.t872 vss 0.62823f ; **FLOATING
C6652 vss.t1227 vss 0.71981f ; **FLOATING
C6653 vss.t1352 vss 0.15603f ; **FLOATING
C6654 vss.t691 vss 0.18226f ; **FLOATING
C6655 vss.t1265 vss 1.03681f ; **FLOATING
C6656 vss.t1266 vss 0.15517f ; **FLOATING
C6657 vss.t1193 vss 0.84184f ; **FLOATING
C6658 vss.t1267 vss 0.15517f ; **FLOATING
C6659 vss.t1321 vss 0.12155f ; **FLOATING
C6660 vss.t2138 vss 0.11694f ; **FLOATING
C6661 vss.t1273 vss 0.11424f ; **FLOATING
C6662 vss.t1379 vss 0.11255f ; **FLOATING
C6663 vss.t1174 vss 0.11147f ; **FLOATING
C6664 vss.t1261 vss 0.1106f ; **FLOATING
C6665 vss.t647 vss 0.11013f ; **FLOATING
C6666 vss.t210 vss 0.10981f ; **FLOATING
C6667 vss.t1330 vss 0.10957f ; **FLOATING
C6668 vss.t2073 vss 0.10967f ; **FLOATING
C6669 vss.t809 vss 0.11f ; **FLOATING
C6670 vss.t1388 vss 0.10946f ; **FLOATING
C6671 vss.t1281 vss 0.10974f ; **FLOATING
C6672 vss.t1327 vss 0.11007f ; **FLOATING
C6673 vss.t1166 vss 0.11048f ; **FLOATING
C6674 vss.t732 vss 0.11106f ; **FLOATING
C6675 vss.t1158 vss 0.11196f ; **FLOATING
C6676 vss.t41 vss 0.11328f ; **FLOATING
C6677 vss.t1345 vss 0.11525f ; **FLOATING
C6678 vss.t801 vss 0.11819f ; **FLOATING
C6679 vss.t1269 vss 0.12646f ; **FLOATING
C6680 vss.t2132 vss 0.18204f ; **FLOATING
C6681 vss.t211 vss 0.62286f ; **FLOATING
C6682 vss.t1376 vss 1.03189f ; **FLOATING
C6683 vss.t1377 vss 1.03189f ; **FLOATING
C6684 vss.t2131 vss 0.18204f ; **FLOATING
C6685 vss.t1268 vss 0.12646f ; **FLOATING
C6686 vss.t800 vss 0.11819f ; **FLOATING
C6687 vss.t1344 vss 0.11525f ; **FLOATING
C6688 vss.t40 vss 0.11328f ; **FLOATING
C6689 vss.t1157 vss 0.11196f ; **FLOATING
C6690 vss.t731 vss 0.11106f ; **FLOATING
C6691 vss.t1165 vss 0.11048f ; **FLOATING
C6692 vss.t1326 vss 0.11007f ; **FLOATING
C6693 vss.t1280 vss 0.10974f ; **FLOATING
C6694 vss.t1387 vss 0.10946f ; **FLOATING
C6695 vss.t808 vss 0.11f ; **FLOATING
C6696 vss.t2072 vss 0.10967f ; **FLOATING
C6697 vss.t1329 vss 0.10957f ; **FLOATING
C6698 vss.t209 vss 0.10981f ; **FLOATING
C6699 vss.t646 vss 0.11013f ; **FLOATING
C6700 vss.t1260 vss 0.1106f ; **FLOATING
C6701 vss.t1173 vss 0.11147f ; **FLOATING
C6702 vss.t1378 vss 0.11255f ; **FLOATING
C6703 vss.t1272 vss 0.11424f ; **FLOATING
C6704 vss.t2137 vss 0.11694f ; **FLOATING
C6705 vss.t1320 vss 0.12155f ; **FLOATING
C6706 vss.t1194 vss 0.84184f ; **FLOATING
C6707 vss.t2071 vss 0.84996f ; **FLOATING
C6708 vss.t1264 vss 1.03681f ; **FLOATING
C6709 vss.t692 vss 0.18226f ; **FLOATING
C6710 vss.t2070 vss 0.84996f ; **FLOATING
C6711 vss.t1353 vss 0.15603f ; **FLOATING
C6712 vss.t817 vss 0.1236f ; **FLOATING
C6713 vss.t706 vss 0.119f ; **FLOATING
C6714 vss.t807 vss 0.11629f ; **FLOATING
C6715 vss.t658 vss 0.1146f ; **FLOATING
C6716 vss.t562 vss 0.11352f ; **FLOATING
C6717 vss.t2089 vss 0.11265f ; **FLOATING
C6718 vss.t803 vss 0.11218f ; **FLOATING
C6719 vss.t820 vss 0.11186f ; **FLOATING
C6720 vss.t1168 vss 0.11162f ; **FLOATING
C6721 vss.t656 vss 0.11144f ; **FLOATING
C6722 vss.t789 vss 0.112f ; **FLOATING
C6723 vss.t1303 vss 0.11144f ; **FLOATING
C6724 vss.t1259 vss 0.1117f ; **FLOATING
C6725 vss.t533 vss 0.112f ; **FLOATING
C6726 vss.t1300 vss 0.11236f ; **FLOATING
C6727 vss.t1001 vss 0.11288f ; **FLOATING
C6728 vss.t1156 vss 0.11367f ; **FLOATING
C6729 vss.t858 vss 0.11484f ; **FLOATING
C6730 vss.t1275 vss 0.11666f ; **FLOATING
C6731 vss.t1048 vss 0.1196f ; **FLOATING
C6732 vss.t1347 vss 0.12352f ; **FLOATING
C6733 vss.t1346 vss 0.12352f ; **FLOATING
C6734 vss.t1047 vss 0.1196f ; **FLOATING
C6735 vss.t1274 vss 0.11666f ; **FLOATING
C6736 vss.t857 vss 0.11484f ; **FLOATING
C6737 vss.t1155 vss 0.11367f ; **FLOATING
C6738 vss.t1000 vss 0.11288f ; **FLOATING
C6739 vss.t1299 vss 0.11236f ; **FLOATING
C6740 vss.t532 vss 0.112f ; **FLOATING
C6741 vss.t1258 vss 0.1117f ; **FLOATING
C6742 vss.t1302 vss 0.11144f ; **FLOATING
C6743 vss.t788 vss 0.112f ; **FLOATING
C6744 vss.t655 vss 0.11144f ; **FLOATING
C6745 vss.t1167 vss 0.11162f ; **FLOATING
C6746 vss.t819 vss 0.11186f ; **FLOATING
C6747 vss.t802 vss 0.11218f ; **FLOATING
C6748 vss.t2088 vss 0.11265f ; **FLOATING
C6749 vss.t561 vss 0.11352f ; **FLOATING
C6750 vss.t657 vss 0.1146f ; **FLOATING
C6751 vss.t806 vss 0.11629f ; **FLOATING
C6752 vss.t705 vss 0.119f ; **FLOATING
C6753 vss.t816 vss 0.1236f ; **FLOATING
C6754 vss.t871 vss 0.62823f ; **FLOATING
C6755 vss.t528 vss 0.40316f ; **FLOATING
C6756 vss.t1051 vss 0.39547f ; **FLOATING
C6757 vss.t1262 vss 0.48904f ; **FLOATING
C6758 vss.t529 vss 0.40316f ; **FLOATING
C6759 vss.t1052 vss 0.39547f ; **FLOATING
C6760 vss.t214 vss 0.5335f ; **FLOATING
C6761 vss.t1263 vss 0.48904f ; **FLOATING
C6762 vss.t213 vss 0.5335f ; **FLOATING
C6763 vss.t1307 vss 0.52893f ; **FLOATING
C6764 vss.t1308 vss 0.52893f ; **FLOATING
C6765 vss.t1245 vss 0.48125f ; **FLOATING
C6766 vss.t1223 vss 0.38145f ; **FLOATING
C6767 vss.t694 vss 0.38914f ; **FLOATING
C6768 vss.t1201 vss 0.99629f ; **FLOATING
C6769 vss.t1188 vss 0.99626f ; **FLOATING
C6770 vss.t1189 vss 0.99626f ; **FLOATING
C6771 vss.t1202 vss 0.99629f ; **FLOATING
C9985 d_ena.n0 vss 0.522347f ; **FLOATING
C9986 d_ena.t4 vss 0.565847f ; **FLOATING
C9987 d_ena.t5 vss 0.223232f ; **FLOATING
C9988 d_ena.n1 vss 0.720587f ; **FLOATING
C9989 d_ena.t10 vss 0.171785f ; **FLOATING
C9990 d_ena.n2 vss 2.71001f ; **FLOATING
C9991 d_ena.t8 vss 0.376177f ; **FLOATING
C9992 d_ena.t6 vss 0.0624228f ; **FLOATING
C9993 d_ena.n3 vss 0.912567f ; **FLOATING
C9994 d_ena.t9 vss 0.231968f ; **FLOATING
C9995 d_ena.t7 vss 0.0871992f ; **FLOATING
C9996 d_ena.n4 vss 0.0823327f ; **FLOATING
C9997 d_ena.n5 vss 0.207662f ; **FLOATING
C9998 d_ena.t3 vss 0.0466208f ; **FLOATING
C9999 d_ena.t2 vss 0.0538394f ; **FLOATING
C10000 d_ena.n6 vss 0.614273f ; **FLOATING
C10001 d_ena.n7 vss 3.15316f ; **FLOATING
C10002 d_ena.t0 vss 0.0617371f ; **FLOATING
C10003 d_ena.t1 vss 0.0544423f ; **FLOATING
C10004 d_ena.t14 vss 3.86215f ; **FLOATING
C10005 d_ena.t11 vss 3.76982f ; **FLOATING
C10006 d_ena.n8 vss 1.02973f ; **FLOATING
C10007 d_ena.n9 vss 2.94482f ; **FLOATING
C10008 d_ena.n10 vss 2.31341f ; **FLOATING
C10009 d_ena.t12 vss 0.402152f ; **FLOATING
C10010 d_ena.t13 vss 0.385297f ; **FLOATING
C10011 vo_p.n0 vss 0.144285f ; **FLOATING
C10012 vo_p.n1 vss 0.153881f ; **FLOATING
C10013 vo_p.t12 vss 0.043573f ; **FLOATING
C10014 vo_p.t1 vss 0.0131438f ; **FLOATING
C10015 vo_p.t0 vss 0.012359f ; **FLOATING
C10016 vo_p.t23 vss 0.0394198f ; **FLOATING
C10017 vo_p.t13 vss 0.0405038f ; **FLOATING
C10018 vo_p.t14 vss 0.0137414f ; **FLOATING
C10019 vo_p.t4 vss 0.0394189f ; **FLOATING
C10020 vo_p.t5 vss 0.0405514f ; **FLOATING
C10021 vo_p.t2 vss 0.0131385f ; **FLOATING
C10022 vo_p.t3 vss 0.012352f ; **FLOATING
C10023 vo_p.n2 vss 8.20865f ; **FLOATING
C10024 vo_p.t22 vss 0.136961f ; **FLOATING
C10025 vo_p.t21 vss 0.126237f ; **FLOATING
C10026 vo_p.n3 vss 0.176577f ; **FLOATING
C10027 vo_p.t20 vss 0.126237f ; **FLOATING
C10028 vo_p.n4 vss 0.122137f ; **FLOATING
C10029 vo_p.t19 vss 0.126237f ; **FLOATING
C10030 vo_p.n5 vss 0.122687f ; **FLOATING
C10031 vo_p.t18 vss 0.12937f ; **FLOATING
C10032 vo_p.n6 vss 0.134574f ; **FLOATING
C10033 vo_p.t8 vss 0.0215808f ; **FLOATING
C10034 vo_p.t6 vss 0.0376464f ; **FLOATING
C10035 vo_p.t7 vss 0.0309456f ; **FLOATING
C10036 vo_p.n7 vss 0.36211f ; **FLOATING
C10037 vo_p.n8 vss 0.099159f ; **FLOATING
C10038 vo_p.n9 vss 0.238024f ; **FLOATING
C10039 vo_p.n10 vss 36.3267f ; **FLOATING
C10040 vo_p.t24 vss 0.951329f ; **FLOATING
C10041 vo_p.t11 vss 0.112849f ; **FLOATING
C10042 vo_p.t16 vss 0.0980794f ; **FLOATING
C10043 vo_p.n11 vss 0.0655864f ; **FLOATING
C10044 vo_p.n12 vss 0.332686f ; **FLOATING
C10045 vo_p.t10 vss 0.112849f ; **FLOATING
C10046 vo_p.t15 vss 0.0980777f ; **FLOATING
C10047 vo_p.n13 vss 0.0655881f ; **FLOATING
C10048 vo_p.n14 vss 0.0288386f ; **FLOATING
C10049 vo_p.t9 vss 0.112849f ; **FLOATING
C10050 vo_p.t17 vss 0.0980794f ; **FLOATING
C10051 vo_p.n15 vss 0.0655864f ; **FLOATING
C10052 vo_p.n16 vss 0.102783f ; **FLOATING
C10053 vo_n.n0 vss 0.154063f ; **FLOATING
C10054 vo_n.n1 vss 0.144466f ; **FLOATING
C10055 vo_n.t6 vss 0.0137553f ; **FLOATING
C10056 vo_n.t24 vss 0.952498f ; **FLOATING
C10057 vo_n.t15 vss 0.112989f ; **FLOATING
C10058 vo_n.t9 vss 0.0981993f ; **FLOATING
C10059 vo_n.n2 vss 0.0656677f ; **FLOATING
C10060 vo_n.n3 vss 0.333096f ; **FLOATING
C10061 vo_n.t16 vss 0.112989f ; **FLOATING
C10062 vo_n.t10 vss 0.0982002f ; **FLOATING
C10063 vo_n.n4 vss 0.0656668f ; **FLOATING
C10064 vo_n.n5 vss 0.0288739f ; **FLOATING
C10065 vo_n.t17 vss 0.112989f ; **FLOATING
C10066 vo_n.t11 vss 0.0981993f ; **FLOATING
C10067 vo_n.n6 vss 0.0656677f ; **FLOATING
C10068 vo_n.n7 vss 0.102821f ; **FLOATING
C10069 vo_n.t23 vss 0.0394814f ; **FLOATING
C10070 vo_n.t7 vss 0.040595f ; **FLOATING
C10071 vo_n.t2 vss 0.0123708f ; **FLOATING
C10072 vo_n.t3 vss 0.0131551f ; **FLOATING
C10073 vo_n.t8 vss 0.0436419f ; **FLOATING
C10074 vo_n.t0 vss 0.0131605f ; **FLOATING
C10075 vo_n.t1 vss 0.0123708f ; **FLOATING
C10076 vo_n.t5 vss 0.0405534f ; **FLOATING
C10077 vo_n.t4 vss 0.039453f ; **FLOATING
C10078 vo_n.n8 vss 8.21876f ; **FLOATING
C10079 vo_n.t22 vss 0.129493f ; **FLOATING
C10080 vo_n.t18 vss 0.137191f ; **FLOATING
C10081 vo_n.t19 vss 0.126295f ; **FLOATING
C10082 vo_n.n9 vss 0.176829f ; **FLOATING
C10083 vo_n.t20 vss 0.126295f ; **FLOATING
C10084 vo_n.n10 vss 0.122384f ; **FLOATING
C10085 vo_n.t21 vss 0.126295f ; **FLOATING
C10086 vo_n.n11 vss 0.122935f ; **FLOATING
C10087 vo_n.n12 vss 0.136296f ; **FLOATING
C10088 vo_n.t12 vss 0.0216072f ; **FLOATING
C10089 vo_n.t14 vss 0.0376932f ; **FLOATING
C10090 vo_n.t13 vss 0.0309842f ; **FLOATING
C10091 vo_n.n13 vss 0.362556f ; **FLOATING
C10092 vo_n.n14 vss 0.099281f ; **FLOATING
C10093 vo_n.n15 vss 0.239699f ; **FLOATING
C10094 vo_n.n16 vss 36.3654f ; **FLOATING
C10095 ibias_200n.n0 vss 0.94627f ; **FLOATING
C10096 ibias_200n.n1 vss 1.86233f ; **FLOATING
C10097 ibias_200n.n2 vss 0.722699f ; **FLOATING
C10098 ibias_200n.t1 vss 0.0250718f ; **FLOATING
C10099 ibias_200n.t0 vss 0.0250718f ; **FLOATING
C10100 ibias_200n.n3 vss 0.286273f ; **FLOATING
C10101 ibias_200n.t2 vss 0.0261283f ; **FLOATING
C10102 ibias_200n.t4 vss 0.0250718f ; **FLOATING
C10103 ibias_200n.t3 vss 0.0250718f ; **FLOATING
C10104 ibias_200n.n4 vss 0.28233f ; **FLOATING
C10105 ibias_200n.t6 vss 0.88578f ; **FLOATING
C10106 ibias_200n.t7 vss 0.88578f ; **FLOATING
C10107 ibias_200n.t8 vss 0.88578f ; **FLOATING
C10108 ibias_200n.t9 vss 0.88578f ; **FLOATING
C10109 ibias_200n.t5 vss 0.162787f ; **FLOATING
C10110 d_phi1.n0 vss 0.184935f ; **FLOATING
C10111 d_phi1.n1 vss 0.959958f ; **FLOATING
C10112 d_phi1.t8 vss 0.648929f ; **FLOATING
C10113 d_phi1.t12 vss 0.642595f ; **FLOATING
C10114 d_phi1.n2 vss 0.599817f ; **FLOATING
C10115 d_phi1.t10 vss 0.0678296f ; **FLOATING
C10116 d_phi1.t9 vss 0.773717f ; **FLOATING
C10117 d_phi1.t11 vss 0.770437f ; **FLOATING
C10118 d_phi1.n3 vss 0.280216f ; **FLOATING
C10119 d_phi1.t7 vss 0.0678296f ; **FLOATING
C10120 d_phi1.t6 vss 0.736369f ; **FLOATING
C10121 d_phi1.t3 vss 0.84607f ; **FLOATING
C10122 d_phi1.t4 vss 0.783799f ; **FLOATING
C10123 d_phi1.n4 vss 0.748598f ; **FLOATING
C10124 d_phi1.t5 vss 0.882934f ; **FLOATING
C10125 d_phi1.n5 vss 0.813478f ; **FLOATING
C10126 d_phi1.t0 vss 0.0193458f ; **FLOATING
C10127 d_phi1.t1 vss 0.0319838f ; **FLOATING
C10128 d_phi1.n6 vss 0.0434067f ; **FLOATING
C10129 d_phi1.t2 vss 0.073376f ; **FLOATING
C10130 d_phi1.n7 vss 1.26459f ; **FLOATING
C10131 d_phi2.n0 vss 1.0019f ; **FLOATING
C10132 d_phi2.n1 vss 1.15388f ; **FLOATING
C10133 d_phi2.t14 vss 0.0717353f ; **FLOATING
C10134 d_phi2.t9 vss 0.760681f ; **FLOATING
C10135 d_phi2.t11 vss 0.764248f ; **FLOATING
C10136 d_phi2.n2 vss 0.306069f ; **FLOATING
C10137 d_phi2.t12 vss 0.674895f ; **FLOATING
C10138 d_phi2.t10 vss 0.0665797f ; **FLOATING
C10139 d_phi2.t13 vss 0.594692f ; **FLOATING
C10140 d_phi2.t8 vss 0.594102f ; **FLOATING
C10141 d_phi2.n3 vss 0.234134f ; **FLOATING
C10142 d_phi2.t5 vss 0.863153f ; **FLOATING
C10143 d_phi2.t7 vss 0.826961f ; **FLOATING
C10144 d_phi2.t6 vss 0.766653f ; **FLOATING
C10145 d_phi2.n4 vss 0.719194f ; **FLOATING
C10146 d_phi2.n5 vss 0.791084f ; **FLOATING
C10147 d_phi2.n6 vss 0.396972f ; **FLOATING
C10148 d_phi2.t3 vss 0.0449369f ; **FLOATING
C10149 d_phi2.t4 vss 0.119906f ; **FLOATING
C10150 d_phi2.n7 vss 0.454516f ; **FLOATING
C10151 d_phi2.t0 vss 0.0206582f ; **FLOATING
C10152 d_phi2.t1 vss 0.0287227f ; **FLOATING
C10153 d_phi2.n8 vss 0.223434f ; **FLOATING
C10154 d_phi2.t2 vss 0.106887f ; **FLOATING
C10155 vcm_esd.n0 vss 0.0199752f ; **FLOATING
C10156 vcm_esd.n1 vss 0.0386155f ; **FLOATING
C10157 vcm_esd.n2 vss 0.0302434f ; **FLOATING
C10158 vcm_esd.n3 vss 0.0155371f ; **FLOATING
C10159 vcm_esd.n4 vss 0.0302363f ; **FLOATING
C10160 vcm_esd.n5 vss 0.0155371f ; **FLOATING
C10161 vcm_esd.n6 vss 0.0199752f ; **FLOATING
C10162 vcm_esd.n7 vss 0.0386084f ; **FLOATING
C10163 vcm_esd.t15 vss 0.00765493f ; **FLOATING
C10164 vcm_esd.t14 vss 0.00801708f ; **FLOATING
C10165 vcm_esd.n8 vss 0.024527f ; **FLOATING
C10166 vcm_esd.t13 vss 0.0254288f ; **FLOATING
C10167 vcm_esd.n9 vss 0.0276302f ; **FLOATING
C10168 vcm_esd.t12 vss 0.0229648f ; **FLOATING
C10169 vcm_esd.n10 vss 0.27763f ; **FLOATING
C10170 vcm_esd.t10 vss 0.0141453f ; **FLOATING
C10171 vcm_esd.t8 vss 0.0290504f ; **FLOATING
C10172 vcm_esd.t9 vss 0.0349371f ; **FLOATING
C10173 vcm_esd.t11 vss 0.0167017f ; **FLOATING
C10174 vcm_esd.t17 vss 0.0139038f ; **FLOATING
C10175 vcm_esd.t18 vss 0.0297321f ; **FLOATING
C10176 vcm_esd.n11 vss 0.077373f ; **FLOATING
C10177 vcm_esd.n12 vss 0.407557f ; **FLOATING
C10178 vcm_esd.t7 vss 0.0166946f ; **FLOATING
C10179 vcm_esd.t20 vss 0.0139038f ; **FLOATING
C10180 vcm_esd.t21 vss 0.0297321f ; **FLOATING
C10181 vcm_esd.t6 vss 0.0141453f ; **FLOATING
C10182 vcm_esd.t4 vss 0.0349442f ; **FLOATING
C10183 vcm_esd.t5 vss 0.0290504f ; **FLOATING
C10184 vcm_esd.n13 vss 0.077373f ; **FLOATING
C10185 vcm_esd.n14 vss 0.187681f ; **FLOATING
C10186 vcm_esd.t3 vss 0.00765493f ; **FLOATING
C10187 vcm_esd.t2 vss 0.00801708f ; **FLOATING
C10188 vcm_esd.n15 vss 0.024527f ; **FLOATING
C10189 vcm_esd.t1 vss 0.0254288f ; **FLOATING
C10190 vcm_esd.n16 vss 0.0276302f ; **FLOATING
C10191 vcm_esd.t0 vss 0.0229648f ; **FLOATING
C10192 vcm_esd.n17 vss 0.0466042f ; **FLOATING
C10193 vcm_esd.n18 vss 0.334552f ; **FLOATING
C10194 vcm_esd.t24 vss 0.215787f ; **FLOATING
C10195 vcm_esd.t23 vss 0.146132f ; **FLOATING
C10196 vcm_esd.t16 vss 0.172435f ; **FLOATING
C10197 vcm_esd.n19 vss 0.178996f ; **FLOATING
C10198 vcm_esd.n20 vss 0.900377f ; **FLOATING
C10199 vcm_esd.t19 vss 0.0692352f ; **FLOATING
C10200 vcm_esd.t25 vss 31.6485f ; **FLOATING
C10201 vcm_esd.t22 vss 0.254388f ; **FLOATING
C10202 vcm_esd.n21 vss 0.241691f ; **FLOATING
C10203 vcm_esd.n22 vss 1.21113f ; **FLOATING
C10204 d_dith_en.n0 vss 1.11005f ; **FLOATING
C10205 d_dith_en.t37 vss 0.0422837f ; **FLOATING
C10206 d_dith_en.t34 vss 0.305074f ; **FLOATING
C10207 d_dith_en.t35 vss 0.0772031f ; **FLOATING
C10208 d_dith_en.n1 vss 0.634509f ; **FLOATING
C10209 d_dith_en.n2 vss 0.232941f ; **FLOATING
C10210 d_dith_en.t7 vss 0.0781842f ; **FLOATING
C10211 d_dith_en.t4 vss 0.222071f ; **FLOATING
C10212 d_dith_en.t5 vss 0.0781842f ; **FLOATING
C10213 d_dith_en.t2 vss 0.175762f ; **FLOATING
C10214 d_dith_en.n3 vss 0.222383f ; **FLOATING
C10215 d_dith_en.t36 vss 0.0781842f ; **FLOATING
C10216 d_dith_en.t32 vss 0.179785f ; **FLOATING
C10217 d_dith_en.t38 vss 0.0781842f ; **FLOATING
C10218 d_dith_en.t33 vss 0.17579f ; **FLOATING
C10219 d_dith_en.n4 vss 0.166564f ; **FLOATING
C10220 d_dith_en.t31 vss 0.0781842f ; **FLOATING
C10221 d_dith_en.t28 vss 0.219349f ; **FLOATING
C10222 d_dith_en.t29 vss 0.0781842f ; **FLOATING
C10223 d_dith_en.t26 vss 0.175762f ; **FLOATING
C10224 d_dith_en.n5 vss 0.220623f ; **FLOATING
C10225 d_dith_en.t30 vss 0.0781842f ; **FLOATING
C10226 d_dith_en.t27 vss 0.175779f ; **FLOATING
C10227 d_dith_en.n6 vss 0.0643108f ; **FLOATING
C10228 d_dith_en.n7 vss 0.30721f ; **FLOATING
C10229 d_dith_en.t25 vss 0.0781842f ; **FLOATING
C10230 d_dith_en.t22 vss 0.219354f ; **FLOATING
C10231 d_dith_en.t23 vss 0.0781842f ; **FLOATING
C10232 d_dith_en.t20 vss 0.175762f ; **FLOATING
C10233 d_dith_en.n8 vss 0.222292f ; **FLOATING
C10234 d_dith_en.t24 vss 0.0781842f ; **FLOATING
C10235 d_dith_en.t21 vss 0.175768f ; **FLOATING
C10236 d_dith_en.n9 vss 0.0625593f ; **FLOATING
C10237 d_dith_en.n10 vss 0.23338f ; **FLOATING
C10238 d_dith_en.t19 vss 0.0781842f ; **FLOATING
C10239 d_dith_en.t16 vss 0.219352f ; **FLOATING
C10240 d_dith_en.t17 vss 0.0781842f ; **FLOATING
C10241 d_dith_en.t14 vss 0.175762f ; **FLOATING
C10242 d_dith_en.n11 vss 0.222275f ; **FLOATING
C10243 d_dith_en.t18 vss 0.0781842f ; **FLOATING
C10244 d_dith_en.t15 vss 0.175765f ; **FLOATING
C10245 d_dith_en.n12 vss 0.0625624f ; **FLOATING
C10246 d_dith_en.n13 vss 0.23338f ; **FLOATING
C10247 d_dith_en.t13 vss 0.0781842f ; **FLOATING
C10248 d_dith_en.t10 vss 0.219347f ; **FLOATING
C10249 d_dith_en.t11 vss 0.0781842f ; **FLOATING
C10250 d_dith_en.t8 vss 0.175762f ; **FLOATING
C10251 d_dith_en.n14 vss 0.220626f ; **FLOATING
C10252 d_dith_en.t12 vss 0.0781842f ; **FLOATING
C10253 d_dith_en.t9 vss 0.175779f ; **FLOATING
C10254 d_dith_en.n15 vss 0.0643108f ; **FLOATING
C10255 d_dith_en.n16 vss 0.30721f ; **FLOATING
C10256 d_dith_en.t6 vss 0.0781842f ; **FLOATING
C10257 d_dith_en.t3 vss 0.175762f ; **FLOATING
C10258 d_dith_en.t1 vss 0.0338974f ; **FLOATING
C10259 d_dith_en.t0 vss 0.0242895f ; **FLOATING
C10260 d_dith_en.n17 vss 0.229999f ; **FLOATING
C10261 d_dith_en.n18 vss 1.01363f ; **FLOATING
C10262 d_rst_b.t1 vss 0.0197239f ; **FLOATING
C10263 d_rst_b.t0 vss 0.0141332f ; **FLOATING
C10264 d_rst_b.n0 vss 0.169066f ; **FLOATING
C10265 d_rst_b.t2 vss 0.265239f ; **FLOATING
C10266 d_qout_en.t2 vss 0.0267352f ; **FLOATING
C10267 d_qout_en.t3 vss 0.0261217f ; **FLOATING
C10268 d_qout_en.n0 vss 0.253605f ; **FLOATING
C10269 d_qout_en.t0 vss 0.0209613f ; **FLOATING
C10270 d_qout_en.t1 vss 0.0150201f ; **FLOATING
C10271 d_qout_en.n1 vss 0.685142f ; **FLOATING
C10272 d_qi_b.t6 vss 0.798278f ; **FLOATING
C10273 d_qi_b.t7 vss 0.682775f ; **FLOATING
C10274 d_qi_b.n0 vss 0.615001f ; **FLOATING
C10275 d_qi_b.t9 vss 0.798278f ; **FLOATING
C10276 d_qi_b.t8 vss 0.682775f ; **FLOATING
C10277 d_qi_b.n1 vss 0.643041f ; **FLOATING
C10278 d_qi_b.n2 vss 0.139528f ; **FLOATING
C10279 d_qi_b.t3 vss 0.0752833f ; **FLOATING
C10280 d_qi_b.t5 vss 0.0581552f ; **FLOATING
C10281 d_qi_b.t0 vss 0.0200772f ; **FLOATING
C10282 d_qi_b.t1 vss 0.0192291f ; **FLOATING
C10283 d_qi_b.n3 vss 0.0411172f ; **FLOATING
C10284 d_qi_b.t2 vss 0.0289786f ; **FLOATING
C10285 d_qi_b.n4 vss 0.0328883f ; **FLOATING
C10286 d_qi_b.n5 vss 0.118346f ; **FLOATING
C10287 d_qi_b.n6 vss 0.105625f ; **FLOATING
C10288 d_qi_b.t4 vss 0.0595657f ; **FLOATING
C10289 d_qi_b.n7 vss 0.11117f ; **FLOATING
C10290 d_qi.n0 vss 0.221059f ; **FLOATING
C10291 d_qi.t4 vss 0.0557846f ; **FLOATING
C10292 d_qi.t2 vss 0.0187947f ; **FLOATING
C10293 d_qi.t0 vss 0.0180022f ; **FLOATING
C10294 d_qi.n1 vss 0.0384914f ; **FLOATING
C10295 d_qi.t1 vss 0.0271285f ; **FLOATING
C10296 d_qi.n2 vss 0.0333104f ; **FLOATING
C10297 d_qi.t5 vss 0.0821917f ; **FLOATING
C10298 d_qi.t3 vss 0.0687001f ; **FLOATING
C10299 d_qi.n3 vss 0.0644629f ; **FLOATING
C10300 d_qi.t6 vss 0.722584f ; **FLOATING
C10301 d_qi.t7 vss 0.658678f ; **FLOATING
C10302 d_qi.n4 vss 0.615151f ; **FLOATING
C10303 d_qi.t9 vss 0.722584f ; **FLOATING
C10304 d_qi.t8 vss 0.658678f ; **FLOATING
C10305 d_qi.n5 vss 0.588902f ; **FLOATING
C10306 d_qi.n6 vss 0.0985781f ; **FLOATING
C10307 vi_esd.n0 vss 0.0194491f ; **FLOATING
C10308 vi_esd.n1 vss 0.0378423f ; **FLOATING
C10309 vi_esd.n2 vss 0.0483291f ; **FLOATING
C10310 vi_esd.n3 vss 0.0250007f ; **FLOATING
C10311 vi_esd.n4 vss 0.0483133f ; **FLOATING
C10312 vi_esd.n5 vss 0.0250007f ; **FLOATING
C10313 vi_esd.n6 vss 0.0194472f ; **FLOATING
C10314 vi_esd.n7 vss 0.0378343f ; **FLOATING
C10315 vi_esd.t9 vss 0.0372013f ; **FLOATING
C10316 vi_esd.t10 vss 0.0173965f ; **FLOATING
C10317 vi_esd.t2 vss 0.0208945f ; **FLOATING
C10318 vi_esd.t1 vss 0.0437336f ; **FLOATING
C10319 vi_esd.t0 vss 0.0363494f ; **FLOATING
C10320 vi_esd.t3 vss 0.0176977f ; **FLOATING
C10321 vi_esd.n8 vss 0.258709f ; **FLOATING
C10322 vi_esd.t4 vss 0.0437177f ; **FLOATING
C10323 vi_esd.t12 vss 0.0363494f ; **FLOATING
C10324 vi_esd.t11 vss 0.0176977f ; **FLOATING
C10325 vi_esd.t5 vss 0.0372033f ; **FLOATING
C10326 vi_esd.t6 vss 0.0209024f ; **FLOATING
C10327 vi_esd.t7 vss 0.0173965f ; **FLOATING
C10328 vi_esd.n9 vss 0.248762f ; **FLOATING
C10329 vi_esd.n10 vss 0.755998f ; **FLOATING
C10330 vi_esd.t14 vss 0.270039f ; **FLOATING
C10331 vi_esd.t13 vss 0.182868f ; **FLOATING
C10332 vi_esd.t8 vss 0.049085f ; **FLOATING
C10333 vi_esd.n11 vss 0.223997f ; **FLOATING
C10334 vi_esd.n12 vss 1.24671f ; **FLOATING
C10335 d_amp_s_b[0].t2 vss 0.324815f ; **FLOATING
C10336 d_amp_s_b[0].t3 vss 0.0238585f ; **FLOATING
C10337 d_amp_s_b[0].n0 vss 0.630086f ; **FLOATING
C10338 d_amp_s_b[0].t0 vss 0.0261865f ; **FLOATING
C10339 d_amp_s_b[0].t1 vss 0.0173787f ; **FLOATING
C10340 d_amp_s_b[0].n1 vss 0.407562f ; **FLOATING
C10341 d_amp_s[0].t2 vss 0.205069f ; **FLOATING
C10342 d_amp_s[0].t3 vss 0.0179107f ; **FLOATING
C10343 d_amp_s[0].n0 vss 0.714333f ; **FLOATING
C10344 d_amp_s[0].t4 vss 0.0396742f ; **FLOATING
C10345 d_amp_s[0].t0 vss 0.0280984f ; **FLOATING
C10346 d_amp_s[0].t1 vss 0.0230519f ; **FLOATING
C10347 d_amp_s[0].n1 vss 0.0704267f ; **FLOATING
C10348 d_amp_s[0].n2 vss 0.420227f ; **FLOATING
C10349 d_amp_s_b[1].t2 vss 0.171903f ; **FLOATING
C10350 d_amp_s_b[1].t3 vss 0.0362388f ; **FLOATING
C10351 d_amp_s_b[1].n0 vss 0.476867f ; **FLOATING
C10352 d_amp_s_b[1].t1 vss 0.011813f ; **FLOATING
C10353 d_amp_s_b[1].t0 vss 0.0177995f ; **FLOATING
C10354 d_amp_s_b[1].n1 vss 0.237708f ; **FLOATING
C10355 d_amp_s[1].t2 vss 0.22682f ; **FLOATING
C10356 d_amp_s[1].t3 vss 0.0115192f ; **FLOATING
C10357 d_amp_s[1].n0 vss 0.399862f ; **FLOATING
C10358 d_amp_s[1].t4 vss 0.0258077f ; **FLOATING
C10359 d_amp_s[1].t0 vss 0.0149669f ; **FLOATING
C10360 d_amp_s[1].t1 vss 0.0182461f ; **FLOATING
C10361 d_amp_s[1].n1 vss 0.0486125f ; **FLOATING
C10362 d_amp_s[1].n2 vss 0.243107f ; **FLOATING
C10363 d_amp_s_b[3].t3 vss 0.0464211f ; **FLOATING
C10364 d_amp_s_b[3].t2 vss 0.416094f ; **FLOATING
C10365 d_amp_s_b[3].n0 vss 1.28203f ; **FLOATING
C10366 d_amp_s_b[3].t1 vss 0.0505708f ; **FLOATING
C10367 d_amp_s_b[3].t0 vss 0.0335613f ; **FLOATING
C10368 d_amp_s_b[3].n1 vss 0.597906f ; **FLOATING
C10369 d_amp_s[3].t2 vss 0.258443f ; **FLOATING
C10370 d_amp_s[3].t3 vss 0.0130216f ; **FLOATING
C10371 d_amp_s[3].n0 vss 0.541788f ; **FLOATING
C10372 d_amp_s[3].t4 vss 0.0468204f ; **FLOATING
C10373 d_amp_s[3].t1 vss 0.0206257f ; **FLOATING
C10374 d_amp_s[3].t0 vss 0.0169215f ; **FLOATING
C10375 d_amp_s[3].n1 vss 0.0375534f ; **FLOATING
C10376 d_amp_s[3].n2 vss 0.306482f ; **FLOATING
C10377 d_amp_s_b[2].t2 vss 0.204707f ; **FLOATING
C10378 d_amp_s_b[2].t3 vss 0.0236727f ; **FLOATING
C10379 d_amp_s_b[2].n0 vss 0.561837f ; **FLOATING
C10380 d_amp_s_b[2].t0 vss 0.0233139f ; **FLOATING
C10381 d_amp_s_b[2].t1 vss 0.0154725f ; **FLOATING
C10382 d_amp_s_b[2].n1 vss 0.277398f ; **FLOATING
C10383 d_amp_s[2].t2 vss 0.151441f ; **FLOATING
C10384 d_amp_s[2].t3 vss 0.021491f ; **FLOATING
C10385 d_amp_s[2].n0 vss 0.51364f ; **FLOATING
C10386 d_amp_s[2].t4 vss 0.0390142f ; **FLOATING
C10387 d_amp_s[2].t1 vss 0.0198885f ; **FLOATING
C10388 d_amp_s[2].t0 vss 0.016317f ; **FLOATING
C10389 d_amp_s[2].n1 vss 0.0362123f ; **FLOATING
C10390 d_amp_s[2].n2 vss 0.26448f ; **FLOATING
C10391 d_dith[1].t2 vss 0.0363969f ; **FLOATING
C10392 d_dith[1].t3 vss 0.0368028f ; **FLOATING
C10393 d_dith[1].n0 vss 0.0957502f ; **FLOATING
C10394 d_dith[1].t1 vss 0.0289427f ; **FLOATING
C10395 d_dith[1].t0 vss 0.0213382f ; **FLOATING
C10396 d_dith[1].n1 vss 0.575393f ; **FLOATING
C10397 do_q_b.t1 vss 0.0324031f ; **FLOATING
C10398 do_q_b.t0 vss 0.0499142f ; **FLOATING
C10399 do_q_b.n0 vss 0.471975f ; **FLOATING
C10400 do_q.t1 vss 0.0293215f ; **FLOATING
C10401 do_q.t0 vss 0.0451687f ; **FLOATING
C10402 do_q.n0 vss 0.357623f ; **FLOATING
C10403 do_q_dec.t0 vss 0.0323989f ; **FLOATING
C10404 do_q_dec.t1 vss 0.0499093f ; **FLOATING
C10405 do_q_dec.n0 vss 0.548591f ; **FLOATING
C10406 d_dith[0].t0 vss 0.0417295f ; **FLOATING
C10407 d_dith[0].t1 vss 0.0307654f ; **FLOATING
C10408 d_dith[0].n0 vss 0.670887f ; **FLOATING
C10409 d_dith[0].t2 vss 0.0533989f ; **FLOATING
C10410 d_dith[0].t3 vss 0.0530604f ; **FLOATING
C10411 d_dith[0].n1 vss 0.564162f ; **FLOATING
C10412 d_dith[2].t2 vss 0.0536183f ; **FLOATING
C10413 d_dith[2].t3 vss 0.0542595f ; **FLOATING
C10414 d_dith[2].n0 vss 0.1542f ; **FLOATING
C10415 d_dith[2].t1 vss 0.042671f ; **FLOATING
C10416 d_dith[2].t0 vss 0.0314595f ; **FLOATING
C10417 d_dith[2].n1 vss 0.953198f ; **FLOATING
C10418 d_qclk.t18 vss 0.165222f ; **FLOATING
C10419 d_qclk.t2 vss 0.407503f ; **FLOATING
C10420 d_qclk.n0 vss 0.85261f ; **FLOATING
C10421 d_qclk.t1 vss 0.0259785f ; **FLOATING
C10422 d_qclk.t0 vss 0.0362952f ; **FLOATING
C10423 d_qclk.n1 vss 0.108111f ; **FLOATING
C10424 d_qclk.t20 vss 0.0504536f ; **FLOATING
C10425 d_qclk.t19 vss 0.0461461f ; **FLOATING
C10426 d_qclk.n2 vss 0.181626f ; **FLOATING
C10427 d_qclk.t17 vss 0.0586857f ; **FLOATING
C10428 d_qclk.n3 vss 0.21654f ; **FLOATING
C10429 d_qclk.t16 vss 0.0503452f ; **FLOATING
C10430 d_qclk.t15 vss 0.0461461f ; **FLOATING
C10431 d_qclk.n4 vss 0.162957f ; **FLOATING
C10432 d_qclk.n5 vss 0.128338f ; **FLOATING
C10433 d_qclk.t14 vss 0.0586857f ; **FLOATING
C10434 d_qclk.n6 vss 0.158341f ; **FLOATING
C10435 d_qclk.t13 vss 0.0503406f ; **FLOATING
C10436 d_qclk.t12 vss 0.0461461f ; **FLOATING
C10437 d_qclk.n7 vss 0.162561f ; **FLOATING
C10438 d_qclk.n8 vss 0.128361f ; **FLOATING
C10439 d_qclk.t11 vss 0.0586857f ; **FLOATING
C10440 d_qclk.n9 vss 0.158341f ; **FLOATING
C10441 d_qclk.t10 vss 0.0503452f ; **FLOATING
C10442 d_qclk.t9 vss 0.0461461f ; **FLOATING
C10443 d_qclk.n10 vss 0.162957f ; **FLOATING
C10444 d_qclk.n11 vss 0.128338f ; **FLOATING
C10445 d_qclk.t8 vss 0.0586857f ; **FLOATING
C10446 d_qclk.n12 vss 0.158341f ; **FLOATING
C10447 d_qclk.t7 vss 0.0504536f ; **FLOATING
C10448 d_qclk.t6 vss 0.0461461f ; **FLOATING
C10449 d_qclk.n13 vss 0.163245f ; **FLOATING
C10450 d_qclk.n14 vss 0.125952f ; **FLOATING
C10451 d_qclk.t5 vss 0.0586857f ; **FLOATING
C10452 d_qclk.n15 vss 0.209744f ; **FLOATING
C10453 d_qclk.t3 vss 0.0461461f ; **FLOATING
C10454 d_qclk.n16 vss 0.118824f ; **FLOATING
C10455 d_qclk.t4 vss 0.0461738f ; **FLOATING
C10456 d_qclk.n17 vss 0.74568f ; **FLOATING
C10457 d_vcm_phi1_b.t1 vss 0.0251126f ; **FLOATING
C10458 d_vcm_phi1_b.t0 vss 0.0182083f ; **FLOATING
C10459 d_vcm_phi1_b.n0 vss 0.0611752f ; **FLOATING
C10460 d_vcm_phi1_b.t2 vss 0.138423f ; **FLOATING
C10461 d_vcm_phi1_b.t3 vss 0.154466f ; **FLOATING
C10462 d_vcm_phi1_b.n1 vss 0.225977f ; **FLOATING
C10463 di_osc_en.t0 vss 0.0680871f ; **FLOATING
C10464 di_osc_en.t1 vss 0.100732f ; **FLOATING
C10465 di_osc_en.n0 vss 1.55531f ; **FLOATING
C10466 di_clk_sel.t0 vss 0.102671f ; **FLOATING
C10467 di_clk_sel.t1 vss 0.151896f ; **FLOATING
C10468 di_clk_sel.n0 vss 2.48992f ; **FLOATING
C10469 do_osc_oe.t1 vss 0.0249135f ; **FLOATING
C10470 do_osc_oe.t0 vss 0.0371048f ; **FLOATING
C10471 do_osc_oe.n0 vss 0.106226f ; **FLOATING
C10472 do_osc_oe.t2 vss 0.0882871f ; **FLOATING
C10473 do_osc_oe.n1 vss 0.370501f ; **FLOATING
C10474 do_clk_osc.t0 vss 0.035114f ; **FLOATING
C10475 do_clk_osc.t1 vss 0.0541434f ; **FLOATING
C10476 do_clk_osc.n0 vss 0.540711f ; **FLOATING
CRF0 a_10757_8608# a_6249_9100.n12 0.01997f
CRF1 a_10757_9168# a_4362_8188.n5 0.01008f
CRF2 a_10757_9168# a_5994_8400.n1 0.01276f
CRF3 a_10757_9808# a_5892_8400.n11 0.01178f
CRF4 a_11115_8608# a_6249_9100.n12 0.02147f
CRF5 a_11115_9168# a_11173_9488.n1 0.01305f
CRF6 a_11173_9488.n1 a_11201_9028# 0.01976f
CRF7 a_11173_9488.n1 a_11201_9168# 0.02903f
CRF8 a_11173_9488.n1 a_11201_9308# 0.0241f
CRF9 a_11173_9488.n1 a_11201_9808# 0.01694f
CRF10 a_11173_9488.n1 a_11259_9488# 0.0212f
CRF11 a_11173_9488.n1 a_11259_9628# 0.03097f
CRF12 a_11173_9488.n1 a_12075_9488.n0 1.52349f
CRF13 a_11173_9488.n1 a_12075_9628.n1 0.03092f
CRF14 a_11173_9488.n1 a_13211_9308.n0 0.13686f
CRF15 a_11173_9488.n1 a_4362_8188.n5 1.12802f
CRF16 a_11173_9488.n1 a_5892_8400.n11 0.30097f
CRF17 a_11173_9488.n1 a_5994_8400.n1 0.02974f
CRF18 a_11173_9488.n1 a_6249_9100.n12 1.06222f
CRF19 a_11173_9488.n1 d_amp_s[1] 0.07104f
CRF20 a_11173_9488.n1 d_amp_s_b[0] 0.02052f
CRF21 a_11173_9488.n1 d_amp_s_b[1] 0.05794f
CRF22 a_11173_9488.n1 d_amp_s_b[2] 0.03394f
CRF23 a_11173_9488.n1 sg13cmos5l_inv_1_13.A 0.01117f
CRF24 a_11173_9488.n1 sg13cmos5l_inv_1_16.Y 0.02568f
CRF25 a_11173_9488.n1 sg13cmos5l_inv_1_17.Y 0.01864f
CRF26 a_11173_9488.n1 sg13cmos5l_inv_1_19.Y 0.02825f
CRF27 a_11173_9488.n1 sg13cmos5l_inv_1_20.Y 0.03987f
CRF28 a_11173_9488.n1 sg13cmos5l_inv_1_3.Y 0.06507f
CRF29 a_11173_9488.n1 sg13cmos5l_inv_1_4.Y 0.01856f
CRF30 a_11173_9488.n1 sg13cmos5l_inv_1_6.Y 0.0152f
CRF31 a_11173_9488.n1 sg13cmos5l_nand2_1_2.Y 0.01179f
CRF32 a_11173_9488.n1 vdd 0.07259f
CRF33 a_11173_9488.n1 xq_vg_p_0_ 0.03529f
CRF34 a_11173_9488.n1 xq_vg_p_1_ 0.03427f
CRF35 a_11173_9488.n1 xq_vg_p_2_ 0.0369f
CRF36 a_11201_8188# a_12075_9628.n1 0.01478f
CRF37 a_11201_8328# a_12075_9628.n1 0.02485f
CRF38 a_11201_8468# a_12075_9628.n1 0.06112f
CRF39 a_11201_8608# a_12075_9628.n1 0.04263f
CRF40 a_11201_8748# a_12075_9628.n1 0.0335f
CRF41 a_11201_8748# a_6249_9100.n12 0.02542f
CRF42 a_11201_8888# a_12075_9628.n1 0.02867f
CRF43 a_11201_8888# a_6249_9100.n12 0.03968f
CRF44 a_11201_9028# a_12075_9628.n1 0.02541f
CRF45 a_11201_9028# a_4362_8188.n5 0.01495f
CRF46 a_11201_9028# a_6249_9100.n12 0.02078f
CRF47 a_11201_9168# a_12075_9488.n0 0.02565f
CRF48 a_11201_9168# a_12075_9628.n1 0.02093f
CRF49 a_11201_9168# a_4362_8188.n5 0.01689f
CRF50 a_11201_9308# a_12075_9488.n0 0.06851f
CRF51 a_11201_9308# a_12075_9628.n1 0.01612f
CRF52 a_11201_9308# a_13211_9308.n0 0.01899f
CRF53 a_11201_9308# a_4362_8188.n5 0.02383f
CRF54 a_11201_9308# a_5892_8400.n11 0.03201f
CRF55 a_11201_9808# a_12075_9628.n1 0.05174f
CRF56 a_11201_9808# a_4362_8188.n5 0.03343f
CRF57 a_11259_9488# a_12075_9488.n0 0.02666f
CRF58 a_11259_9488# a_4362_8188.n5 0.01224f
CRF59 a_11259_9488# a_5892_8400.n11 0.02494f
CRF60 a_11259_9628# a_12075_9628.n1 0.02338f
CRF61 a_11259_9628# a_4362_8188.n5 0.01359f
CRF62 a_11259_9628# a_5892_8400.n11 0.01055f
CRF63 a_11293_11104.n3 a_9357_11104.n0 1.93127f
CRF64 a_11293_11104.n3 a_9533_11104.n3 0.01643f
CRF65 a_11293_11104.n3 d_qclk 0.02247f
CRF66 a_11293_11104.n3 sg13cmos5l_and2_2_1.X 0.51507f
CRF67 a_11293_11104.n3 sg13cmos5l_inv_1_14.A 0.25121f
CRF68 a_11293_11104.n3 sg13cmos5l_inv_1_17.A 0.02314f
CRF69 a_11293_11104.n3 sg13cmos5l_inv_1_19.Y 0.01123f
CRF70 a_11293_11104.n3 sg13cmos5l_inv_1_2.A 0.17169f
CRF71 a_11293_11104.n3 vdd 0.50152f
CRF72 a_11293_11104.n3 vo_n 0.57317f
CRF73 a_11293_11104.n3 xq_vg_p_0_ 0.06035f
CRF74 a_11293_11104.n3 xq_vg_p_1_ 0.138f
CRF75 a_11293_11104.n3 xq_vg_p_2_ 0.19551f
CRF76 a_12075_9488.n0 a_12075_9628.n1 0.37321f
CRF77 a_12075_9488.n0 a_12395_9488# 0.02598f
CRF78 a_12075_9488.n0 a_13211_9308.n0 0.02077f
CRF79 a_12075_9488.n0 a_4362_8188.n5 0.36504f
CRF80 a_12075_9488.n0 a_5892_8400.n11 1.12757f
CRF81 a_12075_9488.n0 a_6249_9100.n12 0.24724f
CRF82 a_12075_9488.n0 d_amp_s[0] 0.01611f
CRF83 a_12075_9488.n0 d_amp_s_b[0] 0.04323f
CRF84 a_12075_9488.n0 sg13cmos5l_inv_1_13.Y 0.05693f
CRF85 a_12075_9488.n0 sg13cmos5l_inv_1_16.Y 0.02176f
CRF86 a_12075_9488.n0 sg13cmos5l_inv_1_17.Y 0.01304f
CRF87 a_12075_9488.n0 sg13cmos5l_inv_1_19.Y 0.02106f
CRF88 a_12075_9488.n0 sg13cmos5l_inv_1_20.Y 0.01561f
CRF89 a_12075_9488.n0 sg13cmos5l_inv_1_3.Y 0.02638f
CRF90 a_12075_9488.n0 sg13cmos5l_inv_1_4.Y 0.01771f
CRF91 a_12075_9488.n0 sg13cmos5l_inv_1_6.Y 0.01891f
CRF92 a_12075_9488.n0 vdd 0.06602f
CRF93 a_12075_9488.n0 vo_n 0.24183f
CRF94 a_12075_9488.n0 xq_dith_v_bp 0.03846f
CRF95 a_12075_9488.n0 xq_vg_p_0_ 0.07309f
CRF96 a_12075_9488.n0 xq_vg_p_1_ 0.25117f
CRF97 a_12075_9488.n0 xq_vg_p_2_ 0.03537f
CRF98 a_12075_9628.n1 a_12395_9488# 0.01099f
CRF99 a_12075_9628.n1 a_12395_9628# 0.02291f
CRF100 a_12075_9628.n1 a_13211_8468# 0.02818f
CRF101 a_12075_9628.n1 a_13211_9308.n0 0.05826f
CRF102 a_12075_9628.n1 a_4362_8188.n5 0.1076f
CRF103 a_12075_9628.n1 a_5892_8400.n11 0.01794f
CRF104 a_12075_9628.n1 a_6249_9100.n12 0.2302f
CRF105 a_12075_9628.n1 d_amp_s[0] 0.10588f
CRF106 a_12075_9628.n1 d_amp_s[3] 0.41614f
CRF107 a_12075_9628.n1 d_amp_s_b[0] 0.04399f
CRF108 a_12075_9628.n1 d_amp_s_b[1] 0.14056f
CRF109 a_12075_9628.n1 d_amp_s_b[2] 0.03163f
CRF110 a_12075_9628.n1 d_amp_s_b[3] 0.04812f
CRF111 a_12075_9628.n1 sg13cmos5l_inv_1_16.Y 0.11529f
CRF112 a_12075_9628.n1 sg13cmos5l_inv_1_19.Y 0.04489f
CRF113 a_12075_9628.n1 sg13cmos5l_inv_1_3.Y 0.02458f
CRF114 a_12075_9628.n1 vdd 0.14702f
CRF115 a_12075_9628.n1 vo_n 0.0504f
CRF116 a_12075_9628.n1 xq_vg_p_0_ 0.1286f
CRF117 a_12075_9628.n1 xq_vg_p_1_ 0.02373f
CRF118 a_12075_9628.n1 xq_vg_p_2_ 0.10647f
CRF119 a_12395_9488# a_13211_9308.n0 0.02798f
CRF120 a_12395_9488# a_4362_8188.n5 0.02151f
CRF121 a_12395_9628# a_4362_8188.n5 0.06091f
CRF122 a_12445_30191# a_6452_29739.n0 0.07272f
CRF123 a_12445_30191# a_7804_29739.n0 0.1459f
CRF124 a_12445_30191# w_9407_29481.t0 0.34447f
CRF125 a_13189_30111# a_6452_29739.n0 0.14675f
CRF126 a_13189_30111# a_7804_29739.n0 0.28023f
CRF127 a_13211_9028# a_13211_9308.n0 0.04601f
CRF128 a_13211_9308.n0 a_4362_8188.n5 0.2084f
CRF129 a_13211_9308.n0 a_5892_8400.n11 0.02244f
CRF130 a_13211_9308.n0 a_6249_9100.n12 0.29917f
CRF131 a_13211_9308.n0 d_amp_s[1] 0.57539f
CRF132 a_13211_9308.n0 d_amp_s[2] 0.01962f
CRF133 a_13211_9308.n0 d_amp_s[3] 0.04781f
CRF134 a_13211_9308.n0 d_amp_s_b[0] 0.06457f
CRF135 a_13211_9308.n0 d_amp_s_b[1] 0.91098f
CRF136 a_13211_9308.n0 d_amp_s_b[2] 0.02848f
CRF137 a_13211_9308.n0 d_amp_s_b[3] 0.02895f
CRF138 a_13211_9308.n0 sg13cmos5l_inv_1_16.Y 0.04298f
CRF139 a_13211_9308.n0 sg13cmos5l_inv_1_17.A 0.07563f
CRF140 a_13211_9308.n0 sg13cmos5l_inv_1_19.Y 0.18425f
CRF141 a_13211_9308.n0 vdd 0.1975f
CRF142 a_13211_9308.n0 xq_vg_p_1_ 0.0259f
CRF143 a_13211_9308.n0 xq_vg_p_2_ 0.01905f
CRF144 a_21276_2052# a_21452_2308.n2 0.23215f
CRF145 a_21276_2052# a_21554_2052.n0 0.05212f
CRF146 a_21452_2308.n2 a_21478_2344# 0.04913f
CRF147 a_21452_2308.n2 a_21478_2578# 0.03424f
CRF148 a_21452_2308.n2 a_21554_2052.n0 1.41873f
CRF149 a_21452_2308.n2 a_21554_2798# 0.53184f
CRF150 a_21452_2308.n2 a_22184_2052# 0.01569f
CRF151 a_21452_2308.n2 a_22644_2344# 0.31493f
CRF152 a_21452_2308.n2 a_23294_2344# 0.07989f
CRF153 a_21452_2308.n2 a_23294_2578# 0.09507f
CRF154 a_21452_2308.n2 a_23674_2344# 0.11794f
CRF155 a_21452_2308.n2 a_23674_2578# 0.09773f
CRF156 a_21452_2308.n2 dsm2_osc_0.d_btest_or 0.1597f
CRF157 a_21452_2308.n2 dsm2_osc_0.dsm2_io_rx_0.di_b 0.76522f
CRF158 a_21452_2308.n2 dsm2_osc_0.ibias_in 0.15004f
CRF159 a_21452_2308.n2 dsm2_osc_0.ibias_pad 0.03836f
CRF160 a_21452_2308.n2 dsm2_osc_0.sg13cmos5l_dfrbp_1_0.CLK 0.01266f
CRF161 a_21452_2308.n2 dsm2_osc_0.sg13cmos5l_dfrbp_1_0.RESET_B 0.6755f
CRF162 a_21452_2308.n2 dsm2_osc_0.sg13cmos5l_inv_1_3.A 0.46855f
CRF163 a_21452_2308.n2 dsm2_osc_0.sg13cmos5l_mux2_1_0.A1 0.08234f
CRF164 a_21452_2308.n2 vcm_esd 0.09335f
CRF165 a_21452_2308.n2 vdd 0.44438f
CRF166 a_21478_2344# a_21554_2052.n0 0.04835f
CRF167 a_21554_2052.n0 a_21554_2798# 0.33295f
CRF168 a_21554_2052.n0 a_21681_1704# 0.01115f
CRF169 a_21554_2052.n0 a_21736_2344# 0.08057f
CRF170 a_21554_2052.n0 a_21830_2088# 0.06581f
CRF171 a_21554_2052.n0 a_22184_2052# 0.12885f
CRF172 a_21554_2052.n0 a_22386_2344# 0.07047f
CRF173 a_21554_2052.n0 a_22644_2344# 0.1073f
CRF174 a_21554_2052.n0 a_22738_2088# 0.0473f
CRF175 a_21554_2052.n0 a_22836_1332# 0.01804f
CRF176 a_21554_2052.n0 a_23294_2344# 0.11296f
CRF177 a_21554_2052.n0 a_23674_2344# 0.05124f
CRF178 a_21554_2052.n0 dsm2_osc_0.d_btest_or 0.02491f
CRF179 a_21554_2052.n0 dsm2_osc_0.dsm2_io_rx_0.di_b 1.06386f
CRF180 a_21554_2052.n0 dsm2_osc_0.ibias_in 0.09815f
CRF181 a_21554_2052.n0 dsm2_osc_0.ibias_pad 0.01295f
CRF182 a_21554_2052.n0 dsm2_osc_0.sg13cmos5l_dfrbp_1_0.RESET_B 0.52207f
CRF183 a_21554_2052.n0 dsm2_osc_0.sg13cmos5l_inv_1_2.A 0.03841f
CRF184 a_21554_2052.n0 dsm2_osc_0.sg13cmos5l_inv_1_2.Y 0.02438f
CRF185 a_21554_2052.n0 dsm2_osc_0.sg13cmos5l_inv_1_3.A 0.11645f
CRF186 a_21554_2052.n0 dsm2_osc_0.sg13cmos5l_mux2_1_0.A1 0.04214f
CRF187 a_21554_2052.n0 vcm_esd 0.07599f
CRF188 a_21554_2052.n0 vdd 0.05907f
CRF189 a_4362_8188.n5 a_5798_8400.n0 0.43171f
CRF190 a_4362_8188.n5 a_5892_8400.n11 2.36968f
CRF191 a_4362_8188.n5 a_5994_8400.n1 1.7759f
CRF192 a_4362_8188.n5 a_6249_9100.n12 1.14856f
CRF193 a_4362_8188.n5 a_6257_8400.n0 0.22261f
CRF194 a_4362_8188.n5 a_6453_8400.n1 0.1417f
CRF195 a_4362_8188.n5 a_6757_9808# 0.02778f
CRF196 a_4362_8188.n5 a_8747_8888# 0.01521f
CRF197 a_4362_8188.n5 a_8747_9028# 0.0555f
CRF198 a_4362_8188.n5 a_8747_9168# 0.03759f
CRF199 a_4362_8188.n5 a_8747_9308# 0.04794f
CRF200 a_4362_8188.n5 a_8747_9488# 0.02159f
CRF201 a_4362_8188.n5 a_8747_9628# 0.06089f
CRF202 a_4362_8188.n5 a_9883_9488# 0.02562f
CRF203 a_4362_8188.n5 a_9883_9628# 0.01863f
CRF204 a_4362_8188.n5 d_amp_s[0] 0.01436f
CRF205 a_4362_8188.n5 d_amp_s[1] 0.1913f
CRF206 a_4362_8188.n5 d_amp_s[2] 0.06033f
CRF207 a_4362_8188.n5 d_amp_s[3] 0.11039f
CRF208 a_4362_8188.n5 d_amp_s_b[0] 0.43371f
CRF209 a_4362_8188.n5 d_amp_s_b[1] 0.09298f
CRF210 a_4362_8188.n5 d_amp_s_b[2] 0.123f
CRF211 a_4362_8188.n5 d_amp_s_b[3] 0.09174f
CRF212 a_4362_8188.n5 d_phi1 0.02117f
CRF213 a_4362_8188.n5 d_phi2 0.03555f
CRF214 a_4362_8188.n5 d_qclk 0.04198f
CRF215 a_4362_8188.n5 sg13cmos5l_inv_1_13.A 0.1385f
CRF216 a_4362_8188.n5 sg13cmos5l_inv_1_13.Y 0.15729f
CRF217 a_4362_8188.n5 sg13cmos5l_inv_1_16.Y 0.1128f
CRF218 a_4362_8188.n5 sg13cmos5l_inv_1_17.A 0.36342f
CRF219 a_4362_8188.n5 sg13cmos5l_inv_1_17.Y 0.04991f
CRF220 a_4362_8188.n5 sg13cmos5l_inv_1_18.Y 0.04373f
CRF221 a_4362_8188.n5 sg13cmos5l_inv_1_19.Y 0.12228f
CRF222 a_4362_8188.n5 sg13cmos5l_inv_1_20.Y 0.04769f
CRF223 a_4362_8188.n5 sg13cmos5l_inv_1_3.A 0.14566f
CRF224 a_4362_8188.n5 sg13cmos5l_inv_1_3.Y 0.25712f
CRF225 a_4362_8188.n5 sg13cmos5l_inv_1_4.A 0.06062f
CRF226 a_4362_8188.n5 sg13cmos5l_inv_1_4.Y 0.03764f
CRF227 a_4362_8188.n5 sg13cmos5l_inv_1_6.Y 0.04313f
CRF228 a_4362_8188.n5 sg13cmos5l_inv_1_9.Y 0.39164f
CRF229 a_4362_8188.n5 sg13cmos5l_nand2_1_2.Y 0.15731f
CRF230 a_4362_8188.n5 sg13cmos5l_or2_1_0.X 0.45395f
CRF231 a_4362_8188.n5 vdd 0.53347f
CRF232 a_4362_8188.n5 vo_n 0.78942f
CRF233 a_4362_8188.n5 vo_p 0.76902f
CRF234 a_4362_8188.n5 xq_dith_v_bp 3.74703f
CRF235 a_4362_8188.n5 xq_dith_v_bq 3.84085f
CRF236 a_4362_8188.n5 xq_vg_p_0_ 0.56074f
CRF237 a_4362_8188.n5 xq_vg_p_1_ 0.09683f
CRF238 a_4362_8188.n5 xq_vg_p_2_ 0.11343f
CRF239 a_4362_8188.n5 xq_vg_q_0_ 0.59039f
CRF240 a_4362_8188.n5 xq_vg_q_1_ 0.16665f
CRF241 a_4362_8188.n5 xq_vg_q_2_ 0.08872f
CRF242 a_5176_30111# a_6452_29739.n0 1.06256f
CRF243 a_5176_30111# a_7804_29739.n0 0.99308f
CRF244 a_5176_30111# w_9407_29481.t0 0.51204f
CRF245 a_5176_31117# a_6452_29739.n0 0.02857f
CRF246 a_5176_31117# a_7804_29739.n0 0.02844f
CRF247 a_5176_31117# w_9407_29481.t0 0.67821f
CRF248 a_5176_31469# a_6452_29739.n0 0.02815f
CRF249 a_5176_31469# a_7804_29739.n0 0.09664f
CRF250 a_5176_31469# w_9407_29481.t0 4.51203f
CRF251 a_5798_8400.n0 a_5892_8400.n11 0.24792f
CRF252 a_5798_8400.n0 a_5994_8400.n1 1.5226f
CRF253 a_5798_8400.n0 a_6249_9100.n12 1.48363f
CRF254 a_5798_8400.n0 a_6257_8400.n0 0.02039f
CRF255 a_5798_8400.n0 a_6453_8400.n1 0.37321f
CRF256 a_5798_8400.n0 a_8747_9168# 0.02463f
CRF257 a_5798_8400.n0 a_8747_9308# 0.06614f
CRF258 a_5798_8400.n0 a_8747_9488# 0.02598f
CRF259 a_5798_8400.n0 a_9883_9488# 0.02643f
CRF260 a_5798_8400.n0 d_amp_s[0] 0.02609f
CRF261 a_5798_8400.n0 d_amp_s[1] 0.0222f
CRF262 a_5798_8400.n0 d_amp_s[3] 0.0139f
CRF263 a_5798_8400.n0 d_amp_s_b[0] 0.04402f
CRF264 a_5798_8400.n0 d_amp_s_b[2] 0.01827f
CRF265 a_5798_8400.n0 sg13cmos5l_inv_1_13.Y 0.05693f
CRF266 a_5798_8400.n0 sg13cmos5l_inv_1_16.Y 0.02175f
CRF267 a_5798_8400.n0 sg13cmos5l_inv_1_17.Y 0.01304f
CRF268 a_5798_8400.n0 sg13cmos5l_inv_1_18.Y 0.01301f
CRF269 a_5798_8400.n0 sg13cmos5l_inv_1_19.Y 0.02106f
CRF270 a_5798_8400.n0 sg13cmos5l_inv_1_20.Y 0.01288f
CRF271 a_5798_8400.n0 sg13cmos5l_inv_1_4.Y 0.01334f
CRF272 a_5798_8400.n0 sg13cmos5l_inv_1_6.Y 0.01618f
CRF273 a_5798_8400.n0 vdd 0.05882f
CRF274 a_5798_8400.n0 vo_p 0.24098f
CRF275 a_5798_8400.n0 xq_dith_v_bq 0.03703f
CRF276 a_5798_8400.n0 xq_vg_q_0_ 0.07271f
CRF277 a_5798_8400.n0 xq_vg_q_1_ 0.08959f
CRF278 a_5798_8400.n0 xq_vg_q_2_ 0.02927f
CRF279 a_5892_8400.n11 a_5994_8400.n1 1.06617f
CRF280 a_5892_8400.n11 a_6249_9100.n12 0.30349f
CRF281 a_5892_8400.n11 a_6257_8400.n0 0.29253f
CRF282 a_5892_8400.n11 a_6453_8400.n1 0.22531f
CRF283 a_5892_8400.n11 a_8747_8888# 0.03274f
CRF284 a_5892_8400.n11 a_8747_9028# 0.01035f
CRF285 a_5892_8400.n11 a_9883_9488# 0.01701f
CRF286 a_5892_8400.n11 d_amp_s[0] 0.02846f
CRF287 a_5892_8400.n11 d_amp_s[1] 0.02966f
CRF288 a_5892_8400.n11 d_amp_s[2] 0.02392f
CRF289 a_5892_8400.n11 d_amp_s[3] 0.03717f
CRF290 a_5892_8400.n11 d_amp_s_b[0] 0.05035f
CRF291 a_5892_8400.n11 d_amp_s_b[1] 0.27228f
CRF292 a_5892_8400.n11 d_amp_s_b[2] 1.94694f
CRF293 a_5892_8400.n11 d_amp_s_b[3] 0.02751f
CRF294 a_5892_8400.n11 d_qclk 0.07092f
CRF295 a_5892_8400.n11 sg13cmos5l_inv_1_13.A 0.03855f
CRF296 a_5892_8400.n11 sg13cmos5l_inv_1_13.Y 0.0538f
CRF297 a_5892_8400.n11 sg13cmos5l_inv_1_16.A 0.06206f
CRF298 a_5892_8400.n11 sg13cmos5l_inv_1_16.Y 0.09355f
CRF299 a_5892_8400.n11 sg13cmos5l_inv_1_17.A 0.03539f
CRF300 a_5892_8400.n11 sg13cmos5l_inv_1_17.Y 0.06001f
CRF301 a_5892_8400.n11 sg13cmos5l_inv_1_18.Y 0.02722f
CRF302 a_5892_8400.n11 sg13cmos5l_inv_1_19.Y 0.03358f
CRF303 a_5892_8400.n11 sg13cmos5l_inv_1_20.Y 0.25992f
CRF304 a_5892_8400.n11 sg13cmos5l_inv_1_3.Y 0.15341f
CRF305 a_5892_8400.n11 sg13cmos5l_inv_1_4.A 0.07524f
CRF306 a_5892_8400.n11 sg13cmos5l_inv_1_4.Y 0.10534f
CRF307 a_5892_8400.n11 sg13cmos5l_inv_1_6.A 0.03961f
CRF308 a_5892_8400.n11 sg13cmos5l_inv_1_6.Y 0.21792f
CRF309 a_5892_8400.n11 sg13cmos5l_nand2_1_2.Y 0.02147f
CRF310 a_5892_8400.n11 vdd 0.51648f
CRF311 a_5892_8400.n11 vo_n 0.02869f
CRF312 a_5892_8400.n11 vo_p 0.26779f
CRF313 a_5892_8400.n11 xq_dith_v_bq 0.02059f
CRF314 a_5892_8400.n11 xq_vg_p_0_ 0.90356f
CRF315 a_5892_8400.n11 xq_vg_p_1_ 1.58651f
CRF316 a_5892_8400.n11 xq_vg_p_2_ 0.37641f
CRF317 a_5892_8400.n11 xq_vg_q_0_ 0.42133f
CRF318 a_5892_8400.n11 xq_vg_q_1_ 0.22515f
CRF319 a_5892_8400.n11 xq_vg_q_2_ 0.2335f
CRF320 a_5994_8400.n1 a_6249_9100.n12 0.21993f
CRF321 a_5994_8400.n1 a_6257_8400.n0 0.13325f
CRF322 a_5994_8400.n1 a_6453_8400.n1 0.02723f
CRF323 a_5994_8400.n1 a_6757_9808# 0.01526f
CRF324 a_5994_8400.n1 a_8747_9028# 0.01202f
CRF325 a_5994_8400.n1 a_8747_9168# 0.02448f
CRF326 a_5994_8400.n1 a_8747_9308# 0.01984f
CRF327 a_5994_8400.n1 a_9883_9488# 0.02061f
CRF328 a_5994_8400.n1 a_9883_9628# 0.03359f
CRF329 a_5994_8400.n1 d_amp_s[1] 0.07163f
CRF330 a_5994_8400.n1 d_amp_s[3] 0.02848f
CRF331 a_5994_8400.n1 d_amp_s_b[0] 0.01648f
CRF332 a_5994_8400.n1 d_amp_s_b[1] 0.09089f
CRF333 a_5994_8400.n1 d_amp_s_b[2] 0.08138f
CRF334 a_5994_8400.n1 d_qclk 0.20293f
CRF335 a_5994_8400.n1 sg13cmos5l_inv_1_16.Y 0.02294f
CRF336 a_5994_8400.n1 sg13cmos5l_inv_1_17.Y 0.01864f
CRF337 a_5994_8400.n1 sg13cmos5l_inv_1_18.Y 0.01258f
CRF338 a_5994_8400.n1 sg13cmos5l_inv_1_19.Y 0.02291f
CRF339 a_5994_8400.n1 sg13cmos5l_inv_1_20.Y 0.03987f
CRF340 a_5994_8400.n1 sg13cmos5l_inv_1_3.Y 0.03395f
CRF341 a_5994_8400.n1 sg13cmos5l_inv_1_4.Y 0.01856f
CRF342 a_5994_8400.n1 sg13cmos5l_inv_1_6.Y 0.0152f
CRF343 a_5994_8400.n1 sg13cmos5l_nand2_1_2.Y 0.01458f
CRF344 a_5994_8400.n1 vdd 0.06711f
CRF345 a_5994_8400.n1 xq_vg_q_0_ 0.03456f
CRF346 a_5994_8400.n1 xq_vg_q_1_ 0.03456f
CRF347 a_5994_8400.n1 xq_vg_q_2_ 0.03301f
CRF348 a_6249_9100.n12 a_6257_8400.n0 0.02236f
CRF349 a_6249_9100.n12 a_6453_8400.n1 0.0177f
CRF350 a_6249_9100.n12 a_8747_8748# 0.02708f
CRF351 a_6249_9100.n12 a_8747_8888# 0.0141f
CRF352 a_6249_9100.n12 a_8747_9028# 0.01088f
CRF353 a_6249_9100.n12 a_8747_9168# 0.01451f
CRF354 a_6249_9100.n12 a_8747_9308# 0.03362f
CRF355 a_6249_9100.n12 d_amp_s[0] 0.03299f
CRF356 a_6249_9100.n12 d_amp_s[1] 0.02788f
CRF357 a_6249_9100.n12 d_amp_s[2] 0.03052f
CRF358 a_6249_9100.n12 d_amp_s[3] 0.01511f
CRF359 a_6249_9100.n12 d_amp_s_b[0] 0.05861f
CRF360 a_6249_9100.n12 d_amp_s_b[1] 0.26293f
CRF361 a_6249_9100.n12 d_amp_s_b[2] 2.238f
CRF362 a_6249_9100.n12 d_amp_s_b[3] 0.02837f
CRF363 a_6249_9100.n12 d_qclk 0.03538f
CRF364 a_6249_9100.n12 sg13cmos5l_inv_1_13.A 0.02956f
CRF365 a_6249_9100.n12 sg13cmos5l_inv_1_13.Y 0.05388f
CRF366 a_6249_9100.n12 sg13cmos5l_inv_1_16.A 0.06308f
CRF367 a_6249_9100.n12 sg13cmos5l_inv_1_16.Y 0.09688f
CRF368 a_6249_9100.n12 sg13cmos5l_inv_1_17.A 0.03557f
CRF369 a_6249_9100.n12 sg13cmos5l_inv_1_17.Y 0.06001f
CRF370 a_6249_9100.n12 sg13cmos5l_inv_1_18.Y 0.01347f
CRF371 a_6249_9100.n12 sg13cmos5l_inv_1_19.Y 0.03697f
CRF372 a_6249_9100.n12 sg13cmos5l_inv_1_20.Y 0.27503f
CRF373 a_6249_9100.n12 sg13cmos5l_inv_1_3.Y 0.34601f
CRF374 a_6249_9100.n12 sg13cmos5l_inv_1_4.A 0.06643f
CRF375 a_6249_9100.n12 sg13cmos5l_inv_1_4.Y 0.12051f
CRF376 a_6249_9100.n12 sg13cmos5l_inv_1_6.A 0.04035f
CRF377 a_6249_9100.n12 sg13cmos5l_inv_1_6.Y 0.23341f
CRF378 a_6249_9100.n12 sg13cmos5l_nand2_1_2.Y 0.02476f
CRF379 a_6249_9100.n12 vdd 0.57453f
CRF380 a_6249_9100.n12 vo_n 0.26834f
CRF381 a_6249_9100.n12 vo_p 0.02501f
CRF382 a_6249_9100.n12 xq_dith_v_bp 0.02124f
CRF383 a_6249_9100.n12 xq_vg_p_0_ 0.4219f
CRF384 a_6249_9100.n12 xq_vg_p_1_ 0.22502f
CRF385 a_6249_9100.n12 xq_vg_p_2_ 0.23808f
CRF386 a_6249_9100.n12 xq_vg_q_0_ 0.87955f
CRF387 a_6249_9100.n12 xq_vg_q_1_ 1.94728f
CRF388 a_6249_9100.n12 xq_vg_q_2_ 0.38566f
CRF389 a_6257_8400.n0 a_6453_8400.n1 0.04553f
CRF390 a_6257_8400.n0 a_6884_8680# 0.07349f
CRF391 a_6257_8400.n0 a_8661_9028# 0.04601f
CRF392 a_6257_8400.n0 a_8747_9308# 0.01899f
CRF393 a_6257_8400.n0 a_8747_9488# 0.02798f
CRF394 a_6257_8400.n0 d_amp_s[1] 0.5751f
CRF395 a_6257_8400.n0 d_amp_s[2] 0.02359f
CRF396 a_6257_8400.n0 d_amp_s[3] 0.11112f
CRF397 a_6257_8400.n0 d_amp_s_b[0] 0.02478f
CRF398 a_6257_8400.n0 d_amp_s_b[1] 1.0285f
CRF399 a_6257_8400.n0 d_amp_s_b[2] 0.02845f
CRF400 a_6257_8400.n0 d_amp_s_b[3] 0.02683f
CRF401 a_6257_8400.n0 sg13cmos5l_inv_1_16.Y 0.04261f
CRF402 a_6257_8400.n0 sg13cmos5l_inv_1_17.A 0.07563f
CRF403 a_6257_8400.n0 sg13cmos5l_inv_1_18.Y 0.03505f
CRF404 a_6257_8400.n0 sg13cmos5l_inv_1_19.Y 0.18355f
CRF405 a_6257_8400.n0 vdd 0.19625f
CRF406 a_6257_8400.n0 xq_vg_q_1_ 0.0257f
CRF407 a_6452_29739.n0 a_6817_30111# 0.33522f
CRF408 a_6452_29739.n0 a_7804_29739.n0 3.66844f
CRF409 a_6452_29739.n0 d_ena 0.08988f
CRF410 a_6452_29739.n0 sw_tgate_cmfb2_1.p 0.64162f
CRF411 a_6452_29739.n0 vdd 0.06834f
CRF412 a_6452_29739.n0 vo_n 0.012f
CRF413 a_6452_29739.n0 vo_p 0.4021f
CRF414 a_6452_29739.n0 w_9407_29481.t0 0.60097f
CRF415 a_6452_29739.n0 xsc_vfb 0.72821f
CRF416 a_6452_29739.n0 xsc_vvg_n 0.4826f
CRF417 a_6452_29739.n0 xsc_vvg_p 0.27646f
CRF418 a_6453_8400.n1 a_6757_9808# 0.05141f
CRF419 a_6453_8400.n1 a_6884_8680# 0.8045f
CRF420 a_6453_8400.n1 a_8661_8468# 0.02818f
CRF421 a_6453_8400.n1 a_8747_8188# 0.01478f
CRF422 a_6453_8400.n1 a_8747_8328# 0.02485f
CRF423 a_6453_8400.n1 a_8747_8468# 0.0624f
CRF424 a_6453_8400.n1 a_8747_8608# 0.04281f
CRF425 a_6453_8400.n1 a_8747_8748# 0.0335f
CRF426 a_6453_8400.n1 a_8747_8888# 0.02867f
CRF427 a_6453_8400.n1 a_8747_9028# 0.02339f
CRF428 a_6453_8400.n1 a_8747_9168# 0.01954f
CRF429 a_6453_8400.n1 a_8747_9308# 0.01612f
CRF430 a_6453_8400.n1 a_8747_9488# 0.01099f
CRF431 a_6453_8400.n1 a_8747_9628# 0.02291f
CRF432 a_6453_8400.n1 a_9883_9628# 0.02338f
CRF433 a_6453_8400.n1 d_amp_s[0] 0.09426f
CRF434 a_6453_8400.n1 d_amp_s[3] 0.12858f
CRF435 a_6453_8400.n1 d_amp_s_b[0] 0.03923f
CRF436 a_6453_8400.n1 d_amp_s_b[1] 0.13772f
CRF437 a_6453_8400.n1 d_amp_s_b[2] 0.03057f
CRF438 a_6453_8400.n1 d_amp_s_b[3] 0.04348f
CRF439 a_6453_8400.n1 sg13cmos5l_inv_1_16.Y 0.0994f
CRF440 a_6453_8400.n1 sg13cmos5l_inv_1_18.Y 0.53823f
CRF441 a_6453_8400.n1 sg13cmos5l_inv_1_19.Y 0.03866f
CRF442 a_6453_8400.n1 sg13cmos5l_inv_1_3.Y 0.02287f
CRF443 a_6453_8400.n1 vdd 0.06354f
CRF444 a_6453_8400.n1 vo_p 0.0504f
CRF445 a_6453_8400.n1 xq_vg_q_0_ 0.1286f
CRF446 a_6453_8400.n1 xq_vg_q_1_ 0.02373f
CRF447 a_6638_31505# w_9407_29481.t0 0.21204f
CRF448 a_6817_30111# a_7804_29739.n0 0.32015f
CRF449 a_6817_30111# w_9407_29481.t0 0.55077f
CRF450 a_7224_31505# w_9407_29481.t0 0.46772f
CRF451 a_7804_29739.n0 d_ena 0.01788f
CRF452 a_7804_29739.n0 sw_tgate_cmfb2_1.p 0.71916f
CRF453 a_7804_29739.n0 vdd 0.06437f
CRF454 a_7804_29739.n0 vo_n 0.40104f
CRF455 a_7804_29739.n0 vo_p 0.01252f
CRF456 a_7804_29739.n0 w_9407_29481.t0 0.64504f
CRF457 a_7804_29739.n0 xsc_vfb 0.80167f
CRF458 a_7804_29739.n0 xsc_vvg_n 0.16474f
CRF459 a_7804_29739.n0 xsc_vvg_p 0.53509f
CRF460 a_8762_31505# w_9407_29481.t0 0.27239f
CRF461 a_9348_31505# w_9407_29481.t0 0.27304f
CRF462 a_9357_11104.n0 a_9533_11104.n3 1.93127f
CRF463 a_9357_11104.n0 d_qclk 0.15772f
CRF464 a_9357_11104.n0 sg13cmos5l_and2_2_1.X 1.23348f
CRF465 a_9357_11104.n0 sg13cmos5l_inv_1_14.A 0.03988f
CRF466 a_9357_11104.n0 sg13cmos5l_inv_1_17.A 0.0359f
CRF467 a_9357_11104.n0 sg13cmos5l_inv_1_19.Y 0.09479f
CRF468 a_9357_11104.n0 sg13cmos5l_inv_1_2.A 0.0407f
CRF469 a_9357_11104.n0 sg13cmos5l_inv_1_3.Y 0.0602f
CRF470 a_9357_11104.n0 sg13cmos5l_inv_1_6.A 0.06425f
CRF471 a_9357_11104.n0 vo_n 0.52258f
CRF472 a_9357_11104.n0 vo_p 0.52258f
CRF473 a_9357_11104.n0 xq_vg_p_0_ 0.12178f
CRF474 a_9357_11104.n0 xq_vg_p_1_ 0.15657f
CRF475 a_9357_11104.n0 xq_vg_p_2_ 0.30833f
CRF476 a_9357_11104.n0 xq_vg_q_0_ 0.12178f
CRF477 a_9357_11104.n0 xq_vg_q_1_ 0.15657f
CRF478 a_9357_11104.n0 xq_vg_q_2_ 0.30833f
CRF479 a_9533_11104.n3 d_qclk 0.07404f
CRF480 a_9533_11104.n3 sg13cmos5l_and2_2_1.X 0.51507f
CRF481 a_9533_11104.n3 sg13cmos5l_inv_1_14.A 0.17208f
CRF482 a_9533_11104.n3 sg13cmos5l_inv_1_17.A 0.02314f
CRF483 a_9533_11104.n3 sg13cmos5l_inv_1_19.Y 0.01137f
CRF484 a_9533_11104.n3 sg13cmos5l_inv_1_2.A 0.25095f
CRF485 a_9533_11104.n3 vdd 0.50302f
CRF486 a_9533_11104.n3 vo_p 0.57317f
CRF487 a_9533_11104.n3 xq_vg_q_0_ 0.06035f
CRF488 a_9533_11104.n3 xq_vg_q_1_ 0.138f
CRF489 a_9533_11104.n3 xq_vg_q_2_ 0.19551f
CRF490 d_ena w_9407_29481.t0 0.11477f
CRF491 m2_6409_30900# w_9407_29481.t0 0.15386f
CRF492 sw_tgate_cmfb2_1.p w_9407_29481.t0 0.11322f
CRF493 vdd w_9407_29481.t0 0.99771f
CRF494 vo_n w_9407_29481.t0 3.20583f
CRF495 vo_p w_9407_29481.t0 3.20413f
CRF496 w_9407_29481.t0 xsc_vfb 0.92775f
CRF497 w_9407_29481.t0 xsc_vvg_n 1.86527f
CRF498 w_9407_29481.t0 xsc_vvg_p 1.91375f
XC_xsc_CDUM_DCOL_0_ vdd vss cap_cmomf w=3u l=5.6u mmin=1 mmax=4 subblock=0 m=1 mm_ok=1
XC_xsc_CDUM_DCOL_1_ vdd vss cap_cmomf w=3u l=5.6u mmin=1 mmax=4 subblock=0 m=1 mm_ok=1
XC_xsc_CDUM_DCOL_2_ vdd vss cap_cmomf w=3u l=5.6u mmin=1 mmax=4 subblock=0 m=1 mm_ok=1
XC_xsc_CDUM_DCOL_3_ vdd vss cap_cmomf w=3u l=5.6u mmin=1 mmax=4 subblock=0 m=1 mm_ok=1
XC_xsc_CDUM_DCOL_4_ vdd vss cap_cmomf w=3u l=5.6u mmin=1 mmax=4 subblock=0 m=1 mm_ok=1
XC_xsc_CDUM_DCOL_5_ vdd vss cap_cmomf w=3u l=5.6u mmin=1 mmax=4 subblock=0 m=1 mm_ok=1
XC_xsc_CDUM_DCOL_6_ vdd vss cap_cmomf w=3u l=5.6u mmin=1 mmax=4 subblock=0 m=1 mm_ok=1
XC_xsc_CDUM_DCOL_7_ vdd vss cap_cmomf w=3u l=5.6u mmin=1 mmax=4 subblock=0 m=1 mm_ok=1
XC_xsc_CDUM_DCOL_8_ vdd vss cap_cmomf w=3u l=5.6u mmin=1 mmax=4 subblock=0 m=1 mm_ok=1
XC_xsc_C2P_0_ xsc_vvg_n vo_p cap_cmomf w=3u l=11.39u mmin=1 mmax=4 subblock=0 m=1 mm_ok=1
XC_xsc_C2P_1_ xsc_vvg_n vo_p cap_cmomf w=3u l=11.39u mmin=1 mmax=4 subblock=0 m=1 mm_ok=1
XC_xsc_C2P_2_ xsc_vvg_n vo_p cap_cmomf w=3u l=11.39u mmin=1 mmax=4 subblock=0 m=1 mm_ok=1
XC_xsc_C1P_0_ xsc_vc1r_p xsc_vc1l_p cap_cmomf w=3u l=11.39u mmin=1 mmax=4 subblock=0 m=1 mm_ok=1
XC_xsc_C2P_3_ xsc_vvg_n vo_p cap_cmomf w=3u l=11.39u mmin=1 mmax=4 subblock=0 m=1 mm_ok=1
XC_xsc_C2P_4_ xsc_vvg_n vo_p cap_cmomf w=3u l=11.39u mmin=1 mmax=4 subblock=0 m=1 mm_ok=1
XC_xsc_C2P_5_ xsc_vvg_n vo_p cap_cmomf w=3u l=11.39u mmin=1 mmax=4 subblock=0 m=1 mm_ok=1
XC_xsc_CDUM_STRIP_0_ vdd vss cap_cmomf w=3u l=11.39u mmin=1 mmax=4 subblock=0 m=1 mm_ok=1
XC_xsc_CDUM_STRIP_1_ vdd vss cap_cmomf w=3u l=11.39u mmin=1 mmax=4 subblock=0 m=1 mm_ok=1
XC_xsc_C2N_0_ xsc_vvg_p vo_n cap_cmomf w=3u l=11.39u mmin=1 mmax=4 subblock=0 m=1 mm_ok=1
XC_xsc_C2N_1_ xsc_vvg_p vo_n cap_cmomf w=3u l=11.39u mmin=1 mmax=4 subblock=0 m=1 mm_ok=1
XC_xsc_C2N_2_ xsc_vvg_p vo_n cap_cmomf w=3u l=11.39u mmin=1 mmax=4 subblock=0 m=1 mm_ok=1
XC_xsc_C1N_0_ xsc_vc1r_n xsc_vc1l_n cap_cmomf w=3u l=11.39u mmin=1 mmax=4 subblock=0 m=1 mm_ok=1
XC_xsc_C2N_3_ xsc_vvg_p vo_n cap_cmomf w=3u l=11.39u mmin=1 mmax=4 subblock=0 m=1 mm_ok=1
XC_xsc_C2N_4_ xsc_vvg_p vo_n cap_cmomf w=3u l=11.39u mmin=1 mmax=4 subblock=0 m=1 mm_ok=1
XC_xsc_C2N_5_ xsc_vvg_p vo_n cap_cmomf w=3u l=11.39u mmin=1 mmax=4 subblock=0 m=1 mm_ok=1
XC_xsc_CDUM_STRIP_2_ vdd vss cap_cmomf w=3u l=11.39u mmin=1 mmax=4 subblock=0 m=1 mm_ok=1
XC_xsc_CDUM_STRIP_3_ vdd vss cap_cmomf w=3u l=11.39u mmin=1 mmax=4 subblock=0 m=1 mm_ok=1
XC_xsc_CDUM_DCOL_9_ vdd vss cap_cmomf w=3u l=5.6u mmin=1 mmax=4 subblock=0 m=1 mm_ok=1
XC_xsc_CDUM_DCOL_10_ vdd vss cap_cmomf w=3u l=5.6u mmin=1 mmax=4 subblock=0 m=1 mm_ok=1
XC_xsc_CDUM_DCOL_11_ vdd vss cap_cmomf w=3u l=5.6u mmin=1 mmax=4 subblock=0 m=1 mm_ok=1
XC_xsc_CDUM_DCOL_12_ vdd vss cap_cmomf w=3u l=5.6u mmin=1 mmax=4 subblock=0 m=1 mm_ok=1
XC_xsc_CDUM_DCOL_13_ vdd vss cap_cmomf w=3u l=5.6u mmin=1 mmax=4 subblock=0 m=1 mm_ok=1
XC_xsc_CDUM_DCOL_14_ vdd vss cap_cmomf w=3u l=5.6u mmin=1 mmax=4 subblock=0 m=1 mm_ok=1
XC_xsc_CDUM_DCOL_15_ vdd vss cap_cmomf w=3u l=5.6u mmin=1 mmax=4 subblock=0 m=1 mm_ok=1
XC_xsc_CDUM_DCOL_16_ vdd vss cap_cmomf w=3u l=5.6u mmin=1 mmax=4 subblock=0 m=1 mm_ok=1
XC_xsc_CDUM_DCOL_17_ vdd vss cap_cmomf w=3u l=5.6u mmin=1 mmax=4 subblock=0 m=1 mm_ok=1
XC_xsc_C2P_6_ xsc_vvg_n vo_p cap_cmomf w=3u l=11.39u mmin=1 mmax=4 subblock=0 m=1 mm_ok=1
XC_xsc_C2P_7_ xsc_vvg_n vo_p cap_cmomf w=3u l=11.39u mmin=1 mmax=4 subblock=0 m=1 mm_ok=1
XC_xsc_C2P_8_ xsc_vvg_n vo_p cap_cmomf w=3u l=11.39u mmin=1 mmax=4 subblock=0 m=1 mm_ok=1
XC_xsc_C1P_1_ xsc_vc1r_p xsc_vc1l_p cap_cmomf w=3u l=11.39u mmin=1 mmax=4 subblock=0 m=1 mm_ok=1
XC_xsc_C2P_9_ xsc_vvg_n vo_p cap_cmomf w=3u l=11.39u mmin=1 mmax=4 subblock=0 m=1 mm_ok=1
XC_xsc_C2P_10_ xsc_vvg_n vo_p cap_cmomf w=3u l=11.39u mmin=1 mmax=4 subblock=0 m=1 mm_ok=1
XC_xsc_C2P_11_ xsc_vvg_n vo_p cap_cmomf w=3u l=11.39u mmin=1 mmax=4 subblock=0 m=1 mm_ok=1
XC_xsc_CDUM_STRIP_4_ vdd vss cap_cmomf w=3u l=11.39u mmin=1 mmax=4 subblock=0 m=1 mm_ok=1
XC_xsc_CDUM_STRIP_5_ vdd vss cap_cmomf w=3u l=11.39u mmin=1 mmax=4 subblock=0 m=1 mm_ok=1
XC_xsc_C2N_6_ xsc_vvg_p vo_n cap_cmomf w=3u l=11.39u mmin=1 mmax=4 subblock=0 m=1 mm_ok=1
XC_xsc_C2N_7_ xsc_vvg_p vo_n cap_cmomf w=3u l=11.39u mmin=1 mmax=4 subblock=0 m=1 mm_ok=1
XC_xsc_C2N_8_ xsc_vvg_p vo_n cap_cmomf w=3u l=11.39u mmin=1 mmax=4 subblock=0 m=1 mm_ok=1
XC_xsc_C1N_1_ xsc_vc1r_n xsc_vc1l_n cap_cmomf w=3u l=11.39u mmin=1 mmax=4 subblock=0 m=1 mm_ok=1
XC_xsc_C2N_9_ xsc_vvg_p vo_n cap_cmomf w=3u l=11.39u mmin=1 mmax=4 subblock=0 m=1 mm_ok=1
XC_xsc_C2N_10_ xsc_vvg_p vo_n cap_cmomf w=3u l=11.39u mmin=1 mmax=4 subblock=0 m=1 mm_ok=1
XC_xsc_C2N_11_ xsc_vvg_p vo_n cap_cmomf w=3u l=11.39u mmin=1 mmax=4 subblock=0 m=1 mm_ok=1
XC_xsc_CDUM_STRIP_6_ vdd vss cap_cmomf w=3u l=11.39u mmin=1 mmax=4 subblock=0 m=1 mm_ok=1
XC_xsc_CDUM_STRIP_7_ vdd vss cap_cmomf w=3u l=11.39u mmin=1 mmax=4 subblock=0 m=1 mm_ok=1
XC_xsc_xcmfb1_C2_0_ xsc_xcmfb1_vsw_cm_p xsc_xcmfb1_vsw_vbias cap_cmomf w=3u l=4.105u mmin=1 mmax=4 subblock=0 m=1 mm_ok=1
XC_xsc_xcmfb1_C2_1_ xsc_xcmfb1_vsw_cm_p xsc_xcmfb1_vsw_vbias cap_cmomf w=3u l=4.105u mmin=1 mmax=4 subblock=0 m=1 mm_ok=1
XC_xsc_xcmfb1_C2_2_ xsc_xcmfb1_vsw_cm_p xsc_xcmfb1_vsw_vbias cap_cmomf w=3u l=4.105u mmin=1 mmax=4 subblock=0 m=1 mm_ok=1
XC_xsc_xcmfb1_C2_3_ xsc_xcmfb1_vsw_cm_p xsc_xcmfb1_vsw_vbias cap_cmomf w=3u l=4.105u mmin=1 mmax=4 subblock=0 m=1 mm_ok=1
XC_xsc_xcmfb1_C1_0_ vo_p xsc_vfb cap_cmomf w=3u l=11.39u mmin=1 mmax=4 subblock=0 m=1 mm_ok=1
XC_xsc_xcmfb1_C1_1_ vo_p xsc_vfb cap_cmomf w=3u l=11.39u mmin=1 mmax=4 subblock=0 m=1 mm_ok=1
XC_xsc_xcmfb1_C1_2_ vo_p xsc_vfb cap_cmomf w=3u l=11.39u mmin=1 mmax=4 subblock=0 m=1 mm_ok=1
XC_xsc_xcmfb1_CDUM_COL_0_ vdd vss cap_cmomf w=3u l=2u mmin=1 mmax=4 subblock=0 m=1 mm_ok=1
XC_xsc_xcmfb1_CDUM_COL_1_ vdd vss cap_cmomf w=3u l=2u mmin=1 mmax=4 subblock=0 m=1 mm_ok=1
XC_xsc_xcmfb1_CDUM_COL_2_ vdd vss cap_cmomf w=3u l=2u mmin=1 mmax=4 subblock=0 m=1 mm_ok=1
XC_xsc_xcmfb1_CDUM_COL_3_ vdd vss cap_cmomf w=3u l=2u mmin=1 mmax=4 subblock=0 m=1 mm_ok=1
XC_xsc_xcmfb1_CDUM_COL_4_ vdd vss cap_cmomf w=3u l=2u mmin=1 mmax=4 subblock=0 m=1 mm_ok=1
XC_xsc_xcmfb1_CDUM_COL_5_ vdd vss cap_cmomf w=3u l=2u mmin=1 mmax=4 subblock=0 m=1 mm_ok=1
XC_xsc_xcmfb1_CDUM_COL_6_ vdd vss cap_cmomf w=3u l=2u mmin=1 mmax=4 subblock=0 m=1 mm_ok=1
XC_xsc_xcmfb1_C4_0_ xsc_xcmfb1_vsw_cm_n xsc_xcmfb1_vsw_vbias cap_cmomf w=3u l=4.105u mmin=1 mmax=4 subblock=0 m=1 mm_ok=1
XC_xsc_xcmfb1_C4_1_ xsc_xcmfb1_vsw_cm_n xsc_xcmfb1_vsw_vbias cap_cmomf w=3u l=4.105u mmin=1 mmax=4 subblock=0 m=1 mm_ok=1
XC_xsc_xcmfb1_C4_2_ xsc_xcmfb1_vsw_cm_n xsc_xcmfb1_vsw_vbias cap_cmomf w=3u l=4.105u mmin=1 mmax=4 subblock=0 m=1 mm_ok=1
XC_xsc_xcmfb1_C4_3_ xsc_xcmfb1_vsw_cm_n xsc_xcmfb1_vsw_vbias cap_cmomf w=3u l=4.105u mmin=1 mmax=4 subblock=0 m=1 mm_ok=1
XC_xsc_xcmfb1_C3_0_ vo_n xsc_vfb cap_cmomf w=3u l=11.39u mmin=1 mmax=4 subblock=0 m=1 mm_ok=1
XC_xsc_xcmfb1_C3_1_ vo_n xsc_vfb cap_cmomf w=3u l=11.39u mmin=1 mmax=4 subblock=0 m=1 mm_ok=1
XC_xsc_xcmfb1_C3_2_ vo_n xsc_vfb cap_cmomf w=3u l=11.39u mmin=1 mmax=4 subblock=0 m=1 mm_ok=1
XC_xsc_xcmfb1_CDUM_COL_7_ vdd vss cap_cmomf w=3u l=2u mmin=1 mmax=4 subblock=0 m=1 mm_ok=1
XC_xsc_xcmfb1_CDUM_COL_8_ vdd vss cap_cmomf w=3u l=2u mmin=1 mmax=4 subblock=0 m=1 mm_ok=1
XC_xsc_xcmfb1_CDUM_COL_9_ vdd vss cap_cmomf w=3u l=2u mmin=1 mmax=4 subblock=0 m=1 mm_ok=1
XC_xsc_xcmfb1_CDUM_COL_10_ vdd vss cap_cmomf w=3u l=2u mmin=1 mmax=4 subblock=0 m=1 mm_ok=1
XC_xsc_xcmfb1_CDUM_COL_11_ vdd vss cap_cmomf w=3u l=2u mmin=1 mmax=4 subblock=0 m=1 mm_ok=1
XC_xsc_xcmfb1_CDUM_COL_12_ vdd vss cap_cmomf w=3u l=2u mmin=1 mmax=4 subblock=0 m=1 mm_ok=1
XC_xsc_xcmfb1_CDUM_COL_13_ vdd vss cap_cmomf w=3u l=2u mmin=1 mmax=4 subblock=0 m=1 mm_ok=1
XC_xvcm_CF1_0_ xvcm_vcf_t xvcm_vcf_b cap_cmomf w=4.2u l=12.4u mmin=3 mmax=4 subblock=0 m=1 mm_ok=1
XC_xvcm_CF2_0_ xvcm_vcf_b xvcm_vcf_t cap_cmomf w=4.2u l=12.4u mmin=3 mmax=4 subblock=0 m=1 mm_ok=1
XC_xvcm_CF2_1_ xvcm_vcf_b xvcm_vcf_t cap_cmomf w=4.2u l=12.4u mmin=3 mmax=4 subblock=0 m=1 mm_ok=1
XC_xvcm_CF1_1_ xvcm_vcf_t xvcm_vcf_b cap_cmomf w=4.2u l=12.4u mmin=3 mmax=4 subblock=0 m=1 mm_ok=1
XC_xvcm_CF2_2_ xvcm_vcf_b xvcm_vcf_t cap_cmomf w=4.2u l=12.4u mmin=3 mmax=4 subblock=0 m=1 mm_ok=1
XC_xvcm_CF1_2_ xvcm_vcf_t xvcm_vcf_b cap_cmomf w=4.2u l=12.4u mmin=3 mmax=4 subblock=0 m=1 mm_ok=1
XC_xvcm_CF1_3_ xvcm_vcf_t xvcm_vcf_b cap_cmomf w=4.2u l=12.4u mmin=3 mmax=4 subblock=0 m=1 mm_ok=1
XC_xvcm_CF2_3_ xvcm_vcf_b xvcm_vcf_t cap_cmomf w=4.2u l=12.4u mmin=3 mmax=4 subblock=0 m=1 mm_ok=1
XC_xq_dith_cfq0_u0 xq_dith_v_bq xq_vg_q_0_ cap_cmomf w=7.6u l=4.1u mmin=1 mmax=4 subblock=0 m=1 mm_ok=1
XC_xq_dith_cfq1_1__u1 xq_dith_v_bq xq_vg_q_1_ cap_cmomf w=7.6u l=4.1u mmin=1 mmax=4 subblock=0 m=1 mm_ok=1
XC_xq_dith_cfq2_3__u2 xq_dith_v_bq xq_vg_q_2_ cap_cmomf w=7.6u l=4.1u mmin=1 mmax=4 subblock=0 m=1 mm_ok=1
XC_xq_dith_cfq2_3__u3 xq_vg_q_2_ xq_dith_v_bq cap_cmomf w=7.6u l=4.1u mmin=1 mmax=4 subblock=0 m=1 mm_ok=1
XC_xq_dith_cfp2_3__u4 xq_dith_v_bp xq_vg_p_2_ cap_cmomf w=7.6u l=4.1u mmin=1 mmax=4 subblock=0 m=1 mm_ok=1
XC_xq_dith_cfp2_3__u5 xq_vg_p_2_ xq_dith_v_bp cap_cmomf w=7.6u l=4.1u mmin=1 mmax=4 subblock=0 m=1 mm_ok=1
XC_xq_dith_cfp1_1__u6 xq_vg_p_1_ xq_dith_v_bp cap_cmomf w=7.6u l=4.1u mmin=1 mmax=4 subblock=0 m=1 mm_ok=1
XC_xq_dith_cfp0_u7 xq_vg_p_0_ xq_dith_v_bp cap_cmomf w=7.6u l=4.1u mmin=1 mmax=4 subblock=0 m=1 mm_ok=1
XC_xq_dith_cfq1_1__u9 xq_dith_v_bq xq_vg_q_1_ cap_cmomf w=7.6u l=4.1u mmin=1 mmax=4 subblock=0 m=1 mm_ok=1
XC_xq_dith_cfq2_3__u10 xq_dith_v_bq xq_vg_q_2_ cap_cmomf w=7.6u l=4.1u mmin=1 mmax=4 subblock=0 m=1 mm_ok=1
XC_xq_dith_cfq2_3__u11 xq_vg_q_2_ xq_dith_v_bq cap_cmomf w=7.6u l=4.1u mmin=1 mmax=4 subblock=0 m=1 mm_ok=1
XC_xq_dith_cfp2_3__u12 xq_dith_v_bp xq_vg_p_2_ cap_cmomf w=7.6u l=4.1u mmin=1 mmax=4 subblock=0 m=1 mm_ok=1
XC_xq_dith_cfp2_3__u13 xq_vg_p_2_ xq_dith_v_bp cap_cmomf w=7.6u l=4.1u mmin=1 mmax=4 subblock=0 m=1 mm_ok=1
XC_xq_dith_cfp1_1__u14 xq_vg_p_1_ xq_dith_v_bp cap_cmomf w=7.6u l=4.1u mmin=1 mmax=4 subblock=0 m=1 mm_ok=1
RFL0 a_10120_5586# vss 1e12
RFL1 a_10291_7286# vss 1e12
RFL2 a_10888_5586# vss 1e12
RFL3 a_11201_8188# vss 1e12
RFL4 a_11201_8328# vss 1e12
RFL5 a_11201_8468# vss 1e12
RFL6 a_11201_8608# vss 1e12
RFL7 a_11201_8748# vss 1e12
RFL8 a_11201_8888# vss 1e12
RFL9 a_11201_9028# vss 1e12
RFL10 a_11201_9168# vss 1e12
RFL11 a_11201_9308# vss 1e12
RFL12 a_11201_9808# vss 1e12
RFL13 a_11201_9948# vss 1e12
RFL14 a_11259_9488# vss 1e12
RFL15 a_11259_9628# vss 1e12
RFL16 a_11656_5586# vss 1e12
RFL17 a_12395_9488# vss 1e12
RFL18 a_12395_9628# vss 1e12
RFL19 a_12424_5586# vss 1e12
RFL20 a_12800_15736# vss 1e12
RFL21 a_13088_15020# vss 1e12
RFL22 a_13192_5586# vss 1e12
RFL23 a_13960_5586# vss 1e12
RFL24 a_14728_5586# vss 1e12
RFL25 a_15496_5586# vss 1e12
RFL26 a_16264_5586# vss 1e12
RFL27 a_16648_5586# vss 1e12
RFL28 a_16832_5586# vss 1e12
RFL29 a_17416_5586# vss 1e12
RFL30 a_17595_6570# vss 1e12
RFL31 a_19000_826# vss 1e12
RFL32 a_19576_826# vss 1e12
RFL33 a_19999_22684# vss 1e12
RFL34 a_19999_22824# vss 1e12
RFL35 a_19999_22964# vss 1e12
RFL36 a_19999_23104# vss 1e12
RFL37 a_20000_19340# vss 1e12
RFL38 a_20000_19480# vss 1e12
RFL39 a_20000_19620# vss 1e12
RFL40 a_20000_19760# vss 1e12
RFL41 a_20000_19900# vss 1e12
RFL42 a_20000_20040# vss 1e12
RFL43 a_20000_20180# vss 1e12
RFL44 a_20000_20320# vss 1e12
RFL45 a_20000_20460# vss 1e12
RFL46 a_20000_20600# vss 1e12
RFL47 a_20000_20740# vss 1e12
RFL48 a_20000_20880# vss 1e12
RFL49 a_20000_21020# vss 1e12
RFL50 a_20000_21160# vss 1e12
RFL51 a_20000_21300# vss 1e12
RFL52 a_20000_21440# vss 1e12
RFL53 a_20000_21580# vss 1e12
RFL54 a_20000_21720# vss 1e12
RFL55 a_20000_21860# vss 1e12
RFL56 a_20000_22000# vss 1e12
RFL57 a_20000_22140# vss 1e12
RFL58 a_20000_22280# vss 1e12
RFL59 a_20000_22420# vss 1e12
RFL60 a_20758_19340# vss 1e12
RFL61 a_20758_19480# vss 1e12
RFL62 a_20758_19620# vss 1e12
RFL63 a_20758_19760# vss 1e12
RFL64 a_20758_19900# vss 1e12
RFL65 a_20758_20040# vss 1e12
RFL66 a_20758_20180# vss 1e12
RFL67 a_20758_20320# vss 1e12
RFL68 a_20758_20460# vss 1e12
RFL69 a_20758_20600# vss 1e12
RFL70 a_20758_20740# vss 1e12
RFL71 a_20758_20880# vss 1e12
RFL72 a_20758_21020# vss 1e12
RFL73 a_20758_21160# vss 1e12
RFL74 a_20758_21300# vss 1e12
RFL75 a_20758_21440# vss 1e12
RFL76 a_20758_21580# vss 1e12
RFL77 a_20758_21720# vss 1e12
RFL78 a_20758_21860# vss 1e12
RFL79 a_20758_22000# vss 1e12
RFL80 a_20758_22140# vss 1e12
RFL81 a_20758_22280# vss 1e12
RFL82 a_20758_22420# vss 1e12
RFL83 a_22063_22684# vss 1e12
RFL84 a_22063_22824# vss 1e12
RFL85 a_22063_22964# vss 1e12
RFL86 a_22063_23104# vss 1e12
RFL87 a_2208_17741# vss 1e12
RFL88 a_2208_18213# vss 1e12
RFL89 a_2208_18597# vss 1e12
RFL90 a_2208_18981# vss 1e12
RFL91 a_2208_19085# vss 1e12
RFL92 a_2208_19557# vss 1e12
RFL93 a_2208_19661# vss 1e12
RFL94 a_2208_20141# vss 1e12
RFL95 a_2208_20613# vss 1e12
RFL96 a_2208_20717# vss 1e12
RFL97 a_2208_21189# vss 1e12
RFL98 a_2208_21293# vss 1e12
RFL99 a_2208_21485# vss 1e12
RFL100 a_2208_22253# vss 1e12
RFL101 a_2208_23021# vss 1e12
RFL102 a_2208_23789# vss 1e12
RFL103 a_2208_24557# vss 1e12
RFL104 a_2208_25325# vss 1e12
RFL105 a_2208_26093# vss 1e12
RFL106 a_2208_26861# vss 1e12
RFL107 a_2208_27629# vss 1e12
RFL108 a_2208_28397# vss 1e12
RFL109 a_2208_29165# vss 1e12
RFL110 a_2208_29933# vss 1e12
RFL111 a_2208_30701# vss 1e12
RFL112 a_2208_31469# vss 1e12
RFL113 a_2208_32237# vss 1e12
RFL114 a_24164_726# vss 1e12
RFL115 a_24626_19340# vss 1e12
RFL116 a_24626_19480# vss 1e12
RFL117 a_24626_19620# vss 1e12
RFL118 a_24626_19760# vss 1e12
RFL119 a_24626_19900# vss 1e12
RFL120 a_24626_20040# vss 1e12
RFL121 a_24626_20180# vss 1e12
RFL122 a_24626_20320# vss 1e12
RFL123 a_24626_20460# vss 1e12
RFL124 a_24626_20600# vss 1e12
RFL125 a_24626_20740# vss 1e12
RFL126 a_24626_20880# vss 1e12
RFL127 a_24626_21020# vss 1e12
RFL128 a_24626_21160# vss 1e12
RFL129 a_24626_21300# vss 1e12
RFL130 a_24626_21440# vss 1e12
RFL131 a_24626_21580# vss 1e12
RFL132 a_24626_21720# vss 1e12
RFL133 a_24626_21860# vss 1e12
RFL134 a_24626_22000# vss 1e12
RFL135 a_24626_22140# vss 1e12
RFL136 a_24626_22280# vss 1e12
RFL137 a_24626_22420# vss 1e12
RFL138 a_24626_22684# vss 1e12
RFL139 a_24626_22824# vss 1e12
RFL140 a_24626_22964# vss 1e12
RFL141 a_24626_23104# vss 1e12
RFL142 a_24712_874# vss 1e12
RFL143 a_26284_874# vss 1e12
RFL144 a_27029_22684# vss 1e12
RFL145 a_27029_22824# vss 1e12
RFL146 a_27029_22964# vss 1e12
RFL147 a_27029_23104# vss 1e12
RFL148 a_27856_874# vss 1e12
RFL149 a_28334_19340# vss 1e12
RFL150 a_28334_19480# vss 1e12
RFL151 a_28334_19620# vss 1e12
RFL152 a_28334_19760# vss 1e12
RFL153 a_28334_19900# vss 1e12
RFL154 a_28334_20040# vss 1e12
RFL155 a_28334_20180# vss 1e12
RFL156 a_28334_20320# vss 1e12
RFL157 a_28334_20460# vss 1e12
RFL158 a_28334_20600# vss 1e12
RFL159 a_28334_20740# vss 1e12
RFL160 a_28334_20880# vss 1e12
RFL161 a_28334_21020# vss 1e12
RFL162 a_28334_21160# vss 1e12
RFL163 a_28334_21300# vss 1e12
RFL164 a_28334_21440# vss 1e12
RFL165 a_28334_21580# vss 1e12
RFL166 a_28334_21720# vss 1e12
RFL167 a_28334_21860# vss 1e12
RFL168 a_28334_22000# vss 1e12
RFL169 a_28334_22140# vss 1e12
RFL170 a_28334_22280# vss 1e12
RFL171 a_28334_22420# vss 1e12
RFL172 a_4251_6570# vss 1e12
RFL173 a_6757_9808# vss 1e12
RFL174 a_6757_9948# vss 1e12
RFL175 a_8392_5586# vss 1e12
RFL176 a_8747_8188# vss 1e12
RFL177 a_8747_8328# vss 1e12
RFL178 a_8747_8468# vss 1e12
RFL179 a_8747_8608# vss 1e12
RFL180 a_8747_8748# vss 1e12
RFL181 a_8747_8888# vss 1e12
RFL182 a_8747_9028# vss 1e12
RFL183 a_8747_9168# vss 1e12
RFL184 a_8747_9308# vss 1e12
RFL185 a_8747_9488# vss 1e12
RFL186 a_8747_9628# vss 1e12
RFL187 a_8768_5586# vss 1e12
RFL188 a_9352_5586# vss 1e12
RFL189 a_9883_9488# vss 1e12
RFL190 a_9883_9628# vss 1e12
RFL191 m2_10908_16655# vss 1e12
RFL192 m2_10908_16863# vss 1e12
RFL193 m2_6409_30900# vss 1e12
RFL194 m3_9560_28731# vss 1e12
.ends
